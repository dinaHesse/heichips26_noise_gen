* PEX produced on Thu Oct  1 10:09:04 PM CEST 2026 using scripts/sak-pex.sh with m=3 and s=1 (extresist threshold=10000 mOhm, minres=1000 mOhm, mindelay=1 ps)
* NGSPICE file created from d_ro_tapped_pex.ext - technology: ihp-sg13cmos5l

.subckt d_ro_tapped_pex VPWR VGND enable osc ffsel[0] ffsel[1] invsel[0]
+ invsel[1] invsel[2] invsel[3] invsel[4]
X0 sg13cmos5l_nor3_1_0.C a_6369_8476# VGND.t164 VGND.t675 sg13_lv_nmos ad=0.2516p pd=2.16u as=0.1543p ps=1.18u w=0.74u l=0.13u
X1 VPWR VGND.t72 VPWR VPWR sg13_lv_pmos ad=0.34p pd=2.68u as=0.921n ps=3.95917m w=1u l=1u
X2 sg13cmos5l_nor2b_1_2.Y sg13cmos5l_nand2_1_1.B a_6124_7216# VPWR sg13_lv_pmos ad=0.3808p pd=2.92u as=0.1176p ps=1.33u w=1.12u l=0.13u
X3 VPWR VGND.t386 VPWR VPWR sg13_lv_pmos ad=0.19p pd=1.38u as=0 ps=0 w=1u l=1u
X4 VPWR sg13cmos5l_mux2_1_0.S a_14462_6192# VPWR sg13_lv_pmos ad=0.253p pd=1.53u as=0.3325p ps=1.665u w=1u l=0.13u
X5 a_10904_6168# sg13cmos5l_buf_1_2.X a_10571_6132# VGND.t788 sg13_lv_nmos ad=0.54188p pd=3.42u as=0.1216p ps=1.02u w=0.64u l=0.13u
X6 VGND.t164 VPWR VGND.t164 VGND.t168 sg13_lv_nmos ad=0.1428p pd=1.52u as=0 ps=0 w=0.42u l=1u
X7 VGND.t320 VPWR VGND.t321 VGND.t293 sg13_lv_nmos ad=79.8f pd=0.8u as=0 ps=0 w=0.42u l=1u
X8 VPWR VGND.t330 VPWR VPWR sg13_lv_pmos ad=0.19p pd=1.38u as=0 ps=0 w=1u l=1u
X9 VGND.t305 VPWR VGND.t304 VGND.t21 sg13_lv_nmos ad=0.1428p pd=1.52u as=0 ps=0 w=0.42u l=1u
X10 VPWR VGND.t147 VPWR VPWR sg13_lv_pmos ad=0.34p pd=2.68u as=0 ps=0 w=1u l=1u
X11 sg13cmos5l_mux2_1_2.X a_4414_8434# VGND.t161 VGND.t682 sg13_lv_nmos ad=0.4033p pd=2.57u as=0.148p ps=1.14u w=0.74u l=0.13u
X12 a_10462_5410# sg13cmos5l_inv_1_1.Y a_10365_5410# VGND.t918 sg13_lv_nmos ad=0.1628p pd=1.18u as=0.13135p ps=1.095u w=0.74u l=0.13u
X13 sg13cmos5l_o21ai_1_6.A2 sg13cmos5l_inv_1_56.Y VPWR VPWR sg13_lv_pmos ad=0.3808p pd=2.92u as=0.3808p ps=2.92u w=1.12u l=0.13u
X14 VPWR VGND.t87 VPWR VPWR sg13_lv_pmos ad=0.34p pd=2.68u as=0 ps=0 w=1u l=1u
X15 VGND.t332 VPWR VGND.t333 VGND.t293 sg13_lv_nmos ad=79.8f pd=0.8u as=0 ps=0 w=0.42u l=1u
X16 VGND.t420 VPWR VGND.t420 VGND.t19 sg13_lv_nmos ad=79.8f pd=0.8u as=0 ps=0 w=0.42u l=1u
X17 a_10388_8434# sg13cmos5l_o21ai_1_6.Y VGND.t52 VGND.t905 sg13_lv_nmos ad=76.8f pd=0.88u as=0.1872p ps=1.225u w=0.64u l=0.13u
X18 VGND.t12 VPWR VGND.t12 VGND.t240 sg13_lv_nmos ad=0.1428p pd=1.52u as=0 ps=0 w=0.42u l=1u
X19 VPWR VGND.t12 VPWR VPWR sg13_lv_pmos ad=0.34p pd=2.68u as=0 ps=0 w=1u l=1u
X20 VPWR sg13cmos5l_inv_1_72.Y sg13cmos5l_inv_1_51.Y VPWR sg13_lv_pmos ad=0.3808p pd=2.92u as=0.3808p ps=2.92u w=1.12u l=0.13u
X21 sg13cmos5l_inv_1_129.Y sg13cmos5l_inv_1_127.Y VPWR VPWR sg13_lv_pmos ad=0.3808p pd=2.92u as=0.3808p ps=2.92u w=1.12u l=0.13u
X22 VPWR sg13cmos5l_buf_1_1.X sg13cmos5l_nand2_1_0.Y VPWR sg13_lv_pmos ad=0.3808p pd=2.92u as=0.2128p ps=1.5u w=1.12u l=0.13u
X23 VPWR sg13cmos5l_inv_1_37.A sg13cmos5l_inv_1_37.Y VPWR sg13_lv_pmos ad=0.3808p pd=2.92u as=0.3808p ps=2.92u w=1.12u l=0.13u
X24 sg13cmos5l_nor2b_1_2.Y a_5902_6960# VGND.t201 VGND.t714 sg13_lv_nmos ad=0.1406p pd=1.12u as=0.17255p ps=1.25u w=0.74u l=0.13u
X25 VGND.t3 sg13cmos5l_inv_1_34.Y sg13cmos5l_inv_1_76.A VGND.t2 sg13_lv_nmos ad=0.2516p pd=2.16u as=0.2516p ps=2.16u w=0.74u l=0.13u
X26 a_4436_6558# sg13cmos5l_mux4_1_0.A0 VGND.t199 VGND.t727 sg13_lv_nmos ad=76.8f pd=0.88u as=0.1872p ps=1.225u w=0.64u l=0.13u
X27 VGND.t97 VPWR VGND.t97 VGND.t98 sg13_lv_nmos ad=79.8f pd=0.8u as=0 ps=0 w=0.42u l=1u
X28 VPWR VGND.t394 VPWR VPWR sg13_lv_pmos ad=0.19p pd=1.38u as=0 ps=0 w=1u l=1u
X29 VPWR VGND.t321 VPWR VPWR sg13_lv_pmos ad=0.19p pd=1.38u as=0 ps=0 w=1u l=1u
X30 VGND.t258 VPWR VGND.t258 VGND.t260 sg13_lv_nmos ad=0.1428p pd=1.52u as=0 ps=0 w=0.42u l=1u
X31 VPWR sg13cmos5l_nand2_1_1.A sg13cmos5l_nand2_1_1.Y VPWR sg13_lv_pmos ad=0.3808p pd=2.92u as=0.2128p ps=1.5u w=1.12u l=0.13u
X32 VPWR VGND.t145 VPWR VPWR sg13_lv_pmos ad=0.34p pd=2.68u as=0 ps=0 w=1u l=1u
X33 VPWR a_11630_4922# sg13cmos5l_mux2_1_0.X VPWR sg13_lv_pmos ad=0.2198p pd=1.52u as=0.6048p ps=3.32u w=1.12u l=0.13u
X34 VGND.t138 VPWR VGND.t137 VGND.t55 sg13_lv_nmos ad=0.1428p pd=1.52u as=0 ps=0 w=0.42u l=1u
X35 sg13cmos5l_inv_1_18.A sg13cmos5l_inv_1_10.Y VPWR VPWR sg13_lv_pmos ad=0.3808p pd=2.92u as=0.3808p ps=2.92u w=1.12u l=0.13u
X36 VGND.t294 VPWR VGND.t30 VGND.t293 sg13_lv_nmos ad=0.1428p pd=1.52u as=0 ps=0 w=0.42u l=1u
X37 sg13cmos5l_o21ai_1_0.Y sg13cmos5l_o21ai_1_0.B1 a_2038_6546# VGND.t825 sg13_lv_nmos ad=0.2516p pd=2.16u as=0.1406p ps=1.12u w=0.74u l=0.15u
X38 VGND.t559 VPWR VGND.t561 VGND.t560 sg13_lv_nmos ad=79.8f pd=0.8u as=0 ps=0 w=0.42u l=1u
X39 VPWR sg13cmos5l_mux2_1_0.S sg13cmos5l_o21ai_1_6.B1 VPWR sg13_lv_pmos ad=0.2198p pd=1.53u as=0.2128p ps=1.5u w=1.12u l=0.13u
X40 VGND.t323 VPWR VGND.t324 VGND.t293 sg13_lv_nmos ad=79.8f pd=0.8u as=0 ps=0 w=0.42u l=1u
X41 a_3116_6882# sg13cmos5l_buf_1_12.X VPWR VPWR sg13_lv_pmos ad=0.2856p pd=2.36u as=0.2114p ps=1.54u w=0.84u l=0.13u
X42 VPWR VGND.t216 VPWR VPWR sg13_lv_pmos ad=0.34p pd=2.68u as=0 ps=0 w=1u l=1u
X43 a_11314_8058# sg13cmos5l_nand2b_1_2.Y sg13cmos5l_o21ai_1_4.Y VGND.t51 sg13_lv_nmos ad=0.1406p pd=1.12u as=0.2516p ps=2.16u w=0.74u l=0.15u
X44 a_2245_6922# sg13cmos5l_o21ai_1_0.A1 VGND.t7 VGND.t808 sg13_lv_nmos ad=0.1406p pd=1.12u as=0.14505p ps=1.15u w=0.74u l=0.13u
X45 VGND.t420 VPWR VGND.t420 VGND.t19 sg13_lv_nmos ad=79.8f pd=0.8u as=0 ps=0 w=0.42u l=1u
X46 VGND.t350 VPWR VGND.t298 VGND.t21 sg13_lv_nmos ad=0.1428p pd=1.52u as=0 ps=0 w=0.42u l=1u
X47 VGND.t332 VPWR VGND.t331 VGND.t293 sg13_lv_nmos ad=0.1428p pd=1.52u as=0 ps=0 w=0.42u l=1u
X48 VGND.t164 sg13cmos5l_mux2_1_2.X a_6015_8434# VGND.t765 sg13_lv_nmos ad=0.2176p pd=1.96u as=76.8f ps=0.88u w=0.64u l=0.13u
X49 sg13cmos5l_nand2_1_1.A a_808_8468# VGND.t763 VGND.t762 sg13_lv_nmos ad=0.2886p pd=2.26u as=0.14875p ps=1.16u w=0.74u l=0.13u
X50 sg13cmos5l_nand2b_1_4.A_N sg13cmos5l_inv_1_100.Y VGND.t84 VGND.t659 sg13_lv_nmos ad=0.2516p pd=2.16u as=0.2516p ps=2.16u w=0.74u l=0.13u
X51 VPWR VGND.t412 VPWR VPWR sg13_lv_pmos ad=0.19p pd=1.38u as=0 ps=0 w=1u l=1u
X52 VGND.t262 VPWR VGND.t262 VGND.t263 sg13_lv_nmos ad=0.1428p pd=1.52u as=0 ps=0 w=0.42u l=1u
X53 a_6101_8747# a_5063_8434# a_5878_8434# VPWR sg13_lv_pmos ad=0.135p pd=1.27u as=0.4425p ps=1.885u w=1u l=0.13u
X54 VGND.t32 sg13cmos5l_buf_1_4.A a_6415_5410# VGND.t761 sg13_lv_nmos ad=0.14505p pd=1.15u as=0.1406p ps=1.12u w=0.74u l=0.13u
X55 VPWR VGND.t104 VPWR VPWR sg13_lv_pmos ad=0.34p pd=2.68u as=0 ps=0 w=1u l=1u
X56 VGND.t97 VPWR VGND.t97 VGND.t100 sg13_lv_nmos ad=79.8f pd=0.8u as=0 ps=0 w=0.42u l=1u
X57 sg13cmos5l_mux4_1_1.A0 a_4606_9562# VPWR VPWR sg13_lv_pmos ad=0.6048p pd=3.32u as=0.2198p ps=1.52u w=1.12u l=0.13u
X58 VPWR VGND.t491 VPWR VPWR sg13_lv_pmos ad=0.19p pd=1.38u as=0 ps=0 w=1u l=1u
X59 VPWR VGND.t324 VPWR VPWR sg13_lv_pmos ad=0.19p pd=1.38u as=0 ps=0 w=1u l=1u
X60 a_4109_3858# a_4839_4112# a_4750_4209# VPWR sg13_lv_pmos ad=0.2048p pd=1.63u as=93.45f ps=0.865u w=0.42u l=0.13u
X61 VPWR VGND.t147 VPWR VPWR sg13_lv_pmos ad=0.34p pd=2.68u as=0 ps=0 w=1u l=1u
X62 sg13cmos5l_nor3_1_0.C a_6369_8476# VPWR VPWR sg13_lv_pmos ad=0.3808p pd=2.92u as=0.34367p ps=1.775u w=1.12u l=0.13u
X63 VPWR VGND.t386 VPWR VPWR sg13_lv_pmos ad=0.19p pd=1.38u as=0 ps=0 w=1u l=1u
X64 VPWR sg13cmos5l_inv_1_109.A sg13cmos5l_inv_1_95.A VPWR sg13_lv_pmos ad=0.3808p pd=2.92u as=0.3808p ps=2.92u w=1.12u l=0.13u
X65 VGND.t420 VPWR VGND.t420 VGND.t19 sg13_lv_nmos ad=79.8f pd=0.8u as=0 ps=0 w=0.42u l=1u
X66 VPWR a_14030_6434# sg13cmos5l_mux4_1_2.A3 VPWR sg13_lv_pmos ad=0.2198p pd=1.52u as=0.6048p ps=3.32u w=1.12u l=0.13u
X67 a_4860_3858# a_4991_4164# a_4109_3858# VPWR sg13_lv_pmos ad=0.34p pd=2.68u as=0.2048p ps=1.63u w=1u l=0.13u
X68 VPWR VGND.t72 VPWR VPWR sg13_lv_pmos ad=0.19p pd=1.38u as=0 ps=0 w=1u l=1u
X69 a_5883_4285# a_4991_4164# a_5781_4052# VPWR sg13_lv_pmos ad=63f pd=0.72u as=79.8f ps=0.8u w=0.42u l=0.13u
X70 VGND.t38 sg13cmos5l_inv_1_31.A sg13cmos5l_inv_1_31.Y VGND.t920 sg13_lv_nmos ad=0.2516p pd=2.16u as=0.2516p ps=2.16u w=0.74u l=0.13u
X71 VGND.t336 VPWR VGND.t376 VGND.t21 sg13_lv_nmos ad=0.1428p pd=1.52u as=0 ps=0 w=0.42u l=1u
X72 VPWR sg13cmos5l_inv_1_17.Y sg13cmos5l_inv_1_13.Y VPWR sg13_lv_pmos ad=0.3808p pd=2.92u as=0.3808p ps=2.92u w=1.12u l=0.13u
X73 VPWR a_5781_3191# a_4860_3505# VPWR sg13_lv_pmos ad=0.36237p pd=2.605u as=0.34p ps=2.68u w=1u l=0.13u
X74 VGND.t30 sg13cmos5l_nor4_1_0.D sg13cmos5l_nor4_1_0.Y VGND.t737 sg13_lv_nmos ad=0.23757p pd=2.16u as=0.1406p ps=1.12u w=0.74u l=0.13u
X75 sg13cmos5l_inv_1_126.Y sg13cmos5l_inv_1_125.Y VPWR VPWR sg13_lv_pmos ad=0.3808p pd=2.92u as=0.3808p ps=2.92u w=1.12u l=0.13u
X76 VPWR VGND.t331 VPWR VPWR sg13_lv_pmos ad=0.34p pd=2.68u as=0 ps=0 w=1u l=1u
X77 a_4528_8434# sg13cmos5l_inv_1_72.Y a_4414_8434# VGND.t955 sg13_lv_nmos ad=0.3367p pd=1.65u as=0.1628p ps=1.18u w=0.74u l=0.13u
X78 VPWR VGND.t402 VPWR VPWR sg13_lv_pmos ad=0.19p pd=1.38u as=0 ps=0 w=1u l=1u
X79 VGND.t706 sg13cmos5l_dfrbp_1_2.RESET_B.t5 a_6038_3907# VGND.t707 sg13_lv_nmos ad=0.1701p pd=1.65u as=37.8f ps=0.6u w=0.42u l=0.13u
X80 sg13cmos5l_nand2b_1_6.A_N sg13cmos5l_inv_1_19.Y VGND.t32 VGND.t957 sg13_lv_nmos ad=0.2516p pd=2.16u as=0.2516p ps=2.16u w=0.74u l=0.13u
X81 VPWR VGND.t164 VPWR VPWR sg13_lv_pmos ad=0.19p pd=1.38u as=0 ps=0 w=1u l=1u
X82 VGND.t412 VPWR VGND.t412 VGND.t19 sg13_lv_nmos ad=79.8f pd=0.8u as=0 ps=0 w=0.42u l=1u
X83 VPWR VGND.t12 VPWR VPWR sg13_lv_pmos ad=0.34p pd=2.68u as=0 ps=0 w=1u l=1u
X84 sg13cmos5l_inv_1_19.A sg13cmos5l_inv_1_15.Y VGND.t627 VGND.t887 sg13_lv_nmos ad=0.2516p pd=2.16u as=0.2516p ps=2.16u w=0.74u l=0.13u
X85 VPWR VGND.t208 VPWR VPWR sg13_lv_pmos ad=0.34p pd=2.68u as=0 ps=0 w=1u l=1u
X86 VGND.t608 VPWR VGND.t607 VGND.t606 sg13_lv_nmos ad=0.1428p pd=1.52u as=0 ps=0 w=0.42u l=1u
X87 a_3990_3431# a_4109_3108# VPWR VPWR sg13_lv_pmos ad=0.3864p pd=2.93u as=0.2128p ps=1.5u w=1.12u l=0.13u
X88 VGND.t335 VPWR VGND.t334 VGND.t293 sg13_lv_nmos ad=0.1428p pd=1.52u as=0 ps=0 w=0.42u l=1u
X89 VPWR VGND.t54 VPWR VPWR sg13_lv_pmos ad=0.34p pd=2.68u as=0 ps=0 w=1u l=1u
X90 VPWR VGND.t291 VPWR VPWR sg13_lv_pmos ad=0.19p pd=1.38u as=0 ps=0 w=1u l=1u
X91 a_11371_6137# sg13cmos5l_mux4_1_0.S0 VGND.t208 VGND.t798 sg13_lv_nmos ad=0.2176p pd=1.96u as=0.1872p ps=1.225u w=0.64u l=0.13u
X92 VGND.t102 VPWR VGND.t104 VGND.t103 sg13_lv_nmos ad=79.8f pd=0.8u as=0 ps=0 w=0.42u l=1u
X93 VPWR VGND.t386 VPWR VPWR sg13_lv_pmos ad=0.19p pd=1.38u as=0 ps=0 w=1u l=1u
X94 sg13cmos5l_inv_1_25.Y sg13cmos5l_inv_1_27.Y VPWR VPWR sg13_lv_pmos ad=0.3808p pd=2.92u as=0.3808p ps=2.92u w=1.12u l=0.13u
X95 sg13cmos5l_inv_1_12.Y sg13cmos5l_inv_1_13.Y VPWR VPWR sg13_lv_pmos ad=0.3808p pd=2.92u as=0.3808p ps=2.92u w=1.12u l=0.13u
X96 VPWR VGND.t26 VPWR VPWR sg13_lv_pmos ad=0.34p pd=2.68u as=0 ps=0 w=1u l=1u
X97 VGND.t1 sg13cmos5l_inv_1_138.Y sg13cmos5l_inv_1_28.Y VGND.t41 sg13_lv_nmos ad=0.2516p pd=2.16u as=0.2516p ps=2.16u w=0.74u l=0.13u
X98 a_7412_6886# sg13cmos5l_nand2_1_1.B VPWR VPWR sg13_lv_pmos ad=0.2856p pd=2.36u as=0.2618p ps=1.63u w=0.84u l=0.13u
X99 a_11103_8434# sg13cmos5l_buf_1_2.X a_10966_8434# VGND.t55 sg13_lv_nmos ad=76.8f pd=0.88u as=0.1776p ps=1.195u w=0.64u l=0.13u
X100 VGND.t155 VPWR VGND.t155 VGND.t51 sg13_lv_nmos ad=0.1428p pd=1.52u as=0 ps=0 w=0.42u l=1u
X101 VPWR VGND.t52 VPWR VPWR sg13_lv_pmos ad=0.34p pd=2.68u as=0 ps=0 w=1u l=1u
X102 a_5566_9946# sg13cmos5l_inv_1_70.A a_5469_9946# VGND.t718 sg13_lv_nmos ad=0.1628p pd=1.18u as=0.13135p ps=1.095u w=0.74u l=0.13u
X103 VPWR VGND.t394 VPWR VPWR sg13_lv_pmos ad=0.19p pd=1.38u as=0 ps=0 w=1u l=1u
X104 a_11736_4918# sg13cmos5l_mux2_1_0.S VGND.t58 VGND.t900 sg13_lv_nmos ad=0.187p pd=1.78u as=0.18945p ps=1.27u w=0.55u l=0.13u
X105 VGND.t544 VPWR VGND.t543 VGND.t542 sg13_lv_nmos ad=0.1428p pd=1.52u as=0 ps=0 w=0.42u l=1u
X106 VGND.t28 sg13cmos5l_and2_1_0.B a_7723_5004# VGND.t647 sg13_lv_nmos ad=0.1331p pd=1.12u as=0.1216p ps=1.02u w=0.64u l=0.13u
X107 VPWR sg13cmos5l_inv_1_72.A sg13cmos5l_inv_1_72.Y VPWR sg13_lv_pmos ad=0.3808p pd=2.92u as=0.3808p ps=2.92u w=1.12u l=0.13u
X108 a_3990_3431# a_4109_3108# VGND.t292 VGND.t21 sg13_lv_nmos ad=0.2516p pd=2.16u as=0.1406p ps=1.12u w=0.74u l=0.13u
X109 a_5151_6558# sg13cmos5l_mux4_1_0.S0 a_5014_6558# VGND.t795 sg13_lv_nmos ad=76.8f pd=0.88u as=0.1776p ps=1.195u w=0.64u l=0.13u
X110 VPWR VGND.t334 VPWR VPWR sg13_lv_pmos ad=0.34p pd=2.68u as=0 ps=0 w=1u l=1u
X111 VPWR VGND.t412 VPWR VPWR sg13_lv_pmos ad=0.19p pd=1.38u as=0 ps=0 w=1u l=1u
X112 a_5687_3191# sg13cmos5l_dfrbp_1_2.D a_6434_3582# VGND.t634 sg13_lv_nmos ad=0.1428p pd=1.52u as=60.89999f ps=0.71u w=0.42u l=0.13u
X113 VPWR sg13cmos5l_inv_1_118.A sg13cmos5l_inv_1_118.Y VPWR sg13_lv_pmos ad=0.3808p pd=2.92u as=0.3808p ps=2.92u w=1.12u l=0.13u
X114 a_5687_3191# sg13cmos5l_dfrbp_1_2.RESET_B.t3 VPWR VPWR sg13_lv_pmos ad=79.8f pd=0.8u as=0.36237p ps=2.605u w=0.42u l=0.13u
X115 sg13cmos5l_inv_1_124.Y sg13cmos5l_inv_1_123.Y VPWR VPWR sg13_lv_pmos ad=0.3808p pd=2.92u as=0.3808p ps=2.92u w=1.12u l=0.13u
X116 a_11600_6173# sg13cmos5l_mux4_1_0.S0 a_10904_6168# VPWR sg13_lv_pmos ad=0.20762p pd=1.605u as=0.4425p ps=1.885u w=1u l=0.13u
X117 a_4414_8434# sg13cmos5l_inv_1_72.Y a_4317_8728# VPWR sg13_lv_pmos ad=0.2225p pd=1.445u as=0.3325p ps=1.665u w=1u l=0.13u
X118 VGND.t49 sg13cmos5l_inv_1_64.Y sg13cmos5l_inv_1_58.A VGND.t644 sg13_lv_nmos ad=0.2516p pd=2.16u as=0.2516p ps=2.16u w=0.74u l=0.13u
X119 VPWR sg13cmos5l_inv_1_93.A sg13cmos5l_inv_1_92.A VPWR sg13_lv_pmos ad=0.3808p pd=2.92u as=0.3808p ps=2.92u w=1.12u l=0.13u
X120 VGND.t386 VPWR VGND.t386 VGND.t19 sg13_lv_nmos ad=0.1428p pd=1.52u as=0 ps=0 w=0.42u l=1u
X121 VGND.t539 VPWR VGND.t538 VGND.t537 sg13_lv_nmos ad=0.1428p pd=1.52u as=0 ps=0 w=0.42u l=1u
X122 osc a_18856_6168# VGND.t12 VGND.t903 sg13_lv_nmos ad=0.2886p pd=2.26u as=0.14875p ps=1.16u w=0.74u l=0.13u
X123 VPWR VGND.t605 VPWR VPWR sg13_lv_pmos ad=0.19p pd=1.38u as=0 ps=0 w=1u l=1u
X124 VGND.t104 VPWR VGND.t104 VGND.t129 sg13_lv_nmos ad=0.1428p pd=1.52u as=0 ps=0 w=0.42u l=1u
X125 VPWR VGND.t394 VPWR VPWR sg13_lv_pmos ad=0.34p pd=2.68u as=0 ps=0 w=1u l=1u
X126 VGND.t49 VPWR VGND.t49 VGND.t70 sg13_lv_nmos ad=79.8f pd=0.8u as=0 ps=0 w=0.42u l=1u
X127 a_5300_8434# sg13cmos5l_mux4_1_1.A0 VGND.t164 VGND.t812 sg13_lv_nmos ad=76.8f pd=0.88u as=0.1872p ps=1.225u w=0.64u l=0.13u
X128 sg13cmos5l_dfrbp_1_1.Q a_9044_3144# VPWR VPWR sg13_lv_pmos ad=0.3808p pd=2.92u as=0.2128p ps=1.5u w=1.12u l=0.13u
X129 VPWR sg13cmos5l_inv_1_73.A sg13cmos5l_inv_1_73.Y VPWR sg13_lv_pmos ad=0.3808p pd=2.92u as=0.3808p ps=2.92u w=1.12u l=0.13u
X130 sg13cmos5l_inv_1_5.Y sg13cmos5l_inv_1_4.Y VPWR VPWR sg13_lv_pmos ad=0.3808p pd=2.92u as=0.3808p ps=2.92u w=1.12u l=0.13u
X131 VPWR VGND.t386 VPWR VPWR sg13_lv_pmos ad=0.19p pd=1.38u as=0 ps=0 w=1u l=1u
X132 VPWR VGND.t97 VPWR VPWR sg13_lv_pmos ad=0.34p pd=2.68u as=0 ps=0 w=1u l=1u
X133 a_10933_6516# a_11371_6137# a_11827_6219# VPWR sg13_lv_pmos ad=0.19p pd=1.38u as=0.16p ps=1.32u w=1u l=0.13u
X134 VGND.t139 sg13cmos5l_inv_1_98.A sg13cmos5l_inv_1_98.Y VGND.t55 sg13_lv_nmos ad=0.2516p pd=2.16u as=0.2516p ps=2.16u w=0.74u l=0.13u
X135 VPWR VGND.t258 VPWR VPWR sg13_lv_pmos ad=0.34p pd=2.68u as=0 ps=0 w=1u l=1u
X136 a_14524_6538# sg13cmos5l_mux2_1_6.A1 a_14030_6434# VGND.t879 sg13_lv_nmos ad=0.13135p pd=1.095u as=0.1628p ps=1.18u w=0.74u l=0.13u
X137 VGND.t347 VPWR VGND.t298 VGND.t21 sg13_lv_nmos ad=79.8f pd=0.8u as=0 ps=0 w=0.42u l=1u
X138 VGND.t386 VPWR VGND.t386 VGND.t19 sg13_lv_nmos ad=0.1428p pd=1.52u as=0 ps=0 w=0.42u l=1u
X139 a_12062_4680# sg13cmos5l_inv_1_123.A a_11630_4922# VPWR sg13_lv_pmos ad=0.3325p pd=1.665u as=0.2225p ps=1.445u w=1u l=0.13u
X140 VGND.t292 a_3990_4069# sg13cmos5l_dfrbp_1_0.Q VGND.t21 sg13_lv_nmos ad=0.1406p pd=1.12u as=0.2516p ps=2.16u w=0.74u l=0.13u
X141 VPWR VGND.t325 VPWR VPWR sg13_lv_pmos ad=0.34p pd=2.68u as=0 ps=0 w=1u l=1u
X142 VPWR sg13cmos5l_o21ai_1_1.A2 sg13cmos5l_inv_1_35.Y VPWR sg13_lv_pmos ad=0.3808p pd=2.92u as=0.3808p ps=2.92u w=1.12u l=0.13u
X143 a_13917_7950# sg13cmos5l_inv_1_93.A VPWR VPWR sg13_lv_pmos ad=0.2856p pd=2.36u as=0.2198p ps=1.53u w=0.84u l=0.13u
X144 VGND.t3 sg13cmos5l_inv_1_72.A sg13cmos5l_inv_1_72.Y VGND.t44 sg13_lv_nmos ad=0.2516p pd=2.16u as=0.2516p ps=2.16u w=0.74u l=0.13u
X145 VGND.t210 VPWR VGND.t235 VGND.t236 sg13_lv_nmos ad=0.1428p pd=1.52u as=0 ps=0 w=0.42u l=1u
X146 VGND.t20 ffsel[1] a_808_2420# VGND.t19 sg13_lv_nmos ad=0.14875p pd=1.16u as=0.187p ps=1.78u w=0.55u l=0.13u
X147 VPWR VGND.t394 VPWR VPWR sg13_lv_pmos ad=0.34p pd=2.68u as=0 ps=0 w=1u l=1u
X148 a_5014_6558# sg13cmos5l_mux4_1_0.S0 a_4933_6219# VPWR sg13_lv_pmos ad=0.4425p pd=1.885u as=0.20762p ps=1.605u w=1u l=0.13u
X149 sg13cmos5l_buf_1_12.X a_808_5444# VGND.t36 VGND.t35 sg13_lv_nmos ad=0.2886p pd=2.26u as=0.14875p ps=1.16u w=0.74u l=0.13u
X150 sg13cmos5l_dfrbp_1_1.Q a_9044_3144# VGND.t23 VGND.t21 sg13_lv_nmos ad=0.2516p pd=2.16u as=0.1406p ps=1.12u w=0.74u l=0.13u
X151 VGND.t1 VPWR VGND.t1 VGND.t229 sg13_lv_nmos ad=0.1428p pd=1.52u as=0 ps=0 w=0.42u l=1u
X152 VGND.t331 VPWR VGND.t333 VGND.t21 sg13_lv_nmos ad=79.8f pd=0.8u as=0 ps=0 w=0.42u l=1u
X153 VPWR VGND.t248 VPWR VPWR sg13_lv_pmos ad=0.19p pd=1.38u as=0 ps=0 w=1u l=1u
X154 a_5237_6173# a_4199_6558# a_5014_6558# VPWR sg13_lv_pmos ad=0.135p pd=1.27u as=0.4425p ps=1.885u w=1u l=0.13u
X155 VPWR VGND.t386 VPWR VPWR sg13_lv_pmos ad=0.34p pd=2.68u as=0 ps=0 w=1u l=1u
X156 VGND.t320 VPWR VGND.t319 VGND.t293 sg13_lv_nmos ad=0.1428p pd=1.52u as=0 ps=0 w=0.42u l=1u
X157 VGND.t72 VPWR VGND.t72 VGND.t73 sg13_lv_nmos ad=79.8f pd=0.8u as=0 ps=0 w=0.42u l=1u
X158 sg13cmos5l_inv_1_66.A sg13cmos5l_inv_1_70.Y VGND.t18 VGND.t17 sg13_lv_nmos ad=0.2516p pd=2.16u as=0.2516p ps=2.16u w=0.74u l=0.13u
X159 VGND.t412 VPWR VGND.t412 VGND.t19 sg13_lv_nmos ad=0.1428p pd=1.52u as=0 ps=0 w=0.42u l=1u
X160 sg13cmos5l_mux2_1_1.X a_4510_5026# VGND.t627 VGND.t626 sg13_lv_nmos ad=0.4033p pd=2.57u as=0.148p ps=1.14u w=0.74u l=0.13u
X161 sg13cmos5l_nor2b_1_0.B_N sg13cmos5l_a221oi_1_0.B1 a_6676_6944# VGND.t848 sg13_lv_nmos ad=0.2516p pd=2.16u as=0.1406p ps=1.12u w=0.74u l=0.13u
X162 VGND.t622 sg13cmos5l_inv_1_73.A sg13cmos5l_inv_1_73.Y VGND.t643 sg13_lv_nmos ad=0.2516p pd=2.16u as=0.2516p ps=2.16u w=0.74u l=0.13u
X163 VPWR VGND.t102 VPWR VPWR sg13_lv_pmos ad=0.34p pd=2.68u as=0 ps=0 w=1u l=1u
X164 a_4317_8728# sg13cmos5l_buf_1_4.A VPWR VPWR sg13_lv_pmos ad=0.3325p pd=1.665u as=0.253p ps=1.53u w=1u l=0.13u
X165 VGND.t97 VPWR VGND.t97 VGND.t124 sg13_lv_nmos ad=79.8f pd=0.8u as=0 ps=0 w=0.42u l=1u
X166 a_6574_7216# sg13cmos5l_a221oi_1_0.C1 sg13cmos5l_nor2b_1_0.B_N VPWR sg13_lv_pmos ad=0.2128p pd=1.5u as=0.3808p ps=2.92u w=1.12u l=0.13u
X167 a_4750_3582# a_4492_3582# VGND.t292 VGND.t21 sg13_lv_nmos ad=0.1428p pd=1.52u as=79.8f ps=0.8u w=0.42u l=0.13u
X168 VGND.t1 sg13cmos5l_nor2_1_1.A sg13cmos5l_nor4_1_0.D VGND.t639 sg13_lv_nmos ad=0.2516p pd=2.16u as=0.1406p ps=1.12u w=0.74u l=0.13u
X169 a_1918_8434# sg13cmos5l_mux2_1_3.A0 a_1821_8728# VPWR sg13_lv_pmos ad=0.2225p pd=1.445u as=0.3325p ps=1.665u w=1u l=0.13u
X170 VGND.t104 VPWR VGND.t104 VGND.t105 sg13_lv_nmos ad=0.1428p pd=1.52u as=0 ps=0 w=0.42u l=1u
X171 VGND.t28 sg13cmos5l_inv_1_22.Y sg13cmos5l_and2_1_0.B VGND.t27 sg13_lv_nmos ad=0.2516p pd=2.16u as=0.1406p ps=1.12u w=0.74u l=0.13u
X172 VPWR VGND.t3 VPWR VPWR sg13_lv_pmos ad=0.34p pd=2.68u as=0 ps=0 w=1u l=1u
X173 VPWR VGND.t155 VPWR VPWR sg13_lv_pmos ad=0.34p pd=2.68u as=0 ps=0 w=1u l=1u
X174 VGND.t420 VPWR VGND.t420 VGND.t19 sg13_lv_nmos ad=0.1428p pd=1.52u as=0 ps=0 w=0.42u l=1u
X175 VPWR VGND.t147 VPWR VPWR sg13_lv_pmos ad=0.19p pd=1.38u as=0 ps=0 w=1u l=1u
X176 VGND.t5 VPWR VGND.t5 VGND.t266 sg13_lv_nmos ad=0.1428p pd=1.52u as=0 ps=0 w=0.42u l=1u
X177 VPWR a_1563_6224# sg13cmos5l_o21ai_1_0.B1 VPWR sg13_lv_pmos ad=0.3808p pd=2.92u as=0.2128p ps=1.5u w=1.12u l=0.13u
X178 VGND.t72 VPWR VGND.t72 VGND.t78 sg13_lv_nmos ad=0.1428p pd=1.52u as=0 ps=0 w=0.42u l=1u
X179 VPWR sg13cmos5l_and2_1_0.X sg13cmos5l_inv_1_119.Y VPWR sg13_lv_pmos ad=0.3808p pd=2.92u as=0.3808p ps=2.92u w=1.12u l=0.13u
X180 sg13cmos5l_inv_1_138.Y sg13cmos5l_inv_1_119.Y VGND.t28 VGND.t655 sg13_lv_nmos ad=0.2516p pd=2.16u as=0.2516p ps=2.16u w=0.74u l=0.13u
X181 VGND.t322 VPWR VGND.t324 VGND.t21 sg13_lv_nmos ad=79.8f pd=0.8u as=0 ps=0 w=0.42u l=1u
X182 sg13cmos5l_o21ai_1_2.B1 a_13917_9462# VPWR VPWR sg13_lv_pmos ad=0.2128p pd=1.5u as=0.3808p ps=2.92u w=1.12u l=0.13u
X183 VPWR VGND.t208 VPWR VPWR sg13_lv_pmos ad=0.34p pd=2.68u as=0 ps=0 w=1u l=1u
X184 VGND.t292 a_4109_3858# sg13cmos5l_dfrbp_1_0.D VGND.t21 sg13_lv_nmos ad=0.2516p pd=2.16u as=0.2849p ps=2.25u w=0.74u l=0.13u
X185 VGND.t147 VPWR VGND.t147 VGND.t51 sg13_lv_nmos ad=79.8f pd=0.8u as=0 ps=0 w=0.42u l=1u
X186 VPWR VGND.t394 VPWR VPWR sg13_lv_pmos ad=0.34p pd=2.68u as=0 ps=0 w=1u l=1u
X187 VPWR a_8207_3505# a_8464_3386# VPWR sg13_lv_pmos ad=0.2639p pd=1.81u as=79.8f ps=0.8u w=0.42u l=0.13u
X188 a_6948_3148# a_6922_3112# VGND.t30 VGND.t678 sg13_lv_nmos ad=0.2516p pd=2.16u as=0.1626p ps=1.415u w=0.74u l=0.13u
X189 VPWR VGND.t319 VPWR VPWR sg13_lv_pmos ad=0.34p pd=2.68u as=0 ps=0 w=1u l=1u
X190 VPWR VGND.t1 VPWR VPWR sg13_lv_pmos ad=0.34p pd=2.68u as=0 ps=0 w=1u l=1u
X191 VPWR sg13cmos5l_inv_1_24.A sg13cmos5l_o21ai_1_1.A2 VPWR sg13_lv_pmos ad=0.3808p pd=2.92u as=0.3808p ps=2.92u w=1.12u l=0.13u
X192 VGND.t3 sg13cmos5l_buf_1_4.A a_1595_8472# VGND.t757 sg13_lv_nmos ad=0.18945p pd=1.27u as=0.187p ps=1.78u w=0.55u l=0.13u
X193 sg13cmos5l_buf_1_1.X a_808_2420# VPWR VPWR sg13_lv_pmos ad=0.42p pd=2.99u as=0.2114p ps=1.54u w=1.12u l=0.13u
X194 VPWR VGND.t394 VPWR VPWR sg13_lv_pmos ad=0.19p pd=1.38u as=0 ps=0 w=1u l=1u
X195 VPWR sg13cmos5l_buf_1_2.X a_10151_8434# VPWR sg13_lv_pmos ad=0.22315p pd=1.555u as=0.34p ps=2.68u w=1u l=0.13u
X196 VPWR sg13cmos5l_dfrbp_1_2.RESET_B.t2 a_6922_3112# VPWR sg13_lv_pmos ad=0.1563p pd=1.22u as=0.147p ps=1.54u w=0.42u l=0.13u
X197 VGND.t706 sg13cmos5l_dfrbp_1_2.RESET_B.t3 a_6038_3569# VGND.t707 sg13_lv_nmos ad=0.1701p pd=1.65u as=37.8f ps=0.6u w=0.42u l=0.13u
X198 VGND.t334 VPWR VGND.t336 VGND.t21 sg13_lv_nmos ad=79.8f pd=0.8u as=0 ps=0 w=0.42u l=1u
X199 sg13cmos5l_inv_1_11.A sg13cmos5l_inv_1_118.Y VGND.t5 VGND.t901 sg13_lv_nmos ad=0.2516p pd=2.16u as=0.2516p ps=2.16u w=0.74u l=0.13u
X200 VPWR a_4860_3858# a_5883_4285# VPWR sg13_lv_pmos ad=0.1563p pd=1.22u as=63f ps=0.72u w=0.42u l=0.13u
X201 VGND.t54 sg13cmos5l_inv_1_95.A sg13cmos5l_inv_1_94.A VGND.t702 sg13_lv_nmos ad=0.2516p pd=2.16u as=0.2516p ps=2.16u w=0.74u l=0.13u
X202 VPWR sg13cmos5l_o21ai_1_2.B1 sg13cmos5l_mux4_1_3.A1 VPWR sg13_lv_pmos ad=0.3808p pd=2.92u as=0.2128p ps=1.5u w=1.12u l=0.15u
X203 VGND.t412 VPWR VGND.t412 VGND.t19 sg13_lv_nmos ad=0.1428p pd=1.52u as=0 ps=0 w=0.42u l=1u
X204 VPWR sg13cmos5l_dfrbp_1_2.RESET_B.t4 a_4492_3582# VPWR sg13_lv_pmos ad=3.76885p pd=24.785u as=79.8f ps=0.8u w=0.42u l=0.13u
X205 VPWR sg13cmos5l_inv_1_11.A sg13cmos5l_inv_1_14.A VPWR sg13_lv_pmos ad=0.3808p pd=2.92u as=0.3808p ps=2.92u w=1.12u l=0.13u
X206 VGND.t14 VPWR VGND.t64 VGND.t63 sg13_lv_nmos ad=0.1428p pd=1.52u as=0 ps=0 w=0.42u l=1u
X207 sg13cmos5l_inv_1_66.A sg13cmos5l_inv_1_70.Y VPWR VPWR sg13_lv_pmos ad=0.3808p pd=2.92u as=0.3808p ps=2.92u w=1.12u l=0.13u
X208 sg13cmos5l_inv_1_26.Y sg13cmos5l_inv_1_25.Y VPWR VPWR sg13_lv_pmos ad=0.3808p pd=2.92u as=0.3808p ps=2.92u w=1.12u l=0.13u
X209 a_5110_5402# sg13cmos5l_inv_1_12.Y VGND.t627 VGND.t826 sg13_lv_nmos ad=0.1406p pd=1.12u as=0.1406p ps=1.12u w=0.74u l=0.15u
X210 VGND.t16 sg13cmos5l_inv_1_52.A sg13cmos5l_mux2_1_3.A0 VGND.t15 sg13_lv_nmos ad=0.2516p pd=2.16u as=0.2516p ps=2.16u w=0.74u l=0.13u
X211 VGND.t627 sg13cmos5l_o21ai_1_0.A1 a_3862_5402# VGND.t803 sg13_lv_nmos ad=0.1406p pd=1.12u as=0.2516p ps=2.16u w=0.74u l=0.15u
X212 VPWR VGND.t72 VPWR VPWR sg13_lv_pmos ad=0.34p pd=2.68u as=0 ps=0 w=1u l=1u
X213 VGND.t72 VPWR VGND.t49 VGND.t71 sg13_lv_nmos ad=0.1428p pd=1.52u as=0 ps=0 w=0.42u l=1u
X214 VGND.t494 VPWR VGND.t493 VGND.t492 sg13_lv_nmos ad=0.1428p pd=1.52u as=0 ps=0 w=0.42u l=1u
X215 VGND.t97 VPWR VGND.t97 VGND.t126 sg13_lv_nmos ad=79.8f pd=0.8u as=0 ps=0 w=0.42u l=1u
X216 VPWR VGND.t420 VPWR VPWR sg13_lv_pmos ad=0.34p pd=2.68u as=0 ps=0 w=1u l=1u
X217 VPWR sg13cmos5l_inv_1_33.Y a_2043_6960# VPWR sg13_lv_pmos ad=0.2198p pd=1.53u as=0.2856p ps=2.36u w=0.84u l=0.13u
X218 VGND.t46 a_4283_9248# a_4720_9562# VGND.t45 sg13_lv_nmos ad=0.148p pd=1.14u as=0.3367p ps=1.65u w=0.74u l=0.13u
X219 VGND.t248 VPWR VGND.t248 VGND.t249 sg13_lv_nmos ad=79.8f pd=0.8u as=0 ps=0 w=0.42u l=1u
X220 VGND.t686 sg13cmos5l_buf_1_12.X a_10120_6168# VGND.t961 sg13_lv_nmos ad=0.14875p pd=1.16u as=0.187p ps=1.78u w=0.55u l=0.13u
X221 sg13cmos5l_inv_1_8.Y sg13cmos5l_inv_1_7.Y VGND.t26 VGND.t964 sg13_lv_nmos ad=0.2516p pd=2.16u as=0.2516p ps=2.16u w=0.74u l=0.13u
X222 VPWR VGND.t66 VPWR VPWR sg13_lv_pmos ad=0.34p pd=2.68u as=0 ps=0 w=1u l=1u
X223 VPWR VGND.t310 VPWR VPWR sg13_lv_pmos ad=0.34p pd=2.68u as=0 ps=0 w=1u l=1u
X224 VPWR VGND.t147 VPWR VPWR sg13_lv_pmos ad=0.19p pd=1.38u as=0 ps=0 w=1u l=1u
X225 VPWR sg13cmos5l_inv_1_33.A sg13cmos5l_inv_1_33.Y VPWR sg13_lv_pmos ad=0.3808p pd=2.92u as=0.3808p ps=2.92u w=1.12u l=0.13u
X226 a_4860_3505# a_4991_3115# a_4109_3108# VPWR sg13_lv_pmos ad=0.34p pd=2.68u as=0.2048p ps=1.63u w=1u l=0.13u
X227 VPWR sg13cmos5l_dfrbp_1_0.D a_5687_4285# VPWR sg13_lv_pmos ad=0.1428p pd=1.52u as=79.8f ps=0.8u w=0.42u l=0.13u
X228 VGND.t292 VPWR VGND.t291 VGND.t21 sg13_lv_nmos ad=0.1428p pd=1.52u as=0 ps=0 w=0.42u l=1u
X229 VGND.t325 VPWR VGND.t326 VGND.t21 sg13_lv_nmos ad=79.8f pd=0.8u as=0 ps=0 w=0.42u l=1u
X230 VGND.t87 sg13cmos5l_inv_1_107.A sg13cmos5l_inv_1_107.Y VGND.t624 sg13_lv_nmos ad=0.2516p pd=2.16u as=0.2516p ps=2.16u w=0.74u l=0.13u
X231 VPWR VGND.t235 VPWR VPWR sg13_lv_pmos ad=0.34p pd=2.68u as=0 ps=0 w=1u l=1u
X232 sg13cmos5l_a21oi_1_0.Y sg13cmos5l_inv_1_22.Y a_6197_4656# VPWR sg13_lv_pmos ad=0.3808p pd=2.92u as=0.2128p ps=1.5u w=1.12u l=0.13u
X233 VGND.t155 VPWR VGND.t155 VGND.t51 sg13_lv_nmos ad=79.8f pd=0.8u as=0 ps=0 w=0.42u l=1u
X234 VGND.t97 VPWR VGND.t97 VGND.t99 sg13_lv_nmos ad=0.1428p pd=1.52u as=0 ps=0 w=0.42u l=1u
X235 VPWR VGND.t394 VPWR VPWR sg13_lv_pmos ad=0.34p pd=2.68u as=0 ps=0 w=1u l=1u
X236 VPWR sg13cmos5l_dfrbp_1_2.RESET_B.t2 a_6662_3582# VPWR sg13_lv_pmos ad=0.36237p pd=2.605u as=79.8f ps=0.8u w=0.42u l=0.13u
X237 a_1821_8728# sg13cmos5l_buf_1_4.A VPWR VPWR sg13_lv_pmos ad=0.3325p pd=1.665u as=0.253p ps=1.53u w=1u l=0.13u
X238 VGND.t137 sg13cmos5l_buf_1_10.X a_12022_8058# VGND.t51 sg13_lv_nmos ad=0.1406p pd=1.12u as=0.2516p ps=2.16u w=0.74u l=0.15u
X239 VPWR sg13cmos5l_mux2_1_0.X a_11600_6173# VPWR sg13_lv_pmos ad=0.29275p pd=1.785u as=0.20762p ps=1.605u w=1u l=0.13u
X240 VPWR VGND.t64 VPWR VPWR sg13_lv_pmos ad=0.34p pd=2.68u as=0 ps=0 w=1u l=1u
X241 VGND.t564 VPWR VGND.t563 VGND.t562 sg13_lv_nmos ad=0.1428p pd=1.52u as=0 ps=0 w=0.42u l=1u
X242 a_4624_5026# sg13cmos5l_dfrbp_1_2.D a_4510_5026# VGND.t632 sg13_lv_nmos ad=0.3367p pd=1.65u as=0.1628p ps=1.18u w=0.74u l=0.13u
X243 sg13cmos5l_inv_1_85.A sg13cmos5l_mux2_1_6.A0 VGND.t216 VGND.t629 sg13_lv_nmos ad=0.2516p pd=2.16u as=0.2516p ps=2.16u w=0.74u l=0.13u
X244 VGND.t316 VPWR VGND.t318 VGND.t21 sg13_lv_nmos ad=79.8f pd=0.8u as=0 ps=0 w=0.42u l=1u
X245 VGND.t3 a_1595_8472# a_2032_8434# VGND.t772 sg13_lv_nmos ad=0.148p pd=1.14u as=0.3367p ps=1.65u w=0.74u l=0.13u
X246 VGND.t14 sg13cmos5l_mux2_1_4.A1 sg13cmos5l_inv_1_38.A VGND.t748 sg13_lv_nmos ad=0.2516p pd=2.16u as=0.2516p ps=2.16u w=0.74u l=0.13u
X247 a_5287_8701# sg13cmos5l_mux4_1_1.A0 VPWR VPWR sg13_lv_pmos ad=0.415p pd=1.83u as=0.22315p ps=1.555u w=1u l=0.13u
X248 VGND.t420 VPWR VGND.t412 VGND.t19 sg13_lv_nmos ad=0.1428p pd=1.52u as=0 ps=0 w=0.42u l=1u
X249 a_10715_6528# sg13cmos5l_buf_1_2.X VPWR VPWR sg13_lv_pmos ad=0.34p pd=2.68u as=0.34367p ps=1.775u w=1u l=0.13u
X250 VPWR VGND.t72 VPWR VPWR sg13_lv_pmos ad=0.34p pd=2.68u as=0 ps=0 w=1u l=1u
X251 VPWR VGND.t612 VPWR VPWR sg13_lv_pmos ad=0.34p pd=2.68u as=0 ps=0 w=1u l=1u
X252 VGND.t39 VPWR VGND.t39 VGND.t21 sg13_lv_nmos ad=79.8f pd=0.8u as=0 ps=0 w=0.42u l=1u
X253 VGND.t10 sg13cmos5l_inv_1_20.A sg13cmos5l_inv_1_130.A VGND.t712 sg13_lv_nmos ad=0.2516p pd=2.16u as=0.2516p ps=2.16u w=0.74u l=0.13u
X254 a_5743_10240# sg13cmos5l_inv_1_70.A a_5566_9946# VPWR sg13_lv_pmos ad=0.2975p pd=1.595u as=0.2225p ps=1.445u w=1u l=0.13u
X255 VGND.t67 VPWR VGND.t16 VGND.t68 sg13_lv_nmos ad=79.8f pd=0.8u as=0 ps=0 w=0.42u l=1u
X256 VPWR sg13cmos5l_inv_1_52.A sg13cmos5l_mux2_1_3.A0 VPWR sg13_lv_pmos ad=0.3808p pd=2.92u as=0.3808p ps=2.92u w=1.12u l=0.13u
X257 VGND.t72 VPWR VGND.t72 VGND.t74 sg13_lv_nmos ad=0.1428p pd=1.52u as=0 ps=0 w=0.42u l=1u
X258 VPWR VGND.t92 VPWR VPWR sg13_lv_pmos ad=0.19p pd=1.38u as=0 ps=0 w=1u l=1u
X259 VGND.t52 sg13cmos5l_buf_1_10.X a_9622_8426# VGND.t929 sg13_lv_nmos ad=0.1406p pd=1.12u as=0.2516p ps=2.16u w=0.74u l=0.15u
X260 VGND.t102 VPWR VGND.t104 VGND.t128 sg13_lv_nmos ad=79.8f pd=0.8u as=0 ps=0 w=0.42u l=1u
X261 VPWR VGND.t402 VPWR VPWR sg13_lv_pmos ad=0.34p pd=2.68u as=0 ps=0 w=1u l=1u
X262 sg13cmos5l_inv_1_0.Y sg13cmos5l_inv_1_124.Y VPWR VPWR sg13_lv_pmos ad=0.3808p pd=2.92u as=0.3808p ps=2.92u w=1.12u l=0.13u
X263 sg13cmos5l_nand2_1_1.A a_808_8468# VPWR VPWR sg13_lv_pmos ad=0.42p pd=2.99u as=0.2114p ps=1.54u w=1.12u l=0.13u
X264 VGND.t72 VPWR VGND.t72 VGND.t79 sg13_lv_nmos ad=79.8f pd=0.8u as=0 ps=0 w=0.42u l=1u
X265 VGND.t92 VPWR VGND.t89 VGND.t91 sg13_lv_nmos ad=0.1428p pd=1.52u as=0 ps=0 w=0.42u l=1u
X266 VPWR VGND.t386 VPWR VPWR sg13_lv_pmos ad=0.34p pd=2.68u as=0 ps=0 w=1u l=1u
X267 VGND.t10 a_10139_5448# a_10576_5410# VGND.t631 sg13_lv_nmos ad=0.148p pd=1.14u as=0.3367p ps=1.65u w=0.74u l=0.13u
X268 VPWR VGND.t72 VPWR VPWR sg13_lv_pmos ad=0.19p pd=1.38u as=0 ps=0 w=1u l=1u
X269 VGND.t21 a_7365_3155# a_7467_3155# VGND.t959 sg13_lv_nmos ad=5.21338p pd=34.275u as=0.2516p ps=2.16u w=0.74u l=0.13u
X270 sg13cmos5l_nor4_1_0.Y sg13cmos5l_nor4_1_0.D a_7362_4192# VPWR sg13_lv_pmos ad=0.4368p pd=3.02u as=0.2128p ps=1.5u w=1.12u l=0.13u
X271 VPWR VGND.t39 VPWR VPWR sg13_lv_pmos ad=0.34p pd=2.68u as=0 ps=0 w=1u l=1u
X272 VGND.t55 VPWR VGND.t55 VGND.t171 sg13_lv_nmos ad=79.8f pd=0.8u as=0 ps=0 w=0.42u l=1u
X273 VPWR sg13cmos5l_inv_1_76.A sg13cmos5l_inv_1_33.A VPWR sg13_lv_pmos ad=0.3808p pd=2.92u as=0.3808p ps=2.92u w=1.12u l=0.13u
X274 sg13cmos5l_inv_1_9.Y sg13cmos5l_inv_1_5.Y VPWR VPWR sg13_lv_pmos ad=0.3808p pd=2.92u as=0.3808p ps=2.92u w=1.12u l=0.13u
X275 VGND.t307 VPWR VGND.t357 VGND.t21 sg13_lv_nmos ad=79.8f pd=0.8u as=0 ps=0 w=0.42u l=1u
X276 VGND.t1 VPWR VGND.t1 VGND.t205 sg13_lv_nmos ad=79.8f pd=0.8u as=0 ps=0 w=0.42u l=1u
X277 VPWR sg13cmos5l_inv_1_107.A sg13cmos5l_inv_1_107.Y VPWR sg13_lv_pmos ad=0.3808p pd=2.92u as=0.3808p ps=2.92u w=1.12u l=0.13u
X278 a_14202_5410# a_14136_5600# VGND.t26 VGND.t857 sg13_lv_nmos ad=0.3367p pd=1.65u as=0.148p ps=1.14u w=0.74u l=0.13u
X279 VPWR VGND.t386 VPWR VPWR sg13_lv_pmos ad=0.34p pd=2.68u as=0 ps=0 w=1u l=1u
X280 VPWR VGND.t161 VPWR VPWR sg13_lv_pmos ad=0.34p pd=2.68u as=0 ps=0 w=1u l=1u
X281 VPWR sg13cmos5l_inv_1_98.A sg13cmos5l_inv_1_98.Y VPWR sg13_lv_pmos ad=0.3808p pd=2.92u as=0.3808p ps=2.92u w=1.12u l=0.13u
X282 VGND.t529 VPWR VGND.t531 VGND.t530 sg13_lv_nmos ad=79.8f pd=0.8u as=0 ps=0 w=0.42u l=1u
X283 VPWR sg13cmos5l_inv_1_35.Y sg13cmos5l_inv_1_29.A VPWR sg13_lv_pmos ad=0.3808p pd=2.92u as=0.3808p ps=2.92u w=1.12u l=0.13u
X284 VGND.t92 VPWR VGND.t97 VGND.t122 sg13_lv_nmos ad=79.8f pd=0.8u as=0 ps=0 w=0.42u l=1u
X285 VGND.t319 VPWR VGND.t321 VGND.t21 sg13_lv_nmos ad=79.8f pd=0.8u as=0 ps=0 w=0.42u l=1u
X286 a_5781_3191# sg13cmos5l_dfrbp_1_2.RESET_B.t3 VPWR VPWR sg13_lv_pmos ad=0.147p pd=1.54u as=0.1563p ps=1.22u w=0.42u l=0.13u
X287 sg13cmos5l_o21ai_1_7.Y sg13cmos5l_o21ai_1_7.B1 a_3862_5402# VGND.t853 sg13_lv_nmos ad=0.2516p pd=2.16u as=0.1406p ps=1.12u w=0.74u l=0.15u
X288 VPWR VGND.t402 VPWR VPWR sg13_lv_pmos ad=0.34p pd=2.68u as=0 ps=0 w=1u l=1u
X289 VGND.t262 VPWR VGND.t262 VGND.t265 sg13_lv_nmos ad=0.1428p pd=1.52u as=0 ps=0 w=0.42u l=1u
X290 a_12175_9562# a_12093_9462# sg13cmos5l_o21ai_1_6.B1 VGND.t745 sg13_lv_nmos ad=0.1406p pd=1.12u as=0.333p ps=2.38u w=0.74u l=0.13u
X291 VPWR VGND.t139 VPWR VPWR sg13_lv_pmos ad=0.19p pd=1.38u as=0 ps=0 w=1u l=1u
X292 VGND.t147 VPWR VGND.t147 VGND.t51 sg13_lv_nmos ad=79.8f pd=0.8u as=0 ps=0 w=0.42u l=1u
X293 VGND.t254 VPWR VGND.t254 VGND.t274 sg13_lv_nmos ad=0.1428p pd=1.52u as=0 ps=0 w=0.42u l=1u
X294 sg13cmos5l_inv_1_117.A sg13cmos5l_inv_1_132.Y VPWR VPWR sg13_lv_pmos ad=0.3808p pd=2.92u as=0.3808p ps=2.92u w=1.12u l=0.13u
X295 VPWR VGND.t104 VPWR VPWR sg13_lv_pmos ad=0.34p pd=2.68u as=0 ps=0 w=1u l=1u
X296 VPWR VGND.t26 VPWR VPWR sg13_lv_pmos ad=0.34p pd=2.68u as=0 ps=0 w=1u l=1u
X297 VGND.t72 VPWR VGND.t72 VGND.t76 sg13_lv_nmos ad=0.1428p pd=1.52u as=0 ps=0 w=0.42u l=1u
X298 sg13cmos5l_inv_1_6.Y sg13cmos5l_inv_1_6.A VGND.t356 VGND.t293 sg13_lv_nmos ad=0.2516p pd=2.16u as=0.2516p ps=2.16u w=0.74u l=0.13u
X299 a_7629_5004# sg13cmos5l_nor2b_1_0.B_N VPWR VPWR sg13_lv_pmos ad=0.1596p pd=1.22u as=0.2856p ps=2.36u w=0.84u l=0.13u
X300 VPWR VGND.t410 VPWR VPWR sg13_lv_pmos ad=0.34p pd=2.68u as=0 ps=0 w=1u l=1u
X301 VGND.t1 sg13cmos5l_a221oi_1_0.A2 a_6982_6944# VGND.t728 sg13_lv_nmos ad=0.2516p pd=2.16u as=0.1406p ps=1.12u w=0.74u l=0.13u
X302 VGND.t328 VPWR VGND.t327 VGND.t21 sg13_lv_nmos ad=0.1428p pd=1.52u as=0 ps=0 w=0.42u l=1u
X303 a_6922_3112# a_7365_3155# a_6662_3582# VGND.t958 sg13_lv_nmos ad=79.8f pd=0.8u as=0.1296p ps=1.52u w=0.42u l=0.13u
X304 sg13cmos5l_inv_1_15.Y sg13cmos5l_inv_1_16.Y VPWR VPWR sg13_lv_pmos ad=0.3808p pd=2.92u as=0.3808p ps=2.92u w=1.12u l=0.13u
X305 VGND.t598 VPWR VGND.t600 VGND.t599 sg13_lv_nmos ad=79.8f pd=0.8u as=0 ps=0 w=0.42u l=1u
X306 sg13cmos5l_mux4_1_3.A1 sg13cmos5l_o21ai_1_2.B1 a_11446_9570# VGND.t834 sg13_lv_nmos ad=0.2516p pd=2.16u as=0.1406p ps=1.12u w=0.74u l=0.15u
X307 VGND.t49 VPWR VGND.t49 VGND.t69 sg13_lv_nmos ad=0.1428p pd=1.52u as=0 ps=0 w=0.42u l=1u
X308 VGND.t67 VPWR VGND.t66 VGND.t109 sg13_lv_nmos ad=0.1428p pd=1.52u as=0 ps=0 w=0.42u l=1u
X309 VGND.t622 sg13cmos5l_inv_1_76.A sg13cmos5l_inv_1_33.A VGND.t621 sg13_lv_nmos ad=0.2516p pd=2.16u as=0.2516p ps=2.16u w=0.74u l=0.13u
X310 VGND.t310 VPWR VGND.t359 VGND.t21 sg13_lv_nmos ad=79.8f pd=0.8u as=0 ps=0 w=0.42u l=1u
X311 VPWR VGND.t147 VPWR VPWR sg13_lv_pmos ad=0.34p pd=2.68u as=0 ps=0 w=1u l=1u
X312 a_4413_5026# sg13cmos5l_buf_1_0.X VGND.t627 VGND.t731 sg13_lv_nmos ad=0.13135p pd=1.095u as=0.18945p ps=1.27u w=0.74u l=0.13u
X313 VGND.t87 VPWR VGND.t87 VGND.t86 sg13_lv_nmos ad=0.1428p pd=1.52u as=0 ps=0 w=0.42u l=1u
X314 VGND.t56 sg13cmos5l_inv_1_97.A sg13cmos5l_o21ai_1_3.A2 VGND.t55 sg13_lv_nmos ad=0.2516p pd=2.16u as=0.2516p ps=2.16u w=0.74u l=0.13u
X315 VGND.t199 sg13cmos5l_inv_1_29.A sg13cmos5l_inv_1_29.Y VGND.t839 sg13_lv_nmos ad=0.2516p pd=2.16u as=0.2516p ps=2.16u w=0.74u l=0.13u
X316 sg13cmos5l_inv_1_3.Y sg13cmos5l_inv_1_6.Y VPWR VPWR sg13_lv_pmos ad=0.3808p pd=2.92u as=0.3808p ps=2.92u w=1.12u l=0.13u
X317 VGND.t161 sg13cmos5l_inv_1_35.Y sg13cmos5l_inv_1_29.A VGND.t687 sg13_lv_nmos ad=0.2516p pd=2.16u as=0.2516p ps=2.16u w=0.74u l=0.13u
X318 VPWR VGND.t402 VPWR VPWR sg13_lv_pmos ad=0.34p pd=2.68u as=0 ps=0 w=1u l=1u
X319 a_10904_6168# sg13cmos5l_mux4_1_0.S0 a_11409_6558# VGND.t796 sg13_lv_nmos ad=0.1776p pd=1.195u as=76.8f ps=0.88u w=0.64u l=0.13u
X320 VPWR VGND.t196 VPWR VPWR sg13_lv_pmos ad=0.34p pd=2.68u as=0 ps=0 w=1u l=1u
X321 sg13cmos5l_dfrbp_1_1.CLK sg13cmos5l_nor4_1_0.D a_7948_4192# VPWR sg13_lv_pmos ad=0.3808p pd=2.92u as=0.1176p ps=1.33u w=1.12u l=0.13u
X322 VGND.t534 VPWR VGND.t536 VGND.t535 sg13_lv_nmos ad=79.8f pd=0.8u as=0 ps=0 w=0.42u l=1u
X323 VGND.t319 VPWR VGND.t318 VGND.t21 sg13_lv_nmos ad=0.1428p pd=1.52u as=0 ps=0 w=0.42u l=1u
X324 VGND.t72 VPWR VGND.t72 VGND.t113 sg13_lv_nmos ad=79.8f pd=0.8u as=0 ps=0 w=0.42u l=1u
X325 VPWR sg13cmos5l_o21ai_1_0.A1 a_4316_7236# VPWR sg13_lv_pmos ad=0.3808p pd=2.92u as=0.2128p ps=1.5u w=1.12u l=0.15u
X326 VPWR VGND.t104 VPWR VPWR sg13_lv_pmos ad=0.19p pd=1.38u as=0 ps=0 w=1u l=1u
X327 a_5505_6516# sg13cmos5l_buf_1_2.X a_4510_6558# VPWR sg13_lv_pmos ad=0.2225p pd=1.445u as=0.34p ps=2.68u w=1u l=0.13u
X328 VGND.t141 VPWR VGND.t139 VGND.t55 sg13_lv_nmos ad=0.1428p pd=1.52u as=0 ps=0 w=0.42u l=1u
X329 VGND.t164 VPWR VGND.t164 VGND.t165 sg13_lv_nmos ad=0.1428p pd=1.52u as=0 ps=0 w=0.42u l=1u
X330 VGND.t194 VPWR VGND.t194 VGND.t193 sg13_lv_nmos ad=0.1428p pd=1.52u as=0 ps=0 w=0.42u l=1u
X331 VPWR VGND.t147 VPWR VPWR sg13_lv_pmos ad=0.19p pd=1.38u as=0 ps=0 w=1u l=1u
X332 VPWR VGND.t58 VPWR VPWR sg13_lv_pmos ad=0.34p pd=2.68u as=0 ps=0 w=1u l=1u
X333 VGND.t54 sg13cmos5l_inv_1_109.A sg13cmos5l_inv_1_95.A VGND.t936 sg13_lv_nmos ad=0.2516p pd=2.16u as=0.2516p ps=2.16u w=0.74u l=0.13u
X334 VGND.t199 sg13cmos5l_mux4_1_0.S0 a_4199_6558# VGND.t789 sg13_lv_nmos ad=0.1872p pd=1.225u as=0.2176p ps=1.96u w=0.64u l=0.13u
X335 a_11836_6558# sg13cmos5l_mux4_1_2.A1 VGND.t208 VGND.t715 sg13_lv_nmos ad=0.2304p pd=1.36u as=0.1824p ps=1.21u w=0.64u l=0.13u
X336 sg13cmos5l_o21ai_1_4.Y sg13cmos5l_nand2b_1_2.Y VPWR VPWR sg13_lv_pmos ad=0.2128p pd=1.5u as=0.3808p ps=2.92u w=1.12u l=0.15u
X337 VPWR VGND.t12 VPWR VPWR sg13_lv_pmos ad=0.19p pd=1.38u as=0 ps=0 w=1u l=1u
X338 VGND.t583 VPWR VGND.t582 VGND.t581 sg13_lv_nmos ad=0.1428p pd=1.52u as=0 ps=0 w=0.42u l=1u
X339 a_6662_3582# a_7467_3155# a_6922_3112# VPWR sg13_lv_pmos ad=0.1428p pd=1.52u as=79.8f ps=0.8u w=0.42u l=0.13u
X340 sg13cmos5l_inv_1_1.Y sg13cmos5l_inv_1_0.Y VGND.t10 VGND.t657 sg13_lv_nmos ad=0.2516p pd=2.16u as=0.2516p ps=2.16u w=0.74u l=0.13u
X341 VGND.t49 VPWR VGND.t49 VGND.t111 sg13_lv_nmos ad=79.8f pd=0.8u as=0 ps=0 w=0.42u l=1u
X342 VPWR VGND.t314 VPWR VPWR sg13_lv_pmos ad=0.19p pd=1.38u as=0 ps=0 w=1u l=1u
X343 VPWR sg13cmos5l_inv_1_88.A sg13cmos5l_mux2_1_6.A1 VPWR sg13_lv_pmos ad=0.3808p pd=2.92u as=0.3808p ps=2.92u w=1.12u l=0.13u
X344 VPWR sg13cmos5l_inv_1_33.Y sg13cmos5l_inv_1_31.A VPWR sg13_lv_pmos ad=0.3808p pd=2.92u as=0.3808p ps=2.92u w=1.12u l=0.13u
X345 VPWR VGND.t402 VPWR VPWR sg13_lv_pmos ad=0.34p pd=2.68u as=0 ps=0 w=1u l=1u
X346 sg13cmos5l_inv_1_129.Y sg13cmos5l_inv_1_127.Y VGND.t10 VGND.t9 sg13_lv_nmos ad=0.2516p pd=2.16u as=0.2516p ps=2.16u w=0.74u l=0.13u
X347 a_14030_5596# sg13cmos5l_mux2_1_7.A1 a_14202_5704# VPWR sg13_lv_pmos ad=0.2225p pd=1.445u as=0.2975p ps=1.595u w=1u l=0.13u
X348 a_4606_9562# sg13cmos5l_mux2_1_4.A1 a_4509_9562# VGND.t749 sg13_lv_nmos ad=0.1628p pd=1.18u as=0.13135p ps=1.095u w=0.74u l=0.13u
X349 VGND.t322 VPWR VGND.t321 VGND.t21 sg13_lv_nmos ad=0.1428p pd=1.52u as=0 ps=0 w=0.42u l=1u
X350 VGND.t147 VPWR VGND.t147 VGND.t51 sg13_lv_nmos ad=0.1428p pd=1.52u as=0 ps=0 w=0.42u l=1u
X351 VGND.t196 sg13cmos5l_buf_1_4.A a_3016_6168# VGND.t756 sg13_lv_nmos ad=0.14875p pd=1.16u as=0.187p ps=1.78u w=0.55u l=0.13u
X352 VGND.t208 VPWR VGND.t208 VGND.t207 sg13_lv_nmos ad=0.1428p pd=1.52u as=0 ps=0 w=0.42u l=1u
X353 VGND.t18 a_5243_9984# a_5680_9946# VGND.t752 sg13_lv_nmos ad=0.148p pd=1.14u as=0.3367p ps=1.65u w=0.74u l=0.13u
X354 a_10933_6516# sg13cmos5l_buf_1_2.X a_10571_6132# VPWR sg13_lv_pmos ad=0.34p pd=2.68u as=0.2225p ps=1.445u w=1u l=0.13u
X355 sg13cmos5l_mux4_1_0.X a_5505_6516# VGND.t201 VGND.t835 sg13_lv_nmos ad=0.2516p pd=2.16u as=0.1543p ps=1.18u w=0.74u l=0.13u
X356 VGND.t514 VPWR VGND.t513 VGND.t512 sg13_lv_nmos ad=0.1428p pd=1.52u as=0 ps=0 w=0.42u l=1u
X357 a_6434_3582# sg13cmos5l_dfrbp_1_2.RESET_B.t3 VGND.t706 VGND.t705 sg13_lv_nmos ad=60.89999f pd=0.71u as=0.1626p ps=1.415u w=0.42u l=0.13u
X358 sg13cmos5l_inv_1_18.A sg13cmos5l_inv_1_10.Y VGND.t5 VGND.t703 sg13_lv_nmos ad=0.2516p pd=2.16u as=0.2516p ps=2.16u w=0.74u l=0.13u
X359 VGND.t89 VPWR VGND.t89 VGND.t117 sg13_lv_nmos ad=0.1428p pd=1.52u as=0 ps=0 w=0.42u l=1u
X360 VPWR VGND.t253 VPWR VPWR sg13_lv_pmos ad=0.34p pd=2.68u as=0 ps=0 w=1u l=1u
X361 VPWR VGND.t291 VPWR VPWR sg13_lv_pmos ad=0.34p pd=2.68u as=0 ps=0 w=1u l=1u
X362 VPWR VGND.t164 VPWR VPWR sg13_lv_pmos ad=0.34p pd=2.68u as=0 ps=0 w=1u l=1u
X363 VPWR VGND.t355 VPWR VPWR sg13_lv_pmos ad=0.19p pd=1.38u as=0 ps=0 w=1u l=1u
X364 VPWR VGND.t1 VPWR VPWR sg13_lv_pmos ad=0.34p pd=2.68u as=0 ps=0 w=1u l=1u
X365 a_6468_2390# sg13cmos5l_buf_1_0.X a_6366_2390# VGND.t19 sg13_lv_nmos ad=0.1406p pd=1.12u as=0.1406p ps=1.12u w=0.74u l=0.13u
X366 VGND.t706 a_5781_4052# a_4860_3858# VGND.t817 sg13_lv_nmos ad=0.1626p pd=1.415u as=0.2516p ps=2.16u w=0.74u l=0.13u
X367 VGND.t10 sg13cmos5l_inv_1_130.Y sg13cmos5l_inv_1_123.A VGND.t858 sg13_lv_nmos ad=0.2516p pd=2.16u as=0.2516p ps=2.16u w=0.74u l=0.13u
X368 a_6615_7680# sg13cmos5l_nand2_1_1.B a_6501_7680# VPWR sg13_lv_pmos ad=0.2128p pd=1.5u as=0.2464p ps=1.56u w=1.12u l=0.13u
X369 VGND.t12 VPWR VGND.t12 VGND.t241 sg13_lv_nmos ad=79.8f pd=0.8u as=0 ps=0 w=0.42u l=1u
X370 a_10966_8434# a_11533_8440# a_11457_8476# VPWR sg13_lv_pmos ad=0.34p pd=2.68u as=0.2225p ps=1.445u w=1u l=0.13u
X371 VPWR VGND.t258 VPWR VPWR sg13_lv_pmos ad=0.34p pd=2.68u as=0 ps=0 w=1u l=1u
X372 VGND.t97 VPWR VGND.t97 VGND.t125 sg13_lv_nmos ad=0.1428p pd=1.52u as=0 ps=0 w=0.42u l=1u
X373 VGND.t554 VPWR VGND.t556 VGND.t555 sg13_lv_nmos ad=79.8f pd=0.8u as=0 ps=0 w=0.42u l=1u
X374 VGND.t64 sg13cmos5l_mux2_1_3.A0 sg13cmos5l_inv_1_73.A VGND.t739 sg13_lv_nmos ad=0.2516p pd=2.16u as=0.2516p ps=2.16u w=0.74u l=0.13u
X375 sg13cmos5l_inv_1_6.A sg13cmos5l_inv_1_1.Y VGND.t10 VGND.t919 sg13_lv_nmos ad=0.2516p pd=2.16u as=0.2516p ps=2.16u w=0.74u l=0.13u
X376 a_10365_5704# sg13cmos5l_buf_1_10.X VPWR VPWR sg13_lv_pmos ad=0.3325p pd=1.665u as=0.253p ps=1.53u w=1u l=0.13u
X377 VGND.t235 sg13cmos5l_inv_1_93.A sg13cmos5l_inv_1_92.A VGND.t695 sg13_lv_nmos ad=0.2516p pd=2.16u as=0.2516p ps=2.16u w=0.74u l=0.13u
X378 VGND.t248 VPWR VGND.t10 VGND.t247 sg13_lv_nmos ad=0.1428p pd=1.52u as=0 ps=0 w=0.42u l=1u
X379 a_4109_3858# a_4839_4112# a_4860_3858# VGND.t21 sg13_lv_nmos ad=0.12665p pd=1.145u as=0.3473p ps=2.71u w=0.74u l=0.13u
X380 VGND.t52 sg13cmos5l_inv_1_60.A sg13cmos5l_inv_1_60.Y VGND.t780 sg13_lv_nmos ad=0.2516p pd=2.16u as=0.2516p ps=2.16u w=0.74u l=0.13u
X381 a_4839_4112# a_4991_4164# VPWR VPWR sg13_lv_pmos ad=0.3864p pd=2.93u as=7.22485p ps=47.9u w=1.12u l=0.13u
X382 a_8236_4656# sg13cmos5l_nor4_1_0.D sg13cmos5l_and2_1_0.B VPWR sg13_lv_pmos ad=0.1176p pd=1.33u as=0.3808p ps=2.92u w=1.12u l=0.13u
X383 VGND.t39 VPWR VGND.t39 VGND.t21 sg13_lv_nmos ad=0.1428p pd=1.52u as=0 ps=0 w=0.42u l=1u
X384 VGND.t325 VPWR VGND.t324 VGND.t21 sg13_lv_nmos ad=0.1428p pd=1.52u as=0 ps=0 w=0.42u l=1u
X385 VGND.t155 VPWR VGND.t147 VGND.t51 sg13_lv_nmos ad=0.1428p pd=1.52u as=0 ps=0 w=0.42u l=1u
X386 VGND.t30 sg13cmos5l_nor4_1_0.D sg13cmos5l_dfrbp_1_1.CLK VGND.t738 sg13_lv_nmos ad=0.2516p pd=2.16u as=0.1406p ps=1.12u w=0.74u l=0.13u
X387 VGND.t201 sg13cmos5l_o21ai_1_1.A2 sg13cmos5l_inv_1_35.Y VGND.t842 sg13_lv_nmos ad=0.2516p pd=2.16u as=0.2516p ps=2.16u w=0.74u l=0.13u
X388 a_4591_8728# sg13cmos5l_inv_1_69.Y a_4414_8434# VPWR sg13_lv_pmos ad=0.2975p pd=1.595u as=0.2225p ps=1.445u w=1u l=0.13u
X389 VGND.t386 VPWR VGND.t394 VGND.t19 sg13_lv_nmos ad=79.8f pd=0.8u as=0 ps=0 w=0.42u l=1u
X390 a_2136_6148# sg13cmos5l_o21ai_1_0.A1 VPWR VPWR sg13_lv_pmos ad=0.2128p pd=1.5u as=0.3808p ps=2.92u w=1.12u l=0.15u
X391 VGND.t92 VPWR VGND.t92 VGND.t119 sg13_lv_nmos ad=0.1428p pd=1.52u as=0 ps=0 w=0.42u l=1u
X392 sg13cmos5l_inv_1_55.Y sg13cmos5l_inv_1_53.Y VGND.t164 VGND.t822 sg13_lv_nmos ad=0.2516p pd=2.16u as=0.2516p ps=2.16u w=0.74u l=0.13u
X393 VGND.t18 sg13cmos5l_inv_1_66.A sg13cmos5l_inv_1_52.A VGND.t972 sg13_lv_nmos ad=0.2516p pd=2.16u as=0.2516p ps=2.16u w=0.74u l=0.13u
X394 VPWR VGND.t12 VPWR VPWR sg13_lv_pmos ad=0.19p pd=1.38u as=0 ps=0 w=1u l=1u
X395 VGND.t39 VPWR VGND.t39 VGND.t21 sg13_lv_nmos ad=0.1428p pd=1.52u as=0 ps=0 w=0.42u l=1u
X396 VGND.t67 VPWR VGND.t66 VGND.t65 sg13_lv_nmos ad=0.1428p pd=1.52u as=0 ps=0 w=0.42u l=1u
X397 sg13cmos5l_inv_1_126.Y sg13cmos5l_inv_1_125.Y VGND.t28 VGND.t847 sg13_lv_nmos ad=0.2516p pd=2.16u as=0.2516p ps=2.16u w=0.74u l=0.13u
X398 VPWR VGND.t262 VPWR VPWR sg13_lv_pmos ad=0.34p pd=2.68u as=0 ps=0 w=1u l=1u
X399 VGND.t484 VPWR VGND.t486 VGND.t485 sg13_lv_nmos ad=79.8f pd=0.8u as=0 ps=0 w=0.42u l=1u
X400 VPWR VGND.t521 VPWR VPWR sg13_lv_pmos ad=0.19p pd=1.38u as=0 ps=0 w=1u l=1u
X401 VGND.t316 VPWR VGND.t315 VGND.t21 sg13_lv_nmos ad=0.1428p pd=1.52u as=0 ps=0 w=0.42u l=1u
X402 VGND.t201 sg13cmos5l_nand2_1_1.B sg13cmos5l_nor2b_1_2.Y VGND.t969 sg13_lv_nmos ad=0.2516p pd=2.16u as=0.1406p ps=1.12u w=0.74u l=0.13u
X403 VGND.t254 VPWR VGND.t253 VGND.t252 sg13_lv_nmos ad=0.1428p pd=1.52u as=0 ps=0 w=0.42u l=1u
X404 VGND.t147 VPWR VGND.t147 VGND.t51 sg13_lv_nmos ad=0.1428p pd=1.52u as=0 ps=0 w=0.42u l=1u
X405 VPWR VGND.t300 VPWR VPWR sg13_lv_pmos ad=0.19p pd=1.38u as=0 ps=0 w=1u l=1u
X406 sg13cmos5l_inv_1_100.Y sg13cmos5l_inv_1_99.Y VPWR VPWR sg13_lv_pmos ad=0.3808p pd=2.92u as=0.3808p ps=2.92u w=1.12u l=0.13u
X407 VPWR sg13cmos5l_inv_1_45.A sg13cmos5l_inv_1_44.A VPWR sg13_lv_pmos ad=0.3808p pd=2.92u as=0.3808p ps=2.92u w=1.12u l=0.13u
X408 a_1765_6538# sg13cmos5l_o21ai_1_0.A1 VGND.t7 VGND.t807 sg13_lv_nmos ad=0.1406p pd=1.12u as=0.14505p ps=1.15u w=0.74u l=0.13u
X409 VGND.t55 VPWR VGND.t164 VGND.t170 sg13_lv_nmos ad=0.1428p pd=1.52u as=0 ps=0 w=0.42u l=1u
X410 a_8207_3505# a_7365_3155# a_6948_3148# VPWR sg13_lv_pmos ad=0.2048p pd=1.63u as=0.34p ps=2.68u w=1u l=0.13u
X411 VGND.t307 VPWR VGND.t356 VGND.t21 sg13_lv_nmos ad=0.1428p pd=1.52u as=0 ps=0 w=0.42u l=1u
X412 sg13cmos5l_o21ai_1_3.B1 a_13917_7950# VPWR VPWR sg13_lv_pmos ad=0.2128p pd=1.5u as=0.3808p ps=2.92u w=1.12u l=0.13u
X413 VPWR sg13cmos5l_inv_1_97.A sg13cmos5l_o21ai_1_3.A2 VPWR sg13_lv_pmos ad=0.3808p pd=2.92u as=0.3808p ps=2.92u w=1.12u l=0.13u
X414 VGND.t603 VPWR VGND.t602 VGND.t601 sg13_lv_nmos ad=0.1428p pd=1.52u as=0 ps=0 w=0.42u l=1u
X415 VPWR VGND.t10 VPWR VPWR sg13_lv_pmos ad=0.34p pd=2.68u as=0 ps=0 w=1u l=1u
X416 a_11457_8476# sg13cmos5l_mux4_1_0.S0 a_10966_8434# VGND.t55 sg13_lv_nmos ad=0.1216p pd=1.02u as=0.54188p ps=3.42u w=0.64u l=0.13u
X417 sg13cmos5l_inv_1_107.A sg13cmos5l_inv_1_103.A VGND.t89 VGND.t646 sg13_lv_nmos ad=0.2516p pd=2.16u as=0.2516p ps=2.16u w=0.74u l=0.13u
X418 VPWR VGND.t420 VPWR VPWR sg13_lv_pmos ad=0.19p pd=1.38u as=0 ps=0 w=1u l=1u
X419 VGND.t484 VPWR VGND.t483 VGND.t482 sg13_lv_nmos ad=0.1428p pd=1.52u as=0 ps=0 w=0.42u l=1u
X420 sg13cmos5l_buf_1_10.X a_10120_6168# VPWR VPWR sg13_lv_pmos ad=0.42p pd=2.99u as=0.2114p ps=1.54u w=1.12u l=0.13u
X421 VGND.t377 VPWR VGND.t377 VGND.t19 sg13_lv_nmos ad=79.8f pd=0.8u as=0 ps=0 w=0.42u l=1u
X422 a_10890_8434# sg13cmos5l_o21ai_1_3.Y VGND.t52 VGND.t648 sg13_lv_nmos ad=80f pd=0.89u as=0.1824p ps=1.21u w=0.64u l=0.13u
X423 VGND.t394 VPWR VGND.t394 VGND.t19 sg13_lv_nmos ad=79.8f pd=0.8u as=0 ps=0 w=0.42u l=1u
X424 VPWR VGND.t394 VPWR VPWR sg13_lv_pmos ad=0.19p pd=1.38u as=0 ps=0 w=1u l=1u
X425 VPWR VGND.t506 VPWR VPWR sg13_lv_pmos ad=0.19p pd=1.38u as=0 ps=0 w=1u l=1u
X426 VGND.t92 VPWR VGND.t92 VGND.t121 sg13_lv_nmos ad=0.1428p pd=1.52u as=0 ps=0 w=0.42u l=1u
X427 VPWR VGND.t333 VPWR VPWR sg13_lv_pmos ad=0.19p pd=1.38u as=0 ps=0 w=1u l=1u
X428 a_11802_4680# a_11736_4918# VPWR VPWR sg13_lv_pmos ad=0.2975p pd=1.595u as=0.2198p ps=1.52u w=1u l=0.13u
X429 VPWR VGND.t155 VPWR VPWR sg13_lv_pmos ad=0.34p pd=2.68u as=0 ps=0 w=1u l=1u
X430 a_4210_6914# sg13cmos5l_nand2b_1_1.Y sg13cmos5l_mux4_1_0.A0 VGND.t884 sg13_lv_nmos ad=0.1406p pd=1.12u as=0.2516p ps=2.16u w=0.74u l=0.15u
X431 VPWR VGND.t137 VPWR VPWR sg13_lv_pmos ad=0.34p pd=2.68u as=0 ps=0 w=1u l=1u
X432 VGND.t12 sg13cmos5l_a21o_1_0.X a_18856_6168# VGND.t11 sg13_lv_nmos ad=0.14875p pd=1.16u as=0.187p ps=1.78u w=0.55u l=0.13u
X433 VGND.t245 VPWR VGND.t245 VGND.t244 sg13_lv_nmos ad=0.1428p pd=1.52u as=0 ps=0 w=0.42u l=1u
X434 a_7468_6168# sg13cmos5l_nand2_1_1.Y sg13cmos5l_nor4_1_0.D VPWR sg13_lv_pmos ad=0.1176p pd=1.33u as=0.3808p ps=2.92u w=1.12u l=0.13u
X435 VGND.t412 VPWR VGND.t412 VGND.t19 sg13_lv_nmos ad=79.8f pd=0.8u as=0 ps=0 w=0.42u l=1u
X436 VPWR VGND.t12 VPWR VPWR sg13_lv_pmos ad=0.19p pd=1.38u as=0 ps=0 w=1u l=1u
X437 a_4938_6558# sg13cmos5l_o21ai_1_0.Y VGND.t201 VGND.t698 sg13_lv_nmos ad=80f pd=0.89u as=0.1824p ps=1.21u w=0.64u l=0.13u
X438 VGND.t1 sg13cmos5l_inv_1_24.A sg13cmos5l_o21ai_1_1.A2 VGND.t700 sg13_lv_nmos ad=0.2516p pd=2.16u as=0.2516p ps=2.16u w=0.74u l=0.13u
X439 VPWR sg13cmos5l_mux4_1_0.S0 a_11533_8440# VPWR sg13_lv_pmos ad=0.34367p pd=1.775u as=0.34p ps=2.68u w=1u l=0.13u
X440 VPWR sg13cmos5l_inv_1_66.A sg13cmos5l_inv_1_52.A VPWR sg13_lv_pmos ad=0.3808p pd=2.92u as=0.3808p ps=2.92u w=1.12u l=0.13u
X441 VPWR VGND.t66 VPWR VPWR sg13_lv_pmos ad=0.34p pd=2.68u as=0 ps=0 w=1u l=1u
X442 VPWR VGND.t92 VPWR VPWR sg13_lv_pmos ad=0.19p pd=1.38u as=0 ps=0 w=1u l=1u
X443 VPWR VGND.t394 VPWR VPWR sg13_lv_pmos ad=0.19p pd=1.38u as=0 ps=0 w=1u l=1u
X444 VPWR sg13cmos5l_inv_1_30.A sg13cmos5l_inv_1_30.Y VPWR sg13_lv_pmos ad=0.3808p pd=2.92u as=0.3808p ps=2.92u w=1.12u l=0.13u
X445 VGND.t46 sg13cmos5l_buf_1_4.A a_5243_9984# VGND.t754 sg13_lv_nmos ad=0.18945p pd=1.27u as=0.187p ps=1.78u w=0.55u l=0.13u
X446 VPWR VGND.t297 VPWR VPWR sg13_lv_pmos ad=0.34p pd=2.68u as=0 ps=0 w=1u l=1u
X447 VGND.t5 sg13cmos5l_inv_1_118.A sg13cmos5l_inv_1_118.Y VGND.t4 sg13_lv_nmos ad=0.2516p pd=2.16u as=0.2516p ps=2.16u w=0.74u l=0.13u
X448 VGND.t164 sg13cmos5l_mux4_1_0.S0 a_5063_8434# VGND.t790 sg13_lv_nmos ad=0.1872p pd=1.225u as=0.2176p ps=1.96u w=0.64u l=0.13u
X449 VGND.t196 a_3116_6882# sg13cmos5l_buf_1_4.A VGND.t697 sg13_lv_nmos ad=0.14875p pd=1.16u as=0.2886p ps=2.26u w=0.74u l=0.13u
X450 VPWR VGND.t304 VPWR VPWR sg13_lv_pmos ad=0.19p pd=1.38u as=0 ps=0 w=1u l=1u
X451 a_5781_4052# a_4839_4112# a_5642_4052# VGND.t59 sg13_lv_nmos ad=79.8f pd=0.8u as=0.2373p ps=1.97u w=0.42u l=0.13u
X452 VGND.t402 VPWR VGND.t402 VGND.t19 sg13_lv_nmos ad=79.8f pd=0.8u as=0 ps=0 w=0.42u l=1u
X453 VGND.t489 VPWR VGND.t491 VGND.t490 sg13_lv_nmos ad=79.8f pd=0.8u as=0 ps=0 w=0.42u l=1u
X454 sg13cmos5l_inv_1_82.A sg13cmos5l_inv_1_85.A VPWR VPWR sg13_lv_pmos ad=0.3808p pd=2.92u as=0.3808p ps=2.92u w=1.12u l=0.13u
X455 sg13cmos5l_inv_1_26.Y sg13cmos5l_inv_1_25.Y VGND.t1 VGND.t617 sg13_lv_nmos ad=0.2516p pd=2.16u as=0.2516p ps=2.16u w=0.74u l=0.13u
X456 VPWR VGND.t30 VPWR VPWR sg13_lv_pmos ad=0.34p pd=2.68u as=0 ps=0 w=1u l=1u
X457 a_6291_5004# sg13cmos5l_nand3b_1_0.Y VGND.t32 VGND.t61 sg13_lv_nmos ad=0.1406p pd=1.12u as=0.2516p ps=2.16u w=0.74u l=0.13u
X458 VGND.t262 VPWR VGND.t262 VGND.t263 sg13_lv_nmos ad=0.1428p pd=1.52u as=0 ps=0 w=0.42u l=1u
X459 sg13cmos5l_o21ai_1_5.Y sg13cmos5l_inv_1_12.Y a_5208_5724# VPWR sg13_lv_pmos ad=0.2128p pd=1.5u as=0.2128p ps=1.5u w=1.12u l=0.15u
X460 sg13cmos5l_o21ai_1_5.B1 a_6333_5596# VPWR VPWR sg13_lv_pmos ad=0.2128p pd=1.5u as=0.3808p ps=2.92u w=1.12u l=0.13u
X461 a_3960_5724# sg13cmos5l_o21ai_1_0.A1 VPWR VPWR sg13_lv_pmos ad=0.2128p pd=1.5u as=0.3808p ps=2.92u w=1.12u l=0.15u
X462 VPWR VGND.t72 VPWR VPWR sg13_lv_pmos ad=0.19p pd=1.38u as=0 ps=0 w=1u l=1u
X463 VGND.t534 VPWR VGND.t533 VGND.t532 sg13_lv_nmos ad=0.1428p pd=1.52u as=0 ps=0 w=0.42u l=1u
X464 VPWR VGND.t12 VPWR VPWR sg13_lv_pmos ad=0.34p pd=2.68u as=0 ps=0 w=1u l=1u
X465 VPWR VGND.t420 VPWR VPWR sg13_lv_pmos ad=0.19p pd=1.38u as=0 ps=0 w=1u l=1u
X466 VPWR sg13cmos5l_inv_1_87.Y sg13cmos5l_inv_1_88.A VPWR sg13_lv_pmos ad=0.3808p pd=2.92u as=0.3808p ps=2.92u w=1.12u l=0.13u
X467 VPWR sg13cmos5l_o21ai_1_0.A2 sg13cmos5l_inv_1_34.Y VPWR sg13_lv_pmos ad=0.3808p pd=2.92u as=0.3808p ps=2.92u w=1.12u l=0.13u
X468 VGND.t38 sg13cmos5l_inv_1_33.A sg13cmos5l_inv_1_33.Y VGND.t50 sg13_lv_nmos ad=0.2516p pd=2.16u as=0.2516p ps=2.16u w=0.74u l=0.13u
X469 VPWR VGND.t309 VPWR VPWR sg13_lv_pmos ad=0.34p pd=2.68u as=0 ps=0 w=1u l=1u
X470 a_10885_8701# sg13cmos5l_o21ai_1_3.Y VPWR VPWR sg13_lv_pmos ad=0.20762p pd=1.605u as=0.29275p ps=1.785u w=1u l=0.13u
X471 a_8464_3386# a_8207_3505# a_8626_3582# VGND.t21 sg13_lv_nmos ad=0.1428p pd=1.52u as=37.8f ps=0.6u w=0.42u l=0.13u
X472 VPWR VGND.t511 VPWR VPWR sg13_lv_pmos ad=0.19p pd=1.38u as=0 ps=0 w=1u l=1u
X473 VPWR VGND.t258 VPWR VPWR sg13_lv_pmos ad=0.34p pd=2.68u as=0 ps=0 w=1u l=1u
X474 VPWR sg13cmos5l_mux2_1_0.S a_12062_4680# VPWR sg13_lv_pmos ad=0.253p pd=1.53u as=0.3325p ps=1.665u w=1u l=0.13u
X475 VPWR VGND.t32 VPWR VPWR sg13_lv_pmos ad=0.34p pd=2.68u as=0 ps=0 w=1u l=1u
X476 a_10580_8434# sg13cmos5l_buf_1_2.X a_10462_8434# VGND.t784 sg13_lv_nmos ad=0.2304p pd=1.36u as=0.1472p ps=1.1u w=0.64u l=0.13u
X477 VGND.t139 VPWR VGND.t139 VGND.t51 sg13_lv_nmos ad=79.8f pd=0.8u as=0 ps=0 w=0.42u l=1u
X478 a_14202_6192# a_14136_6430# VPWR VPWR sg13_lv_pmos ad=0.2975p pd=1.595u as=0.2198p ps=1.52u w=1u l=0.13u
X479 VPWR VGND.t412 VPWR VPWR sg13_lv_pmos ad=0.19p pd=1.38u as=0 ps=0 w=1u l=1u
X480 VPWR a_7365_3155# a_7467_3155# VPWR sg13_lv_pmos ad=4.30725p pd=28.325u as=0.3864p ps=2.93u w=1.12u l=0.13u
X481 VGND.t292 sg13cmos5l_dfrbp_1_2.RESET_B.t6 a_4586_3894# VGND.t21 sg13_lv_nmos ad=79.8f pd=0.8u as=37.8f ps=0.6u w=0.42u l=0.13u
X482 VPWR VGND.t496 VPWR VPWR sg13_lv_pmos ad=0.19p pd=1.38u as=0 ps=0 w=1u l=1u
X483 sg13cmos5l_nor4_1_0.Y sg13cmos5l_inv_1_22.Y VGND.t30 VGND.t29 sg13_lv_nmos ad=0.1406p pd=1.12u as=0.2516p ps=2.16u w=0.74u l=0.13u
X484 sg13cmos5l_inv_1_6.Y sg13cmos5l_inv_1_6.A VPWR VPWR sg13_lv_pmos ad=0.3808p pd=2.92u as=0.3808p ps=2.92u w=1.12u l=0.13u
X485 a_4628_6558# sg13cmos5l_mux4_1_0.S0 a_4510_6558# VGND.t794 sg13_lv_nmos ad=0.2304p pd=1.36u as=0.1472p ps=1.1u w=0.64u l=0.13u
X486 a_5878_8434# a_6445_8440# a_6369_8476# VPWR sg13_lv_pmos ad=0.34p pd=2.68u as=0.2225p ps=1.445u w=1u l=0.13u
X487 VPWR sg13cmos5l_buf_1_4.A a_5243_9984# VPWR sg13_lv_pmos ad=0.253p pd=1.53u as=0.2856p ps=2.36u w=0.84u l=0.13u
X488 VGND.t382 VPWR VGND.t382 VGND.t19 sg13_lv_nmos ad=0.1428p pd=1.52u as=0 ps=0 w=0.42u l=1u
X489 VPWR sg13cmos5l_o21ai_1_4.Y a_11189_8747# VPWR sg13_lv_pmos ad=0.34p pd=2.68u as=0.135p ps=1.27u w=1u l=0.13u
X490 a_10715_6528# sg13cmos5l_buf_1_2.X VGND.t686 VGND.t787 sg13_lv_nmos ad=0.2304p pd=2u as=0.1543p ps=1.18u w=0.64u l=0.13u
X491 VGND.t7 sg13cmos5l_o21ai_1_0.A1 a_2038_6546# VGND.t809 sg13_lv_nmos ad=0.1406p pd=1.12u as=0.2516p ps=2.16u w=0.74u l=0.15u
X492 VPWR VGND.t427 VPWR VPWR sg13_lv_pmos ad=0.34p pd=2.68u as=0 ps=0 w=1u l=1u
X493 VPWR VGND.t412 VPWR VPWR sg13_lv_pmos ad=0.19p pd=1.38u as=0 ps=0 w=1u l=1u
X494 sg13cmos5l_inv_1_37.A sg13cmos5l_inv_1_51.Y VGND.t64 VGND.t966 sg13_lv_nmos ad=0.2516p pd=2.16u as=0.2516p ps=2.16u w=0.74u l=0.13u
X495 VPWR VGND.t194 VPWR VPWR sg13_lv_pmos ad=0.34p pd=2.68u as=0 ps=0 w=1u l=1u
X496 VPWR VGND.t352 VPWR VPWR sg13_lv_pmos ad=0.34p pd=2.68u as=0 ps=0 w=1u l=1u
X497 VPWR sg13cmos5l_dfrbp_1_2.D a_5687_3191# VPWR sg13_lv_pmos ad=0.1428p pd=1.52u as=79.8f ps=0.8u w=0.42u l=0.13u
X498 VGND.t12 VPWR VGND.t12 VGND.t238 sg13_lv_nmos ad=0.1428p pd=1.52u as=0 ps=0 w=0.42u l=1u
X499 sg13cmos5l_and2_1_0.X a_7629_5004# VGND.t28 VGND.t948 sg13_lv_nmos ad=0.2516p pd=2.16u as=0.1331p ps=1.12u w=0.74u l=0.13u
X500 VGND.t64 sg13cmos5l_inv_1_40.A sg13cmos5l_inv_1_70.A VGND.t746 sg13_lv_nmos ad=0.2516p pd=2.16u as=0.2516p ps=2.16u w=0.74u l=0.13u
X501 VGND.t72 VPWR VGND.t72 VGND.t77 sg13_lv_nmos ad=79.8f pd=0.8u as=0 ps=0 w=0.42u l=1u
X502 a_9720_8748# sg13cmos5l_buf_1_10.X VPWR VPWR sg13_lv_pmos ad=0.2128p pd=1.5u as=0.3808p ps=2.92u w=1.12u l=0.15u
X503 sg13cmos5l_o21ai_1_7.B1 sg13cmos5l_o21ai_1_0.A1 VPWR VPWR sg13_lv_pmos ad=0.2128p pd=1.5u as=0.2198p ps=1.53u w=1.12u l=0.13u
X504 VGND.t49 VPWR VGND.t18 VGND.t110 sg13_lv_nmos ad=0.1428p pd=1.52u as=0 ps=0 w=0.42u l=1u
X505 VPWR VGND.t420 VPWR VPWR sg13_lv_pmos ad=0.19p pd=1.38u as=0 ps=0 w=1u l=1u
X506 VGND.t72 VPWR VGND.t72 VGND.t114 sg13_lv_nmos ad=0.1428p pd=1.52u as=0 ps=0 w=0.42u l=1u
X507 VGND.t49 sg13cmos5l_inv_1_60.Y sg13cmos5l_inv_1_54.Y VGND.t872 sg13_lv_nmos ad=0.2516p pd=2.16u as=0.2516p ps=2.16u w=0.74u l=0.13u
X508 VPWR VGND.t402 VPWR VPWR sg13_lv_pmos ad=0.19p pd=1.38u as=0 ps=0 w=1u l=1u
X509 VPWR sg13cmos5l_inv_1_60.A sg13cmos5l_inv_1_60.Y VPWR sg13_lv_pmos ad=0.3808p pd=2.92u as=0.3808p ps=2.92u w=1.12u l=0.13u
X510 a_14524_5410# sg13cmos5l_mux2_1_7.A1 a_14030_5596# VGND.t24 sg13_lv_nmos ad=0.13135p pd=1.095u as=0.1628p ps=1.18u w=0.74u l=0.13u
X511 VPWR VGND.t262 VPWR VPWR sg13_lv_pmos ad=0.34p pd=2.68u as=0 ps=0 w=1u l=1u
X512 a_10904_6168# a_11371_6137# a_11317_6173# VPWR sg13_lv_pmos ad=0.4425p pd=1.885u as=0.135p ps=1.27u w=1u l=0.13u
X513 a_13917_9462# sg13cmos5l_inv_1_107.Y VGND.t89 VGND.t815 sg13_lv_nmos ad=0.187p pd=1.78u as=0.14505p ps=1.15u w=0.55u l=0.13u
X514 VPWR invsel[4] a_808_9192# VPWR sg13_lv_pmos ad=0.2114p pd=1.54u as=0.2856p ps=2.36u w=0.84u l=0.13u
X515 VGND.t377 VPWR VGND.t377 VGND.t19 sg13_lv_nmos ad=0.1428p pd=1.52u as=0 ps=0 w=0.42u l=1u
X516 VGND.t28 sg13cmos5l_and2_1_0.X sg13cmos5l_inv_1_119.Y VGND.t856 sg13_lv_nmos ad=0.2516p pd=2.16u as=0.2516p ps=2.16u w=0.74u l=0.13u
X517 VGND.t394 VPWR VGND.t394 VGND.t19 sg13_lv_nmos ad=0.1428p pd=1.52u as=0 ps=0 w=0.42u l=1u
X518 a_12019_6219# sg13cmos5l_mux4_1_0.S0 a_10933_6516# VPWR sg13_lv_pmos ad=0.415p pd=1.83u as=0.19p ps=1.38u w=1u l=0.13u
X519 VGND.t139 VPWR VGND.t141 VGND.t51 sg13_lv_nmos ad=79.8f pd=0.8u as=0 ps=0 w=0.42u l=1u
X520 a_3990_4069# a_4109_3858# VGND.t292 VGND.t21 sg13_lv_nmos ad=0.2516p pd=2.16u as=0.1406p ps=1.12u w=0.74u l=0.13u
X521 VGND.t394 VPWR VGND.t402 VGND.t19 sg13_lv_nmos ad=79.8f pd=0.8u as=0 ps=0 w=0.42u l=1u
X522 sg13cmos5l_inv_1_104.Y sg13cmos5l_nand2b_1_4.A_N VPWR VPWR sg13_lv_pmos ad=0.3808p pd=2.92u as=0.3808p ps=2.92u w=1.12u l=0.13u
X523 a_12120_7660# sg13cmos5l_buf_1_10.X VPWR VPWR sg13_lv_pmos ad=0.2128p pd=1.5u as=0.3808p ps=2.92u w=1.12u l=0.15u
X524 VPWR VGND.t164 VPWR VPWR sg13_lv_pmos ad=0.19p pd=1.38u as=0 ps=0 w=1u l=1u
X525 VGND.t3 VPWR VGND.t3 VGND.t130 sg13_lv_nmos ad=0.1428p pd=1.52u as=0 ps=0 w=0.42u l=1u
X526 VGND.t39 VPWR VGND.t39 VGND.t21 sg13_lv_nmos ad=0.1428p pd=1.52u as=0 ps=0 w=0.42u l=1u
X527 VGND.t578 VPWR VGND.t578 VGND.t580 sg13_lv_nmos ad=79.8f pd=0.8u as=0 ps=0 w=0.42u l=1u
X528 VPWR VGND.t528 VPWR VPWR sg13_lv_pmos ad=0.34p pd=2.68u as=0 ps=0 w=1u l=1u
X529 VGND.t84 VPWR VGND.t84 VGND.t115 sg13_lv_nmos ad=0.1428p pd=1.52u as=0 ps=0 w=0.42u l=1u
X530 VGND.t554 VPWR VGND.t553 VGND.t552 sg13_lv_nmos ad=0.1428p pd=1.52u as=0 ps=0 w=0.42u l=1u
X531 VPWR sg13cmos5l_o21ai_1_7.B1 sg13cmos5l_o21ai_1_7.Y VPWR sg13_lv_pmos ad=0.3808p pd=2.92u as=0.2128p ps=1.5u w=1.12u l=0.15u
X532 VPWR VGND.t420 VPWR VPWR sg13_lv_pmos ad=0.19p pd=1.38u as=0 ps=0 w=1u l=1u
X533 VGND.t201 VPWR VGND.t201 VGND.t228 sg13_lv_nmos ad=79.8f pd=0.8u as=0 ps=0 w=0.42u l=1u
X534 a_7412_6886# sg13cmos5l_nand2_1_1.B VGND.t1 VGND.t968 sg13_lv_nmos ad=0.187p pd=1.78u as=0.17255p ps=1.25u w=0.55u l=0.13u
X535 a_4317_8434# sg13cmos5l_buf_1_4.A VGND.t161 VGND.t760 sg13_lv_nmos ad=0.13135p pd=1.095u as=0.18945p ps=1.27u w=0.74u l=0.13u
X536 sg13cmos5l_inv_1_37.A sg13cmos5l_inv_1_51.Y VPWR VPWR sg13_lv_pmos ad=0.3808p pd=2.92u as=0.3808p ps=2.92u w=1.12u l=0.13u
X537 VPWR VGND.t304 VPWR VPWR sg13_lv_pmos ad=0.34p pd=2.68u as=0 ps=0 w=1u l=1u
X538 sg13cmos5l_inv_1_55.Y sg13cmos5l_inv_1_53.Y VPWR VPWR sg13_lv_pmos ad=0.3808p pd=2.92u as=0.3808p ps=2.92u w=1.12u l=0.13u
X539 VPWR a_5243_9984# a_5743_10240# VPWR sg13_lv_pmos ad=0.2198p pd=1.52u as=0.2975p ps=1.595u w=1u l=0.13u
X540 VGND.t329 VPWR VGND.t328 VGND.t293 sg13_lv_nmos ad=0.1428p pd=1.52u as=0 ps=0 w=0.42u l=1u
X541 VGND.t663 invsel[4] a_808_9192# VGND.t716 sg13_lv_nmos ad=0.14875p pd=1.16u as=0.187p ps=1.78u w=0.55u l=0.13u
X542 VGND.t574 VPWR VGND.t576 VGND.t575 sg13_lv_nmos ad=79.8f pd=0.8u as=0 ps=0 w=0.42u l=1u
X543 VPWR a_2043_6960# sg13cmos5l_nand2b_1_1.Y VPWR sg13_lv_pmos ad=0.3808p pd=2.92u as=0.2128p ps=1.5u w=1.12u l=0.13u
X544 VPWR VGND.t412 VPWR VPWR sg13_lv_pmos ad=0.19p pd=1.38u as=0 ps=0 w=1u l=1u
X545 a_6676_7216# sg13cmos5l_mux4_1_0.X VPWR VPWR sg13_lv_pmos ad=0.2128p pd=1.5u as=0.3808p ps=2.92u w=1.12u l=0.13u
X546 VPWR VGND.t196 VPWR VPWR sg13_lv_pmos ad=0.34p pd=2.68u as=0 ps=0 w=1u l=1u
X547 VPWR sg13cmos5l_inv_1_60.Y sg13cmos5l_inv_1_54.Y VPWR sg13_lv_pmos ad=0.3808p pd=2.92u as=0.3808p ps=2.92u w=1.12u l=0.13u
X548 VGND.t16 sg13cmos5l_o21ai_1_0.A1 a_4283_9248# VGND.t804 sg13_lv_nmos ad=0.18945p pd=1.27u as=0.187p ps=1.78u w=0.55u l=0.13u
X549 VPWR VGND.t486 VPWR VPWR sg13_lv_pmos ad=0.19p pd=1.38u as=0 ps=0 w=1u l=1u
X550 a_6369_8476# sg13cmos5l_buf_1_2.X a_5878_8434# VGND.t781 sg13_lv_nmos ad=0.1216p pd=1.02u as=0.54188p ps=3.42u w=0.64u l=0.13u
X551 VGND.t394 VPWR VGND.t394 VGND.t19 sg13_lv_nmos ad=0.1428p pd=1.52u as=0 ps=0 w=0.42u l=1u
X552 a_5802_8434# sg13cmos5l_mux4_1_1.A2 VGND.t164 VGND.t940 sg13_lv_nmos ad=80f pd=0.89u as=0.1824p ps=1.21u w=0.64u l=0.13u
X553 VPWR VGND.t513 VPWR VPWR sg13_lv_pmos ad=0.34p pd=2.68u as=0 ps=0 w=1u l=1u
X554 VPWR sg13cmos5l_inv_1_16.Y a_4347_5448# VPWR sg13_lv_pmos ad=0.2198p pd=1.53u as=0.2856p ps=2.36u w=0.84u l=0.13u
X555 VPWR VGND.t394 VPWR VPWR sg13_lv_pmos ad=0.34p pd=2.68u as=0 ps=0 w=1u l=1u
X556 VPWR VGND.t147 VPWR VPWR sg13_lv_pmos ad=0.19p pd=1.38u as=0 ps=0 w=1u l=1u
X557 VGND.t294 a_8464_3386# a_8113_3505# VGND.t21 sg13_lv_nmos ad=79.8f pd=0.8u as=0.1428p ps=1.52u w=0.42u l=0.13u
X558 VGND.t201 sg13cmos5l_a221oi_1_0.C1 sg13cmos5l_nor2b_1_0.B_N VGND.t937 sg13_lv_nmos ad=0.1406p pd=1.12u as=0.2516p ps=2.16u w=0.74u l=0.13u
X559 VGND.t402 VPWR VGND.t402 VGND.t19 sg13_lv_nmos ad=79.8f pd=0.8u as=0 ps=0 w=0.42u l=1u
X560 a_6038_3907# a_4860_3858# a_5642_4052# VGND.t40 sg13_lv_nmos ad=37.8f pd=0.6u as=0.1428p ps=1.52u w=0.42u l=0.13u
X561 VGND.t132 sg13cmos5l_inv_1_36.A sg13cmos5l_inv_1_69.A VGND.t668 sg13_lv_nmos ad=0.2516p pd=2.16u as=0.2516p ps=2.16u w=0.74u l=0.13u
X562 VPWR VGND.t402 VPWR VPWR sg13_lv_pmos ad=0.19p pd=1.38u as=0 ps=0 w=1u l=1u
X563 VGND.t89 sg13cmos5l_mux2_1_0.S a_13999_9562# VGND.t893 sg13_lv_nmos ad=0.14505p pd=1.15u as=0.1406p ps=1.12u w=0.74u l=0.13u
X564 VPWR sg13cmos5l_buf_1_2.X a_6445_8440# VPWR sg13_lv_pmos ad=0.34367p pd=1.775u as=0.34p ps=2.68u w=1u l=0.13u
X565 VGND.t509 VPWR VGND.t511 VGND.t510 sg13_lv_nmos ad=79.8f pd=0.8u as=0 ps=0 w=0.42u l=1u
X566 VGND.t132 VPWR VGND.t134 VGND.t133 sg13_lv_nmos ad=79.8f pd=0.8u as=0 ps=0 w=0.42u l=1u
X567 a_4750_3582# a_4991_3115# a_4109_3108# VGND.t21 sg13_lv_nmos ad=0.1428p pd=1.52u as=0.12665p ps=1.145u w=0.42u l=0.13u
X568 VPWR VGND.t141 VPWR VPWR sg13_lv_pmos ad=0.19p pd=1.38u as=0 ps=0 w=1u l=1u
X569 VPWR VGND.t498 VPWR VPWR sg13_lv_pmos ad=0.34p pd=2.68u as=0 ps=0 w=1u l=1u
X570 VPWR VGND.t328 VPWR VPWR sg13_lv_pmos ad=0.34p pd=2.68u as=0 ps=0 w=1u l=1u
X571 sg13cmos5l_mux4_1_0.S0 a_808_6956# VPWR VPWR sg13_lv_pmos ad=0.42p pd=2.99u as=0.2114p ps=1.54u w=1.12u l=0.13u
X572 a_7236_3569# a_6948_3148# a_7174_3569# VGND.t676 sg13_lv_nmos ad=0.1428p pd=1.52u as=37.8f ps=0.6u w=0.42u l=0.13u
X573 VPWR VGND.t402 VPWR VPWR sg13_lv_pmos ad=0.19p pd=1.38u as=0 ps=0 w=1u l=1u
X574 VGND.t201 VPWR VGND.t201 VGND.t200 sg13_lv_nmos ad=0.1428p pd=1.52u as=0 ps=0 w=0.42u l=1u
X575 a_12022_8058# sg13cmos5l_o21ai_1_3.A2 VGND.t137 VGND.t51 sg13_lv_nmos ad=0.1406p pd=1.12u as=0.1406p ps=1.12u w=0.74u l=0.15u
X576 a_4492_3894# a_4109_3858# VPWR VPWR sg13_lv_pmos ad=79.8f pd=0.8u as=0.2639p ps=1.81u w=0.42u l=0.13u
X577 VPWR VGND.t12 VPWR VPWR sg13_lv_pmos ad=0.34p pd=2.68u as=0 ps=0 w=1u l=1u
X578 VGND.t402 VPWR VGND.t402 VGND.t19 sg13_lv_nmos ad=0.1428p pd=1.52u as=0 ps=0 w=0.42u l=1u
X579 VGND.t559 VPWR VGND.t558 VGND.t557 sg13_lv_nmos ad=0.1428p pd=1.52u as=0 ps=0 w=0.42u l=1u
X580 VPWR VGND.t97 VPWR VPWR sg13_lv_pmos ad=0.34p pd=2.68u as=0 ps=0 w=1u l=1u
X581 sg13cmos5l_o21ai_1_0.A1 a_3016_6168# VPWR VPWR sg13_lv_pmos ad=0.42p pd=2.99u as=0.2114p ps=1.54u w=1.12u l=0.13u
X582 VPWR sg13cmos5l_inv_1_31.A sg13cmos5l_inv_1_31.Y VPWR sg13_lv_pmos ad=0.3808p pd=2.92u as=0.3808p ps=2.92u w=1.12u l=0.13u
X583 VGND.t763 invsel[3] a_808_8468# VGND.t855 sg13_lv_nmos ad=0.14875p pd=1.16u as=0.187p ps=1.78u w=0.55u l=0.13u
X584 VPWR sg13cmos5l_inv_1_89.A sg13cmos5l_inv_1_96.A VPWR sg13_lv_pmos ad=0.3808p pd=2.92u as=0.3808p ps=2.92u w=1.12u l=0.13u
X585 sg13cmos5l_buf_1_0.X a_808_1632# VPWR VPWR sg13_lv_pmos ad=0.42p pd=2.99u as=0.2114p ps=1.54u w=1.12u l=0.13u
X586 sg13cmos5l_inv_1_132.Y sg13cmos5l_inv_1_8.Y VPWR VPWR sg13_lv_pmos ad=0.3808p pd=2.92u as=0.3808p ps=2.92u w=1.12u l=0.13u
X587 VPWR VGND.t386 VPWR VPWR sg13_lv_pmos ad=0.34p pd=2.68u as=0 ps=0 w=1u l=1u
X588 a_5505_6516# sg13cmos5l_buf_1_2.X a_5014_6558# VGND.t785 sg13_lv_nmos ad=0.1216p pd=1.02u as=0.54188p ps=3.42u w=0.64u l=0.13u
X589 VGND.t305 VPWR VGND.t306 VGND.t293 sg13_lv_nmos ad=79.8f pd=0.8u as=0 ps=0 w=0.42u l=1u
X590 a_4750_3267# a_4492_3582# VPWR VPWR sg13_lv_pmos ad=93.45f pd=0.865u as=4.30725p ps=28.325u w=0.42u l=0.13u
X591 VGND.t292 VPWR VGND.t291 VGND.t21 sg13_lv_nmos ad=0.1428p pd=1.52u as=0 ps=0 w=0.42u l=1u
X592 VGND.t132 VPWR VGND.t134 VGND.t159 sg13_lv_nmos ad=79.8f pd=0.8u as=0 ps=0 w=0.42u l=1u
X593 a_1821_8434# sg13cmos5l_buf_1_4.A VGND.t3 VGND.t755 sg13_lv_nmos ad=0.13135p pd=1.095u as=0.18945p ps=1.27u w=0.74u l=0.13u
X594 VPWR sg13cmos5l_mux2_1_3.A0 sg13cmos5l_inv_1_73.A VPWR sg13_lv_pmos ad=0.3808p pd=2.92u as=0.3808p ps=2.92u w=1.12u l=0.13u
X595 VPWR VGND.t558 VPWR VPWR sg13_lv_pmos ad=0.34p pd=2.68u as=0 ps=0 w=1u l=1u
X596 VPWR sg13cmos5l_nand2_1_1.A a_5902_6960# VPWR sg13_lv_pmos ad=0.2618p pd=1.63u as=0.2856p ps=2.36u w=0.84u l=0.13u
X597 a_10462_8434# sg13cmos5l_buf_1_2.X a_10375_8701# VPWR sg13_lv_pmos ad=0.19p pd=1.38u as=0.415p ps=1.83u w=1u l=0.13u
X598 a_9622_8426# sg13cmos5l_o21ai_1_6.A2 VGND.t52 VGND.t818 sg13_lv_nmos ad=0.1406p pd=1.12u as=0.1406p ps=1.12u w=0.74u l=0.15u
X599 VPWR VGND.t210 VPWR VPWR sg13_lv_pmos ad=0.34p pd=2.68u as=0 ps=0 w=1u l=1u
X600 VPWR VGND.t394 VPWR VPWR sg13_lv_pmos ad=0.34p pd=2.68u as=0 ps=0 w=1u l=1u
X601 sg13cmos5l_inv_1_109.A sg13cmos5l_inv_1_83.A VPWR VPWR sg13_lv_pmos ad=0.3808p pd=2.92u as=0.3808p ps=2.92u w=1.12u l=0.13u
X602 VPWR VGND.t155 VPWR VPWR sg13_lv_pmos ad=0.19p pd=1.38u as=0 ps=0 w=1u l=1u
X603 VPWR VGND.t402 VPWR VPWR sg13_lv_pmos ad=0.19p pd=1.38u as=0 ps=0 w=1u l=1u
X604 VGND.t147 VPWR VGND.t147 VGND.t55 sg13_lv_nmos ad=79.8f pd=0.8u as=0 ps=0 w=0.42u l=1u
X605 a_5492_8434# sg13cmos5l_mux4_1_0.S0 a_5374_8434# VGND.t791 sg13_lv_nmos ad=0.2304p pd=1.36u as=0.1472p ps=1.1u w=0.64u l=0.13u
X606 VGND.t627 sg13cmos5l_inv_1_16.Y a_4347_5448# VGND.t733 sg13_lv_nmos ad=0.14505p pd=1.15u as=0.187p ps=1.78u w=0.55u l=0.13u
X607 VGND.t7 sg13cmos5l_inv_1_33.Y sg13cmos5l_inv_1_31.A VGND.t650 sg13_lv_nmos ad=0.2516p pd=2.16u as=0.2516p ps=2.16u w=0.74u l=0.13u
X608 VGND.t52 VPWR VGND.t52 VGND.t176 sg13_lv_nmos ad=0.1428p pd=1.52u as=0 ps=0 w=0.42u l=1u
X609 VGND.t402 VPWR VGND.t402 VGND.t19 sg13_lv_nmos ad=0.1428p pd=1.52u as=0 ps=0 w=0.42u l=1u
X610 VPWR sg13cmos5l_inv_1_138.Y sg13cmos5l_inv_1_28.Y VPWR sg13_lv_pmos ad=0.3808p pd=2.92u as=0.3808p ps=2.92u w=1.12u l=0.13u
X611 VPWR VGND.t503 VPWR VPWR sg13_lv_pmos ad=0.34p pd=2.68u as=0 ps=0 w=1u l=1u
X612 VGND.t1 VPWR VGND.t1 VGND.t231 sg13_lv_nmos ad=79.8f pd=0.8u as=0 ps=0 w=0.42u l=1u
X613 a_12093_9462# sg13cmos5l_nand2b_1_4.A_N VGND.t84 VGND.t950 sg13_lv_nmos ad=0.187p pd=1.78u as=0.14505p ps=1.15u w=0.55u l=0.13u
X614 sg13cmos5l_inv_1_107.A sg13cmos5l_inv_1_103.A VPWR VPWR sg13_lv_pmos ad=0.3808p pd=2.92u as=0.3808p ps=2.92u w=1.12u l=0.13u
X615 sg13cmos5l_inv_1_4.Y sg13cmos5l_mux2_1_0.A1 VGND.t254 VGND.t721 sg13_lv_nmos ad=0.2516p pd=2.16u as=0.2516p ps=2.16u w=0.74u l=0.13u
X616 VPWR VGND.t306 VPWR VPWR sg13_lv_pmos ad=0.19p pd=1.38u as=0 ps=0 w=1u l=1u
X617 sg13cmos5l_inv_1_117.A sg13cmos5l_inv_1_132.Y VGND.t258 VGND.t851 sg13_lv_nmos ad=0.2516p pd=2.16u as=0.2516p ps=2.16u w=0.74u l=0.13u
X618 VPWR sg13cmos5l_mux2_1_2.X a_6101_8747# VPWR sg13_lv_pmos ad=0.34p pd=2.68u as=0.135p ps=1.27u w=1u l=0.13u
X619 a_5014_6558# a_5581_6442# a_5505_6516# VPWR sg13_lv_pmos ad=0.34p pd=2.68u as=0.2225p ps=1.445u w=1u l=0.13u
X620 sg13cmos5l_inv_1_104.Y sg13cmos5l_nand2b_1_4.A_N VGND.t87 VGND.t951 sg13_lv_nmos ad=0.2516p pd=2.16u as=0.2516p ps=2.16u w=0.74u l=0.13u
X621 VGND.t39 VPWR VGND.t39 VGND.t21 sg13_lv_nmos ad=79.8f pd=0.8u as=0 ps=0 w=0.42u l=1u
X622 sg13cmos5l_mux2_1_7.A1 sg13cmos5l_inv_1_82.Y VGND.t12 VGND.t665 sg13_lv_nmos ad=0.2516p pd=2.16u as=0.2516p ps=2.16u w=0.74u l=0.13u
X623 VGND.t412 VPWR VGND.t410 VGND.t19 sg13_lv_nmos ad=0.1428p pd=1.52u as=0 ps=0 w=0.42u l=1u
X624 VPWR VGND.t402 VPWR VPWR sg13_lv_pmos ad=0.34p pd=2.68u as=0 ps=0 w=1u l=1u
X625 VGND.t489 VPWR VGND.t488 VGND.t487 sg13_lv_nmos ad=0.1428p pd=1.52u as=0 ps=0 w=0.42u l=1u
X626 VGND.t21 sg13cmos5l_nand3b_1_0.C a_4991_3115# VGND.t633 sg13_lv_nmos ad=5.21338p pd=34.275u as=0.2516p ps=2.16u w=0.74u l=0.13u
X627 VGND.t420 VPWR VGND.t420 VGND.t19 sg13_lv_nmos ad=0.1428p pd=1.52u as=0 ps=0 w=0.42u l=1u
X628 VPWR VGND.t262 VPWR VPWR sg13_lv_pmos ad=0.34p pd=2.68u as=0 ps=0 w=1u l=1u
X629 sg13cmos5l_mux2_1_1.X a_4510_5026# VPWR VPWR sg13_lv_pmos ad=0.6048p pd=3.32u as=0.2198p ps=1.52u w=1.12u l=0.13u
X630 a_4717_6219# a_4199_6558# a_4510_6558# VPWR sg13_lv_pmos ad=0.16p pd=1.32u as=0.19p ps=1.38u w=1u l=0.13u
X631 sg13cmos5l_inv_1_53.Y sg13cmos5l_inv_1_69.Y VGND.t164 VGND.t751 sg13_lv_nmos ad=0.2516p pd=2.16u as=0.2516p ps=2.16u w=0.74u l=0.13u
X632 sg13cmos5l_mux2_1_3.X a_1918_8434# VPWR VPWR sg13_lv_pmos ad=0.6048p pd=3.32u as=0.2198p ps=1.52u w=1.12u l=0.13u
X633 sg13cmos5l_inv_1_72.A sg13cmos5l_inv_1_73.Y VGND.t64 VGND.t971 sg13_lv_nmos ad=0.2516p pd=2.16u as=0.2516p ps=2.16u w=0.74u l=0.13u
X634 sg13cmos5l_nand3b_1_0.Y sg13cmos5l_nand3b_1_0.C VPWR VPWR sg13_lv_pmos ad=0.2128p pd=1.5u as=0.2198p ps=1.53u w=1.12u l=0.13u
X635 VGND.t26 VPWR VGND.t26 VGND.t276 sg13_lv_nmos ad=79.8f pd=0.8u as=0 ps=0 w=0.42u l=1u
X636 VPWR VGND.t412 VPWR VPWR sg13_lv_pmos ad=0.34p pd=2.68u as=0 ps=0 w=1u l=1u
X637 VGND.t30 sg13cmos5l_nor2b_1_0.B_N a_7726_3936# VGND.t864 sg13_lv_nmos ad=0.17255p pd=1.25u as=0.187p ps=1.78u w=0.55u l=0.13u
X638 VPWR sg13cmos5l_inv_1_39.A sg13cmos5l_inv_1_40.A VPWR sg13_lv_pmos ad=0.3808p pd=2.92u as=0.3808p ps=2.92u w=1.12u l=0.13u
X639 VPWR VGND.t55 VPWR VPWR sg13_lv_pmos ad=0.19p pd=1.38u as=0 ps=0 w=1u l=1u
X640 a_14462_5704# sg13cmos5l_inv_1_7.Y a_14030_5596# VPWR sg13_lv_pmos ad=0.3325p pd=1.665u as=0.2225p ps=1.445u w=1u l=0.13u
X641 VPWR VGND.t488 VPWR VPWR sg13_lv_pmos ad=0.34p pd=2.68u as=0 ps=0 w=1u l=1u
X642 VPWR sg13cmos5l_inv_1_22.Y a_8236_4656# VPWR sg13_lv_pmos ad=0.4032p pd=2.96u as=0.1176p ps=1.33u w=1.12u l=0.13u
X643 VGND.t299 VPWR VGND.t300 VGND.t293 sg13_lv_nmos ad=79.8f pd=0.8u as=0 ps=0 w=0.42u l=1u
X644 VPWR VGND.t39 VPWR VPWR sg13_lv_pmos ad=0.19p pd=1.38u as=0 ps=0 w=1u l=1u
X645 sg13cmos5l_inv_1_8.Y sg13cmos5l_inv_1_7.Y VPWR VPWR sg13_lv_pmos ad=0.3808p pd=2.92u as=0.3808p ps=2.92u w=1.12u l=0.13u
X646 sg13cmos5l_mux2_1_8.X a_10462_5410# VPWR VPWR sg13_lv_pmos ad=0.6048p pd=3.32u as=0.2198p ps=1.52u w=1.12u l=0.13u
X647 VGND.t402 VPWR VGND.t402 VGND.t19 sg13_lv_nmos ad=0.1428p pd=1.52u as=0 ps=0 w=0.42u l=1u
X648 sg13cmos5l_inv_1_30.A sg13cmos5l_inv_1_31.Y VPWR VPWR sg13_lv_pmos ad=0.3808p pd=2.92u as=0.3808p ps=2.92u w=1.12u l=0.13u
X649 VGND.t1 VPWR VGND.t1 VGND.t206 sg13_lv_nmos ad=0.1428p pd=1.52u as=0 ps=0 w=0.42u l=1u
X650 VPWR VGND.t402 VPWR VPWR sg13_lv_pmos ad=0.34p pd=2.68u as=0 ps=0 w=1u l=1u
X651 VGND.t7 sg13cmos5l_inv_1_33.Y a_2043_6960# VGND.t649 sg13_lv_nmos ad=0.14505p pd=1.15u as=0.187p ps=1.78u w=0.55u l=0.13u
X652 VPWR VGND.t508 VPWR VPWR sg13_lv_pmos ad=0.34p pd=2.68u as=0 ps=0 w=1u l=1u
X653 VPWR VGND.t97 VPWR VPWR sg13_lv_pmos ad=0.34p pd=2.68u as=0 ps=0 w=1u l=1u
X654 VGND.t139 VPWR VGND.t139 VGND.t51 sg13_lv_nmos ad=0.1428p pd=1.52u as=0 ps=0 w=0.42u l=1u
X655 VGND.t328 VPWR VGND.t329 VGND.t21 sg13_lv_nmos ad=79.8f pd=0.8u as=0 ps=0 w=0.42u l=1u
X656 VGND.t52 VPWR VGND.t52 VGND.t136 sg13_lv_nmos ad=79.8f pd=0.8u as=0 ps=0 w=0.42u l=1u
X657 a_4586_3582# a_4109_3108# a_4492_3582# VGND.t21 sg13_lv_nmos ad=37.8f pd=0.6u as=0.1428p ps=1.52u w=0.42u l=0.13u
X658 VPWR VGND.t72 VPWR VPWR sg13_lv_pmos ad=0.34p pd=2.68u as=0 ps=0 w=1u l=1u
X659 VPWR VGND.t286 VPWR VPWR sg13_lv_pmos ad=0.34p pd=2.68u as=0 ps=0 w=1u l=1u
X660 a_2032_8434# sg13cmos5l_mux2_1_3.A0 a_1918_8434# VGND.t740 sg13_lv_nmos ad=0.3367p pd=1.65u as=0.1628p ps=1.18u w=0.74u l=0.13u
X661 sg13cmos5l_inv_1_72.A sg13cmos5l_inv_1_73.Y VPWR VPWR sg13_lv_pmos ad=0.3808p pd=2.92u as=0.3808p ps=2.92u w=1.12u l=0.13u
X662 VPWR sg13cmos5l_inv_1_42.A sg13cmos5l_mux2_1_4.A1 VPWR sg13_lv_pmos ad=0.3808p pd=2.92u as=0.3808p ps=2.92u w=1.12u l=0.13u
X663 VPWR VGND.t412 VPWR VPWR sg13_lv_pmos ad=0.34p pd=2.68u as=0 ps=0 w=1u l=1u
X664 a_11544_9172# sg13cmos5l_mux2_1_0.S VPWR VPWR sg13_lv_pmos ad=0.2128p pd=1.5u as=0.3808p ps=2.92u w=1.12u l=0.15u
X665 VPWR sg13cmos5l_and2_1_0.B a_7629_5004# VPWR sg13_lv_pmos ad=0.1918p pd=1.5u as=0.1596p ps=1.22u w=0.84u l=0.13u
X666 a_7158_4192# sg13cmos5l_inv_1_22.Y VPWR VPWR sg13_lv_pmos ad=0.2128p pd=1.5u as=0.3808p ps=2.92u w=1.12u l=0.13u
X667 VGND.t12 VPWR VGND.t54 VGND.t214 sg13_lv_nmos ad=0.1428p pd=1.52u as=0 ps=0 w=0.42u l=1u
X668 VPWR VGND.t493 VPWR VPWR sg13_lv_pmos ad=0.34p pd=2.68u as=0 ps=0 w=1u l=1u
X669 VPWR sg13cmos5l_inv_1_20.A sg13cmos5l_inv_1_130.A VPWR sg13_lv_pmos ad=0.3808p pd=2.92u as=0.3808p ps=2.92u w=1.12u l=0.13u
X670 a_7066_6538# sg13cmos5l_nand2_1_1.B VGND.t1 VGND.t967 sg13_lv_nmos ad=0.1406p pd=1.12u as=0.2516p ps=2.16u w=0.74u l=0.13u
X671 VGND.t39 VPWR VGND.t39 VGND.t21 sg13_lv_nmos ad=79.8f pd=0.8u as=0 ps=0 w=0.42u l=1u
X672 a_7236_3569# a_7467_3155# a_6922_3112# VGND.t717 sg13_lv_nmos ad=0.2373p pd=1.97u as=79.8f ps=0.8u w=0.42u l=0.13u
X673 a_6038_3569# a_4860_3505# a_5642_3424# VGND.t40 sg13_lv_nmos ad=37.8f pd=0.6u as=0.1428p ps=1.52u w=0.42u l=0.13u
X674 VPWR VGND.t14 VPWR VPWR sg13_lv_pmos ad=0.19p pd=1.38u as=0 ps=0 w=1u l=1u
X675 VPWR sg13cmos5l_buf_1_1.X a_6142_2428# VPWR sg13_lv_pmos ad=0.2198p pd=1.53u as=0.2856p ps=2.36u w=0.84u l=0.13u
X676 VPWR VGND.t52 VPWR VPWR sg13_lv_pmos ad=0.34p pd=2.68u as=0 ps=0 w=1u l=1u
X677 sg13cmos5l_mux2_1_0.S a_11848_5444# VGND.t248 VGND.t883 sg13_lv_nmos ad=0.2886p pd=2.26u as=0.14875p ps=1.16u w=0.74u l=0.13u
X678 VPWR VGND.t298 VPWR VPWR sg13_lv_pmos ad=0.19p pd=1.38u as=0 ps=0 w=1u l=1u
X679 VPWR VGND.t402 VPWR VPWR sg13_lv_pmos ad=0.34p pd=2.68u as=0 ps=0 w=1u l=1u
X680 sg13cmos5l_inv_1_133.Y sg13cmos5l_mux2_1_7.A1 VPWR VPWR sg13_lv_pmos ad=0.3808p pd=2.92u as=0.3808p ps=2.92u w=1.12u l=0.13u
X681 VPWR VGND.t1 VPWR VPWR sg13_lv_pmos ad=0.19p pd=1.38u as=0 ps=0 w=1u l=1u
X682 sg13cmos5l_a221oi_1_0.C1 sg13cmos5l_nor3_1_0.C VGND.t164 VGND.t874 sg13_lv_nmos ad=0.2618p pd=2.22u as=0.1463p ps=1.15u w=0.77u l=0.13u
X683 VPWR VGND.t84 VPWR VPWR sg13_lv_pmos ad=0.34p pd=2.68u as=0 ps=0 w=1u l=1u
X684 VGND.t579 VPWR VGND.t578 VGND.t577 sg13_lv_nmos ad=0.1428p pd=1.52u as=0 ps=0 w=0.42u l=1u
X685 sg13cmos5l_buf_1_0.X a_808_1632# VGND.t20 VGND.t19 sg13_lv_nmos ad=0.2886p pd=2.26u as=0.14875p ps=1.16u w=0.74u l=0.13u
X686 VGND.t394 VPWR VGND.t394 VGND.t19 sg13_lv_nmos ad=0.1428p pd=1.52u as=0 ps=0 w=0.42u l=1u
X687 VPWR VGND.t97 VPWR VPWR sg13_lv_pmos ad=0.19p pd=1.38u as=0 ps=0 w=1u l=1u
X688 VPWR sg13cmos5l_inv_1_36.A sg13cmos5l_inv_1_69.A VPWR sg13_lv_pmos ad=0.3808p pd=2.92u as=0.3808p ps=2.92u w=1.12u l=0.13u
X689 a_8409_3267# a_7467_3155# a_8207_3505# VPWR sg13_lv_pmos ad=93.45f pd=0.865u as=0.2048p ps=1.63u w=0.42u l=0.13u
X690 VPWR VGND.t164 VPWR VPWR sg13_lv_pmos ad=0.34p pd=2.68u as=0 ps=0 w=1u l=1u
X691 VGND.t52 VPWR VGND.t52 VGND.t135 sg13_lv_nmos ad=0.1428p pd=1.52u as=0 ps=0 w=0.42u l=1u
X692 VPWR VGND.t333 VPWR VPWR sg13_lv_pmos ad=0.19p pd=1.38u as=0 ps=0 w=1u l=1u
X693 a_12124_5026# sg13cmos5l_mux2_1_0.A1 a_11630_4922# VGND.t720 sg13_lv_nmos ad=0.13135p pd=1.095u as=0.1628p ps=1.18u w=0.74u l=0.13u
X694 sg13cmos5l_inv_1_99.Y sg13cmos5l_inv_1_99.A VPWR VPWR sg13_lv_pmos ad=0.3808p pd=2.92u as=0.3808p ps=2.92u w=1.12u l=0.13u
X695 VPWR VGND.t84 VPWR VPWR sg13_lv_pmos ad=0.34p pd=2.68u as=0 ps=0 w=1u l=1u
X696 VPWR VGND.t412 VPWR VPWR sg13_lv_pmos ad=0.34p pd=2.68u as=0 ps=0 w=1u l=1u
X697 sg13cmos5l_a21o_1_0.X a_7020_5004# VPWR VPWR sg13_lv_pmos ad=0.3808p pd=2.92u as=0.3808p ps=2.92u w=1.12u l=0.13u
X698 sg13cmos5l_mux4_1_1.A2 a_5566_9946# VGND.t18 VGND.t942 sg13_lv_nmos ad=0.4033p pd=2.57u as=0.148p ps=1.14u w=0.74u l=0.13u
X699 VGND.t216 VPWR VGND.t216 VGND.t217 sg13_lv_nmos ad=0.1428p pd=1.52u as=0 ps=0 w=0.42u l=1u
X700 VPWR VGND.t89 VPWR VPWR sg13_lv_pmos ad=0.19p pd=1.38u as=0 ps=0 w=1u l=1u
X701 VPWR sg13cmos5l_nor2_1_1.A a_7468_6168# VPWR sg13_lv_pmos ad=0.4032p pd=2.96u as=0.1176p ps=1.33u w=1.12u l=0.13u
X702 VPWR VGND.t89 VPWR VPWR sg13_lv_pmos ad=0.34p pd=2.68u as=0 ps=0 w=1u l=1u
X703 VGND.t39 VPWR VGND.t291 VGND.t21 sg13_lv_nmos ad=79.8f pd=0.8u as=0 ps=0 w=0.42u l=1u
X704 VPWR sg13cmos5l_o21ai_1_7.Y a_4717_6219# VPWR sg13_lv_pmos ad=0.29275p pd=1.785u as=0.16p ps=1.32u w=1u l=0.13u
X705 a_5374_8434# sg13cmos5l_mux4_1_0.S0 a_5287_8701# VPWR sg13_lv_pmos ad=0.19p pd=1.38u as=0.415p ps=1.83u w=1u l=0.13u
X706 VGND.t302 VPWR VGND.t300 VGND.t293 sg13_lv_nmos ad=0.1428p pd=1.52u as=0 ps=0 w=0.42u l=1u
X707 VGND.t394 VPWR VGND.t394 VGND.t19 sg13_lv_nmos ad=79.8f pd=0.8u as=0 ps=0 w=0.42u l=1u
X708 VPWR sg13cmos5l_mux4_1_0.S0 a_5063_8434# VPWR sg13_lv_pmos ad=0.22315p pd=1.555u as=0.34p ps=2.68u w=1u l=0.13u
X709 sg13cmos5l_mux4_1_1.A2 a_5566_9946# VPWR VPWR sg13_lv_pmos ad=0.6048p pd=3.32u as=0.2198p ps=1.52u w=1.12u l=0.13u
X710 a_10462_5410# sg13cmos5l_inv_1_129.Y a_10365_5704# VPWR sg13_lv_pmos ad=0.2225p pd=1.445u as=0.3325p ps=1.665u w=1u l=0.13u
X711 VPWR sg13cmos5l_inv_1_30.Y a_1563_6224# VPWR sg13_lv_pmos ad=0.2198p pd=1.53u as=0.2856p ps=2.36u w=0.84u l=0.13u
X712 VGND.t509 VPWR VGND.t508 VGND.t507 sg13_lv_nmos ad=0.1428p pd=1.52u as=0 ps=0 w=0.42u l=1u
X713 VGND.t52 VPWR VGND.t52 VGND.t175 sg13_lv_nmos ad=79.8f pd=0.8u as=0 ps=0 w=0.42u l=1u
X714 VGND.t663 enable a_808_9980# VGND.t716 sg13_lv_nmos ad=0.14875p pd=1.16u as=0.187p ps=1.78u w=0.55u l=0.13u
X715 VPWR VGND.t324 VPWR VPWR sg13_lv_pmos ad=0.19p pd=1.38u as=0 ps=0 w=1u l=1u
X716 sg13cmos5l_inv_1_125.Y sg13cmos5l_nand2b_1_6.A_N VPWR VPWR sg13_lv_pmos ad=0.3808p pd=2.92u as=0.3808p ps=2.92u w=1.12u l=0.13u
X717 VPWR VGND.t147 VPWR VPWR sg13_lv_pmos ad=0.34p pd=2.68u as=0 ps=0 w=1u l=1u
X718 VPWR VGND.t412 VPWR VPWR sg13_lv_pmos ad=0.34p pd=2.68u as=0 ps=0 w=1u l=1u
X719 VGND.t7 sg13cmos5l_o21ai_1_0.A2 sg13cmos5l_inv_1_34.Y VGND.t6 sg13_lv_nmos ad=0.2516p pd=2.16u as=0.2516p ps=2.16u w=0.74u l=0.13u
X720 VGND.t144 VPWR VGND.t56 VGND.t55 sg13_lv_nmos ad=0.1428p pd=1.52u as=0 ps=0 w=0.42u l=1u
X721 VGND.t331 VPWR VGND.t330 VGND.t21 sg13_lv_nmos ad=0.1428p pd=1.52u as=0 ps=0 w=0.42u l=1u
X722 VPWR VGND.t10 VPWR VPWR sg13_lv_pmos ad=0.34p pd=2.68u as=0 ps=0 w=1u l=1u
X723 VGND.t10 VPWR VGND.t10 VGND.t272 sg13_lv_nmos ad=0.1428p pd=1.52u as=0 ps=0 w=0.42u l=1u
X724 VGND.t132 VPWR VGND.t132 VGND.t131 sg13_lv_nmos ad=0.1428p pd=1.52u as=0 ps=0 w=0.42u l=1u
X725 VPWR VGND.t139 VPWR VPWR sg13_lv_pmos ad=0.34p pd=2.68u as=0 ps=0 w=1u l=1u
X726 VGND.t286 VPWR VGND.t286 VGND.t21 sg13_lv_nmos ad=79.8f pd=0.8u as=0 ps=0 w=0.42u l=1u
X727 sg13cmos5l_inv_1_85.A sg13cmos5l_mux2_1_6.A0 VPWR VPWR sg13_lv_pmos ad=0.3808p pd=2.92u as=0.3808p ps=2.92u w=1.12u l=0.13u
X728 a_7365_3155# sg13cmos5l_dfrbp_1_1.CLK VGND.t21 VGND.t880 sg13_lv_nmos ad=0.2516p pd=2.16u as=5.21338p ps=34.275u w=0.74u l=0.13u
X729 a_5338_5026# sg13cmos5l_mux2_1_1.X VGND.t627 VGND.t850 sg13_lv_nmos ad=0.1406p pd=1.12u as=0.2516p ps=2.16u w=0.74u l=0.13u
X730 VPWR VGND.t300 VPWR VPWR sg13_lv_pmos ad=0.34p pd=2.68u as=0 ps=0 w=1u l=1u
X731 sg13cmos5l_nand2b_1_2.Y sg13cmos5l_mux2_1_0.S VPWR VPWR sg13_lv_pmos ad=0.2128p pd=1.5u as=0.2198p ps=1.53u w=1.12u l=0.13u
X732 VGND.t386 VPWR VGND.t386 VGND.t19 sg13_lv_nmos ad=79.8f pd=0.8u as=0 ps=0 w=0.42u l=1u
X733 a_10365_5410# sg13cmos5l_buf_1_10.X VGND.t10 VGND.t933 sg13_lv_nmos ad=0.13135p pd=1.095u as=0.18945p ps=1.27u w=0.74u l=0.13u
X734 VGND.t258 VPWR VGND.t258 VGND.t257 sg13_lv_nmos ad=0.1428p pd=1.52u as=0 ps=0 w=0.42u l=1u
X735 VPWR sg13cmos5l_inv_1_90.A sg13cmos5l_inv_1_89.A VPWR sg13_lv_pmos ad=0.3808p pd=2.92u as=0.3808p ps=2.92u w=1.12u l=0.13u
X736 VPWR sg13cmos5l_inv_1_58.A sg13cmos5l_inv_1_57.A VPWR sg13_lv_pmos ad=0.3808p pd=2.92u as=0.3808p ps=2.92u w=1.12u l=0.13u
X737 VGND.t164 VPWR VGND.t164 VGND.t169 sg13_lv_nmos ad=79.8f pd=0.8u as=0 ps=0 w=0.42u l=1u
X738 VGND.t305 VPWR VGND.t304 VGND.t293 sg13_lv_nmos ad=0.1428p pd=1.52u as=0 ps=0 w=0.42u l=1u
X739 a_6948_3148# a_6922_3112# VPWR VPWR sg13_lv_pmos ad=0.34p pd=2.68u as=0.36237p ps=2.605u w=1u l=0.13u
X740 VPWR VGND.t1 VPWR VPWR sg13_lv_pmos ad=0.19p pd=1.38u as=0 ps=0 w=1u l=1u
X741 VPWR VGND.t145 VPWR VPWR sg13_lv_pmos ad=0.34p pd=2.68u as=0 ps=0 w=1u l=1u
X742 a_5781_3191# a_4839_3231# a_5687_3191# VPWR sg13_lv_pmos ad=79.8f pd=0.8u as=0.1428p ps=1.52u w=0.42u l=0.13u
X743 VPWR sg13cmos5l_inv_1_75.A sg13cmos5l_inv_1_75.Y VPWR sg13_lv_pmos ad=0.3808p pd=2.92u as=0.3808p ps=2.92u w=1.12u l=0.13u
X744 VGND.t39 VPWR VGND.t39 VGND.t21 sg13_lv_nmos ad=0.1428p pd=1.52u as=0 ps=0 w=0.42u l=1u
X745 sg13cmos5l_inv_1_53.Y sg13cmos5l_inv_1_69.Y VPWR VPWR sg13_lv_pmos ad=0.3808p pd=2.92u as=0.3808p ps=2.92u w=1.12u l=0.13u
X746 VGND.t386 VPWR VGND.t386 VGND.t19 sg13_lv_nmos ad=79.8f pd=0.8u as=0 ps=0 w=0.42u l=1u
X747 sg13cmos5l_nand3b_1_0.Y a_6142_2428# a_6468_2390# VGND.t19 sg13_lv_nmos ad=0.3404p pd=2.4u as=0.1406p ps=1.12u w=0.74u l=0.13u
X748 VGND.t52 VPWR VGND.t52 VGND.t172 sg13_lv_nmos ad=0.1428p pd=1.52u as=0 ps=0 w=0.42u l=1u
X749 VGND.t81 sg13cmos5l_mux2_1_0.S a_11446_9570# VGND.t892 sg13_lv_nmos ad=0.1406p pd=1.12u as=0.2516p ps=2.16u w=0.74u l=0.15u
X750 VGND.t377 VPWR VGND.t377 VGND.t19 sg13_lv_nmos ad=79.8f pd=0.8u as=0 ps=0 w=0.42u l=1u
X751 VPWR VGND.t326 VPWR VPWR sg13_lv_pmos ad=0.19p pd=1.38u as=0 ps=0 w=1u l=1u
X752 VPWR VGND.t483 VPWR VPWR sg13_lv_pmos ad=0.34p pd=2.68u as=0 ps=0 w=1u l=1u
X753 VPWR VGND.t147 VPWR VPWR sg13_lv_pmos ad=0.34p pd=2.68u as=0 ps=0 w=1u l=1u
X754 a_4510_5026# sg13cmos5l_dfrbp_1_2.D a_4413_4680# VPWR sg13_lv_pmos ad=0.2225p pd=1.445u as=0.3325p ps=1.665u w=1u l=0.13u
X755 sg13cmos5l_inv_1_1.Y sg13cmos5l_inv_1_0.Y VPWR VPWR sg13_lv_pmos ad=0.3808p pd=2.92u as=0.3808p ps=2.92u w=1.12u l=0.13u
X756 sg13cmos5l_inv_1_118.A sg13cmos5l_inv_1_30.Y VPWR VPWR sg13_lv_pmos ad=0.3808p pd=2.92u as=0.3808p ps=2.92u w=1.12u l=0.13u
X757 VGND.t334 VPWR VGND.t333 VGND.t21 sg13_lv_nmos ad=0.1428p pd=1.52u as=0 ps=0 w=0.42u l=1u
X758 VGND.t194 VPWR VGND.t194 VGND.t193 sg13_lv_nmos ad=0.1428p pd=1.52u as=0 ps=0 w=0.42u l=1u
X759 sg13cmos5l_buf_1_2.X a_808_3932# VGND.t286 VGND.t21 sg13_lv_nmos ad=0.2886p pd=2.26u as=0.14875p ps=1.16u w=0.74u l=0.13u
X760 a_5781_4052# sg13cmos5l_dfrbp_1_2.RESET_B.t5 VPWR VPWR sg13_lv_pmos ad=0.147p pd=1.54u as=0.1563p ps=1.22u w=0.42u l=0.13u
X761 VPWR VGND.t318 VPWR VPWR sg13_lv_pmos ad=0.19p pd=1.38u as=0 ps=0 w=1u l=1u
X762 VPWR VGND.t89 VPWR VPWR sg13_lv_pmos ad=0.34p pd=2.68u as=0 ps=0 w=1u l=1u
X763 VGND.t1 VPWR VGND.t1 VGND.t230 sg13_lv_nmos ad=0.1428p pd=1.52u as=0 ps=0 w=0.42u l=1u
X764 VPWR VGND.t304 VPWR VPWR sg13_lv_pmos ad=0.34p pd=2.68u as=0 ps=0 w=1u l=1u
X765 sg13cmos5l_a221oi_1_0.C1 sg13cmos5l_nand2_1_1.A VGND.t164 VGND.t776 sg13_lv_nmos ad=0.1694p pd=1.21u as=0.2618p ps=2.22u w=0.77u l=0.13u
X766 VGND.t377 VPWR VGND.t382 VGND.t19 sg13_lv_nmos ad=79.8f pd=0.8u as=0 ps=0 w=0.42u l=1u
X767 VGND.t394 VPWR VGND.t394 VGND.t19 sg13_lv_nmos ad=79.8f pd=0.8u as=0 ps=0 w=0.42u l=1u
X768 sg13cmos5l_mux4_1_0.A0 sg13cmos5l_nand2b_1_1.Y VPWR VPWR sg13_lv_pmos ad=0.2128p pd=1.5u as=0.3808p ps=2.92u w=1.12u l=0.15u
X769 VPWR VGND.t39 VPWR VPWR sg13_lv_pmos ad=0.19p pd=1.38u as=0 ps=0 w=1u l=1u
X770 VPWR sg13cmos5l_inv_1_92.A sg13cmos5l_inv_1_91.A VPWR sg13_lv_pmos ad=0.3808p pd=2.92u as=0.3808p ps=2.92u w=1.12u l=0.13u
X771 VPWR invsel[3] a_808_8468# VPWR sg13_lv_pmos ad=0.2114p pd=1.54u as=0.2856p ps=2.36u w=0.84u l=0.13u
X772 a_5680_9946# sg13cmos5l_inv_1_45.A a_5566_9946# VGND.t871 sg13_lv_nmos ad=0.3367p pd=1.65u as=0.1628p ps=1.18u w=0.74u l=0.13u
X773 sg13cmos5l_mux4_1_0.X a_5505_6516# VPWR VPWR sg13_lv_pmos ad=0.3808p pd=2.92u as=0.34367p ps=1.775u w=1.12u l=0.13u
X774 VPWR sg13cmos5l_buf_1_4.A a_4091_8472# VPWR sg13_lv_pmos ad=0.253p pd=1.53u as=0.2856p ps=2.36u w=0.84u l=0.13u
X775 sg13cmos5l_inv_1_17.Y sg13cmos5l_inv_1_17.A VGND.t39 VGND.t21 sg13_lv_nmos ad=0.2516p pd=2.16u as=0.2516p ps=2.16u w=0.74u l=0.13u
X776 VPWR sg13cmos5l_inv_1_89.A a_11067_6960# VPWR sg13_lv_pmos ad=0.2198p pd=1.53u as=0.2856p ps=2.36u w=0.84u l=0.13u
X777 VGND.t199 sg13cmos5l_o21ai_1_1.A2 a_4210_6914# VGND.t841 sg13_lv_nmos ad=0.1406p pd=1.12u as=0.1406p ps=1.12u w=0.74u l=0.15u
X778 VPWR VGND.t147 VPWR VPWR sg13_lv_pmos ad=0.34p pd=2.68u as=0 ps=0 w=1u l=1u
X779 VGND.t598 VPWR VGND.t597 VGND.t596 sg13_lv_nmos ad=0.1428p pd=1.52u as=0 ps=0 w=0.42u l=1u
X780 VGND.t386 VPWR VGND.t386 VGND.t19 sg13_lv_nmos ad=79.8f pd=0.8u as=0 ps=0 w=0.42u l=1u
X781 VGND.t52 sg13cmos5l_inv_1_75.A sg13cmos5l_inv_1_75.Y VGND.t780 sg13_lv_nmos ad=0.2516p pd=2.16u as=0.2516p ps=2.16u w=0.74u l=0.13u
X782 VPWR VGND.t245 VPWR VPWR sg13_lv_pmos ad=0.34p pd=2.68u as=0 ps=0 w=1u l=1u
X783 VPWR VGND.t536 VPWR VPWR sg13_lv_pmos ad=0.19p pd=1.38u as=0 ps=0 w=1u l=1u
X784 VGND.t52 sg13cmos5l_inv_1_83.A a_11314_8058# VGND.t51 sg13_lv_nmos ad=0.1406p pd=1.12u as=0.1406p ps=1.12u w=0.74u l=0.15u
X785 VPWR VGND.t1 VPWR VPWR sg13_lv_pmos ad=0.34p pd=2.68u as=0 ps=0 w=1u l=1u
X786 VGND.t16 sg13cmos5l_inv_1_42.A sg13cmos5l_mux2_1_4.A1 VGND.t62 sg13_lv_nmos ad=0.2516p pd=2.16u as=0.2516p ps=2.16u w=0.74u l=0.13u
X787 VPWR VGND.t164 VPWR VPWR sg13_lv_pmos ad=0.34p pd=2.68u as=0 ps=0 w=1u l=1u
X788 VPWR VGND.t377 VPWR VPWR sg13_lv_pmos ad=0.19p pd=1.38u as=0 ps=0 w=1u l=1u
X789 VPWR sg13cmos5l_inv_1_130.Y sg13cmos5l_inv_1_123.A VPWR sg13_lv_pmos ad=0.3808p pd=2.92u as=0.3808p ps=2.92u w=1.12u l=0.13u
X790 VPWR VGND.t357 VPWR VPWR sg13_lv_pmos ad=0.19p pd=1.38u as=0 ps=0 w=1u l=1u
X791 VGND.t402 VPWR VGND.t402 VGND.t19 sg13_lv_nmos ad=79.8f pd=0.8u as=0 ps=0 w=0.42u l=1u
X792 a_4606_9562# sg13cmos5l_mux2_1_4.A0 a_4509_9216# VPWR sg13_lv_pmos ad=0.2225p pd=1.445u as=0.3325p ps=1.665u w=1u l=0.13u
X793 VGND.t420 VPWR VGND.t420 VGND.t19 sg13_lv_nmos ad=79.8f pd=0.8u as=0 ps=0 w=0.42u l=1u
X794 VPWR VGND.t72 VPWR VPWR sg13_lv_pmos ad=0.34p pd=2.68u as=0 ps=0 w=1u l=1u
X795 a_6333_5596# sg13cmos5l_nand2b_1_6.A_N VPWR VPWR sg13_lv_pmos ad=0.2856p pd=2.36u as=0.2198p ps=1.53u w=0.84u l=0.13u
X796 sg13cmos5l_inv_1_6.A sg13cmos5l_inv_1_1.Y VPWR VPWR sg13_lv_pmos ad=0.3808p pd=2.92u as=0.3808p ps=2.92u w=1.12u l=0.13u
X797 VGND.t706 a_5781_3191# a_4860_3505# VGND.t817 sg13_lv_nmos ad=0.1626p pd=1.415u as=0.2516p ps=2.16u w=0.74u l=0.13u
X798 sg13cmos5l_o21ai_1_6.B1 a_12093_9462# VPWR VPWR sg13_lv_pmos ad=0.2128p pd=1.5u as=0.3808p ps=2.92u w=1.12u l=0.13u
X799 VGND.t208 sg13cmos5l_mux2_1_8.X a_12124_6558# VGND.t653 sg13_lv_nmos ad=0.1872p pd=1.225u as=76.8f ps=0.88u w=0.64u l=0.13u
X800 VPWR sg13cmos5l_inv_1_29.A sg13cmos5l_inv_1_29.Y VPWR sg13_lv_pmos ad=0.3808p pd=2.92u as=0.3808p ps=2.92u w=1.12u l=0.13u
X801 VGND.t197 VPWR VGND.t199 VGND.t198 sg13_lv_nmos ad=79.8f pd=0.8u as=0 ps=0 w=0.42u l=1u
X802 VGND.t382 VPWR VGND.t382 VGND.t19 sg13_lv_nmos ad=0.1428p pd=1.52u as=0 ps=0 w=0.42u l=1u
X803 a_6849_4656# sg13cmos5l_nor2b_1_0.B_N VPWR VPWR sg13_lv_pmos ad=0.2125p pd=1.425u as=0.19p ps=1.38u w=1u l=0.13u
X804 sg13cmos5l_buf_1_12.X a_808_5444# VPWR VPWR sg13_lv_pmos ad=0.42p pd=2.99u as=0.2114p ps=1.54u w=1.12u l=0.13u
X805 VPWR VGND.t595 VPWR VPWR sg13_lv_pmos ad=0.19p pd=1.38u as=0 ps=0 w=1u l=1u
X806 a_5687_4285# sg13cmos5l_dfrbp_1_0.D a_6434_3894# VGND.t634 sg13_lv_nmos ad=0.1428p pd=1.52u as=60.89999f ps=0.71u w=0.42u l=0.13u
X807 VGND.t382 VPWR VGND.t382 VGND.t19 sg13_lv_nmos ad=79.8f pd=0.8u as=0 ps=0 w=0.42u l=1u
X808 sg13cmos5l_inv_1_68.Y sg13cmos5l_inv_1_68.A VPWR VPWR sg13_lv_pmos ad=0.3808p pd=2.92u as=0.3808p ps=2.92u w=1.12u l=0.13u
X809 a_10462_8434# a_11533_8440# a_11457_8476# VGND.t55 sg13_lv_nmos ad=0.2176p pd=1.96u as=0.1216p ps=1.02u w=0.64u l=0.13u
X810 VGND.t102 VPWR VGND.t102 VGND.t127 sg13_lv_nmos ad=0.1428p pd=1.52u as=0 ps=0 w=0.42u l=1u
X811 VPWR VGND.t394 VPWR VPWR sg13_lv_pmos ad=0.19p pd=1.38u as=0 ps=0 w=1u l=1u
X812 a_4413_4680# sg13cmos5l_buf_1_0.X VPWR VPWR sg13_lv_pmos ad=0.3325p pd=1.665u as=0.253p ps=1.53u w=1u l=0.13u
X813 VPWR VGND.t39 VPWR VPWR sg13_lv_pmos ad=0.34p pd=2.68u as=0 ps=0 w=1u l=1u
X814 VGND.t84 VPWR VGND.t84 VGND.t85 sg13_lv_nmos ad=79.8f pd=0.8u as=0 ps=0 w=0.42u l=1u
X815 a_11620_6558# a_11371_6137# a_10904_6168# VGND.t673 sg13_lv_nmos ad=80f pd=0.89u as=0.1776p ps=1.195u w=0.64u l=0.13u
X816 VGND.t38 invsel[2] a_808_6956# VGND.t37 sg13_lv_nmos ad=0.14875p pd=1.16u as=0.187p ps=1.78u w=0.55u l=0.13u
X817 a_7370_7216# sg13cmos5l_nand2_1_1.A sg13cmos5l_a221oi_1_0.A2 VPWR sg13_lv_pmos ad=0.1176p pd=1.33u as=0.3808p ps=2.92u w=1.12u l=0.13u
X818 VGND.t412 VPWR VGND.t412 VGND.t19 sg13_lv_nmos ad=79.8f pd=0.8u as=0 ps=0 w=0.42u l=1u
X819 VGND.t549 VPWR VGND.t551 VGND.t550 sg13_lv_nmos ad=79.8f pd=0.8u as=0 ps=0 w=0.42u l=1u
X820 VPWR VGND.t541 VPWR VPWR sg13_lv_pmos ad=0.19p pd=1.38u as=0 ps=0 w=1u l=1u
X821 sg13cmos5l_nand2b_1_1.Y a_2043_6960# a_2245_6922# VGND.t860 sg13_lv_nmos ad=0.333p pd=2.38u as=0.1406p ps=1.12u w=0.74u l=0.13u
X822 a_6415_5410# a_6333_5596# sg13cmos5l_o21ai_1_5.B1 VGND.t923 sg13_lv_nmos ad=0.1406p pd=1.12u as=0.333p ps=2.38u w=0.74u l=0.13u
X823 VPWR VGND.t359 VPWR VPWR sg13_lv_pmos ad=0.19p pd=1.38u as=0 ps=0 w=1u l=1u
X824 VGND.t377 VPWR VGND.t377 VGND.t19 sg13_lv_nmos ad=0.1428p pd=1.52u as=0 ps=0 w=0.42u l=1u
X825 VGND.t686 sg13cmos5l_inv_1_89.A sg13cmos5l_inv_1_96.A VGND.t973 sg13_lv_nmos ad=0.2516p pd=2.16u as=0.2516p ps=2.16u w=0.74u l=0.13u
X826 VGND.t402 VPWR VGND.t402 VGND.t19 sg13_lv_nmos ad=79.8f pd=0.8u as=0 ps=0 w=0.42u l=1u
X827 a_13917_7950# sg13cmos5l_inv_1_93.A VGND.t56 VGND.t51 sg13_lv_nmos ad=0.187p pd=1.78u as=0.14505p ps=1.15u w=0.55u l=0.13u
X828 VGND.t420 VPWR VGND.t427 VGND.t19 sg13_lv_nmos ad=79.8f pd=0.8u as=0 ps=0 w=0.42u l=1u
X829 VPWR VGND.t420 VPWR VPWR sg13_lv_pmos ad=0.19p pd=1.38u as=0 ps=0 w=1u l=1u
X830 VPWR VGND.t578 VPWR VPWR sg13_lv_pmos ad=0.19p pd=1.38u as=0 ps=0 w=1u l=1u
X831 VGND.t641 sg13cmos5l_a21oi_1_0.Y a_7020_5004# VGND.t711 sg13_lv_nmos ad=0.15745p pd=1.175u as=0.1216p ps=1.02u w=0.64u l=0.13u
X832 VPWR VGND.t327 VPWR VPWR sg13_lv_pmos ad=0.34p pd=2.68u as=0 ps=0 w=1u l=1u
X833 a_5687_4285# a_4991_4164# a_5781_4052# VGND.t691 sg13_lv_nmos ad=0.1296p pd=1.52u as=79.8f ps=0.8u w=0.42u l=0.13u
X834 sg13cmos5l_a21oi_1_0.Y sg13cmos5l_nand2_1_0.Y a_6291_5004# VGND.t846 sg13_lv_nmos ad=0.1406p pd=1.12u as=0.1406p ps=1.12u w=0.74u l=0.13u
X835 VPWR sg13cmos5l_nand3b_1_0.C a_4991_3115# VPWR sg13_lv_pmos ad=4.30725p pd=28.325u as=0.4088p ps=2.97u w=1.12u l=0.13u
X836 VPWR VGND.t72 VPWR VPWR sg13_lv_pmos ad=0.19p pd=1.38u as=0 ps=0 w=1u l=1u
X837 a_6333_5596# sg13cmos5l_nand2b_1_6.A_N VGND.t32 VGND.t642 sg13_lv_nmos ad=0.187p pd=1.78u as=0.14505p ps=1.15u w=0.55u l=0.13u
X838 VPWR sg13cmos5l_inv_1_94.A sg13cmos5l_inv_1_93.A VPWR sg13_lv_pmos ad=0.3808p pd=2.92u as=0.3808p ps=2.92u w=1.12u l=0.13u
X839 a_5469_9946# sg13cmos5l_buf_1_4.A VGND.t46 VGND.t758 sg13_lv_nmos ad=0.13135p pd=1.095u as=0.18945p ps=1.27u w=0.74u l=0.13u
X840 VPWR VGND.t1 VPWR VPWR sg13_lv_pmos ad=0.34p pd=2.68u as=0 ps=0 w=1u l=1u
X841 VPWR a_4091_8472# a_4591_8728# VPWR sg13_lv_pmos ad=0.2198p pd=1.52u as=0.2975p ps=1.595u w=1u l=0.13u
X842 sg13cmos5l_inv_1_109.A sg13cmos5l_inv_1_83.A VGND.t54 VGND.t53 sg13_lv_nmos ad=0.2516p pd=2.16u as=0.2516p ps=2.16u w=0.74u l=0.13u
X843 VPWR VGND.t566 VPWR VPWR sg13_lv_pmos ad=0.19p pd=1.38u as=0 ps=0 w=1u l=1u
X844 VGND.t39 VPWR VGND.t39 VGND.t21 sg13_lv_nmos ad=0.1428p pd=1.52u as=0 ps=0 w=0.42u l=1u
X845 VPWR VGND.t139 VPWR VPWR sg13_lv_pmos ad=0.19p pd=1.38u as=0 ps=0 w=1u l=1u
X846 a_4509_9216# sg13cmos5l_o21ai_1_0.A1 VPWR VPWR sg13_lv_pmos ad=0.3325p pd=1.665u as=0.253p ps=1.53u w=1u l=0.13u
X847 VPWR VGND.t318 VPWR VPWR sg13_lv_pmos ad=0.34p pd=2.68u as=0 ps=0 w=1u l=1u
X848 VPWR VGND.t64 VPWR VPWR sg13_lv_pmos ad=0.34p pd=2.68u as=0 ps=0 w=1u l=1u
X849 VGND.t382 VPWR VGND.t386 VGND.t19 sg13_lv_nmos ad=79.8f pd=0.8u as=0 ps=0 w=0.42u l=1u
X850 sg13cmos5l_o21ai_1_6.Y sg13cmos5l_o21ai_1_6.A2 a_9720_8748# VPWR sg13_lv_pmos ad=0.2128p pd=1.5u as=0.2128p ps=1.5u w=1.12u l=0.15u
X851 VPWR VGND.t526 VPWR VPWR sg13_lv_pmos ad=0.19p pd=1.38u as=0 ps=0 w=1u l=1u
X852 sg13cmos5l_inv_1_68.Y sg13cmos5l_inv_1_68.A VGND.t3 VGND.t43 sg13_lv_nmos ad=0.2516p pd=2.16u as=0.2516p ps=2.16u w=0.74u l=0.13u
X853 VPWR VGND.t97 VPWR VPWR sg13_lv_pmos ad=0.34p pd=2.68u as=0 ps=0 w=1u l=1u
X854 sg13cmos5l_inv_1_23.Y sg13cmos5l_inv_1_26.Y VPWR VPWR sg13_lv_pmos ad=0.3808p pd=2.92u as=0.3808p ps=2.92u w=1.12u l=0.13u
X855 VGND.t420 VPWR VGND.t420 VGND.t19 sg13_lv_nmos ad=79.8f pd=0.8u as=0 ps=0 w=0.42u l=1u
X856 a_4109_3108# a_4839_3231# a_4750_3267# VPWR sg13_lv_pmos ad=0.2048p pd=1.63u as=93.45f ps=0.865u w=0.42u l=0.13u
X857 VGND.t211 VPWR VGND.t210 VGND.t209 sg13_lv_nmos ad=0.1428p pd=1.52u as=0 ps=0 w=0.42u l=1u
X858 VPWR VGND.t412 VPWR VPWR sg13_lv_pmos ad=0.19p pd=1.38u as=0 ps=0 w=1u l=1u
X859 VGND.t377 VPWR VGND.t377 VGND.t19 sg13_lv_nmos ad=79.8f pd=0.8u as=0 ps=0 w=0.42u l=1u
X860 VPWR VGND.t546 VPWR VPWR sg13_lv_pmos ad=0.19p pd=1.38u as=0 ps=0 w=1u l=1u
X861 VGND.t216 sg13cmos5l_inv_1_82.A sg13cmos5l_inv_1_82.Y VGND.t696 sg13_lv_nmos ad=0.2516p pd=2.16u as=0.2516p ps=2.16u w=0.74u l=0.13u
X862 a_4750_3894# a_4492_3894# VGND.t292 VGND.t21 sg13_lv_nmos ad=0.1428p pd=1.52u as=79.8f ps=0.8u w=0.42u l=0.13u
X863 sg13cmos5l_o21ai_1_3.Y sg13cmos5l_o21ai_1_3.A2 a_12120_7660# VPWR sg13_lv_pmos ad=0.2128p pd=1.5u as=0.2128p ps=1.5u w=1.12u l=0.15u
X864 VGND.t386 VPWR VGND.t386 VGND.t19 sg13_lv_nmos ad=0.1428p pd=1.52u as=0 ps=0 w=0.42u l=1u
X865 VGND.t30 sg13cmos5l_buf_1_0.X sg13cmos5l_nor4_1_0.Y VGND.t729 sg13_lv_nmos ad=0.1406p pd=1.12u as=0.1406p ps=1.12u w=0.74u l=0.13u
X866 a_4549_5410# sg13cmos5l_o21ai_1_0.A1 VGND.t627 VGND.t810 sg13_lv_nmos ad=0.1406p pd=1.12u as=0.14505p ps=1.15u w=0.74u l=0.13u
X867 VGND.t7 sg13cmos5l_inv_1_30.Y a_1563_6224# VGND.t801 sg13_lv_nmos ad=0.14505p pd=1.15u as=0.187p ps=1.78u w=0.55u l=0.13u
X868 VPWR sg13cmos5l_inv_1_91.A sg13cmos5l_inv_1_90.A VPWR sg13_lv_pmos ad=0.3808p pd=2.92u as=0.3808p ps=2.92u w=1.12u l=0.13u
X869 VPWR VGND.t377 VPWR VPWR sg13_lv_pmos ad=0.34p pd=2.68u as=0 ps=0 w=1u l=1u
X870 VGND.t412 VPWR VGND.t412 VGND.t19 sg13_lv_nmos ad=79.8f pd=0.8u as=0 ps=0 w=0.42u l=1u
X871 VPWR a_3990_4069# sg13cmos5l_dfrbp_1_0.Q VPWR sg13_lv_pmos ad=0.2128p pd=1.5u as=0.3808p ps=2.92u w=1.12u l=0.13u
X872 VPWR sg13cmos5l_inv_1_44.A sg13cmos5l_inv_1_43.A VPWR sg13_lv_pmos ad=0.3808p pd=2.92u as=0.3808p ps=2.92u w=1.12u l=0.13u
X873 VGND.t1 VPWR VGND.t1 VGND.t232 sg13_lv_nmos ad=0.1428p pd=1.52u as=0 ps=0 w=0.42u l=1u
X874 VPWR sg13cmos5l_inv_1_74.A sg13cmos5l_inv_1_74.Y VPWR sg13_lv_pmos ad=0.3808p pd=2.92u as=0.3808p ps=2.92u w=1.12u l=0.13u
X875 VGND.t394 VPWR VGND.t394 VGND.t19 sg13_lv_nmos ad=79.8f pd=0.8u as=0 ps=0 w=0.42u l=1u
X876 VPWR VGND.t394 VPWR VPWR sg13_lv_pmos ad=0.19p pd=1.38u as=0 ps=0 w=1u l=1u
X877 sg13cmos5l_inv_1_87.Y sg13cmos5l_inv_1_133.Y VGND.t54 VGND.t638 sg13_lv_nmos ad=0.2516p pd=2.16u as=0.2516p ps=2.16u w=0.74u l=0.13u
X878 VGND.t56 sg13cmos5l_mux2_1_0.S a_13999_8050# VGND.t51 sg13_lv_nmos ad=0.14505p pd=1.15u as=0.1406p ps=1.12u w=0.74u l=0.13u
X879 a_11409_6558# sg13cmos5l_mux4_1_2.A3 VGND.t208 VGND.t960 sg13_lv_nmos ad=76.8f pd=0.88u as=0.2176p ps=1.96u w=0.64u l=0.13u
X880 VGND.t72 VPWR VGND.t72 VGND.t112 sg13_lv_nmos ad=0.1428p pd=1.52u as=0 ps=0 w=0.42u l=1u
X881 VPWR VGND.t571 VPWR VPWR sg13_lv_pmos ad=0.19p pd=1.38u as=0 ps=0 w=1u l=1u
X882 VGND.t52 VPWR VGND.t52 VGND.t174 sg13_lv_nmos ad=0.1428p pd=1.52u as=0 ps=0 w=0.42u l=1u
X883 VGND.t569 VPWR VGND.t571 VGND.t570 sg13_lv_nmos ad=79.8f pd=0.8u as=0 ps=0 w=0.42u l=1u
X884 VPWR VGND.t141 VPWR VPWR sg13_lv_pmos ad=0.19p pd=1.38u as=0 ps=0 w=1u l=1u
X885 VPWR VGND.t321 VPWR VPWR sg13_lv_pmos ad=0.34p pd=2.68u as=0 ps=0 w=1u l=1u
X886 a_11630_4922# sg13cmos5l_mux2_1_0.A1 a_11802_4680# VPWR sg13_lv_pmos ad=0.2225p pd=1.445u as=0.2975p ps=1.595u w=1u l=0.13u
X887 VPWR a_4347_5448# sg13cmos5l_o21ai_1_7.B1 VPWR sg13_lv_pmos ad=0.3808p pd=2.92u as=0.2128p ps=1.5u w=1.12u l=0.13u
X888 VGND.t386 VPWR VGND.t386 VGND.t19 sg13_lv_nmos ad=79.8f pd=0.8u as=0 ps=0 w=0.42u l=1u
X889 sg13cmos5l_inv_1_123.Y sg13cmos5l_inv_1_123.A VGND.t10 VGND.t829 sg13_lv_nmos ad=0.2516p pd=2.16u as=0.2516p ps=2.16u w=0.74u l=0.13u
X890 VGND.t49 sg13cmos5l_inv_1_57.A sg13cmos5l_inv_1_45.A VGND.t943 sg13_lv_nmos ad=0.2516p pd=2.16u as=0.2516p ps=2.16u w=0.74u l=0.13u
X891 VPWR VGND.t377 VPWR VPWR sg13_lv_pmos ad=0.19p pd=1.38u as=0 ps=0 w=1u l=1u
X892 VGND.t270 VPWR VGND.t270 VGND.t271 sg13_lv_nmos ad=79.8f pd=0.8u as=0 ps=0 w=0.42u l=1u
X893 VGND.t402 VPWR VGND.t402 VGND.t19 sg13_lv_nmos ad=79.8f pd=0.8u as=0 ps=0 w=0.42u l=1u
X894 sg13cmos5l_inv_1_75.A sg13cmos5l_inv_1_74.Y VPWR VPWR sg13_lv_pmos ad=0.3808p pd=2.92u as=0.3808p ps=2.92u w=1.12u l=0.13u
X895 VPWR VGND.t420 VPWR VPWR sg13_lv_pmos ad=0.19p pd=1.38u as=0 ps=0 w=1u l=1u
X896 VPWR VGND.t516 VPWR VPWR sg13_lv_pmos ad=0.19p pd=1.38u as=0 ps=0 w=1u l=1u
X897 a_6943_5004# sg13cmos5l_nor4_1_0.Y VGND.t641 VGND.t680 sg13_lv_nmos ad=81.6f pd=0.895u as=0.2176p ps=1.96u w=0.64u l=0.13u
X898 VPWR sg13cmos5l_inv_1_129.Y sg13cmos5l_inv_1_20.A VPWR sg13_lv_pmos ad=0.3808p pd=2.92u as=0.3808p ps=2.92u w=1.12u l=0.13u
X899 VGND.t386 VPWR VGND.t386 VGND.t19 sg13_lv_nmos ad=0.1428p pd=1.52u as=0 ps=0 w=0.42u l=1u
X900 VPWR VGND.t543 VPWR VPWR sg13_lv_pmos ad=0.34p pd=2.68u as=0 ps=0 w=1u l=1u
X901 VPWR sg13cmos5l_inv_1_117.A sg13cmos5l_mux2_1_6.A0 VPWR sg13_lv_pmos ad=0.3808p pd=2.92u as=0.3808p ps=2.92u w=1.12u l=0.13u
X902 VGND.t504 VPWR VGND.t506 VGND.t505 sg13_lv_nmos ad=79.8f pd=0.8u as=0 ps=0 w=0.42u l=1u
X903 VPWR VGND.t72 VPWR VPWR sg13_lv_pmos ad=0.19p pd=1.38u as=0 ps=0 w=1u l=1u
X904 VGND.t412 VPWR VGND.t412 VGND.t19 sg13_lv_nmos ad=79.8f pd=0.8u as=0 ps=0 w=0.42u l=1u
X905 VPWR VGND.t556 VPWR VPWR sg13_lv_pmos ad=0.19p pd=1.38u as=0 ps=0 w=1u l=1u
X906 VPWR VGND.t412 VPWR VPWR sg13_lv_pmos ad=0.19p pd=1.38u as=0 ps=0 w=1u l=1u
X907 VPWR VGND.t5 VPWR VPWR sg13_lv_pmos ad=0.19p pd=1.38u as=0 ps=0 w=1u l=1u
X908 sg13cmos5l_inv_1_132.Y sg13cmos5l_inv_1_8.Y VGND.t26 VGND.t882 sg13_lv_nmos ad=0.2516p pd=2.16u as=0.2516p ps=2.16u w=0.74u l=0.13u
X909 VPWR VGND.t312 VPWR VPWR sg13_lv_pmos ad=0.34p pd=2.68u as=0 ps=0 w=1u l=1u
X910 VGND.t12 VPWR VGND.t12 VGND.t224 sg13_lv_nmos ad=79.8f pd=0.8u as=0 ps=0 w=0.42u l=1u
X911 VPWR VGND.t394 VPWR VPWR sg13_lv_pmos ad=0.19p pd=1.38u as=0 ps=0 w=1u l=1u
X912 VPWR a_5781_4052# a_4860_3858# VPWR sg13_lv_pmos ad=0.36237p pd=2.605u as=0.34p ps=2.68u w=1u l=0.13u
X913 VGND.t52 sg13cmos5l_inv_1_74.A sg13cmos5l_inv_1_74.Y VGND.t921 sg13_lv_nmos ad=0.2516p pd=2.16u as=0.2516p ps=2.16u w=0.74u l=0.13u
X914 VGND.t262 VPWR VGND.t262 VGND.t265 sg13_lv_nmos ad=0.1428p pd=1.52u as=0 ps=0 w=0.42u l=1u
X915 VGND.t16 sg13cmos5l_inv_1_43.A sg13cmos5l_inv_1_42.A VGND.t616 sg13_lv_nmos ad=0.2516p pd=2.16u as=0.2516p ps=2.16u w=0.74u l=0.13u
X916 a_4423_6219# sg13cmos5l_mux4_1_0.A0 VPWR VPWR sg13_lv_pmos ad=0.415p pd=1.83u as=0.22315p ps=1.555u w=1u l=0.13u
X917 VPWR a_4109_3858# sg13cmos5l_dfrbp_1_0.D VPWR sg13_lv_pmos ad=0.2639p pd=1.81u as=0.4312p ps=3.01u w=1.12u l=0.13u
X918 VGND.t499 VPWR VGND.t501 VGND.t500 sg13_lv_nmos ad=79.8f pd=0.8u as=0 ps=0 w=0.42u l=1u
X919 sg13cmos5l_buf_1_10.X a_10120_6168# VGND.t686 VGND.t685 sg13_lv_nmos ad=0.2886p pd=2.26u as=0.14875p ps=1.16u w=0.74u l=0.13u
X920 VPWR VGND.t324 VPWR VPWR sg13_lv_pmos ad=0.34p pd=2.68u as=0 ps=0 w=1u l=1u
X921 VGND.t216 VPWR VGND.t12 VGND.t218 sg13_lv_nmos ad=79.8f pd=0.8u as=0 ps=0 w=0.42u l=1u
X922 VPWR VGND.t501 VPWR VPWR sg13_lv_pmos ad=0.19p pd=1.38u as=0 ps=0 w=1u l=1u
X923 sg13cmos5l_inv_1_19.Y sg13cmos5l_inv_1_19.A VGND.t32 VGND.t889 sg13_lv_nmos ad=0.2516p pd=2.16u as=0.2516p ps=2.16u w=0.74u l=0.13u
X924 VPWR VGND.t386 VPWR VPWR sg13_lv_pmos ad=0.19p pd=1.38u as=0 ps=0 w=1u l=1u
X925 VGND.t420 VPWR VGND.t420 VGND.t19 sg13_lv_nmos ad=0.1428p pd=1.52u as=0 ps=0 w=0.42u l=1u
X926 VPWR enable a_808_9980# VPWR sg13_lv_pmos ad=0.2114p pd=1.54u as=0.2856p ps=2.36u w=0.84u l=0.13u
X927 VPWR VGND.t49 VPWR VPWR sg13_lv_pmos ad=0.34p pd=2.68u as=0 ps=0 w=1u l=1u
X928 VGND.t287 VPWR VGND.t286 VGND.t21 sg13_lv_nmos ad=0.1428p pd=1.52u as=0 ps=0 w=0.42u l=1u
X929 VGND.t201 VPWR VGND.t201 VGND.t202 sg13_lv_nmos ad=79.8f pd=0.8u as=0 ps=0 w=0.42u l=1u
X930 VGND.t386 VPWR VGND.t386 VGND.t19 sg13_lv_nmos ad=0.1428p pd=1.52u as=0 ps=0 w=0.42u l=1u
X931 sg13cmos5l_o21ai_1_3.Y sg13cmos5l_o21ai_1_3.B1 a_12022_8058# VGND.t51 sg13_lv_nmos ad=0.2516p pd=2.16u as=0.1406p ps=1.12u w=0.74u l=0.15u
X932 a_6982_6944# sg13cmos5l_mux4_1_0.X sg13cmos5l_nor2b_1_0.B_N VGND.t670 sg13_lv_nmos ad=0.1406p pd=1.12u as=0.2516p ps=2.16u w=0.74u l=0.13u
X933 a_5374_8434# a_6445_8440# a_6369_8476# VGND.t773 sg13_lv_nmos ad=0.2176p pd=1.96u as=0.1216p ps=1.02u w=0.64u l=0.13u
X934 a_14030_6434# sg13cmos5l_mux2_1_6.A1 a_14202_6192# VPWR sg13_lv_pmos ad=0.2225p pd=1.445u as=0.2975p ps=1.595u w=1u l=0.13u
X935 VGND.t402 VPWR VGND.t410 VGND.t19 sg13_lv_nmos ad=79.8f pd=0.8u as=0 ps=0 w=0.42u l=1u
X936 VPWR VGND.t402 VPWR VPWR sg13_lv_pmos ad=0.19p pd=1.38u as=0 ps=0 w=1u l=1u
X937 sg13cmos5l_inv_1_75.A sg13cmos5l_inv_1_74.Y VGND.t52 VGND.t873 sg13_lv_nmos ad=0.2516p pd=2.16u as=0.2516p ps=2.16u w=0.74u l=0.13u
X938 VGND.t286 VPWR VGND.t286 VGND.t21 sg13_lv_nmos ad=0.1428p pd=1.52u as=0 ps=0 w=0.42u l=1u
X939 VGND.t377 VPWR VGND.t377 VGND.t19 sg13_lv_nmos ad=0.1428p pd=1.52u as=0 ps=0 w=0.42u l=1u
X940 sg13cmos5l_nor4_1_0.D sg13cmos5l_nand2_1_1.Y VGND.t1 VGND.t722 sg13_lv_nmos ad=0.1406p pd=1.12u as=0.2516p ps=2.16u w=0.74u l=0.13u
X941 VPWR VGND.t548 VPWR VPWR sg13_lv_pmos ad=0.34p pd=2.68u as=0 ps=0 w=1u l=1u
X942 a_4414_8434# sg13cmos5l_inv_1_69.Y a_4317_8434# VGND.t750 sg13_lv_nmos ad=0.1628p pd=1.18u as=0.13135p ps=1.095u w=0.74u l=0.13u
X943 VPWR VGND.t561 VPWR VPWR sg13_lv_pmos ad=0.19p pd=1.38u as=0 ps=0 w=1u l=1u
X944 sg13cmos5l_o21ai_1_6.Y sg13cmos5l_o21ai_1_6.B1 a_9622_8426# VGND.t774 sg13_lv_nmos ad=0.2516p pd=2.16u as=0.1406p ps=1.12u w=0.74u l=0.15u
X945 VPWR VGND.t315 VPWR VPWR sg13_lv_pmos ad=0.34p pd=2.68u as=0 ps=0 w=1u l=1u
X946 a_14136_6430# sg13cmos5l_mux2_1_0.S VPWR VPWR sg13_lv_pmos ad=0.2856p pd=2.36u as=0.253p ps=1.53u w=0.84u l=0.13u
X947 VPWR sg13cmos5l_mux4_1_0.S0 a_4199_6558# VPWR sg13_lv_pmos ad=0.22315p pd=1.555u as=0.34p ps=2.68u w=1u l=0.13u
X948 sg13cmos5l_o21ai_1_0.B1 sg13cmos5l_o21ai_1_0.A1 VPWR VPWR sg13_lv_pmos ad=0.2128p pd=1.5u as=0.2198p ps=1.53u w=1.12u l=0.13u
X949 VGND.t137 sg13cmos5l_mux4_1_0.S0 a_11533_8440# VGND.t55 sg13_lv_nmos ad=0.1543p pd=1.18u as=0.2304p ps=2u w=0.64u l=0.13u
X950 a_8626_3582# sg13cmos5l_dfrbp_1_2.RESET_B.t1 VGND.t294 VGND.t21 sg13_lv_nmos ad=37.8f pd=0.6u as=79.8f ps=0.8u w=0.42u l=0.13u
X951 VGND.t412 VPWR VGND.t412 VGND.t19 sg13_lv_nmos ad=0.1428p pd=1.52u as=0 ps=0 w=0.42u l=1u
X952 sg13cmos5l_inv_1_10.Y sg13cmos5l_inv_1_12.Y VGND.t5 VGND.t827 sg13_lv_nmos ad=0.2516p pd=2.16u as=0.2516p ps=2.16u w=0.74u l=0.13u
X953 sg13cmos5l_o21ai_1_5.Y sg13cmos5l_o21ai_1_5.B1 a_5110_5402# VGND.t625 sg13_lv_nmos ad=0.2516p pd=2.16u as=0.1406p ps=1.12u w=0.74u l=0.15u
X954 VGND.t54 sg13cmos5l_mux2_1_0.S a_14524_6538# VGND.t895 sg13_lv_nmos ad=0.18945p pd=1.27u as=0.13135p ps=1.095u w=0.74u l=0.13u
X955 sg13cmos5l_inv_1_100.Y sg13cmos5l_inv_1_99.Y VGND.t81 VGND.t645 sg13_lv_nmos ad=0.2516p pd=2.16u as=0.2516p ps=2.16u w=0.74u l=0.13u
X956 VPWR sg13cmos5l_dfrbp_1_2.RESET_B.t6 a_4492_3894# VPWR sg13_lv_pmos ad=7.22485p pd=47.9u as=79.8f ps=0.8u w=0.42u l=0.13u
X957 a_6676_7216# sg13cmos5l_nor2b_1_2.Y a_6574_7216# VPWR sg13_lv_pmos ad=0.2128p pd=1.5u as=0.2128p ps=1.5u w=1.12u l=0.13u
X958 VPWR VGND.t533 VPWR VPWR sg13_lv_pmos ad=0.34p pd=2.68u as=0 ps=0 w=1u l=1u
X959 sg13cmos5l_inv_1_105.Y sg13cmos5l_inv_1_122.Y VGND.t72 VGND.t831 sg13_lv_nmos ad=0.2516p pd=2.16u as=0.2516p ps=2.16u w=0.74u l=0.13u
X960 a_6948_3148# a_7467_3155# a_8207_3505# VGND.t21 sg13_lv_nmos ad=0.3473p pd=2.71u as=0.12665p ps=1.145u w=0.74u l=0.13u
X961 VPWR VGND.t356 VPWR VPWR sg13_lv_pmos ad=0.34p pd=2.68u as=0 ps=0 w=1u l=1u
X962 VGND.t5 VPWR VGND.t5 VGND.t243 sg13_lv_nmos ad=79.8f pd=0.8u as=0 ps=0 w=0.42u l=1u
X963 VGND.t12 VPWR VGND.t12 VGND.t220 sg13_lv_nmos ad=79.8f pd=0.8u as=0 ps=0 w=0.42u l=1u
X964 VGND.t402 VPWR VGND.t402 VGND.t19 sg13_lv_nmos ad=0.1428p pd=1.52u as=0 ps=0 w=0.42u l=1u
X965 VGND.t258 VPWR VGND.t258 VGND.t259 sg13_lv_nmos ad=79.8f pd=0.8u as=0 ps=0 w=0.42u l=1u
X966 a_7365_3155# sg13cmos5l_dfrbp_1_1.CLK VPWR VPWR sg13_lv_pmos ad=0.4088p pd=2.97u as=4.30725p ps=28.325u w=1.12u l=0.13u
X967 VPWR sg13cmos5l_mux2_1_0.S a_14462_5704# VPWR sg13_lv_pmos ad=0.253p pd=1.53u as=0.3325p ps=1.665u w=1u l=0.13u
X968 VPWR VGND.t573 VPWR VPWR sg13_lv_pmos ad=0.34p pd=2.68u as=0 ps=0 w=1u l=1u
X969 VPWR a_8464_3386# a_8409_3267# VPWR sg13_lv_pmos ad=4.30725p pd=28.325u as=93.45f ps=0.865u w=0.42u l=0.13u
X970 VGND.t386 VPWR VGND.t386 VGND.t19 sg13_lv_nmos ad=0.1428p pd=1.52u as=0 ps=0 w=0.42u l=1u
X971 a_4750_3894# a_4991_4164# a_4109_3858# VGND.t21 sg13_lv_nmos ad=0.1428p pd=1.52u as=0.12665p ps=1.145u w=0.42u l=0.13u
X972 sg13cmos5l_inv_1_30.A sg13cmos5l_inv_1_31.Y VGND.t5 VGND.t33 sg13_lv_nmos ad=0.2516p pd=2.16u as=0.2516p ps=2.16u w=0.74u l=0.13u
X973 a_10669_8701# a_10151_8434# a_10462_8434# VPWR sg13_lv_pmos ad=0.16p pd=1.32u as=0.19p ps=1.38u w=1u l=0.13u
X974 VGND.t627 a_4187_4712# a_4624_5026# VGND.t915 sg13_lv_nmos ad=0.148p pd=1.14u as=0.3367p ps=1.65u w=0.74u l=0.13u
X975 VPWR VGND.t410 VPWR VPWR sg13_lv_pmos ad=0.19p pd=1.38u as=0 ps=0 w=1u l=1u
X976 VGND.t197 VPWR VGND.t196 VGND.t195 sg13_lv_nmos ad=0.1428p pd=1.52u as=0 ps=0 w=0.42u l=1u
X977 VPWR VGND.t377 VPWR VPWR sg13_lv_pmos ad=0.34p pd=2.68u as=0 ps=0 w=1u l=1u
X978 VGND.t147 VPWR VGND.t147 VGND.t55 sg13_lv_nmos ad=79.8f pd=0.8u as=0 ps=0 w=0.42u l=1u
X979 VGND.t52 VPWR VGND.t52 VGND.t173 sg13_lv_nmos ad=79.8f pd=0.8u as=0 ps=0 w=0.42u l=1u
X980 VGND.t21 sg13cmos5l_dfrbp_1_2.D a_4991_4164# VGND.t633 sg13_lv_nmos ad=5.21338p pd=34.275u as=0.2516p ps=2.16u w=0.74u l=0.13u
X981 VPWR VGND.t134 VPWR VPWR sg13_lv_pmos ad=0.19p pd=1.38u as=0 ps=0 w=1u l=1u
X982 a_12124_6558# a_11371_6137# a_10933_6516# VGND.t674 sg13_lv_nmos ad=76.8f pd=0.88u as=0.1472p ps=1.1u w=0.64u l=0.13u
X983 a_2095_8728# sg13cmos5l_inv_1_68.A a_1918_8434# VPWR sg13_lv_pmos ad=0.2975p pd=1.595u as=0.2225p ps=1.445u w=1u l=0.13u
X984 VPWR VGND.t420 VPWR VPWR sg13_lv_pmos ad=0.34p pd=2.68u as=0 ps=0 w=1u l=1u
X985 VGND.t569 VPWR VGND.t568 VGND.t567 sg13_lv_nmos ad=0.1428p pd=1.52u as=0 ps=0 w=0.42u l=1u
X986 VGND.t382 VPWR VGND.t382 VGND.t19 sg13_lv_nmos ad=0.1428p pd=1.52u as=0 ps=0 w=0.42u l=1u
X987 VPWR VGND.t518 VPWR VPWR sg13_lv_pmos ad=0.34p pd=2.68u as=0 ps=0 w=1u l=1u
X988 sg13cmos5l_mux2_1_3.X a_1918_8434# VGND.t3 VGND.t766 sg13_lv_nmos ad=0.4033p pd=2.57u as=0.148p ps=1.14u w=0.74u l=0.13u
X989 sg13cmos5l_a221oi_1_0.A2 sg13cmos5l_nand2_1_1.A VGND.t1 VGND.t777 sg13_lv_nmos ad=0.1406p pd=1.12u as=0.2516p ps=2.16u w=0.74u l=0.13u
X990 VPWR VGND.t298 VPWR VPWR sg13_lv_pmos ad=0.34p pd=2.68u as=0 ps=0 w=1u l=1u
X991 VGND.t54 VPWR VGND.t54 VGND.t213 sg13_lv_nmos ad=79.8f pd=0.8u as=0 ps=0 w=0.42u l=1u
X992 VGND.t412 VPWR VGND.t412 VGND.t19 sg13_lv_nmos ad=0.1428p pd=1.52u as=0 ps=0 w=0.42u l=1u
X993 sg13cmos5l_inv_1_17.Y sg13cmos5l_inv_1_17.A VPWR VPWR sg13_lv_pmos ad=0.3808p pd=2.92u as=0.3808p ps=2.92u w=1.12u l=0.13u
X994 VPWR VGND.t412 VPWR VPWR sg13_lv_pmos ad=0.34p pd=2.68u as=0 ps=0 w=1u l=1u
X995 VGND.t588 VPWR VGND.t590 VGND.t589 sg13_lv_nmos ad=79.8f pd=0.8u as=0 ps=0 w=0.42u l=1u
X996 a_10462_8434# a_10151_8434# a_10388_8434# VGND.t909 sg13_lv_nmos ad=0.1472p pd=1.1u as=76.8f ps=0.88u w=0.64u l=0.13u
X997 a_5797_8701# sg13cmos5l_mux4_1_1.A2 VPWR VPWR sg13_lv_pmos ad=0.20762p pd=1.605u as=0.29275p ps=1.785u w=1u l=0.13u
X998 sg13cmos5l_inv_1_105.Y sg13cmos5l_inv_1_122.Y VPWR VPWR sg13_lv_pmos ad=0.3808p pd=2.92u as=0.3808p ps=2.92u w=1.12u l=0.13u
X999 VGND.t208 sg13cmos5l_inv_1_90.A sg13cmos5l_inv_1_89.A VGND.t684 sg13_lv_nmos ad=0.2516p pd=2.16u as=0.2516p ps=2.16u w=0.74u l=0.13u
X1000 sg13cmos5l_mux2_1_8.X a_10462_5410# VGND.t10 VGND.t692 sg13_lv_nmos ad=0.4033p pd=2.57u as=0.148p ps=1.14u w=0.74u l=0.13u
X1001 VGND.t12 VPWR VGND.t12 VGND.t222 sg13_lv_nmos ad=79.8f pd=0.8u as=0 ps=0 w=0.42u l=1u
X1002 VGND.t258 VPWR VGND.t262 VGND.t261 sg13_lv_nmos ad=79.8f pd=0.8u as=0 ps=0 w=0.42u l=1u
X1003 VPWR VGND.t579 VPWR VPWR sg13_lv_pmos ad=0.34p pd=2.68u as=0 ps=0 w=1u l=1u
X1004 VPWR sg13cmos5l_inv_1_23.Y sg13cmos5l_inv_1_74.A VPWR sg13_lv_pmos ad=0.3808p pd=2.92u as=0.3808p ps=2.92u w=1.12u l=0.13u
X1005 VGND.t377 VPWR VGND.t377 VGND.t19 sg13_lv_nmos ad=0.1428p pd=1.52u as=0 ps=0 w=0.42u l=1u
X1006 VPWR sg13cmos5l_buf_1_0.X sg13cmos5l_nand3b_1_0.Y VPWR sg13_lv_pmos ad=0.2128p pd=1.5u as=0.2128p ps=1.5u w=1.12u l=0.13u
X1007 VGND.t394 VPWR VGND.t394 VGND.t19 sg13_lv_nmos ad=0.1428p pd=1.52u as=0 ps=0 w=0.42u l=1u
X1008 a_10639_5704# sg13cmos5l_inv_1_1.Y a_10462_5410# VPWR sg13_lv_pmos ad=0.2975p pd=1.595u as=0.2225p ps=1.445u w=1u l=0.13u
X1009 VPWR VGND.t386 VPWR VPWR sg13_lv_pmos ad=0.34p pd=2.68u as=0 ps=0 w=1u l=1u
X1010 VPWR VGND.t201 VPWR VPWR sg13_lv_pmos ad=0.19p pd=1.38u as=0 ps=0 w=1u l=1u
X1011 VPWR VGND.t147 VPWR VPWR sg13_lv_pmos ad=0.19p pd=1.38u as=0 ps=0 w=1u l=1u
X1012 VGND.t627 sg13cmos5l_o21ai_1_0.A1 a_5110_5402# VGND.t811 sg13_lv_nmos ad=0.1406p pd=1.12u as=0.2516p ps=2.16u w=0.74u l=0.15u
X1013 a_8207_3505# a_7365_3155# a_8113_3505# VGND.t21 sg13_lv_nmos ad=0.12665p pd=1.145u as=0.1428p ps=1.52u w=0.42u l=0.13u
X1014 sg13cmos5l_inv_1_133.Y sg13cmos5l_mux2_1_7.A1 VGND.t26 VGND.t25 sg13_lv_nmos ad=0.2516p pd=2.16u as=0.2516p ps=2.16u w=0.74u l=0.13u
X1015 VGND.t155 VPWR VGND.t155 VGND.t55 sg13_lv_nmos ad=79.8f pd=0.8u as=0 ps=0 w=0.42u l=1u
X1016 a_6756_3582# sg13cmos5l_nand3b_1_0.C a_6662_3582# VGND.t724 sg13_lv_nmos ad=60.89999f pd=0.71u as=0.1428p ps=1.52u w=0.42u l=0.13u
X1017 VPWR sg13cmos5l_nand3b_1_0.Y a_6197_4656# VPWR sg13_lv_pmos ad=0.2128p pd=1.5u as=0.3808p ps=2.92u w=1.12u l=0.13u
X1018 VPWR VGND.t262 VPWR VPWR sg13_lv_pmos ad=0.34p pd=2.68u as=0 ps=0 w=1u l=1u
X1019 a_14030_6434# sg13cmos5l_mux2_1_6.A0 a_14202_6538# VGND.t628 sg13_lv_nmos ad=0.1628p pd=1.18u as=0.3367p ps=1.65u w=0.74u l=0.13u
X1020 VGND.t201 sg13cmos5l_nand2_1_1.A a_5902_6960# VGND.t775 sg13_lv_nmos ad=0.17255p pd=1.25u as=0.187p ps=1.78u w=0.55u l=0.13u
X1021 VPWR VGND.t523 VPWR VPWR sg13_lv_pmos ad=0.34p pd=2.68u as=0 ps=0 w=1u l=1u
X1022 VPWR VGND.t81 VPWR VPWR sg13_lv_pmos ad=0.19p pd=1.38u as=0 ps=0 w=1u l=1u
X1023 VPWR VGND.t97 VPWR VPWR sg13_lv_pmos ad=0.34p pd=2.68u as=0 ps=0 w=1u l=1u
X1024 VGND.t49 sg13cmos5l_inv_1_58.A sg13cmos5l_inv_1_57.A VGND.t949 sg13_lv_nmos ad=0.2516p pd=2.16u as=0.2516p ps=2.16u w=0.74u l=0.13u
X1025 sg13cmos5l_inv_1_27.Y sg13cmos5l_inv_1_28.Y VGND.t1 VGND.t704 sg13_lv_nmos ad=0.2516p pd=2.16u as=0.2516p ps=2.16u w=0.74u l=0.13u
X1026 a_5014_6558# a_4199_6558# a_4938_6558# VGND.t742 sg13_lv_nmos ad=0.1776p pd=1.195u as=80f ps=0.89u w=0.64u l=0.13u
X1027 a_11269_6922# sg13cmos5l_mux2_1_0.S VGND.t208 VGND.t894 sg13_lv_nmos ad=0.1406p pd=1.12u as=0.14505p ps=1.15u w=0.74u l=0.13u
X1028 VPWR VGND.t58 VPWR VPWR sg13_lv_pmos ad=0.34p pd=2.68u as=0 ps=0 w=1u l=1u
X1029 VPWR sg13cmos5l_inv_1_3.Y sg13cmos5l_mux2_1_0.A1 VPWR sg13_lv_pmos ad=0.3808p pd=2.92u as=0.3808p ps=2.92u w=1.12u l=0.13u
X1030 VGND.t147 VPWR VGND.t147 VGND.t55 sg13_lv_nmos ad=79.8f pd=0.8u as=0 ps=0 w=0.42u l=1u
X1031 VGND.t12 VPWR VGND.t216 VGND.t215 sg13_lv_nmos ad=79.8f pd=0.8u as=0 ps=0 w=0.42u l=1u
X1032 sg13cmos5l_a221oi_1_0.B1 a_11457_8476# VGND.t137 VGND.t55 sg13_lv_nmos ad=0.2516p pd=2.16u as=0.1543p ps=1.18u w=0.74u l=0.13u
X1033 a_10966_8434# a_10151_8434# a_10890_8434# VGND.t910 sg13_lv_nmos ad=0.1776p pd=1.195u as=80f ps=0.89u w=0.64u l=0.13u
X1034 VGND.t574 VPWR VGND.t573 VGND.t572 sg13_lv_nmos ad=0.1428p pd=1.52u as=0 ps=0 w=0.42u l=1u
X1035 VPWR VGND.t1 VPWR VPWR sg13_lv_pmos ad=0.34p pd=2.68u as=0 ps=0 w=1u l=1u
X1036 a_4720_9562# sg13cmos5l_mux2_1_4.A0 a_4606_9562# VGND.t47 sg13_lv_nmos ad=0.3367p pd=1.65u as=0.1628p ps=1.18u w=0.74u l=0.13u
X1037 VGND.t420 VPWR VGND.t420 VGND.t19 sg13_lv_nmos ad=0.1428p pd=1.52u as=0 ps=0 w=0.42u l=1u
X1038 VPWR VGND.t412 VPWR VPWR sg13_lv_pmos ad=0.34p pd=2.68u as=0 ps=0 w=1u l=1u
X1039 VPWR VGND.t563 VPWR VPWR sg13_lv_pmos ad=0.34p pd=2.68u as=0 ps=0 w=1u l=1u
X1040 VPWR sg13cmos5l_nor2b_1_0.B_N a_7726_3936# VPWR sg13_lv_pmos ad=0.2618p pd=1.63u as=0.2856p ps=2.36u w=0.84u l=0.13u
X1041 sg13cmos5l_inv_1_4.Y sg13cmos5l_mux2_1_0.A1 VPWR VPWR sg13_lv_pmos ad=0.3808p pd=2.92u as=0.3808p ps=2.92u w=1.12u l=0.13u
X1042 a_7174_3569# sg13cmos5l_dfrbp_1_2.RESET_B.t2 VGND.t30 VGND.t821 sg13_lv_nmos ad=37.8f pd=0.6u as=0.1701p ps=1.65u w=0.42u l=0.13u
X1043 VGND.t87 VPWR VGND.t87 VGND.t86 sg13_lv_nmos ad=0.1428p pd=1.52u as=0 ps=0 w=0.42u l=1u
X1044 VGND.t208 sg13cmos5l_inv_1_92.A sg13cmos5l_inv_1_91.A VGND.t713 sg13_lv_nmos ad=0.2516p pd=2.16u as=0.2516p ps=2.16u w=0.74u l=0.13u
X1045 VGND.t593 VPWR VGND.t595 VGND.t594 sg13_lv_nmos ad=79.8f pd=0.8u as=0 ps=0 w=0.42u l=1u
X1046 VPWR VGND.t420 VPWR VPWR sg13_lv_pmos ad=0.34p pd=2.68u as=0 ps=0 w=1u l=1u
X1047 sg13cmos5l_dfrbp_1_1.CLK a_7726_3936# VGND.t30 VGND.t944 sg13_lv_nmos ad=0.1406p pd=1.12u as=0.17255p ps=1.25u w=0.74u l=0.13u
X1048 VGND.t262 VPWR VGND.t262 VGND.t264 sg13_lv_nmos ad=79.8f pd=0.8u as=0 ps=0 w=0.42u l=1u
X1049 VPWR VGND.t201 VPWR VPWR sg13_lv_pmos ad=0.34p pd=2.68u as=0 ps=0 w=1u l=1u
X1050 VPWR VGND.t72 VPWR VPWR sg13_lv_pmos ad=0.34p pd=2.68u as=0 ps=0 w=1u l=1u
X1051 VPWR VGND.t582 VPWR VPWR sg13_lv_pmos ad=0.34p pd=2.68u as=0 ps=0 w=1u l=1u
X1052 VGND.t52 sg13cmos5l_inv_1_23.Y sg13cmos5l_inv_1_74.A VGND.t888 sg13_lv_nmos ad=0.2516p pd=2.16u as=0.2516p ps=2.16u w=0.74u l=0.13u
X1053 VGND.t12 VPWR VGND.t12 VGND.t221 sg13_lv_nmos ad=0.1428p pd=1.52u as=0 ps=0 w=0.42u l=1u
X1054 VPWR VGND.t394 VPWR VPWR sg13_lv_pmos ad=0.34p pd=2.68u as=0 ps=0 w=1u l=1u
X1055 VPWR VGND.t147 VPWR VPWR sg13_lv_pmos ad=0.19p pd=1.38u as=0 ps=0 w=1u l=1u
X1056 a_7260_4192# sg13cmos5l_buf_1_0.X a_7158_4192# VPWR sg13_lv_pmos ad=0.2128p pd=1.5u as=0.2128p ps=1.5u w=1.12u l=0.13u
X1057 VGND.t46 sg13cmos5l_inv_1_44.A sg13cmos5l_inv_1_43.A VGND.t939 sg13_lv_nmos ad=0.2516p pd=2.16u as=0.2516p ps=2.16u w=0.74u l=0.13u
X1058 sg13cmos5l_nand2_1_1.Y sg13cmos5l_nand2_1_1.A a_7066_6538# VGND.t778 sg13_lv_nmos ad=0.2516p pd=2.16u as=0.1406p ps=1.12u w=0.74u l=0.13u
X1059 sg13cmos5l_inv_1_56.Y sg13cmos5l_inv_1_55.Y VGND.t55 VGND.t753 sg13_lv_nmos ad=0.2516p pd=2.16u as=0.2516p ps=2.16u w=0.74u l=0.13u
X1060 a_11630_4922# sg13cmos5l_inv_1_123.A a_11802_5026# VGND.t830 sg13_lv_nmos ad=0.1628p pd=1.18u as=0.3367p ps=1.65u w=0.74u l=0.13u
X1061 VGND.t412 VPWR VGND.t412 VGND.t19 sg13_lv_nmos ad=0.1428p pd=1.52u as=0 ps=0 w=0.42u l=1u
X1062 VPWR VGND.t410 VPWR VPWR sg13_lv_pmos ad=0.34p pd=2.68u as=0 ps=0 w=1u l=1u
X1063 VGND.t84 sg13cmos5l_mux2_1_0.S a_12175_9562# VGND.t891 sg13_lv_nmos ad=0.14505p pd=1.15u as=0.1406p ps=1.12u w=0.74u l=0.13u
X1064 a_6434_3894# sg13cmos5l_dfrbp_1_2.RESET_B.t5 VGND.t706 VGND.t705 sg13_lv_nmos ad=60.89999f pd=0.71u as=0.1626p ps=1.415u w=0.42u l=0.13u
X1065 sg13cmos5l_inv_1_125.Y sg13cmos5l_nand2b_1_6.A_N VGND.t641 VGND.t640 sg13_lv_nmos ad=0.2516p pd=2.16u as=0.2516p ps=2.16u w=0.74u l=0.13u
X1066 sg13cmos5l_and2_1_0.X a_7629_5004# VPWR VPWR sg13_lv_pmos ad=0.3808p pd=2.92u as=0.1918p ps=1.5u w=1.12u l=0.13u
X1067 VPWR sg13cmos5l_buf_1_2.X a_5581_6442# VPWR sg13_lv_pmos ad=0.34367p pd=1.775u as=0.34p ps=2.68u w=1u l=0.13u
X1068 VPWR sg13cmos5l_mux4_1_3.A1 a_10669_8701# VPWR sg13_lv_pmos ad=0.29275p pd=1.785u as=0.16p ps=1.32u w=1u l=0.13u
X1069 VPWR VGND.t300 VPWR VPWR sg13_lv_pmos ad=0.19p pd=1.38u as=0 ps=0 w=1u l=1u
X1070 VGND.t270 VPWR VGND.t269 VGND.t268 sg13_lv_nmos ad=0.1428p pd=1.52u as=0 ps=0 w=0.42u l=1u
X1071 VPWR VGND.t52 VPWR VPWR sg13_lv_pmos ad=0.19p pd=1.38u as=0 ps=0 w=1u l=1u
X1072 VGND.t504 VPWR VGND.t503 VGND.t502 sg13_lv_nmos ad=0.1428p pd=1.52u as=0 ps=0 w=0.42u l=1u
X1073 VGND.t258 VPWR VGND.t258 VGND.t278 sg13_lv_nmos ad=79.8f pd=0.8u as=0 ps=0 w=0.42u l=1u
X1074 VGND.t402 VPWR VGND.t402 VGND.t19 sg13_lv_nmos ad=0.1428p pd=1.52u as=0 ps=0 w=0.42u l=1u
X1075 VPWR VGND.t420 VPWR VPWR sg13_lv_pmos ad=0.34p pd=2.68u as=0 ps=0 w=1u l=1u
X1076 VGND.t5 sg13cmos5l_inv_1_18.Y sg13cmos5l_inv_1_16.Y VGND.t917 sg13_lv_nmos ad=0.2516p pd=2.16u as=0.2516p ps=2.16u w=0.74u l=0.13u
X1077 sg13cmos5l_o21ai_1_0.A1 a_3016_6168# VGND.t196 VGND.t769 sg13_lv_nmos ad=0.2886p pd=2.26u as=0.14875p ps=1.16u w=0.74u l=0.13u
X1078 VGND.t164 sg13cmos5l_buf_1_2.X a_6445_8440# VGND.t782 sg13_lv_nmos ad=0.1543p pd=1.18u as=0.2304p ps=2u w=0.64u l=0.13u
X1079 VGND.t386 VPWR VGND.t386 VGND.t19 sg13_lv_nmos ad=79.8f pd=0.8u as=0 ps=0 w=0.42u l=1u
X1080 VGND.t386 sg13cmos5l_buf_1_1.X a_6142_2428# VGND.t19 sg13_lv_nmos ad=0.18575p pd=1.26u as=0.187p ps=1.78u w=0.55u l=0.13u
X1081 VGND.t302 VPWR VGND.t303 VGND.t293 sg13_lv_nmos ad=79.8f pd=0.8u as=0 ps=0 w=0.42u l=1u
X1082 VPWR VGND.t201 VPWR VPWR sg13_lv_pmos ad=0.34p pd=2.68u as=0 ps=0 w=1u l=1u
X1083 VGND.t524 VPWR VGND.t526 VGND.t525 sg13_lv_nmos ad=79.8f pd=0.8u as=0 ps=0 w=0.42u l=1u
X1084 a_4783_9216# sg13cmos5l_mux2_1_4.A1 a_4606_9562# VPWR sg13_lv_pmos ad=0.2975p pd=1.595u as=0.2225p ps=1.445u w=1u l=0.13u
X1085 sg13cmos5l_inv_1_70.Y sg13cmos5l_inv_1_70.A VGND.t46 VGND.t719 sg13_lv_nmos ad=0.2516p pd=2.16u as=0.2516p ps=2.16u w=0.74u l=0.13u
X1086 VPWR VGND.t420 VPWR VPWR sg13_lv_pmos ad=0.34p pd=2.68u as=0 ps=0 w=1u l=1u
X1087 a_3862_5402# sg13cmos5l_inv_1_14.A VGND.t627 VGND.t832 sg13_lv_nmos ad=0.1406p pd=1.12u as=0.1406p ps=1.12u w=0.74u l=0.15u
X1088 VPWR VGND.t553 VPWR VPWR sg13_lv_pmos ad=0.34p pd=2.68u as=0 ps=0 w=1u l=1u
X1089 VGND.t5 sg13cmos5l_inv_1_14.A sg13cmos5l_inv_1_17.A VGND.t833 sg13_lv_nmos ad=0.2516p pd=2.16u as=0.2516p ps=2.16u w=0.74u l=0.13u
X1090 a_10576_5410# sg13cmos5l_inv_1_129.Y a_10462_5410# VGND.t689 sg13_lv_nmos ad=0.3367p pd=1.65u as=0.1628p ps=1.18u w=0.74u l=0.13u
X1091 VGND.t12 VPWR VGND.t12 VGND.t223 sg13_lv_nmos ad=0.1428p pd=1.52u as=0 ps=0 w=0.42u l=1u
X1092 VPWR a_7412_6886# a_7370_7216# VPWR sg13_lv_pmos ad=0.2618p pd=1.63u as=0.1176p ps=1.33u w=1.12u l=0.13u
X1093 a_5781_3191# a_4839_3231# a_5642_3424# VGND.t59 sg13_lv_nmos ad=79.8f pd=0.8u as=0.2373p ps=1.97u w=0.42u l=0.13u
X1094 VPWR sg13cmos5l_buf_1_0.X a_4187_4712# VPWR sg13_lv_pmos ad=0.253p pd=1.53u as=0.2856p ps=2.36u w=0.84u l=0.13u
X1095 VPWR VGND.t97 VPWR VPWR sg13_lv_pmos ad=0.19p pd=1.38u as=0 ps=0 w=1u l=1u
X1096 sg13cmos5l_mux4_1_1.A0 a_4606_9562# VGND.t46 VGND.t669 sg13_lv_nmos ad=0.4033p pd=2.57u as=0.148p ps=1.14u w=0.74u l=0.13u
X1097 a_11420_7660# sg13cmos5l_inv_1_83.A sg13cmos5l_o21ai_1_4.Y VPWR sg13_lv_pmos ad=0.2128p pd=1.5u as=0.2128p ps=1.5u w=1.12u l=0.15u
X1098 VPWR VGND.t104 VPWR VPWR sg13_lv_pmos ad=0.19p pd=1.38u as=0 ps=0 w=1u l=1u
X1099 VGND.t144 VPWR VGND.t145 VGND.t55 sg13_lv_nmos ad=79.8f pd=0.8u as=0 ps=0 w=0.42u l=1u
X1100 VGND.t139 VPWR VGND.t139 VGND.t51 sg13_lv_nmos ad=0.1428p pd=1.52u as=0 ps=0 w=0.42u l=1u
X1101 VGND.t245 VPWR VGND.t245 VGND.t244 sg13_lv_nmos ad=0.1428p pd=1.52u as=0 ps=0 w=0.42u l=1u
X1102 VPWR VGND.t52 VPWR VPWR sg13_lv_pmos ad=0.19p pd=1.38u as=0 ps=0 w=1u l=1u
X1103 a_5581_8701# a_5063_8434# a_5374_8434# VPWR sg13_lv_pmos ad=0.16p pd=1.32u as=0.19p ps=1.38u w=1u l=0.13u
X1104 sg13cmos5l_buf_1_1.X a_808_2420# VGND.t20 VGND.t19 sg13_lv_nmos ad=0.2886p pd=2.26u as=0.14875p ps=1.16u w=0.74u l=0.13u
X1105 a_4509_9562# sg13cmos5l_o21ai_1_0.A1 VGND.t16 VGND.t806 sg13_lv_nmos ad=0.13135p pd=1.095u as=0.18945p ps=1.27u w=0.74u l=0.13u
X1106 VPWR VGND.t412 VPWR VPWR sg13_lv_pmos ad=0.34p pd=2.68u as=0 ps=0 w=1u l=1u
X1107 VGND.t26 VPWR VGND.t26 VGND.t256 sg13_lv_nmos ad=0.1428p pd=1.52u as=0 ps=0 w=0.42u l=1u
X1108 VPWR VGND.t5 VPWR VPWR sg13_lv_pmos ad=0.34p pd=2.68u as=0 ps=0 w=1u l=1u
X1109 VPWR sg13cmos5l_mux2_1_0.S sg13cmos5l_o21ai_1_2.B1 VPWR sg13_lv_pmos ad=0.2198p pd=1.53u as=0.2128p ps=1.5u w=1.12u l=0.13u
X1110 a_4839_3231# a_4991_3115# VGND.t21 VGND.t690 sg13_lv_nmos ad=0.2516p pd=2.16u as=5.21338p ps=34.275u w=0.74u l=0.13u
X1111 VGND.t377 VPWR VGND.t382 VGND.t19 sg13_lv_nmos ad=79.8f pd=0.8u as=0 ps=0 w=0.42u l=1u
X1112 VGND.t54 a_14030_6434# sg13cmos5l_mux4_1_2.A3 VGND.t876 sg13_lv_nmos ad=0.148p pd=1.14u as=0.4033p ps=2.57u w=0.74u l=0.13u
X1113 VGND.t208 VPWR VGND.t235 VGND.t234 sg13_lv_nmos ad=79.8f pd=0.8u as=0 ps=0 w=0.42u l=1u
X1114 sg13cmos5l_inv_1_130.Y sg13cmos5l_inv_1_130.A VGND.t347 VGND.t293 sg13_lv_nmos ad=0.2516p pd=2.16u as=0.2516p ps=2.16u w=0.74u l=0.13u
X1115 VPWR VGND.t303 VPWR VPWR sg13_lv_pmos ad=0.19p pd=1.38u as=0 ps=0 w=1u l=1u
X1116 VPWR VGND.t258 VPWR VPWR sg13_lv_pmos ad=0.34p pd=2.68u as=0 ps=0 w=1u l=1u
X1117 sg13cmos5l_inv_1_118.A sg13cmos5l_inv_1_30.Y VGND.t5 VGND.t800 sg13_lv_nmos ad=0.2516p pd=2.16u as=0.2516p ps=2.16u w=0.74u l=0.13u
X1118 VGND.t54 sg13cmos5l_inv_1_94.A sg13cmos5l_inv_1_93.A VGND.t693 sg13_lv_nmos ad=0.2516p pd=2.16u as=0.2516p ps=2.16u w=0.74u l=0.13u
X1119 VPWR invsel[2] a_808_6956# VPWR sg13_lv_pmos ad=0.2114p pd=1.54u as=0.2856p ps=2.36u w=0.84u l=0.13u
X1120 VGND.t201 VPWR VGND.t201 VGND.t227 sg13_lv_nmos ad=0.1428p pd=1.52u as=0 ps=0 w=0.42u l=1u
X1121 a_14136_6430# sg13cmos5l_mux2_1_0.S VGND.t54 VGND.t896 sg13_lv_nmos ad=0.187p pd=1.78u as=0.18945p ps=1.27u w=0.55u l=0.13u
X1122 VPWR sg13cmos5l_o21ai_1_5.Y a_5237_6173# VPWR sg13_lv_pmos ad=0.34p pd=2.68u as=0.135p ps=1.27u w=1u l=0.13u
X1123 sg13cmos5l_inv_1_99.A sg13cmos5l_inv_1_106.Y VGND.t81 VGND.t953 sg13_lv_nmos ad=0.2516p pd=2.16u as=0.2516p ps=2.16u w=0.74u l=0.13u
X1124 VPWR VGND.t402 VPWR VPWR sg13_lv_pmos ad=0.34p pd=2.68u as=0 ps=0 w=1u l=1u
X1125 VGND.t201 sg13cmos5l_buf_1_2.X a_5581_6442# VGND.t786 sg13_lv_nmos ad=0.1543p pd=1.18u as=0.2304p ps=2u w=0.64u l=0.13u
X1126 VGND.t147 VPWR VGND.t147 VGND.t55 sg13_lv_nmos ad=0.1428p pd=1.52u as=0 ps=0 w=0.42u l=1u
X1127 VGND.t137 VPWR VGND.t177 VGND.t51 sg13_lv_nmos ad=0.1428p pd=1.52u as=0 ps=0 w=0.42u l=1u
X1128 VPWR VGND.t52 VPWR VPWR sg13_lv_pmos ad=0.34p pd=2.68u as=0 ps=0 w=1u l=1u
X1129 a_10571_6132# a_10715_6528# a_10904_6168# VPWR sg13_lv_pmos ad=0.2225p pd=1.445u as=0.34p ps=2.68u w=1u l=0.13u
X1130 VGND.t386 VPWR VGND.t386 VGND.t19 sg13_lv_nmos ad=79.8f pd=0.8u as=0 ps=0 w=0.42u l=1u
X1131 VPWR VGND.t386 VPWR VPWR sg13_lv_pmos ad=0.19p pd=1.38u as=0 ps=0 w=1u l=1u
X1132 VPWR a_14030_5596# sg13cmos5l_mux4_1_2.A1 VPWR sg13_lv_pmos ad=0.2198p pd=1.52u as=0.6048p ps=3.32u w=1.12u l=0.13u
X1133 a_5374_8434# a_5063_8434# a_5300_8434# VGND.t767 sg13_lv_nmos ad=0.1472p pd=1.1u as=76.8f ps=0.88u w=0.64u l=0.13u
X1134 VGND.t317 VPWR VGND.t318 VGND.t293 sg13_lv_nmos ad=79.8f pd=0.8u as=0 ps=0 w=0.42u l=1u
X1135 a_4510_5026# sg13cmos5l_dfrbp_1_0.D a_4413_5026# VGND.t924 sg13_lv_nmos ad=0.1628p pd=1.18u as=0.13135p ps=1.095u w=0.74u l=0.13u
X1136 sg13cmos5l_inv_1_7.Y sg13cmos5l_inv_1_9.Y VGND.t26 VGND.t677 sg13_lv_nmos ad=0.2516p pd=2.16u as=0.2516p ps=2.16u w=0.74u l=0.13u
X1137 sg13cmos5l_mux2_1_7.A1 sg13cmos5l_inv_1_82.Y VPWR VPWR sg13_lv_pmos ad=0.3808p pd=2.92u as=0.3808p ps=2.92u w=1.12u l=0.13u
X1138 sg13cmos5l_inv_1_23.Y sg13cmos5l_inv_1_26.Y VGND.t1 VGND.t60 sg13_lv_nmos ad=0.2516p pd=2.16u as=0.2516p ps=2.16u w=0.74u l=0.13u
X1139 sg13cmos5l_inv_1_70.Y sg13cmos5l_inv_1_70.A VPWR VPWR sg13_lv_pmos ad=0.3808p pd=2.92u as=0.3808p ps=2.92u w=1.12u l=0.13u
X1140 a_14136_5600# sg13cmos5l_mux2_1_0.S VPWR VPWR sg13_lv_pmos ad=0.2856p pd=2.36u as=0.253p ps=1.53u w=0.84u l=0.13u
X1141 VPWR VGND.t164 VPWR VPWR sg13_lv_pmos ad=0.19p pd=1.38u as=0 ps=0 w=1u l=1u
X1142 sg13cmos5l_nand2_1_0.Y sg13cmos5l_buf_1_1.X a_5338_5026# VGND.t945 sg13_lv_nmos ad=0.2516p pd=2.16u as=0.1406p ps=1.12u w=0.74u l=0.13u
X1143 VPWR VGND.t97 VPWR VPWR sg13_lv_pmos ad=0.19p pd=1.38u as=0 ps=0 w=1u l=1u
X1144 VPWR a_11067_6960# sg13cmos5l_nand2b_1_2.Y VPWR sg13_lv_pmos ad=0.3808p pd=2.92u as=0.2128p ps=1.5u w=1.12u l=0.13u
X1145 VGND.t52 sg13cmos5l_mux4_1_3.A1 a_10580_8434# VGND.t814 sg13_lv_nmos ad=0.1824p pd=1.21u as=0.2304p ps=1.36u w=0.64u l=0.13u
X1146 VPWR VGND.t52 VPWR VPWR sg13_lv_pmos ad=0.34p pd=2.68u as=0 ps=0 w=1u l=1u
X1147 a_4316_7236# sg13cmos5l_o21ai_1_1.A2 sg13cmos5l_mux4_1_0.A0 VPWR sg13_lv_pmos ad=0.2128p pd=1.5u as=0.2128p ps=1.5u w=1.12u l=0.15u
X1148 VGND.t208 sg13cmos5l_inv_1_91.A sg13cmos5l_inv_1_90.A VGND.t701 sg13_lv_nmos ad=0.2516p pd=2.16u as=0.2516p ps=2.16u w=0.74u l=0.13u
X1149 VGND.t49 sg13cmos5l_inv_1_54.Y sg13cmos5l_mux2_1_4.A0 VGND.t681 sg13_lv_nmos ad=0.2516p pd=2.16u as=0.2516p ps=2.16u w=0.74u l=0.13u
X1150 sg13cmos5l_nand2b_1_4.A_N sg13cmos5l_inv_1_100.Y VPWR VPWR sg13_lv_pmos ad=0.3808p pd=2.92u as=0.3808p ps=2.92u w=1.12u l=0.13u
X1151 VPWR sg13cmos5l_inv_1_116.A sg13cmos5l_inv_1_24.A VPWR sg13_lv_pmos ad=0.3808p pd=2.92u as=0.3808p ps=2.92u w=1.12u l=0.13u
X1152 VPWR VGND.t394 VPWR VPWR sg13_lv_pmos ad=0.34p pd=2.68u as=0 ps=0 w=1u l=1u
X1153 VGND.t248 a_11630_4922# sg13cmos5l_mux2_1_0.X VGND.t926 sg13_lv_nmos ad=0.148p pd=1.14u as=0.4033p ps=2.57u w=0.74u l=0.13u
X1154 VGND.t5 VPWR VGND.t5 VGND.t242 sg13_lv_nmos ad=0.1428p pd=1.52u as=0 ps=0 w=0.42u l=1u
X1155 VGND.t593 VPWR VGND.t592 VGND.t591 sg13_lv_nmos ad=0.1428p pd=1.52u as=0 ps=0 w=0.42u l=1u
X1156 a_5883_3191# a_4991_3115# a_5781_3191# VPWR sg13_lv_pmos ad=63f pd=0.72u as=79.8f ps=0.8u w=0.42u l=0.13u
X1157 VGND.t382 VPWR VGND.t382 VGND.t19 sg13_lv_nmos ad=79.8f pd=0.8u as=0 ps=0 w=0.42u l=1u
X1158 VPWR VGND.t382 VPWR VPWR sg13_lv_pmos ad=0.19p pd=1.38u as=0 ps=0 w=1u l=1u
X1159 VGND.t210 VPWR VGND.t54 VGND.t237 sg13_lv_nmos ad=79.8f pd=0.8u as=0 ps=0 w=0.42u l=1u
X1160 VGND.t248 sg13cmos5l_buf_1_10.X a_11848_5444# VGND.t934 sg13_lv_nmos ad=0.14875p pd=1.16u as=0.187p ps=1.78u w=0.55u l=0.13u
X1161 a_11314_8058# sg13cmos5l_buf_1_10.X VGND.t52 VGND.t51 sg13_lv_nmos ad=0.2516p pd=2.16u as=0.1406p ps=1.12u w=0.74u l=0.15u
X1162 VPWR VGND.t336 VPWR VPWR sg13_lv_pmos ad=0.19p pd=1.38u as=0 ps=0 w=1u l=1u
X1163 VGND.t308 VPWR VGND.t309 VGND.t293 sg13_lv_nmos ad=79.8f pd=0.8u as=0 ps=0 w=0.42u l=1u
X1164 VGND.t36 invsel[1] a_808_5444# VGND.t928 sg13_lv_nmos ad=0.14875p pd=1.16u as=0.187p ps=1.78u w=0.55u l=0.13u
X1165 VGND.t147 VPWR VGND.t147 VGND.t55 sg13_lv_nmos ad=0.1428p pd=1.52u as=0 ps=0 w=0.42u l=1u
X1166 a_5878_8434# a_5063_8434# a_5802_8434# VGND.t768 sg13_lv_nmos ad=0.1776p pd=1.195u as=80f ps=0.89u w=0.64u l=0.13u
X1167 VGND.t613 VPWR VGND.t615 VGND.t614 sg13_lv_nmos ad=79.8f pd=0.8u as=0 ps=0 w=0.42u l=1u
X1168 VPWR VGND.t92 VPWR VPWR sg13_lv_pmos ad=0.19p pd=1.38u as=0 ps=0 w=1u l=1u
X1169 VPWR sg13cmos5l_inv_1_96.A sg13cmos5l_inv_1_116.A VPWR sg13_lv_pmos ad=0.3808p pd=2.92u as=0.3808p ps=2.92u w=1.12u l=0.13u
X1170 sg13cmos5l_o21ai_1_0.Y sg13cmos5l_o21ai_1_0.A2 a_2136_6148# VPWR sg13_lv_pmos ad=0.2128p pd=1.5u as=0.2128p ps=1.5u w=1.12u l=0.15u
X1171 sg13cmos5l_inv_1_25.Y sg13cmos5l_inv_1_27.Y VGND.t1 VGND.t907 sg13_lv_nmos ad=0.2516p pd=2.16u as=0.2516p ps=2.16u w=0.74u l=0.13u
X1172 VGND.t412 VPWR VGND.t412 VGND.t19 sg13_lv_nmos ad=79.8f pd=0.8u as=0 ps=0 w=0.42u l=1u
X1173 VGND.t258 VPWR VGND.t258 VGND.t257 sg13_lv_nmos ad=0.1428p pd=1.52u as=0 ps=0 w=0.42u l=1u
X1174 VGND.t54 VPWR VGND.t54 VGND.t212 sg13_lv_nmos ad=0.1428p pd=1.52u as=0 ps=0 w=0.42u l=1u
X1175 VPWR VGND.t54 VPWR VPWR sg13_lv_pmos ad=0.34p pd=2.68u as=0 ps=0 w=1u l=1u
X1176 sg13cmos5l_a221oi_1_0.C1 sg13cmos5l_nor3_1_0.C a_6615_7680# VPWR sg13_lv_pmos ad=0.3808p pd=2.92u as=0.2128p ps=1.5u w=1.12u l=0.13u
X1177 VPWR VGND.t104 VPWR VPWR sg13_lv_pmos ad=0.19p pd=1.38u as=0 ps=0 w=1u l=1u
X1178 VGND.t132 VPWR VGND.t132 VGND.t158 sg13_lv_nmos ad=0.1428p pd=1.52u as=0 ps=0 w=0.42u l=1u
X1179 VGND.t64 sg13cmos5l_inv_1_39.A sg13cmos5l_inv_1_40.A VGND.t744 sg13_lv_nmos ad=0.2516p pd=2.16u as=0.2516p ps=2.16u w=0.74u l=0.13u
X1180 VGND.t104 VPWR VGND.t104 VGND.t106 sg13_lv_nmos ad=79.8f pd=0.8u as=0 ps=0 w=0.42u l=1u
X1181 a_14136_5600# sg13cmos5l_mux2_1_0.S VGND.t26 VGND.t898 sg13_lv_nmos ad=0.187p pd=1.78u as=0.18945p ps=1.27u w=0.55u l=0.13u
X1182 VPWR VGND.t309 VPWR VPWR sg13_lv_pmos ad=0.19p pd=1.38u as=0 ps=0 w=1u l=1u
X1183 VPWR sg13cmos5l_inv_1_54.Y sg13cmos5l_mux2_1_4.A0 VPWR sg13_lv_pmos ad=0.3808p pd=2.92u as=0.3808p ps=2.92u w=1.12u l=0.13u
X1184 VGND.t386 VPWR VGND.t386 VGND.t19 sg13_lv_nmos ad=79.8f pd=0.8u as=0 ps=0 w=0.42u l=1u
X1185 VGND.t147 VPWR VGND.t145 VGND.t55 sg13_lv_nmos ad=0.1428p pd=1.52u as=0 ps=0 w=0.42u l=1u
X1186 VGND.t524 VPWR VGND.t523 VGND.t522 sg13_lv_nmos ad=0.1428p pd=1.52u as=0 ps=0 w=0.42u l=1u
X1187 VPWR VGND.t551 VPWR VPWR sg13_lv_pmos ad=0.19p pd=1.38u as=0 ps=0 w=1u l=1u
X1188 a_10571_6132# a_10715_6528# a_10933_6516# VGND.t861 sg13_lv_nmos ad=0.1216p pd=1.02u as=0.2176p ps=1.96u w=0.64u l=0.13u
X1189 VGND.t258 VPWR VGND.t258 VGND.t260 sg13_lv_nmos ad=0.1428p pd=1.52u as=0 ps=0 w=0.42u l=1u
X1190 VPWR VGND.t49 VPWR VPWR sg13_lv_pmos ad=0.34p pd=2.68u as=0 ps=0 w=1u l=1u
X1191 VGND.t382 VPWR VGND.t386 VGND.t19 sg13_lv_nmos ad=79.8f pd=0.8u as=0 ps=0 w=0.42u l=1u
X1192 VPWR VGND.t235 VPWR VPWR sg13_lv_pmos ad=0.19p pd=1.38u as=0 ps=0 w=1u l=1u
X1193 VPWR VGND.t382 VPWR VPWR sg13_lv_pmos ad=0.19p pd=1.38u as=0 ps=0 w=1u l=1u
X1194 sg13cmos5l_inv_1_122.Y sg13cmos5l_inv_1_61.Y VGND.t72 VGND.t813 sg13_lv_nmos ad=0.2516p pd=2.16u as=0.2516p ps=2.16u w=0.74u l=0.13u
X1195 VGND.t311 VPWR VGND.t312 VGND.t293 sg13_lv_nmos ad=79.8f pd=0.8u as=0 ps=0 w=0.42u l=1u
X1196 VGND.t402 VPWR VGND.t402 VGND.t19 sg13_lv_nmos ad=79.8f pd=0.8u as=0 ps=0 w=0.42u l=1u
X1197 VPWR VGND.t201 VPWR VPWR sg13_lv_pmos ad=0.34p pd=2.68u as=0 ps=0 w=1u l=1u
X1198 VPWR sg13cmos5l_mux2_1_3.X a_5581_8701# VPWR sg13_lv_pmos ad=0.29275p pd=1.785u as=0.16p ps=1.32u w=1u l=0.13u
X1199 sg13cmos5l_inv_1_56.Y sg13cmos5l_inv_1_55.Y VPWR VPWR sg13_lv_pmos ad=0.3808p pd=2.92u as=0.3808p ps=2.92u w=1.12u l=0.13u
X1200 VPWR VGND.t177 VPWR VPWR sg13_lv_pmos ad=0.34p pd=2.68u as=0 ps=0 w=1u l=1u
X1201 VGND.t155 VPWR VGND.t155 VGND.t55 sg13_lv_nmos ad=0.1428p pd=1.52u as=0 ps=0 w=0.42u l=1u
X1202 VGND.t544 VPWR VGND.t546 VGND.t545 sg13_lv_nmos ad=79.8f pd=0.8u as=0 ps=0 w=0.42u l=1u
X1203 VPWR VGND.t97 VPWR VPWR sg13_lv_pmos ad=0.19p pd=1.38u as=0 ps=0 w=1u l=1u
X1204 VGND.t377 VPWR VGND.t377 VGND.t19 sg13_lv_nmos ad=79.8f pd=0.8u as=0 ps=0 w=0.42u l=1u
X1205 VPWR VGND.t427 VPWR VPWR sg13_lv_pmos ad=0.34p pd=2.68u as=0 ps=0 w=1u l=1u
X1206 sg13cmos5l_dfrbp_1_2.RESET_B.t0 a_808_9980# VPWR VPWR sg13_lv_pmos ad=0.42p pd=2.99u as=0.2114p ps=1.54u w=1.12u l=0.13u
X1207 VPWR VGND.t329 VPWR VPWR sg13_lv_pmos ad=0.19p pd=1.38u as=0 ps=0 w=1u l=1u
X1208 VPWR VGND.t245 VPWR VPWR sg13_lv_pmos ad=0.34p pd=2.68u as=0 ps=0 w=1u l=1u
X1209 VGND.t164 VPWR VGND.t164 VGND.t167 sg13_lv_nmos ad=0.1428p pd=1.52u as=0 ps=0 w=0.42u l=1u
X1210 VPWR VGND.t87 VPWR VPWR sg13_lv_pmos ad=0.34p pd=2.68u as=0 ps=0 w=1u l=1u
X1211 VGND.t412 VPWR VGND.t412 VGND.t19 sg13_lv_nmos ad=79.8f pd=0.8u as=0 ps=0 w=0.42u l=1u
X1212 VPWR a_3116_6882# sg13cmos5l_buf_1_4.A VPWR sg13_lv_pmos ad=0.2114p pd=1.54u as=0.42p ps=2.99u w=1.12u l=0.13u
X1213 VPWR VGND.t610 VPWR VPWR sg13_lv_pmos ad=0.19p pd=1.38u as=0 ps=0 w=1u l=1u
X1214 sg13cmos5l_nand2_1_0.Y sg13cmos5l_mux2_1_1.X VPWR VPWR sg13_lv_pmos ad=0.2128p pd=1.5u as=0.3808p ps=2.92u w=1.12u l=0.13u
X1215 osc a_18856_6168# VPWR VPWR sg13_lv_pmos ad=0.42p pd=2.99u as=0.2114p ps=1.54u w=1.12u l=0.13u
X1216 sg13cmos5l_inv_1_127.Y sg13cmos5l_inv_1_126.Y VPWR VPWR sg13_lv_pmos ad=0.3808p pd=2.92u as=0.3808p ps=2.92u w=1.12u l=0.13u
X1217 VPWR VGND.t194 VPWR VPWR sg13_lv_pmos ad=0.34p pd=2.68u as=0 ps=0 w=1u l=1u
X1218 sg13cmos5l_mux2_1_2.X a_4414_8434# VPWR VPWR sg13_lv_pmos ad=0.6048p pd=3.32u as=0.2198p ps=1.52u w=1.12u l=0.13u
X1219 sg13cmos5l_inv_1_69.Y sg13cmos5l_inv_1_69.A VPWR VPWR sg13_lv_pmos ad=0.3808p pd=2.92u as=0.3808p ps=2.92u w=1.12u l=0.13u
X1220 VGND.t26 VPWR VGND.t26 VGND.t275 sg13_lv_nmos ad=0.1428p pd=1.52u as=0 ps=0 w=0.42u l=1u
X1221 sg13cmos5l_nand2_1_1.Y sg13cmos5l_nand2_1_1.B VPWR VPWR sg13_lv_pmos ad=0.2128p pd=1.5u as=0.3808p ps=2.92u w=1.12u l=0.13u
X1222 VGND.t89 VPWR VGND.t89 VGND.t90 sg13_lv_nmos ad=79.8f pd=0.8u as=0 ps=0 w=0.42u l=1u
X1223 VPWR VGND.t386 VPWR VPWR sg13_lv_pmos ad=0.19p pd=1.38u as=0 ps=0 w=1u l=1u
X1224 sg13cmos5l_inv_1_106.Y sg13cmos5l_inv_1_105.Y VGND.t81 VGND.t770 sg13_lv_nmos ad=0.2516p pd=2.16u as=0.2516p ps=2.16u w=0.74u l=0.13u
X1225 VPWR VGND.t312 VPWR VPWR sg13_lv_pmos ad=0.19p pd=1.38u as=0 ps=0 w=1u l=1u
X1226 VPWR VGND.t258 VPWR VPWR sg13_lv_pmos ad=0.34p pd=2.68u as=0 ps=0 w=1u l=1u
X1227 VGND.t299 VPWR VGND.t298 VGND.t293 sg13_lv_nmos ad=0.1428p pd=1.52u as=0 ps=0 w=0.42u l=1u
X1228 VPWR invsel[0] a_808_3932# VPWR sg13_lv_pmos ad=0.2114p pd=1.54u as=0.2856p ps=2.36u w=0.84u l=0.13u
X1229 VGND.t394 VPWR VGND.t394 VGND.t19 sg13_lv_nmos ad=79.8f pd=0.8u as=0 ps=0 w=0.42u l=1u
X1230 sg13cmos5l_o21ai_1_0.B1 a_1563_6224# a_1765_6538# VGND.t840 sg13_lv_nmos ad=0.333p pd=2.38u as=0.1406p ps=1.12u w=0.74u l=0.13u
X1231 VGND.t147 VPWR VGND.t147 VGND.t55 sg13_lv_nmos ad=0.1428p pd=1.52u as=0 ps=0 w=0.42u l=1u
X1232 VGND.t5 sg13cmos5l_inv_1_17.Y sg13cmos5l_inv_1_13.Y VGND.t726 sg13_lv_nmos ad=0.2516p pd=2.16u as=0.2516p ps=2.16u w=0.74u l=0.13u
X1233 VPWR VGND.t89 VPWR VPWR sg13_lv_pmos ad=0.19p pd=1.38u as=0 ps=0 w=1u l=1u
X1234 VPWR VGND.t39 VPWR VPWR sg13_lv_pmos ad=0.19p pd=1.38u as=0 ps=0 w=1u l=1u
X1235 VPWR VGND.t54 VPWR VPWR sg13_lv_pmos ad=0.19p pd=1.38u as=0 ps=0 w=1u l=1u
X1236 VPWR VGND.t386 VPWR VPWR sg13_lv_pmos ad=0.19p pd=1.38u as=0 ps=0 w=1u l=1u
X1237 VPWR sg13cmos5l_o21ai_1_6.B1 sg13cmos5l_o21ai_1_6.Y VPWR sg13_lv_pmos ad=0.3808p pd=2.92u as=0.2128p ps=1.5u w=1.12u l=0.15u
X1238 VGND.t161 a_4091_8472# a_4528_8434# VGND.t779 sg13_lv_nmos ad=0.148p pd=1.14u as=0.3367p ps=1.65u w=0.74u l=0.13u
X1239 a_13999_9562# a_13917_9462# sg13cmos5l_o21ai_1_2.B1 VGND.t764 sg13_lv_nmos ad=0.1406p pd=1.12u as=0.333p ps=2.38u w=0.74u l=0.13u
X1240 sg13cmos5l_inv_1_122.Y sg13cmos5l_inv_1_61.Y VPWR VPWR sg13_lv_pmos ad=0.3808p pd=2.92u as=0.3808p ps=2.92u w=1.12u l=0.13u
X1241 VPWR VGND.t386 VPWR VPWR sg13_lv_pmos ad=0.19p pd=1.38u as=0 ps=0 w=1u l=1u
X1242 VPWR VGND.t321 VPWR VPWR sg13_lv_pmos ad=0.19p pd=1.38u as=0 ps=0 w=1u l=1u
X1243 VGND.t314 VPWR VGND.t315 VGND.t293 sg13_lv_nmos ad=79.8f pd=0.8u as=0 ps=0 w=0.42u l=1u
X1244 a_14462_6192# sg13cmos5l_mux2_1_6.A0 a_14030_6434# VPWR sg13_lv_pmos ad=0.3325p pd=1.665u as=0.2225p ps=1.445u w=1u l=0.13u
X1245 a_11827_6219# sg13cmos5l_mux4_1_2.A1 VPWR VPWR sg13_lv_pmos ad=0.16p pd=1.32u as=0.29275p ps=1.785u w=1u l=0.13u
X1246 VGND.t410 VPWR VGND.t412 VGND.t19 sg13_lv_nmos ad=79.8f pd=0.8u as=0 ps=0 w=0.42u l=1u
X1247 VPWR sg13cmos5l_o21ai_1_5.B1 sg13cmos5l_o21ai_1_5.Y VPWR sg13_lv_pmos ad=0.3808p pd=2.92u as=0.2128p ps=1.5u w=1.12u l=0.15u
X1248 sg13cmos5l_inv_1_61.Y sg13cmos5l_o21ai_1_6.A2 VGND.t72 VGND.t819 sg13_lv_nmos ad=0.2516p pd=2.16u as=0.2516p ps=2.16u w=0.74u l=0.13u
X1249 VGND.t427 VPWR VGND.t427 VGND.t19 sg13_lv_nmos ad=0.1428p pd=1.52u as=0 ps=0 w=0.42u l=1u
X1250 VGND.t529 VPWR VGND.t528 VGND.t527 sg13_lv_nmos ad=0.1428p pd=1.52u as=0 ps=0 w=0.42u l=1u
X1251 VGND.t208 sg13cmos5l_inv_1_89.A a_11067_6960# VGND.t974 sg13_lv_nmos ad=0.14505p pd=1.15u as=0.187p ps=1.78u w=0.55u l=0.13u
X1252 a_7948_4192# a_7726_3936# VPWR VPWR sg13_lv_pmos ad=0.1176p pd=1.33u as=0.2618p ps=1.63u w=1.12u l=0.13u
X1253 VGND.t394 VPWR VGND.t394 VGND.t19 sg13_lv_nmos ad=0.1428p pd=1.52u as=0 ps=0 w=0.42u l=1u
X1254 sg13cmos5l_inv_1_111.A sg13cmos5l_o21ai_1_3.A2 VGND.t56 VGND.t55 sg13_lv_nmos ad=0.2516p pd=2.16u as=0.2516p ps=2.16u w=0.74u l=0.13u
X1255 VGND.t32 sg13cmos5l_inv_1_22.Y sg13cmos5l_a21oi_1_0.Y VGND.t31 sg13_lv_nmos ad=0.2516p pd=2.16u as=0.1406p ps=1.12u w=0.74u l=0.13u
X1256 VPWR sg13cmos5l_o21ai_1_3.B1 sg13cmos5l_o21ai_1_3.Y VPWR sg13_lv_pmos ad=0.3808p pd=2.92u as=0.2128p ps=1.5u w=1.12u l=0.15u
X1257 VPWR VGND.t615 VPWR VPWR sg13_lv_pmos ad=0.19p pd=1.38u as=0 ps=0 w=1u l=1u
X1258 sg13cmos5l_nand2_1_1.B a_808_9192# VPWR VPWR sg13_lv_pmos ad=0.42p pd=2.99u as=0.2114p ps=1.54u w=1.12u l=0.13u
X1259 VPWR VGND.t298 VPWR VPWR sg13_lv_pmos ad=0.34p pd=2.68u as=0 ps=0 w=1u l=1u
X1260 VGND.t386 VPWR VGND.t386 VGND.t19 sg13_lv_nmos ad=79.8f pd=0.8u as=0 ps=0 w=0.42u l=1u
X1261 VGND.t323 VPWR VGND.t322 VGND.t293 sg13_lv_nmos ad=0.1428p pd=1.52u as=0 ps=0 w=0.42u l=1u
X1262 sg13cmos5l_inv_1_12.Y sg13cmos5l_inv_1_13.Y VGND.t5 VGND.t886 sg13_lv_nmos ad=0.2516p pd=2.16u as=0.2516p ps=2.16u w=0.74u l=0.13u
X1263 VGND.t72 VPWR VGND.t72 VGND.t75 sg13_lv_nmos ad=79.8f pd=0.8u as=0 ps=0 w=0.42u l=1u
X1264 VGND.t564 VPWR VGND.t566 VGND.t565 sg13_lv_nmos ad=79.8f pd=0.8u as=0 ps=0 w=0.42u l=1u
X1265 sg13cmos5l_inv_1_99.Y sg13cmos5l_inv_1_99.A VGND.t81 VGND.t965 sg13_lv_nmos ad=0.2516p pd=2.16u as=0.2516p ps=2.16u w=0.74u l=0.13u
X1266 VGND.t196 VPWR VGND.t197 VGND.t226 sg13_lv_nmos ad=0.1428p pd=1.52u as=0 ps=0 w=0.42u l=1u
X1267 sg13cmos5l_inv_1_69.Y sg13cmos5l_inv_1_69.A VGND.t161 VGND.t747 sg13_lv_nmos ad=0.2516p pd=2.16u as=0.2516p ps=2.16u w=0.74u l=0.13u
X1268 VGND.t258 VPWR VGND.t258 VGND.t277 sg13_lv_nmos ad=0.1428p pd=1.52u as=0 ps=0 w=0.42u l=1u
X1269 VPWR VGND.t377 VPWR VPWR sg13_lv_pmos ad=0.19p pd=1.38u as=0 ps=0 w=1u l=1u
X1270 VGND.t92 VPWR VGND.t92 VGND.t93 sg13_lv_nmos ad=79.8f pd=0.8u as=0 ps=0 w=0.42u l=1u
X1271 VPWR VGND.t382 VPWR VPWR sg13_lv_pmos ad=0.19p pd=1.38u as=0 ps=0 w=1u l=1u
X1272 VGND.t10 sg13cmos5l_inv_1_129.Y sg13cmos5l_inv_1_20.A VGND.t688 sg13_lv_nmos ad=0.2516p pd=2.16u as=0.2516p ps=2.16u w=0.74u l=0.13u
X1273 VPWR VGND.t315 VPWR VPWR sg13_lv_pmos ad=0.19p pd=1.38u as=0 ps=0 w=1u l=1u
X1274 VGND.t164 sg13cmos5l_mux2_1_3.X a_5492_8434# VGND.t823 sg13_lv_nmos ad=0.1824p pd=1.21u as=0.2304p ps=1.36u w=0.64u l=0.13u
X1275 sg13cmos5l_inv_1_106.Y sg13cmos5l_inv_1_105.Y VPWR VPWR sg13_lv_pmos ad=0.3808p pd=2.92u as=0.3808p ps=2.92u w=1.12u l=0.13u
X1276 VPWR sg13cmos5l_buf_1_4.A a_1595_8472# VPWR sg13_lv_pmos ad=0.253p pd=1.53u as=0.2856p ps=2.36u w=0.84u l=0.13u
X1277 a_2038_6546# sg13cmos5l_o21ai_1_0.A2 VGND.t7 VGND.t8 sg13_lv_nmos ad=0.1406p pd=1.12u as=0.1406p ps=1.12u w=0.74u l=0.15u
X1278 VGND.t258 sg13cmos5l_inv_1_117.A sg13cmos5l_mux2_1_6.A0 VGND.t885 sg13_lv_nmos ad=0.2516p pd=2.16u as=0.2516p ps=2.16u w=0.74u l=0.13u
X1279 a_4109_3108# a_4839_3231# a_4860_3505# VGND.t21 sg13_lv_nmos ad=0.12665p pd=1.145u as=0.3473p ps=2.71u w=0.74u l=0.13u
X1280 VPWR VGND.t16 VPWR VPWR sg13_lv_pmos ad=0.19p pd=1.38u as=0 ps=0 w=1u l=1u
X1281 VGND.t394 VPWR VGND.t394 VGND.t19 sg13_lv_nmos ad=0.1428p pd=1.52u as=0 ps=0 w=0.42u l=1u
X1282 a_11457_8476# sg13cmos5l_mux4_1_0.S0 a_10462_8434# VPWR sg13_lv_pmos ad=0.2225p pd=1.445u as=0.34p ps=2.68u w=1u l=0.13u
X1283 a_5781_4052# a_4839_4112# a_5687_4285# VPWR sg13_lv_pmos ad=79.8f pd=0.8u as=0.1428p ps=1.52u w=0.42u l=0.13u
X1284 a_6015_8434# sg13cmos5l_mux4_1_0.S0 a_5878_8434# VGND.t792 sg13_lv_nmos ad=76.8f pd=0.88u as=0.1776p ps=1.195u w=0.64u l=0.13u
X1285 VGND.t386 VPWR VGND.t386 VGND.t19 sg13_lv_nmos ad=0.1428p pd=1.52u as=0 ps=0 w=0.42u l=1u
X1286 sg13cmos5l_nor4_1_0.Y sg13cmos5l_buf_1_1.X VGND.t30 VGND.t946 sg13_lv_nmos ad=0.1406p pd=1.12u as=0.1406p ps=1.12u w=0.74u l=0.13u
X1287 a_6501_7680# sg13cmos5l_nand2_1_1.A VPWR VPWR sg13_lv_pmos ad=0.2464p pd=1.56u as=0.3808p ps=2.92u w=1.12u l=0.13u
X1288 sg13cmos5l_inv_1_124.Y sg13cmos5l_inv_1_123.Y VGND.t10 VGND.t869 sg13_lv_nmos ad=0.2516p pd=2.16u as=0.2516p ps=2.16u w=0.74u l=0.13u
X1289 VPWR sg13cmos5l_buf_1_4.A sg13cmos5l_o21ai_1_5.B1 VPWR sg13_lv_pmos ad=0.2198p pd=1.53u as=0.2128p ps=1.5u w=1.12u l=0.13u
X1290 sg13cmos5l_o21ai_1_7.B1 a_4347_5448# a_4549_5410# VGND.t666 sg13_lv_nmos ad=0.333p pd=2.38u as=0.1406p ps=1.12u w=0.74u l=0.13u
X1291 VPWR VGND.t49 VPWR VPWR sg13_lv_pmos ad=0.19p pd=1.38u as=0 ps=0 w=1u l=1u
X1292 VPWR VGND.t382 VPWR VPWR sg13_lv_pmos ad=0.34p pd=2.68u as=0 ps=0 w=1u l=1u
X1293 VPWR VGND.t600 VPWR VPWR sg13_lv_pmos ad=0.19p pd=1.38u as=0 ps=0 w=1u l=1u
X1294 sg13cmos5l_inv_1_61.Y sg13cmos5l_o21ai_1_6.A2 VPWR VPWR sg13_lv_pmos ad=0.3808p pd=2.92u as=0.3808p ps=2.92u w=1.12u l=0.13u
X1295 sg13cmos5l_nand2_1_1.B a_808_9192# VGND.t663 VGND.t662 sg13_lv_nmos ad=0.2886p pd=2.26u as=0.14875p ps=1.16u w=0.74u l=0.13u
X1296 VGND.t314 VPWR VGND.t313 VGND.t293 sg13_lv_nmos ad=0.1428p pd=1.52u as=0 ps=0 w=0.42u l=1u
X1297 VPWR a_4860_3505# a_5883_3191# VPWR sg13_lv_pmos ad=0.1563p pd=1.22u as=63f ps=0.72u w=0.42u l=0.13u
X1298 VPWR VGND.t322 VPWR VPWR sg13_lv_pmos ad=0.34p pd=2.68u as=0 ps=0 w=1u l=1u
X1299 a_3990_4069# a_4109_3858# VPWR VPWR sg13_lv_pmos ad=0.3864p pd=2.93u as=0.2128p ps=1.5u w=1.12u l=0.13u
X1300 VPWR VGND.t402 VPWR VPWR sg13_lv_pmos ad=0.19p pd=1.38u as=0 ps=0 w=1u l=1u
X1301 VPWR VGND.t164 VPWR VPWR sg13_lv_pmos ad=0.34p pd=2.68u as=0 ps=0 w=1u l=1u
X1302 VGND.t3 VPWR VGND.t3 VGND.t130 sg13_lv_nmos ad=0.1428p pd=1.52u as=0 ps=0 w=0.42u l=1u
X1303 VPWR a_3990_3431# sg13cmos5l_dfrbp_1_2.Q VPWR sg13_lv_pmos ad=0.2128p pd=1.5u as=0.3808p ps=2.92u w=1.12u l=0.13u
X1304 VGND.t377 VPWR VGND.t377 VGND.t19 sg13_lv_nmos ad=0.1428p pd=1.52u as=0 ps=0 w=0.42u l=1u
X1305 sg13cmos5l_inv_1_5.Y sg13cmos5l_inv_1_4.Y VGND.t26 VGND.t914 sg13_lv_nmos ad=0.2516p pd=2.16u as=0.2516p ps=2.16u w=0.74u l=0.13u
X1306 VGND.t402 VPWR VGND.t402 VGND.t19 sg13_lv_nmos ad=79.8f pd=0.8u as=0 ps=0 w=0.42u l=1u
X1307 VGND.t208 VPWR VGND.t208 VGND.t233 sg13_lv_nmos ad=0.1428p pd=1.52u as=0 ps=0 w=0.42u l=1u
X1308 VPWR VGND.t585 VPWR VPWR sg13_lv_pmos ad=0.19p pd=1.38u as=0 ps=0 w=1u l=1u
X1309 VPWR sg13cmos5l_inv_1_113.A sg13cmos5l_inv_1_83.A VPWR sg13_lv_pmos ad=0.3808p pd=2.92u as=0.3808p ps=2.92u w=1.12u l=0.13u
X1310 VPWR VGND.t330 VPWR VPWR sg13_lv_pmos ad=0.34p pd=2.68u as=0 ps=0 w=1u l=1u
X1311 VGND.t326 VPWR VGND.t325 VGND.t293 sg13_lv_nmos ad=0.1428p pd=1.52u as=0 ps=0 w=0.42u l=1u
X1312 VPWR sg13cmos5l_mux2_1_4.A1 sg13cmos5l_inv_1_38.A VPWR sg13_lv_pmos ad=0.3808p pd=2.92u as=0.3808p ps=2.92u w=1.12u l=0.13u
X1313 VGND.t494 VPWR VGND.t496 VGND.t495 sg13_lv_nmos ad=79.8f pd=0.8u as=0 ps=0 w=0.42u l=1u
X1314 VPWR sg13cmos5l_inv_1_29.Y sg13cmos5l_o21ai_1_0.A2 VPWR sg13_lv_pmos ad=0.3808p pd=2.92u as=0.3808p ps=2.92u w=1.12u l=0.13u
X1315 VGND.t162 VPWR VGND.t164 VGND.t163 sg13_lv_nmos ad=79.8f pd=0.8u as=0 ps=0 w=0.42u l=1u
X1316 VPWR VGND.t286 VPWR VPWR sg13_lv_pmos ad=0.19p pd=1.38u as=0 ps=0 w=1u l=1u
X1317 a_5208_5724# sg13cmos5l_o21ai_1_0.A1 VPWR VPWR sg13_lv_pmos ad=0.2128p pd=1.5u as=0.3808p ps=2.92u w=1.12u l=0.15u
X1318 VGND.t92 VPWR VGND.t92 VGND.t95 sg13_lv_nmos ad=79.8f pd=0.8u as=0 ps=0 w=0.42u l=1u
X1319 VPWR VGND.t382 VPWR VPWR sg13_lv_pmos ad=0.19p pd=1.38u as=0 ps=0 w=1u l=1u
X1320 a_10375_8701# sg13cmos5l_o21ai_1_6.Y VPWR VPWR sg13_lv_pmos ad=0.415p pd=1.83u as=0.22315p ps=1.555u w=1u l=0.13u
X1321 VPWR VGND.t89 VPWR VPWR sg13_lv_pmos ad=0.34p pd=2.68u as=0 ps=0 w=1u l=1u
X1322 VGND.t291 sg13cmos5l_inv_1_18.A sg13cmos5l_inv_1_18.Y VGND.t21 sg13_lv_nmos ad=0.2516p pd=2.16u as=0.2516p ps=2.16u w=0.74u l=0.13u
X1323 VPWR VGND.t427 VPWR VPWR sg13_lv_pmos ad=0.19p pd=1.38u as=0 ps=0 w=1u l=1u
X1324 sg13cmos5l_inv_1_68.A sg13cmos5l_inv_1_37.Y VGND.t64 VGND.t660 sg13_lv_nmos ad=0.2516p pd=2.16u as=0.2516p ps=2.16u w=0.74u l=0.13u
X1325 VPWR sg13cmos5l_buf_1_12.X a_10120_6168# VPWR sg13_lv_pmos ad=0.2114p pd=1.54u as=0.2856p ps=2.36u w=0.84u l=0.13u
X1326 VPWR VGND.t97 VPWR VPWR sg13_lv_pmos ad=0.19p pd=1.38u as=0 ps=0 w=1u l=1u
X1327 VPWR VGND.t531 VPWR VPWR sg13_lv_pmos ad=0.19p pd=1.38u as=0 ps=0 w=1u l=1u
X1328 VPWR VGND.t313 VPWR VPWR sg13_lv_pmos ad=0.34p pd=2.68u as=0 ps=0 w=1u l=1u
X1329 a_7723_5004# sg13cmos5l_nor2b_1_0.B_N a_7629_5004# VGND.t863 sg13_lv_nmos ad=0.1216p pd=1.02u as=0.2176p ps=1.96u w=0.64u l=0.13u
X1330 VGND.t394 VPWR VGND.t394 VGND.t19 sg13_lv_nmos ad=0.1428p pd=1.52u as=0 ps=0 w=0.42u l=1u
X1331 a_4933_6219# sg13cmos5l_o21ai_1_0.Y VPWR VPWR sg13_lv_pmos ad=0.20762p pd=1.605u as=0.29275p ps=1.785u w=1u l=0.13u
X1332 sg13cmos5l_dfrbp_1_2.RESET_B a_808_9980# VGND.t663 VGND.t662 sg13_lv_nmos ad=0.2886p pd=2.26u as=0.14875p ps=1.16u w=0.74u l=0.13u
X1333 VGND.t64 sg13cmos5l_inv_1_38.A sg13cmos5l_inv_1_39.A VGND.t938 sg13_lv_nmos ad=0.2516p pd=2.16u as=0.2516p ps=2.16u w=0.74u l=0.13u
X1334 VPWR VGND.t39 VPWR VPWR sg13_lv_pmos ad=0.34p pd=2.68u as=0 ps=0 w=1u l=1u
X1335 VGND.t292 a_3990_3431# sg13cmos5l_dfrbp_1_2.Q VGND.t21 sg13_lv_nmos ad=0.1406p pd=1.12u as=0.2516p ps=2.16u w=0.74u l=0.13u
X1336 sg13cmos5l_inv_1_111.Y sg13cmos5l_inv_1_111.A VPWR VPWR sg13_lv_pmos ad=0.3808p pd=2.92u as=0.3808p ps=2.92u w=1.12u l=0.13u
X1337 VGND.t394 VPWR VGND.t394 VGND.t19 sg13_lv_nmos ad=79.8f pd=0.8u as=0 ps=0 w=0.42u l=1u
X1338 VGND.t32 VPWR VGND.t32 VGND.t246 sg13_lv_nmos ad=0.1428p pd=1.52u as=0 ps=0 w=0.42u l=1u
X1339 VPWR VGND.t386 VPWR VPWR sg13_lv_pmos ad=0.34p pd=2.68u as=0 ps=0 w=1u l=1u
X1340 VGND.t420 VPWR VGND.t420 VGND.t19 sg13_lv_nmos ad=79.8f pd=0.8u as=0 ps=0 w=0.42u l=1u
X1341 a_6124_7216# a_5902_6960# VPWR VPWR sg13_lv_pmos ad=0.1176p pd=1.33u as=0.2618p ps=1.63u w=1.12u l=0.13u
X1342 VGND.t102 VPWR VGND.t97 VGND.t101 sg13_lv_nmos ad=0.1428p pd=1.52u as=0 ps=0 w=0.42u l=1u
X1343 VGND.t161 sg13cmos5l_buf_1_4.A a_4091_8472# VGND.t759 sg13_lv_nmos ad=0.18945p pd=1.27u as=0.187p ps=1.78u w=0.55u l=0.13u
X1344 VGND.t317 VPWR VGND.t316 VGND.t293 sg13_lv_nmos ad=0.1428p pd=1.52u as=0 ps=0 w=0.42u l=1u
X1345 VPWR VGND.t402 VPWR VPWR sg13_lv_pmos ad=0.19p pd=1.38u as=0 ps=0 w=1u l=1u
X1346 VPWR VGND.t199 VPWR VPWR sg13_lv_pmos ad=0.19p pd=1.38u as=0 ps=0 w=1u l=1u
X1347 VGND.t613 VPWR VGND.t612 VGND.t611 sg13_lv_nmos ad=0.1428p pd=1.52u as=0 ps=0 w=0.42u l=1u
X1348 VGND.t46 sg13cmos5l_inv_1_45.A sg13cmos5l_inv_1_44.A VGND.t870 sg13_lv_nmos ad=0.2516p pd=2.16u as=0.2516p ps=2.16u w=0.74u l=0.13u
X1349 VGND.t382 VPWR VGND.t382 VGND.t19 sg13_lv_nmos ad=0.1428p pd=1.52u as=0 ps=0 w=0.42u l=1u
X1350 sg13cmos5l_inv_1_22.Y sg13cmos5l_dfrbp_1_2.RESET_B VGND.t30 VGND.t743 sg13_lv_nmos ad=0.2516p pd=2.16u as=0.2516p ps=2.16u w=0.74u l=0.13u
X1351 VPWR VGND.t377 VPWR VPWR sg13_lv_pmos ad=0.34p pd=2.68u as=0 ps=0 w=1u l=1u
X1352 VPWR VGND.t590 VPWR VPWR sg13_lv_pmos ad=0.19p pd=1.38u as=0 ps=0 w=1u l=1u
X1353 VPWR a_8207_3505# a_9044_3144# VPWR sg13_lv_pmos ad=0.2128p pd=1.5u as=0.3864p ps=2.93u w=1.12u l=0.13u
X1354 VPWR VGND.t333 VPWR VPWR sg13_lv_pmos ad=0.34p pd=2.68u as=0 ps=0 w=1u l=1u
X1355 VGND.t308 VPWR VGND.t307 VGND.t293 sg13_lv_nmos ad=0.1428p pd=1.52u as=0 ps=0 w=0.42u l=1u
X1356 VGND.t56 sg13cmos5l_inv_1_113.A sg13cmos5l_inv_1_83.A VGND.t51 sg13_lv_nmos ad=0.2516p pd=2.16u as=0.2516p ps=2.16u w=0.74u l=0.13u
X1357 sg13cmos5l_inv_1_60.A sg13cmos5l_inv_1_75.Y VGND.t52 VGND.t683 sg13_lv_nmos ad=0.2516p pd=2.16u as=0.2516p ps=2.16u w=0.74u l=0.13u
X1358 sg13cmos5l_nand2b_1_6.A_N sg13cmos5l_inv_1_19.Y VPWR VPWR sg13_lv_pmos ad=0.3808p pd=2.92u as=0.3808p ps=2.92u w=1.12u l=0.13u
X1359 VGND.t420 VPWR VGND.t420 VGND.t19 sg13_lv_nmos ad=0.1428p pd=1.52u as=0 ps=0 w=0.42u l=1u
X1360 sg13cmos5l_inv_1_130.Y sg13cmos5l_inv_1_130.A VPWR VPWR sg13_lv_pmos ad=0.3808p pd=2.92u as=0.3808p ps=2.92u w=1.12u l=0.13u
X1361 VGND.t141 VPWR VGND.t141 VGND.t55 sg13_lv_nmos ad=79.8f pd=0.8u as=0 ps=0 w=0.42u l=1u
X1362 VGND.t164 VPWR VGND.t164 VGND.t166 sg13_lv_nmos ad=79.8f pd=0.8u as=0 ps=0 w=0.42u l=1u
X1363 sg13cmos5l_inv_1_19.A sg13cmos5l_inv_1_15.Y VPWR VPWR sg13_lv_pmos ad=0.3808p pd=2.92u as=0.3808p ps=2.92u w=1.12u l=0.13u
X1364 VGND.t132 sg13cmos5l_inv_1_29.Y sg13cmos5l_o21ai_1_0.A2 VGND.t845 sg13_lv_nmos ad=0.2516p pd=2.16u as=0.2516p ps=2.16u w=0.74u l=0.13u
X1365 VPWR a_4109_3108# sg13cmos5l_dfrbp_1_2.D VPWR sg13_lv_pmos ad=0.2639p pd=1.81u as=0.4312p ps=3.01u w=1.12u l=0.13u
X1366 VGND.t201 VPWR VGND.t201 VGND.t203 sg13_lv_nmos ad=0.1428p pd=1.52u as=0 ps=0 w=0.42u l=1u
X1367 VPWR VGND.t386 VPWR VPWR sg13_lv_pmos ad=0.19p pd=1.38u as=0 ps=0 w=1u l=1u
X1368 sg13cmos5l_inv_1_98.A sg13cmos5l_inv_1_107.Y VGND.t89 VGND.t816 sg13_lv_nmos ad=0.2516p pd=2.16u as=0.2516p ps=2.16u w=0.74u l=0.13u
X1369 a_3116_6882# sg13cmos5l_buf_1_12.X VGND.t196 VGND.t962 sg13_lv_nmos ad=0.187p pd=1.78u as=0.14875p ps=1.16u w=0.55u l=0.13u
X1370 VPWR VGND.t92 VPWR VPWR sg13_lv_pmos ad=0.34p pd=2.68u as=0 ps=0 w=1u l=1u
X1371 VGND.t627 sg13cmos5l_buf_1_0.X a_4187_4712# VGND.t730 sg13_lv_nmos ad=0.18945p pd=1.27u as=0.187p ps=1.78u w=0.55u l=0.13u
X1372 VPWR VGND.t58 VPWR VPWR sg13_lv_pmos ad=0.19p pd=1.38u as=0 ps=0 w=1u l=1u
X1373 sg13cmos5l_nand2b_1_1.Y sg13cmos5l_o21ai_1_0.A1 VPWR VPWR sg13_lv_pmos ad=0.2128p pd=1.5u as=0.2198p ps=1.53u w=1.12u l=0.13u
X1374 VGND.t81 VPWR VGND.t81 VGND.t82 sg13_lv_nmos ad=79.8f pd=0.8u as=0 ps=0 w=0.42u l=1u
X1375 sg13cmos5l_inv_1_123.Y sg13cmos5l_inv_1_123.A VPWR VPWR sg13_lv_pmos ad=0.3808p pd=2.92u as=0.3808p ps=2.92u w=1.12u l=0.13u
X1376 VGND.t92 VPWR VGND.t92 VGND.t94 sg13_lv_nmos ad=0.1428p pd=1.52u as=0 ps=0 w=0.42u l=1u
X1377 VGND.t64 VPWR VGND.t14 VGND.t108 sg13_lv_nmos ad=79.8f pd=0.8u as=0 ps=0 w=0.42u l=1u
X1378 sg13cmos5l_inv_1_68.A sg13cmos5l_inv_1_37.Y VPWR VPWR sg13_lv_pmos ad=0.3808p pd=2.92u as=0.3808p ps=2.92u w=1.12u l=0.13u
X1379 VPWR VGND.t316 VPWR VPWR sg13_lv_pmos ad=0.34p pd=2.68u as=0 ps=0 w=1u l=1u
X1380 VPWR VGND.t602 VPWR VPWR sg13_lv_pmos ad=0.34p pd=2.68u as=0 ps=0 w=1u l=1u
X1381 VGND.t549 VPWR VGND.t548 VGND.t547 sg13_lv_nmos ad=0.1428p pd=1.52u as=0 ps=0 w=0.42u l=1u
X1382 VGND.t394 VPWR VGND.t394 VGND.t19 sg13_lv_nmos ad=0.1428p pd=1.52u as=0 ps=0 w=0.42u l=1u
X1383 VPWR VGND.t258 VPWR VPWR sg13_lv_pmos ad=0.19p pd=1.38u as=0 ps=0 w=1u l=1u
X1384 VGND.t58 VPWR VGND.t58 VGND.t273 sg13_lv_nmos ad=0.1428p pd=1.52u as=0 ps=0 w=0.42u l=1u
X1385 VGND.t377 VPWR VGND.t377 VGND.t19 sg13_lv_nmos ad=0.1428p pd=1.52u as=0 ps=0 w=0.42u l=1u
X1386 a_4839_3231# a_4991_3115# VPWR VPWR sg13_lv_pmos ad=0.3864p pd=2.93u as=4.30725p ps=28.325u w=1.12u l=0.13u
X1387 sg13cmos5l_inv_1_111.Y sg13cmos5l_inv_1_111.A VGND.t56 VGND.t51 sg13_lv_nmos ad=0.2516p pd=2.16u as=0.2516p ps=2.16u w=0.74u l=0.13u
X1388 sg13cmos5l_inv_1_64.Y sg13cmos5l_mux2_1_4.A0 VGND.t49 VGND.t48 sg13_lv_nmos ad=0.2516p pd=2.16u as=0.2516p ps=2.16u w=0.74u l=0.13u
X1389 VPWR VGND.t576 VPWR VPWR sg13_lv_pmos ad=0.19p pd=1.38u as=0 ps=0 w=1u l=1u
X1390 VPWR VGND.t420 VPWR VPWR sg13_lv_pmos ad=0.19p pd=1.38u as=0 ps=0 w=1u l=1u
X1391 VPWR VGND.t386 VPWR VPWR sg13_lv_pmos ad=0.34p pd=2.68u as=0 ps=0 w=1u l=1u
X1392 VGND.t23 a_8207_3505# a_9044_3144# VGND.t21 sg13_lv_nmos ad=0.1406p pd=1.12u as=0.2516p ps=2.16u w=0.74u l=0.13u
X1393 VGND.t26 sg13cmos5l_mux2_1_0.S a_14524_5410# VGND.t899 sg13_lv_nmos ad=0.18945p pd=1.27u as=0.13135p ps=1.095u w=0.74u l=0.13u
X1394 VPWR VGND.t307 VPWR VPWR sg13_lv_pmos ad=0.34p pd=2.68u as=0 ps=0 w=1u l=1u
X1395 sg13cmos5l_mux2_1_0.S a_11848_5444# VPWR VPWR sg13_lv_pmos ad=0.42p pd=2.99u as=0.2114p ps=1.54u w=1.12u l=0.13u
X1396 sg13cmos5l_inv_1_103.A sg13cmos5l_inv_1_104.Y VGND.t87 VGND.t941 sg13_lv_nmos ad=0.2516p pd=2.16u as=0.2516p ps=2.16u w=0.74u l=0.13u
X1397 VGND.t386 VPWR VGND.t386 VGND.t19 sg13_lv_nmos ad=0.1428p pd=1.52u as=0 ps=0 w=0.42u l=1u
X1398 VGND.t5 sg13cmos5l_inv_1_11.A sg13cmos5l_inv_1_14.A VGND.t735 sg13_lv_nmos ad=0.2516p pd=2.16u as=0.2516p ps=2.16u w=0.74u l=0.13u
X1399 VPWR VGND.t3 VPWR VPWR sg13_lv_pmos ad=0.34p pd=2.68u as=0 ps=0 w=1u l=1u
X1400 VPWR VGND.t377 VPWR VPWR sg13_lv_pmos ad=0.19p pd=1.38u as=0 ps=0 w=1u l=1u
X1401 VGND.t583 VPWR VGND.t585 VGND.t584 sg13_lv_nmos ad=79.8f pd=0.8u as=0 ps=0 w=0.42u l=1u
X1402 VGND.t292 a_4109_3108# sg13cmos5l_dfrbp_1_2.D VGND.t21 sg13_lv_nmos ad=0.2516p pd=2.16u as=0.2849p ps=2.25u w=0.74u l=0.13u
X1403 VPWR sg13cmos5l_mux2_1_0.S sg13cmos5l_o21ai_1_3.B1 VPWR sg13_lv_pmos ad=0.2198p pd=1.53u as=0.2128p ps=1.5u w=1.12u l=0.13u
X1404 VPWR VGND.t84 VPWR VPWR sg13_lv_pmos ad=0.19p pd=1.38u as=0 ps=0 w=1u l=1u
X1405 a_6574_7216# sg13cmos5l_a221oi_1_0.B1 a_6676_7216# VPWR sg13_lv_pmos ad=0.3808p pd=2.92u as=0.2128p ps=1.5u w=1.12u l=0.13u
X1406 VPWR VGND.t382 VPWR VPWR sg13_lv_pmos ad=0.34p pd=2.68u as=0 ps=0 w=1u l=1u
X1407 a_4750_4209# a_4492_3894# VPWR VPWR sg13_lv_pmos ad=93.45f pd=0.865u as=7.22485p ps=47.9u w=0.42u l=0.13u
X1408 sg13cmos5l_o21ai_1_7.Y sg13cmos5l_inv_1_14.A a_3960_5724# VPWR sg13_lv_pmos ad=0.2128p pd=1.5u as=0.2128p ps=1.5u w=1.12u l=0.15u
X1409 VPWR sg13cmos5l_buf_1_10.X a_11848_5444# VPWR sg13_lv_pmos ad=0.2114p pd=1.54u as=0.2856p ps=2.36u w=0.84u l=0.13u
X1410 VGND.t311 VPWR VGND.t310 VGND.t293 sg13_lv_nmos ad=0.1428p pd=1.52u as=0 ps=0 w=0.42u l=1u
X1411 VGND.t402 VPWR VGND.t402 VGND.t19 sg13_lv_nmos ad=0.1428p pd=1.52u as=0 ps=0 w=0.42u l=1u
X1412 a_6676_6944# sg13cmos5l_nor2b_1_2.Y VGND.t201 VGND.t908 sg13_lv_nmos ad=0.1406p pd=1.12u as=0.1406p ps=1.12u w=0.74u l=0.13u
X1413 VPWR VGND.t587 VPWR VPWR sg13_lv_pmos ad=0.34p pd=2.68u as=0 ps=0 w=1u l=1u
X1414 VPWR invsel[1] a_808_5444# VPWR sg13_lv_pmos ad=0.2114p pd=1.54u as=0.2856p ps=2.36u w=0.84u l=0.13u
X1415 VPWR VGND.t52 VPWR VPWR sg13_lv_pmos ad=0.19p pd=1.38u as=0 ps=0 w=1u l=1u
X1416 VGND.t292 sg13cmos5l_dfrbp_1_2.RESET_B.t4 a_4586_3582# VGND.t21 sg13_lv_nmos ad=79.8f pd=0.8u as=37.8f ps=0.6u w=0.42u l=0.13u
X1417 VPWR VGND.t92 VPWR VPWR sg13_lv_pmos ad=0.34p pd=2.68u as=0 ps=0 w=1u l=1u
X1418 VGND.t89 VPWR VGND.t89 VGND.t118 sg13_lv_nmos ad=79.8f pd=0.8u as=0 ps=0 w=0.42u l=1u
X1419 VPWR VGND.t254 VPWR VPWR sg13_lv_pmos ad=0.19p pd=1.38u as=0 ps=0 w=1u l=1u
X1420 sg13cmos5l_inv_1_98.A sg13cmos5l_inv_1_107.Y VPWR VPWR sg13_lv_pmos ad=0.3808p pd=2.92u as=0.3808p ps=2.92u w=1.12u l=0.13u
X1421 VPWR VGND.t39 VPWR VPWR sg13_lv_pmos ad=0.34p pd=2.68u as=0 ps=0 w=1u l=1u
X1422 sg13cmos5l_inv_1_97.A sg13cmos5l_inv_1_98.Y VGND.t56 VGND.t55 sg13_lv_nmos ad=0.2516p pd=2.16u as=0.2516p ps=2.16u w=0.74u l=0.13u
X1423 sg13cmos5l_and2_1_0.B sg13cmos5l_nor4_1_0.D VGND.t28 VGND.t736 sg13_lv_nmos ad=0.1406p pd=1.12u as=0.2516p ps=2.16u w=0.74u l=0.13u
X1424 sg13cmos5l_inv_1_19.Y sg13cmos5l_inv_1_19.A VPWR VPWR sg13_lv_pmos ad=0.3808p pd=2.92u as=0.3808p ps=2.92u w=1.12u l=0.13u
X1425 sg13cmos5l_inv_1_111.A sg13cmos5l_o21ai_1_3.A2 VPWR VPWR sg13_lv_pmos ad=0.3808p pd=2.92u as=0.3808p ps=2.92u w=1.12u l=0.13u
X1426 VGND.t97 VPWR VGND.t97 VGND.t96 sg13_lv_nmos ad=0.1428p pd=1.52u as=0 ps=0 w=0.42u l=1u
X1427 VPWR VGND.t412 VPWR VPWR sg13_lv_pmos ad=0.19p pd=1.38u as=0 ps=0 w=1u l=1u
X1428 VPWR VGND.t382 VPWR VPWR sg13_lv_pmos ad=0.34p pd=2.68u as=0 ps=0 w=1u l=1u
X1429 a_4586_3894# a_4109_3858# a_4492_3894# VGND.t21 sg13_lv_nmos ad=37.8f pd=0.6u as=0.1428p ps=1.52u w=0.42u l=0.13u
X1430 VPWR VGND.t270 VPWR VPWR sg13_lv_pmos ad=0.19p pd=1.38u as=0 ps=0 w=1u l=1u
X1431 VPWR VGND.t607 VPWR VPWR sg13_lv_pmos ad=0.34p pd=2.68u as=0 ps=0 w=1u l=1u
X1432 VGND.t58 sg13cmos5l_inv_1_3.Y sg13cmos5l_mux2_1_0.A1 VGND.t57 sg13_lv_nmos ad=0.2516p pd=2.16u as=0.2516p ps=2.16u w=0.74u l=0.13u
X1433 VGND.t386 VPWR VGND.t386 VGND.t19 sg13_lv_nmos ad=0.1428p pd=1.52u as=0 ps=0 w=0.42u l=1u
X1434 VPWR VGND.t262 VPWR VPWR sg13_lv_pmos ad=0.19p pd=1.38u as=0 ps=0 w=1u l=1u
X1435 VPWR VGND.t134 VPWR VPWR sg13_lv_pmos ad=0.19p pd=1.38u as=0 ps=0 w=1u l=1u
X1436 a_10966_8434# sg13cmos5l_buf_1_2.X a_10885_8701# VPWR sg13_lv_pmos ad=0.4425p pd=1.885u as=0.20762p ps=1.605u w=1u l=0.13u
X1437 VGND.t313 VPWR VGND.t314 VGND.t21 sg13_lv_nmos ad=79.8f pd=0.8u as=0 ps=0 w=0.42u l=1u
X1438 VGND.t58 VPWR VGND.t58 VGND.t251 sg13_lv_nmos ad=79.8f pd=0.8u as=0 ps=0 w=0.42u l=1u
X1439 a_8464_3386# sg13cmos5l_dfrbp_1_2.RESET_B.t1 VPWR VPWR sg13_lv_pmos ad=79.8f pd=0.8u as=3.76885p ps=24.785u w=0.42u l=0.13u
X1440 VPWR VGND.t377 VPWR VPWR sg13_lv_pmos ad=0.34p pd=2.68u as=0 ps=0 w=1u l=1u
X1441 VGND.t89 VPWR VGND.t89 VGND.t88 sg13_lv_nmos ad=0.1428p pd=1.52u as=0 ps=0 w=0.42u l=1u
X1442 a_4510_6558# a_5581_6442# a_5505_6516# VGND.t620 sg13_lv_nmos ad=0.2176p pd=1.96u as=0.1216p ps=1.02u w=0.64u l=0.13u
X1443 VGND.t145 VPWR VGND.t147 VGND.t51 sg13_lv_nmos ad=79.8f pd=0.8u as=0 ps=0 w=0.42u l=1u
X1444 a_6369_8476# sg13cmos5l_buf_1_2.X a_5374_8434# VPWR sg13_lv_pmos ad=0.2225p pd=1.445u as=0.34p ps=2.68u w=1u l=0.13u
X1445 sg13cmos5l_inv_1_64.Y sg13cmos5l_mux2_1_4.A0 VPWR VPWR sg13_lv_pmos ad=0.3808p pd=2.92u as=0.3808p ps=2.92u w=1.12u l=0.13u
X1446 VPWR VGND.t386 VPWR VPWR sg13_lv_pmos ad=0.34p pd=2.68u as=0 ps=0 w=1u l=1u
X1447 VGND.t1 a_7412_6886# sg13cmos5l_a221oi_1_0.A2 VGND.t837 sg13_lv_nmos ad=0.17255p pd=1.25u as=0.1406p ps=1.12u w=0.74u l=0.13u
X1448 a_10933_6516# sg13cmos5l_mux4_1_0.S0 a_11836_6558# VGND.t797 sg13_lv_nmos ad=0.1472p pd=1.1u as=0.2304p ps=1.36u w=0.64u l=0.13u
X1449 VPWR sg13cmos5l_inv_1_82.A sg13cmos5l_inv_1_82.Y VPWR sg13_lv_pmos ad=0.3808p pd=2.92u as=0.3808p ps=2.92u w=1.12u l=0.13u
X1450 VGND.t420 VPWR VGND.t420 VGND.t19 sg13_lv_nmos ad=0.1428p pd=1.52u as=0 ps=0 w=0.42u l=1u
X1451 sg13cmos5l_inv_1_99.A sg13cmos5l_inv_1_106.Y VPWR VPWR sg13_lv_pmos ad=0.3808p pd=2.92u as=0.3808p ps=2.92u w=1.12u l=0.13u
X1452 VGND.t686 a_10571_6132# sg13cmos5l_nor2_1_1.A VGND.t935 sg13_lv_nmos ad=0.1543p pd=1.18u as=0.2516p ps=2.16u w=0.74u l=0.13u
X1453 VGND.t514 VPWR VGND.t516 VGND.t515 sg13_lv_nmos ad=79.8f pd=0.8u as=0 ps=0 w=0.42u l=1u
X1454 VGND.t305 VPWR VGND.t355 VGND.t21 sg13_lv_nmos ad=79.8f pd=0.8u as=0 ps=0 w=0.42u l=1u
X1455 VGND.t258 VPWR VGND.t258 VGND.t259 sg13_lv_nmos ad=79.8f pd=0.8u as=0 ps=0 w=0.42u l=1u
X1456 a_4492_3582# a_4109_3108# VPWR VPWR sg13_lv_pmos ad=79.8f pd=0.8u as=0.2639p ps=1.81u w=0.42u l=0.13u
X1457 sg13cmos5l_inv_1_0.Y sg13cmos5l_inv_1_124.Y VGND.t10 VGND.t619 sg13_lv_nmos ad=0.2516p pd=2.16u as=0.2516p ps=2.16u w=0.74u l=0.13u
X1458 sg13cmos5l_inv_1_10.Y sg13cmos5l_inv_1_12.Y VPWR VPWR sg13_lv_pmos ad=0.3808p pd=2.92u as=0.3808p ps=2.92u w=1.12u l=0.13u
X1459 VGND.t410 VPWR VGND.t410 VGND.t19 sg13_lv_nmos ad=0.1428p pd=1.52u as=0 ps=0 w=0.42u l=1u
X1460 sg13cmos5l_inv_1_87.Y sg13cmos5l_inv_1_133.Y VPWR VPWR sg13_lv_pmos ad=0.3808p pd=2.92u as=0.3808p ps=2.92u w=1.12u l=0.13u
X1461 VPWR VGND.t592 VPWR VPWR sg13_lv_pmos ad=0.34p pd=2.68u as=0 ps=0 w=1u l=1u
X1462 VGND.t1 sg13cmos5l_inv_1_116.A sg13cmos5l_inv_1_24.A VGND.t0 sg13_lv_nmos ad=0.2516p pd=2.16u as=0.2516p ps=2.16u w=0.74u l=0.13u
X1463 VGND.t286 invsel[0] a_808_3932# VGND.t21 sg13_lv_nmos ad=0.14875p pd=1.16u as=0.187p ps=1.78u w=0.55u l=0.13u
X1464 VGND.t92 VPWR VGND.t92 VGND.t120 sg13_lv_nmos ad=79.8f pd=0.8u as=0 ps=0 w=0.42u l=1u
X1465 VPWR VGND.t39 VPWR VPWR sg13_lv_pmos ad=0.34p pd=2.68u as=0 ps=0 w=1u l=1u
X1466 VPWR VGND.t147 VPWR VPWR sg13_lv_pmos ad=0.19p pd=1.38u as=0 ps=0 w=1u l=1u
X1467 sg13cmos5l_nand3b_1_0.Y a_6142_2428# VPWR VPWR sg13_lv_pmos ad=0.3808p pd=2.92u as=0.2128p ps=1.5u w=1.12u l=0.13u
X1468 sg13cmos5l_mux4_1_0.S0 a_808_6956# VGND.t38 VGND.t637 sg13_lv_nmos ad=0.2886p pd=2.26u as=0.14875p ps=1.16u w=0.74u l=0.13u
X1469 a_7305_3191# a_6948_3148# VPWR VPWR sg13_lv_pmos ad=63f pd=0.72u as=0.1563p ps=1.22u w=0.42u l=0.13u
X1470 sg13cmos5l_inv_1_9.Y sg13cmos5l_inv_1_5.Y VGND.t26 VGND.t672 sg13_lv_nmos ad=0.2516p pd=2.16u as=0.2516p ps=2.16u w=0.74u l=0.13u
X1471 VGND.t84 VPWR VGND.t84 VGND.t83 sg13_lv_nmos ad=0.1428p pd=1.52u as=0 ps=0 w=0.42u l=1u
X1472 a_4510_6558# sg13cmos5l_mux4_1_0.S0 a_4423_6219# VPWR sg13_lv_pmos ad=0.19p pd=1.38u as=0.415p ps=1.83u w=1u l=0.13u
X1473 VPWR VGND.t386 VPWR VPWR sg13_lv_pmos ad=0.34p pd=2.68u as=0 ps=0 w=1u l=1u
X1474 a_14030_5596# sg13cmos5l_inv_1_7.Y a_14202_5410# VGND.t963 sg13_lv_nmos ad=0.1628p pd=1.18u as=0.3367p ps=1.65u w=0.74u l=0.13u
X1475 VPWR sg13cmos5l_buf_1_10.X a_10139_5448# VPWR sg13_lv_pmos ad=0.253p pd=1.53u as=0.2856p ps=2.36u w=0.84u l=0.13u
X1476 VPWR sg13cmos5l_inv_1_111.Y sg13cmos5l_inv_1_113.A VPWR sg13_lv_pmos ad=0.3808p pd=2.92u as=0.3808p ps=2.92u w=1.12u l=0.13u
X1477 a_5687_4285# sg13cmos5l_dfrbp_1_2.RESET_B.t5 VPWR VPWR sg13_lv_pmos ad=79.8f pd=0.8u as=0.36237p ps=2.605u w=0.42u l=0.13u
X1478 a_4510_6558# a_4199_6558# a_4436_6558# VGND.t741 sg13_lv_nmos ad=0.1472p pd=1.1u as=76.8f ps=0.88u w=0.64u l=0.13u
X1479 a_5469_10240# sg13cmos5l_buf_1_4.A VPWR VPWR sg13_lv_pmos ad=0.3325p pd=1.665u as=0.253p ps=1.53u w=1u l=0.13u
X1480 VGND.t54 sg13cmos5l_inv_1_88.A sg13cmos5l_mux2_1_6.A1 VGND.t636 sg13_lv_nmos ad=0.2516p pd=2.16u as=0.2516p ps=2.16u w=0.74u l=0.13u
X1481 VPWR VGND.t538 VPWR VPWR sg13_lv_pmos ad=0.34p pd=2.68u as=0 ps=0 w=1u l=1u
X1482 VPWR VGND.t262 VPWR VPWR sg13_lv_pmos ad=0.19p pd=1.38u as=0 ps=0 w=1u l=1u
X1483 a_6197_4656# sg13cmos5l_nand2_1_0.Y VPWR VPWR sg13_lv_pmos ad=0.2128p pd=1.5u as=0.2128p ps=1.5u w=1.12u l=0.13u
X1484 a_6662_3582# sg13cmos5l_nand3b_1_0.C VPWR VPWR sg13_lv_pmos ad=79.8f pd=0.8u as=0.1428p ps=1.52u w=0.42u l=0.13u
X1485 VGND.t254 VPWR VGND.t254 VGND.t255 sg13_lv_nmos ad=79.8f pd=0.8u as=0 ps=0 w=0.42u l=1u
X1486 VGND.t147 VPWR VGND.t147 VGND.t51 sg13_lv_nmos ad=79.8f pd=0.8u as=0 ps=0 w=0.42u l=1u
X1487 VPWR VGND.t377 VPWR VPWR sg13_lv_pmos ad=0.34p pd=2.68u as=0 ps=0 w=1u l=1u
X1488 VGND.t686 sg13cmos5l_inv_1_96.A sg13cmos5l_inv_1_116.A VGND.t866 sg13_lv_nmos ad=0.2516p pd=2.16u as=0.2516p ps=2.16u w=0.74u l=0.13u
X1489 a_1918_8434# sg13cmos5l_inv_1_68.A a_1821_8434# VGND.t42 sg13_lv_nmos ad=0.1628p pd=1.18u as=0.13135p ps=1.095u w=0.74u l=0.13u
X1490 VPWR VGND.t12 VPWR VPWR sg13_lv_pmos ad=0.19p pd=1.38u as=0 ps=0 w=1u l=1u
X1491 sg13cmos5l_nand2b_1_2.Y a_11067_6960# a_11269_6922# VGND.t922 sg13_lv_nmos ad=0.333p pd=2.38u as=0.1406p ps=1.12u w=0.74u l=0.13u
X1492 VGND.t402 VPWR VGND.t402 VGND.t19 sg13_lv_nmos ad=0.1428p pd=1.52u as=0 ps=0 w=0.42u l=1u
X1493 VGND.t420 VPWR VGND.t420 VGND.t19 sg13_lv_nmos ad=0.1428p pd=1.52u as=0 ps=0 w=0.42u l=1u
X1494 sg13cmos5l_inv_1_138.Y sg13cmos5l_inv_1_119.Y VPWR VPWR sg13_lv_pmos ad=0.3808p pd=2.92u as=0.3808p ps=2.92u w=1.12u l=0.13u
X1495 VGND.t499 VPWR VGND.t498 VGND.t497 sg13_lv_nmos ad=0.1428p pd=1.52u as=0 ps=0 w=0.42u l=1u
X1496 VPWR VGND.t420 VPWR VPWR sg13_lv_pmos ad=0.34p pd=2.68u as=0 ps=0 w=1u l=1u
X1497 VPWR VGND.t336 VPWR VPWR sg13_lv_pmos ad=0.34p pd=2.68u as=0 ps=0 w=1u l=1u
X1498 VGND.t208 sg13cmos5l_mux2_1_0.X a_11620_6558# VGND.t732 sg13_lv_nmos ad=0.1824p pd=1.21u as=80f ps=0.89u w=0.64u l=0.13u
X1499 sg13cmos5l_mux4_1_3.A1 sg13cmos5l_inv_1_106.Y a_11544_9172# VPWR sg13_lv_pmos ad=0.2128p pd=1.5u as=0.2128p ps=1.5u w=1.12u l=0.15u
X1500 VGND.t258 VPWR VGND.t262 VGND.t261 sg13_lv_nmos ad=79.8f pd=0.8u as=0 ps=0 w=0.42u l=1u
X1501 a_11371_6137# sg13cmos5l_mux4_1_0.S0 VPWR VPWR sg13_lv_pmos ad=0.34p pd=2.68u as=0.22315p ps=1.555u w=1u l=0.13u
X1502 VPWR VGND.t12 VPWR VPWR sg13_lv_pmos ad=0.19p pd=1.38u as=0 ps=0 w=1u l=1u
X1503 VGND.t138 VPWR VGND.t139 VGND.t55 sg13_lv_nmos ad=79.8f pd=0.8u as=0 ps=0 w=0.42u l=1u
X1504 VPWR sg13cmos5l_inv_1_57.A sg13cmos5l_inv_1_45.A VPWR sg13_lv_pmos ad=0.3808p pd=2.92u as=0.3808p ps=2.92u w=1.12u l=0.13u
X1505 VGND.t412 VPWR VGND.t412 VGND.t19 sg13_lv_nmos ad=0.1428p pd=1.52u as=0 ps=0 w=0.42u l=1u
X1506 VPWR VGND.t18 VPWR VPWR sg13_lv_pmos ad=0.34p pd=2.68u as=0 ps=0 w=1u l=1u
X1507 VPWR VGND.t597 VPWR VPWR sg13_lv_pmos ad=0.34p pd=2.68u as=0 ps=0 w=1u l=1u
X1508 VGND.t519 VPWR VGND.t521 VGND.t520 sg13_lv_nmos ad=79.8f pd=0.8u as=0 ps=0 w=0.42u l=1u
X1509 VGND.t294 VPWR VGND.t22 VGND.t293 sg13_lv_nmos ad=79.8f pd=0.8u as=0 ps=0 w=0.42u l=1u
X1510 sg13cmos5l_inv_1_11.A sg13cmos5l_inv_1_118.Y VPWR VPWR sg13_lv_pmos ad=0.3808p pd=2.92u as=0.3808p ps=2.92u w=1.12u l=0.13u
X1511 VPWR VGND.t201 VPWR VPWR sg13_lv_pmos ad=0.19p pd=1.38u as=0 ps=0 w=1u l=1u
X1512 VPWR VGND.t139 VPWR VPWR sg13_lv_pmos ad=0.34p pd=2.68u as=0 ps=0 w=1u l=1u
X1513 VPWR sg13cmos5l_buf_1_4.A a_3016_6168# VPWR sg13_lv_pmos ad=0.2114p pd=1.54u as=0.2856p ps=2.36u w=0.84u l=0.13u
X1514 sg13cmos5l_inv_1_15.Y sg13cmos5l_inv_1_16.Y VGND.t627 VGND.t734 sg13_lv_nmos ad=0.2516p pd=2.16u as=0.2516p ps=2.16u w=0.74u l=0.13u
X1515 VPWR ffsel[0] a_808_1632# VPWR sg13_lv_pmos ad=0.2114p pd=1.54u as=0.2856p ps=2.36u w=0.84u l=0.13u
X1516 VPWR VGND.t155 VPWR VPWR sg13_lv_pmos ad=0.19p pd=1.38u as=0 ps=0 w=1u l=1u
X1517 VPWR VGND.t258 VPWR VPWR sg13_lv_pmos ad=0.19p pd=1.38u as=0 ps=0 w=1u l=1u
X1518 VPWR a_1595_8472# a_2095_8728# VPWR sg13_lv_pmos ad=0.2198p pd=1.52u as=0.2975p ps=1.595u w=1u l=0.13u
X1519 a_7362_4192# sg13cmos5l_buf_1_1.X a_7260_4192# VPWR sg13_lv_pmos ad=0.2128p pd=1.5u as=0.2128p ps=1.5u w=1.12u l=0.13u
X1520 VPWR VGND.t49 VPWR VPWR sg13_lv_pmos ad=0.19p pd=1.38u as=0 ps=0 w=1u l=1u
X1521 VPWR sg13cmos5l_buf_1_10.X a_11420_7660# VPWR sg13_lv_pmos ad=0.3808p pd=2.92u as=0.2128p ps=1.5u w=1.12u l=0.15u
X1522 VGND.t56 sg13cmos5l_inv_1_111.Y sg13cmos5l_inv_1_113.A VGND.t51 sg13_lv_nmos ad=0.2516p pd=2.16u as=0.2516p ps=2.16u w=0.74u l=0.13u
X1523 a_11736_4918# sg13cmos5l_mux2_1_0.S VPWR VPWR sg13_lv_pmos ad=0.2856p pd=2.36u as=0.253p ps=1.53u w=0.84u l=0.13u
X1524 sg13cmos5l_inv_1_60.A sg13cmos5l_inv_1_75.Y VPWR VPWR sg13_lv_pmos ad=0.3808p pd=2.92u as=0.3808p ps=2.92u w=1.12u l=0.13u
X1525 VPWR VGND.t5 VPWR VPWR sg13_lv_pmos ad=0.34p pd=2.68u as=0 ps=0 w=1u l=1u
X1526 VGND.t350 VPWR VGND.t300 VGND.t21 sg13_lv_nmos ad=79.8f pd=0.8u as=0 ps=0 w=0.42u l=1u
X1527 VGND.t10 sg13cmos5l_buf_1_10.X a_10139_5448# VGND.t930 sg13_lv_nmos ad=0.18945p pd=1.27u as=0.187p ps=1.78u w=0.55u l=0.13u
X1528 sg13cmos5l_inv_1_3.Y sg13cmos5l_inv_1_6.Y VGND.t58 VGND.t916 sg13_lv_nmos ad=0.2516p pd=2.16u as=0.2516p ps=2.16u w=0.74u l=0.13u
X1529 VPWR VGND.t382 VPWR VPWR sg13_lv_pmos ad=0.34p pd=2.68u as=0 ps=0 w=1u l=1u
X1530 VGND.t603 VPWR VGND.t605 VGND.t604 sg13_lv_nmos ad=79.8f pd=0.8u as=0 ps=0 w=0.42u l=1u
X1531 VGND.t402 VPWR VGND.t402 VGND.t19 sg13_lv_nmos ad=0.1428p pd=1.52u as=0 ps=0 w=0.42u l=1u
X1532 a_14202_6538# a_14136_6430# VGND.t54 VGND.t679 sg13_lv_nmos ad=0.3367p pd=1.65u as=0.148p ps=1.14u w=0.74u l=0.13u
X1533 sg13cmos5l_inv_1_36.A sg13cmos5l_inv_1_68.Y VGND.t14 VGND.t13 sg13_lv_nmos ad=0.2516p pd=2.16u as=0.2516p ps=2.16u w=0.74u l=0.13u
X1534 VGND.t622 sg13cmos5l_inv_1_37.A sg13cmos5l_inv_1_37.Y VGND.t621 sg13_lv_nmos ad=0.2516p pd=2.16u as=0.2516p ps=2.16u w=0.74u l=0.13u
X1535 VPWR a_10139_5448# a_10639_5704# VPWR sg13_lv_pmos ad=0.2198p pd=1.52u as=0.2975p ps=1.595u w=1u l=0.13u
X1536 VPWR ffsel[1] a_808_2420# VPWR sg13_lv_pmos ad=0.2114p pd=1.54u as=0.2856p ps=2.36u w=0.84u l=0.13u
X1537 VPWR VGND.t420 VPWR VPWR sg13_lv_pmos ad=0.34p pd=2.68u as=0 ps=0 w=1u l=1u
X1538 a_4687_4680# sg13cmos5l_dfrbp_1_0.D a_4510_5026# VPWR sg13_lv_pmos ad=0.2975p pd=1.595u as=0.2225p ps=1.445u w=1u l=0.13u
X1539 VPWR VGND.t22 VPWR VPWR sg13_lv_pmos ad=0.19p pd=1.38u as=0 ps=0 w=1u l=1u
X1540 VGND.t262 VPWR VGND.t262 VGND.t264 sg13_lv_nmos ad=79.8f pd=0.8u as=0 ps=0 w=0.42u l=1u
X1541 VGND.t162 VPWR VGND.t161 VGND.t160 sg13_lv_nmos ad=0.1428p pd=1.52u as=0 ps=0 w=0.42u l=1u
X1542 VPWR VGND.t147 VPWR VPWR sg13_lv_pmos ad=0.19p pd=1.38u as=0 ps=0 w=1u l=1u
X1543 VGND.t164 sg13cmos5l_nand2_1_1.B sg13cmos5l_a221oi_1_0.C1 VGND.t970 sg13_lv_nmos ad=0.1463p pd=1.15u as=0.1694p ps=1.21u w=0.77u l=0.13u
X1544 VPWR VGND.t12 VPWR VPWR sg13_lv_pmos ad=0.19p pd=1.38u as=0 ps=0 w=1u l=1u
X1545 sg13cmos5l_inv_1_103.A sg13cmos5l_inv_1_104.Y VPWR VPWR sg13_lv_pmos ad=0.3808p pd=2.92u as=0.3808p ps=2.92u w=1.12u l=0.13u
X1546 VGND.t1 VPWR VGND.t1 VGND.t204 sg13_lv_nmos ad=0.1428p pd=1.52u as=0 ps=0 w=0.42u l=1u
X1547 VPWR sg13cmos5l_a221oi_1_0.A2 a_6676_7216# VPWR sg13_lv_pmos ad=0.3808p pd=2.92u as=0.2128p ps=1.5u w=1.12u l=0.13u
X1548 a_13917_9462# sg13cmos5l_inv_1_107.Y VPWR VPWR sg13_lv_pmos ad=0.2856p pd=2.36u as=0.2198p ps=1.53u w=0.84u l=0.13u
X1549 VPWR sg13cmos5l_inv_1_64.Y sg13cmos5l_inv_1_58.A VPWR sg13_lv_pmos ad=0.3808p pd=2.92u as=0.3808p ps=2.92u w=1.12u l=0.13u
X1550 a_14202_5704# a_14136_5600# VPWR VPWR sg13_lv_pmos ad=0.2975p pd=1.595u as=0.2198p ps=1.52u w=1u l=0.13u
X1551 VPWR sg13cmos5l_dfrbp_1_2.D a_4991_4164# VPWR sg13_lv_pmos ad=7.22485p pd=47.9u as=0.4088p ps=2.97u w=1.12u l=0.13u
X1552 VPWR VGND.t568 VPWR VPWR sg13_lv_pmos ad=0.34p pd=2.68u as=0 ps=0 w=1u l=1u
X1553 VGND.t23 VPWR VGND.t297 VGND.t293 sg13_lv_nmos ad=79.8f pd=0.8u as=0 ps=0 w=0.42u l=1u
X1554 a_4839_4112# a_4991_4164# VGND.t21 VGND.t690 sg13_lv_nmos ad=0.2516p pd=2.16u as=5.21338p ps=34.275u w=0.74u l=0.13u
X1555 VPWR sg13cmos5l_nor4_1_0.Y a_6849_4656# VPWR sg13_lv_pmos ad=0.19p pd=1.38u as=0.34p ps=2.68u w=1u l=0.13u
X1556 VPWR VGND.t139 VPWR VPWR sg13_lv_pmos ad=0.34p pd=2.68u as=0 ps=0 w=1u l=1u
X1557 VPWR VGND.t262 VPWR VPWR sg13_lv_pmos ad=0.19p pd=1.38u as=0 ps=0 w=1u l=1u
X1558 VPWR a_10571_6132# sg13cmos5l_nor2_1_1.A VPWR sg13_lv_pmos ad=0.34367p pd=1.775u as=0.3808p ps=2.92u w=1.12u l=0.13u
X1559 a_5687_3191# a_4991_3115# a_5781_3191# VGND.t691 sg13_lv_nmos ad=0.1296p pd=1.52u as=79.8f ps=0.8u w=0.42u l=0.13u
X1560 VPWR VGND.t377 VPWR VPWR sg13_lv_pmos ad=0.34p pd=2.68u as=0 ps=0 w=1u l=1u
X1561 VGND.t147 VPWR VGND.t147 VGND.t55 sg13_lv_nmos ad=79.8f pd=0.8u as=0 ps=0 w=0.42u l=1u
X1562 VGND.t347 VPWR VGND.t297 VGND.t21 sg13_lv_nmos ad=0.1428p pd=1.52u as=0 ps=0 w=0.42u l=1u
X1563 VGND.t26 a_14030_5596# sg13cmos5l_mux4_1_2.A1 VGND.t34 sg13_lv_nmos ad=0.148p pd=1.14u as=0.4033p ps=2.57u w=0.74u l=0.13u
X1564 VPWR sg13cmos5l_inv_1_40.A sg13cmos5l_inv_1_70.A VPWR sg13_lv_pmos ad=0.3808p pd=2.92u as=0.3808p ps=2.92u w=1.12u l=0.13u
X1565 VGND.t302 VPWR VGND.t304 VGND.t21 sg13_lv_nmos ad=79.8f pd=0.8u as=0 ps=0 w=0.42u l=1u
X1566 a_11802_5026# a_11736_4918# VGND.t248 VGND.t859 sg13_lv_nmos ad=0.3367p pd=1.65u as=0.148p ps=1.14u w=0.74u l=0.13u
X1567 VGND.t335 VPWR VGND.t336 VGND.t293 sg13_lv_nmos ad=79.8f pd=0.8u as=0 ps=0 w=0.42u l=1u
X1568 VPWR VGND.t54 VPWR VPWR sg13_lv_pmos ad=0.19p pd=1.38u as=0 ps=0 w=1u l=1u
X1569 a_5878_8434# sg13cmos5l_mux4_1_0.S0 a_5797_8701# VPWR sg13_lv_pmos ad=0.4425p pd=1.885u as=0.20762p ps=1.605u w=1u l=0.13u
X1570 VPWR VGND.t286 VPWR VPWR sg13_lv_pmos ad=0.34p pd=2.68u as=0 ps=0 w=1u l=1u
X1571 sg13cmos5l_inv_1_97.A sg13cmos5l_inv_1_98.Y VPWR VPWR sg13_lv_pmos ad=0.3808p pd=2.92u as=0.3808p ps=2.92u w=1.12u l=0.13u
X1572 VGND.t81 VPWR VGND.t72 VGND.t80 sg13_lv_nmos ad=0.1428p pd=1.52u as=0 ps=0 w=0.42u l=1u
X1573 sg13cmos5l_inv_1_36.A sg13cmos5l_inv_1_68.Y VPWR VPWR sg13_lv_pmos ad=0.3808p pd=2.92u as=0.3808p ps=2.92u w=1.12u l=0.13u
X1574 VGND.t147 VPWR VGND.t147 VGND.t51 sg13_lv_nmos ad=0.1428p pd=1.52u as=0 ps=0 w=0.42u l=1u
X1575 VPWR sg13cmos5l_inv_1_18.A sg13cmos5l_inv_1_18.Y VPWR sg13_lv_pmos ad=0.3808p pd=2.92u as=0.3808p ps=2.92u w=1.12u l=0.13u
X1576 VGND.t64 VPWR VGND.t64 VGND.t107 sg13_lv_nmos ad=0.1428p pd=1.52u as=0 ps=0 w=0.42u l=1u
X1577 VGND.t427 VPWR VGND.t427 VGND.t19 sg13_lv_nmos ad=0.1428p pd=1.52u as=0 ps=0 w=0.42u l=1u
X1578 VPWR VGND.t297 VPWR VPWR sg13_lv_pmos ad=0.19p pd=1.38u as=0 ps=0 w=1u l=1u
X1579 a_7020_5004# sg13cmos5l_nor2b_1_0.B_N a_6943_5004# VGND.t862 sg13_lv_nmos ad=0.1216p pd=1.02u as=81.6f ps=0.895u w=0.64u l=0.13u
X1580 VGND.t201 sg13cmos5l_o21ai_1_5.Y a_5151_6558# VGND.t799 sg13_lv_nmos ad=0.2176p pd=1.96u as=76.8f ps=0.88u w=0.64u l=0.13u
X1581 VGND.t52 sg13cmos5l_buf_1_2.X a_10151_8434# VGND.t174 sg13_lv_nmos ad=0.1872p pd=1.225u as=0.2176p ps=1.96u w=0.64u l=0.13u
X1582 VGND.t12 VPWR VGND.t12 VGND.t239 sg13_lv_nmos ad=79.8f pd=0.8u as=0 ps=0 w=0.42u l=1u
X1583 VPWR VGND.t26 VPWR VPWR sg13_lv_pmos ad=0.19p pd=1.38u as=0 ps=0 w=1u l=1u
X1584 VGND.t608 VPWR VGND.t610 VGND.t609 sg13_lv_nmos ad=79.8f pd=0.8u as=0 ps=0 w=0.42u l=1u
X1585 VGND.t52 sg13cmos5l_o21ai_1_4.Y a_11103_8434# VGND.t55 sg13_lv_nmos ad=0.2176p pd=1.96u as=76.8f ps=0.88u w=0.64u l=0.13u
X1586 VPWR sg13cmos5l_o21ai_1_0.A1 a_4283_9248# VPWR sg13_lv_pmos ad=0.253p pd=1.53u as=0.2856p ps=2.36u w=0.84u l=0.13u
X1587 VGND.t326 VPWR VGND.t327 VGND.t293 sg13_lv_nmos ad=79.8f pd=0.8u as=0 ps=0 w=0.42u l=1u
X1588 VGND.t310 VPWR VGND.t309 VGND.t21 sg13_lv_nmos ad=0.1428p pd=1.52u as=0 ps=0 w=0.42u l=1u
X1589 VPWR a_4187_4712# a_4687_4680# VPWR sg13_lv_pmos ad=0.2198p pd=1.52u as=0.2975p ps=1.595u w=1u l=0.13u
X1590 VPWR sg13cmos5l_inv_1_18.Y sg13cmos5l_inv_1_16.Y VPWR sg13_lv_pmos ad=0.3808p pd=2.92u as=0.3808p ps=2.92u w=1.12u l=0.13u
X1591 a_11189_8747# a_10151_8434# a_10966_8434# VPWR sg13_lv_pmos ad=0.135p pd=1.27u as=0.4425p ps=1.885u w=1u l=0.13u
X1592 VPWR sg13cmos5l_o21ai_1_0.B1 sg13cmos5l_o21ai_1_0.Y VPWR sg13_lv_pmos ad=0.3808p pd=2.92u as=0.2128p ps=1.5u w=1.12u l=0.15u
X1593 sg13cmos5l_nand3b_1_0.C a_8207_3505# VPWR VPWR sg13_lv_pmos ad=0.4312p pd=3.01u as=0.2639p ps=1.81u w=1.12u l=0.13u
X1594 VGND.t23 VPWR VGND.t296 VGND.t293 sg13_lv_nmos ad=0.1428p pd=1.52u as=0 ps=0 w=0.42u l=1u
X1595 VPWR VGND.t262 VPWR VPWR sg13_lv_pmos ad=0.19p pd=1.38u as=0 ps=0 w=1u l=1u
X1596 VPWR VGND.t145 VPWR VPWR sg13_lv_pmos ad=0.19p pd=1.38u as=0 ps=0 w=1u l=1u
X1597 VPWR sg13cmos5l_inv_1_95.A sg13cmos5l_inv_1_94.A VPWR sg13_lv_pmos ad=0.3808p pd=2.92u as=0.3808p ps=2.92u w=1.12u l=0.13u
X1598 VGND.t97 VPWR VGND.t97 VGND.t123 sg13_lv_nmos ad=0.1428p pd=1.52u as=0 ps=0 w=0.42u l=1u
X1599 a_11446_9570# sg13cmos5l_inv_1_106.Y VGND.t81 VGND.t952 sg13_lv_nmos ad=0.1406p pd=1.12u as=0.1406p ps=1.12u w=0.74u l=0.15u
X1600 VPWR VGND.t336 VPWR VPWR sg13_lv_pmos ad=0.19p pd=1.38u as=0 ps=0 w=1u l=1u
X1601 VPWR sg13cmos5l_inv_1_14.A sg13cmos5l_inv_1_17.A VPWR sg13_lv_pmos ad=0.3808p pd=2.92u as=0.3808p ps=2.92u w=1.12u l=0.13u
X1602 VGND.t38 sg13cmos5l_inv_1_30.A sg13cmos5l_inv_1_30.Y VGND.t836 sg13_lv_nmos ad=0.2516p pd=2.16u as=0.2516p ps=2.16u w=0.74u l=0.13u
X1603 sg13cmos5l_buf_1_2.X a_808_3932# VPWR VPWR sg13_lv_pmos ad=0.42p pd=2.99u as=0.2114p ps=1.54u w=1.12u l=0.13u
X1604 VPWR VGND.t291 VPWR VPWR sg13_lv_pmos ad=0.34p pd=2.68u as=0 ps=0 w=1u l=1u
X1605 VPWR sg13cmos5l_a21o_1_0.X a_18856_6168# VPWR sg13_lv_pmos ad=0.2114p pd=1.54u as=0.2856p ps=2.36u w=0.84u l=0.13u
X1606 sg13cmos5l_a221oi_1_0.B1 a_11457_8476# VPWR VPWR sg13_lv_pmos ad=0.3808p pd=2.92u as=0.34367p ps=1.775u w=1.12u l=0.13u
X1607 sg13cmos5l_inv_1_22.Y sg13cmos5l_dfrbp_1_2.RESET_B VPWR VPWR sg13_lv_pmos ad=0.3808p pd=2.92u as=0.3808p ps=2.92u w=1.12u l=0.13u
X1608 VPWR sg13cmos5l_inv_1_38.A sg13cmos5l_inv_1_39.A VPWR sg13_lv_pmos ad=0.3808p pd=2.92u as=0.3808p ps=2.92u w=1.12u l=0.13u
X1609 VGND.t519 VPWR VGND.t518 VGND.t517 sg13_lv_nmos ad=0.1428p pd=1.52u as=0 ps=0 w=0.42u l=1u
X1610 sg13cmos5l_inv_1_82.A sg13cmos5l_inv_1_85.A VGND.t216 VGND.t656 sg13_lv_nmos ad=0.2516p pd=2.16u as=0.2516p ps=2.16u w=0.74u l=0.13u
X1611 VPWR sg13cmos5l_mux2_1_8.X a_12019_6219# VPWR sg13_lv_pmos ad=0.22315p pd=1.555u as=0.415p ps=1.83u w=1u l=0.13u
X1612 a_6922_3112# a_7365_3155# a_7305_3191# VPWR sg13_lv_pmos ad=79.8f pd=0.8u as=63f ps=0.72u w=0.42u l=0.13u
X1613 VGND.t58 sg13cmos5l_mux2_1_0.S a_12124_5026# VGND.t897 sg13_lv_nmos ad=0.18945p pd=1.27u as=0.13135p ps=1.095u w=0.74u l=0.13u
X1614 VPWR VGND.t216 VPWR VPWR sg13_lv_pmos ad=0.19p pd=1.38u as=0 ps=0 w=1u l=1u
X1615 VPWR VGND.t327 VPWR VPWR sg13_lv_pmos ad=0.19p pd=1.38u as=0 ps=0 w=1u l=1u
X1616 a_11317_6173# sg13cmos5l_mux4_1_2.A3 VPWR VPWR sg13_lv_pmos ad=0.135p pd=1.27u as=0.34p ps=2.68u w=1u l=0.13u
X1617 VGND.t302 VPWR VGND.t352 VGND.t21 sg13_lv_nmos ad=0.1428p pd=1.52u as=0 ps=0 w=0.42u l=1u
X1618 VPWR VGND.t147 VPWR VPWR sg13_lv_pmos ad=0.34p pd=2.68u as=0 ps=0 w=1u l=1u
X1619 sg13cmos5l_o21ai_1_6.A2 sg13cmos5l_inv_1_56.Y VGND.t72 VGND.t824 sg13_lv_nmos ad=0.2516p pd=2.16u as=0.2516p ps=2.16u w=0.74u l=0.13u
X1620 sg13cmos5l_a21o_1_0.X a_7020_5004# VGND.t641 VGND.t975 sg13_lv_nmos ad=0.2351p pd=2.16u as=0.15745p ps=1.175u w=0.74u l=0.13u
X1621 VGND.t201 sg13cmos5l_o21ai_1_7.Y a_4628_6558# VGND.t635 sg13_lv_nmos ad=0.1824p pd=1.21u as=0.2304p ps=1.36u w=0.64u l=0.13u
X1622 VPWR VGND.t269 VPWR VPWR sg13_lv_pmos ad=0.34p pd=2.68u as=0 ps=0 w=1u l=1u
X1623 VGND.t54 sg13cmos5l_inv_1_87.Y sg13cmos5l_inv_1_88.A VGND.t658 sg13_lv_nmos ad=0.2516p pd=2.16u as=0.2516p ps=2.16u w=0.74u l=0.13u
X1624 VGND.t539 VPWR VGND.t541 VGND.t540 sg13_lv_nmos ad=79.8f pd=0.8u as=0 ps=0 w=0.42u l=1u
X1625 VPWR VGND.t258 VPWR VPWR sg13_lv_pmos ad=0.19p pd=1.38u as=0 ps=0 w=1u l=1u
X1626 sg13cmos5l_inv_1_27.Y sg13cmos5l_inv_1_28.Y VPWR VPWR sg13_lv_pmos ad=0.3808p pd=2.92u as=0.3808p ps=2.92u w=1.12u l=0.13u
X1627 sg13cmos5l_nand3b_1_0.C a_8207_3505# VGND.t22 VGND.t21 sg13_lv_nmos ad=0.2849p pd=2.25u as=0.2516p ps=2.16u w=0.74u l=0.13u
X1628 sg13cmos5l_inv_1_127.Y sg13cmos5l_inv_1_126.Y VGND.t270 VGND.t671 sg13_lv_nmos ad=0.2516p pd=2.16u as=0.2516p ps=2.16u w=0.74u l=0.13u
X1629 VPWR VGND.t296 VPWR VPWR sg13_lv_pmos ad=0.34p pd=2.68u as=0 ps=0 w=1u l=1u
X1630 VPWR a_4283_9248# a_4783_9216# VPWR sg13_lv_pmos ad=0.2198p pd=1.52u as=0.2975p ps=1.595u w=1u l=0.13u
X1631 VGND.t20 ffsel[0] a_808_1632# VGND.t19 sg13_lv_nmos ad=0.14875p pd=1.16u as=0.187p ps=1.78u w=0.55u l=0.13u
X1632 VGND.t329 VPWR VGND.t330 VGND.t293 sg13_lv_nmos ad=79.8f pd=0.8u as=0 ps=0 w=0.42u l=1u
X1633 VPWR VGND.t132 VPWR VPWR sg13_lv_pmos ad=0.34p pd=2.68u as=0 ps=0 w=1u l=1u
X1634 VGND.t313 VPWR VGND.t312 VGND.t21 sg13_lv_nmos ad=0.1428p pd=1.52u as=0 ps=0 w=0.42u l=1u
X1635 a_7020_5004# sg13cmos5l_a21oi_1_0.Y a_6849_4656# VPWR sg13_lv_pmos ad=0.35p pd=2.7u as=0.2125p ps=1.425u w=1u l=0.13u
X1636 VGND.t420 VPWR VGND.t420 VGND.t19 sg13_lv_nmos ad=79.8f pd=0.8u as=0 ps=0 w=0.42u l=1u
X1637 VPWR VGND.t254 VPWR VPWR sg13_lv_pmos ad=0.34p pd=2.68u as=0 ps=0 w=1u l=1u
X1638 VGND.t58 VPWR VGND.t58 VGND.t250 sg13_lv_nmos ad=0.1428p pd=1.52u as=0 ps=0 w=0.42u l=1u
X1639 a_13999_8050# a_13917_7950# sg13cmos5l_o21ai_1_3.B1 VGND.t51 sg13_lv_nmos ad=0.1406p pd=1.12u as=0.333p ps=2.38u w=0.74u l=0.13u
X1640 VGND.t64 sg13cmos5l_inv_1_72.Y sg13cmos5l_inv_1_51.Y VGND.t954 sg13_lv_nmos ad=0.2516p pd=2.16u as=0.2516p ps=2.16u w=0.74u l=0.13u
X1641 VGND.t145 VPWR VGND.t145 VGND.t51 sg13_lv_nmos ad=0.1428p pd=1.52u as=0 ps=0 w=0.42u l=1u
X1642 VGND.t30 sg13cmos5l_dfrbp_1_2.RESET_B.t2 a_6756_3582# VGND.t820 sg13_lv_nmos ad=0.1626p pd=1.415u as=60.89999f ps=0.71u w=0.42u l=0.13u
X1643 VPWR VGND.t12 VPWR VPWR sg13_lv_pmos ad=0.34p pd=2.68u as=0 ps=0 w=1u l=1u
X1644 VGND.t12 VPWR VGND.t12 VGND.t219 sg13_lv_nmos ad=0.1428p pd=1.52u as=0 ps=0 w=0.42u l=1u
X1645 a_4210_6914# sg13cmos5l_o21ai_1_0.A1 VGND.t199 VGND.t805 sg13_lv_nmos ad=0.2516p pd=2.16u as=0.1406p ps=1.12u w=0.74u l=0.15u
X1646 a_5566_9946# sg13cmos5l_inv_1_45.A a_5469_10240# VPWR sg13_lv_pmos ad=0.2225p pd=1.445u as=0.3325p ps=1.665u w=1u l=0.13u
X1647 VPWR sg13cmos5l_inv_1_34.Y sg13cmos5l_inv_1_76.A VPWR sg13_lv_pmos ad=0.3808p pd=2.92u as=0.3808p ps=2.92u w=1.12u l=0.13u
X1648 VGND.t588 VPWR VGND.t587 VGND.t586 sg13_lv_nmos ad=0.1428p pd=1.52u as=0 ps=0 w=0.42u l=1u
X1649 sg13cmos5l_inv_1_7.Y sg13cmos5l_inv_1_9.Y VPWR VPWR sg13_lv_pmos ad=0.3808p pd=2.92u as=0.3808p ps=2.92u w=1.12u l=0.13u
X1650 VPWR VGND.t92 VPWR VPWR sg13_lv_pmos ad=0.34p pd=2.68u as=0 ps=0 w=1u l=1u
X1651 VPWR VGND.t318 VPWR VPWR sg13_lv_pmos ad=0.19p pd=1.38u as=0 ps=0 w=1u l=1u
X1652 VPWR VGND.t56 VPWR VPWR sg13_lv_pmos ad=0.34p pd=2.68u as=0 ps=0 w=1u l=1u
X1653 a_6366_2390# sg13cmos5l_nand3b_1_0.C VGND.t386 VGND.t19 sg13_lv_nmos ad=0.1406p pd=1.12u as=0.18575p ps=1.26u w=0.74u l=0.13u
X1654 VGND.t394 VPWR VGND.t394 VGND.t19 sg13_lv_nmos ad=79.8f pd=0.8u as=0 ps=0 w=0.42u l=1u
X1655 a_12093_9462# sg13cmos5l_nand2b_1_4.A_N VPWR VPWR sg13_lv_pmos ad=0.2856p pd=2.36u as=0.2198p ps=1.53u w=0.84u l=0.13u
X1656 VPWR sg13cmos5l_inv_1_43.A sg13cmos5l_inv_1_42.A VPWR sg13_lv_pmos ad=0.3808p pd=2.92u as=0.3808p ps=2.92u w=1.12u l=0.13u
X1657 VPWR VGND.t132 VPWR VPWR sg13_lv_pmos ad=0.34p pd=2.68u as=0 ps=0 w=1u l=1u
R0 VGND.n380 VGND.n379 1.21534e+06
R1 VGND.t21 VGND.n262 6300
R2 VGND.n377 VGND.n262 6300
R3 VGND.n378 VGND.n377 6300
R4 VGND.n379 VGND.n378 6300
R5 VGND.t19 VGND.t21 3081.43
R6 VGND.n382 VGND.t21 6031.92
R7 VGND.n382 VGND.n381 6031.92
R8 VGND.n381 VGND.t55 6031.92
R9 VGND.t55 VGND.n380 6031.92
R10 VGND.n117 VGND.t495 183.805
R11 VGND.t510 VGND.n117 183.805
R12 VGND.n117 VGND.t515 183.806
R13 VGND.t530 VGND.n117 183.806
R14 VGND.t540 VGND.n117 183.805
R15 VGND.t557 VGND.n117 182.042
R16 VGND.n117 VGND.t565 183.805
R17 VGND.n117 VGND.t584 183.805
R18 VGND.t19 VGND.n117 3144.99
R19 VGND.t258 VGND.n382 427.779
R20 VGND.n185 VGND.t258 0.356983
R21 VGND.n380 VGND.n43 427.755
R22 VGND.n381 VGND.n49 427.132
R23 VGND.t941 VGND.n188 4.08161
R24 VGND.n281 VGND.t842 423.478
R25 VGND.n171 VGND.t12 16.1874
R26 VGND.n158 VGND.t0 11.5857
R27 VGND.n131 VGND.t700 12.367
R28 VGND.n163 VGND.t55 0.620139
R29 VGND.n43 VGND.n143 15.4357
R30 VGND.t748 VGND.n154 4.24424
R31 VGND.t258 VGND.n123 15.4357
R32 VGND.t957 VGND.n78 19.0607
R33 VGND.t258 VGND.n160 16.1874
R34 VGND.t721 VGND.n83 19.0607
R35 VGND.n106 VGND.n43 7.00082
R36 VGND.t953 VGND.n20 19.0607
R37 VGND.n143 VGND.t951 4.24424
R38 VGND.n117 VGND.t577 182.042
R39 VGND.n76 VGND.t901 422.846
R40 VGND.n88 VGND.t25 422.846
R41 VGND.t882 VGND.n82 422.846
R42 VGND.n81 VGND.t885 422.846
R43 VGND.n47 VGND.t836 422.846
R44 VGND.t920 VGND.n45 422.846
R45 VGND.n48 VGND.t6 422.846
R46 VGND.n275 VGND.t839 422.846
R47 VGND.n299 VGND.t41 422.846
R48 VGND.t704 VGND.n299 422.846
R49 VGND.t907 VGND.n301 422.846
R50 VGND.t696 VGND.n315 422.846
R51 VGND.n315 VGND.t629 422.846
R52 VGND.t656 VGND.n53 422.846
R53 VGND.n52 VGND.t665 422.846
R54 VGND.t668 VGND.n70 422.846
R55 VGND.t55 VGND.n119 15.4357
R56 VGND.n369 VGND.t873 422.846
R57 VGND.n6 VGND.t938 422.846
R58 VGND.n24 VGND.t870 422.846
R59 VGND.n43 VGND.t949 19.6259
R60 VGND.n103 VGND.n43 15.4357
R61 VGND.t824 VGND.n28 422.846
R62 VGND.t770 VGND.n29 423.127
R63 VGND.t645 VGND.n43 19.6268
R64 VGND.n31 VGND.t816 422.846
R65 VGND.t258 VGND.n113 15.8598
R66 VGND.n396 VGND.n262 411.43
R67 VGND.n85 VGND.t916 19.0601
R68 VGND.n377 VGND.n376 411.43
R69 VGND.n378 VGND.n250 411.43
R70 VGND.t955 VGND.n191 208.56
R71 VGND.n379 VGND.n207 411.43
R72 VGND.n43 VGND.t15 19.3829
R73 VGND.t258 VGND.t900 410.613
R74 VGND.n373 VGND.t790 410.104
R75 VGND.n125 VGND.t55 15.6959
R76 VGND.t754 VGND.n24 409.99
R77 VGND.n397 VGND.t726 407.144
R78 VGND.n397 VGND.t33 407.144
R79 VGND.t735 VGND.n395 407.144
R80 VGND.t800 VGND.n395 407.144
R81 VGND.n398 VGND.t886 407.144
R82 VGND.t827 VGND.n128 18.8704
R83 VGND.t847 VGND.n387 407.144
R84 VGND.t27 VGND.n146 71.2776
R85 VGND.t671 VGND.n147 413.861
R86 VGND.t858 VGND.n151 18.8696
R87 VGND.t688 VGND.n159 422.707
R88 VGND.n413 VGND.t657 407.144
R89 VGND.n408 VGND.t919 407.144
R90 VGND.n96 VGND.t25 19.849
R91 VGND.n268 VGND.t50 407.144
R92 VGND.t617 VGND.n126 18.8704
R93 VGND.n142 VGND.t695 18.9474
R94 VGND.n306 VGND.t702 407.144
R95 VGND.n309 VGND.t658 407.144
R96 VGND.n140 VGND.t213 242.707
R97 VGND.t2 VGND.n324 407.144
R98 VGND.t55 VGND.t169 109.638
R99 VGND.t822 VGND.n144 413.861
R100 VGND.n180 VGND.t753 18.8913
R101 VGND.n209 VGND.t954 18.8912
R102 VGND.t739 VGND.n348 407.144
R103 VGND.t966 VGND.n348 407.144
R104 VGND.n349 VGND.t746 407.144
R105 VGND.n349 VGND.t971 407.144
R106 VGND.t744 VGND.n347 407.144
R107 VGND.t660 VGND.n347 407.144
R108 VGND.t62 VGND.n44 18.8661
R109 VGND.t939 VGND.n344 407.144
R110 VGND.n120 VGND.t681 414.188
R111 VGND.t872 VGND.n121 18.8696
R112 VGND.n117 VGND.t517 182.042
R113 VGND.t522 VGND.n117 182.042
R114 VGND.t542 VGND.n117 182.042
R115 VGND.n117 VGND.t547 182.042
R116 VGND.n117 VGND.t567 182.042
R117 VGND.t586 VGND.n117 182.042
R118 VGND.t601 VGND.n117 182.042
R119 VGND.t611 VGND.n117 182.042
R120 VGND.t712 VGND.n152 18.7207
R121 VGND.t787 VGND.n150 406.135
R122 VGND.n334 VGND.t782 402.858
R123 VGND.n112 VGND.t908 53.8071
R124 VGND.n296 VGND.t778 398.572
R125 VGND.n401 VGND.t730 394.286
R126 VGND.n403 VGND.t846 394.286
R127 VGND.n160 VGND.t930 394.45
R128 VGND.t804 VGND.n44 409.849
R129 VGND.t798 VGND.n303 392.274
R130 VGND.n117 VGND.t485 183.804
R131 VGND.n117 VGND.t505 183.805
R132 VGND.n117 VGND.t535 183.805
R133 VGND.n117 VGND.t555 183.805
R134 VGND.t898 VGND.t677 390
R135 VGND.t53 VGND.t896 390
R136 VGND.t759 VGND.t687 390
R137 VGND.n2 VGND.t29 386.502
R138 VGND.n405 VGND.t948 385.714
R139 VGND.t61 VGND.n78 384.305
R140 VGND.t690 VGND.n5 57.341
R141 VGND.n331 VGND.t776 377.144
R142 VGND.t928 VGND.n132 112.825
R143 VGND.t637 VGND.n267 372.858
R144 VGND.n314 VGND.t903 372.858
R145 VGND.t762 VGND.n325 372.858
R146 VGND.n208 VGND.t662 46.0435
R147 VGND.t685 VGND.t866 368.572
R148 VGND.t937 VGND.n292 362.846
R149 VGND.t967 VGND.t670 360
R150 VGND.t21 VGND.t864 355.861
R151 VGND.t647 VGND.t856 355.714
R152 VGND.t27 VGND.n406 355.714
R153 VGND.t639 VGND.n298 355.714
R154 VGND.t12 VGND.n115 13.5664
R155 VGND.n206 VGND.t863 60.8157
R156 VGND.n290 VGND.t714 347.144
R157 VGND.n295 VGND.t728 347.144
R158 VGND.t736 VGND.n79 345.704
R159 VGND.t698 VGND.n282 343.24
R160 VGND.t732 VGND.n318 343.24
R161 VGND.n370 VGND.t940 343.24
R162 VGND.n363 VGND.t648 343.24
R163 VGND.n150 VGND.t935 65.9199
R164 VGND.t500 VGND.n117 183.806
R165 VGND.t520 VGND.n117 183.806
R166 VGND.t545 VGND.n117 183.806
R167 VGND.t550 VGND.n117 183.806
R168 VGND.t560 VGND.n117 183.806
R169 VGND.t570 VGND.n117 183.806
R170 VGND.n117 VGND.t580 183.806
R171 VGND.t599 VGND.n117 183.806
R172 VGND.t609 VGND.n117 183.806
R173 VGND.n404 VGND.t923 334.286
R174 VGND.n269 VGND.t840 334.286
R175 VGND.t769 VGND.t697 334.286
R176 VGND.n302 VGND.t922 334.286
R177 VGND.t764 VGND.n338 334.286
R178 VGND.t853 VGND.n393 330
R179 VGND.t626 VGND.n391 330
R180 VGND.t625 VGND.n390 330
R181 VGND.n411 VGND.t692 330
R182 VGND.n417 VGND.t926 330
R183 VGND.n420 VGND.t34 330
R184 VGND.t825 VGND.n264 330
R185 VGND.n276 VGND.t884 330
R186 VGND.t775 VGND.t786 330
R187 VGND.t722 VGND.n297 330
R188 VGND.n304 VGND.t876 330
R189 VGND.n322 VGND.t766 330
R190 VGND.t682 VGND.n328 330
R191 VGND.n353 VGND.t669 330
R192 VGND.t17 VGND.n111 16.8956
R193 VGND.n99 VGND.t834 72.5306
R194 VGND.t745 VGND.t659 330
R195 VGND.t12 VGND.n182 12.5837
R196 VGND.n157 VGND.t961 72.9582
R197 VGND.n259 VGND.t678 329.168
R198 VGND.n289 VGND.t835 325.714
R199 VGND.n149 VGND.t675 334.726
R200 VGND.n291 VGND.t969 321.43
R201 VGND.t777 VGND.n296 321.43
R202 VGND.t817 VGND.n156 64.595
R203 VGND.t634 VGND.n3 319.99
R204 VGND.n3 VGND.t724 319.99
R205 VGND.t614 VGND.n117 183.806
R206 VGND.n117 VGND.t606 182.042
R207 VGND.t604 VGND.n117 183.805
R208 VGND.n117 VGND.t596 182.042
R209 VGND.n117 VGND.t591 182.042
R210 VGND.t589 VGND.n117 183.806
R211 VGND.n117 VGND.t581 182.042
R212 VGND.n117 VGND.t572 182.042
R213 VGND.n117 VGND.t562 182.042
R214 VGND.n117 VGND.t552 182.042
R215 VGND.t537 VGND.n117 182.042
R216 VGND.n117 VGND.t532 182.042
R217 VGND.t527 VGND.n117 182.042
R218 VGND.t525 VGND.n117 183.805
R219 VGND.n117 VGND.t512 182.042
R220 VGND.t507 VGND.n117 182.042
R221 VGND.n117 VGND.t502 182.042
R222 VGND.t497 VGND.n117 182.042
R223 VGND.n117 VGND.t492 182.042
R224 VGND.t487 VGND.n117 182.042
R225 VGND.n117 VGND.t482 181.96
R226 VGND.t799 VGND.t795 317.144
R227 VGND.t620 VGND.n287 317.144
R228 VGND.n170 VGND.t861 78.8753
R229 VGND.t796 VGND.t960 317.144
R230 VGND.t773 VGND.n155 321.731
R231 VGND.n396 VGND.t928 312.858
R232 VGND.n418 VGND.t934 312.858
R233 VGND.n376 VGND.t37 312.858
R234 VGND.t11 VGND.n138 321.541
R235 VGND.t855 VGND.n250 312.858
R236 VGND.t716 VGND.n207 312.858
R237 VGND.t807 VGND.n266 308.572
R238 VGND.t894 VGND.n274 308.572
R239 VGND.n356 VGND.t891 308.572
R240 VGND.n357 VGND.t893 308.572
R241 VGND.t781 VGND.n155 83.0368
R242 VGND.t785 VGND.n286 307.132
R243 VGND.n74 VGND.t915 302.846
R244 VGND.n69 VGND.t772 302.846
R245 VGND.t752 VGND.n22 302.846
R246 VGND.t975 VGND.n205 86.188
R247 VGND.n332 VGND.t970 300
R248 VGND.n102 VGND.t680 86.49
R249 VGND.n277 VGND.t841 298.663
R250 VGND.n400 VGND.t832 287.144
R251 VGND.n118 VGND.t826 293.533
R252 VGND.n412 VGND.t631 287.144
R253 VGND.n418 VGND.t859 287.144
R254 VGND.n270 VGND.t8 287.144
R255 VGND.n305 VGND.t679 287.144
R256 VGND.n368 VGND.t818 287.144
R257 VGND.t45 VGND.n344 287.144
R258 VGND.t952 VGND.n341 287.144
R259 VGND.t857 VGND.t914 282.858
R260 VGND.n279 VGND.t741 280.832
R261 VGND.n282 VGND.t635 280.832
R262 VGND.n318 VGND.t715 280.832
R263 VGND.n317 VGND.t674 280.832
R264 VGND.t909 VGND.n365 280.832
R265 VGND.t814 VGND.n363 280.832
R266 VGND.t880 VGND.n256 275.072
R267 VGND.t897 VGND.n384 274.286
R268 VGND.n421 VGND.t899 274.286
R269 VGND.n326 VGND.t755 274.286
R270 VGND.n333 VGND.t874 274.286
R271 VGND.n351 VGND.t806 274.286
R272 VGND.n354 VGND.t758 274.286
R273 VGND.n101 VGND.t642 94.8677
R274 VGND.t950 VGND.n30 272.846
R275 VGND.t933 VGND.t619 270
R276 VGND.t918 VGND.n414 270
R277 VGND.n419 VGND.t720 270
R278 VGND.t24 VGND.n383 270
R279 VGND.t879 VGND.n307 270
R280 VGND.t895 VGND.t936 270
R281 VGND.t42 VGND.n323 270
R282 VGND.t747 VGND.t760 270
R283 VGND.t750 VGND.n320 270
R284 VGND.t749 VGND.n345 270
R285 VGND.t718 VGND.n342 270
R286 VGND.t803 VGND.t258 260.637
R287 VGND.n118 VGND.t258 9.96245
R288 VGND.t809 VGND.n48 259.99
R289 VGND.n20 VGND.t892 260.019
R290 VGND.t821 VGND.t676 258.334
R291 VGND.t958 VGND.n257 258.334
R292 VGND.t673 VGND.n319 254.087
R293 VGND.t768 VGND.n329 254.087
R294 VGND.t650 VGND.t801 252.857
R295 VGND.t815 VGND.t646 252.857
R296 VGND.n186 VGND.t277 99.5817
R297 VGND.t263 VGND.t258 108.999
R298 VGND.n29 VGND.t80 108.639
R299 VGND.t214 VGND.t12 108.957
R300 VGND.t170 VGND.n144 99.5776
R301 VGND.t258 VGND.n129 9.63482
R302 VGND.t258 VGND.n147 9.63482
R303 VGND.n127 VGND.t12 11.6992
R304 VGND.n133 VGND.t172 99.5774
R305 VGND.n109 VGND.n43 0.369499
R306 VGND.n409 VGND.t247 251.417
R307 VGND.t252 VGND.n85 251.447
R308 VGND.n51 VGND.t219 251.417
R309 VGND.n50 VGND.t238 251.417
R310 VGND.t221 VGND.n55 251.417
R311 VGND.t240 VGND.n56 251.417
R312 VGND.n62 VGND.t12 0.356799
R313 VGND.n70 VGND.t158 251.417
R314 VGND.t107 VGND.n6 251.417
R315 VGND.t112 VGND.n21 251.417
R316 VGND.n27 VGND.t74 251.417
R317 VGND.n30 VGND.t83 251.417
R318 VGND.n32 VGND.t88 251.417
R319 VGND.n33 VGND.t117 251.417
R320 VGND.t91 VGND.n17 251.417
R321 VGND.t119 VGND.n16 251.417
R322 VGND.n35 VGND.t94 251.417
R323 VGND.n36 VGND.t121 251.417
R324 VGND.t96 VGND.n14 251.417
R325 VGND.t123 VGND.n13 251.417
R326 VGND.n38 VGND.t99 251.417
R327 VGND.n39 VGND.t125 251.417
R328 VGND.t101 VGND.n11 251.417
R329 VGND.t127 VGND.n10 251.417
R330 VGND.n41 VGND.t105 251.417
R331 VGND.n166 VGND.t691 257.877
R332 VGND.t40 VGND.t707 251.351
R333 VGND.n260 VGND.t820 250.952
R334 VGND.t717 VGND.t21 249.643
R335 VGND.t705 VGND.n261 249.151
R336 VGND.t794 VGND.n279 245.172
R337 VGND.t200 VGND.n283 245.172
R338 VGND.t797 VGND.n317 245.172
R339 VGND.t653 VGND.n303 245.172
R340 VGND.n373 VGND.t812 245.172
R341 VGND.n371 VGND.t791 245.172
R342 VGND.n183 VGND.t905 260.308
R343 VGND.n133 VGND.t929 251.004
R344 VGND.t12 VGND.n175 9.30764
R345 VGND.t276 VGND.n187 100.888
R346 VGND.t259 VGND.t258 109.993
R347 VGND.t258 VGND.t261 109.992
R348 VGND.t258 VGND.n95 9.30721
R349 VGND.t258 VGND.n124 0.356968
R350 VGND.n142 VGND.t12 0.792095
R351 VGND.t133 VGND.n169 100.883
R352 VGND.n134 VGND.t55 9.30721
R353 VGND.n19 VGND.t85 109.639
R354 VGND.t82 VGND.n104 100.883
R355 VGND.n108 VGND.n43 9.30721
R356 VGND.n43 VGND.n120 9.30721
R357 VGND.n110 VGND.n43 11.3014
R358 VGND.n162 VGND.n43 0.356968
R359 VGND.n148 VGND.n43 9.30721
R360 VGND.n166 VGND.t59 93.3945
R361 VGND.n286 VGND.t202 242.846
R362 VGND.t218 VGND.n52 242.846
R363 VGND.n54 VGND.t220 242.846
R364 VGND.n55 VGND.t239 242.846
R365 VGND.t73 VGND.n26 242.846
R366 VGND.t113 VGND.n27 242.846
R367 VGND.n18 VGND.t90 242.846
R368 VGND.n17 VGND.t118 242.846
R369 VGND.t93 VGND.n34 242.846
R370 VGND.t120 VGND.n35 242.846
R371 VGND.n15 VGND.t95 242.846
R372 VGND.n14 VGND.t122 242.846
R373 VGND.t98 VGND.n37 242.846
R374 VGND.t124 VGND.n38 242.846
R375 VGND.n12 VGND.t100 242.846
R376 VGND.n11 VGND.t126 242.846
R377 VGND.t103 VGND.n40 242.846
R378 VGND.t128 VGND.n41 242.846
R379 VGND.t166 VGND.n370 236.256
R380 VGND.t275 VGND.n97 243.578
R381 VGND.t227 VGND.n291 235.714
R382 VGND.t236 VGND.n142 251.274
R383 VGND.t212 VGND.n141 251.278
R384 VGND.t217 VGND.n311 235.714
R385 VGND.t131 VGND.n321 235.714
R386 VGND.n191 VGND.t160 251.417
R387 VGND.t168 VGND.n149 101.781
R388 VGND.t71 VGND.n121 251.278
R389 VGND.t76 VGND.n107 105.331
R390 VGND.n106 VGND.t813 12.6791
R391 VGND.t888 VGND.t135 231.429
R392 VGND.t711 VGND.n388 227.143
R393 VGND.t249 VGND.n173 242.846
R394 VGND.n139 VGND.t215 102.475
R395 VGND.n200 VGND.t163 242.846
R396 VGND.n180 VGND.t171 242.706
R397 VGND.t851 VGND.t278 222.857
R398 VGND.t77 VGND.n105 100.675
R399 VGND.t79 VGND.n130 100.671
R400 VGND.t265 VGND.t258 111.032
R401 VGND.t12 VGND.t193 111.032
R402 VGND.n145 VGND.t12 96.0268
R403 VGND.n116 VGND.t12 96.0216
R404 VGND.t258 VGND.t244 111.02
R405 VGND.n114 VGND.t246 100.716
R406 VGND.t258 VGND.n98 96.0214
R407 VGND.t258 VGND.n97 8.48812
R408 VGND.n100 VGND.t203 102.703
R409 VGND.n158 VGND.t12 8.09421
R410 VGND.t109 VGND.n153 15.001
R411 VGND.t114 VGND.n107 107.358
R412 VGND.n43 VGND.t86 111.02
R413 VGND.n410 VGND.t272 221.417
R414 VGND.t272 VGND.n409 221.417
R415 VGND.t274 VGND.n84 221.417
R416 VGND.n301 VGND.t206 221.417
R417 VGND.t209 VGND.n61 221.417
R418 VGND.n42 VGND.t129 221.417
R419 VGND.n402 VGND.t632 218.571
R420 VGND.n414 VGND.t689 218.571
R421 VGND.t963 VGND.n383 218.571
R422 VGND.n307 VGND.t628 218.571
R423 VGND.t955 VGND.n320 218.571
R424 VGND.t47 VGND.n345 218.571
R425 VGND.t293 VGND.t738 214.9
R426 VGND.t740 VGND.t44 214.286
R427 VGND.t871 VGND.t972 214.286
R428 VGND.n362 VGND.t176 213.968
R429 VGND.t862 VGND.n388 210
R430 VGND.n86 VGND.t963 208.56
R431 VGND.n69 VGND.t740 208.56
R432 VGND.n22 VGND.t871 208.56
R433 VGND.t266 VGND.n129 212.431
R434 VGND.n95 VGND.t274 212.76
R435 VGND.t256 VGND.n97 102.703
R436 VGND.t860 VGND.t12 93.4981
R437 VGND.t226 VGND.n135 15.001
R438 VGND.n100 VGND.t620 102.15
R439 VGND.t206 VGND.n300 205.714
R440 VGND.n158 VGND.t232 102.934
R441 VGND.n175 VGND.t209 212.758
R442 VGND.t55 VGND.t130 111.034
R443 VGND.n350 VGND.t63 205.714
R444 VGND.t115 VGND.n339 205.714
R445 VGND.t129 VGND.n148 212.76
R446 VGND.n114 VGND.t889 9.35058
R447 VGND.n102 VGND.t862 206.345
R448 VGND.n131 VGND.t12 7.31297
R449 VGND.n139 VGND.t12 7.67043
R450 VGND.t251 VGND.t258 109.7
R451 VGND.t258 VGND.t264 109.993
R452 VGND.t198 VGND.n136 109.7
R453 VGND.t205 VGND.n122 102.457
R454 VGND.t234 VGND.t12 109.948
R455 VGND.n138 VGND.t224 102.457
R456 VGND.t68 VGND.n43 109.7
R457 VGND.n43 VGND.n105 9.31266
R458 VGND.n43 VGND.n130 9.32294
R459 VGND.t243 VGND.n124 109.639
R460 VGND.t271 VGND.n185 109.644
R461 VGND.n407 VGND.t249 199.989
R462 VGND.t278 VGND.n81 199.989
R463 VGND.t239 VGND.n54 199.989
R464 VGND.n62 VGND.t241 109.588
R465 VGND.t159 VGND.n71 199.989
R466 VGND.t163 VGND.n68 199.989
R467 VGND.t171 VGND.n66 199.989
R468 VGND.n162 VGND.t108 109.639
R469 VGND.n26 VGND.t113 199.989
R470 VGND.n19 VGND.t115 221.71
R471 VGND.t118 VGND.n18 199.989
R472 VGND.n34 VGND.t120 199.989
R473 VGND.t122 VGND.n15 199.989
R474 VGND.n37 VGND.t124 199.989
R475 VGND.t126 VGND.n12 199.989
R476 VGND.n40 VGND.t128 199.989
R477 VGND.t791 VGND.n65 198.513
R478 VGND.t784 VGND.n364 198.513
R479 VGND.t167 VGND.t792 197.143
R480 VGND.t689 VGND.n413 192.857
R481 VGND.t830 VGND.n385 192.857
R482 VGND.t628 VGND.n306 192.857
R483 VGND.n352 VGND.t47 192.857
R484 VGND.t260 VGND.t258 109.001
R485 VGND.t258 VGND.t257 108.999
R486 VGND.t250 VGND.n98 12.9744
R487 VGND.t12 VGND.n135 96.0214
R488 VGND.n116 VGND.t204 12.9743
R489 VGND.t223 VGND.t12 108.719
R490 VGND.n145 VGND.t233 12.9737
R491 VGND.t55 VGND.n149 7.34144
R492 VGND.n106 VGND.t78 102.001
R493 VGND.n43 VGND.n107 3.67126
R494 VGND.n43 VGND.t110 108.922
R495 VGND.n43 VGND.n153 96.0214
R496 VGND.n365 VGND.t175 191.679
R497 VGND.n84 VGND.t252 191.417
R498 VGND.n82 VGND.t275 191.417
R499 VGND.n292 VGND.t227 191.417
R500 VGND.n61 VGND.t236 191.417
R501 VGND.n59 VGND.t212 191.417
R502 VGND.n53 VGND.t217 191.417
R503 VGND.t219 VGND.n50 191.417
R504 VGND.n56 VGND.t221 191.417
R505 VGND.n71 VGND.t131 191.417
R506 VGND.t135 VGND.n369 191.417
R507 VGND.n109 VGND.t69 108.635
R508 VGND.n21 VGND.t71 191.417
R509 VGND.t74 VGND.n28 191.417
R510 VGND.t88 VGND.n33 191.417
R511 VGND.n16 VGND.t91 191.417
R512 VGND.t94 VGND.n36 191.417
R513 VGND.n13 VGND.t96 191.417
R514 VGND.t99 VGND.n39 191.417
R515 VGND.n10 VGND.t101 191.417
R516 VGND.t105 VGND.n42 191.417
R517 VGND.n284 VGND.t742 189.552
R518 VGND.n57 VGND.t673 189.552
R519 VGND.n67 VGND.t768 189.552
R520 VGND.t908 VGND.t228 188.571
R521 VGND.t255 VGND.n95 100.883
R522 VGND.t882 VGND.n187 11.3303
R523 VGND.t202 VGND.n285 184.286
R524 VGND.t228 VGND.n293 184.286
R525 VGND.t237 VGND.n175 100.888
R526 VGND.t213 VGND.n309 184.286
R527 VGND.n312 VGND.t218 184.286
R528 VGND.t220 VGND.n310 184.286
R529 VGND.n313 VGND.t222 184.286
R530 VGND.t159 VGND.n169 234.188
R531 VGND.n134 VGND.t136 100.883
R532 VGND.n367 VGND.t173 184.286
R533 VGND.t70 VGND.n120 100.883
R534 VGND.n355 VGND.t73 184.286
R535 VGND.n108 VGND.t75 100.883
R536 VGND.t770 VGND.n104 11.3307
R537 VGND.t90 VGND.n337 184.286
R538 VGND.n358 VGND.t93 184.286
R539 VGND.t95 VGND.n336 184.286
R540 VGND.n359 VGND.t98 184.286
R541 VGND.t100 VGND.n335 184.286
R542 VGND.n360 VGND.t103 184.286
R543 VGND.n148 VGND.t106 100.883
R544 VGND.n278 VGND.t727 182.764
R545 VGND.n280 VGND.t794 182.764
R546 VGND.n316 VGND.t653 182.764
R547 VGND.t812 VGND.n372 182.764
R548 VGND.t165 VGND.n371 182.764
R549 VGND.t905 VGND.n366 182.764
R550 VGND.t640 VGND.t711 180
R551 VGND.t883 VGND.t830 180
R552 VGND.n110 VGND.t111 98.6869
R553 VGND.t701 VGND.t797 178.306
R554 VGND.t242 VGND.n129 99.5774
R555 VGND.t268 VGND.n147 99.5774
R556 VGND.t247 VGND.n408 175.714
R557 VGND.t238 VGND.n310 175.714
R558 VGND.n313 VGND.t240 175.714
R559 VGND.t158 VGND.n321 175.714
R560 VGND.n350 VGND.t107 175.714
R561 VGND.n355 VGND.t112 175.714
R562 VGND.t83 VGND.n339 175.714
R563 VGND.t117 VGND.n337 175.714
R564 VGND.n358 VGND.t119 175.714
R565 VGND.t121 VGND.n336 175.714
R566 VGND.n359 VGND.t123 175.714
R567 VGND.t125 VGND.n335 175.714
R568 VGND.n360 VGND.t127 175.714
R569 VGND.t805 VGND.n277 173.849
R570 VGND.t910 VGND.t51 173.849
R571 VGND.n127 VGND.t230 97.2962
R572 VGND.t810 VGND.t924 167.143
R573 VGND.n118 VGND.t811 97.9413
R574 VGND.t929 VGND.n368 167.143
R575 VGND.t892 VGND.n341 167.143
R576 VGND.t734 VGND.t803 162.857
R577 VGND.t715 VGND.n58 162.852
R578 VGND.n65 VGND.t823 162.852
R579 VGND.n364 VGND.t814 162.852
R580 VGND.t733 VGND.n392 154.286
R581 VGND.n101 VGND.t761 314.469
R582 VGND.t801 VGND.n266 154.286
R583 VGND.n270 VGND.t649 154.286
R584 VGND.t974 VGND.n274 154.286
R585 VGND.n356 VGND.t950 154.286
R586 VGND.n357 VGND.t815 154.286
R587 VGND.t820 VGND.n259 154.167
R588 VGND.t633 VGND.n5 100.585
R589 VGND.t691 VGND.n4 153.474
R590 VGND.n75 VGND.t731 152.846
R591 VGND.n416 VGND.t933 152.846
R592 VGND.n80 VGND.t897 152.846
R593 VGND.t899 VGND.n87 152.846
R594 VGND.n60 VGND.t895 152.846
R595 VGND.t760 VGND.n72 152.846
R596 VGND.t758 VGND.n23 152.846
R597 VGND.n156 VGND.t705 162.888
R598 VGND.t741 VGND.n278 147.103
R599 VGND.t635 VGND.n281 147.103
R600 VGND.t674 VGND.n316 147.103
R601 VGND.n372 VGND.t767 147.103
R602 VGND.n366 VGND.t909 147.103
R603 VGND.t173 VGND.t774 145.714
R604 VGND.t924 VGND.n392 141.429
R605 VGND.n415 VGND.t918 141.429
R606 VGND.t720 VGND.n384 141.429
R607 VGND.n308 VGND.t879 141.429
R608 VGND.n326 VGND.t42 141.429
R609 VGND.n327 VGND.t750 141.429
R610 VGND.n351 VGND.t749 141.429
R611 VGND.n354 VGND.t718 141.429
R612 VGND.t672 VGND.t24 137.143
R613 VGND.t788 VGND.t974 137.143
R614 VGND.t755 VGND.n324 137.143
R615 VGND.t874 VGND.n332 137.143
R616 VGND.t806 VGND.t616 132.857
R617 VGND.t258 VGND.n205 4.88493
R618 VGND.t832 VGND.n393 124.287
R619 VGND.t915 VGND.n391 124.287
R620 VGND.t631 VGND.n411 124.287
R621 VGND.t859 VGND.n417 124.287
R622 VGND.n420 VGND.t857 124.287
R623 VGND.t679 VGND.n304 124.287
R624 VGND.t772 VGND.n322 124.287
R625 VGND.n328 VGND.t779 124.287
R626 VGND.t818 VGND.n367 124.287
R627 VGND.n353 VGND.t45 124.287
R628 VGND.t946 VGND.t958 120.834
R629 VGND.t737 VGND.t717 120.834
R630 VGND.t731 VGND.t733 120.001
R631 VGND.n287 VGND.t785 120.001
R632 VGND.n170 VGND.t788 132.124
R633 VGND.t765 VGND.t167 120.001
R634 VGND.t17 VGND.t752 120.001
R635 VGND.t965 VGND.t952 120.001
R636 VGND.n4 VGND.t40 116.987
R637 VGND.t632 VGND.t666 115.715
R638 VGND.t841 VGND.t789 111.442
R639 VGND.t826 VGND.t850 111.43
R640 VGND.t970 VGND.n331 111.43
R641 VGND.n170 VGND.t12 4.22895
R642 VGND.n261 VGND.t634 107.144
R643 VGND.t724 VGND.t743 102.858
R644 VGND.n402 VGND.t810 102.858
R645 VGND.n269 VGND.t807 102.858
R646 VGND.t808 VGND.n264 102.858
R647 VGND.n302 VGND.t894 102.858
R648 VGND.t891 VGND.n340 102.858
R649 VGND.t893 VGND.n338 102.858
R650 VGND.t55 VGND.t765 102.041
R651 VGND.t676 VGND.t729 100.001
R652 VGND.t934 VGND.n385 98.5719
R653 VGND.n267 VGND.t37 98.5719
R654 VGND.t756 VGND.n182 72.9596
R655 VGND.t769 VGND.n137 42.3401
R656 VGND.n314 VGND.t11 98.5719
R657 VGND.n325 VGND.t855 98.5719
R658 VGND.n208 VGND.t716 112.823
R659 VGND.t767 VGND.t165 98.0689
R660 VGND.t774 VGND.t55 97.7799
R661 VGND.t942 VGND.n111 72.6312
R662 VGND.t692 VGND.n410 97.1319
R663 VGND.t34 VGND.n83 97.1617
R664 VGND.t884 VGND.n275 97.1319
R665 VGND.n68 VGND.t682 97.1319
R666 VGND.t31 VGND.t761 94.2862
R667 VGND.n330 VGND.t773 94.2862
R668 VGND.n43 VGND.t745 93.4693
R669 VGND.t666 VGND.n74 92.8462
R670 VGND.t738 VGND.n256 90.2584
R671 VGND.t969 VGND.n290 90.0005
R672 VGND.n297 VGND.t777 90.0005
R673 VGND.t678 VGND.n2 86.5025
R674 VGND.n285 VGND.t799 85.7148
R675 VGND.t835 VGND.n288 85.7148
R676 VGND.t960 VGND.n273 85.7148
R677 VGND.t675 VGND.n334 85.7148
R678 VGND.t21 VGND.n156 3.42966
R679 VGND.n283 VGND.t698 84.6959
R680 VGND.t940 VGND.n329 84.6959
R681 VGND.t648 VGND.n362 84.6959
R682 VGND.n401 VGND.t853 81.4291
R683 VGND.n113 VGND.t625 81.921
R684 VGND.n406 VGND.t736 81.4291
R685 VGND.t926 VGND.n173 97.1319
R686 VGND.t876 VGND.n174 96.9911
R687 VGND.t669 VGND.n343 81.4291
R688 VGND.t684 VGND.t732 80.2382
R689 VGND.n0 VGND.t944 80.1767
R690 VGND.t887 VGND.t626 77.1434
R691 VGND.t923 VGND.n389 77.1434
R692 VGND.t840 VGND.n265 77.1434
R693 VGND.t922 VGND.n273 77.1434
R694 VGND.t766 VGND.t43 77.1434
R695 VGND.n188 VGND.t764 77.3077
R696 VGND.t944 VGND.t880 73.0664
R697 VGND.n288 VGND.t775 72.8576
R698 VGND.t968 VGND.n115 58.1383
R699 VGND.t727 VGND.t805 71.3229
R700 VGND.t959 VGND.n0 67.2827
R701 VGND.t714 VGND.n289 64.2862
R702 VGND.n293 VGND.t937 64.2862
R703 VGND.t728 VGND.n294 64.2862
R704 VGND.n298 VGND.t837 64.2862
R705 VGND.n115 VGND.t639 58.5001
R706 VGND.n208 VGND.n43 2.10026
R707 VGND.t35 VGND.n132 46.0246
R708 VGND.t12 VGND.t685 54.8988
R709 VGND.t670 VGND.t12 54.8979
R710 VGND.n46 VGND.t637 54.2748
R711 VGND.t903 VGND.n49 54.2748
R712 VGND.t175 VGND.t784 53.4923
R713 VGND.t707 VGND.t21 52.777
R714 VGND.n405 VGND.t647 51.4291
R715 VGND.t779 VGND.t160 51.4291
R716 VGND.n257 VGND.t737 45.8338
R717 VGND.t823 VGND.t166 44.577
R718 VGND.n403 VGND.t61 42.8576
R719 VGND.t176 VGND.t910 40.1194
R720 VGND.n419 VGND.t883 38.5719
R721 VGND.t697 VGND.n182 42.34
R722 VGND.n258 VGND.t821 37.5005
R723 VGND.n1 VGND.t946 36.5025
R724 VGND.t776 VGND.n330 34.2862
R725 VGND.n183 VGND.t174 29.8229
R726 VGND.t12 VGND.t713 33.4941
R727 VGND.t730 VGND.n75 32.8462
R728 VGND.t930 VGND.n416 32.8462
R729 VGND.n87 VGND.t898 32.8462
R730 VGND.t896 VGND.n60 32.8462
R731 VGND.n72 VGND.t759 32.8462
R732 VGND.n25 VGND.t804 32.8462
R733 VGND.t273 VGND.n98 15.001
R734 VGND.t195 VGND.n135 12.9744
R735 VGND.n116 VGND.t229 15.001
R736 VGND.n145 VGND.t207 15.0018
R737 VGND.t65 VGND.n153 12.9744
R738 VGND.n112 VGND.t848 26.1545
R739 VGND.t29 VGND.n258 29.1672
R740 VGND.t948 VGND.n387 25.7148
R741 VGND.t786 VGND.t12 24.8989
R742 VGND.t795 VGND.n284 24.2748
R743 VGND.n57 VGND.t796 24.2748
R744 VGND.t792 VGND.n67 24.2748
R745 VGND.t864 VGND.t959 21.4905
R746 VGND.t8 VGND.t808 21.4291
R747 VGND.t55 VGND.t780 19.6485
R748 VGND.t258 VGND.t851 20.637
R749 VGND.n180 VGND.t55 0.789752
R750 VGND.t831 VGND.n130 10.3566
R751 VGND.t845 VGND.n201 18.8912
R752 VGND.n209 VGND.n43 0.789748
R753 VGND.t693 VGND.n174 18.8904
R754 VGND.n96 VGND.t964 18.8704
R755 VGND.t829 VGND.n159 18.8704
R756 VGND.t9 VGND.n152 18.6991
R757 VGND.t655 VGND.n146 18.8704
R758 VGND.n114 VGND.t258 10.3073
R759 VGND.t258 VGND.t887 20.6131
R760 VGND.t258 VGND.n128 0.788882
R761 VGND.t12 VGND.n126 0.788882
R762 VGND.t636 VGND.n141 18.8704
R763 VGND.t55 VGND.t43 20.6392
R764 VGND.t819 VGND.n105 10.3452
R765 VGND.t258 VGND.t833 19.6259
R766 VGND.t258 VGND.n151 0.788846
R767 VGND.n127 VGND.t60 7.95772
R768 VGND.t12 VGND.t53 20.6121
R769 VGND.n140 VGND.t638 18.8696
R770 VGND.t621 VGND.t55 19.6259
R771 VGND.t687 VGND.t55 20.6121
R772 VGND.t55 VGND.t751 19.3001
R773 VGND.t55 VGND.t888 20.6121
R774 VGND.n110 VGND.t943 8.35554
R775 VGND.n43 VGND.n121 0.788846
R776 VGND.n58 VGND.t701 20.2074
R777 VGND.n93 VGND.t4 18.8658
R778 VGND.t33 VGND.n77 19.9891
R779 VGND.n77 VGND.t735 19.9891
R780 VGND.t886 VGND.n76 19.9891
R781 VGND.n79 VGND.t847 19.9891
R782 VGND.t919 VGND.n407 19.9891
R783 VGND.t57 VGND.n80 19.9891
R784 VGND.t914 VGND.n86 19.9891
R785 VGND.t677 VGND.n88 19.9891
R786 VGND.t836 VGND.n46 19.9891
R787 VGND.t50 VGND.n47 19.9891
R788 VGND.n45 VGND.t650 19.9891
R789 VGND.t658 VGND.n59 19.9891
R790 VGND.t665 VGND.n51 19.9891
R791 VGND.n163 VGND.t643 19.0607
R792 VGND.n66 VGND.t822 19.9891
R793 VGND.n8 VGND.t966 19.9891
R794 VGND.t746 VGND.n8 19.9891
R795 VGND.t971 VGND.n9 19.9891
R796 VGND.n9 VGND.t744 19.9891
R797 VGND.n7 VGND.t660 19.9891
R798 VGND.t938 VGND.n7 19.9891
R799 VGND.n43 VGND.n44 0.788702
R800 VGND.t616 VGND.n25 19.9891
R801 VGND.n23 VGND.t719 19.9891
R802 VGND.t681 VGND.n109 20.2695
R803 VGND.t646 VGND.n31 19.9891
R804 VGND.t816 VGND.n32 19.9891
R805 VGND.t729 VGND.n1 19.8359
R806 VGND.t713 VGND.t798 17.8311
R807 VGND.t846 VGND.n389 17.1434
R808 VGND.t789 VGND.n276 17.1434
R809 VGND.t837 VGND.t722 17.1434
R810 VGND.n125 VGND.t757 15.8278
R811 VGND.n200 VGND.t790 32.8462
R812 VGND.t21 VGND.n202 4.20933
R813 VGND.t21 VGND.n256 17.0005
R814 VGND.t21 VGND.n257 17.0005
R815 VGND.t21 VGND.n258 17.0005
R816 VGND.t21 VGND.n259 17.0005
R817 VGND.t21 VGND.n260 17.0005
R818 VGND.t21 VGND.n261 17.0005
R819 VGND.t21 VGND.n166 9.79175
R820 VGND.t21 VGND.n179 3.33087
R821 VGND.t326 VGND.n167 0.179511
R822 VGND.n243 VGND.t21 5.6463
R823 VGND.n242 VGND.t21 5.6463
R824 VGND.t21 VGND.t359 17.0005
R825 VGND.n238 VGND.t357 0.069885
R826 VGND.n240 VGND.t355 0.069885
R827 VGND.t258 VGND.n186 9.63523
R828 VGND.t258 VGND.n187 9.30762
R829 VGND.t258 VGND.n96 0.788882
R830 VGND.t258 VGND.n421 17.0005
R831 VGND.t258 VGND.n383 17.0005
R832 VGND.t258 VGND.n420 17.0005
R833 VGND.t258 VGND.n384 17.0005
R834 VGND.t258 VGND.n419 17.0005
R835 VGND.t258 VGND.n385 17.0005
R836 VGND.t258 VGND.n418 17.0005
R837 VGND.t258 VGND.n417 17.0005
R838 VGND.t258 VGND.n173 0.649813
R839 VGND.n408 VGND.t258 17.0005
R840 VGND.n411 VGND.t258 17.0005
R841 VGND.n412 VGND.t258 17.0005
R842 VGND.n413 VGND.t258 17.0005
R843 VGND.n414 VGND.t258 17.0005
R844 VGND.n415 VGND.t258 17.0005
R845 VGND.n159 VGND.t258 0.788882
R846 VGND.t258 VGND.n146 0.788882
R847 VGND.t258 VGND.n406 17.0005
R848 VGND.t258 VGND.n387 17.0005
R849 VGND.t258 VGND.n405 17.0005
R850 VGND.t258 VGND.n206 13.4027
R851 VGND.t258 VGND.n388 17.0005
R852 VGND.t258 VGND.n102 11.4368
R853 VGND.t258 VGND.n101 10.4539
R854 VGND.t258 VGND.n404 17.0005
R855 VGND.t258 VGND.n389 17.0005
R856 VGND.t258 VGND.n403 17.0005
R857 VGND.t258 VGND.n390 17.0005
R858 VGND.t258 VGND.n391 17.0005
R859 VGND.t258 VGND.n402 17.0005
R860 VGND.t258 VGND.n392 17.0005
R861 VGND.t258 VGND.n401 17.0005
R862 VGND.t258 VGND.n393 17.0005
R863 VGND.t258 VGND.n400 17.0005
R864 VGND.t258 VGND.n398 17.0005
R865 VGND.t258 VGND.n395 17.0005
R866 VGND.t258 VGND.n397 17.0005
R867 VGND.t258 VGND.n93 0.788688
R868 VGND.t258 VGND.n132 2.09939
R869 VGND.t258 VGND.n396 17.0005
R870 VGND.n276 VGND.t12 17.0005
R871 VGND.n136 VGND.t12 0.294308
R872 VGND.t12 VGND.n137 12.5835
R873 VGND.t12 VGND.n264 17.0005
R874 VGND.t12 VGND.n270 17.0005
R875 VGND.t12 VGND.n265 17.0005
R876 VGND.t12 VGND.n269 17.0005
R877 VGND.t12 VGND.n266 17.0005
R878 VGND.t12 VGND.n268 17.0005
R879 VGND.t12 VGND.n267 17.0005
R880 VGND.n376 VGND.t12 17.0005
R881 VGND.n283 VGND.t12 17.0005
R882 VGND.n282 VGND.t12 17.0005
R883 VGND.n281 VGND.t12 17.0005
R884 VGND.n280 VGND.t12 17.0005
R885 VGND.n279 VGND.t12 17.0005
R886 VGND.n278 VGND.t12 17.0005
R887 VGND.n277 VGND.t12 17.0005
R888 VGND.t12 VGND.n273 17.0005
R889 VGND.t12 VGND.n302 17.0005
R890 VGND.t12 VGND.n274 17.0005
R891 VGND.t12 VGND.n150 13.0749
R892 VGND.t12 VGND.n157 12.5835
R893 VGND.n300 VGND.t12 17.0005
R894 VGND.n122 VGND.t12 7.66905
R895 VGND.n298 VGND.t12 17.0005
R896 VGND.n297 VGND.t12 17.0005
R897 VGND.n296 VGND.t12 17.0005
R898 VGND.n295 VGND.t12 17.0005
R899 VGND.n294 VGND.t12 17.0005
R900 VGND.n112 VGND.t12 1.11651
R901 VGND.n293 VGND.t12 17.0005
R902 VGND.n291 VGND.t12 17.0005
R903 VGND.n290 VGND.t12 17.0005
R904 VGND.n289 VGND.t12 17.0005
R905 VGND.n288 VGND.t12 17.0005
R906 VGND.n100 VGND.t12 8.48812
R907 VGND.n287 VGND.t12 17.0005
R908 VGND.n285 VGND.t12 17.0005
R909 VGND.t12 VGND.n303 17.0005
R910 VGND.t12 VGND.n316 17.0005
R911 VGND.t12 VGND.n317 17.0005
R912 VGND.t12 VGND.n318 17.0005
R913 VGND.t12 VGND.n319 17.0005
R914 VGND.t12 VGND.n314 17.0005
R915 VGND.t12 VGND.n138 7.66905
R916 VGND.t12 VGND.n313 17.0005
R917 VGND.t12 VGND.n310 17.0005
R918 VGND.t12 VGND.n312 17.0005
R919 VGND.t12 VGND.n311 17.0005
R920 VGND.t12 VGND.n140 0.788846
R921 VGND.t12 VGND.n309 17.0005
R922 VGND.t12 VGND.n141 0.788882
R923 VGND.t12 VGND.n308 17.0005
R924 VGND.t12 VGND.n307 17.0005
R925 VGND.t12 VGND.n306 17.0005
R926 VGND.t12 VGND.n305 17.0005
R927 VGND.t12 VGND.n304 17.0005
R928 VGND.t12 VGND.n174 0.789715
R929 VGND.n200 VGND.t55 0.649813
R930 VGND.t55 VGND.n328 17.0005
R931 VGND.t55 VGND.n191 0.649813
R932 VGND.t55 VGND.n320 17.0005
R933 VGND.t55 VGND.n327 17.0005
R934 VGND.t55 VGND.n169 9.30721
R935 VGND.t55 VGND.n321 17.0005
R936 VGND.t55 VGND.n201 0.789748
R937 VGND.t55 VGND.n322 17.0005
R938 VGND.t55 VGND.n323 17.0005
R939 VGND.t55 VGND.n326 17.0005
R940 VGND.t55 VGND.n324 17.0005
R941 VGND.t55 VGND.n325 17.0005
R942 VGND.t55 VGND.n250 17.0005
R943 VGND.t55 VGND.n329 17.0005
R944 VGND.t55 VGND.n370 17.0005
R945 VGND.t55 VGND.n371 17.0005
R946 VGND.t55 VGND.n372 17.0005
R947 VGND.t55 VGND.n373 17.0005
R948 VGND.n367 VGND.t55 17.0005
R949 VGND.n368 VGND.t55 17.0005
R950 VGND.n133 VGND.t55 9.63482
R951 VGND.t55 VGND.n144 9.63483
R952 VGND.t55 VGND.n334 17.0005
R953 VGND.t55 VGND.n333 17.0005
R954 VGND.t55 VGND.n332 17.0005
R955 VGND.t55 VGND.n331 17.0005
R956 VGND.t55 VGND.n330 17.0005
R957 VGND.t55 VGND.n155 11.7644
R958 VGND.n362 VGND.t55 17.0005
R959 VGND.n363 VGND.t55 17.0005
R960 VGND.n365 VGND.t55 17.0005
R961 VGND.n366 VGND.t55 17.0005
R962 VGND.n183 VGND.t55 1.2372
R963 VGND.n43 VGND.n360 17.0005
R964 VGND.n43 VGND.n335 17.0005
R965 VGND.n43 VGND.n359 17.0005
R966 VGND.n43 VGND.n336 17.0005
R967 VGND.n43 VGND.n358 17.0005
R968 VGND.n43 VGND.n337 17.0005
R969 VGND.n43 VGND.n357 17.0005
R970 VGND.n43 VGND.n338 17.0005
R971 VGND.n43 VGND.n188 16.1874
R972 VGND.n43 VGND.n339 17.0005
R973 VGND.n43 VGND.n356 17.0005
R974 VGND.n43 VGND.n340 17.0005
R975 VGND.n43 VGND.n341 17.0005
R976 VGND.n43 VGND.n104 9.30721
R977 VGND.n43 VGND.n355 17.0005
R978 VGND.n43 VGND.n111 3.74255
R979 VGND.n43 VGND.n342 17.0005
R980 VGND.n43 VGND.n354 17.0005
R981 VGND.n43 VGND.n343 17.0005
R982 VGND.n43 VGND.n353 17.0005
R983 VGND.n43 VGND.n344 17.0005
R984 VGND.n43 VGND.n352 17.0005
R985 VGND.n43 VGND.n345 17.0005
R986 VGND.n43 VGND.n351 17.0005
R987 VGND.n43 VGND.n154 15.4357
R988 VGND.n43 VGND.n350 17.0005
R989 VGND.n43 VGND.n347 17.0005
R990 VGND.n43 VGND.n349 17.0005
R991 VGND.n43 VGND.n348 17.0005
R992 VGND.n43 VGND.n207 17.0005
R993 VGND.t850 VGND.n390 12.8576
R994 VGND.t945 VGND.n113 11.995
R995 VGND.t900 VGND.t57 12.8576
R996 VGND.t649 VGND.t809 12.8576
R997 VGND.n294 VGND.t967 12.8576
R998 VGND.t778 VGND.n295 12.8576
R999 VGND.t719 VGND.t754 12.8576
R1000 VGND.n165 VGND.n161 2.73979
R1001 VGND.t742 VGND.t200 8.91581
R1002 VGND.n404 VGND.t31 8.57193
R1003 VGND.n171 VGND.t787 8.73624
R1004 VGND.t782 VGND.n333 8.57193
R1005 VGND.t615 VGND.n117 3.46061
R1006 VGND.t612 VGND.n235 0.130189
R1007 VGND.t610 VGND.n117 8.501
R1008 VGND.t607 VGND.n234 0.130189
R1009 VGND.t605 VGND.n117 8.501
R1010 VGND.t602 VGND.n233 0.130189
R1011 VGND.t600 VGND.n117 8.501
R1012 VGND.t597 VGND.n232 0.130189
R1013 VGND.t595 VGND.n117 8.501
R1014 VGND.t592 VGND.n231 0.130189
R1015 VGND.t590 VGND.n117 8.501
R1016 VGND.t587 VGND.n230 0.130189
R1017 VGND.t585 VGND.n117 8.501
R1018 VGND.t582 VGND.n229 0.130189
R1019 VGND.t578 VGND.n203 0.219244
R1020 VGND.t576 VGND.n117 8.501
R1021 VGND.n228 VGND.t573 0.130189
R1022 VGND.t571 VGND.n117 8.501
R1023 VGND.n227 VGND.t568 0.130189
R1024 VGND.t566 VGND.n117 8.501
R1025 VGND.n226 VGND.t563 0.130189
R1026 VGND.t561 VGND.n117 8.501
R1027 VGND.n225 VGND.t558 0.130189
R1028 VGND.t556 VGND.n117 8.501
R1029 VGND.n224 VGND.t553 0.130189
R1030 VGND.t551 VGND.n117 8.501
R1031 VGND.n223 VGND.t548 0.130189
R1032 VGND.t546 VGND.n117 8.501
R1033 VGND.n222 VGND.t543 0.130189
R1034 VGND.t541 VGND.n117 8.501
R1035 VGND.n221 VGND.t538 0.130189
R1036 VGND.t536 VGND.n117 8.501
R1037 VGND.n220 VGND.t533 0.130189
R1038 VGND.t531 VGND.n117 8.501
R1039 VGND.n219 VGND.t528 0.130189
R1040 VGND.t526 VGND.n117 8.501
R1041 VGND.n218 VGND.t523 0.130189
R1042 VGND.t521 VGND.n117 8.501
R1043 VGND.n217 VGND.t518 0.130189
R1044 VGND.t516 VGND.n117 8.501
R1045 VGND.n216 VGND.t513 0.130189
R1046 VGND.t511 VGND.n117 8.501
R1047 VGND.n215 VGND.t508 0.130189
R1048 VGND.t506 VGND.n117 8.501
R1049 VGND.n214 VGND.t503 0.130189
R1050 VGND.t501 VGND.n117 8.501
R1051 VGND.n213 VGND.t498 0.130189
R1052 VGND.t496 VGND.n117 8.501
R1053 VGND.n212 VGND.t493 0.130189
R1054 VGND.t491 VGND.n117 8.501
R1055 VGND.n211 VGND.t488 0.130189
R1056 VGND.t486 VGND.n117 8.501
R1057 VGND.n117 VGND.n210 3.33079
R1058 VGND.t377 VGND.n236 0.726507
R1059 VGND.n244 VGND.t21 0.763832
R1060 VGND.n197 VGND.t296 0.0793054
R1061 VGND.t21 VGND.n189 4.20253
R1062 VGND.t336 VGND.n202 0.0719136
R1063 VGND.t333 VGND.n196 0.13364
R1064 VGND.t21 VGND.n199 4.20315
R1065 VGND.t324 VGND.n243 0.0333775
R1066 VGND.t321 VGND.n190 0.13364
R1067 VGND.t318 VGND.n195 0.13364
R1068 VGND.t21 VGND.n198 4.20315
R1069 VGND.t312 VGND.n242 0.0333775
R1070 VGND.n238 VGND.t21 5.64493
R1071 VGND.n240 VGND.t21 5.64493
R1072 VGND.n247 VGND.t258 2.77795
R1073 VGND.t258 VGND.n246 0.915424
R1074 VGND.t270 VGND.n245 0.0811489
R1075 VGND.t12 VGND.n192 1.3728
R1076 VGND.t194 VGND.n192 0.418939
R1077 VGND.n249 VGND.t12 0.571214
R1078 VGND.n253 VGND.t55 3.33087
R1079 VGND.t3 VGND.n254 0.432129
R1080 VGND.t145 VGND.t55 0.918791
R1081 VGND.t56 VGND.n252 0.129991
R1082 VGND.t137 VGND.n251 0.562557
R1083 VGND.n255 VGND.n43 0.466171
R1084 VGND.n197 VGND.t21 4.20468
R1085 VGND.t294 VGND.n189 0.083315
R1086 VGND.t21 VGND.n164 4.177
R1087 VGND.n194 VGND.t21 4.177
R1088 VGND.n177 VGND.t334 0.17801
R1089 VGND.t21 VGND.t331 8.47111
R1090 VGND.n199 VGND.t329 0.0820912
R1091 VGND.t328 VGND.n179 0.145818
R1092 VGND.t21 VGND.n178 3.30688
R1093 VGND.t21 VGND.t319 8.47111
R1094 VGND.t21 VGND.t316 8.47111
R1095 VGND.n198 VGND.t314 0.0820912
R1096 VGND.t21 VGND.n422 8.47111
R1097 VGND.t21 VGND.n237 4.177
R1098 VGND.t310 VGND.n237 0.119605
R1099 VGND.t21 VGND.n239 4.177
R1100 VGND.t307 VGND.n239 0.119605
R1101 VGND.n193 VGND.t21 3.30696
R1102 VGND.n241 VGND.t21 4.177
R1103 VGND.t303 VGND.n241 0.119605
R1104 VGND.n184 VGND.t21 4.177
R1105 VGND.n184 VGND.t352 0.119605
R1106 VGND.n181 VGND.t21 4.177
R1107 VGND.t350 VGND.n181 0.119605
R1108 VGND.t21 VGND.n176 4.177
R1109 VGND.t298 VGND.n176 0.119605
R1110 VGND.n245 VGND.t258 4.20376
R1111 VGND.t12 VGND.n90 0.935198
R1112 VGND.n235 VGND.n117 3.33079
R1113 VGND.n234 VGND.n117 3.33079
R1114 VGND.n233 VGND.n117 3.33079
R1115 VGND.n232 VGND.n117 3.33079
R1116 VGND.n231 VGND.n117 3.33079
R1117 VGND.n230 VGND.n117 3.33079
R1118 VGND.n229 VGND.n117 3.33079
R1119 VGND.n228 VGND.n117 3.33079
R1120 VGND.n117 VGND.n227 3.33079
R1121 VGND.n226 VGND.n117 3.33079
R1122 VGND.n117 VGND.n225 3.33079
R1123 VGND.n224 VGND.n117 3.33079
R1124 VGND.n117 VGND.n223 3.33079
R1125 VGND.n222 VGND.n117 3.33079
R1126 VGND.n117 VGND.n221 3.33079
R1127 VGND.n220 VGND.n117 3.33079
R1128 VGND.n117 VGND.n219 3.33079
R1129 VGND.n218 VGND.n117 3.33079
R1130 VGND.n117 VGND.n217 3.33079
R1131 VGND.n216 VGND.n117 3.33079
R1132 VGND.n117 VGND.n215 3.33079
R1133 VGND.n214 VGND.n117 3.33079
R1134 VGND.n117 VGND.n213 3.33079
R1135 VGND.n212 VGND.n117 3.33079
R1136 VGND.n117 VGND.n211 3.33079
R1137 VGND.t484 VGND.n210 0.0863258
R1138 VGND.n177 VGND.t21 3.30688
R1139 VGND.n196 VGND.t21 3.32942
R1140 VGND.t21 VGND.n167 4.17719
R1141 VGND.t323 VGND.n178 0.118323
R1142 VGND.n190 VGND.t21 3.32942
R1143 VGND.n195 VGND.t21 3.32942
R1144 VGND.t305 VGND.n193 0.118193
R1145 VGND.t197 VGND.t12 5.61485
R1146 VGND.n253 VGND.t162 0.0861948
R1147 VGND.n252 VGND.t55 3.33087
R1148 VGND.n43 VGND.t67 5.61485
R1149 VGND.t55 VGND.t51 5.08771
R1150 VGND.n89 VGND.n161 0.549345
R1151 VGND.n172 VGND.n165 0.0492866
R1152 VGND.t842 VGND.n280 4.45815
R1153 VGND.n319 VGND.t684 4.45815
R1154 VGND.t743 VGND.n260 4.28621
R1155 VGND.t726 VGND.n93 19.8492
R1156 VGND.n398 VGND.t800 4.28621
R1157 VGND.t901 VGND.n128 19.849
R1158 VGND.t703 VGND.n123 4.24424
R1159 VGND.t917 VGND.n123 4.2443
R1160 VGND.n400 VGND.t734 4.28621
R1161 VGND.n205 VGND.t640 15.753
R1162 VGND.t856 VGND.n206 7.23521
R1163 VGND.n151 VGND.t688 19.8491
R1164 VGND.t869 VGND.n160 4.0816
R1165 VGND.t619 VGND.n415 4.28621
R1166 VGND.t657 VGND.n412 4.28621
R1167 VGND.n421 VGND.t672 4.28621
R1168 VGND.t885 VGND.n186 11.0027
R1169 VGND.n268 VGND.t920 4.28621
R1170 VGND.t6 VGND.n265 4.28621
R1171 VGND.t860 VGND.t825 4.28621
R1172 VGND.t839 VGND.n136 20.3446
R1173 VGND.t41 VGND.n122 12.9689
R1174 VGND.n300 VGND.t704 4.28621
R1175 VGND.n126 VGND.t907 19.849
R1176 VGND.n131 VGND.t231 102.68
R1177 VGND.t866 VGND.n157 8.05444
R1178 VGND.n171 VGND.t973 4.0816
R1179 VGND.t702 VGND.n305 4.28621
R1180 VGND.t936 VGND.n308 4.28621
R1181 VGND.n139 VGND.t696 12.9676
R1182 VGND.n311 VGND.t629 4.28621
R1183 VGND.n312 VGND.t656 4.28621
R1184 VGND.n125 VGND.t2 4.94198
R1185 VGND.t44 VGND.n323 4.28621
R1186 VGND.n201 VGND.t668 19.8482
R1187 VGND.n327 VGND.t747 4.28621
R1188 VGND.t683 VGND.n119 4.24424
R1189 VGND.n119 VGND.t921 4.2443
R1190 VGND.t873 VGND.n134 11.3307
R1191 VGND.n209 VGND.t739 19.8482
R1192 VGND.t13 VGND.n154 4.2443
R1193 VGND.n352 VGND.t939 4.28621
R1194 VGND.t870 VGND.n343 4.28621
R1195 VGND.t972 VGND.n342 4.28621
R1196 VGND.n103 VGND.t48 4.24424
R1197 VGND.n103 VGND.t644 4.2443
R1198 VGND.n108 VGND.t824 11.3307
R1199 VGND.n99 VGND.t965 16.9005
R1200 VGND.t659 VGND.n340 4.28621
R1201 VGND.t624 VGND.n143 4.2443
R1202 VGND.t20 VGND.n204 4.22908
R1203 VGND.t258 VGND.n399 4.20597
R1204 VGND.t253 VGND.n247 0.0547982
R1205 VGND.t427 VGND.n204 2.37337
R1206 VGND.n94 VGND.t55 0.717863
R1207 VGND.n374 VGND.t66 2.13314
R1208 VGND.t579 VGND.n429 2.13314
R1209 VGND.n361 VGND.t87 2.13314
R1210 VGND.n374 VGND.t132 1.8005
R1211 VGND.n271 VGND.n375 1.8005
R1212 VGND.t245 VGND.n89 1.8005
R1213 VGND.n89 VGND.t291 1.8005
R1214 VGND.t382 VGND.n89 1.8005
R1215 VGND.t503 VGND.n430 1.8005
R1216 VGND.t139 VGND.n361 1.8005
R1217 VGND.t210 VGND.n263 1.8005
R1218 VGND.n168 VGND.t254 1.8005
R1219 VGND.n172 VGND.t312 1.8005
R1220 VGND.n429 VGND.t410 1.8005
R1221 VGND.n254 VGND.t55 1.36089
R1222 VGND.n428 VGND.n204 1.58408
R1223 VGND.n43 VGND.t14 1.56278
R1224 VGND.t258 VGND.t269 1.55023
R1225 VGND.t55 VGND.t134 1.51784
R1226 VGND.n43 VGND.t104 1.25225
R1227 VGND.t706 VGND.n92 0.460627
R1228 VGND.t21 VGND.t287 1.2088
R1229 VGND.t199 VGND.n248 0.980754
R1230 VGND.t55 VGND.t164 0.983694
R1231 VGND.t21 VGND.t292 1.14684
R1232 VGND.n251 VGND.t55 0.933997
R1233 VGND.t72 VGND.n64 0.410849
R1234 VGND.n63 VGND.t81 0.400278
R1235 VGND.t32 VGND.t641 1.10764
R1236 VGND.t394 VGND.n427 1.09923
R1237 VGND.t12 VGND.t216 0.430593
R1238 VGND.t97 VGND.t102 1.08391
R1239 VGND.t627 VGND.t245 1.08157
R1240 VGND.n73 VGND.t147 0.172322
R1241 VGND.n346 VGND.t64 1.06677
R1242 VGND.n394 VGND.t5 1.06621
R1243 VGND.n90 VGND.t54 0.014542
R1244 VGND.n424 VGND.t412 1.05049
R1245 VGND.n425 VGND.t402 1.05014
R1246 VGND.n426 VGND.t394 1.05014
R1247 VGND.t92 VGND.t89 1.04884
R1248 VGND.t46 VGND.t18 1.04804
R1249 VGND.n386 VGND.t10 1.04706
R1250 VGND.n272 VGND.t1 1.04695
R1251 VGND.t248 VGND.n386 1.04403
R1252 VGND.t686 VGND.t208 1.04309
R1253 VGND.t641 VGND.t28 1.04283
R1254 VGND.t627 VGND.t32 1.04101
R1255 VGND.t420 VGND.n423 1.03536
R1256 VGND.t410 VGND.n425 1.03123
R1257 VGND.n92 VGND.t30 0.972548
R1258 VGND.t16 VGND.n255 0.867999
R1259 VGND.n427 VGND.t386 1.02275
R1260 VGND.t141 VGND.t55 0.998967
R1261 VGND.t26 VGND.n91 0.40146
R1262 VGND.t402 VGND.n426 0.993734
R1263 VGND.t87 VGND.t89 0.972736
R1264 VGND.n424 VGND.t410 0.957897
R1265 VGND.t254 VGND.n91 1.16979
R1266 VGND.n272 VGND.t201 0.947044
R1267 VGND.t7 VGND.t194 0.944481
R1268 VGND.t622 VGND.t3 0.943608
R1269 VGND.t412 VGND.n423 0.901111
R1270 VGND.t87 VGND.t84 0.887061
R1271 VGND.t210 VGND.t235 0.875062
R1272 VGND.n63 VGND.t84 0.159954
R1273 VGND.t49 VGND.t18 0.870882
R1274 VGND.t382 VGND.n236 0.830406
R1275 VGND.t36 VGND.n394 0.806157
R1276 VGND.t1 VGND.n249 0.685046
R1277 VGND.t97 VGND.t92 0.799098
R1278 VGND.t291 VGND.n244 0.841707
R1279 VGND.t235 VGND.t208 0.772673
R1280 VGND.t141 VGND.t56 0.77198
R1281 VGND.t39 VGND.n244 0.63684
R1282 VGND.t262 VGND.t258 0.721081
R1283 VGND.t248 VGND.n246 0.590318
R1284 VGND.t287 VGND.t39 0.709581
R1285 VGND.t21 VGND.n4 0.68391
R1286 VGND.n251 VGND.t138 0.0757838
R1287 VGND.t55 VGND.t622 0.671052
R1288 VGND.t12 VGND.t7 0.670636
R1289 VGND.t686 VGND.n249 0.16442
R1290 VGND.t21 VGND.n1 0.666899
R1291 VGND.t21 VGND.n2 0.666899
R1292 VGND.t58 VGND.n246 0.7359
R1293 VGND.t763 VGND.t622 0.654395
R1294 VGND.t38 VGND.t7 0.653609
R1295 VGND.t21 VGND.n3 0.649813
R1296 VGND.t258 VGND.n81 0.649813
R1297 VGND.t258 VGND.n82 0.649813
R1298 VGND.t258 VGND.n88 0.649813
R1299 VGND.t258 VGND.n87 0.649813
R1300 VGND.t258 VGND.n86 0.649813
R1301 VGND.t258 VGND.n83 0.620139
R1302 VGND.t258 VGND.n84 0.649813
R1303 VGND.t258 VGND.n85 0.620121
R1304 VGND.t258 VGND.n80 0.649813
R1305 VGND.n407 VGND.t258 0.649813
R1306 VGND.n409 VGND.t258 0.649813
R1307 VGND.n410 VGND.t258 0.649813
R1308 VGND.n416 VGND.t258 0.649813
R1309 VGND.n185 VGND.t671 20.282
R1310 VGND.t258 VGND.n79 0.649813
R1311 VGND.t258 VGND.n78 0.620139
R1312 VGND.t258 VGND.n74 0.649813
R1313 VGND.t258 VGND.n75 0.649813
R1314 VGND.n124 VGND.t266 221.71
R1315 VGND.t258 VGND.n76 0.649813
R1316 VGND.t258 VGND.n77 0.649813
R1317 VGND.n275 VGND.t12 0.649813
R1318 VGND.n137 VGND.t962 72.9583
R1319 VGND.t12 VGND.n48 0.649813
R1320 VGND.t12 VGND.n45 0.649813
R1321 VGND.t12 VGND.n47 0.649813
R1322 VGND.t12 VGND.n46 0.649813
R1323 VGND.t12 VGND.n57 0.649813
R1324 VGND.n301 VGND.t12 0.649813
R1325 VGND.n299 VGND.t12 0.649813
R1326 VGND.n292 VGND.t12 0.649813
R1327 VGND.n286 VGND.t12 0.649813
R1328 VGND.n284 VGND.t12 0.649813
R1329 VGND.t12 VGND.n49 0.649813
R1330 VGND.n62 VGND.t222 243.139
R1331 VGND.t12 VGND.n56 0.649813
R1332 VGND.t12 VGND.n55 0.649813
R1333 VGND.t12 VGND.n54 0.649813
R1334 VGND.t12 VGND.n50 0.649813
R1335 VGND.t12 VGND.n51 0.649813
R1336 VGND.t12 VGND.n52 0.649813
R1337 VGND.t12 VGND.n53 0.649813
R1338 VGND.n315 VGND.t12 0.649813
R1339 VGND.t12 VGND.n59 0.649813
R1340 VGND.t12 VGND.n60 0.649813
R1341 VGND.t12 VGND.n61 0.649813
R1342 VGND.t55 VGND.n68 0.649813
R1343 VGND.t55 VGND.n72 0.649813
R1344 VGND.t55 VGND.n71 0.649813
R1345 VGND.t55 VGND.n70 0.649813
R1346 VGND.t55 VGND.n69 0.649813
R1347 VGND.n163 VGND.t762 54.3045
R1348 VGND.n369 VGND.t55 0.649813
R1349 VGND.t55 VGND.n66 0.649813
R1350 VGND.t55 VGND.n67 0.649813
R1351 VGND.n43 VGND.n42 0.649813
R1352 VGND.n43 VGND.n41 0.649813
R1353 VGND.n43 VGND.n40 0.649813
R1354 VGND.n43 VGND.n10 0.649813
R1355 VGND.n43 VGND.n11 0.649813
R1356 VGND.n43 VGND.n12 0.649813
R1357 VGND.n43 VGND.n39 0.649813
R1358 VGND.n43 VGND.n38 0.649813
R1359 VGND.n43 VGND.n37 0.649813
R1360 VGND.n43 VGND.n13 0.649813
R1361 VGND.n43 VGND.n14 0.649813
R1362 VGND.n43 VGND.n15 0.649813
R1363 VGND.n43 VGND.n36 0.649813
R1364 VGND.n43 VGND.n35 0.649813
R1365 VGND.n43 VGND.n34 0.649813
R1366 VGND.n43 VGND.n16 0.649813
R1367 VGND.n43 VGND.n17 0.649813
R1368 VGND.n43 VGND.n18 0.649813
R1369 VGND.n43 VGND.n33 0.649813
R1370 VGND.n43 VGND.n32 0.649813
R1371 VGND.n43 VGND.n31 0.649813
R1372 VGND.n43 VGND.n19 0.356968
R1373 VGND.n43 VGND.n30 0.649813
R1374 VGND.n43 VGND.n99 3.73737
R1375 VGND.n43 VGND.n20 0.620139
R1376 VGND.n43 VGND.n29 0.369515
R1377 VGND.n43 VGND.n28 0.649813
R1378 VGND.n43 VGND.n27 0.649813
R1379 VGND.n43 VGND.n26 0.649813
R1380 VGND.n43 VGND.n21 0.649813
R1381 VGND.n43 VGND.n22 0.649813
R1382 VGND.n43 VGND.n23 0.649813
R1383 VGND.n43 VGND.n24 0.649813
R1384 VGND.n43 VGND.n25 0.649813
R1385 VGND.n162 VGND.t63 221.71
R1386 VGND.n43 VGND.n6 0.649813
R1387 VGND.n43 VGND.n7 0.649813
R1388 VGND.n43 VGND.n9 0.649813
R1389 VGND.n43 VGND.n8 0.649813
R1390 VGND.t21 VGND.n0 0.648101
R1391 VGND.t21 VGND.n5 0.359559
R1392 VGND.t139 VGND.t141 0.635167
R1393 VGND.t12 VGND.n58 0.62663
R1394 VGND.t55 VGND.n65 0.62663
R1395 VGND.n364 VGND.t55 0.62663
R1396 VGND.t134 VGND.t161 0.615368
R1397 VGND.n43 VGND.n346 0.612177
R1398 VGND VGND.n161 0.621781
R1399 VGND.t138 VGND.t139 0.572446
R1400 VGND.t132 VGND.t134 0.552384
R1401 VGND.n255 VGND.t46 0.0572618
R1402 VGND.t132 VGND.n254 0.627855
R1403 VGND.t663 VGND.n346 0.536625
R1404 VGND.t270 VGND.t269 0.534503
R1405 VGND.t286 VGND.t287 0.52746
R1406 VGND.t28 VGND.t269 0.523239
R1407 VGND.n236 VGND.n204 0.445701
R1408 VGND.t12 VGND.t235 0.467696
R1409 VGND.t258 VGND.t641 0.462041
R1410 VGND.n43 VGND.t89 0.456536
R1411 VGND.n43 VGND.n63 0.202771
R1412 VGND.n386 VGND.t258 0.441223
R1413 VGND.t196 VGND.n192 0.422151
R1414 VGND.n73 VGND.t155 0.476376
R1415 VGND.n43 VGND.t97 0.430657
R1416 VGND.n424 VGND.n204 0.398331
R1417 VGND.t102 VGND.t104 0.397911
R1418 VGND.t258 VGND.t627 0.387757
R1419 VGND.t177 VGND.t137 0.38229
R1420 VGND.t66 VGND.t14 0.381272
R1421 VGND.t258 VGND.n394 0.365401
R1422 VGND.n64 VGND.t49 0.171275
R1423 VGND.t14 VGND.t64 0.356272
R1424 VGND.n428 VGND.t382 0.341008
R1425 VGND.n423 VGND.n204 0.340732
R1426 VGND.t201 VGND.n248 1.08467
R1427 VGND.n430 VGND.n89 0.33314
R1428 VGND.n375 VGND.n374 0.33314
R1429 VGND.n429 VGND.n172 0.33314
R1430 VGND.n168 VGND.n263 0.33314
R1431 VGND.n361 VGND.n263 0.33314
R1432 VGND.n425 VGND.n204 0.316152
R1433 VGND.n426 VGND.n204 0.316152
R1434 VGND.t386 VGND.n428 0.314842
R1435 VGND.t579 VGND.n203 0.220255
R1436 VGND.n272 VGND.t12 0.306557
R1437 VGND.n177 VGND.t335 0.118323
R1438 VGND.t331 VGND.t332 0.301114
R1439 VGND.t322 VGND.n178 0.17801
R1440 VGND.t319 VGND.t320 0.301114
R1441 VGND.t316 VGND.t317 0.301114
R1442 VGND.t305 VGND.t304 0.301114
R1443 VGND.t306 VGND.n193 0.177814
R1444 VGND.n94 VGND.t177 0.170352
R1445 VGND.t21 VGND.t293 0.269293
R1446 VGND.n165 VGND.n168 0.291767
R1447 VGND.t294 VGND.t30 0.246041
R1448 VGND.n164 VGND.t347 0.119605
R1449 VGND.t328 VGND.t329 0.241078
R1450 VGND.n422 VGND.t314 0.241078
R1451 VGND.n194 VGND.t23 0.360183
R1452 VGND.n194 VGND.t297 0.119605
R1453 VGND.t347 VGND.t297 0.241078
R1454 VGND.t298 VGND.n164 0.360183
R1455 VGND.t299 VGND.n176 0.119605
R1456 VGND.t299 VGND.t350 0.241078
R1457 VGND.t300 VGND.n181 0.119605
R1458 VGND.t352 VGND.t300 0.241078
R1459 VGND.n184 VGND.t302 0.119605
R1460 VGND.t303 VGND.t302 0.241078
R1461 VGND.t304 VGND.n241 0.119605
R1462 VGND.t308 VGND.n239 0.119605
R1463 VGND.t311 VGND.n237 0.119605
R1464 VGND.n167 VGND.t325 0.30028
R1465 VGND.t254 VGND.t253 0.239432
R1466 VGND.t377 VGND.t20 0.232593
R1467 VGND.t16 VGND.t67 0.227075
R1468 VGND.t162 VGND.t164 0.227075
R1469 VGND.t199 VGND.t197 0.227075
R1470 VGND.t613 VGND.t615 0.226736
R1471 VGND.t608 VGND.t610 0.226736
R1472 VGND.t603 VGND.t605 0.226736
R1473 VGND.t598 VGND.t600 0.226736
R1474 VGND.t593 VGND.t595 0.226736
R1475 VGND.t588 VGND.t590 0.226736
R1476 VGND.t583 VGND.t585 0.226736
R1477 VGND.t484 VGND.t486 0.226736
R1478 VGND.t491 VGND.t489 0.226736
R1479 VGND.t494 VGND.t496 0.226736
R1480 VGND.t501 VGND.t499 0.226736
R1481 VGND.t504 VGND.t506 0.226736
R1482 VGND.t511 VGND.t509 0.226736
R1483 VGND.t514 VGND.t516 0.226736
R1484 VGND.t521 VGND.t519 0.226736
R1485 VGND.t524 VGND.t526 0.226736
R1486 VGND.t531 VGND.t529 0.226736
R1487 VGND.t534 VGND.t536 0.226736
R1488 VGND.t541 VGND.t539 0.226736
R1489 VGND.t544 VGND.t546 0.226736
R1490 VGND.t551 VGND.t549 0.226736
R1491 VGND.t554 VGND.t556 0.226736
R1492 VGND.t561 VGND.t559 0.226736
R1493 VGND.t564 VGND.t566 0.226736
R1494 VGND.t571 VGND.t569 0.226736
R1495 VGND.t574 VGND.t576 0.226736
R1496 VGND.t145 VGND.t144 0.224575
R1497 VGND.t317 VGND.n195 0.0886049
R1498 VGND.t320 VGND.n190 0.0886049
R1499 VGND.t323 VGND.t324 0.224236
R1500 VGND.t332 VGND.n196 0.0886049
R1501 VGND.t483 VGND.n210 0.130189
R1502 VGND.n212 VGND.t494 0.0863258
R1503 VGND.n214 VGND.t504 0.0863258
R1504 VGND.n216 VGND.t514 0.0863258
R1505 VGND.n218 VGND.t524 0.0863258
R1506 VGND.n220 VGND.t534 0.0863258
R1507 VGND.n222 VGND.t544 0.0863258
R1508 VGND.n224 VGND.t554 0.0863258
R1509 VGND.n226 VGND.t564 0.0863258
R1510 VGND.n228 VGND.t574 0.0863258
R1511 VGND.n229 VGND.t583 0.0863258
R1512 VGND.n230 VGND.t588 0.0863258
R1513 VGND.n231 VGND.t593 0.0863258
R1514 VGND.n232 VGND.t598 0.0863258
R1515 VGND.n233 VGND.t603 0.0863258
R1516 VGND.n234 VGND.t608 0.0863258
R1517 VGND.n235 VGND.t613 0.0863258
R1518 VGND.t569 VGND.n227 0.0863258
R1519 VGND.t559 VGND.n225 0.0863258
R1520 VGND.t549 VGND.n223 0.0863258
R1521 VGND.t539 VGND.n221 0.0863258
R1522 VGND.t529 VGND.n219 0.0863258
R1523 VGND.t519 VGND.n217 0.0863258
R1524 VGND.t509 VGND.n215 0.0863258
R1525 VGND.t499 VGND.n213 0.0863258
R1526 VGND.t489 VGND.n211 0.0863258
R1527 VGND.n252 VGND.t144 0.0861948
R1528 VGND.t161 VGND.n253 0.129991
R1529 VGND.t335 VGND.t336 0.212986
R1530 VGND.t420 VGND.t427 0.211906
R1531 VGND.t52 VGND.n94 0.0846535
R1532 VGND.t327 VGND.n179 0.130401
R1533 VGND.n422 VGND.t313 0.180789
R1534 VGND.t311 VGND.t359 0.180789
R1535 VGND.t308 VGND.t357 0.180789
R1536 VGND.t355 VGND.t306 0.180789
R1537 VGND.n427 VGND.n204 0.1696
R1538 VGND.t22 VGND.n189 0.0836055
R1539 VGND.n247 VGND.t58 0.109776
R1540 VGND.t330 VGND.n199 0.0823774
R1541 VGND.t315 VGND.n198 0.0823774
R1542 VGND.n271 VGND.t197 0.160486
R1543 VGND.t66 VGND.t67 0.160486
R1544 VGND.t333 VGND.t334 0.158289
R1545 VGND.t330 VGND.t331 0.158289
R1546 VGND.t321 VGND.t322 0.158289
R1547 VGND.t318 VGND.t319 0.158289
R1548 VGND.t315 VGND.t316 0.158289
R1549 VGND.t310 VGND.t309 0.158289
R1550 VGND.t307 VGND.t356 0.158289
R1551 VGND.t23 VGND.n197 0.07903
R1552 VGND.n399 VGND.t5 0.13649
R1553 VGND.t10 VGND.n245 0.206156
R1554 VGND.n399 VGND.t245 0.123476
R1555 VGND.n90 VGND.t211 0.108686
R1556 VGND.t326 VGND.t327 0.10425
R1557 VGND.t312 VGND.t359 0.10425
R1558 VGND.t309 VGND.n238 0.0354445
R1559 VGND.t356 VGND.n240 0.0354445
R1560 VGND.n243 VGND.t325 0.0657511
R1561 VGND.n242 VGND.t313 0.0657511
R1562 VGND.n202 VGND.t376 0.0716964
R1563 VGND.t19 VGND.n204 0.0900423
R1564 VGND.t610 VGND.t612 0.0855
R1565 VGND.t605 VGND.t607 0.0855
R1566 VGND.t600 VGND.t602 0.0855
R1567 VGND.t595 VGND.t597 0.0855
R1568 VGND.t590 VGND.t592 0.0855
R1569 VGND.t585 VGND.t587 0.0855
R1570 VGND.t578 VGND.t582 0.0855
R1571 VGND.t486 VGND.t488 0.0855
R1572 VGND.t493 VGND.t491 0.0855
R1573 VGND.t496 VGND.t498 0.0855
R1574 VGND.t503 VGND.t501 0.0855
R1575 VGND.t506 VGND.t508 0.0855
R1576 VGND.t513 VGND.t511 0.0855
R1577 VGND.t516 VGND.t518 0.0855
R1578 VGND.t523 VGND.t521 0.0855
R1579 VGND.t526 VGND.t528 0.0855
R1580 VGND.t533 VGND.t531 0.0855
R1581 VGND.t536 VGND.t538 0.0855
R1582 VGND.t543 VGND.t541 0.0855
R1583 VGND.t546 VGND.t548 0.0855
R1584 VGND.t553 VGND.t551 0.0855
R1585 VGND.t556 VGND.t558 0.0855
R1586 VGND.t563 VGND.t561 0.0855
R1587 VGND.t566 VGND.t568 0.0855
R1588 VGND.t573 VGND.t571 0.0855
R1589 VGND.t22 VGND.t296 0.0855
R1590 VGND.t576 VGND.t579 0.08175
R1591 VGND.t211 VGND.t210 0.080789
R1592 VGND.t196 VGND.n271 0.04675
R1593 VGND.t291 VGND.t292 0.0405
R1594 VGND.n152 VGND.t258 0.958817
R1595 VGND.n430 VGND 0.01018
R1596 VGND.t594 VGND.n117 183.805
R1597 VGND.t575 VGND.n117 183.805
R1598 VGND.n117 VGND.t490 183.805
R1599 VGND.n117 VGND.n203 2.58853
R1600 VGND.n248 VGND.t12 1.21748
R1601 VGND.n92 VGND.t21 1.17575
R1602 VGND.n73 VGND.t55 1.17078
R1603 VGND.t258 VGND.n91 1.11903
R1604 VGND.n64 VGND.n43 1.08125
R1605 VGND.n375 VGND.n89 1.00135
R1606 sg13cmos5l_dfrbp_1_2.RESET_B sg13cmos5l_dfrbp_1_2.RESET_B.n2 41.6397
R1607 sg13cmos5l_dfrbp_1_2.RESET_B.t2 sg13cmos5l_dfrbp_1_2.RESET_B.t1 33.4028
R1608 sg13cmos5l_dfrbp_1_2.RESET_B.t3 sg13cmos5l_dfrbp_1_2.RESET_B.t4 33.4028
R1609 sg13cmos5l_dfrbp_1_2.RESET_B.t5 sg13cmos5l_dfrbp_1_2.RESET_B.t6 33.4028
R1610 sg13cmos5l_dfrbp_1_2.RESET_B sg13cmos5l_dfrbp_1_2.RESET_B.t2 15.0489
R1611 sg13cmos5l_dfrbp_1_2.RESET_B sg13cmos5l_dfrbp_1_2.RESET_B.t3 15.0005
R1612 sg13cmos5l_dfrbp_1_2.RESET_B sg13cmos5l_dfrbp_1_2.RESET_B.t5 15.0005
R1613 sg13cmos5l_dfrbp_1_2.RESET_B.n0 sg13cmos5l_dfrbp_1_2.RESET_B 11.2357
R1614 sg13cmos5l_dfrbp_1_2.RESET_B.n2 sg13cmos5l_dfrbp_1_2.RESET_B.n0 11.1447
R1615 sg13cmos5l_dfrbp_1_2.RESET_B.n1 sg13cmos5l_dfrbp_1_2.RESET_B 10.5273
R1616 sg13cmos5l_dfrbp_1_2.RESET_B.n2 sg13cmos5l_dfrbp_1_2.RESET_B.n1 9.92146
R1617 sg13cmos5l_dfrbp_1_2.RESET_B.n1 sg13cmos5l_dfrbp_1_2.RESET_B 9.04885
R1618 sg13cmos5l_dfrbp_1_2.RESET_B.n0 sg13cmos5l_dfrbp_1_2.RESET_B 9.00217
R1619 sg13cmos5l_dfrbp_1_2.RESET_B sg13cmos5l_dfrbp_1_2.RESET_B.t0 6.3941
C0 sg13cmos5l_inv_1_118.A sg13cmos5l_inv_1_31.A 0.01055f
C1 sg13cmos5l_inv_1_19.Y a_6197_4656# 0.02975f
C2 sg13cmos5l_inv_1_127.Y sg13cmos5l_inv_1_129.Y 0.18635f
C3 a_6848_6254# sg13cmos5l_nand2_1_1.B 0.04321f
C4 sg13cmos5l_mux4_1_3.A1 sg13cmos5l_o21ai_1_6.B1 0.74926f
C5 sg13cmos5l_o21ai_1_2.B1 sg13cmos5l_inv_1_107.Y 0.05439f
C6 sg13cmos5l_inv_1_3.Y sg13cmos5l_inv_1_6.Y 0.1539f
C7 sg13cmos5l_inv_1_22.Y sg13cmos5l_dfrbp_1_2.RESET_B 0.548f
C8 sg13cmos5l_inv_1_54.Y sg13cmos5l_inv_1_60.Y 0.1599f
C9 VPWR sg13cmos5l_inv_1_23.Y 0.57597f
C10 a_3776_6254# VPWR 0.1198f
C11 a_5566_9946# a_5743_10240# 0.01068f
C12 a_5243_9984# sg13cmos5l_mux4_1_1.A2 0.02133f
C13 sg13cmos5l_inv_1_58.A sg13cmos5l_inv_1_64.Y 0.18584f
C14 a_15784_6254# a_15968_6254# 0.11523f
C15 a_4414_8434# sg13cmos5l_mux2_1_2.X 0.2332f
C16 sg13cmos5l_inv_1_43.A sg13cmos5l_inv_1_44.A 0.20065f
C17 sg13cmos5l_inv_1_60.A sg13cmos5l_inv_1_75.Y 0.52041f
C18 VPWR a_6676_7216# 0.29852f
C19 sg13cmos5l_dfrbp_1_2.D a_4860_3505# 0.0586f
C20 sg13cmos5l_inv_1_123.Y VPWR 0.43166f
C21 sg13cmos5l_inv_1_27.Y VPWR 0.44785f
C22 sg13cmos5l_a221oi_1_0.B1 sg13cmos5l_inv_1_116.A 0.01228f
C23 sg13cmos5l_nor2_1_1.A sg13cmos5l_buf_1_12.X 0.47004f
C24 sg13cmos5l_o21ai_1_0.A2 a_2043_6960# 0.05085f
C25 a_5505_6516# VPWR 0.71633f
C26 sg13cmos5l_nor4_1_0.D a_7629_5004# 0.05324f
C27 sg13cmos5l_dfrbp_1_2.RESET_B a_808_9192# 0.04647f
C28 sg13cmos5l_inv_1_14.A a_992_4742# 0.03646f
C29 sg13cmos5l_buf_1_1.X sg13cmos5l_inv_1_22.Y 0.16987f
C30 sg13cmos5l_inv_1_34.Y sg13cmos5l_o21ai_1_0.A2 0.09167f
C31 sg13cmos5l_o21ai_1_1.A2 sg13cmos5l_a221oi_1_0.A2 0.011f
C32 sg13cmos5l_a21o_1_0.X sg13cmos5l_inv_1_7.Y 0.02095f
C33 a_4199_6558# a_5014_6558# 0.49917f
C34 a_19048_9278# VPWR 0.17282f
C35 sg13cmos5l_inv_1_73.Y sg13cmos5l_inv_1_68.A 0.36299f
C36 sg13cmos5l_inv_1_72.Y sg13cmos5l_inv_1_36.A 0.0141f
C37 sg13cmos5l_inv_1_37.Y sg13cmos5l_inv_1_72.A 0.79208f
C38 sg13cmos5l_o21ai_1_5.B1 a_5110_5402# 0.05201f
C39 sg13cmos5l_a21o_1_0.X a_7629_5004# 0.0694f
C40 sg13cmos5l_inv_1_98.Y sg13cmos5l_inv_1_97.A 0.24243f
C41 sg13cmos5l_mux2_1_0.S sg13cmos5l_o21ai_1_3.B1 0.1536f
C42 sg13cmos5l_buf_1_1.X sg13cmos5l_nor2b_1_0.B_N 0.06278f
C43 sg13cmos5l_inv_1_98.A a_12992_8562# 0.03545f
C44 a_3776_9278# VPWR 0.11938f
C45 sg13cmos5l_dfrbp_1_2.RESET_B sg13cmos5l_inv_1_73.Y 0.16075f
C46 sg13cmos5l_mux4_1_3.A1 a_11457_8476# 0.03166f
C47 VPWR a_10016_7050# 0.08084f
C48 a_2038_6546# sg13cmos5l_o21ai_1_0.A2 0.10097f
C49 sg13cmos5l_o21ai_1_3.Y sg13cmos5l_inv_1_83.A 0.01199f
C50 sg13cmos5l_mux2_1_7.A1 VPWR 0.93163f
C51 sg13cmos5l_mux4_1_0.S0 sg13cmos5l_inv_1_75.A 0.15003f
C52 sg13cmos5l_a221oi_1_0.C1 a_6368_7050# 0.03993f
C53 sg13cmos5l_inv_1_104.Y a_13760_10074# 0.04512f
C54 VPWR a_11420_7660# 0.01858f
C55 sg13cmos5l_nand3b_1_0.Y sg13cmos5l_dfrbp_1_2.RESET_B 1.18553f
C56 a_3016_6168# sg13cmos5l_buf_1_4.A 0.33554f
C57 sg13cmos5l_dfrbp_1_0.D a_5687_4285# 0.30784f
C58 VPWR sg13cmos5l_inv_1_74.A 0.43214f
C59 sg13cmos5l_nor2b_1_0.B_N a_6574_7216# 0.19068f
C60 sg13cmos5l_inv_1_69.Y a_5063_8434# 0.0264f
C61 sg13cmos5l_buf_1_2.X sg13cmos5l_inv_1_55.Y 0.01946f
C62 sg13cmos5l_buf_1_4.A sg13cmos5l_mux4_1_1.A0 0.21874f
C63 a_10933_6516# sg13cmos5l_buf_1_2.X 0.03259f
C64 sg13cmos5l_inv_1_14.A a_3862_5402# 0.10331f
C65 sg13cmos5l_o21ai_1_3.Y a_10966_8434# 0.0308f
C66 sg13cmos5l_inv_1_28.Y VPWR 0.51381f
C67 sg13cmos5l_a221oi_1_0.B1 sg13cmos5l_inv_1_24.A 0.01225f
C68 sg13cmos5l_nand2_1_1.B a_6368_7050# 0.04384f
C69 sg13cmos5l_o21ai_1_3.B1 a_13917_7950# 0.3304f
C70 sg13cmos5l_nor4_1_0.D sg13cmos5l_and2_1_0.B 0.2347f
C71 sg13cmos5l_mux4_1_3.A1 a_11533_8440# 0.02041f
C72 sg13cmos5l_o21ai_1_6.B1 a_10151_8434# 0.01312f
C73 sg13cmos5l_inv_1_93.A a_13760_7050# 0.01213f
C74 sg13cmos5l_inv_1_106.Y a_11176_9278# 0.03335f
C75 sg13cmos5l_inv_1_118.Y sg13cmos5l_dfrbp_1_2.RESET_B 0.02715f
C76 a_13917_9462# sg13cmos5l_inv_1_98.A 0.02031f
C77 sg13cmos5l_nor2_1_1.A sg13cmos5l_inv_1_129.Y 0.05492f
C78 sg13cmos5l_buf_1_1.X sg13cmos5l_nand3b_1_0.Y 0.26424f
C79 sg13cmos5l_buf_1_4.A a_3116_6882# 0.33927f
C80 sg13cmos5l_o21ai_1_0.Y a_4510_6558# 0.1077f
C81 a_4199_6558# sg13cmos5l_o21ai_1_5.Y 0.08403f
C82 sg13cmos5l_inv_1_37.Y sg13cmos5l_inv_1_37.A 0.49475f
C83 sg13cmos5l_inv_1_87.Y sg13cmos5l_inv_1_133.Y 0.27822f
C84 sg13cmos5l_inv_1_73.Y sg13cmos5l_inv_1_72.A 0.18369f
C85 sg13cmos5l_inv_1_72.Y sg13cmos5l_inv_1_68.Y 0.98192f
C86 sg13cmos5l_inv_1_98.A VPWR 0.66874f
C87 sg13cmos5l_o21ai_1_2.B1 a_11446_9570# 0.05758f
C88 sg13cmos5l_a21o_1_0.X sg13cmos5l_and2_1_0.B 0.03173f
C89 sg13cmos5l_o21ai_1_0.A1 sg13cmos5l_inv_1_69.Y 0.51102f
C90 a_4347_5448# sg13cmos5l_inv_1_16.Y 0.20094f
C91 sg13cmos5l_o21ai_1_0.A1 sg13cmos5l_buf_1_12.X 0.24646f
C92 a_7520_5538# VPWR 0.06556f
C93 sg13cmos5l_inv_1_39.A sg13cmos5l_inv_1_37.Y 0.0201f
C94 sg13cmos5l_inv_1_52.A VPWR 0.38125f
C95 a_5992_4742# a_6197_4656# 0.01003f
C96 a_6333_5596# VPWR 0.28635f
C97 sg13cmos5l_nand2_1_1.A sg13cmos5l_a221oi_1_0.A2 0.31796f
C98 sg13cmos5l_inv_1_126.Y sg13cmos5l_inv_1_127.Y 0.15241f
C99 a_6333_5596# a_6760_5538# 0.01439f
C100 a_14136_6430# a_14202_6192# 0.03336f
C101 a_14030_6434# a_14462_6192# 0.02925f
C102 sg13cmos5l_inv_1_30.Y sg13cmos5l_o21ai_1_0.A1 0.32214f
C103 sg13cmos5l_inv_1_12.Y sg13cmos5l_o21ai_1_0.A1 0.73716f
C104 a_5063_8434# a_5287_8701# 0.01074f
C105 a_5781_3191# a_5687_3191# 0.87117f
C106 sg13cmos5l_inv_1_6.A sg13cmos5l_mux2_1_0.S 0.01222f
C107 sg13cmos5l_inv_1_15.Y sg13cmos5l_buf_1_0.X 0.17144f
C108 sg13cmos5l_inv_1_104.Y sg13cmos5l_inv_1_103.A 0.18681f
C109 sg13cmos5l_inv_1_72.Y sg13cmos5l_mux2_1_3.X 2.50082f
C110 sg13cmos5l_o21ai_1_0.Y sg13cmos5l_buf_1_4.A 0.87186f
C111 sg13cmos5l_mux4_1_2.A3 sg13cmos5l_inv_1_83.A 0.0225f
C112 sg13cmos5l_inv_1_118.Y sg13cmos5l_inv_1_14.A 0.02295f
C113 VPWR sg13cmos5l_inv_1_75.A 0.47316f
C114 sg13cmos5l_mux4_1_1.A2 sg13cmos5l_mux2_1_3.X 0.34342f
C115 sg13cmos5l_mux2_1_3.A0 sg13cmos5l_inv_1_72.Y 0.17515f
C116 sg13cmos5l_inv_1_57.A sg13cmos5l_inv_1_58.A 0.20065f
C117 sg13cmos5l_inv_1_69.Y sg13cmos5l_mux2_1_2.X 1.63757f
C118 sg13cmos5l_inv_1_70.A sg13cmos5l_buf_1_4.A 0.38767f
C119 sg13cmos5l_inv_1_42.A sg13cmos5l_inv_1_43.A 0.20065f
C120 sg13cmos5l_inv_1_55.Y sg13cmos5l_inv_1_60.A 0.03618f
C121 a_5243_9984# VPWR 1.01069f
C122 sg13cmos5l_buf_1_2.X sg13cmos5l_inv_1_53.Y 0.02395f
C123 a_1765_6538# a_1563_6224# 0.01126f
C124 sg13cmos5l_nand2_1_1.B a_1184_9278# 0.0154f
C125 sg13cmos5l_inv_1_6.Y VPWR 1.07968f
C126 sg13cmos5l_inv_1_11.A sg13cmos5l_o21ai_1_0.B1 0.02201f
C127 sg13cmos5l_inv_1_92.A a_12904_7050# 0.02418f
C128 sg13cmos5l_inv_1_138.Y VPWR 0.67963f
C129 sg13cmos5l_inv_1_96.A a_10016_7050# 0.03523f
C130 a_10462_5410# a_10365_5410# 0.01637f
C131 sg13cmos5l_o21ai_1_6.B1 sg13cmos5l_mux4_1_0.S0 0.05039f
C132 sg13cmos5l_a221oi_1_0.B1 sg13cmos5l_o21ai_1_1.A2 0.30232f
C133 sg13cmos5l_o21ai_1_6.B1 sg13cmos5l_o21ai_1_6.Y 0.29948f
C134 sg13cmos5l_inv_1_118.A sg13cmos5l_dfrbp_1_2.RESET_B 0.03303f
C135 sg13cmos5l_mux2_1_7.A1 sg13cmos5l_inv_1_7.Y 0.56304f
C136 a_4199_6558# sg13cmos5l_o21ai_1_7.Y 0.19498f
C137 a_6662_3582# a_7467_3155# 0.11742f
C138 a_6948_3148# a_7365_3155# 0.49014f
C139 sg13cmos5l_inv_1_73.Y sg13cmos5l_inv_1_37.A 0.02418f
C140 sg13cmos5l_o21ai_1_3.A2 sg13cmos5l_inv_1_111.A 0.17666f
C141 a_11544_9172# VPWR 0.01784f
C142 sg13cmos5l_inv_1_15.Y a_4187_4712# 0.17114f
C143 a_14030_6434# VPWR 0.10929f
C144 a_14030_5596# a_14202_5704# 0.01068f
C145 sg13cmos5l_mux2_1_0.S sg13cmos5l_inv_1_83.A 0.0746f
C146 sg13cmos5l_o21ai_1_0.A2 sg13cmos5l_inv_1_33.Y 0.45471f
C147 sg13cmos5l_inv_1_40.A sg13cmos5l_inv_1_37.Y 0.0317f
C148 sg13cmos5l_inv_1_36.A VPWR 0.52171f
C149 sg13cmos5l_inv_1_104.Y sg13cmos5l_o21ai_1_2.B1 0.10605f
C150 a_4109_3858# a_4839_4112# 0.3087f
C151 a_6948_3148# a_8113_3505# 0.4858f
C152 VPWR osc 0.19003f
C153 sg13cmos5l_inv_1_15.Y sg13cmos5l_o21ai_1_0.A1 0.09387f
C154 a_10462_5410# sg13cmos5l_buf_1_10.X 0.16163f
C155 a_11736_4918# a_12062_4680# 0.02749f
C156 sg13cmos5l_mux2_1_3.X sg13cmos5l_mux4_1_0.S0 0.0408f
C157 sg13cmos5l_inv_1_118.A sg13cmos5l_inv_1_14.A 0.01175f
C158 a_6922_3112# sg13cmos5l_dfrbp_1_2.RESET_B 0.32715f
C159 a_10139_5448# a_10462_5410# 0.55132f
C160 sg13cmos5l_nand2b_1_6.A_N VPWR 0.50964f
C161 sg13cmos5l_nand2_1_1.A a_1184_8562# 0.0125f
C162 sg13cmos5l_mux2_1_0.S a_10966_8434# 0.04456f
C163 a_4991_4164# a_5781_4052# 0.02241f
C164 a_4839_4112# a_4860_3858# 0.38871f
C165 sg13cmos5l_mux2_1_4.A1 sg13cmos5l_inv_1_44.A 0.02295f
C166 sg13cmos5l_inv_1_69.A VPWR 0.48646f
C167 sg13cmos5l_nand2b_1_6.A_N a_6760_5538# 0.05448f
C168 a_4510_5026# a_5120_4742# 0.0344f
C169 sg13cmos5l_mux2_1_0.S a_11360_9278# 0.06067f
C170 sg13cmos5l_nand2_1_1.B sg13cmos5l_inv_1_37.Y 0.05392f
C171 VPWR sg13cmos5l_nor2b_1_2.Y 0.2044f
C172 sg13cmos5l_inv_1_31.Y a_1563_6224# 0.03247f
C173 sg13cmos5l_nand3b_1_0.C a_4991_3115# 0.36203f
C174 a_4839_3231# a_5642_3424# 0.15089f
C175 sg13cmos5l_a221oi_1_0.C1 sg13cmos5l_nor2b_1_0.B_N 0.20896f
C176 sg13cmos5l_mux4_1_0.S0 a_11457_8476# 0.2038f
C177 a_8207_3505# sg13cmos5l_dfrbp_1_2.RESET_B 0.20049f
C178 sg13cmos5l_inv_1_83.A a_13917_7950# 0.05764f
C179 sg13cmos5l_inv_1_116.A a_10016_7050# 0.05751f
C180 sg13cmos5l_buf_1_10.X sg13cmos5l_o21ai_1_4.Y 0.02301f
C181 VPWR a_19136_8562# 0.05666f
C182 a_5687_4285# a_5642_4052# 0.36169f
C183 sg13cmos5l_inv_1_45.A a_5566_9946# 0.1001f
C184 sg13cmos5l_buf_1_2.X sg13cmos5l_a221oi_1_0.B1 0.24542f
C185 sg13cmos5l_mux4_1_0.S0 a_808_6956# 0.28827f
C186 a_3776_5538# VPWR 0.11395f
C187 a_5687_4285# sg13cmos5l_dfrbp_1_2.RESET_B 0.12182f
C188 sg13cmos5l_inv_1_51.Y sg13cmos5l_inv_1_37.A 0.10416f
C189 sg13cmos5l_inv_1_88.A sg13cmos5l_inv_1_87.Y 0.2023f
C190 sg13cmos5l_nor4_1_0.D a_7616_4026# 0.0377f
C191 sg13cmos5l_o21ai_1_7.Y a_3862_5402# 0.12054f
C192 sg13cmos5l_inv_1_97.A sg13cmos5l_inv_1_111.A 0.04188f
C193 a_13856_6254# VPWR 0.08914f
C194 sg13cmos5l_o21ai_1_6.B1 VPWR 0.83217f
C195 sg13cmos5l_buf_1_0.X a_6662_3582# 0.04658f
C196 sg13cmos5l_nand3b_1_0.C a_6662_3582# 0.32766f
C197 sg13cmos5l_inv_1_70.A sg13cmos5l_mux4_1_1.A0 0.05202f
C198 sg13cmos5l_dfrbp_1_1.CLK a_7365_3155# 0.35449f
C199 sg13cmos5l_mux2_1_0.S sg13cmos5l_nand2b_1_2.Y 0.59597f
C200 sg13cmos5l_buf_1_10.X sg13cmos5l_o21ai_1_3.A2 0.28734f
C201 a_5992_4742# sg13cmos5l_dfrbp_1_2.RESET_B 0.02162f
C202 sg13cmos5l_nand2_1_1.A sg13cmos5l_a221oi_1_0.B1 0.02202f
C203 sg13cmos5l_nand2_1_1.B sg13cmos5l_nor2b_1_0.B_N 0.08322f
C204 sg13cmos5l_inv_1_107.A sg13cmos5l_inv_1_98.A 0.01891f
C205 sg13cmos5l_buf_1_0.X a_3990_4069# 0.04987f
C206 sg13cmos5l_inv_1_68.Y VPWR 0.91303f
C207 sg13cmos5l_inv_1_31.Y VPWR 0.59563f
C208 sg13cmos5l_mux4_1_2.A3 sg13cmos5l_inv_1_92.A 0.08284f
C209 sg13cmos5l_inv_1_119.Y sg13cmos5l_inv_1_126.Y 0.10644f
C210 sg13cmos5l_buf_1_12.X sg13cmos5l_mux4_1_0.X 0.20629f
C211 VPWR invsel[2] 0.10803f
C212 sg13cmos5l_nand3b_1_0.C a_7467_3155# 0.02508f
C213 a_808_9192# sg13cmos5l_nand2_1_1.B 0.29228f
C214 sg13cmos5l_buf_1_1.X a_5687_4285# 0.02773f
C215 a_13917_7950# a_14344_7766# 0.01439f
C216 sg13cmos5l_inv_1_123.A a_11736_4918# 0.03408f
C217 sg13cmos5l_mux4_1_0.S0 a_11533_8440# 0.35946f
C218 a_7020_5004# VPWR 0.37592f
C219 a_10151_8434# sg13cmos5l_o21ai_1_4.Y 0.08571f
C220 a_4860_3505# sg13cmos5l_dfrbp_1_2.RESET_B 0.49179f
C221 sg13cmos5l_inv_1_69.Y a_6369_8476# 0.01458f
C222 sg13cmos5l_nand2b_1_4.A_N sg13cmos5l_o21ai_1_2.B1 0.17855f
C223 sg13cmos5l_inv_1_52.A a_4283_9248# 0.02505f
C224 sg13cmos5l_nor2b_1_2.Y a_6124_7216# 0.01489f
C225 sg13cmos5l_mux2_1_4.A1 sg13cmos5l_inv_1_43.A 0.07823f
C226 sg13cmos5l_mux2_1_3.X VPWR 0.72361f
C227 sg13cmos5l_inv_1_53.Y sg13cmos5l_inv_1_55.Y 0.19345f
C228 sg13cmos5l_nand2_1_1.B sg13cmos5l_inv_1_73.Y 0.0558f
C229 a_7520_4742# sg13cmos5l_nor2b_1_0.B_N 0.04806f
C230 sg13cmos5l_inv_1_31.Y sg13cmos5l_inv_1_30.A 0.34183f
C231 sg13cmos5l_mux2_1_3.A0 VPWR 0.92893f
C232 sg13cmos5l_inv_1_15.Y sg13cmos5l_dfrbp_1_2.D 0.01649f
C233 sg13cmos5l_mux2_1_8.X a_10933_6516# 0.03798f
C234 sg13cmos5l_nand2b_1_4.A_N sg13cmos5l_inv_1_104.Y 0.22301f
C235 a_10715_6528# a_10904_6168# 0.40359f
C236 a_18952_1002# a_19136_1002# 0.11523f
C237 sg13cmos5l_inv_1_129.Y sg13cmos5l_inv_1_123.A 0.07443f
C238 sg13cmos5l_inv_1_30.Y sg13cmos5l_inv_1_31.A 0.14291f
C239 a_4423_6219# sg13cmos5l_o21ai_1_0.A1 0.01281f
C240 sg13cmos5l_inv_1_93.A sg13cmos5l_inv_1_94.A 0.19924f
C241 VPWR a_11457_8476# 0.71771f
C242 sg13cmos5l_o21ai_1_7.B1 VPWR 0.45277f
C243 sg13cmos5l_nor2_1_1.A sg13cmos5l_inv_1_119.Y 0.02681f
C244 sg13cmos5l_mux2_1_6.A1 sg13cmos5l_inv_1_87.Y 0.01565f
C245 sg13cmos5l_inv_1_23.Y sg13cmos5l_inv_1_26.Y 0.15756f
C246 sg13cmos5l_buf_1_1.X a_4860_3505# 0.02596f
C247 VPWR a_808_6956# 0.24949f
C248 sg13cmos5l_inv_1_75.Y sg13cmos5l_inv_1_74.Y 0.02897f
C249 sg13cmos5l_buf_1_0.X a_4109_3108# 0.01713f
C250 a_4860_3505# a_4750_3582# 0.4858f
C251 a_11848_5444# sg13cmos5l_mux2_1_0.S 0.32009f
C252 a_4492_3582# a_4839_3231# 0.06778f
C253 a_14030_5596# a_14136_5600# 0.55132f
C254 sg13cmos5l_inv_1_23.Y sg13cmos5l_o21ai_1_1.A2 0.17518f
C255 a_1918_8434# a_1821_8434# 0.01637f
C256 VPWR a_12128_7050# 0.08061f
C257 sg13cmos5l_inv_1_125.Y sg13cmos5l_inv_1_126.Y 0.09104f
C258 a_5374_8434# a_6101_8747# 0.01228f
C259 VPWR invsel[3] 0.10907f
C260 sg13cmos5l_buf_1_10.X a_12022_8058# 0.1021f
C261 a_2043_6960# a_2245_6922# 0.01126f
C262 sg13cmos5l_inv_1_56.Y sg13cmos5l_inv_1_75.Y 0.12894f
C263 sg13cmos5l_inv_1_1.Y sg13cmos5l_buf_1_10.X 0.07199f
C264 sg13cmos5l_buf_1_0.X sg13cmos5l_nand3b_1_0.C 0.92203f
C265 sg13cmos5l_inv_1_56.Y sg13cmos5l_buf_1_2.X 0.98881f
C266 sg13cmos5l_mux4_1_0.S0 sg13cmos5l_o21ai_1_4.Y 0.08489f
C267 sg13cmos5l_nor4_1_0.Y VPWR 0.2551f
C268 sg13cmos5l_inv_1_118.Y sg13cmos5l_inv_1_11.A 0.12488f
C269 sg13cmos5l_inv_1_1.Y a_10139_5448# 0.15776f
C270 a_5687_3191# VPWR 0.93219f
C271 sg13cmos5l_nand2_1_1.Y sg13cmos5l_nor2_1_1.A 0.12224f
C272 a_10904_6168# sg13cmos5l_mux4_1_0.S0 0.02662f
C273 VPWR a_11533_8440# 0.12158f
C274 sg13cmos5l_mux2_1_4.A1 sg13cmos5l_inv_1_42.A 0.19544f
C275 sg13cmos5l_nand2_1_1.B a_4606_9562# 0.01205f
C276 a_808_3932# VPWR 0.26614f
C277 sg13cmos5l_nand2_1_1.B sg13cmos5l_inv_1_51.Y 0.27551f
C278 sg13cmos5l_inv_1_95.A sg13cmos5l_inv_1_109.A 0.2023f
C279 sg13cmos5l_inv_1_94.A a_13760_7050# 0.03497f
C280 sg13cmos5l_mux4_1_0.S0 sg13cmos5l_o21ai_1_3.A2 0.43133f
C281 sg13cmos5l_mux4_1_2.A1 a_10933_6516# 0.14722f
C282 a_6848_6254# VPWR 0.093f
C283 a_7365_3155# VPWR 0.26181f
C284 sg13cmos5l_inv_1_75.A a_8192_7766# 0.03567f
C285 sg13cmos5l_nor2_1_1.A sg13cmos5l_inv_1_125.Y 0.03295f
C286 a_4991_4164# VPWR 0.24057f
C287 sg13cmos5l_mux2_1_6.A1 sg13cmos5l_inv_1_88.A 0.11131f
C288 sg13cmos5l_inv_1_72.Y a_1184_9278# 0.03465f
C289 sg13cmos5l_buf_1_0.X a_4187_4712# 0.19825f
C290 sg13cmos5l_dfrbp_1_2.D a_4991_3115# 0.02348f
C291 a_10600_9278# a_10784_9278# 0.11523f
C292 sg13cmos5l_inv_1_15.Y sg13cmos5l_dfrbp_1_0.D 0.02662f
C293 a_10462_5410# VPWR 0.11659f
C294 sg13cmos5l_a221oi_1_0.B1 sg13cmos5l_a221oi_1_0.A2 0.05318f
C295 sg13cmos5l_inv_1_30.Y sg13cmos5l_inv_1_33.Y 0.01097f
C296 sg13cmos5l_mux2_1_3.X a_5374_8434# 0.15756f
C297 a_4510_6558# a_5505_6516# 0.48298f
C298 sg13cmos5l_inv_1_126.Y a_8192_5538# 0.01257f
C299 sg13cmos5l_inv_1_125.Y sg13cmos5l_inv_1_119.Y 0.51001f
C300 sg13cmos5l_and2_1_0.X sg13cmos5l_inv_1_126.Y 0.0526f
C301 VPWR invsel[4] 0.11105f
C302 sg13cmos5l_inv_1_27.Y sg13cmos5l_inv_1_25.Y 0.1118f
C303 sg13cmos5l_inv_1_56.Y sg13cmos5l_inv_1_60.A 0.02232f
C304 sg13cmos5l_inv_1_132.Y VPWR 0.47173f
C305 sg13cmos5l_mux4_1_2.A1 a_13856_5538# 0.01449f
C306 a_5505_6516# sg13cmos5l_buf_1_2.X 0.24448f
C307 sg13cmos5l_a21oi_1_0.Y VPWR 0.23682f
C308 a_6142_2428# VPWR 0.32016f
C309 sg13cmos5l_inv_1_118.A sg13cmos5l_inv_1_11.A 0.48406f
C310 sg13cmos5l_inv_1_20.A a_10139_5448# 0.01207f
C311 sg13cmos5l_inv_1_99.Y sg13cmos5l_o21ai_1_2.B1 0.01635f
C312 a_9544_4026# VPWR 0.17297f
C313 VPWR sg13cmos5l_o21ai_1_4.Y 0.50038f
C314 a_6944_4026# VPWR 0.08105f
C315 sg13cmos5l_mux2_1_6.A0 a_15880_5538# 0.0199f
C316 sg13cmos5l_inv_1_68.Y a_1918_8434# 0.01331f
C317 sg13cmos5l_mux2_1_0.X a_10933_6516# 0.13831f
C318 sg13cmos5l_mux4_1_2.A1 sg13cmos5l_mux2_1_8.X 0.10687f
C319 a_5505_6516# sg13cmos5l_buf_1_4.A 0.02171f
C320 a_10904_6168# VPWR 0.02997f
C321 a_19136_1002# VPWR 0.05698f
C322 sg13cmos5l_inv_1_45.A a_6184_10074# 0.02965f
C323 VPWR sg13cmos5l_o21ai_1_3.A2 0.76442f
C324 sg13cmos5l_o21ai_1_2.B1 a_11936_9278# 0.03913f
C325 sg13cmos5l_o21ai_1_4.Y a_11314_8058# 0.12886f
C326 sg13cmos5l_inv_1_72.Y sg13cmos5l_inv_1_37.Y 0.23988f
C327 sg13cmos5l_inv_1_105.Y a_10784_9278# 0.04853f
C328 sg13cmos5l_mux2_1_0.A1 a_11630_4922# 0.58988f
C329 sg13cmos5l_inv_1_100.Y sg13cmos5l_nand2b_1_4.A_N 0.12033f
C330 sg13cmos5l_dfrbp_1_2.D a_4750_3894# 0.01043f
C331 sg13cmos5l_mux2_1_3.A0 a_4283_9248# 0.01919f
C332 a_1918_8434# sg13cmos5l_mux2_1_3.X 0.2269f
C333 a_5243_9984# a_5469_10240# 0.02749f
C334 a_4091_8472# a_4591_8728# 0.03336f
C335 sg13cmos5l_inv_1_111.A sg13cmos5l_inv_1_83.A 0.1035f
C336 a_4414_8434# a_4317_8728# 0.02925f
C337 sg13cmos5l_inv_1_119.Y a_8192_5538# 0.04578f
C338 sg13cmos5l_mux2_1_3.A0 a_1918_8434# 0.10346f
C339 sg13cmos5l_nand3b_1_0.Y a_5781_3191# 0.03626f
C340 sg13cmos5l_and2_1_0.X sg13cmos5l_inv_1_119.Y 0.1637f
C341 VPWR a_6368_7050# 0.0797f
C342 sg13cmos5l_dfrbp_1_2.RESET_B sg13cmos5l_buf_1_12.X 0.16367f
C343 sg13cmos5l_inv_1_28.Y sg13cmos5l_inv_1_25.Y 0.01076f
C344 sg13cmos5l_mux2_1_2.X a_5063_8434# 0.3024f
C345 sg13cmos5l_inv_1_56.Y sg13cmos5l_inv_1_55.Y 0.16401f
C346 a_10784_9278# VPWR 0.07232f
C347 sg13cmos5l_dfrbp_1_2.D a_4109_3108# 0.06767f
C348 sg13cmos5l_inv_1_117.A VPWR 0.48397f
C349 sg13cmos5l_mux2_1_0.X a_11630_4922# 0.2476f
C350 sg13cmos5l_mux2_1_8.X sg13cmos5l_mux2_1_0.A1 0.01252f
C351 sg13cmos5l_mux2_1_4.A1 sg13cmos5l_o21ai_1_0.A1 0.1083f
C352 a_7240_9278# VPWR 0.14743f
C353 a_10885_8701# a_10462_8434# 0.01929f
C354 sg13cmos5l_inv_1_30.Y sg13cmos5l_dfrbp_1_2.RESET_B 0.1611f
C355 sg13cmos5l_inv_1_12.Y sg13cmos5l_dfrbp_1_2.RESET_B 0.07066f
C356 a_6369_8476# a_7048_8562# 0.03389f
C357 sg13cmos5l_nand2_1_1.B sg13cmos5l_mux2_1_4.A0 0.30217f
C358 a_1563_6224# sg13cmos5l_o21ai_1_0.B1 0.33122f
C359 sg13cmos5l_buf_1_0.X sg13cmos5l_dfrbp_1_2.D 0.40006f
C360 sg13cmos5l_dfrbp_1_2.D sg13cmos5l_nand3b_1_0.C 1.71848f
C361 sg13cmos5l_inv_1_94.A sg13cmos5l_inv_1_95.A 0.20065f
C362 sg13cmos5l_mux2_1_0.X sg13cmos5l_mux2_1_8.X 0.08008f
C363 sg13cmos5l_o21ai_1_0.A1 sg13cmos5l_mux2_1_2.X 0.08032f
C364 sg13cmos5l_dfrbp_1_0.D a_3990_4069# 0.25116f
C365 sg13cmos5l_mux4_1_3.A1 a_10966_8434# 0.02797f
C366 VPWR sg13cmos5l_inv_1_97.A 0.53491f
C367 sg13cmos5l_mux4_1_0.S0 sg13cmos5l_o21ai_1_3.B1 0.15919f
C368 a_15784_6254# VPWR 0.14101f
C369 sg13cmos5l_inv_1_72.Y sg13cmos5l_inv_1_73.Y 0.06143f
C370 sg13cmos5l_o21ai_1_5.B1 a_6333_5596# 0.33029f
C371 a_4199_6558# sg13cmos5l_mux4_1_0.S0 0.54902f
C372 sg13cmos5l_inv_1_75.Y sg13cmos5l_inv_1_75.A 0.09269f
C373 sg13cmos5l_nand3b_1_0.Y a_5781_4052# 0.02955f
C374 sg13cmos5l_buf_1_4.A sg13cmos5l_inv_1_52.A 0.17423f
C375 sg13cmos5l_inv_1_14.A sg13cmos5l_inv_1_12.Y 0.23514f
C376 VPWR a_12022_8058# 0.01854f
C377 a_6333_5596# sg13cmos5l_buf_1_4.A 0.34448f
C378 sg13cmos5l_inv_1_1.Y VPWR 0.65588f
C379 a_5014_6558# sg13cmos5l_buf_1_12.X 0.01024f
C380 a_1184_9278# VPWR 0.07762f
C381 VPWR sg13cmos5l_o21ai_1_0.B1 0.59047f
C382 sg13cmos5l_inv_1_129.Y a_9832_5538# 0.05379f
C383 sg13cmos5l_inv_1_82.Y a_15968_6254# 0.0111f
C384 sg13cmos5l_inv_1_125.Y a_8192_5538# 0.03571f
C385 sg13cmos5l_o21ai_1_1.A2 sg13cmos5l_nor2b_1_2.Y 0.6544f
C386 sg13cmos5l_and2_1_0.X sg13cmos5l_inv_1_125.Y 0.22678f
C387 sg13cmos5l_buf_1_10.X sg13cmos5l_inv_1_83.A 0.71399f
C388 sg13cmos5l_dfrbp_1_2.D a_4187_4712# 0.04017f
C389 sg13cmos5l_o21ai_1_7.B1 sg13cmos5l_inv_1_19.A 0.02775f
C390 sg13cmos5l_inv_1_8.Y VPWR 0.59778f
C391 sg13cmos5l_inv_1_54.Y VPWR 0.44125f
C392 sg13cmos5l_o21ai_1_3.Y a_10462_8434# 0.10857f
C393 sg13cmos5l_inv_1_15.Y sg13cmos5l_dfrbp_1_2.RESET_B 0.01008f
C394 sg13cmos5l_buf_1_4.A a_5243_9984# 0.16325f
C395 sg13cmos5l_a221oi_1_0.A2 a_6676_7216# 0.01246f
C396 a_13917_9462# a_13760_9278# 0.03547f
C397 sg13cmos5l_o21ai_1_6.A2 a_9622_8426# 0.08096f
C398 sg13cmos5l_a21o_1_0.X sg13cmos5l_inv_1_130.A 0.04377f
C399 sg13cmos5l_mux2_1_0.S sg13cmos5l_inv_1_107.Y 1.46213f
C400 a_13760_9278# VPWR 0.11599f
C401 sg13cmos5l_mux2_1_4.A1 a_4720_9562# 0.02076f
C402 sg13cmos5l_inv_1_68.A a_1595_8472# 0.20812f
C403 sg13cmos5l_mux2_1_0.X sg13cmos5l_mux4_1_2.A1 0.33691f
C404 sg13cmos5l_o21ai_1_0.A1 a_2043_6960# 0.36978f
C405 a_6944_5538# VPWR 0.0694f
C406 sg13cmos5l_nor2b_1_0.B_N a_6676_6944# 0.01753f
C407 sg13cmos5l_mux2_1_4.A0 sg13cmos5l_inv_1_66.A 0.03925f
C408 a_6760_5538# a_6944_5538# 0.11523f
C409 sg13cmos5l_o21ai_1_0.A1 sg13cmos5l_inv_1_34.Y 0.0149f
C410 sg13cmos5l_inv_1_72.Y sg13cmos5l_inv_1_51.Y 0.18367f
C411 a_14136_6430# sg13cmos5l_mux2_1_6.A1 0.31158f
C412 sg13cmos5l_inv_1_12.Y sg13cmos5l_mux2_1_1.X 0.01671f
C413 sg13cmos5l_buf_1_0.X sg13cmos5l_dfrbp_1_0.D 0.22547f
C414 a_5642_3424# a_5687_3191# 0.36169f
C415 a_11736_4918# sg13cmos5l_mux2_1_0.S 0.19204f
C416 sg13cmos5l_inv_1_73.Y sg13cmos5l_mux4_1_0.S0 0.01592f
C417 a_14136_5600# sg13cmos5l_mux2_1_0.S 0.20982f
C418 sg13cmos5l_inv_1_60.A sg13cmos5l_inv_1_75.A 0.01951f
C419 sg13cmos5l_inv_1_18.A sg13cmos5l_inv_1_12.Y 0.04976f
C420 sg13cmos5l_inv_1_14.A sg13cmos5l_inv_1_15.Y 0.25647f
C421 VPWR sg13cmos5l_o21ai_1_3.B1 0.6818f
C422 sg13cmos5l_inv_1_99.Y sg13cmos5l_inv_1_100.Y 0.20065f
C423 sg13cmos5l_inv_1_20.A VPWR 0.36813f
C424 sg13cmos5l_inv_1_37.Y VPWR 0.48045f
C425 a_4199_6558# VPWR 0.45046f
C426 sg13cmos5l_nand2_1_0.Y sg13cmos5l_a21oi_1_0.Y 0.11835f
C427 sg13cmos5l_mux2_1_6.A0 sg13cmos5l_mux2_1_7.A1 0.46971f
C428 sg13cmos5l_a221oi_1_0.B1 sg13cmos5l_inv_1_74.Y 0.08821f
C429 a_2038_6546# sg13cmos5l_o21ai_1_0.A1 0.12881f
C430 sg13cmos5l_buf_1_2.X sg13cmos5l_nor2b_1_2.Y 0.02888f
C431 sg13cmos5l_buf_1_10.X sg13cmos5l_nand2b_1_2.Y 0.0449f
C432 sg13cmos5l_mux4_1_0.S0 sg13cmos5l_inv_1_29.A 0.08747f
C433 sg13cmos5l_o21ai_1_5.Y sg13cmos5l_inv_1_12.Y 0.02217f
C434 sg13cmos5l_inv_1_6.Y a_12904_4742# 0.04688f
C435 a_992_4742# VPWR 0.06618f
C436 sg13cmos5l_o21ai_1_5.B1 sg13cmos5l_nand2b_1_6.A_N 0.29901f
C437 sg13cmos5l_mux2_1_0.X sg13cmos5l_mux2_1_0.A1 0.03666f
C438 a_10151_8434# a_10966_8434# 0.49917f
C439 sg13cmos5l_nand2b_1_6.A_N sg13cmos5l_buf_1_4.A 0.25242f
C440 VPWR a_6272_7766# 0.12156f
C441 sg13cmos5l_inv_1_22.Y VPWR 0.80357f
C442 sg13cmos5l_nand2_1_1.A sg13cmos5l_inv_1_69.A 1.4276f
C443 sg13cmos5l_buf_1_4.A sg13cmos5l_inv_1_69.A 1.95713f
C444 a_11176_9278# sg13cmos5l_o21ai_1_4.Y 0.01016f
C445 sg13cmos5l_nand2_1_1.A sg13cmos5l_nor2b_1_2.Y 0.66998f
C446 sg13cmos5l_a21o_1_0.X sg13cmos5l_mux2_1_0.A1 0.86609f
C447 VPWR sg13cmos5l_nor2b_1_0.B_N 0.7298f
C448 sg13cmos5l_o21ai_1_6.B1 sg13cmos5l_buf_1_2.X 0.2952f
C449 a_6922_3112# a_6948_3148# 0.43042f
C450 sg13cmos5l_dfrbp_1_0.D a_4187_4712# 0.18501f
C451 sg13cmos5l_o21ai_1_7.B1 sg13cmos5l_inv_1_16.Y 0.21992f
C452 sg13cmos5l_inv_1_72.A a_1595_8472# 0.01795f
C453 a_6760_5538# sg13cmos5l_nor2b_1_0.B_N 0.01786f
C454 sg13cmos5l_o21ai_1_0.A1 sg13cmos5l_inv_1_31.A 0.11262f
C455 a_4991_3115# sg13cmos5l_dfrbp_1_2.RESET_B 0.05204f
C456 sg13cmos5l_inv_1_138.Y a_8576_5538# 0.01271f
C457 a_808_9192# VPWR 0.24597f
C458 sg13cmos5l_inv_1_10.Y sg13cmos5l_buf_1_12.X 0.0133f
C459 sg13cmos5l_dfrbp_1_0.Q a_3776_4026# 0.01132f
C460 sg13cmos5l_mux4_1_0.A0 a_4210_6914# 0.12617f
C461 a_1184_5538# VPWR 0.07805f
C462 a_6948_3148# a_8207_3505# 0.01741f
C463 sg13cmos5l_mux4_1_0.S0 sg13cmos5l_inv_1_83.A 0.04609f
C464 sg13cmos5l_mux2_1_6.A1 a_14202_6538# 0.02105f
C465 a_808_4742# a_992_4742# 0.11523f
C466 sg13cmos5l_nor4_1_0.D sg13cmos5l_a21o_1_0.X 0.39998f
C467 a_11630_4922# a_11802_4680# 0.01068f
C468 sg13cmos5l_inv_1_7.Y sg13cmos5l_inv_1_8.Y 0.21108f
C469 sg13cmos5l_inv_1_35.Y a_4210_6914# 0.05973f
C470 sg13cmos5l_inv_1_68.Y sg13cmos5l_nand2_1_1.A 0.01673f
C471 sg13cmos5l_inv_1_124.Y sg13cmos5l_inv_1_0.Y 0.20065f
C472 sg13cmos5l_buf_1_4.A sg13cmos5l_inv_1_68.Y 0.96948f
C473 sg13cmos5l_inv_1_10.Y sg13cmos5l_inv_1_12.Y 0.76181f
C474 sg13cmos5l_inv_1_56.Y a_8768_9278# 0.04514f
C475 sg13cmos5l_mux2_1_3.X a_4091_8472# 0.01817f
C476 a_6662_3582# sg13cmos5l_dfrbp_1_2.RESET_B 0.09463f
C477 sg13cmos5l_mux4_1_0.S0 sg13cmos5l_mux4_1_0.A0 0.42476f
C478 sg13cmos5l_inv_1_73.Y VPWR 1.90017f
C479 a_3862_5402# VPWR 0.0158f
C480 sg13cmos5l_inv_1_82.A a_15968_6254# 0.03465f
C481 sg13cmos5l_mux2_1_0.S a_10462_8434# 0.03767f
C482 a_4991_4164# a_4860_3858# 0.49014f
C483 a_8464_3386# a_8113_3505# 0.01017f
C484 a_8207_3505# a_9044_3144# 0.1333f
C485 sg13cmos5l_a221oi_1_0.B1 sg13cmos5l_inv_1_23.Y 0.04535f
C486 a_4510_5026# a_4413_4680# 0.02925f
C487 a_4187_4712# a_4687_4680# 0.03336f
C488 sg13cmos5l_nor4_1_0.Y a_7616_4026# 0.01442f
C489 a_11848_5444# sg13cmos5l_buf_1_10.X 0.31772f
C490 sg13cmos5l_buf_1_1.X a_4991_3115# 0.04529f
C491 sg13cmos5l_mux2_1_0.S a_11446_9570# 0.10078f
C492 sg13cmos5l_inv_1_133.Y sg13cmos5l_mux2_1_0.S 0.01239f
C493 VPWR a_4316_7236# 0.01784f
C494 sg13cmos5l_o21ai_1_7.Y sg13cmos5l_inv_1_12.Y 0.07666f
C495 a_4860_3505# a_5781_3191# 0.43042f
C496 a_4750_3582# a_4991_3115# 0.01058f
C497 sg13cmos5l_inv_1_6.A VPWR 0.75663f
C498 sg13cmos5l_mux4_1_0.S0 a_10966_8434# 0.05441f
C499 a_6849_4656# VPWR 0.35651f
C500 sg13cmos5l_buf_1_0.X ffsel[0] 0.01038f
C501 sg13cmos5l_inv_1_70.A sg13cmos5l_inv_1_52.A 0.06713f
C502 sg13cmos5l_a221oi_1_0.B1 a_6676_7216# 0.03165f
C503 a_7467_3155# sg13cmos5l_dfrbp_1_2.RESET_B 0.55134f
C504 sg13cmos5l_nand3b_1_0.Y VPWR 1.18993f
C505 sg13cmos5l_inv_1_34.Y a_2043_6960# 0.01978f
C506 a_10462_5410# a_10639_5704# 0.01068f
C507 VPWR sg13cmos5l_inv_1_29.A 0.51679f
C508 sg13cmos5l_buf_1_4.A sg13cmos5l_mux2_1_3.X 0.09368f
C509 a_5687_4285# a_5781_4052# 0.87117f
C510 a_4492_3894# a_4750_3894# 0.01017f
C511 sg13cmos5l_mux2_1_3.A0 sg13cmos5l_buf_1_4.A 0.03529f
C512 sg13cmos5l_inv_1_36.A a_2920_8562# 0.03352f
C513 sg13cmos5l_inv_1_37.A a_1595_8472# 0.03532f
C514 sg13cmos5l_nand2_1_1.B sg13cmos5l_inv_1_69.Y 0.03063f
C515 a_11848_5444# sg13cmos5l_inv_1_3.Y 0.03376f
C516 sg13cmos5l_nand2_1_1.B a_7412_6886# 0.35375f
C517 sg13cmos5l_nand2_1_1.B sg13cmos5l_buf_1_12.X 0.20329f
C518 sg13cmos5l_inv_1_70.A a_5243_9984# 0.20897f
C519 sg13cmos5l_inv_1_118.Y VPWR 0.43393f
C520 sg13cmos5l_inv_1_17.A a_992_4742# 0.01054f
C521 sg13cmos5l_mux4_1_1.A2 sg13cmos5l_mux2_1_4.A0 0.04096f
C522 a_14030_6434# sg13cmos5l_mux2_1_6.A0 0.10611f
C523 sg13cmos5l_inv_1_11.A sg13cmos5l_inv_1_12.Y 0.12356f
C524 sg13cmos5l_inv_1_99.A sg13cmos5l_inv_1_99.Y 0.20065f
C525 VPWR sg13cmos5l_inv_1_83.A 1.07785f
C526 sg13cmos5l_inv_1_73.A a_808_7766# 0.03352f
C527 a_4606_9562# VPWR 0.11132f
C528 sg13cmos5l_inv_1_69.A a_2920_8562# 0.01986f
C529 sg13cmos5l_o21ai_1_0.A1 sg13cmos5l_inv_1_33.Y 0.39001f
C530 a_4839_4112# a_4839_3231# 0.01307f
C531 sg13cmos5l_inv_1_51.Y VPWR 0.36141f
C532 a_4109_3108# sg13cmos5l_dfrbp_1_2.RESET_B 0.20027f
C533 sg13cmos5l_inv_1_69.Y a_5878_8434# 0.01703f
C534 sg13cmos5l_inv_1_19.Y VPWR 0.42924f
C535 sg13cmos5l_inv_1_72.Y sg13cmos5l_o21ai_1_0.A2 0.01039f
C536 a_808_3932# sg13cmos5l_buf_1_2.X 0.2908f
C537 sg13cmos5l_mux2_1_0.S sg13cmos5l_o21ai_1_2.B1 0.45039f
C538 sg13cmos5l_dfrbp_1_0.D sg13cmos5l_dfrbp_1_2.D 1.15992f
C539 a_7629_5004# sg13cmos5l_nor2b_1_0.B_N 0.16173f
C540 sg13cmos5l_o21ai_1_7.Y sg13cmos5l_inv_1_15.Y 1.0497f
C541 VPWR sg13cmos5l_mux4_1_0.A0 0.43798f
C542 sg13cmos5l_inv_1_118.Y sg13cmos5l_inv_1_30.A 0.16047f
C543 sg13cmos5l_inv_1_130.Y sg13cmos5l_inv_1_123.A 0.40441f
C544 a_10571_6132# a_10715_6528# 0.26108f
C545 sg13cmos5l_inv_1_83.A a_11314_8058# 0.08077f
C546 a_7726_3936# sg13cmos5l_dfrbp_1_1.CLK 0.28516f
C547 sg13cmos5l_inv_1_34.Y sg13cmos5l_inv_1_31.A 0.02874f
C548 VPWR sg13cmos5l_inv_1_35.Y 0.59024f
C549 sg13cmos5l_buf_1_0.X sg13cmos5l_dfrbp_1_2.RESET_B 0.36184f
C550 sg13cmos5l_inv_1_23.Y sg13cmos5l_inv_1_74.Y 0.16494f
C551 sg13cmos5l_nand3b_1_0.C sg13cmos5l_dfrbp_1_2.RESET_B 0.23291f
C552 sg13cmos5l_nand2_1_1.Y a_7066_6538# 0.01589f
C553 VPWR a_10966_8434# 0.03053f
C554 sg13cmos5l_inv_1_76.A sg13cmos5l_inv_1_34.Y 0.19028f
C555 a_11360_9278# VPWR 0.06449f
C556 sg13cmos5l_buf_1_1.X a_4109_3108# 0.01407f
C557 VPWR a_14344_7766# 0.13213f
C558 a_4109_3108# a_4750_3582# 0.32273f
C559 sg13cmos5l_inv_1_37.Y a_1918_8434# 0.03341f
C560 sg13cmos5l_mux4_1_0.S0 sg13cmos5l_inv_1_92.A 0.17115f
C561 a_7948_4192# sg13cmos5l_dfrbp_1_1.CLK 0.01417f
C562 sg13cmos5l_inv_1_33.A a_808_6956# 0.03526f
C563 VPWR a_10888_7050# 0.13509f
C564 a_11848_5444# sg13cmos5l_mux4_1_0.S0 0.01132f
C565 sg13cmos5l_inv_1_118.A VPWR 0.43525f
C566 a_6445_8440# a_6369_8476# 0.2611f
C567 a_14030_6434# a_14524_6538# 0.01637f
C568 a_5374_8434# a_5581_8701# 0.01967f
C569 sg13cmos5l_buf_1_0.X sg13cmos5l_buf_1_1.X 0.2486f
C570 sg13cmos5l_mux4_1_1.A0 sg13cmos5l_mux2_1_3.X 0.0284f
C571 sg13cmos5l_buf_1_1.X sg13cmos5l_nand3b_1_0.C 0.47403f
C572 sg13cmos5l_inv_1_30.Y a_808_6254# 0.02053f
C573 sg13cmos5l_inv_1_72.Y a_4414_8434# 0.09503f
C574 sg13cmos5l_inv_1_123.Y sg13cmos5l_inv_1_124.Y 0.20065f
C575 VPWR sg13cmos5l_nand2b_1_2.Y 0.5447f
C576 a_4187_4712# sg13cmos5l_dfrbp_1_2.RESET_B 0.0115f
C577 sg13cmos5l_inv_1_22.Y sg13cmos5l_and2_1_0.B 0.13366f
C578 sg13cmos5l_mux2_1_7.A1 sg13cmos5l_a21o_1_0.X 0.09021f
C579 sg13cmos5l_nand2_1_0.Y sg13cmos5l_inv_1_22.Y 0.14875f
C580 sg13cmos5l_buf_1_2.X sg13cmos5l_o21ai_1_4.Y 0.07296f
C581 sg13cmos5l_dfrbp_1_2.RESET_B a_808_8468# 0.04269f
C582 sg13cmos5l_a221oi_1_0.B1 sg13cmos5l_inv_1_75.A 0.03787f
C583 sg13cmos5l_inv_1_88.A sg13cmos5l_mux2_1_0.S 0.04252f
C584 sg13cmos5l_mux4_1_0.S0 sg13cmos5l_o21ai_1_0.A2 0.05348f
C585 sg13cmos5l_and2_1_0.B sg13cmos5l_nor2b_1_0.B_N 0.26929f
C586 a_13760_4742# VPWR 0.11868f
C587 sg13cmos5l_inv_1_45.A sg13cmos5l_inv_1_66.A 0.0164f
C588 a_10904_6168# sg13cmos5l_buf_1_2.X 0.03726f
C589 sg13cmos5l_inv_1_118.A sg13cmos5l_inv_1_30.A 0.04585f
C590 sg13cmos5l_inv_1_89.A a_10888_7050# 0.09991f
C591 sg13cmos5l_nand2b_1_2.Y a_11314_8058# 0.03851f
C592 sg13cmos5l_inv_1_76.A sg13cmos5l_inv_1_31.A 0.01167f
C593 sg13cmos5l_inv_1_74.A sg13cmos5l_inv_1_74.Y 0.19244f
C594 a_6922_3112# VPWR 0.10112f
C595 VPWR a_7616_8562# 0.08597f
C596 sg13cmos5l_inv_1_73.A a_1192_10074# 0.02554f
C597 sg13cmos5l_nand2b_1_2.Y sg13cmos5l_inv_1_89.A 0.19491f
C598 sg13cmos5l_dfrbp_1_0.Q VPWR 0.34059f
C599 sg13cmos5l_inv_1_33.Y a_2043_6960# 0.1881f
C600 sg13cmos5l_mux4_1_0.S0 sg13cmos5l_inv_1_91.A 0.02598f
C601 sg13cmos5l_inv_1_34.Y sg13cmos5l_inv_1_33.Y 0.04443f
C602 a_8207_3505# VPWR 0.31715f
C603 sg13cmos5l_mux2_1_4.A0 a_6760_9278# 0.05176f
C604 sg13cmos5l_a221oi_1_0.C1 a_6615_7680# 0.02677f
C605 sg13cmos5l_nand2b_1_4.A_N sg13cmos5l_mux2_1_0.S 0.18633f
C606 VPWR sg13cmos5l_inv_1_92.A 0.73748f
C607 sg13cmos5l_inv_1_64.Y a_7240_9278# 0.01986f
C608 a_5687_4285# VPWR 0.92871f
C609 sg13cmos5l_mux2_1_3.A0 sg13cmos5l_inv_1_70.A 0.06571f
C610 sg13cmos5l_inv_1_14.A sg13cmos5l_o21ai_1_0.A1 0.37616f
C611 sg13cmos5l_mux2_1_0.A1 sg13cmos5l_inv_1_6.Y 0.01723f
C612 a_4414_8434# sg13cmos5l_mux4_1_0.S0 0.03569f
C613 a_11848_5444# VPWR 0.2976f
C614 sg13cmos5l_inv_1_73.A sg13cmos5l_inv_1_76.A 0.05567f
C615 a_5992_4742# VPWR 0.13049f
C616 sg13cmos5l_mux2_1_4.A0 VPWR 0.53675f
C617 a_9720_8748# sg13cmos5l_o21ai_1_6.Y 0.01087f
C618 a_808_5444# a_1184_5538# 0.03376f
C619 a_5566_9946# a_6184_10074# 0.03326f
C620 sg13cmos5l_nand2_1_0.Y sg13cmos5l_nand3b_1_0.Y 0.24026f
C621 a_7726_3936# VPWR 0.21747f
C622 sg13cmos5l_dfrbp_1_0.D a_4687_4680# 0.01198f
C623 sg13cmos5l_mux4_1_0.S0 sg13cmos5l_inv_1_29.Y 0.01688f
C624 sg13cmos5l_mux2_1_6.A1 sg13cmos5l_mux2_1_0.S 0.09209f
C625 sg13cmos5l_inv_1_9.Y VPWR 0.42456f
C626 a_10571_6132# VPWR 0.70688f
C627 sg13cmos5l_inv_1_89.A sg13cmos5l_inv_1_92.A 0.0105f
C628 sg13cmos5l_dfrbp_1_2.D a_4492_3894# 0.04096f
C629 a_19048_1718# VPWR 0.18334f
C630 VPWR sg13cmos5l_o21ai_1_0.A2 1.30112f
C631 sg13cmos5l_nor4_1_0.D sg13cmos5l_inv_1_138.Y 0.05764f
C632 sg13cmos5l_a221oi_1_0.B1 sg13cmos5l_nor2b_1_2.Y 0.18967f
C633 sg13cmos5l_inv_1_74.A sg13cmos5l_inv_1_23.Y 0.19028f
C634 sg13cmos5l_inv_1_75.A sg13cmos5l_inv_1_74.Y 0.93795f
C635 a_4283_9248# a_4606_9562# 0.55132f
C636 a_4860_3505# VPWR 0.07451f
C637 sg13cmos5l_inv_1_118.Y sg13cmos5l_inv_1_13.Y 0.06383f
C638 sg13cmos5l_buf_1_10.X sg13cmos5l_buf_1_12.X 0.1555f
C639 sg13cmos5l_a21o_1_0.X sg13cmos5l_inv_1_6.Y 0.18747f
C640 a_4510_5026# a_4624_5026# 0.03097f
C641 sg13cmos5l_inv_1_38.A sg13cmos5l_mux2_1_4.A1 0.22258f
C642 a_4187_4712# sg13cmos5l_mux2_1_1.X 0.01402f
C643 a_12808_8562# a_12992_8562# 0.11523f
C644 sg13cmos5l_inv_1_33.Y sg13cmos5l_inv_1_31.A 0.1298f
C645 sg13cmos5l_inv_1_68.A a_2032_8434# 0.02075f
C646 a_14030_5596# a_14524_5410# 0.01637f
C647 sg13cmos5l_o21ai_1_7.B1 a_4347_5448# 0.36798f
C648 sg13cmos5l_dfrbp_1_2.D sg13cmos5l_dfrbp_1_2.RESET_B 0.21742f
C649 a_1595_8472# a_2095_8728# 0.03336f
C650 a_1918_8434# a_1821_8728# 0.02925f
C651 sg13cmos5l_inv_1_70.A a_5680_9946# 0.01671f
C652 VPWR sg13cmos5l_inv_1_91.A 0.4238f
C653 sg13cmos5l_inv_1_19.A sg13cmos5l_nand3b_1_0.Y 0.02515f
C654 sg13cmos5l_inv_1_19.Y sg13cmos5l_nand2_1_0.Y 0.04257f
C655 sg13cmos5l_inv_1_72.Y sg13cmos5l_inv_1_69.Y 0.4875f
C656 sg13cmos5l_dfrbp_1_2.RESET_B sg13cmos5l_inv_1_34.Y 0.01583f
C657 sg13cmos5l_inv_1_28.Y sg13cmos5l_inv_1_27.Y 0.2023f
C658 sg13cmos5l_inv_1_69.Y sg13cmos5l_nor3_1_0.C 0.02407f
C659 sg13cmos5l_a21o_1_0.X osc 0.12239f
C660 sg13cmos5l_inv_1_97.A sg13cmos5l_inv_1_93.A 0.01025f
C661 a_4414_8434# VPWR 0.11594f
C662 VPWR a_9720_8748# 0.01829f
C663 sg13cmos5l_o21ai_1_1.A2 sg13cmos5l_nor2b_1_0.B_N 0.02104f
C664 sg13cmos5l_dfrbp_1_2.D sg13cmos5l_buf_1_1.X 0.35664f
C665 sg13cmos5l_mux2_1_6.A0 sg13cmos5l_inv_1_132.Y 0.10042f
C666 sg13cmos5l_inv_1_5.Y VPWR 0.42302f
C667 sg13cmos5l_dfrbp_1_2.D a_4750_3582# 0.01967f
C668 a_10904_6168# a_10933_6516# 0.97548f
C669 a_10462_8434# a_11189_8747# 0.01228f
C670 a_13917_7950# a_13999_8050# 0.01126f
C671 VPWR sg13cmos5l_inv_1_29.Y 0.63273f
C672 a_7616_4026# sg13cmos5l_nor2b_1_0.B_N 0.04984f
C673 a_3776_4742# VPWR 0.11847f
C674 sg13cmos5l_mux4_1_3.A1 a_10462_8434# 0.17219f
C675 sg13cmos5l_inv_1_45.A sg13cmos5l_mux4_1_1.A2 0.15142f
C676 VPWR a_12808_8562# 0.18918f
C677 sg13cmos5l_inv_1_106.Y sg13cmos5l_o21ai_1_6.B1 0.03217f
C678 sg13cmos5l_inv_1_118.A sg13cmos5l_inv_1_13.Y 0.02328f
C679 sg13cmos5l_nor2_1_1.A sg13cmos5l_nand2_1_1.B 0.05734f
C680 a_4199_6558# a_4510_6558# 0.49675f
C681 sg13cmos5l_dfrbp_1_2.RESET_B a_1192_10074# 0.02116f
C682 a_11176_9278# a_11360_9278# 0.11523f
C683 a_11446_9570# sg13cmos5l_mux4_1_3.A1 0.11628f
C684 sg13cmos5l_o21ai_1_2.B1 a_12093_9462# 0.01104f
C685 sg13cmos5l_inv_1_19.A sg13cmos5l_inv_1_19.Y 0.09044f
C686 sg13cmos5l_inv_1_122.Y a_10600_9278# 0.03352f
C687 sg13cmos5l_inv_1_129.Y sg13cmos5l_buf_1_10.X 0.37383f
C688 sg13cmos5l_nand3b_1_0.Y a_4860_3858# 0.04182f
C689 sg13cmos5l_mux4_1_2.A3 a_14136_6430# 0.02041f
C690 a_11457_8476# sg13cmos5l_a221oi_1_0.B1 0.20329f
C691 sg13cmos5l_inv_1_3.Y a_11736_4918# 0.02152f
C692 sg13cmos5l_mux2_1_8.X a_10462_5410# 0.2293f
C693 sg13cmos5l_dfrbp_1_0.D a_4492_3894# 0.17501f
C694 sg13cmos5l_nor4_1_0.Y a_6664_4742# 0.03829f
C695 sg13cmos5l_inv_1_129.Y a_10139_5448# 0.04452f
C696 VPWR sg13cmos5l_inv_1_90.A 0.42841f
C697 sg13cmos5l_inv_1_52.A a_3776_9278# 0.03571f
C698 sg13cmos5l_inv_1_125.Y a_7336_5538# 0.02958f
C699 sg13cmos5l_inv_1_72.A sg13cmos5l_inv_1_34.Y 0.04067f
C700 sg13cmos5l_dfrbp_1_2.RESET_B sg13cmos5l_inv_1_31.A 0.02171f
C701 sg13cmos5l_inv_1_7.Y sg13cmos5l_inv_1_9.Y 0.24145f
C702 sg13cmos5l_inv_1_16.Y a_3862_5402# 0.01694f
C703 sg13cmos5l_inv_1_123.A sg13cmos5l_mux2_1_0.S 0.23492f
C704 a_10208_9278# VPWR 0.08357f
C705 sg13cmos5l_inv_1_37.Y sg13cmos5l_nand2_1_1.A 0.74193f
C706 sg13cmos5l_buf_1_4.A sg13cmos5l_inv_1_37.Y 0.33052f
C707 a_4199_6558# sg13cmos5l_buf_1_4.A 0.01345f
C708 sg13cmos5l_inv_1_69.Y sg13cmos5l_mux4_1_0.S0 1.08128f
C709 sg13cmos5l_inv_1_83.A sg13cmos5l_inv_1_111.Y 0.02202f
C710 sg13cmos5l_dfrbp_1_0.D sg13cmos5l_dfrbp_1_2.RESET_B 0.35127f
C711 sg13cmos5l_mux4_1_0.S0 sg13cmos5l_buf_1_12.X 0.52726f
C712 sg13cmos5l_o21ai_1_0.A1 a_4160_9278# 0.03597f
C713 sg13cmos5l_o21ai_1_7.Y sg13cmos5l_o21ai_1_0.A1 0.23395f
C714 sg13cmos5l_buf_1_2.X sg13cmos5l_nor2b_1_0.B_N 0.0353f
C715 a_12904_9278# VPWR 0.21547f
C716 a_14136_6430# sg13cmos5l_mux2_1_0.S 0.19845f
C717 sg13cmos5l_a21o_1_0.X a_7020_5004# 0.21223f
C718 sg13cmos5l_mux2_1_6.A0 sg13cmos5l_inv_1_117.A 0.11298f
C719 sg13cmos5l_inv_1_4.Y VPWR 0.44308f
C720 sg13cmos5l_nand2_1_1.A a_6272_7766# 0.03846f
C721 sg13cmos5l_inv_1_22.Y sg13cmos5l_buf_1_4.A 0.01198f
C722 sg13cmos5l_inv_1_30.Y sg13cmos5l_mux4_1_0.S0 0.21295f
C723 sg13cmos5l_o21ai_1_3.B1 sg13cmos5l_inv_1_93.A 0.01544f
C724 sg13cmos5l_inv_1_89.A sg13cmos5l_inv_1_90.A 0.16948f
C725 sg13cmos5l_o21ai_1_5.B1 sg13cmos5l_nor2b_1_0.B_N 0.01945f
C726 sg13cmos5l_inv_1_75.A sg13cmos5l_inv_1_74.A 0.07352f
C727 sg13cmos5l_mux2_1_4.A0 a_4283_9248# 0.02921f
C728 sg13cmos5l_nand2_1_1.A sg13cmos5l_nor2b_1_0.B_N 0.07698f
C729 sg13cmos5l_buf_1_4.A sg13cmos5l_nor2b_1_0.B_N 0.15502f
C730 sg13cmos5l_inv_1_118.A sg13cmos5l_inv_1_17.Y 0.03727f
C731 sg13cmos5l_nand2_1_1.Y sg13cmos5l_nand2_1_1.B 0.13278f
C732 sg13cmos5l_dfrbp_1_2.RESET_B sg13cmos5l_inv_1_73.A 0.48217f
C733 sg13cmos5l_o21ai_1_2.B1 sg13cmos5l_mux4_1_3.A1 0.26766f
C734 sg13cmos5l_inv_1_82.Y VPWR 0.42754f
C735 sg13cmos5l_dfrbp_1_0.D sg13cmos5l_buf_1_1.X 1.34637f
C736 a_4991_3115# a_5781_3191# 0.02241f
C737 a_14030_5596# sg13cmos5l_mux2_1_0.S 0.14462f
C738 sg13cmos5l_inv_1_122.Y sg13cmos5l_inv_1_105.Y 0.16061f
C739 sg13cmos5l_inv_1_72.Y a_1595_8472# 0.04913f
C740 a_5581_6442# sg13cmos5l_mux4_1_0.X 0.01016f
C741 a_8968_5538# VPWR 0.13423f
C742 sg13cmos5l_a21oi_1_0.Y a_6664_4742# 0.02579f
C743 a_2136_6148# VPWR 0.01838f
C744 VPWR a_19048_7050# 0.14401f
C745 sg13cmos5l_inv_1_130.A a_9544_4026# 0.05955f
C746 sg13cmos5l_mux2_1_6.A0 a_15784_6254# 0.01579f
C747 sg13cmos5l_nand2_1_1.B sg13cmos5l_o21ai_1_0.A1 0.03455f
C748 sg13cmos5l_o21ai_1_1.A2 sg13cmos5l_mux4_1_0.A0 0.02149f
C749 a_19048_5538# a_19048_4742# 0.01095f
C750 a_5063_8434# a_5878_8434# 0.49917f
C751 sg13cmos5l_inv_1_125.Y sg13cmos5l_nand2_1_1.B 0.02347f
C752 sg13cmos5l_inv_1_30.Y a_1563_6224# 0.22069f
C753 sg13cmos5l_inv_1_7.Y sg13cmos5l_inv_1_5.Y 0.01677f
C754 sg13cmos5l_inv_1_122.Y VPWR 0.43319f
C755 sg13cmos5l_inv_1_73.Y sg13cmos5l_nand2_1_1.A 0.44848f
C756 sg13cmos5l_buf_1_4.A sg13cmos5l_inv_1_73.Y 0.01247f
C757 sg13cmos5l_inv_1_29.A sg13cmos5l_nand2b_1_1.Y 0.07665f
C758 sg13cmos5l_inv_1_35.Y sg13cmos5l_o21ai_1_1.A2 0.1185f
C759 sg13cmos5l_inv_1_83.A sg13cmos5l_inv_1_113.A 0.1885f
C760 sg13cmos5l_nand3b_1_0.Y sg13cmos5l_buf_1_2.X 0.03014f
C761 a_10151_8434# a_10462_8434# 0.49675f
C762 sg13cmos5l_mux2_1_4.A1 sg13cmos5l_nand2_1_1.B 0.09016f
C763 sg13cmos5l_inv_1_138.Y sg13cmos5l_inv_1_28.Y 0.23065f
C764 sg13cmos5l_inv_1_16.Y sg13cmos5l_mux4_1_0.A0 0.02097f
C765 sg13cmos5l_nand2b_1_4.A_N a_12093_9462# 0.19611f
C766 sg13cmos5l_nor4_1_0.D sg13cmos5l_nor4_1_0.Y 1.2663f
C767 a_8968_5538# a_9152_5538# 0.11523f
C768 sg13cmos5l_o21ai_1_0.A2 a_2912_7766# 0.01054f
C769 sg13cmos5l_inv_1_69.Y VPWR 0.5482f
C770 sg13cmos5l_o21ai_1_6.A2 sg13cmos5l_buf_1_10.X 0.29964f
C771 a_6662_3582# a_6948_3148# 0.50066f
C772 VPWR a_7412_6886# 0.29509f
C773 sg13cmos5l_o21ai_1_0.Y sg13cmos5l_o21ai_1_0.B1 0.36834f
C774 sg13cmos5l_dfrbp_1_2.RESET_B sg13cmos5l_inv_1_33.Y 0.03797f
C775 sg13cmos5l_a21o_1_0.X sg13cmos5l_nor4_1_0.Y 0.24633f
C776 VPWR sg13cmos5l_buf_1_12.X 1.0109f
C777 sg13cmos5l_buf_1_4.A sg13cmos5l_inv_1_29.A 0.03212f
C778 sg13cmos5l_inv_1_15.Y sg13cmos5l_mux4_1_0.S0 0.01376f
C779 sg13cmos5l_inv_1_1.Y a_11630_4922# 0.03479f
C780 ffsel[1] ffsel[0] 0.0439f
C781 sg13cmos5l_nand2_1_1.B sg13cmos5l_mux2_1_2.X 0.04188f
C782 sg13cmos5l_inv_1_30.Y VPWR 0.64499f
C783 sg13cmos5l_inv_1_12.Y VPWR 0.80579f
C784 sg13cmos5l_nor4_1_0.D a_7365_3155# 0.0131f
C785 sg13cmos5l_inv_1_107.Y a_13917_9462# 0.19317f
C786 a_3990_4069# a_3776_4026# 0.03121f
C787 sg13cmos5l_inv_1_19.A a_5992_4742# 0.03747f
C788 a_7365_3155# a_7236_3569# 0.01562f
C789 a_6948_3148# a_7467_3155# 0.38871f
C790 sg13cmos5l_inv_1_45.A VPWR 0.44844f
C791 sg13cmos5l_dfrbp_1_0.D sg13cmos5l_mux2_1_1.X 0.03159f
C792 sg13cmos5l_inv_1_85.A VPWR 0.44645f
C793 sg13cmos5l_inv_1_107.Y VPWR 0.62517f
C794 sg13cmos5l_inv_1_132.Y a_15880_5538# 0.03094f
C795 sg13cmos5l_a221oi_1_0.B1 sg13cmos5l_o21ai_1_3.A2 0.18913f
C796 a_14136_5600# a_14462_5704# 0.02749f
C797 sg13cmos5l_inv_1_113.A a_14344_7766# 0.03352f
C798 sg13cmos5l_inv_1_70.Y sg13cmos5l_mux2_1_2.X 0.01923f
C799 a_4510_6558# sg13cmos5l_mux4_1_0.A0 0.01301f
C800 sg13cmos5l_mux2_1_8.X sg13cmos5l_inv_1_1.Y 0.01317f
C801 sg13cmos5l_buf_1_12.X sg13cmos5l_inv_1_30.A 0.8899f
C802 sg13cmos5l_inv_1_19.Y sg13cmos5l_buf_1_2.X 0.1184f
C803 a_4991_4164# a_4839_4112# 0.6663f
C804 a_8464_3386# a_8207_3505# 0.35645f
C805 sg13cmos5l_inv_1_37.A sg13cmos5l_inv_1_76.A 0.01549f
C806 sg13cmos5l_inv_1_73.Y sg13cmos5l_inv_1_33.A 0.03654f
C807 sg13cmos5l_nand2b_1_1.Y sg13cmos5l_mux4_1_0.A0 0.20614f
C808 sg13cmos5l_mux2_1_2.X a_5878_8434# 0.22897f
C809 sg13cmos5l_inv_1_30.Y sg13cmos5l_inv_1_30.A 0.34981f
C810 VPWR a_5287_8701# 0.02431f
C811 sg13cmos5l_o21ai_1_5.B1 sg13cmos5l_inv_1_19.Y 0.06862f
C812 sg13cmos5l_inv_1_54.Y sg13cmos5l_inv_1_53.Y 0.01918f
C813 a_11736_4918# VPWR 1.05808f
C814 a_4860_3505# a_5642_3424# 0.4806f
C815 a_14136_5600# VPWR 1.01187f
C816 sg13cmos5l_mux4_1_0.S0 a_10462_8434# 0.04586f
C817 sg13cmos5l_inv_1_35.Y sg13cmos5l_nand2b_1_1.Y 0.02203f
C818 sg13cmos5l_o21ai_1_6.Y a_10462_8434# 0.01621f
C819 sg13cmos5l_inv_1_106.Y sg13cmos5l_o21ai_1_4.Y 0.01008f
C820 a_10139_5448# a_10365_5704# 0.02749f
C821 sg13cmos5l_nor3_1_0.C a_7048_8562# 0.02653f
C822 sg13cmos5l_buf_1_2.X a_10966_8434# 0.02723f
C823 a_4860_3858# a_5687_4285# 0.50066f
C824 sg13cmos5l_inv_1_29.Y a_2912_7766# 0.03465f
C825 sg13cmos5l_a21o_1_0.X sg13cmos5l_inv_1_132.Y 0.05789f
C826 a_4492_3894# sg13cmos5l_dfrbp_1_2.RESET_B 0.17545f
C827 sg13cmos5l_o21ai_1_0.Y a_4199_6558# 0.22305f
C828 sg13cmos5l_nand2b_1_6.A_N a_6333_5596# 0.20842f
C829 sg13cmos5l_nand3b_1_0.C a_5781_3191# 0.01727f
C830 a_4839_3231# a_5687_3191# 0.11742f
C831 sg13cmos5l_nor2_1_1.A sg13cmos5l_buf_1_10.X 0.2654f
C832 sg13cmos5l_buf_1_4.A sg13cmos5l_inv_1_35.Y 0.48652f
C833 sg13cmos5l_mux4_1_2.A3 a_11371_6137# 0.10616f
C834 a_10904_6168# sg13cmos5l_mux2_1_0.X 0.02205f
C835 sg13cmos5l_inv_1_83.A sg13cmos5l_inv_1_93.A 0.22667f
C836 sg13cmos5l_inv_1_73.A sg13cmos5l_inv_1_37.A 0.16841f
C837 sg13cmos5l_mux2_1_3.A0 a_3776_9278# 0.01135f
C838 sg13cmos5l_inv_1_107.A a_12904_9278# 0.03435f
C839 a_4606_9562# a_4509_9216# 0.02925f
C840 sg13cmos5l_inv_1_129.Y VPWR 0.49342f
C841 a_4283_9248# a_4783_9216# 0.03336f
C842 sg13cmos5l_buf_1_2.X a_10888_7050# 0.02729f
C843 a_13760_10074# VPWR 0.11796f
C844 sg13cmos5l_inv_1_15.Y VPWR 0.40665f
C845 sg13cmos5l_a221oi_1_0.A2 sg13cmos5l_nor2b_1_0.B_N 0.35454f
C846 sg13cmos5l_inv_1_44.A VPWR 0.42062f
C847 sg13cmos5l_inv_1_82.A VPWR 0.45105f
C848 sg13cmos5l_buf_1_0.X a_6948_3148# 0.05981f
C849 sg13cmos5l_nand3b_1_0.C a_6948_3148# 0.03955f
C850 sg13cmos5l_inv_1_117.A a_15880_5538# 0.03631f
C851 sg13cmos5l_dfrbp_1_1.CLK a_7467_3155# 0.01951f
C852 a_11630_4922# a_11802_5026# 0.03097f
C853 sg13cmos5l_buf_1_2.X sg13cmos5l_nand2b_1_2.Y 0.06744f
C854 a_5896_2514# sg13cmos5l_dfrbp_1_2.RESET_B 0.01776f
C855 a_4860_3858# a_4860_3505# 0.01103f
C856 a_6142_2428# a_6366_2390# 0.01261f
C857 a_4510_6558# a_4933_6219# 0.01929f
C858 sg13cmos5l_mux2_1_0.S sg13cmos5l_o21ai_1_3.Y 0.04665f
C859 sg13cmos5l_a221oi_1_0.B1 a_12022_8058# 0.01366f
C860 sg13cmos5l_o21ai_1_6.A2 sg13cmos5l_o21ai_1_6.Y 0.02225f
C861 a_1595_8472# VPWR 1.01336f
C862 a_5063_8434# a_5300_8434# 0.01012f
C863 sg13cmos5l_nand3b_1_0.C a_9044_3144# 0.25909f
C864 sg13cmos5l_o21ai_1_7.Y a_3960_5724# 0.01087f
C865 a_11371_6137# sg13cmos5l_mux2_1_0.S 0.05816f
C866 sg13cmos5l_inv_1_93.A a_14344_7766# 0.05383f
C867 a_11067_6960# a_10888_7050# 0.01439f
C868 sg13cmos5l_buf_1_1.X sg13cmos5l_dfrbp_1_2.RESET_B 0.70446f
C869 sg13cmos5l_nand2_1_1.B sg13cmos5l_mux4_1_0.X 0.13757f
C870 sg13cmos5l_nor2_1_1.A a_10715_6528# 0.01029f
C871 sg13cmos5l_nand2_1_1.B a_6445_8440# 0.05588f
C872 sg13cmos5l_inv_1_14.A sg13cmos5l_dfrbp_1_2.RESET_B 0.9593f
C873 VPWR a_10462_8434# 0.88462f
C874 sg13cmos5l_buf_1_1.X a_5896_2514# 0.03569f
C875 sg13cmos5l_mux2_1_7.A1 a_14202_5410# 0.01917f
C876 sg13cmos5l_inv_1_72.A sg13cmos5l_inv_1_68.A 0.27931f
C877 sg13cmos5l_nand2b_1_2.Y a_11067_6960# 0.37149f
C878 a_10933_6516# a_11827_6219# 0.01967f
C879 a_11446_9570# VPWR 0.01374f
C880 sg13cmos5l_inv_1_133.Y VPWR 0.69614f
C881 sg13cmos5l_inv_1_36.A sg13cmos5l_inv_1_69.A 0.08704f
C882 sg13cmos5l_inv_1_37.Y a_1184_8562# 0.01054f
C883 sg13cmos5l_inv_1_20.A sg13cmos5l_inv_1_130.A 0.13737f
C884 sg13cmos5l_inv_1_1.Y sg13cmos5l_inv_1_0.Y 0.14886f
C885 sg13cmos5l_mux2_1_3.A0 sg13cmos5l_inv_1_52.A 0.0901f
C886 sg13cmos5l_nand2_1_1.B a_6369_8476# 0.03937f
C887 sg13cmos5l_inv_1_127.Y VPWR 0.42934f
C888 a_4606_9562# sg13cmos5l_mux4_1_1.A0 0.22704f
C889 invsel[0] ffsel[1] 0.04367f
C890 sg13cmos5l_inv_1_103.A VPWR 0.44424f
C891 a_12093_9462# a_11936_9278# 0.03547f
C892 sg13cmos5l_o21ai_1_0.Y sg13cmos5l_inv_1_29.A 0.02066f
C893 a_18752_6254# VPWR 0.06696f
C894 a_6445_8440# a_5878_8434# 0.40359f
C895 a_5287_8701# a_5374_8434# 0.02548f
C896 a_14030_6434# a_13856_6254# 0.0344f
C897 sg13cmos5l_inv_1_43.A VPWR 0.41749f
C898 sg13cmos5l_inv_1_64.Y sg13cmos5l_mux2_1_4.A0 0.25632f
C899 sg13cmos5l_inv_1_8.Y a_15880_5538# 0.03352f
C900 sg13cmos5l_buf_1_0.X sg13cmos5l_dfrbp_1_2.Q 0.01099f
C901 a_14136_5600# sg13cmos5l_inv_1_7.Y 0.03391f
C902 sg13cmos5l_buf_1_0.X sg13cmos5l_dfrbp_1_1.CLK 0.04564f
C903 sg13cmos5l_dfrbp_1_1.CLK sg13cmos5l_nand3b_1_0.C 0.03097f
C904 sg13cmos5l_inv_1_60.Y a_7712_9278# 0.03603f
C905 sg13cmos5l_mux2_1_4.A0 sg13cmos5l_buf_1_2.X 0.07081f
C906 sg13cmos5l_mux2_1_0.X sg13cmos5l_inv_1_1.Y 0.08444f
C907 sg13cmos5l_inv_1_107.A sg13cmos5l_inv_1_107.Y 1.44694f
C908 sg13cmos5l_buf_1_10.X a_10408_7050# 0.01108f
C909 a_4414_8434# a_4317_8434# 0.01637f
C910 sg13cmos5l_inv_1_22.Y a_6664_4742# 0.0532f
C911 a_4991_3115# VPWR 0.24277f
C912 sg13cmos5l_inv_1_127.Y a_9152_5538# 0.04853f
C913 sg13cmos5l_buf_1_12.X sg13cmos5l_inv_1_116.A 0.05736f
C914 sg13cmos5l_mux4_1_1.A2 a_5063_8434# 0.22973f
C915 sg13cmos5l_inv_1_68.Y sg13cmos5l_inv_1_36.A 0.69696f
C916 a_5878_8434# a_6369_8476# 0.3824f
C917 a_19048_5538# VPWR 0.1716f
C918 sg13cmos5l_buf_1_4.A sg13cmos5l_mux2_1_4.A0 0.02389f
C919 a_10571_6132# sg13cmos5l_buf_1_2.X 0.20489f
C920 sg13cmos5l_mux4_1_2.A3 sg13cmos5l_mux2_1_0.S 0.24774f
C921 sg13cmos5l_mux2_1_6.A0 sg13cmos5l_inv_1_83.A 0.01542f
C922 sg13cmos5l_o21ai_1_6.A2 VPWR 0.88029f
C923 sg13cmos5l_o21ai_1_0.A2 sg13cmos5l_nand2b_1_1.Y 1.06919f
C924 sg13cmos5l_mux2_1_1.X sg13cmos5l_dfrbp_1_2.RESET_B 0.01629f
C925 a_4423_6219# VPWR 0.02431f
C926 sg13cmos5l_inv_1_73.A sg13cmos5l_nand2_1_1.B 0.10246f
C927 sg13cmos5l_inv_1_12.Y sg13cmos5l_inv_1_13.Y 0.14573f
C928 a_6662_3582# VPWR 0.93911f
C929 sg13cmos5l_inv_1_18.A sg13cmos5l_dfrbp_1_2.RESET_B 0.01248f
C930 sg13cmos5l_inv_1_93.A sg13cmos5l_inv_1_92.A 0.15449f
C931 sg13cmos5l_inv_1_83.A sg13cmos5l_inv_1_109.A 0.23182f
C932 sg13cmos5l_dfrbp_1_2.RESET_B enable 0.01006f
C933 sg13cmos5l_mux2_1_7.A1 sg13cmos5l_inv_1_132.Y 0.08445f
C934 sg13cmos5l_o21ai_1_2.B1 a_13917_9462# 0.33557f
C935 sg13cmos5l_a21o_1_0.X sg13cmos5l_inv_1_8.Y 0.01207f
C936 sg13cmos5l_inv_1_72.Y sg13cmos5l_o21ai_1_0.A1 0.05454f
C937 VPWR a_7048_8562# 0.13677f
C938 sg13cmos5l_inv_1_16.Y a_3776_4742# 0.04811f
C939 a_3990_4069# VPWR 0.35557f
C940 sg13cmos5l_o21ai_1_2.B1 VPWR 0.65301f
C941 sg13cmos5l_inv_1_87.Y VPWR 0.38791f
C942 sg13cmos5l_inv_1_68.Y sg13cmos5l_inv_1_69.A 0.05544f
C943 sg13cmos5l_inv_1_36.A sg13cmos5l_mux2_1_3.X 0.01585f
C944 sg13cmos5l_nand2_1_1.A sg13cmos5l_o21ai_1_0.A2 0.03597f
C945 sg13cmos5l_inv_1_70.A a_4606_9562# 0.04609f
C946 sg13cmos5l_buf_1_4.A sg13cmos5l_o21ai_1_0.A2 0.41715f
C947 sg13cmos5l_o21ai_1_0.Y sg13cmos5l_mux4_1_0.A0 0.01251f
C948 sg13cmos5l_mux2_1_3.A0 sg13cmos5l_inv_1_36.A 0.02182f
C949 sg13cmos5l_a221oi_1_0.B1 sg13cmos5l_nor2b_1_0.B_N 0.17831f
C950 sg13cmos5l_inv_1_126.Y VPWR 0.44721f
C951 a_7467_3155# VPWR 0.23644f
C952 sg13cmos5l_inv_1_104.Y VPWR 0.49893f
C953 a_808_5444# sg13cmos5l_buf_1_12.X 0.28849f
C954 sg13cmos5l_dfrbp_1_2.RESET_B invsel[1] 0.4432f
C955 a_5014_6558# a_5581_6442# 0.40359f
C956 sg13cmos5l_o21ai_1_4.Y a_11420_7660# 0.01087f
C957 sg13cmos5l_mux4_1_3.A1 a_11936_9278# 0.01241f
C958 sg13cmos5l_mux2_1_1.X sg13cmos5l_buf_1_1.X 0.14405f
C959 a_808_9980# a_1192_10074# 0.03269f
C960 sg13cmos5l_inv_1_42.A VPWR 0.42688f
C961 sg13cmos5l_inv_1_58.A sg13cmos5l_mux2_1_4.A0 0.01537f
C962 sg13cmos5l_mux2_1_0.A1 a_11802_5026# 0.01813f
C963 a_4091_8472# a_4414_8434# 0.55132f
C964 sg13cmos5l_inv_1_18.A sg13cmos5l_inv_1_14.A 0.36204f
C965 a_5566_9946# a_5469_9946# 0.01637f
C966 sg13cmos5l_mux4_1_0.S0 a_5063_8434# 0.52281f
C967 sg13cmos5l_mux4_1_1.A2 sg13cmos5l_mux2_1_2.X 0.0335f
C968 sg13cmos5l_buf_1_12.X sg13cmos5l_inv_1_24.A 0.02461f
C969 sg13cmos5l_inv_1_12.Y sg13cmos5l_inv_1_19.A 0.11161f
C970 sg13cmos5l_o21ai_1_0.A1 a_4210_6914# 0.11819f
C971 sg13cmos5l_inv_1_29.Y sg13cmos5l_nand2b_1_1.Y 0.02141f
C972 sg13cmos5l_nor2_1_1.A VPWR 0.49581f
C973 sg13cmos5l_inv_1_69.Y a_7232_8562# 0.04583f
C974 sg13cmos5l_buf_1_4.A a_4414_8434# 0.13972f
C975 sg13cmos5l_nor4_1_0.D sg13cmos5l_inv_1_22.Y 0.92424f
C976 a_4109_3108# VPWR 0.25824f
C977 sg13cmos5l_inv_1_83.A sg13cmos5l_inv_1_95.A 0.01145f
C978 sg13cmos5l_o21ai_1_5.Y a_5014_6558# 0.22178f
C979 sg13cmos5l_inv_1_37.A sg13cmos5l_inv_1_72.A 0.026f
C980 sg13cmos5l_inv_1_123.A sg13cmos5l_buf_1_10.X 0.09006f
C981 sg13cmos5l_o21ai_1_0.A1 sg13cmos5l_mux4_1_0.S0 3.93934f
C982 sg13cmos5l_a21o_1_0.X sg13cmos5l_inv_1_22.Y 0.06903f
C983 sg13cmos5l_inv_1_88.A VPWR 0.43804f
C984 sg13cmos5l_nor4_1_0.D sg13cmos5l_nor2b_1_0.B_N 1.01444f
C985 sg13cmos5l_inv_1_68.Y sg13cmos5l_mux2_1_3.X 0.06839f
C986 a_11371_6137# a_12124_6558# 0.01012f
C987 sg13cmos5l_nand2_1_1.A sg13cmos5l_inv_1_29.Y 0.1338f
C988 sg13cmos5l_mux2_1_0.S a_13917_7950# 0.34825f
C989 sg13cmos5l_buf_1_4.A sg13cmos5l_inv_1_29.Y 0.17208f
C990 sg13cmos5l_inv_1_98.A sg13cmos5l_o21ai_1_3.A2 0.07583f
C991 sg13cmos5l_mux2_1_3.A0 sg13cmos5l_inv_1_68.Y 0.02415f
C992 a_1595_8472# a_1918_8434# 0.55132f
C993 sg13cmos5l_o21ai_1_6.B1 a_11457_8476# 0.01112f
C994 sg13cmos5l_inv_1_119.Y VPWR 0.38003f
C995 invsel[1] invsel[0] 0.03658f
C996 sg13cmos5l_a21o_1_0.X sg13cmos5l_nor2b_1_0.B_N 0.19334f
C997 sg13cmos5l_buf_1_0.X VPWR 3.93913f
C998 sg13cmos5l_nand3b_1_0.C VPWR 1.34371f
C999 sg13cmos5l_nand2b_1_6.A_N sg13cmos5l_nor4_1_0.Y 0.02574f
C1000 sg13cmos5l_inv_1_18.Y sg13cmos5l_dfrbp_1_2.RESET_B 0.0171f
C1001 sg13cmos5l_inv_1_39.A sg13cmos5l_inv_1_38.A 0.18681f
C1002 sg13cmos5l_inv_1_103.A sg13cmos5l_inv_1_107.A 0.11728f
C1003 sg13cmos5l_inv_1_10.Y sg13cmos5l_inv_1_14.A 0.15575f
C1004 a_5566_9946# sg13cmos5l_mux4_1_1.A2 0.24917f
C1005 sg13cmos5l_mux2_1_0.S sg13cmos5l_inv_1_98.Y 0.02854f
C1006 sg13cmos5l_mux4_1_0.S0 sg13cmos5l_mux2_1_2.X 0.08637f
C1007 a_5338_5026# sg13cmos5l_nand2_1_0.Y 0.01727f
C1008 sg13cmos5l_nand2b_1_4.A_N VPWR 1.01518f
C1009 sg13cmos5l_mux2_1_3.A0 sg13cmos5l_mux2_1_3.X 0.45223f
C1010 sg13cmos5l_a221oi_1_0.B1 sg13cmos5l_inv_1_83.A 0.15538f
C1011 sg13cmos5l_o21ai_1_1.A2 a_7412_6886# 0.01038f
C1012 sg13cmos5l_o21ai_1_0.A1 a_1563_6224# 0.37868f
C1013 invsel[2] a_808_6956# 0.32459f
C1014 sg13cmos5l_buf_1_12.X sg13cmos5l_o21ai_1_1.A2 5.95575f
C1015 sg13cmos5l_inv_1_72.Y sg13cmos5l_inv_1_34.Y 0.26824f
C1016 sg13cmos5l_nand2_1_1.B sg13cmos5l_inv_1_68.A 0.01173f
C1017 sg13cmos5l_o21ai_1_7.Y sg13cmos5l_inv_1_14.A 0.09261f
C1018 VPWR a_5063_8434# 0.40686f
C1019 sg13cmos5l_inv_1_15.Y sg13cmos5l_inv_1_19.A 0.38025f
C1020 sg13cmos5l_mux2_1_0.X sg13cmos5l_inv_1_6.A 0.22349f
C1021 a_10016_6254# sg13cmos5l_buf_1_12.X 0.0604f
C1022 a_10571_6132# a_10933_6516# 0.48298f
C1023 a_10462_8434# a_10669_8701# 0.01967f
C1024 a_11067_6960# sg13cmos5l_inv_1_90.A 0.03533f
C1025 sg13cmos5l_nand2_1_1.Y VPWR 0.57824f
C1026 sg13cmos5l_dfrbp_1_2.RESET_B sg13cmos5l_nand2_1_1.B 0.23934f
C1027 sg13cmos5l_inv_1_14.A sg13cmos5l_inv_1_18.Y 0.02595f
C1028 a_4187_4712# VPWR 0.96608f
C1029 sg13cmos5l_inv_1_53.Y a_7616_8562# 0.05751f
C1030 invsel[3] invsel[2] 0.04758f
C1031 sg13cmos5l_inv_1_11.A sg13cmos5l_dfrbp_1_2.RESET_B 0.02044f
C1032 sg13cmos5l_a21o_1_0.X sg13cmos5l_inv_1_6.A 0.03513f
C1033 sg13cmos5l_mux2_1_7.A1 sg13cmos5l_inv_1_8.Y 0.05942f
C1034 a_808_8468# VPWR 0.247f
C1035 a_11371_6137# a_12019_6219# 0.01074f
C1036 sg13cmos5l_mux2_1_6.A1 VPWR 0.32379f
C1037 sg13cmos5l_inv_1_12.Y sg13cmos5l_inv_1_16.Y 0.02881f
C1038 sg13cmos5l_inv_1_70.A sg13cmos5l_mux2_1_4.A0 0.08092f
C1039 sg13cmos5l_inv_1_98.A sg13cmos5l_inv_1_97.A 0.48053f
C1040 sg13cmos5l_o21ai_1_0.A1 VPWR 1.84274f
C1041 sg13cmos5l_nor4_1_0.Y a_7020_5004# 0.04398f
C1042 sg13cmos5l_inv_1_107.A sg13cmos5l_o21ai_1_2.B1 0.88563f
C1043 sg13cmos5l_inv_1_125.Y VPWR 0.42576f
C1044 sg13cmos5l_nand2b_1_6.A_N sg13cmos5l_a21oi_1_0.Y 0.01267f
C1045 VPWR a_10408_7050# 0.14687f
C1046 a_6445_8440# sg13cmos5l_nor3_1_0.C 0.02183f
C1047 sg13cmos5l_o21ai_1_0.Y sg13cmos5l_o21ai_1_0.A2 0.01631f
C1048 sg13cmos5l_mux2_1_4.A1 VPWR 0.55647f
C1049 sg13cmos5l_nor2_1_1.A sg13cmos5l_inv_1_96.A 0.04839f
C1050 sg13cmos5l_inv_1_122.Y sg13cmos5l_buf_1_2.X 0.01889f
C1051 sg13cmos5l_inv_1_69.Y a_4091_8472# 0.15507f
C1052 sg13cmos5l_dfrbp_1_0.D a_5781_4052# 0.01508f
C1053 sg13cmos5l_inv_1_10.Y sg13cmos5l_inv_1_18.A 0.25556f
C1054 sg13cmos5l_inv_1_11.A sg13cmos5l_inv_1_14.A 0.09884f
C1055 sg13cmos5l_nor2b_1_0.B_N a_6676_7216# 0.4524f
C1056 sg13cmos5l_inv_1_69.Y sg13cmos5l_buf_1_2.X 0.43464f
C1057 sg13cmos5l_inv_1_100.Y VPWR 0.44243f
C1058 a_6369_8476# sg13cmos5l_nor3_1_0.C 0.21028f
C1059 sg13cmos5l_buf_1_12.X sg13cmos5l_inv_1_25.Y 0.04146f
C1060 sg13cmos5l_a221oi_1_0.B1 sg13cmos5l_nand2b_1_2.Y 0.03235f
C1061 sg13cmos5l_buf_1_12.X sg13cmos5l_nand2b_1_1.Y 0.48672f
C1062 sg13cmos5l_inv_1_72.Y sg13cmos5l_inv_1_76.A 0.11011f
C1063 sg13cmos5l_buf_1_2.X sg13cmos5l_buf_1_12.X 0.03634f
C1064 VPWR sg13cmos5l_mux2_1_2.X 0.42322f
C1065 a_11533_8440# a_11457_8476# 0.2611f
C1066 sg13cmos5l_nand2_1_1.B a_6574_7216# 0.02778f
C1067 sg13cmos5l_inv_1_89.A a_10408_7050# 0.03609f
C1068 sg13cmos5l_nand2_1_1.A sg13cmos5l_inv_1_69.Y 0.46055f
C1069 a_808_6254# sg13cmos5l_dfrbp_1_2.RESET_B 0.01107f
C1070 sg13cmos5l_buf_1_4.A sg13cmos5l_inv_1_69.Y 1.21608f
C1071 VPWR a_808_7766# 0.1261f
C1072 sg13cmos5l_inv_1_38.A sg13cmos5l_nand2_1_1.B 0.0824f
C1073 sg13cmos5l_inv_1_12.Y sg13cmos5l_buf_1_2.X 0.01492f
C1074 sg13cmos5l_inv_1_18.A sg13cmos5l_inv_1_18.Y 0.285f
C1075 sg13cmos5l_inv_1_126.Y sg13cmos5l_and2_1_0.B 0.01549f
C1076 sg13cmos5l_mux4_1_3.A1 sg13cmos5l_o21ai_1_3.Y 0.74619f
C1077 sg13cmos5l_nand2_1_1.A a_7412_6886# 0.10667f
C1078 sg13cmos5l_nand2_1_1.B sg13cmos5l_inv_1_60.Y 0.02486f
C1079 sg13cmos5l_nand2_1_1.A sg13cmos5l_buf_1_12.X 0.02789f
C1080 sg13cmos5l_buf_1_4.A sg13cmos5l_buf_1_12.X 1.06319f
C1081 sg13cmos5l_o21ai_1_7.Y sg13cmos5l_o21ai_1_5.Y 0.06578f
C1082 sg13cmos5l_inv_1_12.Y a_4510_5026# 0.01171f
C1083 a_4991_3115# a_5642_3424# 0.01562f
C1084 sg13cmos5l_inv_1_68.A a_2095_8728# 0.01611f
C1085 sg13cmos5l_inv_1_15.Y sg13cmos5l_inv_1_16.Y 0.15334f
C1086 sg13cmos5l_inv_1_12.Y sg13cmos5l_o21ai_1_5.B1 0.41455f
C1087 sg13cmos5l_buf_1_10.X a_9622_8426# 0.12442f
C1088 sg13cmos5l_inv_1_12.Y sg13cmos5l_buf_1_4.A 0.05811f
C1089 a_8192_5538# VPWR 0.0797f
C1090 sg13cmos5l_inv_1_73.A sg13cmos5l_inv_1_72.Y 0.54893f
C1091 sg13cmos5l_a21oi_1_0.Y a_7020_5004# 0.27213f
C1092 sg13cmos5l_and2_1_0.X VPWR 0.34328f
C1093 sg13cmos5l_inv_1_45.A sg13cmos5l_buf_1_4.A 0.1388f
C1094 a_3776_6254# sg13cmos5l_inv_1_29.A 0.03553f
C1095 a_14136_6430# a_14462_6192# 0.02749f
C1096 sg13cmos5l_inv_1_18.Y a_2920_4742# 0.03918f
C1097 a_5063_8434# a_5374_8434# 0.49675f
C1098 a_808_9980# sg13cmos5l_dfrbp_1_2.RESET_B 0.29863f
C1099 sg13cmos5l_inv_1_40.A sg13cmos5l_inv_1_39.A 0.20065f
C1100 sg13cmos5l_mux2_1_0.A1 a_13760_4742# 0.04511f
C1101 sg13cmos5l_dfrbp_1_2.D VPWR 0.51171f
C1102 sg13cmos5l_mux4_1_0.S0 sg13cmos5l_inv_1_31.A 0.07219f
C1103 sg13cmos5l_inv_1_99.Y VPWR 0.42292f
C1104 a_5566_9946# VPWR 0.10618f
C1105 a_11744_5538# sg13cmos5l_buf_1_10.X 0.06148f
C1106 sg13cmos5l_mux2_1_0.S a_12093_9462# 0.34425f
C1107 sg13cmos5l_nand2_1_1.B sg13cmos5l_inv_1_37.A 0.03502f
C1108 sg13cmos5l_mux2_1_6.A1 sg13cmos5l_inv_1_7.Y 0.02484f
C1109 VPWR a_2043_6960# 0.33743f
C1110 sg13cmos5l_inv_1_123.A VPWR 0.61748f
C1111 sg13cmos5l_inv_1_96.A a_10408_7050# 0.07018f
C1112 a_10462_5410# a_10576_5410# 0.03097f
C1113 VPWR sg13cmos5l_inv_1_34.Y 0.5966f
C1114 a_7048_8562# a_7232_8562# 0.11523f
C1115 sg13cmos5l_inv_1_10.Y sg13cmos5l_inv_1_18.Y 0.03368f
C1116 invsel[4] invsel[3] 0.05772f
C1117 a_3990_4069# a_4109_3858# 0.1333f
C1118 sg13cmos5l_inv_1_12.Y a_5110_5402# 0.10452f
C1119 a_11936_9278# VPWR 0.08007f
C1120 sg13cmos5l_inv_1_15.Y a_4510_5026# 0.05406f
C1121 a_14136_6430# VPWR 0.96567f
C1122 sg13cmos5l_inv_1_61.Y a_10208_9278# 0.03465f
C1123 a_14030_5596# a_14462_5704# 0.02925f
C1124 a_6333_5596# sg13cmos5l_nor2b_1_0.B_N 0.01403f
C1125 a_3016_6168# sg13cmos5l_buf_1_12.X 0.04268f
C1126 sg13cmos5l_inv_1_31.A a_1563_6224# 0.01127f
C1127 a_5781_3191# sg13cmos5l_dfrbp_1_2.RESET_B 0.31827f
C1128 sg13cmos5l_a21oi_1_0.Y sg13cmos5l_nor4_1_0.Y 0.07311f
C1129 a_2038_6546# VPWR 0.0162f
C1130 a_7467_3155# a_8464_3386# 0.07046f
C1131 a_7365_3155# a_8113_3505# 0.01058f
C1132 sg13cmos5l_mux2_1_6.A0 sg13cmos5l_inv_1_82.Y 0.19445f
C1133 VPWR sg13cmos5l_mux4_1_0.X 0.37455f
C1134 sg13cmos5l_mux2_1_2.X a_5374_8434# 0.15883f
C1135 a_1192_10074# VPWR 0.13455f
C1136 VPWR a_6445_8440# 0.11841f
C1137 sg13cmos5l_a221oi_1_0.B1 sg13cmos5l_inv_1_91.A 0.01334f
C1138 a_14030_5596# VPWR 0.10791f
C1139 a_10151_8434# sg13cmos5l_o21ai_1_3.Y 0.23687f
C1140 a_6948_3148# sg13cmos5l_dfrbp_1_2.RESET_B 0.50038f
C1141 sg13cmos5l_mux4_1_1.A2 a_6184_10074# 0.03464f
C1142 sg13cmos5l_mux2_1_0.S sg13cmos5l_inv_1_111.A 0.0492f
C1143 sg13cmos5l_buf_1_4.A a_1595_8472# 0.17153f
C1144 a_19048_4742# a_19048_4026# 0.01275f
C1145 a_4109_3858# a_4750_3894# 0.32273f
C1146 a_4839_4112# a_5687_4285# 0.11742f
C1147 sg13cmos5l_o21ai_1_0.A1 a_4283_9248# 0.19717f
C1148 sg13cmos5l_buf_1_2.X a_10462_8434# 0.06816f
C1149 sg13cmos5l_inv_1_99.A VPWR 0.43065f
C1150 sg13cmos5l_nand2b_1_6.A_N a_6944_5538# 0.04589f
C1151 sg13cmos5l_buf_1_1.X a_5781_3191# 0.01366f
C1152 sg13cmos5l_mux2_1_0.S sg13cmos5l_mux4_1_3.A1 0.21605f
C1153 sg13cmos5l_o21ai_1_0.Y a_2136_6148# 0.01087f
C1154 a_3116_6882# sg13cmos5l_buf_1_12.X 0.32775f
C1155 sg13cmos5l_nor4_1_0.D a_7726_3936# 0.1209f
C1156 VPWR a_6369_8476# 0.7066f
C1157 VPWR sg13cmos5l_inv_1_31.A 0.41348f
C1158 sg13cmos5l_mux2_1_4.A1 a_4283_9248# 0.15765f
C1159 sg13cmos5l_inv_1_130.Y VPWR 0.63949f
C1160 sg13cmos5l_o21ai_1_6.Y a_9622_8426# 0.11898f
C1161 sg13cmos5l_inv_1_83.A a_11420_7660# 0.01045f
C1162 a_4109_3858# a_4109_3108# 0.05275f
C1163 VPWR sg13cmos5l_inv_1_76.A 0.42496f
C1164 a_4860_3858# a_4750_3894# 0.4858f
C1165 sg13cmos5l_inv_1_45.A sg13cmos5l_inv_1_57.A 0.16945f
C1166 sg13cmos5l_dfrbp_1_0.D VPWR 0.5028f
C1167 sg13cmos5l_and2_1_0.X a_7629_5004# 0.13391f
C1168 a_3960_5724# VPWR 0.01834f
C1169 sg13cmos5l_mux4_1_0.S0 sg13cmos5l_inv_1_33.Y 0.32461f
C1170 sg13cmos5l_a21o_1_0.X sg13cmos5l_inv_1_9.Y 0.0202f
C1171 sg13cmos5l_a221oi_1_0.A2 a_7412_6886# 0.2839f
C1172 a_5781_4052# sg13cmos5l_dfrbp_1_2.RESET_B 0.34405f
C1173 sg13cmos5l_nand2_1_1.B sg13cmos5l_a221oi_1_0.C1 0.81062f
C1174 a_808_9980# enable 0.33057f
C1175 sg13cmos5l_inv_1_72.Y sg13cmos5l_inv_1_68.A 0.03985f
C1176 sg13cmos5l_inv_1_88.A sg13cmos5l_inv_1_111.Y 0.01104f
C1177 a_808_2420# ffsel[1] 0.31645f
C1178 sg13cmos5l_mux4_1_1.A0 a_5287_8701# 0.01129f
C1179 sg13cmos5l_inv_1_61.Y sg13cmos5l_inv_1_122.Y 0.17062f
C1180 sg13cmos5l_buf_1_0.X a_4109_3858# 0.0281f
C1181 sg13cmos5l_o21ai_1_0.Y sg13cmos5l_buf_1_12.X 0.10968f
C1182 sg13cmos5l_inv_1_31.A sg13cmos5l_inv_1_30.A 0.05602f
C1183 a_4510_6558# a_4423_6219# 0.02548f
C1184 sg13cmos5l_nand2b_1_6.A_N sg13cmos5l_inv_1_22.Y 0.06419f
C1185 sg13cmos5l_mux2_1_6.A0 sg13cmos5l_inv_1_85.A 0.18538f
C1186 sg13cmos5l_nand3b_1_0.C a_8464_3386# 0.18111f
C1187 sg13cmos5l_inv_1_73.A VPWR 0.48344f
C1188 sg13cmos5l_inv_1_6.A sg13cmos5l_inv_1_6.Y 0.09907f
C1189 sg13cmos5l_o21ai_1_6.A2 sg13cmos5l_buf_1_2.X 0.03547f
C1190 sg13cmos5l_a221oi_1_0.B1 sg13cmos5l_inv_1_90.A 0.01182f
C1191 sg13cmos5l_mux4_1_0.S0 sg13cmos5l_o21ai_1_3.Y 0.92875f
C1192 sg13cmos5l_nand2b_1_6.A_N sg13cmos5l_nor2b_1_0.B_N 0.10939f
C1193 a_6197_4656# VPWR 0.28466f
C1194 a_10120_6168# a_10571_6132# 0.03333f
C1195 sg13cmos5l_o21ai_1_6.Y sg13cmos5l_o21ai_1_3.Y 0.02455f
C1196 sg13cmos5l_inv_1_69.Y sg13cmos5l_inv_1_53.Y 0.16012f
C1197 sg13cmos5l_inv_1_52.A a_4606_9562# 0.01206f
C1198 sg13cmos5l_buf_1_1.X a_808_2420# 0.2906f
C1199 a_11371_6137# sg13cmos5l_mux4_1_0.S0 0.5389f
C1200 sg13cmos5l_nor2b_1_2.Y sg13cmos5l_nor2b_1_0.B_N 0.29721f
C1201 sg13cmos5l_inv_1_70.A sg13cmos5l_inv_1_45.A 1.42009f
C1202 sg13cmos5l_mux2_1_0.S sg13cmos5l_buf_1_10.X 0.78993f
C1203 sg13cmos5l_nand2_1_1.B sg13cmos5l_inv_1_70.Y 0.64479f
C1204 sg13cmos5l_inv_1_19.A sg13cmos5l_o21ai_1_0.A1 0.06052f
C1205 sg13cmos5l_inv_1_19.Y a_6333_5596# 0.03556f
C1206 a_10933_6516# a_11600_6173# 0.01929f
C1207 sg13cmos5l_inv_1_98.Y sg13cmos5l_inv_1_111.A 0.06856f
C1208 a_4109_3108# a_4492_3582# 0.35645f
C1209 sg13cmos5l_inv_1_1.Y a_10576_5410# 0.02103f
C1210 sg13cmos5l_nand2_1_1.B a_5902_6960# 0.10317f
C1211 sg13cmos5l_nand2_1_1.B a_5878_8434# 0.03505f
C1212 a_4606_9562# a_4509_9562# 0.01637f
C1213 sg13cmos5l_and2_1_0.X sg13cmos5l_and2_1_0.B 0.22608f
C1214 VPWR a_9622_8426# 0.0159f
C1215 sg13cmos5l_a21o_1_0.X sg13cmos5l_inv_1_5.Y 0.02026f
C1216 sg13cmos5l_buf_1_0.X a_808_1632# 0.29366f
C1217 sg13cmos5l_inv_1_72.Y sg13cmos5l_inv_1_72.A 0.38807f
C1218 sg13cmos5l_inv_1_117.A sg13cmos5l_inv_1_132.Y 0.25447f
C1219 sg13cmos5l_inv_1_16.Y sg13cmos5l_buf_1_0.X 0.07709f
C1220 VPWR sg13cmos5l_inv_1_33.Y 0.4578f
C1221 a_11630_4922# a_11736_4918# 0.55132f
C1222 a_4860_3505# a_4839_3231# 0.38902f
C1223 sg13cmos5l_inv_1_3.Y sg13cmos5l_mux2_1_0.S 0.13772f
C1224 a_14030_5596# sg13cmos5l_inv_1_7.Y 0.12854f
C1225 a_1918_8434# a_2032_8434# 0.03097f
C1226 sg13cmos5l_mux2_1_3.A0 sg13cmos5l_inv_1_37.Y 0.31228f
C1227 sg13cmos5l_inv_1_22.Y a_7020_5004# 0.01766f
C1228 sg13cmos5l_dfrbp_1_2.RESET_B sg13cmos5l_mux4_1_0.S0 0.30912f
C1229 VPWR a_12904_7050# 0.21523f
C1230 sg13cmos5l_mux2_1_0.X sg13cmos5l_inv_1_90.A 0.01228f
C1231 VPWR ffsel[0] 0.25226f
C1232 sg13cmos5l_mux2_1_6.A0 sg13cmos5l_inv_1_82.A 0.50456f
C1233 a_5374_8434# a_6369_8476# 0.48298f
C1234 sg13cmos5l_nor2_1_1.A sg13cmos5l_inv_1_25.Y 0.01593f
C1235 a_7020_5004# sg13cmos5l_nor2b_1_0.B_N 0.03915f
C1236 sg13cmos5l_mux2_1_0.A1 sg13cmos5l_inv_1_4.Y 0.18711f
C1237 a_11744_5538# VPWR 0.0838f
C1238 a_10151_8434# a_10388_8434# 0.01012f
C1239 sg13cmos5l_nor2_1_1.A sg13cmos5l_buf_1_2.X 0.06308f
C1240 sg13cmos5l_inv_1_1.Y a_10462_5410# 0.58113f
C1241 sg13cmos5l_mux4_1_2.A3 sg13cmos5l_mux4_1_0.S0 0.081f
C1242 VPWR sg13cmos5l_o21ai_1_3.Y 0.61662f
C1243 a_6184_10074# VPWR 0.14819f
C1244 sg13cmos5l_inv_1_70.A sg13cmos5l_inv_1_44.A 0.03189f
C1245 sg13cmos5l_nand2_1_1.B sg13cmos5l_inv_1_66.A 0.01993f
C1246 sg13cmos5l_inv_1_73.Y sg13cmos5l_inv_1_68.Y 0.54505f
C1247 a_1568_4026# VPWR 0.1233f
C1248 sg13cmos5l_nor2_1_1.A sg13cmos5l_nand2_1_1.A 0.01549f
C1249 a_11371_6137# VPWR 0.4808f
C1250 sg13cmos5l_o21ai_1_0.A1 sg13cmos5l_o21ai_1_1.A2 0.50424f
C1251 sg13cmos5l_inv_1_66.A sg13cmos5l_inv_1_70.Y 0.21291f
C1252 sg13cmos5l_buf_1_0.X sg13cmos5l_buf_1_2.X 0.02295f
C1253 sg13cmos5l_a221oi_1_0.B1 sg13cmos5l_buf_1_12.X 0.10119f
C1254 sg13cmos5l_a21o_1_0.X sg13cmos5l_inv_1_4.Y 0.02026f
C1255 a_18856_6168# VPWR 0.28164f
C1256 sg13cmos5l_inv_1_16.Y sg13cmos5l_o21ai_1_0.A1 0.52006f
C1257 a_4492_3894# VPWR 0.14711f
C1258 sg13cmos5l_mux2_1_6.A0 sg13cmos5l_inv_1_133.Y 0.17229f
C1259 sg13cmos5l_inv_1_72.Y sg13cmos5l_inv_1_37.A 0.58133f
C1260 sg13cmos5l_buf_1_0.X a_4510_5026# 0.12218f
C1261 sg13cmos5l_inv_1_19.Y sg13cmos5l_nand2b_1_6.A_N 0.2233f
C1262 sg13cmos5l_inv_1_97.A sg13cmos5l_o21ai_1_3.A2 0.18451f
C1263 a_5014_6558# sg13cmos5l_mux4_1_0.S0 0.07306f
C1264 sg13cmos5l_inv_1_8.Y sg13cmos5l_inv_1_132.Y 0.15441f
C1265 sg13cmos5l_o21ai_1_6.A2 a_9536_9278# 0.04883f
C1266 a_4347_5448# sg13cmos5l_inv_1_15.Y 0.03939f
C1267 sg13cmos5l_inv_1_73.Y sg13cmos5l_mux2_1_3.X 0.1874f
C1268 a_9832_5538# VPWR 0.13075f
C1269 a_7020_5004# a_6849_4656# 0.16591f
C1270 sg13cmos5l_mux2_1_3.A0 sg13cmos5l_inv_1_73.Y 0.04047f
C1271 sg13cmos5l_inv_1_68.A VPWR 0.68807f
C1272 sg13cmos5l_inv_1_22.Y sg13cmos5l_nor4_1_0.Y 0.07234f
C1273 sg13cmos5l_o21ai_1_3.A2 a_12022_8058# 0.10265f
C1274 sg13cmos5l_mux2_1_0.S sg13cmos5l_mux4_1_0.S0 0.16734f
C1275 sg13cmos5l_inv_1_126.Y a_8576_5538# 0.04597f
C1276 a_3776_6254# sg13cmos5l_inv_1_29.Y 0.01054f
C1277 VPWR ffsel[1] 0.22357f
C1278 sg13cmos5l_inv_1_69.A sg13cmos5l_inv_1_35.Y 0.07412f
C1279 sg13cmos5l_dfrbp_1_2.RESET_B VPWR 5.14272f
C1280 sg13cmos5l_nor4_1_0.Y sg13cmos5l_nor2b_1_0.B_N 0.34851f
C1281 sg13cmos5l_o21ai_1_7.B1 a_3862_5402# 0.04111f
C1282 sg13cmos5l_mux4_1_2.A1 a_14136_5600# 0.01528f
C1283 sg13cmos5l_inv_1_31.Y sg13cmos5l_inv_1_118.Y 0.03427f
C1284 a_7712_9278# VPWR 0.08597f
C1285 a_5896_2514# VPWR 0.17359f
C1286 sg13cmos5l_dfrbp_1_2.D a_4109_3858# 0.0399f
C1287 sg13cmos5l_inv_1_52.A sg13cmos5l_mux2_1_4.A0 0.43906f
C1288 a_4510_6558# sg13cmos5l_o21ai_1_0.A1 0.03845f
C1289 a_19048_4026# VPWR 0.15006f
C1290 sg13cmos5l_inv_1_70.A sg13cmos5l_inv_1_43.A 0.02982f
C1291 sg13cmos5l_nand2_1_1.A a_5063_8434# 0.01173f
C1292 a_7158_4192# VPWR 0.01713f
C1293 sg13cmos5l_buf_1_4.A a_5063_8434# 0.04521f
C1294 a_4187_4712# a_4510_5026# 0.55132f
C1295 sg13cmos5l_o21ai_1_0.A1 a_4091_8472# 0.05836f
C1296 sg13cmos5l_nand2_1_1.Y sg13cmos5l_nand2_1_1.A 0.37563f
C1297 sg13cmos5l_mux4_1_2.A3 VPWR 0.62596f
C1298 a_7365_3155# sg13cmos5l_nor2b_1_0.B_N 0.01688f
C1299 sg13cmos5l_dfrbp_1_2.D a_4860_3858# 0.09966f
C1300 sg13cmos5l_o21ai_1_0.A1 sg13cmos5l_nand2b_1_1.Y 0.01659f
C1301 sg13cmos5l_dfrbp_1_2.RESET_B sg13cmos5l_inv_1_30.A 0.14086f
C1302 sg13cmos5l_buf_1_1.X VPWR 7.23479f
C1303 a_808_8468# sg13cmos5l_nand2_1_1.A 0.28909f
C1304 sg13cmos5l_inv_1_14.A VPWR 0.83748f
C1305 sg13cmos5l_mux2_1_7.A1 sg13cmos5l_inv_1_5.Y 0.01846f
C1306 a_808_4742# sg13cmos5l_dfrbp_1_2.RESET_B 0.01107f
C1307 sg13cmos5l_mux2_1_6.A0 sg13cmos5l_inv_1_87.Y 0.0561f
C1308 sg13cmos5l_o21ai_1_5.Y sg13cmos5l_mux4_1_0.S0 0.0518f
C1309 sg13cmos5l_inv_1_8.Y sg13cmos5l_inv_1_117.A 0.01255f
C1310 sg13cmos5l_buf_1_4.A sg13cmos5l_o21ai_1_0.A1 0.25885f
C1311 sg13cmos5l_o21ai_1_0.A1 sg13cmos5l_nand2_1_1.A 0.02267f
C1312 sg13cmos5l_mux2_1_0.A1 a_11736_4918# 0.16818f
C1313 sg13cmos5l_o21ai_1_6.A2 sg13cmos5l_inv_1_61.Y 0.20874f
C1314 sg13cmos5l_inv_1_54.Y a_7240_9278# 0.03488f
C1315 sg13cmos5l_nor4_1_0.Y a_6849_4656# 0.01667f
C1316 sg13cmos5l_mux2_1_3.A0 sg13cmos5l_inv_1_51.Y 0.26031f
C1317 a_5014_6558# VPWR 0.03153f
C1318 a_5566_9946# a_5469_10240# 0.02925f
C1319 a_5243_9984# a_5743_10240# 0.03336f
C1320 sg13cmos5l_inv_1_72.A VPWR 0.46494f
C1321 sg13cmos5l_nand2_1_0.Y a_6197_4656# 0.04224f
C1322 sg13cmos5l_inv_1_22.Y sg13cmos5l_a21oi_1_0.Y 0.34356f
C1323 sg13cmos5l_o21ai_1_3.A2 sg13cmos5l_o21ai_1_3.B1 0.70855f
C1324 a_4091_8472# sg13cmos5l_mux2_1_2.X 0.01734f
C1325 a_4414_8434# a_4591_8728# 0.01068f
C1326 sg13cmos5l_inv_1_119.Y a_8576_5538# 0.03522f
C1327 sg13cmos5l_nand3b_1_0.Y a_5687_3191# 0.03582f
C1328 sg13cmos5l_mux4_1_2.A3 sg13cmos5l_inv_1_89.A 0.04487f
C1329 sg13cmos5l_mux2_1_0.S a_13917_9462# 0.34834f
C1330 VPWR a_6574_7216# 0.19491f
C1331 VPWR invsel[0] 0.11981f
C1332 sg13cmos5l_inv_1_17.A a_1568_4026# 0.04665f
C1333 sg13cmos5l_inv_1_19.A sg13cmos5l_dfrbp_1_0.D 0.01734f
C1334 sg13cmos5l_inv_1_38.A VPWR 0.6859f
C1335 sg13cmos5l_mux2_1_2.X sg13cmos5l_buf_1_2.X 0.18998f
C1336 sg13cmos5l_inv_1_22.Y a_6944_4026# 0.05649f
C1337 sg13cmos5l_mux2_1_0.S VPWR 2.53802f
C1338 sg13cmos5l_a21oi_1_0.Y sg13cmos5l_nor2b_1_0.B_N 0.39163f
C1339 sg13cmos5l_dfrbp_1_2.D a_4492_3582# 0.1843f
C1340 sg13cmos5l_nor3_1_0.C sg13cmos5l_a221oi_1_0.C1 0.12089f
C1341 sg13cmos5l_mux2_1_0.X a_11736_4918# 0.02049f
C1342 a_10120_6168# sg13cmos5l_buf_1_12.X 0.33179f
C1343 sg13cmos5l_inv_1_60.Y VPWR 0.62716f
C1344 sg13cmos5l_inv_1_31.Y sg13cmos5l_inv_1_118.A 0.12106f
C1345 a_10375_8701# a_10462_8434# 0.02548f
C1346 a_808_9192# invsel[4] 0.32093f
C1347 a_5581_6442# VPWR 0.12151f
C1348 sg13cmos5l_inv_1_70.A sg13cmos5l_inv_1_42.A 0.0292f
C1349 sg13cmos5l_buf_1_4.A sg13cmos5l_mux2_1_2.X 0.03765f
C1350 sg13cmos5l_a21o_1_0.X a_11736_4918# 0.01763f
C1351 sg13cmos5l_nand2_1_1.B sg13cmos5l_inv_1_72.Y 0.02202f
C1352 sg13cmos5l_inv_1_98.Y a_12992_8562# 0.011f
C1353 sg13cmos5l_mux2_1_0.S a_11314_8058# 0.0226f
C1354 a_10966_8434# a_11457_8476# 0.3824f
C1355 sg13cmos5l_mux4_1_1.A2 sg13cmos5l_nand2_1_1.B 0.09986f
C1356 sg13cmos5l_nand2_1_1.B sg13cmos5l_nor3_1_0.C 0.68249f
C1357 sg13cmos5l_dfrbp_1_0.D a_4109_3858# 0.05765f
C1358 sg13cmos5l_mux2_1_1.X VPWR 0.51516f
C1359 a_5110_5402# sg13cmos5l_o21ai_1_0.A1 0.10726f
C1360 sg13cmos5l_mux2_1_0.S sg13cmos5l_inv_1_89.A 0.45769f
C1361 VPWR a_9632_7050# 0.07995f
C1362 sg13cmos5l_inv_1_18.A VPWR 0.66166f
C1363 sg13cmos5l_o21ai_1_1.A2 sg13cmos5l_mux4_1_0.X 0.0199f
C1364 a_15968_6254# VPWR 0.06861f
C1365 sg13cmos5l_inv_1_17.A sg13cmos5l_dfrbp_1_2.RESET_B 0.12351f
C1366 VPWR enable 0.18523f
C1367 sg13cmos5l_mux4_1_1.A2 sg13cmos5l_inv_1_70.Y 0.0956f
C1368 sg13cmos5l_mux2_1_6.A0 sg13cmos5l_inv_1_88.A 0.02866f
C1369 sg13cmos5l_o21ai_1_7.Y sg13cmos5l_mux4_1_0.S0 0.03906f
C1370 sg13cmos5l_mux4_1_1.A0 a_5063_8434# 0.22646f
C1371 VPWR a_13917_7950# 0.27952f
C1372 sg13cmos5l_dfrbp_1_0.D a_4860_3858# 0.01639f
C1373 sg13cmos5l_a21oi_1_0.Y a_6849_4656# 0.13148f
C1374 sg13cmos5l_o21ai_1_5.Y VPWR 0.59341f
C1375 sg13cmos5l_inv_1_37.A VPWR 0.53404f
C1376 sg13cmos5l_dfrbp_1_2.D sg13cmos5l_buf_1_2.X 0.01718f
C1377 a_18568_6254# a_18752_6254# 0.11523f
C1378 sg13cmos5l_nand3b_1_0.Y sg13cmos5l_a21oi_1_0.Y 0.03034f
C1379 sg13cmos5l_inv_1_82.Y sg13cmos5l_mux2_1_7.A1 0.14039f
C1380 sg13cmos5l_mux4_1_1.A2 a_5878_8434# 0.08113f
C1381 sg13cmos5l_nand3b_1_0.Y a_6142_2428# 0.23846f
C1382 a_3016_6168# sg13cmos5l_o21ai_1_0.A1 0.29217f
C1383 VPWR invsel[1] 0.10668f
C1384 sg13cmos5l_dfrbp_1_2.D a_4510_5026# 0.10492f
C1385 a_2920_4742# VPWR 0.21436f
C1386 a_2043_6960# sg13cmos5l_nand2b_1_1.Y 0.33667f
C1387 sg13cmos5l_inv_1_39.A VPWR 0.4372f
C1388 a_11533_8440# a_10966_8434# 0.40359f
C1389 sg13cmos5l_o21ai_1_3.B1 a_12022_8058# 0.05201f
C1390 sg13cmos5l_o21ai_1_0.A1 sg13cmos5l_mux4_1_1.A0 0.04292f
C1391 sg13cmos5l_inv_1_20.A sg13cmos5l_inv_1_1.Y 0.02116f
C1392 sg13cmos5l_buf_1_4.A a_5566_9946# 0.1529f
C1393 sg13cmos5l_inv_1_106.Y a_11446_9570# 0.111f
C1394 sg13cmos5l_inv_1_14.A sg13cmos5l_inv_1_17.A 0.15144f
C1395 VPWR sg13cmos5l_inv_1_98.Y 0.49963f
C1396 sg13cmos5l_a221oi_1_0.A2 a_7370_7216# 0.01359f
C1397 a_13917_9462# a_13999_9562# 0.01126f
C1398 sg13cmos5l_o21ai_1_3.Y a_12120_7660# 0.01087f
C1399 sg13cmos5l_buf_1_1.X a_5600_4742# 0.0439f
C1400 sg13cmos5l_nand2_1_1.B sg13cmos5l_mux4_1_0.S0 0.05595f
C1401 sg13cmos5l_inv_1_68.A a_1918_8434# 0.60262f
C1402 sg13cmos5l_buf_1_4.A sg13cmos5l_inv_1_34.Y 0.01042f
C1403 a_7336_5538# VPWR 0.12439f
C1404 sg13cmos5l_nor2b_1_0.B_N a_6982_6944# 0.01675f
C1405 sg13cmos5l_inv_1_133.Y sg13cmos5l_a21o_1_0.X 0.04098f
C1406 sg13cmos5l_inv_1_10.Y VPWR 0.96584f
C1407 a_6333_5596# a_6415_5410# 0.01126f
C1408 a_14030_6434# a_14202_6192# 0.01068f
C1409 sg13cmos5l_inv_1_70.Y sg13cmos5l_mux4_1_0.S0 0.01535f
C1410 sg13cmos5l_buf_1_2.X sg13cmos5l_mux4_1_0.X 0.06537f
C1411 sg13cmos5l_o21ai_1_4.Y sg13cmos5l_inv_1_83.A 0.01608f
C1412 sg13cmos5l_mux4_1_1.A2 sg13cmos5l_inv_1_66.A 0.11754f
C1413 sg13cmos5l_mux2_1_6.A0 sg13cmos5l_mux2_1_6.A1 0.50139f
C1414 sg13cmos5l_buf_1_2.X a_6445_8440# 0.34862f
C1415 sg13cmos5l_inv_1_7.Y sg13cmos5l_mux2_1_0.S 0.09487f
C1416 sg13cmos5l_mux4_1_1.A0 sg13cmos5l_mux2_1_2.X 0.04571f
C1417 sg13cmos5l_nand2_1_0.Y sg13cmos5l_dfrbp_1_2.RESET_B 0.08605f
C1418 sg13cmos5l_inv_1_69.A a_4414_8434# 0.02246f
C1419 a_4160_9278# VPWR 0.07938f
C1420 sg13cmos5l_a21o_1_0.X a_18752_6254# 0.05996f
C1421 sg13cmos5l_mux2_1_6.A1 sg13cmos5l_inv_1_109.A 0.06934f
C1422 sg13cmos5l_o21ai_1_7.Y VPWR 0.50919f
C1423 sg13cmos5l_mux4_1_0.S0 a_5878_8434# 0.03525f
C1424 sg13cmos5l_inv_1_85.A sg13cmos5l_mux2_1_7.A1 0.01079f
C1425 sg13cmos5l_nand2_1_1.A sg13cmos5l_mux4_1_0.X 0.09525f
C1426 sg13cmos5l_o21ai_1_3.A2 sg13cmos5l_inv_1_83.A 0.05514f
C1427 sg13cmos5l_buf_1_4.A sg13cmos5l_mux4_1_0.X 0.12055f
C1428 sg13cmos5l_o21ai_1_0.Y sg13cmos5l_o21ai_1_0.A1 0.91864f
C1429 sg13cmos5l_buf_1_2.X a_6369_8476# 0.2426f
C1430 a_808_9192# a_1184_9278# 0.03376f
C1431 sg13cmos5l_inv_1_18.Y VPWR 0.9488f
C1432 sg13cmos5l_inv_1_40.A VPWR 0.42126f
C1433 sg13cmos5l_inv_1_92.A a_12128_7050# 0.0351f
C1434 sg13cmos5l_o21ai_1_4.Y a_10966_8434# 0.23698f
C1435 VPWR sg13cmos5l_a221oi_1_0.C1 0.46344f
C1436 sg13cmos5l_dfrbp_1_0.D sg13cmos5l_buf_1_2.X 0.54026f
C1437 sg13cmos5l_inv_1_14.A sg13cmos5l_inv_1_13.Y 0.3095f
C1438 sg13cmos5l_mux4_1_3.A1 a_10151_8434# 0.19771f
C1439 sg13cmos5l_inv_1_106.Y sg13cmos5l_o21ai_1_2.B1 0.29425f
C1440 a_808_5444# sg13cmos5l_dfrbp_1_2.RESET_B 0.04371f
C1441 sg13cmos5l_buf_1_1.X sg13cmos5l_nand2_1_0.Y 0.27563f
C1442 sg13cmos5l_inv_1_70.A sg13cmos5l_mux2_1_4.A1 0.49861f
C1443 sg13cmos5l_inv_1_34.Y sg13cmos5l_inv_1_33.A 0.06897f
C1444 sg13cmos5l_mux2_1_7.A1 a_14136_5600# 0.20226f
C1445 a_6922_3112# a_7365_3155# 0.02241f
C1446 a_6662_3582# a_7236_3569# 0.36169f
C1447 sg13cmos5l_dfrbp_1_0.D a_4510_5026# 0.56185f
C1448 sg13cmos5l_inv_1_72.A a_1918_8434# 0.04201f
C1449 sg13cmos5l_inv_1_1.Y sg13cmos5l_inv_1_6.A 0.09359f
C1450 sg13cmos5l_inv_1_19.A sg13cmos5l_dfrbp_1_2.RESET_B 0.14802f
C1451 sg13cmos5l_o21ai_1_3.A2 a_14344_7766# 0.01254f
C1452 sg13cmos5l_nand2_1_1.B VPWR 1.32602f
C1453 sg13cmos5l_nor4_1_0.D sg13cmos5l_inv_1_126.Y 0.01275f
C1454 sg13cmos5l_inv_1_107.Y sg13cmos5l_inv_1_98.A 0.09475f
C1455 a_4109_3858# a_4492_3894# 0.35645f
C1456 sg13cmos5l_inv_1_11.A VPWR 0.50656f
C1457 a_7236_3569# a_7467_3155# 0.15089f
C1458 sg13cmos5l_inv_1_66.A sg13cmos5l_mux4_1_0.S0 0.01469f
C1459 sg13cmos5l_o21ai_1_4.Y sg13cmos5l_nand2b_1_2.Y 0.24059f
C1460 sg13cmos5l_inv_1_17.Y sg13cmos5l_dfrbp_1_2.RESET_B 0.02785f
C1461 a_4347_5448# sg13cmos5l_o21ai_1_0.A1 0.35132f
C1462 a_10139_5448# sg13cmos5l_buf_1_10.X 0.21432f
C1463 sg13cmos5l_nor4_1_0.Y a_7726_3936# 0.06273f
C1464 a_808_1632# ffsel[0] 0.32955f
C1465 a_11630_4922# a_12062_4680# 0.02925f
C1466 a_11736_4918# a_11802_4680# 0.03336f
C1467 sg13cmos5l_inv_1_56.Y sg13cmos5l_o21ai_1_6.A2 0.20732f
C1468 sg13cmos5l_inv_1_70.Y VPWR 0.43127f
C1469 sg13cmos5l_mux2_1_3.X a_4414_8434# 0.01036f
C1470 sg13cmos5l_mux2_1_6.A1 sg13cmos5l_inv_1_95.A 0.03676f
C1471 a_808_8468# a_1184_8562# 0.03376f
C1472 sg13cmos5l_inv_1_82.A sg13cmos5l_mux2_1_7.A1 0.14518f
C1473 a_4991_4164# a_5687_4285# 0.02431f
C1474 sg13cmos5l_inv_1_73.A sg13cmos5l_nand2_1_1.A 0.18695f
C1475 a_8207_3505# a_8113_3505# 0.32273f
C1476 a_4109_3858# sg13cmos5l_dfrbp_1_2.RESET_B 0.2005f
C1477 a_4510_5026# a_4687_4680# 0.01068f
C1478 sg13cmos5l_inv_1_19.A sg13cmos5l_buf_1_1.X 0.04258f
C1479 VPWR a_5902_6960# 0.31008f
C1480 VPWR a_5878_8434# 0.03093f
C1481 a_4839_3231# a_4991_3115# 0.66105f
C1482 a_4860_3505# a_5687_3191# 0.50066f
C1483 sg13cmos5l_inv_1_22.Y sg13cmos5l_nor2b_1_0.B_N 0.47651f
C1484 sg13cmos5l_inv_1_91.A a_12128_7050# 0.05751f
C1485 a_7520_4742# VPWR 0.07647f
C1486 a_8464_3386# sg13cmos5l_dfrbp_1_2.RESET_B 0.17543f
C1487 sg13cmos5l_inv_1_116.A a_9632_7050# 0.03465f
C1488 sg13cmos5l_nor4_1_0.D a_7468_6168# 0.01687f
C1489 sg13cmos5l_inv_1_33.A sg13cmos5l_inv_1_31.A 0.03371f
C1490 VPWR a_18952_8562# 0.1517f
C1491 sg13cmos5l_nor2_1_1.A sg13cmos5l_nor4_1_0.D 0.10492f
C1492 sg13cmos5l_mux4_1_3.A1 sg13cmos5l_mux4_1_0.S0 0.05413f
C1493 a_4860_3858# a_5642_4052# 0.4806f
C1494 sg13cmos5l_inv_1_14.A sg13cmos5l_inv_1_17.Y 0.28702f
C1495 sg13cmos5l_inv_1_45.A a_5243_9984# 0.06202f
C1496 sg13cmos5l_mux2_1_1.X sg13cmos5l_nand2_1_0.Y 0.18405f
C1497 a_4860_3858# sg13cmos5l_dfrbp_1_2.RESET_B 0.49664f
C1498 sg13cmos5l_inv_1_76.A sg13cmos5l_inv_1_33.A 0.11183f
C1499 sg13cmos5l_o21ai_1_5.Y a_5208_5724# 0.01459f
C1500 sg13cmos5l_inv_1_51.Y a_1184_9278# 0.01054f
C1501 sg13cmos5l_nor4_1_0.D a_7362_4192# 0.02468f
C1502 sg13cmos5l_inv_1_73.Y sg13cmos5l_inv_1_37.Y 0.32761f
C1503 a_12019_6219# VPWR 0.02431f
C1504 a_12093_9462# VPWR 0.38786f
C1505 sg13cmos5l_inv_1_33.Y sg13cmos5l_nand2b_1_1.Y 0.01099f
C1506 sg13cmos5l_dfrbp_1_1.CLK a_6948_3148# 0.09818f
C1507 a_808_6254# VPWR 0.126f
C1508 sg13cmos5l_nor4_1_0.D sg13cmos5l_inv_1_119.Y 0.06994f
C1509 sg13cmos5l_inv_1_70.A a_5566_9946# 0.57347f
C1510 sg13cmos5l_inv_1_133.Y sg13cmos5l_mux2_1_7.A1 0.44123f
C1511 a_4199_6558# sg13cmos5l_inv_1_29.A 0.03196f
C1512 a_14136_6430# sg13cmos5l_mux2_1_6.A0 0.04037f
C1513 sg13cmos5l_buf_1_1.X a_4860_3858# 0.02369f
C1514 sg13cmos5l_inv_1_123.A a_11630_4922# 0.10438f
C1515 sg13cmos5l_inv_1_106.Y sg13cmos5l_nand2b_1_4.A_N 0.02819f
C1516 sg13cmos5l_inv_1_73.A sg13cmos5l_inv_1_33.A 0.03173f
C1517 sg13cmos5l_inv_1_66.A VPWR 0.44909f
C1518 sg13cmos5l_inv_1_69.A sg13cmos5l_inv_1_69.Y 0.2254f
C1519 sg13cmos5l_nor2_1_1.A a_10120_6168# 0.01666f
C1520 sg13cmos5l_inv_1_16.Y sg13cmos5l_dfrbp_1_2.RESET_B 0.8462f
C1521 sg13cmos5l_inv_1_22.Y a_6849_4656# 0.01237f
C1522 a_4492_3582# sg13cmos5l_dfrbp_1_2.RESET_B 0.18225f
C1523 sg13cmos5l_buf_1_2.X sg13cmos5l_o21ai_1_3.Y 0.03504f
C1524 sg13cmos5l_nand3b_1_0.Y sg13cmos5l_inv_1_22.Y 0.0146f
C1525 sg13cmos5l_mux4_1_0.X sg13cmos5l_a221oi_1_0.A2 0.16212f
C1526 sg13cmos5l_inv_1_19.A sg13cmos5l_mux2_1_1.X 0.10587f
C1527 a_2038_6546# sg13cmos5l_o21ai_1_0.Y 0.11628f
C1528 a_808_6254# sg13cmos5l_inv_1_30.A 0.03352f
C1529 a_6849_4656# sg13cmos5l_nor2b_1_0.B_N 0.08525f
C1530 a_808_9980# VPWR 0.24591f
C1531 a_10571_6132# a_10904_6168# 0.3824f
C1532 a_3990_3431# a_4109_3108# 0.1333f
C1533 sg13cmos5l_inv_1_83.A sg13cmos5l_o21ai_1_3.B1 0.36177f
C1534 sg13cmos5l_mux4_1_0.S0 sg13cmos5l_buf_1_10.X 0.3615f
C1535 sg13cmos5l_inv_1_24.A a_9632_7050# 0.05751f
C1536 sg13cmos5l_buf_1_10.X sg13cmos5l_o21ai_1_6.Y 0.03249f
C1537 sg13cmos5l_nand2_1_1.B a_5374_8434# 0.0122f
C1538 a_4283_9248# a_4160_9278# 0.01107f
C1539 a_808_5444# invsel[1] 0.32557f
C1540 VPWR sg13cmos5l_inv_1_111.A 0.49504f
C1541 sg13cmos5l_nand2_1_1.Y sg13cmos5l_nor4_1_0.D 0.22219f
C1542 sg13cmos5l_inv_1_27.Y sg13cmos5l_inv_1_126.Y 0.02484f
C1543 sg13cmos5l_inv_1_44.A a_5243_9984# 0.02641f
C1544 sg13cmos5l_inv_1_93.A a_12904_7050# 0.03552f
C1545 sg13cmos5l_o21ai_1_5.Y sg13cmos5l_inv_1_19.A 0.01288f
C1546 sg13cmos5l_mux4_1_3.A1 VPWR 0.51398f
C1547 VPWR a_19136_7766# 0.10567f
C1548 sg13cmos5l_buf_1_0.X a_3990_3431# 0.04988f
C1549 sg13cmos5l_inv_1_14.A sg13cmos5l_inv_1_16.Y 0.6224f
C1550 a_4109_3108# a_4839_3231# 0.3087f
C1551 a_14030_5596# a_13856_5538# 0.0344f
C1552 a_4492_3582# a_4750_3582# 0.01017f
C1553 a_4199_6558# sg13cmos5l_mux4_1_0.A0 0.24947f
C1554 sg13cmos5l_inv_1_33.A sg13cmos5l_inv_1_33.Y 0.2305f
C1555 sg13cmos5l_mux2_1_4.A0 a_7240_9278# 0.06206f
C1556 sg13cmos5l_inv_1_31.Y sg13cmos5l_buf_1_12.X 0.03242f
C1557 sg13cmos5l_nor4_1_0.D sg13cmos5l_inv_1_125.Y 0.07656f
C1558 sg13cmos5l_inv_1_87.Y sg13cmos5l_mux2_1_7.A1 0.01217f
C1559 sg13cmos5l_inv_1_68.A a_2144_7766# 0.0447f
C1560 a_5374_8434# a_5878_8434# 0.97548f
C1561 sg13cmos5l_dfrbp_1_2.RESET_B sg13cmos5l_buf_1_2.X 5.43971f
C1562 sg13cmos5l_inv_1_30.Y sg13cmos5l_inv_1_31.Y 0.22429f
C1563 a_4839_3231# sg13cmos5l_nand3b_1_0.C 0.02533f
C1564 sg13cmos5l_inv_1_68.A sg13cmos5l_nand2_1_1.A 0.02428f
C1565 sg13cmos5l_buf_1_4.A sg13cmos5l_inv_1_68.A 0.09514f
C1566 sg13cmos5l_inv_1_123.A sg13cmos5l_inv_1_130.A 0.0986f
C1567 sg13cmos5l_mux4_1_0.S0 a_10151_8434# 0.02861f
C1568 sg13cmos5l_inv_1_19.Y sg13cmos5l_nor2b_1_0.B_N 0.02186f
C1569 sg13cmos5l_mux4_1_1.A2 sg13cmos5l_mux4_1_0.S0 0.04003f
C1570 sg13cmos5l_mux2_1_3.X sg13cmos5l_inv_1_69.Y 0.08679f
C1571 sg13cmos5l_o21ai_1_6.Y a_10151_8434# 0.36989f
C1572 sg13cmos5l_inv_1_118.Y a_1184_5538# 0.01182f
C1573 a_4510_5026# sg13cmos5l_dfrbp_1_2.RESET_B 0.01025f
C1574 sg13cmos5l_mux4_1_0.S0 sg13cmos5l_nor3_1_0.C 0.04127f
C1575 sg13cmos5l_nor2_1_1.A sg13cmos5l_inv_1_27.Y 0.02792f
C1576 a_5781_3191# VPWR 0.10215f
C1577 sg13cmos5l_dfrbp_1_2.RESET_B sg13cmos5l_nand2_1_1.A 0.15975f
C1578 sg13cmos5l_mux2_1_4.A1 a_2920_10074# 0.03378f
C1579 sg13cmos5l_nand2_1_1.B a_4283_9248# 0.01925f
C1580 a_19048_4742# VPWR 0.17056f
C1581 sg13cmos5l_mux4_1_2.A3 sg13cmos5l_buf_1_2.X 0.06337f
C1582 sg13cmos5l_buf_1_1.X sg13cmos5l_buf_1_2.X 0.51736f
C1583 a_6948_3148# VPWR 0.07875f
C1584 sg13cmos5l_inv_1_138.Y sg13cmos5l_inv_1_127.Y 0.02094f
C1585 sg13cmos5l_inv_1_11.A sg13cmos5l_inv_1_13.Y 0.13464f
C1586 a_5014_6558# a_4510_6558# 0.97548f
C1587 sg13cmos5l_inv_1_73.A sg13cmos5l_inv_1_70.A 0.02678f
C1588 VPWR sg13cmos5l_buf_1_10.X 1.65063f
C1589 sg13cmos5l_inv_1_51.Y sg13cmos5l_inv_1_73.Y 0.03916f
C1590 a_3776_4026# VPWR 0.11873f
C1591 sg13cmos5l_inv_1_18.A sg13cmos5l_inv_1_16.Y 0.22726f
C1592 sg13cmos5l_o21ai_1_7.B1 sg13cmos5l_inv_1_12.Y 0.03688f
C1593 a_10139_5448# VPWR 0.98816f
C1594 a_5014_6558# sg13cmos5l_buf_1_2.X 0.06756f
C1595 a_9044_3144# VPWR 0.37817f
C1596 sg13cmos5l_mux2_1_4.A0 sg13cmos5l_inv_1_54.Y 0.11954f
C1597 sg13cmos5l_nor4_1_0.D sg13cmos5l_and2_1_0.X 0.11899f
C1598 sg13cmos5l_inv_1_88.A sg13cmos5l_mux2_1_7.A1 0.02159f
C1599 sg13cmos5l_mux4_1_0.A0 a_4316_7236# 0.01157f
C1600 sg13cmos5l_inv_1_19.Y sg13cmos5l_nand3b_1_0.Y 0.01455f
C1601 sg13cmos5l_inv_1_72.A a_2144_7766# 0.04367f
C1602 sg13cmos5l_o21ai_1_0.A2 sg13cmos5l_o21ai_1_0.B1 0.2998f
C1603 a_5781_4052# VPWR 0.09635f
C1604 sg13cmos5l_buf_1_10.X a_11314_8058# 0.10537f
C1605 sg13cmos5l_inv_1_60.Y sg13cmos5l_inv_1_75.Y 0.05896f
C1606 sg13cmos5l_mux2_1_0.S sg13cmos5l_buf_1_2.X 0.08586f
C1607 sg13cmos5l_inv_1_60.Y sg13cmos5l_buf_1_2.X 0.03803f
C1608 a_5014_6558# sg13cmos5l_buf_1_4.A 0.02467f
C1609 sg13cmos5l_inv_1_72.A sg13cmos5l_nand2_1_1.A 0.02491f
C1610 sg13cmos5l_mux4_1_2.A1 a_14030_5596# 0.22722f
C1611 sg13cmos5l_mux4_1_2.A3 sg13cmos5l_inv_1_93.A 0.05566f
C1612 sg13cmos5l_inv_1_130.Y sg13cmos5l_inv_1_130.A 0.50186f
C1613 sg13cmos5l_inv_1_29.A sg13cmos5l_mux4_1_0.A0 0.32303f
C1614 sg13cmos5l_buf_1_4.A sg13cmos5l_inv_1_72.A 0.02133f
C1615 sg13cmos5l_inv_1_123.A sg13cmos5l_inv_1_0.Y 0.0195f
C1616 sg13cmos5l_mux2_1_0.A1 sg13cmos5l_inv_1_123.A 0.62955f
C1617 sg13cmos5l_inv_1_3.Y VPWR 0.86226f
C1618 a_5581_6442# sg13cmos5l_buf_1_2.X 0.39945f
C1619 sg13cmos5l_mux4_1_0.S0 sg13cmos5l_o21ai_1_6.Y 0.21412f
C1620 sg13cmos5l_dfrbp_1_2.RESET_B sg13cmos5l_inv_1_33.A 0.10117f
C1621 a_808_2420# VPWR 0.28982f
C1622 sg13cmos5l_inv_1_118.A a_1184_5538# 0.03465f
C1623 sg13cmos5l_inv_1_57.A a_6184_10074# 0.03352f
C1624 sg13cmos5l_a221oi_1_0.B1 sg13cmos5l_mux4_1_0.X 0.18783f
C1625 sg13cmos5l_buf_1_10.X sg13cmos5l_inv_1_89.A 0.02595f
C1626 sg13cmos5l_inv_1_16.Y a_2920_4742# 0.01986f
C1627 sg13cmos5l_nor2_1_1.A sg13cmos5l_inv_1_28.Y 0.06045f
C1628 sg13cmos5l_inv_1_72.Y VPWR 0.78372f
C1629 sg13cmos5l_inv_1_35.Y sg13cmos5l_inv_1_29.A 0.44808f
C1630 VPWR a_10151_8434# 0.43265f
C1631 sg13cmos5l_mux4_1_1.A2 VPWR 0.52999f
C1632 VPWR sg13cmos5l_nor3_1_0.C 0.26027f
C1633 a_5581_6442# sg13cmos5l_buf_1_4.A 0.01207f
C1634 a_11371_6137# a_10933_6516# 0.49675f
C1635 a_10715_6528# VPWR 0.12546f
C1636 sg13cmos5l_mux2_1_0.X sg13cmos5l_inv_1_123.A 0.04676f
C1637 sg13cmos5l_dfrbp_1_2.D a_4839_4112# 0.01634f
C1638 a_18952_1002# VPWR 0.14555f
C1639 sg13cmos5l_o21ai_1_6.B1 a_10462_8434# 0.02065f
C1640 sg13cmos5l_inv_1_138.Y sg13cmos5l_inv_1_126.Y 0.09462f
C1641 sg13cmos5l_inv_1_98.Y sg13cmos5l_inv_1_113.A 0.01227f
C1642 sg13cmos5l_inv_1_18.A sg13cmos5l_buf_1_2.X 0.019f
C1643 sg13cmos5l_inv_1_11.A sg13cmos5l_inv_1_17.Y 0.07128f
C1644 sg13cmos5l_mux2_1_0.S a_11067_6960# 0.33337f
C1645 sg13cmos5l_dfrbp_1_2.Q VPWR 0.39134f
C1646 sg13cmos5l_dfrbp_1_1.CLK VPWR 0.28211f
C1647 sg13cmos5l_o21ai_1_5.Y a_4510_6558# 0.19309f
C1648 a_4510_5026# sg13cmos5l_mux2_1_1.X 0.23515f
C1649 sg13cmos5l_a21o_1_0.X sg13cmos5l_inv_1_123.A 3.00052f
C1650 sg13cmos5l_inv_1_105.Y a_10600_9278# 0.03474f
C1651 sg13cmos5l_mux2_1_0.S sg13cmos5l_inv_1_93.A 0.18334f
C1652 sg13cmos5l_o21ai_1_7.B1 sg13cmos5l_inv_1_15.Y 0.04625f
C1653 sg13cmos5l_o21ai_1_5.Y sg13cmos5l_buf_1_2.X 0.37741f
C1654 a_1595_8472# sg13cmos5l_mux2_1_3.X 0.01611f
C1655 a_1918_8434# a_2095_8728# 0.01068f
C1656 a_4091_8472# a_4317_8728# 0.02749f
C1657 sg13cmos5l_inv_1_119.Y a_7520_5538# 0.011f
C1658 sg13cmos5l_mux2_1_3.A0 a_1595_8472# 0.03936f
C1659 sg13cmos5l_mux2_1_6.A1 sg13cmos5l_mux2_1_7.A1 0.04415f
C1660 VPWR a_4210_6914# 0.01374f
C1661 sg13cmos5l_o21ai_1_5.Y sg13cmos5l_o21ai_1_5.B1 0.28054f
C1662 sg13cmos5l_o21ai_1_7.Y sg13cmos5l_inv_1_16.Y 0.07049f
C1663 sg13cmos5l_inv_1_60.Y sg13cmos5l_inv_1_60.A 0.10328f
C1664 sg13cmos5l_dfrbp_1_2.D a_3990_3431# 0.25145f
C1665 a_10600_9278# VPWR 0.13103f
C1666 sg13cmos5l_o21ai_1_5.Y sg13cmos5l_buf_1_4.A 0.03673f
C1667 sg13cmos5l_inv_1_83.A a_14344_7766# 0.02834f
C1668 sg13cmos5l_buf_1_4.A sg13cmos5l_inv_1_37.A 0.05741f
C1669 sg13cmos5l_inv_1_123.A sg13cmos5l_inv_1_124.Y 0.02079f
C1670 sg13cmos5l_inv_1_35.Y sg13cmos5l_mux4_1_0.A0 0.06034f
C1671 sg13cmos5l_inv_1_106.Y sg13cmos5l_inv_1_99.A 0.20049f
C1672 sg13cmos5l_inv_1_118.A sg13cmos5l_inv_1_118.Y 0.28709f
C1673 sg13cmos5l_buf_1_10.X sg13cmos5l_inv_1_96.A 0.2147f
C1674 sg13cmos5l_inv_1_16.Y sg13cmos5l_inv_1_18.Y 0.3586f
C1675 sg13cmos5l_nor2_1_1.A sg13cmos5l_inv_1_138.Y 0.02074f
C1676 a_7726_3936# sg13cmos5l_nor2b_1_0.B_N 0.33058f
C1677 sg13cmos5l_mux4_1_0.S0 VPWR 4.62274f
C1678 VPWR sg13cmos5l_o21ai_1_6.Y 0.41345f
C1679 sg13cmos5l_o21ai_1_6.A2 sg13cmos5l_o21ai_1_6.B1 0.56812f
C1680 sg13cmos5l_dfrbp_1_2.D a_4839_3231# 0.01275f
C1681 a_11371_6137# sg13cmos5l_mux2_1_8.X 0.22695f
C1682 sg13cmos5l_mux4_1_2.A3 a_10933_6516# 0.16607f
C1683 a_10462_8434# a_11457_8476# 0.48298f
C1684 a_13917_7950# sg13cmos5l_inv_1_93.A 0.20577f
C1685 sg13cmos5l_nand2b_1_2.Y sg13cmos5l_inv_1_83.A 0.41981f
C1686 sg13cmos5l_nand2_1_1.B sg13cmos5l_o21ai_1_1.A2 0.10736f
C1687 VPWR a_12992_8562# 0.07514f
C1688 sg13cmos5l_inv_1_138.Y sg13cmos5l_inv_1_119.Y 0.16766f
C1689 sg13cmos5l_o21ai_1_7.Y a_4510_6558# 0.16573f
C1690 a_4199_6558# a_4628_6558# 0.0289f
C1691 sg13cmos5l_o21ai_1_2.B1 sg13cmos5l_o21ai_1_6.B1 0.05572f
C1692 sg13cmos5l_a21o_1_0.X sg13cmos5l_inv_1_130.Y 0.02933f
C1693 sg13cmos5l_mux4_1_2.A3 sg13cmos5l_mux2_1_6.A0 0.03258f
C1694 sg13cmos5l_nand3b_1_0.Y a_5687_4285# 0.02401f
C1695 sg13cmos5l_dfrbp_1_0.D a_4839_4112# 0.02463f
C1696 sg13cmos5l_inv_1_107.Y sg13cmos5l_o21ai_1_3.A2 0.01422f
C1697 VPWR a_1563_6224# 0.32577f
C1698 sg13cmos5l_nand3b_1_0.Y a_5992_4742# 0.04692f
C1699 sg13cmos5l_inv_1_129.Y a_10462_5410# 0.09546f
C1700 sg13cmos5l_mux4_1_1.A2 a_5374_8434# 0.13695f
C1701 sg13cmos5l_inv_1_52.A sg13cmos5l_o21ai_1_0.A1 0.05376f
C1702 sg13cmos5l_o21ai_1_5.Y a_5110_5402# 0.11633f
C1703 sg13cmos5l_inv_1_73.Y sg13cmos5l_o21ai_1_0.A2 0.04503f
C1704 a_4199_6558# sg13cmos5l_inv_1_29.Y 0.02563f
C1705 sg13cmos5l_o21ai_1_1.A2 a_5902_6960# 0.01042f
C1706 sg13cmos5l_inv_1_18.Y sg13cmos5l_buf_1_2.X 0.02397f
C1707 sg13cmos5l_inv_1_60.Y sg13cmos5l_inv_1_55.Y 0.04925f
C1708 a_10933_6516# sg13cmos5l_mux2_1_0.S 0.04066f
C1709 sg13cmos5l_inv_1_105.Y VPWR 0.43626f
C1710 sg13cmos5l_o21ai_1_7.Y sg13cmos5l_buf_1_4.A 0.02935f
C1711 sg13cmos5l_inv_1_123.A sg13cmos5l_inv_1_123.Y 0.22172f
C1712 a_6760_9278# VPWR 0.1588f
C1713 sg13cmos5l_mux2_1_4.A1 sg13cmos5l_inv_1_52.A 0.03443f
C1714 sg13cmos5l_buf_1_10.X sg13cmos5l_inv_1_116.A 0.01159f
C1715 sg13cmos5l_inv_1_83.A sg13cmos5l_inv_1_92.A 0.08377f
C1716 sg13cmos5l_o21ai_1_0.Y a_5014_6558# 0.01634f
C1717 a_13917_9462# VPWR 0.3294f
C1718 a_2136_6148# sg13cmos5l_o21ai_1_0.B1 0.01135f
C1719 sg13cmos5l_nand3b_1_0.Y a_4860_3505# 0.04542f
C1720 sg13cmos5l_mux2_1_6.A0 sg13cmos5l_mux2_1_0.S 0.10888f
C1721 sg13cmos5l_nand2_1_1.A sg13cmos5l_a221oi_1_0.C1 0.68402f
C1722 sg13cmos5l_mux4_1_2.A3 sg13cmos5l_mux2_1_8.X 0.07974f
C1723 a_11371_6137# sg13cmos5l_mux4_1_2.A1 0.20716f
C1724 sg13cmos5l_o21ai_1_3.Y sg13cmos5l_a221oi_1_0.B1 0.0191f
C1725 sg13cmos5l_nand2_1_1.B sg13cmos5l_inv_1_25.Y 0.02322f
C1726 a_6760_5538# VPWR 0.12407f
C1727 sg13cmos5l_nand2_1_1.B sg13cmos5l_buf_1_2.X 0.35668f
C1728 sg13cmos5l_inv_1_111.A sg13cmos5l_inv_1_111.Y 0.23152f
C1729 sg13cmos5l_mux2_1_4.A0 a_4606_9562# 0.10698f
C1730 sg13cmos5l_mux4_1_0.X a_6676_7216# 0.01098f
C1731 sg13cmos5l_inv_1_19.Y a_5992_4742# 0.03504f
C1732 sg13cmos5l_inv_1_38.A sg13cmos5l_inv_1_70.A 0.96467f
C1733 a_14030_6434# sg13cmos5l_mux2_1_6.A1 0.60377f
C1734 a_4991_3115# a_5687_3191# 0.02453f
C1735 a_11630_4922# sg13cmos5l_mux2_1_0.S 0.17186f
C1736 a_6664_4742# sg13cmos5l_dfrbp_1_2.RESET_B 0.01215f
C1737 a_5505_6516# sg13cmos5l_mux4_1_0.X 0.20413f
C1738 sg13cmos5l_inv_1_72.Y a_1918_8434# 0.01075f
C1739 VPWR a_11314_8058# 0.01505f
C1740 sg13cmos5l_nand2_1_1.B sg13cmos5l_nand2_1_1.A 2.04045f
C1741 sg13cmos5l_buf_1_4.A sg13cmos5l_nand2_1_1.B 0.01561f
C1742 sg13cmos5l_inv_1_107.Y sg13cmos5l_inv_1_97.A 0.03349f
C1743 a_9152_5538# VPWR 0.06986f
C1744 sg13cmos5l_buf_1_12.X sg13cmos5l_o21ai_1_0.B1 0.01604f
C1745 a_2912_6254# VPWR 0.12261f
C1746 sg13cmos5l_mux4_1_0.S0 a_5374_8434# 0.06529f
C1747 VPWR sg13cmos5l_inv_1_30.A 0.54641f
C1748 sg13cmos5l_nand2_1_0.Y a_6291_5004# 0.01137f
C1749 sg13cmos5l_and2_1_0.X a_7520_5538# 0.03523f
C1750 VPWR sg13cmos5l_inv_1_89.A 0.46143f
C1751 sg13cmos5l_buf_1_2.X a_5902_6960# 0.02781f
C1752 sg13cmos5l_buf_1_2.X a_5878_8434# 0.06343f
C1753 sg13cmos5l_inv_1_133.Y sg13cmos5l_inv_1_132.Y 0.04922f
C1754 a_5687_3191# a_6662_3582# 0.0441f
C1755 sg13cmos5l_inv_1_30.Y sg13cmos5l_o21ai_1_0.B1 0.34168f
C1756 a_808_4742# VPWR 0.11502f
C1757 sg13cmos5l_buf_1_4.A sg13cmos5l_inv_1_70.Y 0.19816f
C1758 sg13cmos5l_mux2_1_8.X sg13cmos5l_mux2_1_0.S 0.89278f
C1759 sg13cmos5l_inv_1_130.Y sg13cmos5l_inv_1_123.Y 0.01174f
C1760 sg13cmos5l_o21ai_1_4.Y a_10462_8434# 0.15633f
C1761 a_4991_4164# a_4991_3115# 0.11208f
C1762 sg13cmos5l_nand2b_1_4.A_N sg13cmos5l_o21ai_1_6.B1 0.04116f
C1763 sg13cmos5l_nand2_1_1.A a_5902_6960# 0.3297f
C1764 sg13cmos5l_nand2_1_1.A a_5878_8434# 0.01861f
C1765 sg13cmos5l_inv_1_29.Y sg13cmos5l_inv_1_29.A 1.15957f
C1766 sg13cmos5l_o21ai_1_0.Y sg13cmos5l_o21ai_1_5.Y 0.0191f
C1767 a_6662_3582# a_7365_3155# 0.02431f
C1768 sg13cmos5l_inv_1_82.A sg13cmos5l_inv_1_117.A 0.01416f
C1769 sg13cmos5l_nand2b_1_6.A_N sg13cmos5l_inv_1_125.Y 0.15824f
C1770 sg13cmos5l_mux2_1_7.A1 a_14030_5596# 0.56783f
C1771 sg13cmos5l_o21ai_1_0.A1 sg13cmos5l_inv_1_69.A 0.0306f
C1772 sg13cmos5l_mux4_1_2.A3 sg13cmos5l_mux4_1_2.A1 2.68243f
C1773 a_11371_6137# sg13cmos5l_mux2_1_0.X 0.20867f
C1774 sg13cmos5l_inv_1_111.A sg13cmos5l_inv_1_113.A 0.06096f
C1775 a_19136_10074# VPWR 0.07723f
C1776 sg13cmos5l_mux4_1_2.A3 sg13cmos5l_a221oi_1_0.B1 0.02444f
C1777 a_7365_3155# a_7467_3155# 0.6663f
C1778 sg13cmos5l_inv_1_39.A sg13cmos5l_inv_1_70.A 0.02947f
C1779 a_3776_5538# sg13cmos5l_o21ai_1_0.A1 0.05844f
C1780 a_18856_6168# sg13cmos5l_a21o_1_0.X 0.32715f
C1781 a_5243_9984# a_5566_9946# 0.55132f
C1782 sg13cmos5l_inv_1_129.Y sg13cmos5l_inv_1_1.Y 0.4806f
C1783 a_4492_3894# a_4839_4112# 0.07046f
C1784 sg13cmos5l_mux2_1_3.X a_5063_8434# 0.20233f
C1785 VPWR sg13cmos5l_inv_1_96.A 0.39497f
C1786 a_4187_4712# a_4413_4680# 0.02749f
C1787 VPWR a_5374_8434# 0.88448f
C1788 sg13cmos5l_inv_1_17.A VPWR 0.58762f
C1789 sg13cmos5l_mux4_1_2.A1 sg13cmos5l_mux2_1_0.S 0.276f
C1790 sg13cmos5l_buf_1_4.A sg13cmos5l_inv_1_66.A 0.06414f
C1791 sg13cmos5l_inv_1_7.Y VPWR 0.52046f
C1792 a_7629_5004# VPWR 0.45263f
C1793 sg13cmos5l_a221oi_1_0.B1 a_6574_7216# 0.02494f
C1794 a_5600_4742# VPWR 0.08459f
C1795 a_10139_5448# a_10639_5704# 0.03336f
C1796 a_10462_5410# a_10365_5704# 0.02925f
C1797 a_9832_5538# a_10016_5538# 0.11523f
C1798 sg13cmos5l_mux2_1_0.S sg13cmos5l_a221oi_1_0.B1 0.1845f
C1799 a_4860_3858# a_5781_4052# 0.43042f
C1800 a_4839_4112# a_5642_4052# 0.15089f
C1801 a_4991_4164# a_4750_3894# 0.01058f
C1802 a_9044_3144# sg13cmos5l_dfrbp_1_1.Q 0.13002f
C1803 sg13cmos5l_inv_1_29.Y sg13cmos5l_inv_1_35.Y 0.09693f
C1804 sg13cmos5l_nand2_1_1.B sg13cmos5l_mux4_1_1.A0 0.02034f
C1805 sg13cmos5l_mux2_1_1.X a_5120_4742# 0.06205f
C1806 sg13cmos5l_buf_1_0.X sg13cmos5l_nor4_1_0.Y 0.11071f
C1807 a_4839_4112# sg13cmos5l_dfrbp_1_2.RESET_B 0.55527f
C1808 sg13cmos5l_buf_1_12.X sg13cmos5l_nor2b_1_0.B_N 0.032f
C1809 sg13cmos5l_o21ai_1_0.Y sg13cmos5l_o21ai_1_7.Y 0.34287f
C1810 sg13cmos5l_mux4_1_3.A1 sg13cmos5l_buf_1_2.X 0.0633f
C1811 sg13cmos5l_o21ai_1_0.A1 sg13cmos5l_mux2_1_3.X 0.03548f
C1812 sg13cmos5l_nand3b_1_0.C a_5687_3191# 0.02449f
C1813 sg13cmos5l_inv_1_37.A a_1184_8562# 0.03597f
C1814 sg13cmos5l_mux4_1_2.A3 sg13cmos5l_mux2_1_0.X 0.01683f
C1815 sg13cmos5l_mux2_1_3.A0 sg13cmos5l_o21ai_1_0.A1 0.02177f
C1816 sg13cmos5l_inv_1_107.A a_13917_9462# 0.02199f
C1817 sg13cmos5l_inv_1_96.A sg13cmos5l_inv_1_89.A 0.15307f
C1818 sg13cmos5l_inv_1_70.Y sg13cmos5l_mux4_1_1.A0 0.08051f
C1819 a_4606_9562# a_4783_9216# 0.01068f
C1820 sg13cmos5l_inv_1_107.A VPWR 0.49728f
C1821 sg13cmos5l_nor4_1_0.D sg13cmos5l_buf_1_1.X 0.38144f
C1822 a_1184_5538# sg13cmos5l_buf_1_12.X 0.0114f
C1823 sg13cmos5l_inv_1_133.Y a_15784_6254# 0.04247f
C1824 sg13cmos5l_inv_1_40.A sg13cmos5l_inv_1_70.A 0.19163f
C1825 sg13cmos5l_o21ai_1_7.B1 sg13cmos5l_o21ai_1_0.A1 0.10383f
C1826 sg13cmos5l_nand3b_1_0.C a_7365_3155# 0.01914f
C1827 a_14030_6434# a_14136_6430# 0.55132f
C1828 a_11630_4922# a_12124_5026# 0.01637f
C1829 sg13cmos5l_mux2_1_0.A1 sg13cmos5l_mux2_1_0.S 0.99327f
C1830 sg13cmos5l_buf_1_1.X a_4839_4112# 0.06474f
C1831 sg13cmos5l_nand2_1_1.B sg13cmos5l_a221oi_1_0.A2 0.0819f
C1832 a_4283_9248# VPWR 1.00073f
C1833 sg13cmos5l_nand2_1_1.Y sg13cmos5l_nor4_1_0.Y 0.01313f
C1834 a_5208_5724# VPWR 0.01784f
C1835 a_6142_2428# a_6468_2390# 0.01251f
C1836 sg13cmos5l_inv_1_111.A sg13cmos5l_inv_1_93.A 0.01644f
C1837 a_808_8468# invsel[3] 0.32386f
C1838 a_4510_6558# a_5237_6173# 0.01228f
C1839 sg13cmos5l_inv_1_129.Y sg13cmos5l_inv_1_20.A 0.34473f
C1840 sg13cmos5l_inv_1_106.Y sg13cmos5l_mux2_1_0.S 0.60866f
C1841 sg13cmos5l_mux2_1_3.X sg13cmos5l_mux2_1_2.X 0.40571f
C1842 VPWR sg13cmos5l_inv_1_116.A 0.42779f
C1843 a_1918_8434# VPWR 0.11648f
C1844 a_5063_8434# a_5492_8434# 0.0289f
C1845 sg13cmos5l_inv_1_69.Y sg13cmos5l_inv_1_29.A 0.01788f
C1846 VPWR a_2912_7050# 0.12728f
C1847 sg13cmos5l_inv_1_133.Y sg13cmos5l_inv_1_8.Y 0.04695f
C1848 sg13cmos5l_inv_1_105.Y a_11176_9278# 0.03488f
C1849 sg13cmos5l_inv_1_13.Y VPWR 0.45831f
C1850 sg13cmos5l_o21ai_1_7.Y a_4347_5448# 0.10479f
C1851 sg13cmos5l_mux2_1_0.X sg13cmos5l_mux2_1_0.S 0.65373f
C1852 sg13cmos5l_inv_1_91.A sg13cmos5l_inv_1_92.A 0.15735f
C1853 a_11067_6960# a_11269_6922# 0.01126f
C1854 sg13cmos5l_and2_1_0.B VPWR 0.31564f
C1855 sg13cmos5l_inv_1_29.A sg13cmos5l_buf_1_12.X 0.01658f
C1856 VPWR a_2912_7766# 0.12684f
C1857 sg13cmos5l_nand2_1_0.Y VPWR 0.51591f
C1858 sg13cmos5l_inv_1_70.A sg13cmos5l_nand2_1_1.B 0.06613f
C1859 sg13cmos5l_buf_1_10.X a_9536_8562# 0.05925f
C1860 a_4839_3231# sg13cmos5l_dfrbp_1_2.RESET_B 0.55274f
C1861 sg13cmos5l_inv_1_75.Y sg13cmos5l_buf_1_10.X 0.01913f
C1862 sg13cmos5l_inv_1_125.Y sg13cmos5l_nor4_1_0.Y 0.01357f
C1863 sg13cmos5l_buf_1_2.X sg13cmos5l_buf_1_10.X 0.90146f
C1864 sg13cmos5l_a21o_1_0.X sg13cmos5l_mux2_1_0.S 0.05571f
C1865 sg13cmos5l_buf_1_0.X a_6142_2428# 0.23543f
C1866 sg13cmos5l_inv_1_38.A a_2920_10074# 0.02412f
C1867 sg13cmos5l_nand3b_1_0.C a_6142_2428# 0.07512f
C1868 a_10933_6516# a_12019_6219# 0.02548f
C1869 a_11176_9278# VPWR 0.12721f
C1870 sg13cmos5l_buf_1_1.X a_7260_4192# 0.02035f
C1871 sg13cmos5l_inv_1_70.A sg13cmos5l_inv_1_70.Y 0.09457f
C1872 VPWR a_12120_7660# 0.01867f
C1873 sg13cmos5l_inv_1_37.Y a_1595_8472# 0.06332f
C1874 sg13cmos5l_nand2b_1_6.A_N sg13cmos5l_mux4_1_0.X 0.02494f
C1875 sg13cmos5l_inv_1_18.A a_3008_4026# 0.03646f
C1876 sg13cmos5l_inv_1_118.Y sg13cmos5l_buf_1_12.X 0.20162f
C1877 sg13cmos5l_nor2b_1_2.Y sg13cmos5l_mux4_1_0.X 0.02312f
C1878 sg13cmos5l_inv_1_87.Y a_15784_6254# 0.02074f
C1879 sg13cmos5l_o21ai_1_1.A2 a_4210_6914# 0.09175f
C1880 sg13cmos5l_o21ai_1_6.B1 a_11936_9278# 0.01557f
C1881 a_808_5444# VPWR 0.24785f
C1882 a_12093_9462# a_12175_9562# 0.01126f
C1883 a_14030_6434# a_14202_6538# 0.03097f
C1884 sg13cmos5l_buf_1_1.X a_4839_3231# 0.07386f
C1885 sg13cmos5l_inv_1_72.Y a_4091_8472# 0.03134f
C1886 invsel[3] a_808_7766# 0.01862f
C1887 sg13cmos5l_inv_1_30.Y sg13cmos5l_inv_1_118.Y 0.09867f
C1888 VPWR a_8192_7766# 0.08752f
C1889 sg13cmos5l_inv_1_60.Y sg13cmos5l_inv_1_56.Y 0.24611f
C1890 sg13cmos5l_inv_1_64.Y sg13cmos5l_mux4_1_1.A2 0.02105f
C1891 a_4414_8434# a_4528_8434# 0.03097f
C1892 sg13cmos5l_mux4_1_0.S0 sg13cmos5l_o21ai_1_1.A2 0.08918f
C1893 sg13cmos5l_inv_1_19.A VPWR 0.4751f
C1894 sg13cmos5l_inv_1_127.Y sg13cmos5l_inv_1_20.A 0.01409f
C1895 sg13cmos5l_mux4_1_1.A2 sg13cmos5l_buf_1_2.X 0.01833f
C1896 sg13cmos5l_buf_1_2.X a_10151_8434# 0.54094f
C1897 sg13cmos5l_inv_1_75.Y sg13cmos5l_nor3_1_0.C 0.01485f
C1898 VPWR sg13cmos5l_inv_1_24.A 0.43174f
C1899 sg13cmos5l_buf_1_2.X sg13cmos5l_nor3_1_0.C 0.05521f
C1900 sg13cmos5l_inv_1_5.Y sg13cmos5l_inv_1_9.Y 0.20065f
C1901 sg13cmos5l_buf_1_12.X sg13cmos5l_mux4_1_0.A0 0.02381f
C1902 sg13cmos5l_inv_1_69.Y sg13cmos5l_inv_1_35.Y 0.02331f
C1903 sg13cmos5l_inv_1_87.Y sg13cmos5l_inv_1_8.Y 0.01449f
C1904 sg13cmos5l_inv_1_17.Y VPWR 0.68581f
C1905 a_4347_5448# a_4549_5410# 0.01126f
C1906 sg13cmos5l_inv_1_16.Y sg13cmos5l_mux4_1_0.S0 0.01491f
C1907 a_10715_6528# sg13cmos5l_buf_1_2.X 0.35941f
C1908 sg13cmos5l_inv_1_72.Y sg13cmos5l_nand2_1_1.A 0.02445f
C1909 sg13cmos5l_buf_1_4.A sg13cmos5l_inv_1_72.Y 1.15229f
C1910 sg13cmos5l_buf_1_4.A sg13cmos5l_mux4_1_1.A2 0.09026f
C1911 sg13cmos5l_inv_1_29.Y sg13cmos5l_o21ai_1_0.A2 0.09063f
C1912 sg13cmos5l_o21ai_1_2.B1 a_13760_9278# 0.01211f
C1913 VPWR a_7232_8562# 0.07289f
C1914 sg13cmos5l_a221oi_1_0.B1 sg13cmos5l_a221oi_1_0.C1 0.02728f
C1915 a_4109_3858# VPWR 0.25579f
C1916 sg13cmos5l_mux2_1_8.X a_12019_6219# 0.01381f
C1917 VPWR sg13cmos5l_inv_1_111.Y 0.54677f
C1918 sg13cmos5l_inv_1_70.A sg13cmos5l_inv_1_66.A 0.04359f
C1919 sg13cmos5l_inv_1_116.A sg13cmos5l_inv_1_96.A 0.16625f
C1920 a_8464_3386# VPWR 0.15587f
C1921 sg13cmos5l_mux2_1_6.A0 sg13cmos5l_inv_1_111.A 0.02605f
C1922 sg13cmos5l_inv_1_31.Y sg13cmos5l_inv_1_31.A 0.13129f
C1923 sg13cmos5l_a221oi_1_0.C1 a_6501_7680# 0.03078f
C1924 a_6574_7216# a_6676_7216# 0.22838f
C1925 sg13cmos5l_nor4_1_0.D a_7336_5538# 0.01328f
C1926 a_4199_6558# a_4423_6219# 0.01074f
C1927 a_5014_6558# a_5505_6516# 0.3824f
C1928 sg13cmos5l_nand2b_1_1.Y a_4210_6914# 0.04447f
C1929 a_4860_3858# VPWR 0.07206f
C1930 sg13cmos5l_inv_1_13.Y sg13cmos5l_inv_1_17.A 0.02602f
C1931 sg13cmos5l_mux2_1_3.A0 a_1192_10074# 0.03631f
C1932 a_4510_6558# sg13cmos5l_mux4_1_0.S0 0.07237f
C1933 sg13cmos5l_dfrbp_1_2.D a_5687_3191# 0.30016f
C1934 a_10600_9278# sg13cmos5l_buf_1_2.X 0.01766f
C1935 sg13cmos5l_nand2_1_1.B sg13cmos5l_a221oi_1_0.B1 0.47667f
C1936 sg13cmos5l_inv_1_30.Y sg13cmos5l_inv_1_118.A 0.1103f
C1937 sg13cmos5l_and2_1_0.B a_8236_4656# 0.01357f
C1938 sg13cmos5l_and2_1_0.B a_7629_5004# 0.34186f
C1939 sg13cmos5l_dfrbp_1_1.Q VPWR 0.36262f
C1940 a_5566_9946# a_5680_9946# 0.03097f
C1941 sg13cmos5l_mux4_1_0.S0 sg13cmos5l_inv_1_75.Y 0.03354f
C1942 sg13cmos5l_mux4_1_0.S0 sg13cmos5l_nand2b_1_1.Y 0.14216f
C1943 sg13cmos5l_mux4_1_0.S0 sg13cmos5l_buf_1_2.X 0.60968f
C1944 a_5581_6442# a_5505_6516# 0.2611f
C1945 sg13cmos5l_inv_1_126.Y sg13cmos5l_inv_1_20.A 0.01093f
C1946 sg13cmos5l_buf_1_2.X sg13cmos5l_o21ai_1_6.Y 0.58433f
C1947 sg13cmos5l_inv_1_18.Y a_3008_4026# 0.01054f
C1948 VPWR sg13cmos5l_inv_1_26.Y 0.45402f
C1949 sg13cmos5l_inv_1_88.A sg13cmos5l_inv_1_8.Y 0.01116f
C1950 VPWR sg13cmos5l_o21ai_1_1.A2 0.63432f
C1951 a_10016_6254# VPWR 0.11215f
C1952 sg13cmos5l_inv_1_90.A sg13cmos5l_inv_1_91.A 0.19345f
C1953 a_808_1632# VPWR 0.25817f
C1954 sg13cmos5l_dfrbp_1_2.D a_4991_4164# 0.35606f
C1955 sg13cmos5l_nand2_1_1.A sg13cmos5l_mux4_1_0.S0 1.59359f
C1956 sg13cmos5l_buf_1_4.A sg13cmos5l_mux4_1_0.S0 0.18426f
C1957 sg13cmos5l_inv_1_69.Y a_7616_8562# 0.03541f
C1958 sg13cmos5l_inv_1_16.Y VPWR 0.70827f
C1959 a_4492_3582# VPWR 0.14589f
C1960 sg13cmos5l_inv_1_126.Y sg13cmos5l_inv_1_22.Y 0.01467f
C1961 a_7616_4026# VPWR 0.07467f
C1962 sg13cmos5l_mux2_1_7.A1 sg13cmos5l_mux2_1_0.S 0.46143f
C1963 a_4510_5026# a_4413_5026# 0.01637f
C1964 a_14030_5596# a_14202_5410# 0.03097f
C1965 VPWR sg13cmos5l_inv_1_113.A 0.41556f
C1966 a_1595_8472# a_1821_8728# 0.02749f
C1967 sg13cmos5l_o21ai_1_6.B1 a_9622_8426# 0.03945f
C1968 sg13cmos5l_o21ai_1_5.Y a_5505_6516# 0.02258f
C1969 sg13cmos5l_inv_1_19.A a_5600_4742# 0.04476f
C1970 sg13cmos5l_mux2_1_3.A0 sg13cmos5l_inv_1_73.A 0.19824f
C1971 sg13cmos5l_inv_1_17.Y sg13cmos5l_inv_1_17.A 0.16013f
C1972 sg13cmos5l_inv_1_105.Y sg13cmos5l_buf_1_2.X 0.01489f
C1973 a_4510_6558# VPWR 0.88394f
C1974 sg13cmos5l_inv_1_69.Y a_4528_8434# 0.0213f
C1975 sg13cmos5l_mux4_1_0.S0 sg13cmos5l_inv_1_60.A 0.04224f
C1976 a_18856_6168# osc 0.28823f
C1977 a_4091_8472# VPWR 1.05266f
C1978 sg13cmos5l_o21ai_1_0.A1 sg13cmos5l_o21ai_1_0.B1 0.40186f
C1979 VPWR a_9536_8562# 0.0903f
C1980 sg13cmos5l_inv_1_64.Y VPWR 0.3817f
C1981 sg13cmos5l_mux2_1_0.S sg13cmos5l_inv_1_98.A 0.19229f
C1982 VPWR sg13cmos5l_inv_1_25.Y 0.50113f
C1983 VPWR sg13cmos5l_inv_1_75.Y 0.49988f
C1984 sg13cmos5l_inv_1_4.Y sg13cmos5l_inv_1_5.Y 0.20065f
C1985 VPWR sg13cmos5l_nand2b_1_1.Y 0.74073f
C1986 VPWR sg13cmos5l_buf_1_2.X 2.98668f
C1987 sg13cmos5l_inv_1_45.A sg13cmos5l_mux2_1_4.A0 0.18861f
C1988 a_10462_8434# a_10966_8434# 0.97548f
C1989 VPWR a_2144_7766# 0.08493f
C1990 a_4510_5026# VPWR 0.10687f
C1991 sg13cmos5l_o21ai_1_6.B1 sg13cmos5l_o21ai_1_3.Y 0.06083f
C1992 sg13cmos5l_o21ai_1_5.B1 VPWR 0.44831f
C1993 sg13cmos5l_inv_1_119.Y sg13cmos5l_inv_1_22.Y 0.10209f
C1994 sg13cmos5l_mux2_1_8.X sg13cmos5l_buf_1_10.X 0.29351f
C1995 a_4199_6558# a_4436_6558# 0.01012f
C1996 sg13cmos5l_nand2_1_1.A VPWR 0.94998f
C1997 sg13cmos5l_buf_1_0.X sg13cmos5l_inv_1_22.Y 0.2475f
C1998 sg13cmos5l_buf_1_4.A VPWR 2.23248f
C1999 sg13cmos5l_a21o_1_0.X a_7520_4742# 0.01487f
C2000 sg13cmos5l_mux4_1_2.A3 a_14030_6434# 0.23521f
C2001 sg13cmos5l_inv_1_119.Y sg13cmos5l_nor2b_1_0.B_N 0.01323f
C2002 sg13cmos5l_mux2_1_8.X a_10139_5448# 0.01579f
C2003 sg13cmos5l_dfrbp_1_0.D a_4991_4164# 0.01337f
C2004 sg13cmos5l_nand2b_1_6.A_N sg13cmos5l_dfrbp_1_2.RESET_B 0.01056f
C2005 sg13cmos5l_inv_1_24.A sg13cmos5l_inv_1_116.A 0.16343f
C2006 sg13cmos5l_inv_1_70.A sg13cmos5l_mux4_1_1.A2 0.03707f
C2007 sg13cmos5l_buf_1_2.X sg13cmos5l_inv_1_89.A 0.23953f
C2008 VPWR a_11067_6960# 0.29032f
C2009 sg13cmos5l_mux4_1_1.A0 sg13cmos5l_mux4_1_0.S0 0.29246f
C2010 sg13cmos5l_inv_1_19.A sg13cmos5l_nand2_1_0.Y 0.54315f
C2011 sg13cmos5l_inv_1_58.A a_6760_9278# 0.01078f
C2012 sg13cmos5l_inv_1_17.Y sg13cmos5l_inv_1_13.Y 0.21378f
C2013 sg13cmos5l_inv_1_6.Y sg13cmos5l_mux2_1_0.S 0.01073f
C2014 VPWR sg13cmos5l_inv_1_93.A 0.82994f
C2015 a_2912_6254# sg13cmos5l_buf_1_4.A 0.05865f
C2016 sg13cmos5l_inv_1_69.Y a_4414_8434# 0.57965f
C2017 sg13cmos5l_mux4_1_0.S0 sg13cmos5l_inv_1_55.Y 0.01765f
C2018 a_10933_6516# sg13cmos5l_mux4_1_0.S0 0.06202f
C2019 sg13cmos5l_inv_1_53.Y sg13cmos5l_nor3_1_0.C 0.01296f
C2020 a_4199_6558# sg13cmos5l_o21ai_1_0.A1 0.06741f
C2021 sg13cmos5l_inv_1_68.A sg13cmos5l_inv_1_68.Y 0.60393f
C2022 sg13cmos5l_inv_1_58.A VPWR 0.43105f
C2023 sg13cmos5l_inv_1_130.Y a_9544_4026# 0.01296f
C2024 VPWR sg13cmos5l_inv_1_60.A 0.4509f
C2025 a_14030_6434# sg13cmos5l_mux2_1_0.S 0.1368f
C2026 a_12904_4742# VPWR 0.23161f
C2027 sg13cmos5l_nand2_1_1.Y sg13cmos5l_nor2b_1_0.B_N 0.03252f
C2028 sg13cmos5l_o21ai_1_3.Y a_11457_8476# 0.01118f
C2029 sg13cmos5l_nand2_1_1.B a_6676_7216# 0.0169f
C2030 sg13cmos5l_inv_1_89.A a_11067_6960# 0.19821f
C2031 sg13cmos5l_inv_1_98.A sg13cmos5l_inv_1_98.Y 1.68569f
C2032 sg13cmos5l_inv_1_29.Y sg13cmos5l_buf_1_12.X 0.01871f
C2033 a_5110_5402# VPWR 0.01374f
C2034 sg13cmos5l_inv_1_31.Y sg13cmos5l_dfrbp_1_2.RESET_B 0.01935f
C2035 VPWR sg13cmos5l_inv_1_33.A 0.53199f
C2036 sg13cmos5l_inv_1_106.Y sg13cmos5l_mux4_1_3.A1 0.05034f
C2037 sg13cmos5l_dfrbp_1_2.RESET_B invsel[2] 0.59646f
C2038 sg13cmos5l_inv_1_125.Y sg13cmos5l_inv_1_22.Y 0.05553f
C2039 sg13cmos5l_buf_1_0.X sg13cmos5l_nand3b_1_0.Y 0.0977f
C2040 sg13cmos5l_nand3b_1_0.Y sg13cmos5l_nand3b_1_0.C 0.54302f
C2041 sg13cmos5l_mux4_1_2.A3 a_13856_6254# 0.01667f
C2042 sg13cmos5l_inv_1_122.Y a_10208_9278# 0.05751f
C2043 sg13cmos5l_inv_1_68.A sg13cmos5l_mux2_1_3.X 0.03928f
C2044 sg13cmos5l_o21ai_1_0.Y sg13cmos5l_mux4_1_0.S0 0.78284f
C2045 sg13cmos5l_inv_1_125.Y sg13cmos5l_nor2b_1_0.B_N 0.0193f
C2046 sg13cmos5l_buf_1_10.X sg13cmos5l_a221oi_1_0.B1 1.0997f
C2047 a_8576_5538# VPWR 0.08607f
C2048 sg13cmos5l_mux2_1_3.A0 sg13cmos5l_inv_1_68.A 0.88339f
C2049 sg13cmos5l_inv_1_1.Y sg13cmos5l_inv_1_123.A 0.02545f
C2050 sg13cmos5l_a21oi_1_0.Y a_6197_4656# 0.18823f
C2051 sg13cmos5l_inv_1_70.A sg13cmos5l_mux4_1_0.S0 0.01969f
C2052 a_3016_6168# VPWR 0.34803f
C2053 VPWR a_13760_7050# 0.11872f
C2054 a_7336_5538# a_7520_5538# 0.11523f
C2055 sg13cmos5l_nor2b_1_2.Y a_6574_7216# 0.0109f
C2056 sg13cmos5l_buf_1_2.X sg13cmos5l_inv_1_96.A 0.04616f
C2057 sg13cmos5l_inv_1_17.A sg13cmos5l_buf_1_2.X 0.44624f
C2058 sg13cmos5l_buf_1_2.X a_5374_8434# 0.06848f
C2059 a_9536_9278# VPWR 0.1214f
C2060 sg13cmos5l_mux4_1_1.A0 VPWR 0.55176f
C2061 a_10151_8434# a_10375_8701# 0.01074f
C2062 sg13cmos5l_mux4_1_0.S0 sg13cmos5l_inv_1_53.Y 0.0217f
C2063 sg13cmos5l_inv_1_52.A a_4160_9278# 0.04554f
C2064 sg13cmos5l_buf_1_1.X a_7020_5004# 0.01076f
C2065 sg13cmos5l_mux2_1_8.X sg13cmos5l_mux4_1_0.S0 0.29057f
C2066 a_2920_8562# VPWR 0.20234f
C2067 sg13cmos5l_buf_1_4.A a_5374_8434# 0.05495f
C2068 sg13cmos5l_inv_1_57.A VPWR 0.4344f
C2069 a_3862_5402# sg13cmos5l_o21ai_1_0.A1 0.10902f
C2070 sg13cmos5l_mux2_1_0.A1 sg13cmos5l_buf_1_10.X 0.01712f
C2071 sg13cmos5l_mux2_1_0.S sg13cmos5l_o21ai_1_6.B1 0.23014f
C2072 a_2038_6546# sg13cmos5l_o21ai_1_0.B1 0.12628f
C2073 a_6662_3582# a_6922_3112# 0.87117f
C2074 VPWR sg13cmos5l_inv_1_55.Y 0.43323f
C2075 sg13cmos5l_dfrbp_1_2.RESET_B a_808_6956# 0.04261f
C2076 VPWR a_3116_6882# 0.34195f
C2077 a_10933_6516# VPWR 0.88402f
C2078 a_4347_5448# sg13cmos5l_mux4_1_0.S0 0.01341f
C2079 sg13cmos5l_inv_1_96.A a_11067_6960# 0.01216f
C2080 sg13cmos5l_o21ai_1_0.A1 sg13cmos5l_inv_1_29.A 0.04564f
C2081 sg13cmos5l_inv_1_107.Y a_12904_9278# 0.02203f
C2082 sg13cmos5l_and2_1_0.X sg13cmos5l_inv_1_22.Y 0.0234f
C2083 a_3990_4069# sg13cmos5l_dfrbp_1_0.Q 0.13002f
C2084 sg13cmos5l_dfrbp_1_2.RESET_B invsel[3] 0.74971f
C2085 sg13cmos5l_mux2_1_0.X sg13cmos5l_buf_1_10.X 0.06701f
C2086 a_6948_3148# a_7236_3569# 0.4806f
C2087 sg13cmos5l_dfrbp_1_0.D a_4624_5026# 0.0167f
C2088 VPWR sg13cmos5l_a221oi_1_0.A2 0.30304f
C2089 sg13cmos5l_mux2_1_6.A0 VPWR 0.72546f
C2090 a_14136_5600# a_14202_5704# 0.03336f
C2091 sg13cmos5l_and2_1_0.X sg13cmos5l_nor2b_1_0.B_N 0.039f
C2092 sg13cmos5l_inv_1_14.A sg13cmos5l_o21ai_1_7.B1 0.28535f
C2093 sg13cmos5l_inv_1_3.Y sg13cmos5l_mux2_1_0.A1 1.37618f
C2094 sg13cmos5l_inv_1_20.A sg13cmos5l_inv_1_123.A 0.08128f
C2095 sg13cmos5l_mux2_1_3.A0 sg13cmos5l_inv_1_72.A 0.51569f
C2096 a_5687_3191# sg13cmos5l_dfrbp_1_2.RESET_B 0.09216f
C2097 sg13cmos5l_inv_1_26.Y sg13cmos5l_inv_1_24.A 0.04677f
C2098 sg13cmos5l_o21ai_1_0.Y VPWR 0.70894f
C2099 VPWR sg13cmos5l_inv_1_109.A 0.45521f
C2100 sg13cmos5l_inv_1_85.A sg13cmos5l_inv_1_82.Y 0.07349f
C2101 a_4109_3858# a_4860_3858# 0.01741f
C2102 sg13cmos5l_o21ai_1_1.A2 sg13cmos5l_inv_1_24.A 0.10515f
C2103 a_7467_3155# a_8207_3505# 0.3087f
C2104 sg13cmos5l_nand2_1_1.B sg13cmos5l_inv_1_52.A 1.91641f
C2105 sg13cmos5l_inv_1_73.Y a_808_7766# 0.01986f
C2106 a_10016_5538# sg13cmos5l_buf_1_10.X 0.03649f
C2107 sg13cmos5l_inv_1_70.A VPWR 0.86038f
C2108 sg13cmos5l_buf_1_10.X sg13cmos5l_inv_1_74.Y 0.01535f
C2109 a_11630_4922# VPWR 0.11636f
C2110 a_4860_3505# a_4991_3115# 0.48921f
C2111 sg13cmos5l_inv_1_61.Y VPWR 0.44782f
C2112 a_13856_5538# VPWR 0.089f
C2113 sg13cmos5l_nand2_1_0.Y sg13cmos5l_buf_1_2.X 0.05708f
C2114 sg13cmos5l_o21ai_1_4.Y sg13cmos5l_o21ai_1_3.Y 0.04119f
C2115 a_7365_3155# sg13cmos5l_dfrbp_1_2.RESET_B 0.05264f
C2116 a_10139_5448# a_10016_5538# 0.01107f
C2117 sg13cmos5l_buf_1_4.A a_1918_8434# 0.13207f
C2118 sg13cmos5l_o21ai_1_0.A1 a_4606_9562# 0.16557f
C2119 sg13cmos5l_mux2_1_0.S a_11457_8476# 0.0517f
C2120 sg13cmos5l_inv_1_52.A sg13cmos5l_inv_1_70.Y 0.19259f
C2121 a_4991_4164# a_5642_4052# 0.01562f
C2122 sg13cmos5l_buf_1_1.X sg13cmos5l_nor4_1_0.Y 0.08567f
C2123 sg13cmos5l_mux4_1_2.A1 sg13cmos5l_mux4_1_0.S0 0.04706f
C2124 sg13cmos5l_buf_1_4.A a_2912_7050# 0.01142f
C2125 sg13cmos5l_nand2b_1_6.A_N a_7336_5538# 0.03352f
C2126 a_4991_4164# sg13cmos5l_dfrbp_1_2.RESET_B 0.05488f
C2127 sg13cmos5l_inv_1_124.Y sg13cmos5l_buf_1_10.X 0.01677f
C2128 sg13cmos5l_buf_1_1.X a_5687_3191# 0.01795f
C2129 sg13cmos5l_o21ai_1_5.B1 sg13cmos5l_nand2_1_0.Y 0.18147f
C2130 a_10120_6168# sg13cmos5l_buf_1_10.X 0.29857f
C2131 VPWR sg13cmos5l_inv_1_53.Y 0.43507f
C2132 sg13cmos5l_o21ai_1_3.Y sg13cmos5l_o21ai_1_3.A2 0.26232f
C2133 sg13cmos5l_mux2_1_4.A1 a_4606_9562# 0.58004f
C2134 sg13cmos5l_mux2_1_8.X VPWR 0.78035f
C2135 sg13cmos5l_mux4_1_0.S0 sg13cmos5l_a221oi_1_0.B1 0.24004f
C2136 a_10904_6168# a_11371_6137# 0.49917f
C2137 sg13cmos5l_o21ai_1_0.A1 sg13cmos5l_mux4_1_0.A0 0.36867f
C2138 a_4283_9248# a_4509_9216# 0.02749f
C2139 sg13cmos5l_inv_1_30.Y sg13cmos5l_buf_1_12.X 0.16541f
C2140 sg13cmos5l_inv_1_12.Y sg13cmos5l_buf_1_12.X 0.08536f
C2141 invsel[2] invsel[1] 0.0464f
C2142 a_4347_5448# VPWR 0.28353f
C2143 sg13cmos5l_o21ai_1_0.A1 sg13cmos5l_inv_1_35.Y 0.26306f
C2144 sg13cmos5l_dfrbp_1_2.RESET_B invsel[4] 0.14089f
C2145 sg13cmos5l_nor4_1_0.D sg13cmos5l_dfrbp_1_1.CLK 0.1936f
C2146 sg13cmos5l_buf_1_0.X a_6922_3112# 0.03526f
C2147 sg13cmos5l_nand3b_1_0.C a_6922_3112# 0.02103f
C2148 sg13cmos5l_inv_1_75.Y a_8192_7766# 0.01054f
C2149 sg13cmos5l_mux4_1_1.A0 a_5374_8434# 0.01655f
C2150 sg13cmos5l_inv_1_113.A sg13cmos5l_inv_1_111.Y 0.20239f
C2151 sg13cmos5l_buf_1_1.X a_4991_4164# 0.04744f
C2152 sg13cmos5l_a21oi_1_0.Y sg13cmos5l_dfrbp_1_2.RESET_B 0.02778f
C2153 sg13cmos5l_buf_1_0.X sg13cmos5l_dfrbp_1_0.Q 0.01099f
C2154 sg13cmos5l_inv_1_20.A sg13cmos5l_inv_1_130.Y 0.09793f
C2155 sg13cmos5l_mux2_1_3.A0 sg13cmos5l_inv_1_37.A 0.10596f
C2156 sg13cmos5l_inv_1_19.A sg13cmos5l_buf_1_2.X 0.18259f
C2157 VPWR sg13cmos5l_inv_1_95.A 0.42665f
C2158 a_6142_2428# a_5896_2514# 0.01756f
C2159 a_4510_6558# a_4717_6219# 0.01967f
C2160 sg13cmos5l_mux2_1_0.S a_11533_8440# 0.01872f
C2161 sg13cmos5l_mux4_1_0.X sg13cmos5l_nor2b_1_0.B_N 0.55663f
C2162 sg13cmos5l_o21ai_1_1.A2 sg13cmos5l_inv_1_26.Y 0.02985f
C2163 sg13cmos5l_inv_1_82.A sg13cmos5l_inv_1_82.Y 0.93696f
C2164 a_808_3932# invsel[0] 0.32078f
C2165 a_6944_4026# sg13cmos5l_dfrbp_1_2.RESET_B 0.04561f
C2166 sg13cmos5l_mux2_1_8.X sg13cmos5l_inv_1_89.A 0.01504f
C2167 sg13cmos5l_dfrbp_1_2.D sg13cmos5l_nand3b_1_0.Y 0.0583f
C2168 sg13cmos5l_o21ai_1_6.A2 a_9720_8748# 0.01258f
C2169 a_1184_8562# VPWR 0.07801f
C2170 sg13cmos5l_nand2_1_1.B sg13cmos5l_inv_1_36.A 0.01006f
C2171 sg13cmos5l_inv_1_19.A a_4510_5026# 0.02177f
C2172 sg13cmos5l_nand3b_1_0.C a_8207_3505# 0.06552f
C2173 sg13cmos5l_inv_1_17.Y sg13cmos5l_buf_1_2.X 0.03629f
C2174 sg13cmos5l_buf_1_10.X sg13cmos5l_inv_1_23.Y 0.03918f
C2175 sg13cmos5l_a221oi_1_0.C1 sg13cmos5l_nor2b_1_2.Y 0.22522f
C2176 sg13cmos5l_inv_1_123.A sg13cmos5l_inv_1_6.A 0.01677f
C2177 sg13cmos5l_inv_1_130.A VPWR 0.72883f
C2178 a_6664_4742# VPWR 0.13305f
C2179 a_5120_4742# VPWR 0.08309f
C2180 sg13cmos5l_nor2_1_1.A a_10571_6132# 0.20901f
C2181 sg13cmos5l_inv_1_52.A sg13cmos5l_inv_1_66.A 0.16607f
C2182 sg13cmos5l_buf_1_1.X a_6142_2428# 0.22161f
C2183 sg13cmos5l_mux2_1_0.X sg13cmos5l_mux4_1_0.S0 0.03698f
C2184 VPWR a_10375_8701# 0.02431f
C2185 sg13cmos5l_dfrbp_1_0.D sg13cmos5l_inv_1_22.Y 0.02078f
C2186 a_10933_6516# a_11317_6173# 0.01228f
C2187 sg13cmos5l_mux2_1_6.A0 sg13cmos5l_inv_1_7.Y 0.01288f
C2188 sg13cmos5l_mux4_1_2.A1 VPWR 0.72612f
C2189 a_3990_3431# sg13cmos5l_dfrbp_1_2.Q 0.13002f
C2190 a_4109_3108# a_4860_3505# 0.01741f
C2191 a_10904_6168# sg13cmos5l_mux4_1_2.A3 0.22041f
C2192 sg13cmos5l_inv_1_98.A sg13cmos5l_inv_1_111.A 0.05357f
C2193 sg13cmos5l_inv_1_73.A sg13cmos5l_inv_1_37.Y 0.10166f
C2194 sg13cmos5l_nand2_1_1.B sg13cmos5l_nor2b_1_2.Y 0.28193f
C2195 a_4283_9248# sg13cmos5l_mux4_1_1.A0 0.01437f
C2196 a_4606_9562# a_4720_9562# 0.03097f
C2197 VPWR sg13cmos5l_a221oi_1_0.B1 1.05239f
C2198 sg13cmos5l_o21ai_1_3.Y a_12022_8058# 0.11745f
C2199 a_18568_6254# VPWR 0.15385f
C2200 a_5797_8701# a_5374_8434# 0.01929f
C2201 sg13cmos5l_inv_1_15.Y sg13cmos5l_inv_1_12.Y 0.04545f
C2202 a_4860_3505# sg13cmos5l_nand3b_1_0.C 0.08664f
C2203 VPWR a_6501_7680# 0.01258f
C2204 sg13cmos5l_inv_1_25.Y sg13cmos5l_inv_1_26.Y 0.18584f
C2205 VPWR sg13cmos5l_inv_1_94.A 0.41514f
C2206 sg13cmos5l_inv_1_127.Y a_8968_5538# 0.03474f
C2207 sg13cmos5l_inv_1_44.A sg13cmos5l_inv_1_45.A 0.18681f
C2208 sg13cmos5l_mux2_1_0.S sg13cmos5l_o21ai_1_4.Y 0.19607f
C2209 sg13cmos5l_inv_1_82.A sg13cmos5l_inv_1_85.A 0.19123f
C2210 sg13cmos5l_inv_1_106.Y sg13cmos5l_inv_1_105.Y 0.10946f
C2211 sg13cmos5l_o21ai_1_1.A2 sg13cmos5l_inv_1_25.Y 0.03971f
C2212 sg13cmos5l_inv_1_56.Y sg13cmos5l_mux4_1_0.S0 0.23912f
C2213 a_5902_6960# sg13cmos5l_nor2b_1_2.Y 0.30303f
C2214 sg13cmos5l_inv_1_19.A a_5110_5402# 0.06237f
C2215 a_3116_6882# a_2912_7050# 0.03376f
C2216 sg13cmos5l_nand2_1_1.B sg13cmos5l_inv_1_68.Y 0.02385f
C2217 sg13cmos5l_nand2b_1_1.Y sg13cmos5l_o21ai_1_1.A2 0.3401f
C2218 sg13cmos5l_inv_1_73.Y sg13cmos5l_inv_1_76.A 0.01533f
C2219 sg13cmos5l_buf_1_2.X sg13cmos5l_o21ai_1_1.A2 0.03678f
C2220 sg13cmos5l_mux2_1_3.A0 sg13cmos5l_inv_1_40.A 0.04199f
C2221 sg13cmos5l_o21ai_1_7.Y sg13cmos5l_o21ai_1_7.B1 0.57502f
C2222 a_15880_5538# VPWR 0.14176f
C2223 a_10904_6168# sg13cmos5l_mux2_1_0.S 0.1461f
C2224 sg13cmos5l_inv_1_0.Y VPWR 0.43924f
C2225 a_8768_9278# VPWR 0.09527f
C2226 a_10151_8434# a_10580_8434# 0.0289f
C2227 sg13cmos5l_mux2_1_0.A1 VPWR 0.60604f
C2228 sg13cmos5l_a221oi_1_0.B1 sg13cmos5l_inv_1_89.A 0.19622f
C2229 sg13cmos5l_mux2_1_0.S sg13cmos5l_o21ai_1_3.A2 0.29656f
C2230 sg13cmos5l_o21ai_1_0.A1 sg13cmos5l_mux2_1_4.A0 0.08547f
C2231 enable invsel[4] 0.05458f
C2232 sg13cmos5l_nand2_1_1.A sg13cmos5l_o21ai_1_1.A2 0.50891f
C2233 sg13cmos5l_inv_1_106.Y VPWR 0.53048f
C2234 sg13cmos5l_dfrbp_1_0.D sg13cmos5l_nand3b_1_0.Y 0.0701f
C2235 a_18952_8562# a_19136_8562# 0.11523f
C2236 a_3008_4026# VPWR 0.12455f
C2237 sg13cmos5l_mux2_1_0.X VPWR 0.48524f
C2238 sg13cmos5l_mux2_1_4.A1 sg13cmos5l_mux2_1_4.A0 0.59252f
C2239 sg13cmos5l_nand2_1_1.B sg13cmos5l_mux2_1_3.X 0.15413f
C2240 sg13cmos5l_nor4_1_0.D VPWR 0.90028f
C2241 sg13cmos5l_inv_1_73.A sg13cmos5l_inv_1_73.Y 0.24446f
C2242 sg13cmos5l_mux2_1_3.A0 sg13cmos5l_nand2_1_1.B 0.45348f
C2243 sg13cmos5l_o21ai_1_0.A1 sg13cmos5l_o21ai_1_0.A2 1.06554f
C2244 sg13cmos5l_inv_1_87.Y sg13cmos5l_inv_1_82.Y 0.06024f
C2245 sg13cmos5l_o21ai_1_3.Y sg13cmos5l_o21ai_1_3.B1 0.2627f
C2246 a_12093_9462# sg13cmos5l_o21ai_1_6.B1 0.35368f
C2247 sg13cmos5l_mux4_1_3.A1 a_11544_9172# 0.01429f
C2248 sg13cmos5l_a21o_1_0.X VPWR 2.00828f
C2249 a_4839_4112# VPWR 0.20744f
C2250 sg13cmos5l_inv_1_70.Y sg13cmos5l_mux2_1_3.X 0.04704f
C2251 a_2920_10074# VPWR 0.20601f
C2252 a_10016_5538# VPWR 0.06627f
C2253 sg13cmos5l_inv_1_54.Y a_7712_9278# 0.05751f
C2254 VPWR sg13cmos5l_inv_1_74.Y 0.49641f
C2255 a_4510_6558# sg13cmos5l_buf_1_2.X 0.03321f
C2256 a_7020_5004# a_7520_4742# 0.02875f
C2257 sg13cmos5l_inv_1_103.A sg13cmos5l_inv_1_107.Y 0.01039f
C2258 sg13cmos5l_nand3b_1_0.Y a_6197_4656# 0.11352f
C2259 sg13cmos5l_inv_1_126.Y a_8968_5538# 0.03495f
C2260 sg13cmos5l_buf_1_2.X sg13cmos5l_inv_1_75.Y 0.03057f
C2261 sg13cmos5l_buf_1_10.X sg13cmos5l_inv_1_75.A 0.02813f
C2262 sg13cmos5l_inv_1_133.Y a_14136_5600# 0.02684f
C2263 sg13cmos5l_o21ai_1_7.B1 a_4549_5410# 0.01048f
C2264 a_4510_6558# sg13cmos5l_buf_1_4.A 0.0286f
C2265 sg13cmos5l_inv_1_56.Y VPWR 0.60577f
C2266 sg13cmos5l_inv_1_124.Y VPWR 0.42749f
C2267 a_10120_6168# VPWR 0.3125f
C2268 sg13cmos5l_a221oi_1_0.B1 sg13cmos5l_inv_1_96.A 0.07933f
C2269 a_808_6254# invsel[2] 0.01199f
C2270 sg13cmos5l_buf_1_4.A a_4091_8472# 0.1732f
C2271 sg13cmos5l_inv_1_69.Y a_7048_8562# 0.01071f
C2272 sg13cmos5l_mux2_1_0.S sg13cmos5l_inv_1_97.A 0.13284f
C2273 sg13cmos5l_inv_1_73.Y sg13cmos5l_inv_1_33.Y 0.04464f
C2274 sg13cmos5l_o21ai_1_5.B1 sg13cmos5l_buf_1_2.X 0.07102f
C2275 a_3990_3431# VPWR 0.37477f
C2276 sg13cmos5l_buf_1_4.A sg13cmos5l_nand2b_1_1.Y 0.21631f
C2277 sg13cmos5l_nand2_1_1.A sg13cmos5l_buf_1_2.X 1.08484f
C2278 sg13cmos5l_buf_1_4.A sg13cmos5l_buf_1_2.X 0.10502f
C2279 a_7260_4192# VPWR 0.01155f
C2280 sg13cmos5l_inv_1_37.Y sg13cmos5l_inv_1_68.A 0.10091f
C2281 sg13cmos5l_o21ai_1_0.A1 a_4414_8434# 0.04572f
C2282 sg13cmos5l_inv_1_98.Y sg13cmos5l_o21ai_1_3.A2 1.60228f
C2283 a_11371_6137# a_11836_6558# 0.0289f
C2284 sg13cmos5l_o21ai_1_5.B1 sg13cmos5l_buf_1_4.A 0.08512f
C2285 sg13cmos5l_inv_1_73.A sg13cmos5l_inv_1_51.Y 0.24162f
C2286 sg13cmos5l_buf_1_4.A sg13cmos5l_nand2_1_1.A 1.8533f
C2287 a_4839_3231# VPWR 0.21115f
C2288 sg13cmos5l_o21ai_1_0.A1 sg13cmos5l_inv_1_29.Y 0.01757f
C2289 osc VGND 1.3368f
C2290 VPWR VGND 0.0726f
C2291 a_19136_1002# VGND 0.07577f ; **FLOATING
C2292 a_18952_1002# VGND 0.12409f ; **FLOATING
C2293 a_19048_1718# VGND 0.13512f ; **FLOATING
C2294 a_808_1632# VGND 0.25428f
C2295 a_6468_2390# VGND 0.23877f
C2296 a_5896_2514# VGND 0.12964f ; **FLOATING
C2297 sg13cmos5l_dfrbp_1_1.Q VGND 0.44747f
C2298 a_7305_3191# VGND 0.3063f
C2299 a_5883_3191# VGND 0.08491f
C2300 a_8626_3582# VGND 0.47514f
C2301 a_8113_3505# VGND 0.51174f
C2302 a_9044_3144# VGND 0.07211f
C2303 a_7236_3569# VGND 0.94212f
C2304 a_7174_3569# VGND 0.90061f
C2305 a_6662_3582# VGND 0.4266f
C2306 a_6434_3582# VGND 0.86398f
C2307 a_4750_3267# VGND 0.23562f
C2308 a_5687_3191# VGND 2.17032f
C2309 a_6038_3569# VGND 1.00784f
C2310 a_5642_3424# VGND 1.04831f
C2311 a_4750_3582# VGND 0.25301f
C2312 a_4586_3582# VGND 0.11633f
C2313 sg13cmos5l_dfrbp_1_2.Q VGND 0.5461f
C2314 a_4492_3582# VGND 0.11284f
C2315 a_19048_4026# VGND 0.17047f ; **FLOATING
C2316 a_9544_4026# VGND 0.13296f ; **FLOATING
C2317 sg13cmos5l_dfrbp_1_1.CLK VGND 0.12441f
C2318 a_7616_4026# VGND 0.04324f ; **FLOATING
C2319 a_7362_4192# VGND 0.20039f
C2320 a_6944_4026# VGND 0.04423f ; **FLOATING
C2321 a_6038_3907# VGND 1.02954f
C2322 a_4750_3894# VGND 0.285f
C2323 a_4586_3894# VGND 0.47479f
C2324 a_5642_4052# VGND 0.08472f
C2325 a_5883_4285# VGND 1.03307f
C2326 a_5687_4285# VGND 1.25713f
C2327 a_4750_4209# VGND 0.11221f
C2328 a_4839_4112# VGND 0.0149f
C2329 a_3776_4026# VGND 0.0696f ; **FLOATING
C2330 sg13cmos5l_dfrbp_1_0.Q VGND 0.45164f
C2331 a_3008_4026# VGND 0.06239f ; **FLOATING
C2332 a_1568_4026# VGND 0.06098f ; **FLOATING
C2333 a_19048_4742# VGND 0.13511f ; **FLOATING
C2334 a_13760_4742# VGND 0.06986f ; **FLOATING
C2335 a_12904_4742# VGND 0.09657f ; **FLOATING
C2336 a_12062_4680# VGND 0.27726f
C2337 a_11802_4680# VGND 0.12754f
C2338 sg13cmos5l_inv_1_0.Y VGND 0.02787f
C2339 sg13cmos5l_inv_1_130.Y VGND 0.44685f
C2340 a_7723_5004# VGND 0.2129f
C2341 a_7520_4742# VGND 0.04494f ; **FLOATING
C2342 a_6849_4656# VGND 0.31109f
C2343 sg13cmos5l_and2_1_0.B VGND 0.24387f
C2344 a_6943_5004# VGND 0.97388f
C2345 a_6664_4742# VGND 0.08727f ; **FLOATING
C2346 a_6197_4656# VGND 0.12334f
C2347 a_7020_5004# VGND 0.27538f
C2348 a_6291_5004# VGND 0.8443f
C2349 a_5992_4742# VGND 0.08292f ; **FLOATING
C2350 sg13cmos5l_inv_1_22.Y VGND 5.29437f
C2351 a_5600_4742# VGND 0.04036f ; **FLOATING
C2352 a_5338_5026# VGND 0.32224f
C2353 a_5120_4742# VGND 0.04193f ; **FLOATING
C2354 a_4413_4680# VGND 0.07395f
C2355 a_4624_5026# VGND 0.09015f
C2356 a_4413_5026# VGND 1.50855f
C2357 a_3776_4742# VGND 0.06272f ; **FLOATING
C2358 a_2920_4742# VGND 0.10122f ; **FLOATING
C2359 a_992_4742# VGND 0.03785f ; **FLOATING
C2360 a_808_4742# VGND 0.1149f ; **FLOATING
C2361 a_19048_5538# VGND 0.13472f ; **FLOATING
C2362 a_15880_5538# VGND 0.08783f ; **FLOATING
C2363 a_14202_5410# VGND 0.27484f
C2364 a_14202_5704# VGND 0.33317f
C2365 sg13cmos5l_inv_1_7.Y VGND 0.09286f
C2366 a_13856_5538# VGND 0.0906f ; **FLOATING
C2367 a_11744_5538# VGND 0.08437f ; **FLOATING
C2368 a_10576_5410# VGND 0.10078f
C2369 a_10365_5410# VGND 0.42767f
C2370 sg13cmos5l_inv_1_3.Y VGND 0.04337f
C2371 a_10365_5704# VGND 0.35691f
C2372 a_10016_5538# VGND 0.0381f ; **FLOATING
C2373 a_9832_5538# VGND 0.08616f ; **FLOATING
C2374 a_9152_5538# VGND 0.04099f ; **FLOATING
C2375 a_8968_5538# VGND 0.08887f ; **FLOATING
C2376 a_8576_5538# VGND 0.0419f ; **FLOATING
C2377 a_8192_5538# VGND 0.0418f ; **FLOATING
C2378 a_7520_5538# VGND 0.03776f ; **FLOATING
C2379 a_7336_5538# VGND 0.07795f ; **FLOATING
C2380 a_6944_5538# VGND 0.03659f ; **FLOATING
C2381 a_6760_5538# VGND 0.07622f ; **FLOATING
C2382 a_6415_5410# VGND 1.02581f
C2383 a_5110_5402# VGND 1.11668f
C2384 sg13cmos5l_inv_1_127.Y VGND 0.39093f
C2385 sg13cmos5l_inv_1_125.Y VGND 0.3537f
C2386 sg13cmos5l_and2_1_0.X VGND 0.11149f
C2387 sg13cmos5l_nand2b_1_6.A_N VGND 0.16642f
C2388 a_3862_5402# VGND 1.08512f
C2389 sg13cmos5l_inv_1_19.Y VGND 0.23293f
C2390 sg13cmos5l_inv_1_16.Y VGND 0.40455f
C2391 sg13cmos5l_inv_1_15.Y VGND 0.12999f
C2392 a_3776_5538# VGND 0.06229f ; **FLOATING
C2393 sg13cmos5l_o21ai_1_7.B1 VGND 0.11138f
C2394 sg13cmos5l_inv_1_10.Y VGND 0.05152f
C2395 a_1184_5538# VGND 0.04442f ; **FLOATING
C2396 a_808_5444# VGND 0.20403f
C2397 a_18752_6254# VGND 0.04162f ; **FLOATING
C2398 a_18568_6254# VGND 0.12179f ; **FLOATING
C2399 sg13cmos5l_a21o_1_0.X VGND 0.05667f
C2400 a_18856_6168# VGND 0.09312f
C2401 sg13cmos5l_mux2_1_7.A1 VGND 0.17643f
C2402 a_15968_6254# VGND 0.03837f ; **FLOATING
C2403 a_15784_6254# VGND 0.07673f ; **FLOATING
C2404 a_14462_6192# VGND 1.28429f
C2405 a_14202_6192# VGND 0.1797f
C2406 a_14524_6538# VGND 0.19653f
C2407 a_14202_6538# VGND 0.24838f
C2408 a_13856_6254# VGND 0.08954f ; **FLOATING
C2409 a_12019_6219# VGND 0.08923f
C2410 a_11827_6219# VGND 1.40896f
C2411 a_11317_6173# VGND 0.13331f
C2412 a_11600_6173# VGND 0.32391f
C2413 sg13cmos5l_inv_1_88.A VGND 0.14534f
C2414 sg13cmos5l_mux2_1_6.A1 VGND 0.1113f
C2415 a_12124_6558# VGND 0.41059f
C2416 a_11836_6558# VGND 0.32158f
C2417 a_11620_6558# VGND 0.07353f
C2418 a_11409_6558# VGND 0.45805f
C2419 a_10933_6516# VGND 1.18981f
C2420 sg13cmos5l_mux4_1_2.A1 VGND 0.08323f
C2421 a_10904_6168# VGND 2.61797f
C2422 a_10016_6254# VGND 0.0579f ; **FLOATING
C2423 a_7468_6168# VGND 0.48776f
C2424 sg13cmos5l_inv_1_138.Y VGND 0.14945f
C2425 a_6848_6254# VGND 0.08403f ; **FLOATING
C2426 a_5237_6173# VGND 0.68732f
C2427 a_4717_6219# VGND 0.23268f
C2428 a_4423_6219# VGND 0.24388f
C2429 sg13cmos5l_nor2_1_1.A VGND 0.96234f
C2430 a_5505_6516# VGND 0.03939f
C2431 a_4938_6558# VGND 0.25131f
C2432 a_4510_6558# VGND 0.11302f
C2433 a_4436_6558# VGND 0.17473f
C2434 a_3776_6254# VGND 0.06411f ; **FLOATING
C2435 a_5014_6558# VGND 1.35603f
C2436 a_2912_6254# VGND 0.06278f ; **FLOATING
C2437 sg13cmos5l_o21ai_1_0.Y VGND 0.14099f
C2438 a_2038_6546# VGND 0.37913f
C2439 a_1765_6538# VGND 0.16485f
C2440 a_808_6254# VGND 0.11815f ; **FLOATING
C2441 sg13cmos5l_inv_1_30.Y VGND 0.15718f
C2442 a_19048_7050# VGND 0.16251f ; **FLOATING
C2443 a_13760_7050# VGND 0.06723f ; **FLOATING
C2444 sg13cmos5l_inv_1_109.A VGND 0.37755f
C2445 a_12904_7050# VGND 0.11374f ; **FLOATING
C2446 a_12128_7050# VGND 0.04272f ; **FLOATING
C2447 a_11269_6922# VGND 0.06298f
C2448 a_10888_7050# VGND 0.09321f ; **FLOATING
C2449 a_10408_7050# VGND 0.09149f ; **FLOATING
C2450 a_10016_7050# VGND 0.04269f ; **FLOATING
C2451 a_9632_7050# VGND 0.04723f ; **FLOATING
C2452 a_6982_6944# VGND 0.18899f
C2453 a_6676_6944# VGND 0.34808f
C2454 sg13cmos5l_inv_1_24.A VGND 0.35033f
C2455 sg13cmos5l_inv_1_25.Y VGND 0.20691f
C2456 a_7370_7216# VGND 0.11582f
C2457 a_6676_7216# VGND 0.97193f
C2458 a_6574_7216# VGND 0.8993f
C2459 a_6368_7050# VGND 0.04025f ; **FLOATING
C2460 a_4210_6914# VGND 0.51623f
C2461 a_6124_7216# VGND 0.75535f
C2462 a_2912_7050# VGND 0.05935f ; **FLOATING
C2463 a_2245_6922# VGND 0.88892f
C2464 sg13cmos5l_inv_1_31.A VGND 0.06516f
C2465 a_19136_7766# VGND 0.09543f ; **FLOATING
C2466 a_14344_7766# VGND 0.0827f ; **FLOATING
C2467 sg13cmos5l_inv_1_113.A VGND 0.37943f
C2468 sg13cmos5l_inv_1_93.A VGND 0.34504f
C2469 a_12022_8058# VGND 1.9295f
C2470 a_11314_8058# VGND 0.45324f
C2471 sg13cmos5l_inv_1_83.A VGND 0.18039f
C2472 sg13cmos5l_nand2b_1_2.Y VGND 0.27985f
C2473 a_8192_7766# VGND 0.09182f ; **FLOATING
C2474 sg13cmos5l_inv_1_74.A VGND 0.35379f
C2475 sg13cmos5l_inv_1_75.A VGND 0.28261f
C2476 sg13cmos5l_a221oi_1_0.C1 VGND 0.41712f
C2477 a_6272_7766# VGND 0.06005f ; **FLOATING
C2478 sg13cmos5l_inv_1_35.Y VGND 0.0957f
C2479 a_2912_7766# VGND 0.05945f ; **FLOATING
C2480 sg13cmos5l_o21ai_1_0.A2 VGND 0.87372f
C2481 a_2144_7766# VGND 0.04134f ; **FLOATING
C2482 a_808_7766# VGND 0.11873f ; **FLOATING
C2483 sg13cmos5l_inv_1_76.A VGND 0.14092f
C2484 a_19136_8562# VGND 0.07463f ; **FLOATING
C2485 a_18952_8562# VGND 0.12139f ; **FLOATING
C2486 sg13cmos5l_inv_1_97.A VGND 0.46671f
C2487 a_12992_8562# VGND 0.03918f ; **FLOATING
C2488 a_12808_8562# VGND 0.12007f ; **FLOATING
C2489 a_10890_8434# VGND 0.17361f
C2490 a_10388_8434# VGND 0.08303f
C2491 a_9622_8426# VGND 0.96753f
C2492 a_11189_8747# VGND 0.23369f
C2493 a_10966_8434# VGND 0.9232f
C2494 a_10669_8701# VGND 0.67068f
C2495 a_10462_8434# VGND 0.4231f
C2496 a_10375_8701# VGND 0.1138f
C2497 sg13cmos5l_o21ai_1_3.Y VGND 0.38773f
C2498 a_9720_8748# VGND 0.07223f
C2499 a_9536_8562# VGND 0.08268f ; **FLOATING
C2500 a_7616_8562# VGND 0.04188f ; **FLOATING
C2501 a_7232_8562# VGND 0.0357f ; **FLOATING
C2502 a_7048_8562# VGND 0.07657f ; **FLOATING
C2503 a_6015_8434# VGND 0.2806f
C2504 a_5802_8434# VGND 0.19571f
C2505 a_5492_8434# VGND 0.07113f
C2506 a_5300_8434# VGND 0.27076f
C2507 sg13cmos5l_inv_1_60.A VGND 0.41029f
C2508 a_6369_8476# VGND 0.12751f
C2509 a_6101_8747# VGND 0.40326f
C2510 a_5878_8434# VGND 1.33742f
C2511 a_5581_8701# VGND 0.46375f
C2512 a_5374_8434# VGND 0.08616f
C2513 a_5797_8701# VGND 0.31431f
C2514 sg13cmos5l_buf_1_2.X VGND 0.11986f
C2515 sg13cmos5l_mux2_1_2.X VGND 0.214f
C2516 a_4591_8728# VGND 0.4437f
C2517 a_4317_8728# VGND 0.10937f
C2518 sg13cmos5l_inv_1_69.Y VGND 0.52075f
C2519 a_2920_8562# VGND 0.1098f ; **FLOATING
C2520 a_2032_8434# VGND 0.10487f
C2521 a_1821_8434# VGND 0.16898f
C2522 a_1821_8728# VGND 0.4578f
C2523 a_1918_8434# VGND 0.16857f
C2524 a_1184_8562# VGND 0.0445f ; **FLOATING
C2525 a_808_8468# VGND 0.23134f
C2526 a_19048_9278# VGND 0.13655f ; **FLOATING
C2527 a_13999_9562# VGND 0.26341f
C2528 a_13760_9278# VGND 0.07028f ; **FLOATING
C2529 a_12904_9278# VGND 0.10108f ; **FLOATING
C2530 a_12175_9562# VGND 0.13908f
C2531 a_11936_9278# VGND 0.0435f ; **FLOATING
C2532 a_12093_9462# VGND 0.0726f
C2533 a_11360_9278# VGND 0.03597f ; **FLOATING
C2534 a_11176_9278# VGND 0.07899f ; **FLOATING
C2535 a_11446_9570# VGND 0.27541f
C2536 sg13cmos5l_o21ai_1_2.B1 VGND 0.25451f
C2537 a_10784_9278# VGND 0.0355f ; **FLOATING
C2538 a_10600_9278# VGND 0.07763f ; **FLOATING
C2539 a_10208_9278# VGND 0.04234f ; **FLOATING
C2540 sg13cmos5l_inv_1_122.Y VGND 0.18872f
C2541 a_9536_9278# VGND 0.05759f ; **FLOATING
C2542 sg13cmos5l_o21ai_1_6.A2 VGND 0.13882f
C2543 a_8768_9278# VGND 0.08375f ; **FLOATING
C2544 a_7712_9278# VGND 0.04186f ; **FLOATING
C2545 a_7240_9278# VGND 0.0849f ; **FLOATING
C2546 a_6760_9278# VGND 0.12585f ; **FLOATING
C2547 a_4783_9216# VGND 0.10226f
C2548 a_4509_9216# VGND 0.46362f
C2549 sg13cmos5l_mux4_1_1.A0 VGND 0.25045f
C2550 a_4720_9562# VGND 0.10234f
C2551 a_4160_9278# VGND 0.04206f ; **FLOATING
C2552 sg13cmos5l_inv_1_70.Y VGND 0.09408f
C2553 a_3776_9278# VGND 0.06899f ; **FLOATING
C2554 sg13cmos5l_inv_1_52.A VGND 0.31359f
C2555 sg13cmos5l_inv_1_36.A VGND 0.44139f
C2556 sg13cmos5l_inv_1_72.A VGND 0.42796f
C2557 a_1184_9278# VGND 0.04415f ; **FLOATING
C2558 sg13cmos5l_inv_1_37.Y VGND 0.19446f
C2559 a_19136_10074# VGND 0.12323f ; **FLOATING
C2560 sg13cmos5l_inv_1_107.A VGND 0.2174f
C2561 a_13760_10074# VGND 0.06579f ; **FLOATING
C2562 sg13cmos5l_inv_1_103.A VGND 0.72527f
C2563 sg13cmos5l_inv_1_99.Y VGND 0.19313f
C2564 sg13cmos5l_inv_1_99.A VGND 0.15079f
C2565 a_6184_10074# VGND 0.08718f ; **FLOATING
C2566 a_5680_9946# VGND 0.10642f
C2567 a_5469_9946# VGND 0.63743f
C2568 a_5743_10240# VGND 0.13768f
C2569 sg13cmos5l_inv_1_58.A VGND 0.08964f
C2570 sg13cmos5l_inv_1_44.A VGND 0.17948f
C2571 sg13cmos5l_inv_1_42.A VGND 0.34972f
C2572 a_2920_10074# VGND 0.10664f ; **FLOATING
C2573 sg13cmos5l_inv_1_70.A VGND 0.09706f
C2574 a_1192_10074# VGND 0.09045f ; **FLOATING
C2575 sg13cmos5l_inv_1_73.A VGND 0.10202f
C2576 sg13cmos5l_inv_1_39.A VGND 0.54793f
C2577 sg13cmos5l_dfrbp_1_2.RESET_B.t0 VGND 0.70041f
C2578 sg13cmos5l_dfrbp_1_2.RESET_B.n0 VGND 1.56335f
C2579 sg13cmos5l_dfrbp_1_2.RESET_B.n1 VGND 1.15779f
C2580 sg13cmos5l_dfrbp_1_2.RESET_B.n2 VGND 7.6576f
C2581 VGND.t21 VGND 1.25599f
C2582 VGND.t12 VGND 0.61927f
C2583 VGND.t55 VGND 0.27765f
C2584 VGND.t292 VGND 2.80404f
C2585 VGND.t376 VGND 0.15618f
C2586 VGND.t30 VGND 5.41878f
C2587 VGND.t706 VGND 1.10494f
C2588 VGND.t287 VGND 0.62367f
C2589 VGND.t484 VGND 0.55681f
C2590 VGND.t498 VGND 0.07473f
C2591 VGND.t499 VGND 0.16919f
C2592 VGND.t504 VGND 0.51906f
C2593 VGND.t503 VGND 0.25296f
C2594 VGND.t508 VGND 0.15632f
C2595 VGND.t509 VGND 0.72484f
C2596 VGND.t514 VGND 0.07539f
C2597 VGND.t511 VGND 0.56853f
C2598 VGND.t518 VGND 0.75155f
C2599 VGND.t519 VGND 1.87708f
C2600 VGND.t521 VGND 1.12553f
C2601 VGND.t529 VGND 0.15574f
C2602 VGND.t534 VGND 0.7599f
C2603 VGND.t539 VGND 1.02079f
C2604 VGND.t544 VGND 0.03976f
C2605 VGND.t541 VGND 1.02079f
C2606 VGND.t548 VGND 0.03324f
C2607 VGND.t549 VGND 0.03324f
C2608 VGND.t564 VGND 0.39623f
C2609 VGND.t569 VGND 1.1191f
C2610 VGND.t58 VGND 0.4228f
C2611 VGND.t7 VGND 0.94546f
C2612 VGND.t38 VGND 0.84566f
C2613 VGND.t1 VGND 0.36214f
C2614 VGND.t686 VGND 1.02672f
C2615 VGND.t208 VGND 1.57529f
C2616 VGND.t210 VGND 1.49231f
C2617 VGND.t54 VGND 0.14534f
C2618 VGND.t162 VGND 0.43686f
C2619 VGND.t622 VGND 0.19446f
C2620 VGND.t763 VGND 0.3598f
C2621 VGND.t164 VGND 0.53948f
C2622 VGND.t137 VGND 0.64947f
C2623 VGND.t138 VGND 0.47332f
C2624 VGND.t144 VGND 0.72021f
C2625 VGND.t89 VGND 0.41029f
C2626 VGND.t84 VGND 0.56727f
C2627 VGND.t87 VGND 0.72527f
C2628 VGND.t81 VGND 0.10312p
C2629 VGND.t102 VGND 0.31456f
C2630 VGND.t97 VGND 0.70023f
C2631 VGND.t72 VGND 0.38319f
C2632 VGND.t46 VGND 0.6249f
C2633 VGND.t14 VGND 0.44139f
C2634 VGND.t64 VGND 0.88507f
C2635 VGND.t663 VGND 0.22291f
C2636 VGND.t248 VGND 2.54356f
C2637 VGND.t10 VGND 0.37355f
C2638 VGND.t28 VGND 2.12237f
C2639 VGND.t641 VGND 1.13313f
C2640 VGND.t32 VGND 0.33284f
C2641 VGND.t627 VGND 3.8808f
C2642 VGND.t36 VGND 0.33279f
C2643 VGND.t310 VGND 0.24304f
C2644 VGND.t311 VGND 0.33268f
C2645 VGND.t308 VGND 0.95007f
C2646 VGND.t305 VGND 0.61598f
C2647 VGND.t304 VGND 0.04853f
C2648 VGND.t302 VGND 0.80143f
C2649 VGND.t300 VGND 2.87956f
C2650 VGND.t352 VGND 0.63656f
C2651 VGND.t350 VGND 2.87956f
C2652 VGND.t299 VGND 0.93815f
C2653 VGND.t347 VGND 0.17709p
C2654 VGND.t23 VGND 0.89204f
C2655 VGND.t294 VGND 0.87923f
C2656 VGND.t313 VGND 1.87807f
C2657 VGND.t314 VGND 45.99076f
C2658 VGND.t317 VGND 0.24115f
C2659 VGND.t325 VGND 0.0902f
C2660 VGND.t326 VGND 0.0902f
C2661 VGND.t329 VGND 0.13638f
C2662 VGND.t330 VGND 0.13638f
C2663 VGND.t332 VGND 0.10501f
C2664 VGND.t335 VGND 0.10786f
C2665 VGND.t334 VGND 1.39905f
C2666 VGND.t312 VGND 1.5051f
C2667 VGND.t410 VGND 0.17209f
C2668 VGND.t402 VGND 2.02089f
C2669 VGND.t394 VGND 48.70702f
C2670 VGND.t20 VGND 0.17173f
C2671 VGND.t583 VGND 0.935f
C2672 VGND.t588 VGND 0.07046f
C2673 VGND.t587 VGND 0.07046f
C2674 VGND.t598 VGND 1.47013f
C2675 VGND.t603 VGND 0.06649f
C2676 VGND.t608 VGND 2.10888f
C2677 VGND.t613 VGND 0.29701f
C2678 VGND.t612 VGND 0.29701f
C2679 VGND.t610 VGND 2.10888f
C2680 VGND.t585 VGND 0.8736f
C2681 VGND.t516 VGND 0.07539f
C2682 VGND.t506 VGND 0.2661f
.ends
