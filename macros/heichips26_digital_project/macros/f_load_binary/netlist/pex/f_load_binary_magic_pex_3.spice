* PEX produced on Thu Oct  1 10:19:57 PM CEST 2026 using scripts/sak-pex.sh with m=3 and s=1 (extresist threshold=10000 mOhm, minres=1000 mOhm, mindelay=1 ps)
* NGSPICE file created from f_load_binary_pex.ext - technology: ihp-sg13cmos5l

.subckt f_load_binary_pex VPWR VGND en[0] en[1] en[2] en[3] en[4] osc
X0 VPWR.t309 sg13cmos5l_dfrbpq_1_53.RESET_B.t8 a_25354_7648# VPWR.t2 sg13_lv_pmos ad=0.1563p pd=1.22u as=0.147p ps=1.54u w=0.42u l=0.13u
X1 sg13cmos5l_and2_1_1.A a_18843_5410# VGND.t133 VGND.t1394 sg13_lv_nmos ad=0.1406p pd=1.12u as=0.1406p ps=1.12u w=0.74u l=0.13u
X2 VGND.t664 a_6453_4703# a_5532_5017# VGND.t663 sg13_lv_nmos ad=0.1626p pd=1.415u as=0.2516p ps=2.16u w=0.74u l=0.13u
X3 a_7594_5374# sg13cmos5l_buf_8_9.A VGND.t131 VGND.t1569 sg13_lv_nmos ad=0.2553p pd=2.17u as=0.1406p ps=1.12u w=0.74u l=0.13u
X4 sg13cmos5l_nand3_1_0.B sg13cmos5l_nor4_2_0.B VGND.t160 VGND.t214 sg13_lv_nmos ad=0.1406p pd=1.12u as=0.3293p ps=1.63u w=0.74u l=0.13u
X5 a_24540_3902# sg13cmos5l_nand3_1_2.A sg13cmos5l_nand3_1_2.Y VGND.t202 sg13_lv_nmos ad=0.1406p pd=1.12u as=0.2516p ps=2.16u w=0.74u l=0.13u
X6 VPWR.t227 sg13cmos5l_nand3_1_2.C sg13cmos5l_nand3_1_2.Y VPWR.t43 sg13_lv_pmos ad=0.3808p pd=2.92u as=0.2128p ps=1.5u w=1.12u l=0.13u
X7 VPWR.t221 sg13cmos5l_buf_1_0.X.t5 a_24326_6606# VPWR.t7 sg13_lv_pmos ad=0.36237p pd=2.605u as=79.8f ps=0.8u w=0.42u l=0.13u
X8 a_16164_5724# a_16138_5629# VGND.t350 VGND.t762 sg13_lv_nmos ad=0.2516p pd=2.16u as=0.1626p ps=1.415u w=0.74u l=0.13u
X9 VPWR.t108 sg13cmos5l_dfrbpq_1_13.RESET_B.t8 a_10282_1600# VPWR.t15 sg13_lv_pmos ad=0.1563p pd=1.22u as=0.147p ps=1.54u w=0.42u l=0.13u
X10 VPWR.t227 sg13cmos5l_dfrbpq_1_5.Q a_23576_3898# VPWR.t43 sg13_lv_pmos ad=0.1523p pd=1.38u as=0.1428p ps=1.52u w=0.42u l=0.13u
X11 VPWR.t1 a_10725_8409# a_10827_8552# VPWR.t0 sg13_lv_pmos ad=1.8922p pd=12.27u as=0.3864p ps=2.93u w=1.12u l=0.13u
X12 a_15334_8105# sg13cmos5l_dfrbpq_1_57.RESET_B.t10 VGND.t93 VGND.t92 sg13_lv_nmos ad=37.8f pd=0.6u as=0.1701p ps=1.65u w=0.42u l=0.13u
X13 VPWR.t6 VGND.t20 VPWR.t4 VPWR.t2 sg13_lv_pmos ad=0.19p pd=1.38u as=0 ps=0 w=1u l=1u
X14 sg13cmos5l_buf_8_2.X a_21435_3514# VGND.t54 VGND.t53 sg13_lv_nmos ad=0.1406p pd=1.12u as=0.1406p ps=1.12u w=0.74u l=0.13u
X15 a_6250_3108# sg13cmos5l_buf_8_4.A VPWR.t631 VPWR.t10 sg13_lv_pmos ad=0.2128p pd=1.5u as=0.2128p ps=1.5u w=1.12u l=0.13u
X16 VPWR.t166 VGND.t20 VPWR.t166 VPWR.t0 sg13_lv_pmos ad=0.34p pd=2.68u as=0 ps=0 w=1u l=1u
X17 a_14926_6435# a_15041_6434# VGND.t332 VGND.t95 sg13_lv_nmos ad=0.1428p pd=1.52u as=0.1426p ps=1.16u w=0.42u l=0.5u
X18 VGND.t131 a_7594_5374# sg13cmos5l_buf_8_4.A VGND.t1167 sg13_lv_nmos ad=0.1406p pd=1.12u as=0.1406p ps=1.12u w=0.74u l=0.13u
X19 VPWR.t314 a_27226_2350# a_26945_2572# VPWR.t10 sg13_lv_pmos ad=0.1523p pd=1.38u as=0.34p ps=2.68u w=1u l=0.5u
X20 VPWR.t6 sg13cmos5l_buf_1_0.X.t9 a_23818_7141# VPWR.t2 sg13_lv_pmos ad=0.1563p pd=1.22u as=0.147p ps=1.54u w=0.42u l=0.13u
X21 a_20388_5724# a_20907_5528# a_21647_5483# VGND.t142 sg13_lv_nmos ad=0.3473p pd=2.71u as=0.12665p ps=1.145u w=0.74u l=0.13u
X22 a_28570_4620# sg13cmos5l_dfrbpq_1_7.Q VGND.t1159 VGND.t200 sg13_lv_nmos ad=0.1428p pd=1.52u as=79.8f ps=0.8u w=0.42u l=0.13u
X23 a_26150_6918# sg13cmos5l_dlygate4sd3_1_9.X VPWR.t309 VPWR.t2 sg13_lv_pmos ad=79.8f pd=0.8u as=0.1428p ps=1.52u w=0.42u l=0.13u
X24 VGND.t11 sg13cmos5l_buf_1_1.X.t3 a_26486_2057# VGND.t109 sg13_lv_nmos ad=0.1701p pd=1.65u as=37.8f ps=0.6u w=0.42u l=0.13u
X25 VPWR.t417 sg13cmos5l_buf_1_1.X.t13 a_18278_3582# VPWR.t10 sg13_lv_pmos ad=0.36237p pd=2.605u as=79.8f ps=0.8u w=0.42u l=0.13u
X26 VPWR.t2 a_16485_6897# a_16587_7040# VPWR.t2 sg13_lv_pmos ad=1.34765p pd=8.56u as=0.3864p ps=2.93u w=1.12u l=0.13u
X27 VGND.t126 a_25871_6529# a_26538_6168# VGND.t247 sg13_lv_nmos ad=0.1406p pd=1.12u as=0.2516p ps=2.16u w=0.74u l=0.13u
X28 VPWR.t60 VGND.t572 VPWR.t59 VPWR.t10 sg13_lv_pmos ad=0.34p pd=2.68u as=0 ps=0 w=1u l=1u
X29 a_25066_1093# a_25509_849# a_25449_1261# VPWR.t15 sg13_lv_pmos ad=79.8f pd=0.8u as=63f ps=0.72u w=0.42u l=0.13u
X30 sg13cmos5l_dlygate4sd3_1_38.A a_9258_7680# VPWR.t347 VPWR.t2 sg13_lv_pmos ad=0.3808p pd=2.92u as=0.2128p ps=1.5u w=1.12u l=0.13u
X31 a_9446_4656# a_9176_4697# VGND.t131 VGND.t1221 sg13_lv_nmos ad=0.1428p pd=1.52u as=79.8f ps=0.8u w=0.42u l=0.5u
X32 a_16167_4743# a_16319_4627# VGND.t30 VGND.t1174 sg13_lv_nmos ad=0.2516p pd=2.16u as=3.5351p ps=22.08u w=0.74u l=0.13u
X33 VGND.t50 sg13cmos5l_dfrbpq_1_54.Q a_16184_3185# VGND.t1240 sg13_lv_nmos ad=79.8f pd=0.8u as=0.1428p ps=1.52u w=0.42u l=0.13u
X34 VGND.t45 sg13cmos5l_buf_8_11.A a_27963_6538# VGND.t998 sg13_lv_nmos ad=0.1406p pd=1.12u as=0.2553p ps=2.17u w=0.74u l=0.13u
X35 VGND.t172 sg13cmos5l_nor3_1_1.A sg13cmos5l_nor3_1_1.Y VGND.t187 sg13_lv_nmos ad=0.2618p pd=2.22u as=0.1694p ps=1.21u w=0.77u l=0.13u
X36 a_23660_1168# sg13cmos5l_nor4_2_0.B a_23872_1168# VPWR.t15 sg13_lv_pmos ad=0.2128p pd=1.5u as=0.3808p ps=2.92u w=1.12u l=0.13u
X37 VPWR.t157 a_11567_947# a_12234_1168# VPWR.t15 sg13_lv_pmos ad=0.2128p pd=1.5u as=0.3864p ps=2.93u w=1.12u l=0.13u
X38 a_19142_870# a_19947_992# a_19402_1093# VPWR.t15 sg13_lv_pmos ad=0.1428p pd=1.52u as=79.8f ps=0.8u w=0.42u l=0.13u
X39 a_7232_1919# a_7351_1596# VPWR.t440 VPWR.t15 sg13_lv_pmos ad=0.3864p pd=2.93u as=0.2128p ps=1.5u w=1.12u l=0.13u
X40 a_14542_4923# a_14657_4922# VGND.t179 VGND.t900 sg13_lv_nmos ad=0.1428p pd=1.52u as=0.1426p ps=1.16u w=0.42u l=0.5u
X41 sg13cmos5l_dlygate4sd3_1_21.X a_1302_1656# VGND.t15 VGND.t14 sg13_lv_nmos ad=0.2516p pd=2.16u as=0.1426p ps=1.16u w=0.74u l=0.13u
X42 VGND.t40 a_11567_8507# a_12234_8728# VGND.t701 sg13_lv_nmos ad=0.1406p pd=1.12u as=0.2516p ps=2.16u w=0.74u l=0.13u
X43 VPWR.t79 sg13cmos5l_dlygate4sd3_1_10.A a_23576_3185# VPWR.t10 sg13_lv_pmos ad=0.1523p pd=1.38u as=0.1428p ps=1.52u w=0.42u l=0.13u
X44 VGND.t851 a_23846_3144# a_23958_3168# VGND.t53 sg13_lv_nmos ad=0.1426p pd=1.16u as=0.1428p ps=1.52u w=0.42u l=0.5u
X45 VPWR.t79 sg13cmos5l_and2_1_0.X a_21435_3514# VPWR.t10 sg13_lv_pmos ad=0.2128p pd=1.5u as=0.2128p ps=1.5u w=1.12u l=0.13u
X46 a_21647_3971# a_20805_3873# a_21553_3971# VGND.t202 sg13_lv_nmos ad=0.12665p pd=1.145u as=0.1428p ps=1.52u w=0.42u l=0.13u
X47 VGND.t40 a_11733_7727# a_10812_8041# VGND.t461 sg13_lv_nmos ad=0.1626p pd=1.415u as=0.2516p ps=2.16u w=0.74u l=0.13u
X48 VPWR.t1345 a_2016_5721# sg13cmos5l_xnor2_1_8.Y VPWR.t7 sg13_lv_pmos ad=0.3808p pd=2.92u as=0.2408p ps=1.55u w=1.12u l=0.13u
X49 sg13cmos5l_dfrbpq_1_53.Q a_27690_4656# VPWR.t536 VPWR.t43 sg13_lv_pmos ad=0.3808p pd=2.92u as=0.2128p ps=1.5u w=1.12u l=0.13u
X50 sg13cmos5l_xnor2_1_3.A a_28506_2578# VGND.t11 VGND.t867 sg13_lv_nmos ad=0.1628p pd=1.18u as=0.3108p ps=2.32u w=0.74u l=0.13u
X51 VPWR.t2 a_26853_6897# a_26955_7040# VPWR.t2 sg13_lv_pmos ad=1.34765p pd=8.56u as=0.3864p ps=2.93u w=1.12u l=0.13u
X52 VPWR.t1241 a_18843_5410# sg13cmos5l_and2_1_1.A VPWR.t7 sg13_lv_pmos ad=0.2128p pd=1.5u as=0.2128p ps=1.5u w=1.12u l=0.13u
X53 sg13cmos5l_xnor2_1_10.Y a_24780_5596# VPWR.t221 VPWR.t7 sg13_lv_pmos ad=0.2408p pd=1.55u as=0.3808p ps=2.92u w=1.12u l=0.13u
X54 a_7696_6410# sg13cmos5l_dfrbpq_1_58.RESET_B VPWR.t7 VPWR.t7 sg13_lv_pmos ad=79.8f pd=0.8u as=1.42587p ps=9.11u w=0.42u l=0.13u
X55 a_20150_2057# a_18972_1993# a_19754_1912# VGND.t104 sg13_lv_nmos ad=37.8f pd=0.6u as=0.1428p ps=1.52u w=0.42u l=0.13u
X56 a_7893_4052# sg13cmos5l_dfrbpq_1_21.RESET_B.t5 VPWR.t410 VPWR.t43 sg13_lv_pmos ad=0.147p pd=1.54u as=0.1563p ps=1.22u w=0.42u l=0.13u
X57 a_10702_6606# a_10444_6606# VGND.t558 VGND.t557 sg13_lv_nmos ad=0.1428p pd=1.52u as=79.8f ps=0.8u w=0.42u l=0.13u
X58 a_23660_1168# sg13cmos5l_dfrbpq_1_3.D VPWR.t184 VPWR.t15 sg13_lv_pmos ad=0.2128p pd=1.5u as=0.3864p ps=2.93u w=1.12u l=0.13u
X59 VPWR.t105 sg13cmos5l_dfrbpq_1_13.RESET_B.t12 a_4972_2070# VPWR.t15 sg13_lv_pmos ad=1.46697p pd=9.345u as=79.8f ps=0.8u w=0.42u l=0.13u
X60 a_6951_4112# a_7103_4164# VPWR.t43 VPWR.t43 sg13_lv_pmos ad=0.3864p pd=2.93u as=1.3927p ps=8.9u w=1.12u l=0.13u
X61 VGND.t121 VPWR.t1474 VGND.t121 VGND.t1467 sg13_lv_nmos ad=79.8f pd=0.8u as=0 ps=0 w=0.42u l=1u
X62 a_10308_7236# a_10282_7141# VPWR.t599 VPWR.t2 sg13_lv_pmos ad=0.34p pd=2.68u as=0.36237p ps=2.605u w=1u l=0.13u
X63 a_21719_7309# a_21023_7188# a_21813_7076# VGND.t64 sg13_lv_nmos ad=0.1296p pd=1.52u as=79.8f ps=0.8u w=0.42u l=0.13u
X64 VGND.t278 VPWR.t1466 VGND.t278 VGND.t1474 sg13_lv_nmos ad=0.1428p pd=1.52u as=0 ps=0 w=0.42u l=1u
X65 VPWR.t693 a_14630_3898# a_14742_3962# VPWR.t43 sg13_lv_pmos ad=0.2254p pd=1.53u as=0.34p ps=2.68u w=1u l=0.5u
X66 sg13cmos5l_dfrbpq_1_13.CLK a_6250_2350# VGND.t115 VGND.t1386 sg13_lv_nmos ad=0.1406p pd=1.12u as=0.1406p ps=1.12u w=0.74u l=0.13u
X67 a_20311_6882# a_20871_7136# a_20892_6882# VGND.t333 sg13_lv_nmos ad=0.12665p pd=1.145u as=0.3473p ps=2.71u w=0.74u l=0.13u
X68 VGND.t286 sg13cmos5l_dfrbpq_1_46.D sg13cmos5l_nand3_1_2.A VGND.t287 sg13_lv_nmos ad=0.1406p pd=1.12u as=0.1406p ps=1.12u w=0.74u l=0.13u
X69 a_7792_7138# sg13cmos5l_dfrbpq_1_58.RESET_B VPWR.t2 VPWR.t2 sg13_lv_pmos ad=79.8f pd=0.8u as=1.34765p ps=8.56u w=0.42u l=0.13u
X70 VPWR.t276 a_27023_5483# a_27690_5704# VPWR.t7 sg13_lv_pmos ad=0.2128p pd=1.5u as=0.3864p ps=2.93u w=1.12u l=0.13u
X71 VPWR.t371 a_4640_1919# sg13cmos5l_dfrbpq_1_13.Q VPWR.t15 sg13_lv_pmos ad=0.2128p pd=1.5u as=0.3808p ps=2.92u w=1.12u l=0.13u
X72 a_7535_6995# a_6693_6897# a_7441_6995# VGND.t911 sg13_lv_nmos ad=0.12665p pd=1.145u as=0.1428p ps=1.52u w=0.42u l=0.13u
X73 a_13676_6168# sg13cmos5l_dlygate4sd3_1_28.X a_13888_6168# VPWR.t7 sg13_lv_pmos ad=0.2128p pd=1.5u as=0.3808p ps=2.92u w=1.12u l=0.13u
X74 VGND.t71 a_19631_2459# a_20298_2680# VGND.t8 sg13_lv_nmos ad=0.1406p pd=1.12u as=0.2516p ps=2.16u w=0.74u l=0.13u
X75 a_6551_5797# sg13cmos5l_dfrbpq_1_58.RESET_B VPWR.t845 VPWR.t7 sg13_lv_pmos ad=79.8f pd=0.8u as=0.36237p ps=2.605u w=0.42u l=0.13u
X76 a_4380_834# a_4511_1140# a_3799_834# VPWR.t15 sg13_lv_pmos ad=0.34p pd=2.68u as=0.2048p ps=1.63u w=1u l=0.13u
X77 VGND.t842 a_18010_8398# a_17729_8620# VGND.t0 sg13_lv_nmos ad=79.8f pd=0.8u as=0.1428p ps=1.52u w=0.42u l=0.5u
X78 a_18862_1755# a_18604_2070# VPWR.t105 VPWR.t15 sg13_lv_pmos ad=93.45f pd=0.865u as=1.50275p ps=9.57u w=0.42u l=0.13u
X79 VGND.t1510 VPWR.t1456 VGND.t1510 VGND.t1509 sg13_lv_nmos ad=0.1428p pd=1.52u as=0 ps=0 w=0.42u l=1u
X80 VGND.t3 a_16367_8041# a_17034_7680# VGND.t443 sg13_lv_nmos ad=0.1406p pd=1.12u as=0.2516p ps=2.16u w=0.74u l=0.13u
X81 a_23712_6207# sg13cmos5l_dlygate4sd3_1_6.X VPWR.t8 VPWR.t7 sg13_lv_pmos ad=0.1596p pd=1.22u as=0.4536p ps=2.76u w=0.84u l=0.13u
X82 a_6862_870# a_6604_870# VGND.t38 VGND.t37 sg13_lv_nmos ad=0.1428p pd=1.52u as=79.8f ps=0.8u w=0.42u l=0.13u
X83 VGND.t115 a_6250_2350# sg13cmos5l_dfrbpq_1_13.CLK VGND.t1383 sg13_lv_nmos ad=0.1406p pd=1.12u as=0.1406p ps=1.12u w=0.74u l=0.13u
X84 VGND.t15 VPWR.t1453 VGND.t15 VGND.t1519 sg13_lv_nmos ad=0.1428p pd=1.52u as=0 ps=0 w=0.42u l=1u
X85 VPWR.t592 sg13cmos5l_dfrbpq_1_53.RESET_B.t10 a_25478_8430# VPWR.t0 sg13_lv_pmos ad=0.36237p pd=2.605u as=79.8f ps=0.8u w=0.42u l=0.13u
X86 sg13cmos5l_xnor2_1_3.B sg13cmos5l_dfrbpq_1_2.D a_18387_4656# VPWR.t43 sg13_lv_pmos ad=0.2408p pd=1.55u as=0.1428p ps=1.375u w=1.12u l=0.13u
X87 a_15930_1168# sg13cmos5l_xnor2_1_6.Y sg13cmos5l_xnor2_1_0.Y VPWR.t15 sg13_lv_pmos ad=0.1428p pd=1.375u as=0.2408p ps=1.55u w=1.12u l=0.13u
X88 VGND.t201 a_28174_5595# sg13cmos5l_dfrbpq_1_37.D VGND.t200 sg13_lv_nmos ad=0.1426p pd=1.16u as=0.2516p ps=2.16u w=0.74u l=0.13u
X89 a_18391_1596# a_18951_1719# a_18972_1993# VGND.t879 sg13_lv_nmos ad=0.12665p pd=1.145u as=0.3473p ps=2.71u w=0.74u l=0.13u
X90 a_24134_2382# a_24939_2504# a_24394_2605# VPWR.t10 sg13_lv_pmos ad=0.1428p pd=1.52u as=79.8f ps=0.8u w=0.42u l=0.13u
X91 a_24874_3112# a_25317_3155# a_25257_3191# VPWR.t10 sg13_lv_pmos ad=79.8f pd=0.8u as=63f ps=0.72u w=0.42u l=0.13u
X92 a_18213_3873# sg13cmos5l_dfrbpq_1_2.CLK VGND.t50 VGND.t1342 sg13_lv_nmos ad=0.2516p pd=2.16u as=3.63467p ps=22.73u w=0.74u l=0.13u
X93 VGND.t478 sg13cmos5l_dfrbpq_1_55.RESET_B a_10538_2382# VGND.t578 sg13_lv_nmos ad=79.8f pd=0.8u as=37.8f ps=0.6u w=0.42u l=0.13u
X94 a_16138_5629# a_16581_5385# a_16521_5797# VPWR.t7 sg13_lv_pmos ad=79.8f pd=0.8u as=63f ps=0.72u w=0.42u l=0.13u
X95 a_6154_6136# a_6597_6179# a_5894_6606# VGND.t1284 sg13_lv_nmos ad=79.8f pd=0.8u as=0.1296p ps=1.52u w=0.42u l=0.13u
X96 VGND.t467 a_17036_1596# sg13cmos5l_dfrbpq_1_13.RESET_B VGND.t878 sg13_lv_nmos ad=0.14875p pd=1.16u as=0.2886p ps=2.26u w=0.74u l=0.13u
X97 VGND.t150 VPWR.t17 VGND.t150 VGND.t1522 sg13_lv_nmos ad=79.8f pd=0.8u as=0 ps=0 w=0.42u l=1u
X98 a_6272_4069# a_6391_3858# VGND.t50 VGND.t193 sg13_lv_nmos ad=0.2516p pd=2.16u as=0.1406p ps=1.12u w=0.74u l=0.13u
X99 a_3590_8430# sg13cmos5l_dlygate4sd3_1_31.X VPWR.t511 VPWR.t0 sg13_lv_pmos ad=79.8f pd=0.8u as=0.1428p ps=1.52u w=0.42u l=0.13u
X100 VPWR.t1 a_21647_8507# a_21904_8650# VPWR.t0 sg13_lv_pmos ad=1.8922p pd=12.27u as=79.8f ps=0.8u w=0.42u l=0.13u
X101 VPWR.t721 sg13cmos5l_dlygate4sd3_1_53.A a_8312_4697# VPWR.t43 sg13_lv_pmos ad=0.1523p pd=1.38u as=0.1428p ps=1.52u w=0.42u l=0.13u
X102 a_10112_4943# a_10231_4620# VPWR.t1048 VPWR.t43 sg13_lv_pmos ad=0.3864p pd=2.93u as=0.2128p ps=1.5u w=1.12u l=0.13u
X103 VPWR.t43 sg13cmos5l_dfrbpq_1_21.CLK a_5663_4627# VPWR.t43 sg13_lv_pmos ad=1.36105p pd=8.695u as=0.4088p ps=2.97u w=1.12u l=0.13u
X104 VPWR.t667 a_5301_2540# a_4380_2346# VPWR.t10 sg13_lv_pmos ad=0.36237p pd=2.605u as=0.34p ps=2.68u w=1u l=0.13u
X105 a_7620_8105# a_7851_7691# a_7306_7648# VGND.t432 sg13_lv_nmos ad=0.2373p pd=1.97u as=79.8f ps=0.8u w=0.42u l=0.13u
X106 a_25305_7233# a_24363_7040# a_25103_6995# VPWR.t2 sg13_lv_pmos ad=93.45f pd=0.865u as=0.2048p ps=1.63u w=0.42u l=0.13u
X107 a_10112_7967# a_10231_7644# VGND.t90 VGND.t390 sg13_lv_nmos ad=0.2516p pd=2.16u as=0.1406p ps=1.12u w=0.74u l=0.13u
X108 a_23755_2428# sg13cmos5l_and2_1_1.A a_23661_2428# VGND.t989 sg13_lv_nmos ad=0.1216p pd=1.02u as=0.2176p ps=1.96u w=0.64u l=0.13u
X109 VGND.t30 VPWR.t1462 VGND.t30 VGND.t30 sg13_lv_nmos ad=0.1428p pd=1.52u as=0 ps=0 w=0.42u l=1u
X110 VPWR.t612 sg13cmos5l_buf_1_4.X.t10 a_20362_4624# VPWR.t43 sg13_lv_pmos ad=0.1563p pd=1.22u as=0.147p ps=1.54u w=0.42u l=0.13u
X111 a_28532_2680# sg13cmos5l_dfrbpq_1_0.D VPWR.t313 VPWR.t10 sg13_lv_pmos ad=0.3808p pd=2.92u as=0.2128p ps=1.5u w=1.12u l=0.13u
X112 a_8975_2459# a_8133_2361# a_8881_2459# VGND.t1438 sg13_lv_nmos ad=0.12665p pd=1.145u as=0.1428p ps=1.52u w=0.42u l=0.13u
X113 a_21849_4209# a_20907_4016# a_21647_3971# VPWR.t43 sg13_lv_pmos ad=93.45f pd=0.865u as=0.2048p ps=1.63u w=0.42u l=0.13u
X114 VPWR.t1237 a_18843_5410# sg13cmos5l_and2_1_1.A VPWR.t7 sg13_lv_pmos ad=0.2128p pd=1.5u as=0.2128p ps=1.5u w=1.12u l=0.13u
X115 a_26128_6410# sg13cmos5l_buf_1_0.X.t4 VPWR.t7 VPWR.t7 sg13_lv_pmos ad=79.8f pd=0.8u as=1.42587p ps=9.11u w=0.42u l=0.13u
X116 a_2054_874# a_1784_874# VPWR.t94 VPWR.t15 sg13_lv_pmos ad=0.34p pd=2.68u as=0.1523p ps=1.38u w=1u l=0.5u
X117 a_5403_1261# a_4511_1140# a_5301_1028# VPWR.t15 sg13_lv_pmos ad=63f pd=0.72u as=79.8f ps=0.8u w=0.42u l=0.13u
X118 sg13cmos5l_xnor2_1_5.A sg13cmos5l_xor2_1_2.B a_14010_3910# VGND.t676 sg13_lv_nmos ad=0.1628p pd=1.18u as=88.8f ps=0.98u w=0.74u l=0.13u
X119 a_17680_5626# a_17423_5483# a_17842_5406# VGND.t723 sg13_lv_nmos ad=0.1428p pd=1.52u as=37.8f ps=0.6u w=0.42u l=0.13u
X120 VPWR.t105 sg13cmos5l_dfrbpq_1_13.CLK a_4511_1140# VPWR.t15 sg13_lv_pmos ad=1.46697p pd=9.345u as=0.4088p ps=2.97u w=1.12u l=0.13u
X121 a_14630_3898# a_14360_3898# VGND.t316 VGND.t315 sg13_lv_nmos ad=0.1428p pd=1.52u as=79.8f ps=0.8u w=0.42u l=0.5u
X122 VPWR.t1107 sg13cmos5l_dlygate4sd3_1_11.A a_28376_3898# VPWR.t43 sg13_lv_pmos ad=0.1523p pd=1.38u as=0.1428p ps=1.52u w=0.42u l=0.13u
X123 a_15687_8648# a_15839_8700# VGND.t0 VGND.t369 sg13_lv_nmos ad=0.2516p pd=2.16u as=3.41162p ps=21.215u w=0.74u l=0.13u
X124 a_10812_6529# a_10943_6139# a_10231_6132# VPWR.t7 sg13_lv_pmos ad=0.34p pd=2.68u as=0.2048p ps=1.63u w=1u l=0.13u
X125 a_28646_874# a_28376_874# VPWR.t562 VPWR.t15 sg13_lv_pmos ad=0.34p pd=2.68u as=0.1523p ps=1.38u w=1u l=0.5u
X126 a_25317_3155# sg13cmos5l_dfrbpq_1_0.CLK VGND.t50 VGND.t1627 sg13_lv_nmos ad=0.2516p pd=2.16u as=3.63467p ps=22.73u w=0.74u l=0.13u
X127 VGND.t50 a_18981_3155# a_19083_3155# VGND.t1640 sg13_lv_nmos ad=3.8943p pd=24.355u as=0.2516p ps=2.16u w=0.74u l=0.13u
X128 a_24201_7309# a_23844_7236# VPWR.t6 VPWR.t2 sg13_lv_pmos ad=63f pd=0.72u as=0.1563p ps=1.22u w=0.42u l=0.13u
X129 sg13cmos5l_xnor2_1_6.Y a_1152_1185# a_1301_874# VGND.t594 sg13_lv_nmos ad=0.2516p pd=2.16u as=0.1406p ps=1.12u w=0.74u l=0.13u
X130 sg13cmos5l_dlygate4sd3_1_17.A a_27690_8728# VGND.t273 VGND.t72 sg13_lv_nmos ad=0.2516p pd=2.16u as=0.1406p ps=1.12u w=0.74u l=0.13u
X131 VGND.t179 sg13cmos5l_buf_8_0.X a_13642_5374# VGND.t180 sg13_lv_nmos ad=0.1406p pd=1.12u as=0.1406p ps=1.12u w=0.74u l=0.13u
X132 a_18843_5410# sg13cmos5l_buf_8_0.X VPWR.t209 VPWR.t7 sg13_lv_pmos ad=0.2128p pd=1.5u as=0.2128p ps=1.5u w=1.12u l=0.13u
X133 a_1248_4695# sg13cmos5l_xnor2_1_12.B a_1211_5004# VGND.t30 sg13_lv_nmos ad=0.2176p pd=1.96u as=78.39999f ps=0.885u w=0.64u l=0.13u
X134 a_26351_947# a_25509_849# a_26257_947# VGND.t330 sg13_lv_nmos ad=0.12665p pd=1.145u as=0.1428p ps=1.52u w=0.42u l=0.13u
X135 sg13cmos5l_buf_8_4.A a_7594_5374# VPWR.t1035 VPWR.t7 sg13_lv_pmos ad=0.2128p pd=1.5u as=0.2128p ps=1.5u w=1.12u l=0.13u
X136 a_11786_4192# sg13cmos5l_dfrbpq_1_22.D a_11488_4192# VPWR.t43 sg13_lv_pmos ad=0.2128p pd=1.5u as=0.2128p ps=1.5u w=1.12u l=0.13u
X137 VGND.t156 sg13cmos5l_xnor2_1_2.Y a_17135_2386# VGND.t147 sg13_lv_nmos ad=0.1898p pd=1.36u as=0.1406p ps=1.12u w=0.74u l=0.13u
X138 a_16535_8821# a_15839_8700# a_16629_8588# VGND.t0 sg13_lv_nmos ad=0.1296p pd=1.52u as=79.8f ps=0.8u w=0.42u l=0.13u
X139 VGND.t96 VPWR.t1469 VGND.t96 VGND.t95 sg13_lv_nmos ad=0.1428p pd=1.52u as=0 ps=0 w=0.42u l=1u
X140 a_3817_5452# sg13cmos5l_dfrbpq_1_13.RESET_B.t15 VGND.t52 VGND.t194 sg13_lv_nmos ad=0.1216p pd=1.02u as=0.1331p ps=1.12u w=0.64u l=0.13u
X141 a_8591_8041# a_7749_7691# a_8497_8041# VGND.t354 sg13_lv_nmos ad=0.12665p pd=1.145u as=0.1428p ps=1.52u w=0.42u l=0.13u
X142 VPWR.t333 a_14926_6435# sg13cmos5l_xor2_1_2.B VPWR.t7 sg13_lv_pmos ad=0.2254p pd=1.53u as=0.4256p ps=3u w=1.12u l=0.13u
X143 VPWR.t469 sg13cmos5l_buf_8_3.A a_13563_874# VPWR.t15 sg13_lv_pmos ad=0.2128p pd=1.5u as=0.2128p ps=1.5u w=1.12u l=0.13u
X144 a_8975_2459# a_8133_2361# a_7716_2700# VPWR.t10 sg13_lv_pmos ad=0.2048p pd=1.63u as=0.34p ps=2.68u w=1u l=0.13u
X145 VGND.t312 a_5135_8507# a_5802_8728# VGND.t311 sg13_lv_nmos ad=0.1406p pd=1.12u as=0.2516p ps=2.16u w=0.74u l=0.13u
X146 a_21813_7076# a_20871_7136# a_21719_7309# VPWR.t2 sg13_lv_pmos ad=79.8f pd=0.8u as=0.1428p ps=1.52u w=0.42u l=0.13u
X147 a_15850_3862# osc VPWR.t1289 VPWR.t43 sg13_lv_pmos ad=0.3808p pd=2.92u as=0.2128p ps=1.5u w=1.12u l=0.13u
X148 VGND.t77 sg13cmos5l_dfrbpq_1_2.CLK a_19103_1603# VGND.t399 sg13_lv_nmos ad=3.06955p pd=19.355u as=0.2516p ps=2.16u w=0.74u l=0.13u
X149 VGND.t238 sg13cmos5l_xnor2_1_2.B sg13cmos5l_nand3_1_1.A VGND.t1089 sg13_lv_nmos ad=0.1406p pd=1.12u as=0.1406p ps=1.12u w=0.74u l=0.13u
X150 a_15191_1679# sg13cmos5l_dfrbpq_1_55.D a_15938_2070# VGND.t547 sg13_lv_nmos ad=0.1428p pd=1.52u as=60.89999f ps=0.71u w=0.42u l=0.13u
X151 a_7799_4285# sg13cmos5l_dfrbpq_1_23.D a_8546_3894# VGND.t716 sg13_lv_nmos ad=0.1428p pd=1.52u as=60.89999f ps=0.71u w=0.42u l=0.13u
X152 sg13cmos5l_and2_1_3.A a_13642_5374# VGND.t179 VGND.t532 sg13_lv_nmos ad=0.1406p pd=1.12u as=0.1406p ps=1.12u w=0.74u l=0.13u
X153 VPWR.t580 sg13cmos5l_dfrbpq_1_21.Q a_1784_3185# VPWR.t10 sg13_lv_pmos ad=0.1523p pd=1.38u as=0.1428p ps=1.52u w=0.42u l=0.13u
X154 VGND.t861 a_2054_3144# a_2166_3168# VGND.t1220 sg13_lv_nmos ad=0.1426p pd=1.16u as=0.1428p ps=1.52u w=0.42u l=0.5u
X155 a_17132_3108# sg13cmos5l_buf_1_2.A VPWR.t432 VPWR.t10 sg13_lv_pmos ad=0.2856p pd=2.36u as=0.2114p ps=1.54u w=0.84u l=0.13u
X156 a_27023_5483# a_26181_5385# a_26929_5483# VGND.t200 sg13_lv_nmos ad=0.12665p pd=1.145u as=0.1428p ps=1.52u w=0.42u l=0.13u
X157 a_5356_5406# a_5143_5370# VPWR.t7 VPWR.t7 sg13_lv_pmos ad=79.8f pd=0.8u as=1.46065p ps=9.335u w=0.42u l=0.13u
X158 a_14148_3569# a_14379_3155# a_13834_3112# VGND.t694 sg13_lv_nmos ad=0.2373p pd=1.97u as=79.8f ps=0.8u w=0.42u l=0.13u
X159 a_26447_3971# a_25605_3873# a_26353_3971# VGND.t1224 sg13_lv_nmos ad=0.12665p pd=1.145u as=0.1428p ps=1.52u w=0.42u l=0.13u
X160 VGND.t341 a_27280_5626# a_26929_5483# VGND.t200 sg13_lv_nmos ad=79.8f pd=0.8u as=0.1428p ps=1.52u w=0.42u l=0.13u
X161 VPWR.t774 a_7930_4620# a_7649_4922# VPWR.t43 sg13_lv_pmos ad=0.1523p pd=1.38u as=0.34p ps=2.68u w=1u l=0.5u
X162 VPWR.t258 a_14054_8434# a_14166_8498# VPWR.t0 sg13_lv_pmos ad=0.2254p pd=1.53u as=0.34p ps=2.68u w=1u l=0.5u
X163 VPWR.t1000 a_15850_3862# sg13cmos5l_buf_8_0.X VPWR.t43 sg13_lv_pmos ad=0.2128p pd=1.5u as=0.2128p ps=1.5u w=1.12u l=0.13u
X164 VPWR.t841 sg13cmos5l_dfrbpq_1_58.RESET_B a_8768_6427# VPWR.t7 sg13_lv_pmos ad=0.2856p pd=2.36u as=0.1596p ps=1.22u w=0.84u l=0.13u
X165 a_5230_2070# a_4972_2070# VGND.t205 VGND.t389 sg13_lv_nmos ad=0.1428p pd=1.52u as=79.8f ps=0.8u w=0.42u l=0.13u
X166 sg13cmos5l_nand3_1_3.B sg13cmos5l_dfrbpq_1_22.D VGND.t572 VGND.t717 sg13_lv_nmos ad=0.1406p pd=1.12u as=0.1406p ps=1.12u w=0.74u l=0.13u
X167 VGND.t50 a_17702_3144# a_17814_3168# VGND.t657 sg13_lv_nmos ad=0.1426p pd=1.16u as=0.1428p ps=1.52u w=0.42u l=0.5u
X168 VGND.t203 sg13cmos5l_dlygate4sd3_1_51.X sg13cmos5l_nand3_1_2.B VGND.t142 sg13_lv_nmos ad=0.3293p pd=1.63u as=0.1406p ps=1.12u w=0.74u l=0.13u
X169 VPWR.t23 VGND.t15 VPWR.t22 VPWR.t10 sg13_lv_pmos ad=0.34p pd=2.68u as=0 ps=0 w=1u l=1u
X170 VGND.t50 a_4293_3155# a_4395_3155# VGND.t537 sg13_lv_nmos ad=3.8943p pd=24.355u as=0.2516p ps=2.16u w=0.74u l=0.13u
X171 a_13642_5374# sg13cmos5l_buf_8_0.X VPWR.t207 VPWR.t7 sg13_lv_pmos ad=0.3808p pd=2.92u as=0.2128p ps=1.5u w=1.12u l=0.13u
X172 VPWR.t91 sg13cmos5l_dfrbpq_1_11.CLK a_10943_2652# VPWR.t10 sg13_lv_pmos ad=1.4003p pd=8.92u as=0.4088p ps=2.97u w=1.12u l=0.13u
X173 sg13cmos5l_dlygate4sd3_1_18.A a_9642_2680# VPWR.t1263 VPWR.t10 sg13_lv_pmos ad=0.3808p pd=2.92u as=0.2128p ps=1.5u w=1.12u l=0.13u
X174 sg13cmos5l_buf_8_0.X a_15850_3862# VPWR.t996 VPWR.t43 sg13_lv_pmos ad=0.2128p pd=1.5u as=0.2128p ps=1.5u w=1.12u l=0.13u
X175 a_8842_6886# sg13cmos5l_buf_8_10.A VPWR.t969 VPWR.t2 sg13_lv_pmos ad=0.3808p pd=2.92u as=0.2128p ps=1.5u w=1.12u l=0.13u
X176 a_3680_1045# a_3799_834# VGND.t32 VGND.t503 sg13_lv_nmos ad=0.2516p pd=2.16u as=0.1406p ps=1.12u w=0.74u l=0.13u
X177 VPWR.t43 a_27280_4898# a_27225_4779# VPWR.t43 sg13_lv_pmos ad=1.3927p pd=8.9u as=93.45f ps=0.865u w=0.42u l=0.13u
X178 a_11824_1874# sg13cmos5l_dfrbpq_1_13.RESET_B.t7 VPWR.t105 VPWR.t15 sg13_lv_pmos ad=79.8f pd=0.8u as=1.46697p ps=9.345u w=0.42u l=0.13u
X179 a_21904_4114# sg13cmos5l_buf_1_1.X.t14 VPWR.t43 VPWR.t43 sg13_lv_pmos ad=79.8f pd=0.8u as=1.3927p ps=8.9u w=0.42u l=0.13u
X180 a_17914_7644# sg13cmos5l_dfrbpq_1_52.Q VPWR.t765 VPWR.t2 sg13_lv_pmos ad=0.1428p pd=1.52u as=0.1523p ps=1.38u w=0.42u l=0.13u
X181 sg13cmos5l_dfrbpq_1_0.CLK a_27195_3514# VGND.t58 VGND.t262 sg13_lv_nmos ad=0.1406p pd=1.12u as=0.1406p ps=1.12u w=0.74u l=0.13u
X182 VPWR.t206 a_13642_5374# sg13cmos5l_and2_1_3.A VPWR.t7 sg13_lv_pmos ad=0.2128p pd=1.5u as=0.2128p ps=1.5u w=1.12u l=0.13u
X183 VGND.t462 a_16270_2571# sg13cmos5l_dfrbpq_1_22.D VGND.t147 sg13_lv_nmos ad=0.1426p pd=1.16u as=0.2516p ps=2.16u w=0.74u l=0.13u
X184 VGND.t358 sg13cmos5l_dfrbpq_1_21.RESET_B.t12 a_4970_8118# VGND.t437 sg13_lv_nmos ad=79.8f pd=0.8u as=37.8f ps=0.6u w=0.42u l=0.13u
X185 VGND.t131 sg13cmos5l_buf_1_5.A a_8776_5444# VGND.t130 sg13_lv_nmos ad=0.14875p pd=1.16u as=0.187p ps=1.78u w=0.55u l=0.13u
X186 a_20080_3386# a_19823_3505# a_20242_3582# VGND.t1635 sg13_lv_nmos ad=0.1428p pd=1.52u as=37.8f ps=0.6u w=0.42u l=0.13u
X187 VPWR.t960 a_8842_6886# sg13cmos5l_dfrbpq_1_57.CLK VPWR.t2 sg13_lv_pmos ad=0.2128p pd=1.5u as=0.2128p ps=1.5u w=1.12u l=0.13u
X188 a_5135_3971# a_4293_3873# a_3876_4212# VPWR.t43 sg13_lv_pmos ad=0.2048p pd=1.63u as=0.34p ps=2.68u w=1u l=0.13u
X189 VGND.t216 sg13cmos5l_nor4_2_0.D sg13cmos5l_nand3_1_0.B VGND.t846 sg13_lv_nmos ad=0.2516p pd=2.16u as=0.1406p ps=1.12u w=0.74u l=0.13u
X190 VPWR.t7 a_11567_5483# a_11824_5626# VPWR.t7 sg13_lv_pmos ad=1.46065p pd=9.335u as=79.8f ps=0.8u w=0.42u l=0.13u
X191 a_25380_883# a_25092_1188# a_25318_883# VGND.t326 sg13_lv_nmos ad=0.1428p pd=1.52u as=37.8f ps=0.6u w=0.42u l=0.13u
X192 a_15321_3267# a_14379_3155# a_15119_3505# VPWR.t10 sg13_lv_pmos ad=93.45f pd=0.865u as=0.2048p ps=1.63u w=0.42u l=0.13u
X193 VGND.t54 a_21647_3971# a_22314_4192# VGND.t202 sg13_lv_nmos ad=0.1406p pd=1.12u as=0.2516p ps=2.16u w=0.74u l=0.13u
X194 VPWR.t28 VGND.t1525 VPWR.t28 VPWR.t15 sg13_lv_pmos ad=0.19p pd=1.38u as=0 ps=0 w=1u l=1u
X195 a_3799_2346# a_4359_2600# a_4270_2697# VPWR.t10 sg13_lv_pmos ad=0.2048p pd=1.63u as=93.45f ps=0.865u w=0.42u l=0.13u
X196 a_4730_6168# sg13cmos5l_nor4_2_5.D sg13cmos5l_nor4_2_5.Y VPWR.t7 sg13_lv_pmos ad=0.3808p pd=2.92u as=0.2128p ps=1.5u w=1.12u l=0.13u
X197 VGND.t58 sg13cmos5l_buf_8_2.X a_27195_3514# VGND.t782 sg13_lv_nmos ad=0.1406p pd=1.12u as=0.1406p ps=1.12u w=0.74u l=0.13u
X198 a_17132_3108# sg13cmos5l_buf_1_2.A VGND.t50 VGND.t468 sg13_lv_nmos ad=0.187p pd=1.78u as=0.14875p ps=1.16u w=0.55u l=0.13u
X199 a_28698_3144# sg13cmos5l_xnor2_1_4.B sg13cmos5l_xnor2_1_4.Y VPWR.t10 sg13_lv_pmos ad=0.1428p pd=1.375u as=0.2408p ps=1.55u w=1.12u l=0.13u
X200 a_27952_7138# a_27695_6995# a_28114_6918# VGND.t1260 sg13_lv_nmos ad=0.1428p pd=1.52u as=37.8f ps=0.6u w=0.42u l=0.13u
X201 VPWR.t198 a_6272_1045# sg13cmos5l_dlygate4sd3_1_22.A VPWR.t15 sg13_lv_pmos ad=0.2128p pd=1.5u as=0.3808p ps=2.92u w=1.12u l=0.13u
X202 VGND.t0 a_4293_8409# a_4395_8552# VGND.t1036 sg13_lv_nmos ad=3.41162p pd=21.215u as=0.2516p ps=2.16u w=0.74u l=0.13u
X203 VGND.t312 a_6272_8605# sg13cmos5l_dlygate4sd3_1_34.A VGND.t760 sg13_lv_nmos ad=0.1406p pd=1.12u as=0.2516p ps=2.16u w=0.74u l=0.13u
X204 a_6406_6593# sg13cmos5l_dfrbpq_1_58.RESET_B VGND.t25 VGND.t941 sg13_lv_nmos ad=37.8f pd=0.6u as=0.1701p ps=1.65u w=0.42u l=0.13u
X205 a_17015_4703# sg13cmos5l_dfrbpq_1_56.RESET_B VPWR.t758 VPWR.t43 sg13_lv_pmos ad=79.8f pd=0.8u as=0.36237p ps=2.605u w=0.42u l=0.13u
X206 a_1870_6435# a_1985_6434# VGND.t280 VGND.t1269 sg13_lv_nmos ad=0.1428p pd=1.52u as=0.1426p ps=1.16u w=0.42u l=0.5u
X207 VGND.t115 a_6261_1679# a_5340_1993# VGND.t114 sg13_lv_nmos ad=0.1626p pd=1.415u as=0.2516p ps=2.16u w=0.74u l=0.13u
X208 a_7893_8588# a_6951_8648# a_7799_8821# VPWR.t0 sg13_lv_pmos ad=79.8f pd=0.8u as=0.1428p ps=1.52u w=0.42u l=0.13u
X209 a_10116_5406# sg13cmos5l_dlygate4sd3_1_52.X a_10022_5406# VGND.t689 sg13_lv_nmos ad=60.89999f pd=0.71u as=0.1428p ps=1.52u w=0.42u l=0.13u
X210 a_13834_2605# a_14277_2361# a_14217_2773# VPWR.t10 sg13_lv_pmos ad=79.8f pd=0.8u as=63f ps=0.72u w=0.42u l=0.13u
X211 a_26649_4209# a_25707_4016# a_26447_3971# VPWR.t43 sg13_lv_pmos ad=93.45f pd=0.865u as=0.2048p ps=1.63u w=0.42u l=0.13u
X212 a_14010_3910# sg13cmos5l_xor2_1_2.A VGND.t316 VGND.t930 sg13_lv_nmos ad=88.8f pd=0.98u as=0.15245p ps=1.17u w=0.74u l=0.13u
X213 VGND.t1619 sg13cmos5l_dfrbpq_1_13.RESET_B.t3 a_8150_883# VGND.t1618 sg13_lv_nmos ad=0.1701p pd=1.65u as=37.8f ps=0.6u w=0.42u l=0.13u
X214 sg13cmos5l_xnor2_1_4.B a_23712_6207# a_23861_6538# VGND.t64 sg13_lv_nmos ad=0.2516p pd=2.16u as=0.1406p ps=1.12u w=0.74u l=0.13u
X215 VGND.t535 a_9446_4656# a_9558_4680# VGND.t1250 sg13_lv_nmos ad=0.1426p pd=1.16u as=0.1428p ps=1.52u w=0.42u l=0.5u
X216 VPWR.t91 a_8975_2459# a_9232_2602# VPWR.t10 sg13_lv_pmos ad=1.43285p pd=9.125u as=79.8f ps=0.8u w=0.42u l=0.13u
X217 a_7893_4052# a_6951_4112# a_7754_4052# VGND.t1324 sg13_lv_nmos ad=79.8f pd=0.8u as=0.2373p ps=1.97u w=0.42u l=0.13u
X218 VPWR.t3 a_21813_7076# a_20892_6882# VPWR.t2 sg13_lv_pmos ad=0.36237p pd=2.605u as=0.34p ps=2.68u w=1u l=0.13u
X219 a_6453_4703# a_5511_4743# a_6359_4703# VPWR.t43 sg13_lv_pmos ad=79.8f pd=0.8u as=0.1428p ps=1.52u w=0.42u l=0.13u
X220 VPWR.t975 sg13cmos5l_xnor2_1_2.B a_11639_7727# VPWR.t2 sg13_lv_pmos ad=0.1428p pd=1.52u as=79.8f ps=0.8u w=0.42u l=0.13u
X221 VGND.t741 sg13cmos5l_buf_8_4.A a_8763_8434# VGND.t89 sg13_lv_nmos ad=0.1406p pd=1.12u as=0.2553p ps=2.17u w=0.74u l=0.13u
X222 sg13cmos5l_xnor2_1_8.Y sg13cmos5l_xnor2_1_5.Y a_2259_5704# VPWR.t7 sg13_lv_pmos ad=0.2408p pd=1.55u as=0.1428p ps=1.375u w=1.12u l=0.13u
X223 a_9394_2382# sg13cmos5l_dfrbpq_1_13.RESET_B.t13 VGND.t608 VGND.t607 sg13_lv_nmos ad=37.8f pd=0.6u as=79.8f ps=0.8u w=0.42u l=0.13u
X224 VGND.t50 a_9915_3898# sg13cmos5l_buf_8_3.A VGND.t1578 sg13_lv_nmos ad=0.1406p pd=1.12u as=0.1406p ps=1.12u w=0.74u l=0.13u
X225 VGND.t32 a_2054_874# a_2166_938# VGND.t31 sg13_lv_nmos ad=0.1426p pd=1.16u as=0.1428p ps=1.52u w=0.42u l=0.5u
X226 a_6391_3858# a_6951_4112# a_6862_4209# VPWR.t43 sg13_lv_pmos ad=0.2048p pd=1.63u as=93.45f ps=0.865u w=0.42u l=0.13u
X227 VPWR.t1151 a_18874_8398# a_18593_8620# VPWR.t0 sg13_lv_pmos ad=0.1523p pd=1.38u as=0.34p ps=2.68u w=1u l=0.5u
X228 a_13783_1596# a_14343_1719# a_14254_1755# VPWR.t15 sg13_lv_pmos ad=0.2048p pd=1.63u as=93.45f ps=0.865u w=0.42u l=0.13u
X229 VPWR.t17 VGND.t32 VPWR.t16 VPWR.t15 sg13_lv_pmos ad=0.34p pd=2.68u as=0 ps=0 w=1u l=1u
X230 a_6261_1679# a_5319_1719# a_6167_1679# VPWR.t15 sg13_lv_pmos ad=79.8f pd=0.8u as=0.1428p ps=1.52u w=0.42u l=0.13u
X231 a_14054_8434# a_13784_8434# VGND.t40 VGND.t1306 sg13_lv_nmos ad=0.1428p pd=1.52u as=79.8f ps=0.8u w=0.42u l=0.5u
X232 VPWR.t131 sg13cmos5l_dfrbpq_1_21.RESET_B.t16 a_3850_8653# VPWR.t0 sg13_lv_pmos ad=0.1563p pd=1.22u as=0.147p ps=1.54u w=0.42u l=0.13u
X233 VPWR.t8 VGND.t143 VPWR.t8 VPWR.t7 sg13_lv_pmos ad=0.34p pd=2.68u as=0 ps=0 w=1u l=1u
X234 a_2266_2350# sg13cmos5l_dfrbpq_1_13.Q VPWR.t682 VPWR.t10 sg13_lv_pmos ad=0.1428p pd=1.52u as=0.1523p ps=1.38u w=0.42u l=0.13u
X235 VPWR.t349 a_4544_7967# sg13cmos5l_dlygate4sd3_1_33.A VPWR.t2 sg13_lv_pmos ad=0.2128p pd=1.5u as=0.3808p ps=2.92u w=1.12u l=0.13u
X236 a_7558_8105# sg13cmos5l_dfrbpq_1_21.RESET_B.t10 VGND.t856 VGND.t431 sg13_lv_nmos ad=37.8f pd=0.6u as=0.1701p ps=1.65u w=0.42u l=0.13u
X237 VGND.t203 VPWR.t76 VGND.t203 VGND.t142 sg13_lv_nmos ad=79.8f pd=0.8u as=0 ps=0 w=0.42u l=1u
X238 VPWR.t585 a_8582_4656# a_8694_4680# VPWR.t43 sg13_lv_pmos ad=0.2254p pd=1.53u as=0.34p ps=2.68u w=1u l=0.5u
X239 VPWR.t559 sg13cmos5l_dfrbpq_1_13.RESET_B.t14 a_7690_2605# VPWR.t10 sg13_lv_pmos ad=0.1563p pd=1.22u as=0.147p ps=1.54u w=0.42u l=0.13u
X240 a_20311_6882# a_20871_7136# a_20782_7233# VPWR.t2 sg13_lv_pmos ad=0.2048p pd=1.63u as=93.45f ps=0.865u w=0.42u l=0.13u
X241 a_19236_870# sg13cmos5l_dfrbpq_1_2.D a_19142_870# VGND.t542 sg13_lv_nmos ad=60.89999f pd=0.71u as=0.1428p ps=1.52u w=0.42u l=0.13u
X242 a_5301_2540# a_4359_2600# a_5162_2540# VGND.t270 sg13_lv_nmos ad=79.8f pd=0.8u as=0.2373p ps=1.97u w=0.42u l=0.13u
X243 VGND.t38 a_6272_1045# sg13cmos5l_dlygate4sd3_1_22.A VGND.t163 sg13_lv_nmos ad=0.1406p pd=1.12u as=0.2516p ps=2.16u w=0.74u l=0.13u
X244 VPWR.t2 a_25797_7691# a_25899_7691# VPWR.t2 sg13_lv_pmos ad=1.34765p pd=8.56u as=0.3864p ps=2.93u w=1.12u l=0.13u
X245 VGND.t145 sg13cmos5l_buf_1_0.X.t7 a_20196_6606# VGND.t421 sg13_lv_nmos ad=0.1626p pd=1.415u as=60.89999f ps=0.71u w=0.42u l=0.13u
X246 VGND.t393 VPWR.t1451 VGND.t393 VGND.t1523 sg13_lv_nmos ad=0.1428p pd=1.52u as=0 ps=0 w=0.42u l=1u
X247 VGND.t117 a_2054_8434# a_2166_8498# VGND.t977 sg13_lv_nmos ad=0.1426p pd=1.16u as=0.1428p ps=1.52u w=0.42u l=0.5u
X248 a_19995_1679# a_19103_1603# a_19893_1679# VPWR.t15 sg13_lv_pmos ad=63f pd=0.72u as=79.8f ps=0.8u w=0.42u l=0.13u
X249 a_20546_2070# sg13cmos5l_buf_1_1.X.t5 VGND.t71 VGND.t103 sg13_lv_nmos ad=60.89999f pd=0.71u as=0.1626p ps=1.415u w=0.42u l=0.13u
X250 VGND.t54 sg13cmos5l_dlygate4sd3_1_10.A a_23576_3185# VGND.t53 sg13_lv_nmos ad=79.8f pd=0.8u as=0.1428p ps=1.52u w=0.42u l=0.13u
X251 sg13cmos5l_dlygate4sd3_1_38.A a_9258_7680# VGND.t357 VGND.t356 sg13_lv_nmos ad=0.2516p pd=2.16u as=0.1406p ps=1.12u w=0.74u l=0.13u
X252 a_10538_6606# a_10231_6132# a_10444_6606# VGND.t557 sg13_lv_nmos ad=37.8f pd=0.6u as=0.1428p ps=1.52u w=0.42u l=0.13u
X253 a_17109_4703# a_16167_4743# a_17015_4703# VPWR.t43 sg13_lv_pmos ad=79.8f pd=0.8u as=0.1428p ps=1.52u w=0.42u l=0.13u
X254 VGND.t83 a_11567_5483# a_12234_5704# VGND.t711 sg13_lv_nmos ad=0.1406p pd=1.12u as=0.2516p ps=2.16u w=0.74u l=0.13u
X255 a_7232_1919# a_7351_1596# VGND.t115 VGND.t816 sg13_lv_nmos ad=0.2516p pd=2.16u as=0.1406p ps=1.12u w=0.74u l=0.13u
X256 sg13cmos5l_dfrbpq_1_53.CLK a_27963_6538# VPWR.t1317 VPWR.t7 sg13_lv_pmos ad=0.2128p pd=1.5u as=0.2128p ps=1.5u w=1.12u l=0.13u
X257 a_8763_8434# sg13cmos5l_buf_8_4.A VPWR.t1347 VPWR.t0 sg13_lv_pmos ad=0.2128p pd=1.5u as=0.2128p ps=1.5u w=1.12u l=0.13u
X258 VPWR.t89 a_16629_8588# a_15708_8394# VPWR.t0 sg13_lv_pmos ad=0.36237p pd=2.605u as=0.34p ps=2.68u w=1u l=0.13u
X259 a_17488_6410# a_17231_6529# a_17650_6606# VGND.t1154 sg13_lv_nmos ad=0.1428p pd=1.52u as=37.8f ps=0.6u w=0.42u l=0.13u
X260 a_16454_3144# a_16184_3185# VPWR.t1096 VPWR.t10 sg13_lv_pmos ad=0.34p pd=2.68u as=0.1523p ps=1.38u w=1u l=0.5u
X261 VGND.t50 a_6250_3108# sg13cmos5l_dfrbpq_1_21.CLK VGND.t674 sg13_lv_nmos ad=0.1406p pd=1.12u as=0.1406p ps=1.12u w=0.74u l=0.13u
X262 a_25764_8748# a_25738_8653# VPWR.t592 VPWR.t0 sg13_lv_pmos ad=0.34p pd=2.68u as=0.36237p ps=2.605u w=1u l=0.13u
X263 a_6951_1088# a_7103_1140# VPWR.t105 VPWR.t15 sg13_lv_pmos ad=0.3864p pd=2.93u as=1.50275p ps=9.57u w=1.12u l=0.13u
X264 a_24170_1168# sg13cmos5l_nor4_2_0.D sg13cmos5l_nand3_1_0.B VPWR.t15 sg13_lv_pmos ad=0.3808p pd=2.92u as=0.2128p ps=1.5u w=1.12u l=0.13u
X265 a_6914_2070# sg13cmos5l_dfrbpq_1_13.RESET_B.t11 VGND.t115 VGND.t609 sg13_lv_nmos ad=60.89999f pd=0.71u as=0.1626p ps=1.415u w=0.42u l=0.13u
X266 a_27280_5626# sg13cmos5l_dfrbpq_1_53.RESET_B.t3 VPWR.t7 VPWR.t7 sg13_lv_pmos ad=79.8f pd=0.8u as=1.46065p ps=9.335u w=0.42u l=0.13u
X267 a_21934_2571# a_22049_2572# VPWR.t79 VPWR.t10 sg13_lv_pmos ad=0.34p pd=2.68u as=0.2254p ps=1.53u w=1u l=0.5u
X268 a_20362_4624# a_20805_4667# a_20102_5094# VGND.t1545 sg13_lv_nmos ad=79.8f pd=0.8u as=0.1296p ps=1.52u w=0.42u l=0.13u
X269 VGND.t50 sg13cmos5l_dfrbpq_1_21.RESET_B.t6 a_6698_3894# VGND.t193 sg13_lv_nmos ad=79.8f pd=0.8u as=37.8f ps=0.6u w=0.42u l=0.13u
X270 a_20871_7767# a_21023_7651# VGND.t0 VGND.t1041 sg13_lv_nmos ad=0.2516p pd=2.16u as=3.41162p ps=21.215u w=0.74u l=0.13u
X271 VPWR.t1315 a_27963_6538# sg13cmos5l_dfrbpq_1_53.CLK VPWR.t7 sg13_lv_pmos ad=0.2128p pd=1.5u as=0.2128p ps=1.5u w=1.12u l=0.13u
X272 VPWR.t609 a_6453_4703# a_5532_5017# VPWR.t43 sg13_lv_pmos ad=0.36237p pd=2.605u as=0.34p ps=2.68u w=1u l=0.13u
X273 VGND.t350 a_15488_4943# sg13cmos5l_dfrbpq_1_56.Q VGND.t613 sg13_lv_nmos ad=0.1406p pd=1.12u as=0.2516p ps=2.16u w=0.74u l=0.13u
X274 sg13cmos5l_dfrbpq_1_13.CLK a_6250_2350# VPWR.t1231 VPWR.t10 sg13_lv_pmos ad=0.2128p pd=1.5u as=0.2128p ps=1.5u w=1.12u l=0.13u
X275 a_1137_3144# sg13cmos5l_dfrbpq_1_12.D VPWR.t1087 VPWR.t10 sg13_lv_pmos ad=0.1225p pd=1.245u as=0.36p ps=2.72u w=1u l=0.13u
X276 a_23872_5704# sg13cmos5l_nor4_2_7.B a_23660_5704# VPWR.t7 sg13_lv_pmos ad=0.2128p pd=1.5u as=0.2128p ps=1.5u w=1.12u l=0.13u
X277 a_27442_5094# sg13cmos5l_dfrbpq_1_53.RESET_B.t1 VGND.t341 VGND.t200 sg13_lv_nmos ad=37.8f pd=0.6u as=79.8f ps=0.8u w=0.42u l=0.13u
X278 VGND.t861 VPWR.t1458 VGND.t861 VGND.t1506 sg13_lv_nmos ad=79.8f pd=0.8u as=0 ps=0 w=0.42u l=1u
X279 VGND.t418 a_7535_6995# a_8202_7216# VGND.t1108 sg13_lv_nmos ad=0.1406p pd=1.12u as=0.2516p ps=2.16u w=0.74u l=0.13u
X280 sg13cmos5l_buf_8_10.A a_14235_6922# VGND.t332 VGND.t95 sg13_lv_nmos ad=0.1406p pd=1.12u as=0.1406p ps=1.12u w=0.74u l=0.13u
X281 VPWR.t8 a_21647_5483# a_22314_5704# VPWR.t7 sg13_lv_pmos ad=0.2128p pd=1.5u as=0.3864p ps=2.93u w=1.12u l=0.13u
X282 VGND.t3 a_16629_8588# a_15708_8394# VGND.t0 sg13_lv_nmos ad=0.1626p pd=1.415u as=0.2516p ps=2.16u w=0.74u l=0.13u
X283 a_5207_2773# sg13cmos5l_dfrbpq_1_21.RESET_B.t1 VPWR.t667 VPWR.t10 sg13_lv_pmos ad=79.8f pd=0.8u as=0.36237p ps=2.605u w=0.42u l=0.13u
X284 sg13cmos5l_dfrbpq_1_21.CLK a_6250_3108# VGND.t50 VGND.t674 sg13_lv_nmos ad=0.1406p pd=1.12u as=0.1406p ps=1.12u w=0.74u l=0.13u
X285 a_10231_7644# a_10791_7767# a_10812_8041# VGND.t456 sg13_lv_nmos ad=0.12665p pd=1.145u as=0.3473p ps=2.71u w=0.74u l=0.13u
X286 a_23872_1168# sg13cmos5l_nor4_2_0.C a_24170_1168# VPWR.t15 sg13_lv_pmos ad=0.3808p pd=2.92u as=0.2128p ps=1.5u w=1.12u l=0.13u
X287 a_4270_1185# a_4012_870# VPWR.t105 VPWR.t15 sg13_lv_pmos ad=93.45f pd=0.865u as=1.50275p ps=9.57u w=0.42u l=0.13u
X288 a_18444_1060# sg13cmos5l_xnor2_1_3.B VPWR.t692 VPWR.t15 sg13_lv_pmos ad=0.1596p pd=1.22u as=0.2891p ps=1.695u w=0.84u l=0.13u
X289 a_15127_8394# a_15687_8648# a_15598_8745# VPWR.t0 sg13_lv_pmos ad=0.2048p pd=1.63u as=93.45f ps=0.865u w=0.42u l=0.13u
X290 sg13cmos5l_dlygate4sd3_1_39.A a_27306_7680# VPWR.t389 VPWR.t2 sg13_lv_pmos ad=0.3808p pd=2.92u as=0.2128p ps=1.5u w=1.12u l=0.13u
X291 VGND.t205 a_4640_1919# sg13cmos5l_dfrbpq_1_13.Q VGND.t388 sg13_lv_nmos ad=0.1406p pd=1.12u as=0.2516p ps=2.16u w=0.74u l=0.13u
X292 a_22330_838# sg13cmos5l_dlygate4sd3_1_16.A VPWR.t195 VPWR.t15 sg13_lv_pmos ad=0.1428p pd=1.52u as=0.1523p ps=1.38u w=0.42u l=0.13u
X293 a_16270_2571# a_16385_2572# VGND.t462 VGND.t147 sg13_lv_nmos ad=0.1428p pd=1.52u as=0.1426p ps=1.16u w=0.42u l=0.5u
X294 VPWR.t328 sg13cmos5l_buf_1_0.X.t15 a_20102_8430# VPWR.t0 sg13_lv_pmos ad=0.36237p pd=2.605u as=79.8f ps=0.8u w=0.42u l=0.13u
X295 VGND.t25 a_25029_6179# a_25131_6179# VGND.t241 sg13_lv_nmos ad=3.51837p pd=21.815u as=0.2516p ps=2.16u w=0.74u l=0.13u
X296 sg13cmos5l_dfrbpq_1_53.CLK a_27963_6538# VPWR.t891 VPWR.t7 sg13_lv_pmos ad=0.2128p pd=1.5u as=0.2128p ps=1.5u w=1.12u l=0.13u
X297 VPWR.t1229 a_6250_2350# sg13cmos5l_dfrbpq_1_13.CLK VPWR.t10 sg13_lv_pmos ad=0.2128p pd=1.5u as=0.2128p ps=1.5u w=1.12u l=0.13u
X298 a_10791_7767# a_10943_7651# VPWR.t2 VPWR.t2 sg13_lv_pmos ad=0.3864p pd=2.93u as=1.34765p ps=8.56u w=1.12u l=0.13u
X299 VPWR.t369 sg13cmos5l_dlygate4sd3_1_17.A a_27608_2386# VPWR.t10 sg13_lv_pmos ad=0.1523p pd=1.38u as=0.1428p ps=1.52u w=0.42u l=0.13u
X300 VGND.t58 a_26447_3971# a_27114_4192# VGND.t1445 sg13_lv_nmos ad=0.1406p pd=1.12u as=0.2516p ps=2.16u w=0.74u l=0.13u
X301 VGND.t332 sg13cmos5l_and2_1_4.X a_14235_6922# VGND.t95 sg13_lv_nmos ad=0.1406p pd=1.12u as=0.2553p ps=2.17u w=0.74u l=0.13u
X302 VPWR.t105 sg13cmos5l_dfrbpq_1_13.CLK a_5471_1603# VPWR.t15 sg13_lv_pmos ad=1.46697p pd=9.345u as=0.4088p ps=2.97u w=1.12u l=0.13u
X303 VPWR.t182 VGND.t137 VPWR.t184 VPWR.t15 sg13_lv_pmos ad=0.19p pd=1.38u as=0 ps=0 w=1u l=1u
X304 a_5558_2395# a_4380_2346# a_5162_2540# VGND.t730 sg13_lv_nmos ad=37.8f pd=0.6u as=0.1428p ps=1.52u w=0.42u l=0.13u
X305 VGND.t77 sg13cmos5l_dfrbpq_1_11.CLK a_10943_2652# VGND.t1350 sg13_lv_nmos ad=3.06955p pd=19.355u as=0.2516p ps=2.16u w=0.74u l=0.13u
X306 a_25380_7684# a_25899_7691# a_26639_8041# VGND.t898 sg13_lv_nmos ad=0.3473p pd=2.71u as=0.12665p ps=1.145u w=0.74u l=0.13u
X307 a_14186_6168# sg13cmos5l_nor4_2_4.D sg13cmos5l_nand3_1_1.B VPWR.t7 sg13_lv_pmos ad=0.3808p pd=2.92u as=0.2128p ps=1.5u w=1.12u l=0.13u
X308 sg13cmos5l_dfrbpq_1_1.Q a_27018_1168# VPWR.t317 VPWR.t15 sg13_lv_pmos ad=0.3808p pd=2.92u as=0.2128p ps=1.5u w=1.12u l=0.13u
X309 VGND.t567 sg13cmos5l_dfrbpq_1_55.RESET_B a_15542_2057# VGND.t394 sg13_lv_nmos ad=0.1701p pd=1.65u as=37.8f ps=0.6u w=0.42u l=0.13u
X310 a_17518_7947# a_17633_7946# VPWR.t800 VPWR.t2 sg13_lv_pmos ad=0.34p pd=2.68u as=0.2254p ps=1.53u w=1u l=0.5u
X311 VPWR.t962 sg13cmos5l_nor3_1_2.C a_7799_8821# VPWR.t0 sg13_lv_pmos ad=0.1428p pd=1.52u as=79.8f ps=0.8u w=0.42u l=0.13u
X312 a_6272_1045# a_6391_834# VGND.t38 VGND.t505 sg13_lv_nmos ad=0.2516p pd=2.16u as=0.1406p ps=1.12u w=0.74u l=0.13u
X313 VPWR.t91 a_25936_2602# a_25881_2697# VPWR.t10 sg13_lv_pmos ad=1.43285p pd=9.125u as=93.45f ps=0.865u w=0.42u l=0.13u
X314 a_26181_8409# sg13cmos5l_dfrbpq_1_53.CLK VPWR.t1 VPWR.t0 sg13_lv_pmos ad=0.4088p pd=2.97u as=1.8922p ps=12.27u w=1.12u l=0.13u
X315 a_24132_6931# a_24363_7040# a_23818_7141# VGND.t4 sg13_lv_nmos ad=0.2373p pd=1.97u as=79.8f ps=0.8u w=0.42u l=0.13u
X316 VGND.t15 sg13cmos5l_dlygate4sd3_1_21.A a_920_1673# VGND.t814 sg13_lv_nmos ad=79.8f pd=0.8u as=0.1428p ps=1.52u w=0.42u l=0.13u
X317 VGND.t115 sg13cmos5l_buf_8_3.A a_6250_2350# VGND.t767 sg13_lv_nmos ad=0.1406p pd=1.12u as=0.1406p ps=1.12u w=0.74u l=0.13u
X318 a_10596_8443# a_10308_8748# a_10534_8443# VGND.t89 sg13_lv_nmos ad=0.1428p pd=1.52u as=37.8f ps=0.6u w=0.42u l=0.13u
X319 sg13cmos5l_dlygate4sd3_1_18.X a_9558_938# VGND.t167 VGND.t166 sg13_lv_nmos ad=0.2516p pd=2.16u as=0.1426p ps=1.16u w=0.74u l=0.13u
X320 a_15782_6918# a_16587_7040# a_16042_7141# VPWR.t2 sg13_lv_pmos ad=0.1428p pd=1.52u as=79.8f ps=0.8u w=0.42u l=0.13u
X321 a_24780_5596# sg13cmos5l_xnor2_1_4.Y VPWR.t221 VPWR.t7 sg13_lv_pmos ad=0.1596p pd=1.22u as=0.2891p ps=1.695u w=0.84u l=0.13u
X322 a_13860_3148# a_13834_3112# VPWR.t525 VPWR.t10 sg13_lv_pmos ad=0.34p pd=2.68u as=0.36237p ps=2.605u w=1u l=0.13u
X323 VGND.t40 VPWR.t1473 VGND.t40 VGND.t1462 sg13_lv_nmos ad=79.8f pd=0.8u as=0 ps=0 w=0.42u l=1u
X324 VGND.t824 a_17680_5626# a_17329_5483# VGND.t1356 sg13_lv_nmos ad=79.8f pd=0.8u as=0.1428p ps=1.52u w=0.42u l=0.13u
X325 VPWR.t21 VGND.t150 VPWR.t20 VPWR.t15 sg13_lv_pmos ad=0.34p pd=2.68u as=0 ps=0 w=1u l=1u
X326 a_25094_8118# a_25899_7691# a_25354_7648# VPWR.t2 sg13_lv_pmos ad=0.1428p pd=1.52u as=79.8f ps=0.8u w=0.42u l=0.13u
X327 a_24420_2700# a_24394_2605# VPWR.t79 VPWR.t10 sg13_lv_pmos ad=0.34p pd=2.68u as=0.36237p ps=2.605u w=1u l=0.13u
X328 VGND.t191 sg13cmos5l_buf_8_10.A a_18363_6922# VGND.t1080 sg13_lv_nmos ad=0.1406p pd=1.12u as=0.2553p ps=2.17u w=0.74u l=0.13u
X329 a_24420_2700# a_24939_2504# a_25679_2459# VGND.t282 sg13_lv_nmos ad=0.3473p pd=2.71u as=0.12665p ps=1.145u w=0.74u l=0.13u
X330 a_25764_4660# a_26283_4667# a_27023_5017# VGND.t200 sg13_lv_nmos ad=0.3473p pd=2.71u as=0.12665p ps=1.145u w=0.74u l=0.13u
X331 VPWR.t6 sg13cmos5l_and2_1_1.X a_23835_8050# VPWR.t2 sg13_lv_pmos ad=0.2128p pd=1.5u as=0.3808p ps=2.92u w=1.12u l=0.13u
X332 VPWR.t94 sg13cmos5l_dlygate4sd3_1_22.A a_1784_874# VPWR.t15 sg13_lv_pmos ad=0.1523p pd=1.38u as=0.1428p ps=1.52u w=0.42u l=0.13u
X333 a_18084_3907# a_18315_4016# a_17770_4117# VGND.t59 sg13_lv_nmos ad=0.2373p pd=1.97u as=79.8f ps=0.8u w=0.42u l=0.13u
X334 VPWR.t79 a_23846_3144# a_23958_3168# VPWR.t10 sg13_lv_pmos ad=0.2254p pd=1.53u as=0.34p ps=2.68u w=1u l=0.5u
X335 VPWR.t562 sg13cmos5l_dlygate4sd3_1_4.A a_28376_874# VPWR.t15 sg13_lv_pmos ad=0.1523p pd=1.38u as=0.1428p ps=1.52u w=0.42u l=0.13u
X336 a_14364_1993# a_14495_1603# a_13783_1596# VPWR.t15 sg13_lv_pmos ad=0.34p pd=2.68u as=0.2048p ps=1.63u w=1u l=0.13u
X337 VGND.t176 a_27686_874# a_27798_938# VGND.t177 sg13_lv_nmos ad=0.1426p pd=1.16u as=0.1428p ps=1.52u w=0.42u l=0.5u
X338 a_4233_4285# a_3876_4212# VPWR.t215 VPWR.t43 sg13_lv_pmos ad=63f pd=0.72u as=0.1563p ps=1.22u w=0.42u l=0.13u
X339 VPWR.t964 VGND.t393 VPWR.t27 VPWR.t10 sg13_lv_pmos ad=0.34p pd=2.68u as=0 ps=0 w=1u l=1u
X340 a_5207_2773# sg13cmos5l_dlygate4sd3_1_19.X a_5954_2382# VGND.t699 sg13_lv_nmos ad=0.1428p pd=1.52u as=60.89999f ps=0.71u w=0.42u l=0.13u
X341 a_26662_6931# sg13cmos5l_dfrbpq_1_53.RESET_B.t6 VGND.t126 VGND.t426 sg13_lv_nmos ad=37.8f pd=0.6u as=0.1701p ps=1.65u w=0.42u l=0.13u
X342 a_20782_6918# a_21023_7188# a_20311_6882# VGND.t1028 sg13_lv_nmos ad=0.1428p pd=1.52u as=0.12665p ps=1.145u w=0.42u l=0.13u
X343 VPWR.t67 VGND.t861 VPWR.t65 VPWR.t43 sg13_lv_pmos ad=0.19p pd=1.38u as=0 ps=0 w=1u l=1u
X344 VPWR.t781 sg13cmos5l_dfrbpq_1_21.RESET_B.t8 a_3590_3894# VPWR.t43 sg13_lv_pmos ad=0.36237p pd=2.605u as=79.8f ps=0.8u w=0.42u l=0.13u
X345 sg13cmos5l_dlygate4sd3_1_9.A a_27690_5704# VGND.t259 VGND.t200 sg13_lv_nmos ad=0.2516p pd=2.16u as=0.1406p ps=1.12u w=0.74u l=0.13u
X346 VPWR.t1028 a_17231_6529# a_17898_6168# VPWR.t7 sg13_lv_pmos ad=0.2128p pd=1.5u as=0.3864p ps=2.93u w=1.12u l=0.13u
X347 VPWR.t892 sg13cmos5l_xnor2_1_13.Y a_2016_7233# VPWR.t2 sg13_lv_pmos ad=0.2891p pd=1.695u as=0.1596p ps=1.22u w=0.84u l=0.13u
X348 a_10022_5406# a_10827_5528# a_10282_5629# VPWR.t7 sg13_lv_pmos ad=0.1428p pd=1.52u as=79.8f ps=0.8u w=0.42u l=0.13u
X349 a_25146_8446# sg13cmos5l_dfrbpq_1_37.D VGND.t62 VGND.t976 sg13_lv_nmos ad=88.8f pd=0.98u as=0.15245p ps=1.17u w=0.74u l=0.13u
X350 VGND.t203 VPWR.t8 VGND.t143 VGND.t142 sg13_lv_nmos ad=0.1428p pd=1.52u as=0 ps=0 w=0.42u l=1u
X351 sg13cmos5l_dfrbpq_1_21.CLK a_6250_3108# VGND.t50 VGND.t674 sg13_lv_nmos ad=0.1406p pd=1.12u as=0.2516p ps=2.16u w=0.74u l=0.13u
X352 a_24902_3894# sg13cmos5l_nor3_1_0.B VPWR.t227 VPWR.t43 sg13_lv_pmos ad=79.8f pd=0.8u as=0.1428p ps=1.52u w=0.42u l=0.13u
X353 VGND.t176 a_26608_1090# a_26257_947# VGND.t327 sg13_lv_nmos ad=79.8f pd=0.8u as=0.1428p ps=1.52u w=0.42u l=0.13u
X354 a_25738_8653# a_26181_8409# a_25478_8430# VGND.t271 sg13_lv_nmos ad=79.8f pd=0.8u as=0.1296p ps=1.52u w=0.42u l=0.13u
X355 VPWR.t1082 sg13cmos5l_dfrbpq_1_57.Q a_9176_5410# VPWR.t7 sg13_lv_pmos ad=0.1523p pd=1.38u as=0.1428p ps=1.52u w=0.42u l=0.13u
X356 VGND.t25 a_6693_6897# a_6795_7040# VGND.t910 sg13_lv_nmos ad=3.51837p pd=21.815u as=0.2516p ps=2.16u w=0.74u l=0.13u
X357 VPWR.t105 a_19845_849# a_19947_992# VPWR.t15 sg13_lv_pmos ad=1.50275p pd=9.57u as=0.3864p ps=2.93u w=1.12u l=0.13u
X358 VGND.t121 sg13cmos5l_dlygate4sd3_1_35.A a_1784_8434# VGND.t978 sg13_lv_nmos ad=79.8f pd=0.8u as=0.1428p ps=1.52u w=0.42u l=0.13u
X359 VPWR.t227 a_23846_3898# a_23958_3962# VPWR.t43 sg13_lv_pmos ad=0.2254p pd=1.53u as=0.34p ps=2.68u w=1u l=0.5u
X360 sg13cmos5l_buf_2_0.X a_19609_6942# VPWR.t882 VPWR.t2 sg13_lv_pmos ad=0.2128p pd=1.5u as=0.2086p ps=1.5u w=1.12u l=0.13u
X361 VGND.t632 sg13cmos5l_dfrbpq_1_21.Q a_1784_3185# VGND.t631 sg13_lv_nmos ad=79.8f pd=0.8u as=0.1428p ps=1.52u w=0.42u l=0.13u
X362 VGND.t728 sg13cmos5l_dfrbpq_1_21.RESET_B.t16 a_3684_8430# VGND.t81 sg13_lv_nmos ad=0.1626p pd=1.415u as=60.89999f ps=0.71u w=0.42u l=0.13u
X363 a_20805_4667# sg13cmos5l_dfrbpq_1_2.CLK VPWR.t43 VPWR.t43 sg13_lv_pmos ad=0.4088p pd=2.97u as=1.36105p ps=8.695u w=1.12u l=0.13u
X364 a_20618_6918# a_20311_6882# a_20524_6918# VGND.t314 sg13_lv_nmos ad=37.8f pd=0.6u as=0.1428p ps=1.52u w=0.42u l=0.13u
X365 VPWR.t1013 a_18826_4620# sg13cmos5l_dfrbpq_1_2.CLK VPWR.t43 sg13_lv_pmos ad=0.2128p pd=1.5u as=0.2128p ps=1.5u w=1.12u l=0.13u
X366 VGND.t50 sg13cmos5l_buf_1_1.X.t13 a_18372_3582# VGND.t447 sg13_lv_nmos ad=0.1626p pd=1.415u as=60.89999f ps=0.71u w=0.42u l=0.13u
X367 sg13cmos5l_dfrbpq_1_58.RESET_B a_2920_6956# VPWR.t291 VPWR.t2 sg13_lv_pmos ad=0.42p pd=2.99u as=0.2114p ps=1.54u w=1.12u l=0.13u
X368 VGND.t191 a_17584_7138# a_17233_6995# VGND.t346 sg13_lv_nmos ad=79.8f pd=0.8u as=0.1428p ps=1.52u w=0.42u l=0.13u
X369 a_8759_1679# sg13cmos5l_dfrbpq_1_13.RESET_B.t9 VPWR.t200 VPWR.t15 sg13_lv_pmos ad=79.8f pd=0.8u as=0.36237p ps=2.605u w=0.42u l=0.13u
X370 a_7524_2382# sg13cmos5l_xnor2_1_6.A a_7430_2382# VGND.t1433 sg13_lv_nmos ad=60.89999f pd=0.71u as=0.1428p ps=1.52u w=0.42u l=0.13u
X371 a_20388_6172# a_20362_6136# VPWR.t397 VPWR.t7 sg13_lv_pmos ad=0.34p pd=2.68u as=0.36237p ps=2.605u w=1u l=0.13u
X372 a_14186_6168# sg13cmos5l_dfrbpq_1_56.D a_13888_6168# VPWR.t7 sg13_lv_pmos ad=0.2128p pd=1.5u as=0.2128p ps=1.5u w=1.12u l=0.13u
X373 a_3850_3112# a_4293_3155# a_4233_3191# VPWR.t10 sg13_lv_pmos ad=79.8f pd=0.8u as=63f ps=0.72u w=0.42u l=0.13u
X374 VPWR.t352 a_13563_874# sg13cmos5l_dfrbpq_1_11.CLK VPWR.t15 sg13_lv_pmos ad=0.2128p pd=1.5u as=0.2128p ps=1.5u w=1.12u l=0.13u
X375 a_20745_5797# a_20388_5724# VPWR.t177 VPWR.t7 sg13_lv_pmos ad=63f pd=0.72u as=0.1563p ps=1.22u w=0.42u l=0.13u
X376 VPWR.t183 VGND.t160 VPWR.t184 VPWR.t15 sg13_lv_pmos ad=0.19p pd=1.38u as=0 ps=0 w=1u l=1u
X377 a_11824_8650# sg13cmos5l_dfrbpq_1_57.RESET_B.t13 VPWR.t1 VPWR.t0 sg13_lv_pmos ad=79.8f pd=0.8u as=1.8922p ps=12.27u w=0.42u l=0.13u
X378 sg13cmos5l_dfrbpq_1_3.D a_23958_1656# VPWR.t184 VPWR.t15 sg13_lv_pmos ad=0.4256p pd=3u as=0.2254p ps=1.53u w=1.12u l=0.13u
X379 VGND.t800 a_18922_7644# sg13cmos5l_dfrbpq_1_46.CLK VGND.t0 sg13_lv_nmos ad=0.1406p pd=1.12u as=0.1406p ps=1.12u w=0.74u l=0.13u
X380 a_10282_1600# a_10725_1643# a_10022_2070# VGND.t479 sg13_lv_nmos ad=79.8f pd=0.8u as=0.1296p ps=1.52u w=0.42u l=0.13u
X381 a_13676_7680# sg13cmos5l_xnor2_1_2.B a_13888_7680# VPWR.t2 sg13_lv_pmos ad=0.2128p pd=1.5u as=0.3808p ps=2.92u w=1.12u l=0.13u
X382 VPWR.t291 sg13cmos5l_buf_1_11.A a_2920_6956# VPWR.t2 sg13_lv_pmos ad=0.2114p pd=1.54u as=0.2856p ps=2.36u w=0.84u l=0.13u
X383 a_26052_5081# a_26283_4667# a_25738_4624# VGND.t707 sg13_lv_nmos ad=0.2373p pd=1.97u as=79.8f ps=0.8u w=0.42u l=0.13u
X384 sg13cmos5l_nand3_1_3.B sg13cmos5l_dfrbpq_1_17.D a_11786_4192# VPWR.t43 sg13_lv_pmos ad=0.2128p pd=1.5u as=0.3808p ps=2.92u w=1.12u l=0.13u
X385 a_7439_6529# a_6597_6179# a_6180_6172# VPWR.t7 sg13_lv_pmos ad=0.2048p pd=1.63u as=0.34p ps=2.68u w=1u l=0.13u
X386 VPWR.t130 a_4380_834# a_5403_1261# VPWR.t15 sg13_lv_pmos ad=0.1563p pd=1.22u as=63f ps=0.72u w=0.42u l=0.13u
X387 VGND.t40 a_11824_8650# a_11473_8507# VGND.t1389 sg13_lv_nmos ad=79.8f pd=0.8u as=0.1428p ps=1.52u w=0.42u l=0.13u
X388 sg13cmos5l_xnor2_1_4.Y a_28524_3410# VPWR.t1410 VPWR.t10 sg13_lv_pmos ad=0.2408p pd=1.55u as=0.3808p ps=2.92u w=1.12u l=0.13u
X389 a_26135_1679# a_25439_1603# a_26229_1679# VGND.t497 sg13_lv_nmos ad=0.1296p pd=1.52u as=79.8f ps=0.8u w=0.42u l=0.13u
X390 a_18382_6435# a_18497_6434# VPWR.t571 VPWR.t7 sg13_lv_pmos ad=0.34p pd=2.68u as=0.2254p ps=1.53u w=1u l=0.5u
X391 a_10231_4620# a_10791_4743# a_10702_4779# VPWR.t43 sg13_lv_pmos ad=0.2048p pd=1.63u as=93.45f ps=0.865u w=0.42u l=0.13u
X392 VPWR.t1 sg13cmos5l_dfrbpq_1_21.RESET_B.t14 a_6604_8430# VPWR.t0 sg13_lv_pmos ad=1.82695p pd=11.845u as=79.8f ps=0.8u w=0.42u l=0.13u
X393 a_23818_7141# a_24261_6897# a_24201_7309# VPWR.t2 sg13_lv_pmos ad=79.8f pd=0.8u as=63f ps=0.72u w=0.42u l=0.13u
X394 sg13cmos5l_dfrbpq_1_46.CLK a_18922_7644# VGND.t1016 VGND.t0 sg13_lv_nmos ad=0.1406p pd=1.12u as=0.1406p ps=1.12u w=0.74u l=0.13u
X395 VGND.t62 a_23835_8050# sg13cmos5l_buf_8_11.A VGND.t895 sg13_lv_nmos ad=0.2516p pd=2.16u as=0.1406p ps=1.12u w=0.74u l=0.13u
X396 sg13cmos5l_dfrbpq_1_35.Q a_12234_7216# VGND.t96 VGND.t95 sg13_lv_nmos ad=0.2516p pd=2.16u as=0.1406p ps=1.12u w=0.74u l=0.13u
X397 VPWR.t850 a_5626_6886# a_5345_7108# VPWR.t2 sg13_lv_pmos ad=0.1523p pd=1.38u as=0.34p ps=2.68u w=1u l=0.5u
X398 a_4358_5410# a_4088_5410# VGND.t52 VGND.t345 sg13_lv_nmos ad=0.1428p pd=1.52u as=79.8f ps=0.8u w=0.42u l=0.5u
X399 VPWR.t677 sg13cmos5l_dfrbpq_1_57.RESET_B.t3 a_10022_5406# VPWR.t7 sg13_lv_pmos ad=0.36237p pd=2.605u as=79.8f ps=0.8u w=0.42u l=0.13u
X400 VGND.t106 a_20080_3386# a_19729_3505# VGND.t446 sg13_lv_nmos ad=79.8f pd=0.8u as=0.1428p ps=1.52u w=0.42u l=0.13u
X401 a_16886_8443# a_15708_8394# a_16490_8588# VGND.t0 sg13_lv_nmos ad=37.8f pd=0.6u as=0.1428p ps=1.52u w=0.42u l=0.13u
X402 a_19474_3894# sg13cmos5l_buf_1_4.X.t7 VGND.t50 VGND.t1234 sg13_lv_nmos ad=37.8f pd=0.6u as=79.8f ps=0.8u w=0.42u l=0.13u
X403 VPWR.t379 a_18272_1919# sg13cmos5l_dfrbpq_1_3.Q VPWR.t15 sg13_lv_pmos ad=0.2128p pd=1.5u as=0.3808p ps=2.92u w=1.12u l=0.13u
X404 a_18698_2070# a_18391_1596# a_18604_2070# VGND.t398 sg13_lv_nmos ad=37.8f pd=0.6u as=0.1428p ps=1.52u w=0.42u l=0.13u
X405 sg13cmos5l_nand3_1_3.B sg13cmos5l_dfrbpq_1_17.D VGND.t572 VGND.t1192 sg13_lv_nmos ad=0.1406p pd=1.12u as=0.3293p ps=1.63u w=0.74u l=0.13u
X406 sg13cmos5l_buf_8_11.A a_23835_8050# VGND.t286 VGND.t892 sg13_lv_nmos ad=0.1406p pd=1.12u as=0.1406p ps=1.12u w=0.74u l=0.13u
X407 a_15820_5094# a_15607_4620# VPWR.t43 VPWR.t43 sg13_lv_pmos ad=79.8f pd=0.8u as=1.3927p ps=8.9u w=0.42u l=0.13u
X408 VGND.t861 sg13cmos5l_dfrbpq_1_21.RESET_B.t4 a_3684_3582# VGND.t862 sg13_lv_nmos ad=0.1626p pd=1.415u as=60.89999f ps=0.71u w=0.42u l=0.13u
X409 a_21719_7309# sg13cmos5l_buf_1_0.X.t10 VPWR.t3 VPWR.t2 sg13_lv_pmos ad=79.8f pd=0.8u as=0.36237p ps=2.605u w=0.42u l=0.13u
X410 a_17472_1671# sg13cmos5l_nand3_1_0.Y VPWR.t191 VPWR.t15 sg13_lv_pmos ad=0.1596p pd=1.22u as=0.4536p ps=2.76u w=0.84u l=0.13u
X411 VGND.t278 VPWR.t1467 VGND.t278 VGND.t1482 sg13_lv_nmos ad=0.1428p pd=1.52u as=0 ps=0 w=0.42u l=1u
X412 VGND.t96 sg13cmos5l_dlygate4sd3_1_52.X sg13cmos5l_nand3_1_1.B VGND.t95 sg13_lv_nmos ad=0.3293p pd=1.63u as=0.1406p ps=1.12u w=0.74u l=0.13u
X413 a_21849_5721# a_20907_5528# a_21647_5483# VPWR.t7 sg13_lv_pmos ad=93.45f pd=0.865u as=0.2048p ps=1.63u w=0.42u l=0.13u
X414 VGND.t106 sg13cmos5l_buf_1_1.X.t15 a_20196_3894# VGND.t105 sg13_lv_nmos ad=0.1626p pd=1.415u as=60.89999f ps=0.71u w=0.42u l=0.13u
X415 a_19526_8434# a_19256_8434# VGND.t800 VGND.t0 sg13_lv_nmos ad=0.1428p pd=1.52u as=79.8f ps=0.8u w=0.42u l=0.5u
X416 a_7298_5406# sg13cmos5l_dfrbpq_1_58.RESET_B VGND.t664 VGND.t256 sg13_lv_nmos ad=60.89999f pd=0.71u as=0.1626p ps=1.415u w=0.42u l=0.13u
X417 a_25572_5094# sg13cmos5l_dlygate4sd3_1_17.X a_25478_5094# VGND.t142 sg13_lv_nmos ad=60.89999f pd=0.71u as=0.1428p ps=1.52u w=0.42u l=0.13u
X418 VPWR.t91 a_15376_2602# a_15321_2697# VPWR.t10 sg13_lv_pmos ad=1.43285p pd=9.125u as=93.45f ps=0.865u w=0.42u l=0.13u
X419 a_11639_4703# sg13cmos5l_dfrbpq_1_57.RESET_B.t0 VPWR.t132 VPWR.t43 sg13_lv_pmos ad=79.8f pd=0.8u as=0.36237p ps=2.605u w=0.42u l=0.13u
X420 a_6267_7727# a_5375_7651# a_6165_7727# VPWR.t2 sg13_lv_pmos ad=63f pd=0.72u as=79.8f ps=0.8u w=0.42u l=0.13u
X421 VPWR.t2 sg13cmos5l_dfrbpq_1_57.RESET_B.t12 a_10444_8118# VPWR.t2 sg13_lv_pmos ad=1.31957p pd=8.38u as=79.8f ps=0.8u w=0.42u l=0.13u
X422 a_23955_6168# sg13cmos5l_dlygate4sd3_1_6.X VPWR.t8 VPWR.t7 sg13_lv_pmos ad=0.1428p pd=1.375u as=0.2891p ps=1.695u w=1.12u l=0.13u
X423 VPWR.t1081 a_2054_3144# a_2166_3168# VPWR.t10 sg13_lv_pmos ad=0.2254p pd=1.53u as=0.34p ps=2.68u w=1u l=0.5u
X424 a_16535_8821# sg13cmos5l_nor4_2_4.D a_17282_8430# VGND.t0 sg13_lv_nmos ad=0.1428p pd=1.52u as=60.89999f ps=0.71u w=0.42u l=0.13u
X425 VPWR.t469 a_13563_874# sg13cmos5l_dfrbpq_1_11.CLK VPWR.t15 sg13_lv_pmos ad=0.2128p pd=1.5u as=0.2128p ps=1.5u w=1.12u l=0.13u
X426 VGND.t65 VPWR.t4 VGND.t65 VGND.t64 sg13_lv_nmos ad=79.8f pd=0.8u as=0 ps=0 w=0.42u l=1u
X427 VGND.t30 a_1265_5460# sg13cmos5l_xnor2_1_13.A VGND.t339 sg13_lv_nmos ad=0.3108p pd=2.32u as=0.1628p ps=1.18u w=0.74u l=0.13u
X428 a_13860_2700# a_14379_2504# a_15119_2459# VGND.t147 sg13_lv_nmos ad=0.3473p pd=2.71u as=0.12665p ps=1.145u w=0.74u l=0.13u
X429 a_17796_4212# a_18315_4016# a_19055_3971# VGND.t60 sg13_lv_nmos ad=0.3473p pd=2.71u as=0.12665p ps=1.145u w=0.74u l=0.13u
X430 a_7893_1028# a_6951_1088# a_7754_1028# VGND.t219 sg13_lv_nmos ad=79.8f pd=0.8u as=0.2373p ps=1.97u w=0.42u l=0.13u
X431 a_8150_3907# a_6972_3858# a_7754_4052# VGND.t786 sg13_lv_nmos ad=37.8f pd=0.6u as=0.1428p ps=1.52u w=0.42u l=0.13u
X432 a_20102_8430# a_20907_8552# a_20362_8653# VPWR.t0 sg13_lv_pmos ad=0.1428p pd=1.52u as=79.8f ps=0.8u w=0.42u l=0.13u
X433 VPWR.t239 VGND.t278 VPWR.t238 VPWR.t2 sg13_lv_pmos ad=0.34p pd=2.68u as=0 ps=0 w=1u l=1u
X434 VPWR.t16 a_2266_1596# a_1985_1898# VPWR.t15 sg13_lv_pmos ad=0.1523p pd=1.38u as=0.34p ps=2.68u w=1u l=0.5u
X435 sg13cmos5l_dlygate4sd3_1_23.X a_2166_3168# VGND.t861 VGND.t1339 sg13_lv_nmos ad=0.2516p pd=2.16u as=0.1426p ps=1.16u w=0.74u l=0.13u
X436 a_7792_7138# a_7535_6995# a_7954_6918# VGND.t1107 sg13_lv_nmos ad=0.1428p pd=1.52u as=37.8f ps=0.6u w=0.42u l=0.13u
X437 a_17680_5626# sg13cmos5l_dfrbpq_1_56.RESET_B VPWR.t7 VPWR.t7 sg13_lv_pmos ad=79.8f pd=0.8u as=1.42587p ps=9.11u w=0.42u l=0.13u
X438 VGND.t1159 a_28570_4620# a_28289_4922# VGND.t200 sg13_lv_nmos ad=79.8f pd=0.8u as=0.1428p ps=1.52u w=0.42u l=0.5u
X439 sg13cmos5l_dfrbpq_1_32.CLK a_8763_8434# VGND.t1014 VGND.t89 sg13_lv_nmos ad=0.1406p pd=1.12u as=0.1406p ps=1.12u w=0.74u l=0.13u
X440 VGND.t203 sg13cmos5l_xnor2_1_4.Y a_24815_5410# VGND.t142 sg13_lv_nmos ad=0.1898p pd=1.36u as=0.1406p ps=1.12u w=0.74u l=0.13u
X441 VPWR.t602 a_17702_3144# a_17814_3168# VPWR.t10 sg13_lv_pmos ad=0.2254p pd=1.53u as=0.34p ps=2.68u w=1u l=0.5u
X442 a_6391_8394# a_6951_8648# a_6972_8394# VGND.t220 sg13_lv_nmos ad=0.12665p pd=1.145u as=0.3473p ps=2.71u w=0.74u l=0.13u
X443 a_20676_3907# a_20907_4016# a_20362_4117# VGND.t105 sg13_lv_nmos ad=0.2373p pd=1.97u as=79.8f ps=0.8u w=0.42u l=0.13u
X444 VPWR.t91 a_18789_2361# a_18891_2504# VPWR.t10 sg13_lv_pmos ad=1.43285p pd=9.125u as=0.3864p ps=2.93u w=1.12u l=0.13u
X445 a_22070_6931# a_20892_6882# a_21674_7076# VGND.t64 sg13_lv_nmos ad=37.8f pd=0.6u as=0.1428p ps=1.52u w=0.42u l=0.13u
X446 a_5036_6168# sg13cmos5l_nor4_2_5.C a_4730_6168# VPWR.t7 sg13_lv_pmos ad=0.2128p pd=1.5u as=0.2128p ps=1.5u w=1.12u l=0.13u
X447 a_8905_6516# sg13cmos5l_and2_1_3.A VGND.t630 VGND.t1054 sg13_lv_nmos ad=0.1216p pd=1.02u as=0.1331p ps=1.12u w=0.64u l=0.13u
X448 VPWR.t1257 sg13cmos5l_dfrbpq_1_3.Q a_17432_3185# VPWR.t10 sg13_lv_pmos ad=0.1523p pd=1.38u as=0.1428p ps=1.52u w=0.42u l=0.13u
X449 a_2016_5721# sg13cmos5l_xnor2_1_5.Y a_1979_5452# VGND.t194 sg13_lv_nmos ad=0.2176p pd=1.96u as=78.39999f ps=0.885u w=0.64u l=0.13u
X450 a_16535_8821# sg13cmos5l_dfrbpq_1_56.RESET_B VPWR.t89 VPWR.t0 sg13_lv_pmos ad=79.8f pd=0.8u as=0.36237p ps=2.605u w=0.42u l=0.13u
X451 VPWR.t901 en[1] a_9640_7680# VPWR.t2 sg13_lv_pmos ad=0.2114p pd=1.54u as=0.2856p ps=2.36u w=0.84u l=0.13u
X452 a_11567_6995# a_10725_6897# a_10308_7236# VPWR.t2 sg13_lv_pmos ad=0.2048p pd=1.63u as=0.34p ps=2.68u w=1u l=0.13u
X453 a_11733_6215# a_10791_6255# a_11639_6215# VPWR.t7 sg13_lv_pmos ad=79.8f pd=0.8u as=0.1428p ps=1.52u w=0.42u l=0.13u
X454 VPWR.t77 VGND.t143 VPWR.t76 VPWR.t43 sg13_lv_pmos ad=0.34p pd=2.68u as=0 ps=0 w=1u l=1u
X455 a_26052_5081# a_25764_4660# a_25990_5081# VGND.t564 sg13_lv_nmos ad=0.1428p pd=1.52u as=37.8f ps=0.6u w=0.42u l=0.13u
X456 a_7911_1719# a_8063_1603# VPWR.t105 VPWR.t15 sg13_lv_pmos ad=0.3864p pd=2.93u as=1.50275p ps=9.57u w=1.12u l=0.13u
X457 a_9177_2697# a_8235_2504# a_8975_2459# VPWR.t10 sg13_lv_pmos ad=93.45f pd=0.865u as=0.2048p ps=1.63u w=0.42u l=0.13u
X458 a_10725_1643# sg13cmos5l_dfrbpq_1_13.CLK VPWR.t105 VPWR.t15 sg13_lv_pmos ad=0.4088p pd=2.97u as=1.46697p ps=9.345u w=1.12u l=0.13u
X459 VGND.t357 a_8763_8434# sg13cmos5l_dfrbpq_1_32.CLK VGND.t89 sg13_lv_nmos ad=0.1406p pd=1.12u as=0.1406p ps=1.12u w=0.74u l=0.13u
X460 a_15972_6172# a_15946_6136# VGND.t25 VGND.t381 sg13_lv_nmos ad=0.2516p pd=2.16u as=0.1626p ps=1.415u w=0.74u l=0.13u
X461 sg13cmos5l_nand3_1_0.A sg13cmos5l_nor4_2_1.D a_20666_2680# VPWR.t10 sg13_lv_pmos ad=0.2128p pd=1.5u as=0.3808p ps=2.92u w=1.12u l=0.13u
X462 a_23660_8728# sg13cmos5l_dfrbpq_1_46.D a_23872_8728# VPWR.t0 sg13_lv_pmos ad=0.2128p pd=1.5u as=0.3808p ps=2.92u w=1.12u l=0.13u
X463 VPWR.t107 a_11567_8507# a_12234_8728# VPWR.t0 sg13_lv_pmos ad=0.2128p pd=1.5u as=0.3864p ps=2.93u w=1.12u l=0.13u
X464 a_28506_2578# sg13cmos5l_dlygate4sd3_1_0.X VGND.t11 VGND.t304 sg13_lv_nmos ad=0.17462p pd=1.185u as=0.15245p ps=1.17u w=0.55u l=0.13u
X465 VGND.t358 a_4544_7967# sg13cmos5l_dlygate4sd3_1_33.A VGND.t68 sg13_lv_nmos ad=0.1406p pd=1.12u as=0.2516p ps=2.16u w=0.74u l=0.13u
X466 a_11990_8105# a_10812_8041# a_11594_7960# VGND.t1604 sg13_lv_nmos ad=37.8f pd=0.6u as=0.1428p ps=1.52u w=0.42u l=0.13u
X467 a_21742_1899# a_21857_1898# VGND.t17 VGND.t1668 sg13_lv_nmos ad=0.1428p pd=1.52u as=0.1426p ps=1.16u w=0.42u l=0.5u
X468 a_18922_7644# sg13cmos5l_buf_8_11.A VPWR.t886 VPWR.t2 sg13_lv_pmos ad=0.2128p pd=1.5u as=0.2128p ps=1.5u w=1.12u l=0.13u
X469 a_10308_7236# a_10282_7141# VGND.t558 VGND.t654 sg13_lv_nmos ad=0.2516p pd=2.16u as=0.1626p ps=1.415u w=0.74u l=0.13u
X470 sg13cmos5l_buf_8_11.A a_23835_8050# VGND.t286 VGND.t888 sg13_lv_nmos ad=0.1406p pd=1.12u as=0.1406p ps=1.12u w=0.74u l=0.13u
X471 a_6604_3894# a_6391_3858# VPWR.t43 VPWR.t43 sg13_lv_pmos ad=79.8f pd=0.8u as=1.3927p ps=8.9u w=0.42u l=0.13u
X472 a_25478_5406# sg13cmos5l_dlygate4sd3_1_11.X VPWR.t221 VPWR.t7 sg13_lv_pmos ad=79.8f pd=0.8u as=0.1428p ps=1.52u w=0.42u l=0.13u
X473 a_13996_2070# a_13783_1596# VPWR.t105 VPWR.t15 sg13_lv_pmos ad=79.8f pd=0.8u as=1.50275p ps=9.57u w=0.42u l=0.13u
X474 a_21067_3492# sg13cmos5l_and2_1_1.A a_20973_3492# VGND.t988 sg13_lv_nmos ad=0.1216p pd=1.02u as=0.2176p ps=1.96u w=0.64u l=0.13u
X475 a_10534_8443# sg13cmos5l_dfrbpq_1_57.RESET_B.t14 VGND.t91 VGND.t89 sg13_lv_nmos ad=37.8f pd=0.6u as=0.1701p ps=1.65u w=0.42u l=0.13u
X476 VGND.t191 a_17488_6410# a_17137_6529# VGND.t190 sg13_lv_nmos ad=79.8f pd=0.8u as=0.1428p ps=1.52u w=0.42u l=0.13u
X477 VGND.t205 sg13cmos5l_dfrbpq_1_21.RESET_B.t2 a_4106_2382# VGND.t732 sg13_lv_nmos ad=79.8f pd=0.8u as=37.8f ps=0.6u w=0.42u l=0.13u
X478 sg13cmos5l_dfrbpq_1_32.CLK a_8763_8434# VGND.t1594 VGND.t89 sg13_lv_nmos ad=0.1406p pd=1.12u as=0.1406p ps=1.12u w=0.74u l=0.13u
X479 VGND.t30 sg13cmos5l_xnor2_1_13.A a_2165_5026# VGND.t30 sg13_lv_nmos ad=0.1898p pd=1.36u as=0.2516p ps=2.16u w=0.74u l=0.13u
X480 a_10112_2557# a_10231_2346# VPWR.t1302 VPWR.t10 sg13_lv_pmos ad=0.3864p pd=2.93u as=0.2128p ps=1.5u w=1.12u l=0.13u
X481 a_23660_8728# sg13cmos5l_dlygate4sd3_1_6.X VPWR.t167 VPWR.t0 sg13_lv_pmos ad=0.2128p pd=1.5u as=0.3864p ps=2.93u w=1.12u l=0.13u
X482 VGND.t17 sg13cmos5l_nor4_2_1.D sg13cmos5l_nand3_1_0.A VGND.t1128 sg13_lv_nmos ad=0.3293p pd=1.63u as=0.1406p ps=1.12u w=0.74u l=0.13u
X483 a_20311_7644# a_20871_7767# a_20782_7803# VPWR.t2 sg13_lv_pmos ad=0.2048p pd=1.63u as=93.45f ps=0.865u w=0.42u l=0.13u
X484 VGND.t25 a_10725_6897# a_10827_7040# VGND.t923 sg13_lv_nmos ad=3.51837p pd=21.815u as=0.2516p ps=2.16u w=0.74u l=0.13u
X485 a_21904_6410# a_21647_6529# a_22066_6606# VGND.t423 sg13_lv_nmos ad=0.1428p pd=1.52u as=37.8f ps=0.6u w=0.42u l=0.13u
X486 a_20388_8748# a_20362_8653# VPWR.t328 VPWR.t0 sg13_lv_pmos ad=0.34p pd=2.68u as=0.36237p ps=2.605u w=1u l=0.13u
X487 VPWR.t1420 a_8763_8434# sg13cmos5l_dfrbpq_1_32.CLK VPWR.t0 sg13_lv_pmos ad=0.3864p pd=2.93u as=0.2128p ps=1.5u w=1.12u l=0.13u
X488 a_24612_6172# a_25131_6179# a_25871_6529# VGND.t1659 sg13_lv_nmos ad=0.3473p pd=2.71u as=0.12665p ps=1.145u w=0.74u l=0.13u
X489 a_4359_1088# a_4511_1140# VGND.t35 VGND.t34 sg13_lv_nmos ad=0.2516p pd=2.16u as=5.40863p ps=35.155u w=0.74u l=0.13u
X490 a_9562_3862# sg13cmos5l_dfrbpq_1_17.Q VGND.t50 VGND.t1422 sg13_lv_nmos ad=0.1428p pd=1.52u as=79.8f ps=0.8u w=0.42u l=0.13u
X491 a_20524_6918# a_20311_6882# VPWR.t2 VPWR.t2 sg13_lv_pmos ad=79.8f pd=0.8u as=1.34765p ps=8.56u w=0.42u l=0.13u
X492 a_21904_5626# sg13cmos5l_buf_1_0.X.t2 VPWR.t7 VPWR.t7 sg13_lv_pmos ad=79.8f pd=0.8u as=1.42587p ps=9.11u w=0.42u l=0.13u
X493 VPWR.t227 a_24526_4923# sg13cmos5l_dlygate4sd3_1_55.X VPWR.t43 sg13_lv_pmos ad=0.2254p pd=1.53u as=0.4256p ps=3u w=1.12u l=0.13u
X494 VPWR.t898 sg13cmos5l_dfrbpq_1_58.D a_6359_4703# VPWR.t43 sg13_lv_pmos ad=0.1428p pd=1.52u as=79.8f ps=0.8u w=0.42u l=0.13u
X495 VGND.t133 a_18826_4620# sg13cmos5l_dfrbpq_1_2.CLK VGND.t1141 sg13_lv_nmos ad=0.1406p pd=1.12u as=0.1406p ps=1.12u w=0.74u l=0.13u
X496 a_23846_3144# a_23576_3185# VPWR.t79 VPWR.t10 sg13_lv_pmos ad=0.34p pd=2.68u as=0.1523p ps=1.38u w=1u l=0.5u
X497 VPWR.t43 a_20805_3873# a_20907_4016# VPWR.t43 sg13_lv_pmos ad=1.3927p pd=8.9u as=0.3864p ps=2.93u w=1.12u l=0.13u
X498 VPWR.t942 a_14235_6922# sg13cmos5l_buf_8_10.A VPWR.t2 sg13_lv_pmos ad=0.2128p pd=1.5u as=0.2128p ps=1.5u w=1.12u l=0.13u
X499 VPWR.t635 a_27695_6995# a_28362_7216# VPWR.t2 sg13_lv_pmos ad=0.2128p pd=1.5u as=0.3864p ps=2.93u w=1.12u l=0.13u
X500 a_23661_2428# sg13cmos5l_and2_1_1.A VPWR.t79 VPWR.t10 sg13_lv_pmos ad=0.1596p pd=1.22u as=0.2856p ps=2.36u w=0.84u l=0.13u
X501 VGND.t268 sg13cmos5l_xnor2_1_4.B a_28559_3514# VGND.t1190 sg13_lv_nmos ad=0.1898p pd=1.36u as=0.1406p ps=1.12u w=0.74u l=0.13u
X502 a_22066_5094# sg13cmos5l_buf_1_4.X.t9 VGND.t143 VGND.t142 sg13_lv_nmos ad=37.8f pd=0.6u as=79.8f ps=0.8u w=0.42u l=0.13u
X503 a_25679_2459# a_24837_2361# a_25585_2459# VGND.t78 sg13_lv_nmos ad=0.12665p pd=1.145u as=0.1428p ps=1.52u w=0.42u l=0.13u
X504 VGND.t52 a_3680_5609# sg13cmos5l_buf_8_5.A VGND.t586 sg13_lv_nmos ad=0.1331p pd=1.12u as=0.2516p ps=2.16u w=0.74u l=0.13u
X505 a_25606_8105# sg13cmos5l_dfrbpq_1_53.RESET_B.t8 VGND.t299 VGND.t298 sg13_lv_nmos ad=37.8f pd=0.6u as=0.1701p ps=1.65u w=0.42u l=0.13u
X506 a_26244_6918# sg13cmos5l_dlygate4sd3_1_9.X a_26150_6918# VGND.t1005 sg13_lv_nmos ad=60.89999f pd=0.71u as=0.1428p ps=1.52u w=0.42u l=0.13u
X507 a_4166_6168# a_3896_6209# VGND.t1033 VGND.t1034 sg13_lv_nmos ad=0.1428p pd=1.52u as=79.8f ps=0.8u w=0.42u l=0.5u
X508 a_1434_3502# sg13cmos5l_dfrbpq_1_12.D VGND.t632 VGND.t1229 sg13_lv_nmos ad=88.8f pd=0.98u as=0.15245p ps=1.17u w=0.74u l=0.13u
X509 sg13cmos5l_dfrbpq_1_32.CLK a_8763_8434# VPWR.t1416 VPWR.t0 sg13_lv_pmos ad=0.2128p pd=1.5u as=0.2128p ps=1.5u w=1.12u l=0.13u
X510 a_5230_2070# a_5471_1603# a_4759_1596# VGND.t222 sg13_lv_nmos ad=0.1428p pd=1.52u as=0.12665p ps=1.145u w=0.42u l=0.13u
X511 a_18564_3148# a_19083_3155# a_19823_3505# VGND.t1227 sg13_lv_nmos ad=0.3473p pd=2.71u as=0.12665p ps=1.145u w=0.74u l=0.13u
X512 a_18010_8398# sg13cmos5l_dfrbpq_1_47.Q VGND.t842 VGND.t0 sg13_lv_nmos ad=0.1428p pd=1.52u as=79.8f ps=0.8u w=0.42u l=0.13u
X513 a_10231_4620# a_10791_4743# a_10812_5017# VGND.t1304 sg13_lv_nmos ad=0.12665p pd=1.145u as=0.3473p ps=2.71u w=0.74u l=0.13u
X514 sg13cmos5l_dfrbpq_1_2.CLK a_18826_4620# VGND.t133 VGND.t1138 sg13_lv_nmos ad=0.1406p pd=1.12u as=0.1406p ps=1.12u w=0.74u l=0.13u
X515 a_4293_3873# sg13cmos5l_dfrbpq_1_21.CLK VPWR.t43 VPWR.t43 sg13_lv_pmos ad=0.4088p pd=2.97u as=1.36105p ps=8.695u w=1.12u l=0.13u
X516 VGND.t15 a_1870_2571# sg13cmos5l_xnor2_1_6.A VGND.t473 sg13_lv_nmos ad=0.1426p pd=1.16u as=0.2516p ps=2.16u w=0.74u l=0.13u
X517 VPWR.t278 a_27195_3514# sg13cmos5l_dfrbpq_1_0.CLK VPWR.t10 sg13_lv_pmos ad=0.2128p pd=1.5u as=0.2128p ps=1.5u w=1.12u l=0.13u
X518 a_5135_3505# a_4293_3155# a_3876_3148# VPWR.t10 sg13_lv_pmos ad=0.2048p pd=1.63u as=0.34p ps=2.68u w=1u l=0.13u
X519 VGND.t121 VPWR.t1474 VGND.t121 VGND.t1466 sg13_lv_nmos ad=0.1428p pd=1.52u as=0 ps=0 w=0.42u l=1u
X520 VGND.t25 sg13cmos5l_dfrbpq_1_58.RESET_B a_6084_6918# VGND.t937 sg13_lv_nmos ad=0.1626p pd=1.415u as=60.89999f ps=0.71u w=0.42u l=0.13u
X521 VGND.t176 sg13cmos5l_dfrbpq_1_1.Q a_27416_874# VGND.t1189 sg13_lv_nmos ad=79.8f pd=0.8u as=0.1428p ps=1.52u w=0.42u l=0.13u
X522 a_14235_6922# sg13cmos5l_and2_1_4.X VPWR.t950 VPWR.t2 sg13_lv_pmos ad=0.2128p pd=1.5u as=0.2128p ps=1.5u w=1.12u l=0.13u
X523 a_11567_1993# a_10725_1643# a_10308_1636# VPWR.t15 sg13_lv_pmos ad=0.2048p pd=1.63u as=0.34p ps=2.68u w=1u l=0.13u
X524 a_10791_4743# a_10943_4627# VPWR.t43 VPWR.t43 sg13_lv_pmos ad=0.3864p pd=2.93u as=1.3927p ps=8.9u w=1.12u l=0.13u
X525 sg13cmos5l_dlygate4sd3_1_39.A a_27306_7680# VGND.t273 VGND.t276 sg13_lv_nmos ad=0.2516p pd=2.16u as=0.1406p ps=1.12u w=0.74u l=0.13u
X526 a_13773_6964# sg13cmos5l_and2_1_3.A VPWR.t938 VPWR.t2 sg13_lv_pmos ad=0.1596p pd=1.22u as=0.2856p ps=2.36u w=0.84u l=0.13u
X527 VPWR.t873 a_18363_6922# sg13cmos5l_dfrbpq_1_56.CLK VPWR.t2 sg13_lv_pmos ad=0.2128p pd=1.5u as=0.2128p ps=1.5u w=1.12u l=0.13u
X528 a_21719_7727# sg13cmos5l_buf_1_0.X.t12 VPWR.t3 VPWR.t2 sg13_lv_pmos ad=79.8f pd=0.8u as=0.36237p ps=2.605u w=0.42u l=0.13u
X529 sg13cmos5l_buf_8_10.A a_14235_6922# VGND.t332 VGND.t95 sg13_lv_nmos ad=0.1406p pd=1.12u as=0.1406p ps=1.12u w=0.74u l=0.13u
X530 a_16068_7236# a_16042_7141# VPWR.t748 VPWR.t2 sg13_lv_pmos ad=0.34p pd=2.68u as=0.36237p ps=2.605u w=1u l=0.13u
X531 a_27418_6132# sg13cmos5l_dlygate4sd3_1_39.A VGND.t45 VGND.t933 sg13_lv_nmos ad=0.1428p pd=1.52u as=79.8f ps=0.8u w=0.42u l=0.13u
X532 a_3680_5609# sg13cmos5l_dfrbpq_1_13.RESET_B.t15 VPWR.t535 VPWR.t7 sg13_lv_pmos ad=0.1596p pd=1.22u as=0.1918p ps=1.5u w=0.84u l=0.13u
X533 a_27195_3514# sg13cmos5l_buf_8_2.X VPWR.t710 VPWR.t10 sg13_lv_pmos ad=0.2128p pd=1.5u as=0.2128p ps=1.5u w=1.12u l=0.13u
X534 VGND.t293 sg13cmos5l_buf_1_4.X.t6 a_24996_3894# VGND.t1282 sg13_lv_nmos ad=0.1626p pd=1.415u as=60.89999f ps=0.71u w=0.42u l=0.13u
X535 VPWR.t730 sg13cmos5l_dfrbpq_1_0.D a_26135_1679# VPWR.t15 sg13_lv_pmos ad=0.1428p pd=1.52u as=79.8f ps=0.8u w=0.42u l=0.13u
X536 VPWR.t224 a_19055_3971# a_19722_4192# VPWR.t43 sg13_lv_pmos ad=0.2128p pd=1.5u as=0.3864p ps=2.93u w=1.12u l=0.13u
X537 a_24526_4923# a_24641_4922# VPWR.t227 VPWR.t43 sg13_lv_pmos ad=0.34p pd=2.68u as=0.2254p ps=1.53u w=1u l=0.5u
X538 a_3876_4212# a_3850_4117# VPWR.t781 VPWR.t43 sg13_lv_pmos ad=0.34p pd=2.68u as=0.36237p ps=2.605u w=1u l=0.13u
X539 a_18478_8619# a_18593_8620# VPWR.t866 VPWR.t0 sg13_lv_pmos ad=0.34p pd=2.68u as=0.2254p ps=1.53u w=1u l=0.5u
X540 VPWR.t784 sg13cmos5l_xnor2_1_5.A a_17100_2572# VPWR.t10 sg13_lv_pmos ad=0.4536p pd=2.76u as=0.1596p ps=1.22u w=0.84u l=0.13u
X541 sg13cmos5l_dfrbpq_1_46.CLK a_18922_7644# VPWR.t905 VPWR.t2 sg13_lv_pmos ad=0.2128p pd=1.5u as=0.2128p ps=1.5u w=1.12u l=0.13u
X542 a_10596_5419# a_10308_5724# a_10534_5419# VGND.t331 sg13_lv_nmos ad=0.1428p pd=1.52u as=37.8f ps=0.6u w=0.42u l=0.13u
X543 a_8759_1679# sg13cmos5l_dfrbpq_1_18.D a_9506_2070# VGND.t257 sg13_lv_nmos ad=0.1428p pd=1.52u as=60.89999f ps=0.71u w=0.42u l=0.13u
X544 VPWR.t700 sg13cmos5l_buf_8_3.A a_6250_2350# VPWR.t10 sg13_lv_pmos ad=0.2128p pd=1.5u as=0.2128p ps=1.5u w=1.12u l=0.13u
X545 a_15340_8430# a_15127_8394# VPWR.t1 VPWR.t0 sg13_lv_pmos ad=79.8f pd=0.8u as=1.8922p ps=12.27u w=0.42u l=0.13u
X546 a_15756_1060# sg13cmos5l_xnor2_1_6.Y VPWR.t214 VPWR.t15 sg13_lv_pmos ad=0.1596p pd=1.22u as=0.2891p ps=1.695u w=0.84u l=0.13u
X547 sg13cmos5l_dlygate4sd3_1_0.X a_27798_938# VGND.t176 VGND.t175 sg13_lv_nmos ad=0.2516p pd=2.16u as=0.1426p ps=1.16u w=0.74u l=0.13u
X548 a_7332_7684# a_7306_7648# VPWR.t778 VPWR.t2 sg13_lv_pmos ad=0.34p pd=2.68u as=0.36237p ps=2.605u w=1u l=0.13u
X549 VPWR.t893 sg13cmos5l_nor4_2_5.Y sg13cmos5l_xnor2_1_9.A VPWR.t2 sg13_lv_pmos ad=0.2128p pd=1.5u as=0.2128p ps=1.5u w=1.12u l=0.13u
X550 a_18363_6922# sg13cmos5l_buf_8_10.A VPWR.t967 VPWR.t2 sg13_lv_pmos ad=0.2128p pd=1.5u as=0.2128p ps=1.5u w=1.12u l=0.13u
X551 a_17604_3894# sg13cmos5l_nor3_1_0.A a_17510_3894# VGND.t641 sg13_lv_nmos ad=60.89999f pd=0.71u as=0.1428p ps=1.52u w=0.42u l=0.13u
X552 VPWR.t364 sg13cmos5l_dfrbpq_1_56.RESET_B a_15686_6606# VPWR.t7 sg13_lv_pmos ad=0.36237p pd=2.605u as=79.8f ps=0.8u w=0.42u l=0.13u
X553 a_19893_1679# sg13cmos5l_buf_1_1.X.t5 VPWR.t146 VPWR.t15 sg13_lv_pmos ad=0.147p pd=1.54u as=0.1563p ps=1.22u w=0.42u l=0.13u
X554 a_2054_8434# a_1784_8434# VPWR.t871 VPWR.t0 sg13_lv_pmos ad=0.34p pd=2.68u as=0.1523p ps=1.38u w=1u l=0.5u
X555 a_18387_4656# sg13cmos5l_nor4_2_1.A VPWR.t496 VPWR.t43 sg13_lv_pmos ad=0.1428p pd=1.375u as=0.2891p ps=1.695u w=1.12u l=0.13u
X556 a_20614_5081# sg13cmos5l_buf_1_4.X.t10 VGND.t133 VGND.t138 sg13_lv_nmos ad=37.8f pd=0.6u as=0.1701p ps=1.65u w=0.42u l=0.13u
X557 a_13745_3948# sg13cmos5l_xor2_1_2.A VGND.t316 VGND.t926 sg13_lv_nmos ad=0.17462p pd=1.185u as=0.374p ps=2.46u w=0.55u l=0.13u
X558 a_8582_4656# a_8312_4697# VPWR.t721 VPWR.t43 sg13_lv_pmos ad=0.34p pd=2.68u as=0.1523p ps=1.38u w=1u l=0.5u
X559 a_26770_870# sg13cmos5l_buf_1_4.X.t1 VGND.t176 VGND.t1289 sg13_lv_nmos ad=37.8f pd=0.6u as=79.8f ps=0.8u w=0.42u l=0.13u
X560 sg13cmos5l_dfrbpq_1_56.CLK a_18363_6922# VGND.t145 VGND.t985 sg13_lv_nmos ad=0.1406p pd=1.12u as=0.1406p ps=1.12u w=0.74u l=0.13u
X561 a_5558_883# a_4380_834# a_5162_1028# VGND.t80 sg13_lv_nmos ad=37.8f pd=0.6u as=0.1428p ps=1.52u w=0.42u l=0.13u
X562 a_24849_8752# sg13cmos5l_dfrbpq_1_37.D VPWR.t867 VPWR.t0 sg13_lv_pmos ad=0.1225p pd=1.245u as=0.36p ps=2.72u w=1u l=0.13u
X563 sg13cmos5l_dlygate4sd3_1_17.A a_27690_8728# VPWR.t286 VPWR.t0 sg13_lv_pmos ad=0.3808p pd=2.92u as=0.2128p ps=1.5u w=1.12u l=0.13u
X564 VPWR.t903 a_18922_7644# sg13cmos5l_dfrbpq_1_46.CLK VPWR.t2 sg13_lv_pmos ad=0.2128p pd=1.5u as=0.2128p ps=1.5u w=1.12u l=0.13u
X565 sg13cmos5l_buf_8_11.A a_23835_8050# VPWR.t6 VPWR.t2 sg13_lv_pmos ad=0.2128p pd=1.5u as=0.2128p ps=1.5u w=1.12u l=0.13u
X566 sg13cmos5l_nor3_1_1.C a_9558_3168# VPWR.t1080 VPWR.t10 sg13_lv_pmos ad=0.4256p pd=3u as=0.2254p ps=1.53u w=1.12u l=0.13u
X567 VGND.t65 VPWR.t8 VGND.t65 VGND.t64 sg13_lv_nmos ad=79.8f pd=0.8u as=0 ps=0 w=0.42u l=1u
X568 a_25476_3907# a_25707_4016# a_25162_4117# VGND.t784 sg13_lv_nmos ad=0.2373p pd=1.97u as=79.8f ps=0.8u w=0.42u l=0.13u
X569 a_18346_2605# a_18789_2361# a_18086_2382# VGND.t639 sg13_lv_nmos ad=79.8f pd=0.8u as=0.1296p ps=1.52u w=0.42u l=0.13u
X570 a_20388_4212# a_20907_4016# a_21647_3971# VGND.t202 sg13_lv_nmos ad=0.3473p pd=2.71u as=0.12665p ps=1.145u w=0.74u l=0.13u
X571 a_3590_8430# a_4395_8552# a_3850_8653# VPWR.t0 sg13_lv_pmos ad=0.1428p pd=1.52u as=79.8f ps=0.8u w=0.42u l=0.13u
X572 VPWR.t28 VGND.t393 VPWR.t28 VPWR.t15 sg13_lv_pmos ad=0.34p pd=2.68u as=0 ps=0 w=1u l=1u
X573 VPWR.t1293 sg13cmos5l_xnor2_1_4.A a_28524_3410# VPWR.t10 sg13_lv_pmos ad=0.4536p pd=2.76u as=0.1596p ps=1.22u w=0.84u l=0.13u
X574 VPWR.t319 a_5135_8507# a_5802_8728# VPWR.t0 sg13_lv_pmos ad=0.2128p pd=1.5u as=0.3864p ps=2.93u w=1.12u l=0.13u
X575 VPWR.t71 VGND.t861 VPWR.t69 VPWR.t10 sg13_lv_pmos ad=0.19p pd=1.38u as=0 ps=0 w=1u l=1u
X576 VGND.t145 a_18363_6922# sg13cmos5l_dfrbpq_1_56.CLK VGND.t982 sg13_lv_nmos ad=0.1406p pd=1.12u as=0.1406p ps=1.12u w=0.74u l=0.13u
X577 VPWR.t1271 sg13cmos5l_xnor2_1_0.Y a_2016_4209# VPWR.t43 sg13_lv_pmos ad=0.2891p pd=1.695u as=0.1596p ps=1.22u w=0.84u l=0.13u
X578 a_4164_3907# a_4395_4016# a_3850_4117# VGND.t347 sg13_lv_nmos ad=0.2373p pd=1.97u as=79.8f ps=0.8u w=0.42u l=0.13u
X579 VPWR.t6 a_23835_8050# sg13cmos5l_buf_8_11.A VPWR.t2 sg13_lv_pmos ad=0.2128p pd=1.5u as=0.2128p ps=1.5u w=1.12u l=0.13u
X580 a_17914_7644# sg13cmos5l_dfrbpq_1_52.Q VGND.t842 VGND.t0 sg13_lv_nmos ad=0.1428p pd=1.52u as=79.8f ps=0.8u w=0.42u l=0.13u
X581 sg13cmos5l_nor4_2_9.Y sg13cmos5l_nor4_2_9.D VGND.t52 VGND.t30 sg13_lv_nmos ad=0.1406p pd=1.12u as=0.3293p ps=1.63u w=0.74u l=0.13u
X582 VGND.t62 a_24881_8484# sg13cmos5l_xnor2_1_4.A VGND.t246 sg13_lv_nmos ad=0.3108p pd=2.32u as=0.1628p ps=1.18u w=0.74u l=0.13u
X583 sg13cmos5l_nor3_1_4.C a_15414_5474# VGND.t350 VGND.t626 sg13_lv_nmos ad=0.2516p pd=2.16u as=0.1426p ps=1.16u w=0.74u l=0.13u
X584 VPWR.t184 sg13cmos5l_dfrbpq_1_2.Q a_23576_1673# VPWR.t15 sg13_lv_pmos ad=0.1523p pd=1.38u as=0.1428p ps=1.52u w=0.42u l=0.13u
X585 a_7564_2070# a_7351_1596# VPWR.t105 VPWR.t15 sg13_lv_pmos ad=79.8f pd=0.8u as=1.50275p ps=9.57u w=0.42u l=0.13u
X586 VGND.t630 a_8842_6886# sg13cmos5l_dfrbpq_1_57.CLK VGND.t1069 sg13_lv_nmos ad=0.1406p pd=1.12u as=0.1406p ps=1.12u w=0.74u l=0.13u
X587 a_10702_6606# a_10943_6139# a_10231_6132# VGND.t582 sg13_lv_nmos ad=0.1428p pd=1.52u as=0.12665p ps=1.145u w=0.42u l=0.13u
X588 VPWR.t191 sg13cmos5l_nand3_1_0.B sg13cmos5l_nand3_1_0.Y VPWR.t15 sg13_lv_pmos ad=0.2128p pd=1.5u as=0.2128p ps=1.5u w=1.12u l=0.13u
X589 a_5954_2382# sg13cmos5l_dfrbpq_1_21.RESET_B.t1 VGND.t205 VGND.t731 sg13_lv_nmos ad=60.89999f pd=0.71u as=0.1626p ps=1.415u w=0.42u l=0.13u
X590 VGND.t93 sg13cmos5l_dfrbpq_1_56.RESET_B a_15434_8430# VGND.t821 sg13_lv_nmos ad=79.8f pd=0.8u as=37.8f ps=0.6u w=0.42u l=0.13u
X591 VPWR.t241 VGND.t278 VPWR.t240 VPWR.t7 sg13_lv_pmos ad=0.34p pd=2.68u as=0 ps=0 w=1u l=1u
X592 a_14938_4620# sg13cmos5l_dfrbpq_1_55.Q VGND.t350 VGND.t373 sg13_lv_nmos ad=0.1428p pd=1.52u as=79.8f ps=0.8u w=0.42u l=0.13u
X593 VGND.t324 sg13cmos5l_dfrbpq_1_55.RESET_B a_14090_2070# VGND.t323 sg13_lv_nmos ad=79.8f pd=0.8u as=37.8f ps=0.6u w=0.42u l=0.13u
X594 a_4164_3907# a_3876_4212# a_4102_3907# VGND.t188 sg13_lv_nmos ad=0.1428p pd=1.52u as=37.8f ps=0.6u w=0.42u l=0.13u
X595 a_20676_6593# a_20907_6179# a_20362_6136# VGND.t743 sg13_lv_nmos ad=0.2373p pd=1.97u as=79.8f ps=0.8u w=0.42u l=0.13u
X596 VPWR.t360 a_14938_4620# a_14657_4922# VPWR.t43 sg13_lv_pmos ad=0.1523p pd=1.38u as=0.34p ps=2.68u w=1u l=0.5u
X597 VGND.t15 a_1870_1899# sg13cmos5l_xnor2_1_6.B VGND.t473 sg13_lv_nmos ad=0.1426p pd=1.16u as=0.2516p ps=2.16u w=0.74u l=0.13u
X598 VPWR.t2 a_6693_6897# a_6795_7040# VPWR.t2 sg13_lv_pmos ad=1.34765p pd=8.56u as=0.3864p ps=2.93u w=1.12u l=0.13u
X599 sg13cmos5l_nor4_2_9.Y sg13cmos5l_dlygate4sd3_1_19.X VGND.t52 VGND.t30 sg13_lv_nmos ad=0.1406p pd=1.12u as=0.1406p ps=1.12u w=0.74u l=0.13u
X600 a_18826_4620# sg13cmos5l_buf_8_2.X VPWR.t712 VPWR.t43 sg13_lv_pmos ad=0.3808p pd=2.92u as=0.2128p ps=1.5u w=1.12u l=0.13u
X601 VGND.t77 a_18789_2361# a_18891_2504# VGND.t399 sg13_lv_nmos ad=3.25012p pd=20.49u as=0.2516p ps=2.16u w=0.74u l=0.13u
X602 a_10308_5724# a_10282_5629# VPWR.t677 VPWR.t7 sg13_lv_pmos ad=0.34p pd=2.68u as=0.36237p ps=2.605u w=1u l=0.13u
X603 a_21742_1899# a_21857_1898# VPWR.t257 VPWR.t15 sg13_lv_pmos ad=0.34p pd=2.68u as=0.2254p ps=1.53u w=1u l=0.5u
X604 a_6071_7727# sg13cmos5l_dfrbpq_1_21.RESET_B.t11 VPWR.t672 VPWR.t2 sg13_lv_pmos ad=79.8f pd=0.8u as=0.36237p ps=2.605u w=0.42u l=0.13u
X605 a_11835_7727# a_10943_7651# a_11733_7727# VPWR.t2 sg13_lv_pmos ad=63f pd=0.72u as=79.8f ps=0.8u w=0.42u l=0.13u
X606 VGND.t145 a_18778_6132# a_18497_6434# VGND.t521 sg13_lv_nmos ad=79.8f pd=0.8u as=0.1428p ps=1.52u w=0.42u l=0.5u
X607 a_11639_4703# sg13cmos5l_dfrbpq_1_57.D a_12386_5094# VGND.t436 sg13_lv_nmos ad=0.1428p pd=1.52u as=60.89999f ps=0.71u w=0.42u l=0.13u
X608 a_2054_3144# a_1784_3185# VPWR.t580 VPWR.t10 sg13_lv_pmos ad=0.34p pd=2.68u as=0.1523p ps=1.38u w=1u l=0.5u
X609 VPWR.t43 a_19312_4114# a_19257_4209# VPWR.t43 sg13_lv_pmos ad=1.3927p pd=8.9u as=93.45f ps=0.865u w=0.42u l=0.13u
X610 a_19823_3505# a_18981_3155# a_19729_3505# VGND.t1641 sg13_lv_nmos ad=0.12665p pd=1.145u as=0.1428p ps=1.52u w=0.42u l=0.13u
X611 sg13cmos5l_buf_8_2.X a_21435_3514# VGND.t54 VGND.t53 sg13_lv_nmos ad=0.1406p pd=1.12u as=0.1406p ps=1.12u w=0.74u l=0.13u
X612 sg13cmos5l_dfrbpq_1_21.CLK a_6250_3108# VPWR.t629 VPWR.t10 sg13_lv_pmos ad=0.2128p pd=1.5u as=0.2128p ps=1.5u w=1.12u l=0.13u
X613 a_15850_3862# osc VGND.t50 VGND.t1446 sg13_lv_nmos ad=0.1406p pd=1.12u as=0.1406p ps=1.12u w=0.74u l=0.13u
X614 a_22466_6918# sg13cmos5l_buf_1_0.X.t10 VGND.t65 VGND.t64 sg13_lv_nmos ad=60.89999f pd=0.71u as=0.1626p ps=1.415u w=0.42u l=0.13u
X615 sg13cmos5l_buf_1_0.A a_1384_8468# VGND.t121 VGND.t120 sg13_lv_nmos ad=0.2886p pd=2.26u as=0.14875p ps=1.16u w=0.74u l=0.13u
X616 VGND.t30 sg13cmos5l_nand3_1_1.Y a_2165_5410# VGND.t195 sg13_lv_nmos ad=0.1898p pd=1.36u as=0.2516p ps=2.16u w=0.74u l=0.13u
X617 a_20805_8409# sg13cmos5l_dfrbpq_1_46.CLK VGND.t0 VGND.t23 sg13_lv_nmos ad=0.2516p pd=2.16u as=3.2221p ps=20.04u w=0.74u l=0.13u
X618 VPWR.t351 a_5301_1028# a_4380_834# VPWR.t15 sg13_lv_pmos ad=0.36237p pd=2.605u as=0.34p ps=2.68u w=1u l=0.13u
X619 a_18086_2382# a_18891_2504# a_18346_2605# VPWR.t10 sg13_lv_pmos ad=0.1428p pd=1.52u as=79.8f ps=0.8u w=0.42u l=0.13u
X620 VPWR.t43 a_25605_3873# a_25707_4016# VPWR.t43 sg13_lv_pmos ad=1.3927p pd=8.9u as=0.3864p ps=2.93u w=1.12u l=0.13u
X621 VGND.t0 sg13cmos5l_dfrbpq_1_32.CLK a_7103_8700# VGND.t1211 sg13_lv_nmos ad=3.2221p pd=20.04u as=0.2516p ps=2.16u w=0.74u l=0.13u
X622 VGND.t83 a_11824_5626# a_11473_5483# VGND.t1183 sg13_lv_nmos ad=79.8f pd=0.8u as=0.1428p ps=1.52u w=0.42u l=0.13u
X623 a_17556_2428# sg13cmos5l_xnor2_1_2.Y a_17100_2572# VGND.t147 sg13_lv_nmos ad=78.39999f pd=0.885u as=0.2176p ps=1.96u w=0.64u l=0.13u
X624 a_7954_6918# sg13cmos5l_dfrbpq_1_58.RESET_B VGND.t418 VGND.t939 sg13_lv_nmos ad=37.8f pd=0.6u as=79.8f ps=0.8u w=0.42u l=0.13u
X625 a_16320_1671# sg13cmos5l_xnor2_1_2.B a_16283_1980# VGND.t155 sg13_lv_nmos ad=0.2176p pd=1.96u as=78.39999f ps=0.885u w=0.64u l=0.13u
X626 a_26416_3386# sg13cmos5l_buf_1_4.X.t3 VPWR.t91 VPWR.t10 sg13_lv_pmos ad=79.8f pd=0.8u as=1.43285p ps=9.125u w=0.42u l=0.13u
X627 a_6698_8430# a_6391_8394# a_6604_8430# VGND.t703 sg13_lv_nmos ad=37.8f pd=0.6u as=0.1428p ps=1.52u w=0.42u l=0.13u
X628 VGND.t54 sg13cmos5l_and2_1_0.X a_21435_3514# VGND.t53 sg13_lv_nmos ad=0.1406p pd=1.12u as=0.2553p ps=2.17u w=0.74u l=0.13u
X629 VPWR.t627 a_6250_3108# sg13cmos5l_dfrbpq_1_21.CLK VPWR.t10 sg13_lv_pmos ad=0.2128p pd=1.5u as=0.2128p ps=1.5u w=1.12u l=0.13u
X630 a_24969_6215# a_24612_6172# VPWR.t221 VPWR.t7 sg13_lv_pmos ad=63f pd=0.72u as=0.1563p ps=1.22u w=0.42u l=0.13u
X631 a_7995_1261# a_7103_1140# a_7893_1028# VPWR.t15 sg13_lv_pmos ad=63f pd=0.72u as=79.8f ps=0.8u w=0.42u l=0.13u
X632 a_8073_2773# a_7716_2700# VPWR.t559 VPWR.t10 sg13_lv_pmos ad=63f pd=0.72u as=0.1563p ps=1.22u w=0.42u l=0.13u
X633 a_17250_3902# sg13cmos5l_nand3_1_1.B a_17148_3902# VGND.t595 sg13_lv_nmos ad=0.1406p pd=1.12u as=0.1406p ps=1.12u w=0.74u l=0.13u
X634 VPWR.t1333 a_9915_3898# sg13cmos5l_buf_8_3.A VPWR.t43 sg13_lv_pmos ad=0.2128p pd=1.5u as=0.2128p ps=1.5u w=1.12u l=0.13u
X635 a_14186_7680# sg13cmos5l_dfrbpq_1_57.D sg13cmos5l_nand3_1_1.A VPWR.t2 sg13_lv_pmos ad=0.3808p pd=2.92u as=0.2128p ps=1.5u w=1.12u l=0.13u
X636 sg13cmos5l_and2_1_4.X a_13773_6964# VPWR.t140 VPWR.t2 sg13_lv_pmos ad=0.3808p pd=2.92u as=0.1918p ps=1.5u w=1.12u l=0.13u
X637 sg13cmos5l_dlygate4sd3_1_10.A a_22314_4656# VGND.t143 VGND.t142 sg13_lv_nmos ad=0.2516p pd=2.16u as=0.1406p ps=1.12u w=0.74u l=0.13u
X638 a_1870_2571# a_1985_2572# VGND.t15 VGND.t274 sg13_lv_nmos ad=0.1428p pd=1.52u as=0.1426p ps=1.16u w=0.42u l=0.5u
X639 a_25317_3155# sg13cmos5l_dfrbpq_1_0.CLK VPWR.t91 VPWR.t10 sg13_lv_pmos ad=0.4088p pd=2.97u as=1.4003p ps=8.92u w=1.12u l=0.13u
X640 a_24900_6593# a_24612_6172# a_24838_6593# VGND.t485 sg13_lv_nmos ad=0.1428p pd=1.52u as=37.8f ps=0.6u w=0.42u l=0.13u
X641 a_26098_2382# sg13cmos5l_buf_1_1.X.t7 VGND.t13 VGND.t1293 sg13_lv_nmos ad=37.8f pd=0.6u as=79.8f ps=0.8u w=0.42u l=0.13u
X642 VPWR.t91 a_18981_3155# a_19083_3155# VPWR.t10 sg13_lv_pmos ad=1.43285p pd=9.125u as=0.3864p ps=2.93u w=1.12u l=0.13u
X643 a_26793_7309# a_26436_7236# VPWR.t401 VPWR.t2 sg13_lv_pmos ad=63f pd=0.72u as=0.1563p ps=1.22u w=0.42u l=0.13u
X644 VGND.t396 a_15119_2459# a_15786_2680# VGND.t147 sg13_lv_nmos ad=0.1406p pd=1.12u as=0.2516p ps=2.16u w=0.74u l=0.13u
X645 VPWR.t91 a_14277_2361# a_14379_2504# VPWR.t10 sg13_lv_pmos ad=1.43285p pd=9.125u as=0.3864p ps=2.93u w=1.12u l=0.13u
X646 a_10444_5094# a_10231_4620# VPWR.t43 VPWR.t43 sg13_lv_pmos ad=79.8f pd=0.8u as=1.3927p ps=8.9u w=0.42u l=0.13u
X647 a_15322_838# sg13cmos5l_dfrbpq_1_11.Q VGND.t411 VGND.t1610 sg13_lv_nmos ad=0.1428p pd=1.52u as=79.8f ps=0.8u w=0.42u l=0.13u
X648 VPWR.t163 sg13cmos5l_buf_1_5.A a_8776_5444# VPWR.t7 sg13_lv_pmos ad=0.2114p pd=1.54u as=0.2856p ps=2.36u w=0.84u l=0.13u
X649 VGND.t50 sg13cmos5l_buf_8_5.A a_9915_3898# VGND.t1328 sg13_lv_nmos ad=0.1406p pd=1.12u as=0.2553p ps=2.17u w=0.74u l=0.13u
X650 VPWR.t642 a_6272_8605# sg13cmos5l_dlygate4sd3_1_34.A VPWR.t0 sg13_lv_pmos ad=0.2128p pd=1.5u as=0.3808p ps=2.92u w=1.12u l=0.13u
X651 a_10112_6455# a_10231_6132# VGND.t558 VGND.t1631 sg13_lv_nmos ad=0.2516p pd=2.16u as=0.1406p ps=1.12u w=0.74u l=0.13u
X652 VGND.t77 a_18272_1919# sg13cmos5l_dfrbpq_1_3.Q VGND.t1606 sg13_lv_nmos ad=0.1406p pd=1.12u as=0.2516p ps=2.16u w=0.74u l=0.13u
X653 VGND.t861 VPWR.t1455 VGND.t861 VGND.t1505 sg13_lv_nmos ad=0.1428p pd=1.52u as=0 ps=0 w=0.42u l=1u
X654 VGND.t664 a_7594_5374# sg13cmos5l_buf_8_4.A VGND.t1161 sg13_lv_nmos ad=0.1406p pd=1.12u as=0.1406p ps=1.12u w=0.74u l=0.13u
X655 VPWR.t866 a_18478_8619# sg13cmos5l_xnor2_1_2.B VPWR.t0 sg13_lv_pmos ad=0.2254p pd=1.53u as=0.4256p ps=3u w=1.12u l=0.13u
X656 VGND.t558 sg13cmos5l_dfrbpq_1_57.RESET_B.t8 a_10116_6918# VGND.t654 sg13_lv_nmos ad=0.1626p pd=1.415u as=60.89999f ps=0.71u w=0.42u l=0.13u
X657 a_15119_2459# a_14277_2361# a_13860_2700# VPWR.t10 sg13_lv_pmos ad=0.2048p pd=1.63u as=0.34p ps=2.68u w=1u l=0.13u
X658 a_17488_6410# sg13cmos5l_dfrbpq_1_56.RESET_B VPWR.t7 VPWR.t7 sg13_lv_pmos ad=79.8f pd=0.8u as=1.42587p ps=9.11u w=0.42u l=0.13u
X659 a_20196_5094# sg13cmos5l_nor3_1_0.C a_20102_5094# VGND.t289 sg13_lv_nmos ad=60.89999f pd=0.71u as=0.1428p ps=1.52u w=0.42u l=0.13u
X660 a_25449_1261# a_25092_1188# VPWR.t329 VPWR.t15 sg13_lv_pmos ad=63f pd=0.72u as=0.1563p ps=1.22u w=0.42u l=0.13u
X661 VPWR.t105 sg13cmos5l_dfrbpq_1_2.CLK a_19103_1603# VPWR.t15 sg13_lv_pmos ad=1.46697p pd=9.345u as=0.4088p ps=2.97u w=1.12u l=0.13u
X662 VGND.t0 sg13cmos5l_dfrbpq_1_57.CLK a_10943_7651# VGND.t1099 sg13_lv_nmos ad=3.2221p pd=20.04u as=0.2516p ps=2.16u w=0.74u l=0.13u
X663 a_20362_5629# a_20805_5385# a_20745_5797# VPWR.t7 sg13_lv_pmos ad=79.8f pd=0.8u as=63f ps=0.72u w=0.42u l=0.13u
X664 VPWR.t227 a_23846_4656# a_23958_4680# VPWR.t43 sg13_lv_pmos ad=0.2254p pd=1.53u as=0.34p ps=2.68u w=1u l=0.5u
X665 a_5223_7767# a_5375_7651# VPWR.t2 VPWR.t2 sg13_lv_pmos ad=0.3864p pd=2.93u as=1.34765p ps=8.56u w=1.12u l=0.13u
X666 a_15878_5406# sg13cmos5l_nor3_1_4.C VPWR.t1269 VPWR.t7 sg13_lv_pmos ad=79.8f pd=0.8u as=0.1428p ps=1.52u w=0.42u l=0.13u
X667 a_10812_5017# a_10943_4627# a_10231_4620# VPWR.t43 sg13_lv_pmos ad=0.34p pd=2.68u as=0.2048p ps=1.63u w=1u l=0.13u
X668 a_20782_8118# a_20524_8118# VGND.t141 VGND.t140 sg13_lv_nmos ad=0.1428p pd=1.52u as=79.8f ps=0.8u w=0.42u l=0.13u
X669 a_10282_7141# a_10725_6897# a_10022_6918# VGND.t654 sg13_lv_nmos ad=79.8f pd=0.8u as=0.1296p ps=1.52u w=0.42u l=0.13u
X670 a_5024_5581# a_5143_5370# VGND.t52 VGND.t1323 sg13_lv_nmos ad=0.2516p pd=2.16u as=0.1406p ps=1.12u w=0.74u l=0.13u
X671 a_10308_1188# a_10827_992# a_11567_947# VGND.t169 sg13_lv_nmos ad=0.3473p pd=2.71u as=0.12665p ps=1.145u w=0.74u l=0.13u
X672 a_16389_6179# sg13cmos5l_dfrbpq_1_56.CLK VPWR.t7 VPWR.t7 sg13_lv_pmos ad=0.4088p pd=2.97u as=1.42587p ps=9.11u w=1.12u l=0.13u
X673 a_1436_5704# sg13cmos5l_nor4_2_9.D VPWR.t638 VPWR.t7 sg13_lv_pmos ad=0.2128p pd=1.5u as=0.2128p ps=1.5u w=1.12u l=0.13u
X674 a_21904_4114# a_21647_3971# a_22066_3894# VGND.t202 sg13_lv_nmos ad=0.1428p pd=1.52u as=37.8f ps=0.6u w=0.42u l=0.13u
X675 VGND.t280 sg13cmos5l_nor3_1_2.B sg13cmos5l_nor3_1_2.Y VGND.t451 sg13_lv_nmos ad=0.1463p pd=1.15u as=0.1694p ps=1.21u w=0.77u l=0.13u
X676 VPWR.t1 sg13cmos5l_dfrbpq_1_56.CLK a_15839_8700# VPWR.t0 sg13_lv_pmos ad=1.8922p pd=12.27u as=0.4088p ps=2.97u w=1.12u l=0.13u
X677 a_25188_4212# a_25707_4016# a_26447_3971# VGND.t785 sg13_lv_nmos ad=0.3473p pd=2.71u as=0.12665p ps=1.145u w=0.74u l=0.13u
X678 sg13cmos5l_dfrbpq_1_57.D a_13974_4680# VPWR.t601 VPWR.t43 sg13_lv_pmos ad=0.4256p pd=3u as=0.2254p ps=1.53u w=1.12u l=0.13u
X679 a_15108_7684# a_15627_7691# a_16367_8041# VGND.t442 sg13_lv_nmos ad=0.3473p pd=2.71u as=0.12665p ps=1.145u w=0.74u l=0.13u
X680 VPWR.t1015 a_18826_4620# sg13cmos5l_dfrbpq_1_2.CLK VPWR.t43 sg13_lv_pmos ad=0.2128p pd=1.5u as=0.2128p ps=1.5u w=1.12u l=0.13u
X681 VPWR.t182 VGND.t17 VPWR.t195 VPWR.t15 sg13_lv_pmos ad=0.34p pd=2.68u as=0 ps=0 w=1u l=1u
X682 a_11639_3191# a_10943_3115# a_11733_3191# VGND.t694 sg13_lv_nmos ad=0.1296p pd=1.52u as=79.8f ps=0.8u w=0.42u l=0.13u
X683 a_10231_2346# a_10791_2600# a_10812_2346# VGND.t1554 sg13_lv_nmos ad=0.12665p pd=1.145u as=0.3473p ps=2.71u w=0.74u l=0.13u
X684 VPWR.t91 a_4293_3155# a_4395_3155# VPWR.t10 sg13_lv_pmos ad=1.43285p pd=9.125u as=0.3864p ps=2.93u w=1.12u l=0.13u
X685 VGND.t332 sg13cmos5l_dlygate4sd3_1_28.X sg13cmos5l_nand3_1_1.B VGND.t95 sg13_lv_nmos ad=0.1406p pd=1.12u as=0.1406p ps=1.12u w=0.74u l=0.13u
X686 VGND.t50 sg13cmos5l_dfrbpq_1_3.Q a_17432_3185# VGND.t1429 sg13_lv_nmos ad=79.8f pd=0.8u as=0.1428p ps=1.52u w=0.42u l=0.13u
X687 sg13cmos5l_nor3_1_0.Y sg13cmos5l_nor3_1_0.C a_17655_1168# VPWR.t15 sg13_lv_pmos ad=0.3808p pd=2.92u as=0.2128p ps=1.5u w=1.12u l=0.13u
X688 a_1265_5460# sg13cmos5l_dlygate4sd3_1_19.X VGND.t30 VGND.t696 sg13_lv_nmos ad=0.17462p pd=1.185u as=0.374p ps=2.46u w=0.55u l=0.13u
X689 a_27952_7138# sg13cmos5l_dfrbpq_1_53.RESET_B.t5 VPWR.t2 VPWR.t2 sg13_lv_pmos ad=79.8f pd=0.8u as=1.31957p ps=8.38u w=0.42u l=0.13u
X690 VPWR.t16 a_2054_874# a_2166_938# VPWR.t15 sg13_lv_pmos ad=0.2254p pd=1.53u as=0.34p ps=2.68u w=1u l=0.5u
X691 VGND.t115 sg13cmos5l_dfrbpq_1_13.RESET_B.t10 a_7658_2070# VGND.t817 sg13_lv_nmos ad=79.8f pd=0.8u as=37.8f ps=0.6u w=0.42u l=0.13u
X692 sg13cmos5l_buf_8_4.A a_7594_5374# VPWR.t1033 VPWR.t7 sg13_lv_pmos ad=0.2128p pd=1.5u as=0.2128p ps=1.5u w=1.12u l=0.13u
X693 sg13cmos5l_dfrbpq_1_0.D a_28374_1656# VPWR.t197 VPWR.t15 sg13_lv_pmos ad=0.4256p pd=3u as=0.2254p ps=1.53u w=1.12u l=0.13u
X694 VGND.t77 sg13cmos5l_buf_1_1.X.t10 a_18180_2382# VGND.t444 sg13_lv_nmos ad=0.1626p pd=1.415u as=60.89999f ps=0.71u w=0.42u l=0.13u
X695 a_14186_7680# sg13cmos5l_xor2_1_2.A a_13888_7680# VPWR.t2 sg13_lv_pmos ad=0.2128p pd=1.5u as=0.2128p ps=1.5u w=1.12u l=0.13u
X696 a_15946_6136# a_16389_6179# a_15686_6606# VGND.t46 sg13_lv_nmos ad=79.8f pd=0.8u as=0.1296p ps=1.52u w=0.42u l=0.13u
X697 a_25764_4660# a_25738_4624# VPWR.t311 VPWR.t43 sg13_lv_pmos ad=0.34p pd=2.68u as=0.36237p ps=2.605u w=1u l=0.13u
X698 sg13cmos5l_dfrbpq_1_52.Q a_17034_7680# VPWR.t413 VPWR.t2 sg13_lv_pmos ad=0.3808p pd=2.92u as=0.2128p ps=1.5u w=1.12u l=0.13u
X699 a_10231_2346# a_10791_2600# a_10702_2697# VPWR.t10 sg13_lv_pmos ad=0.2048p pd=1.63u as=93.45f ps=0.865u w=0.42u l=0.13u
X700 VGND.t1014 en[1] a_9640_7680# VGND.t1449 sg13_lv_nmos ad=0.14875p pd=1.16u as=0.187p ps=1.78u w=0.55u l=0.13u
X701 VPWR.t79 sg13cmos5l_nor4_2_1.A a_21270_2680# VPWR.t10 sg13_lv_pmos ad=0.3864p pd=2.93u as=0.2128p ps=1.5u w=1.12u l=0.13u
X702 a_24614_3582# sg13cmos5l_nor4_2_0.C VPWR.t659 VPWR.t10 sg13_lv_pmos ad=79.8f pd=0.8u as=0.1428p ps=1.52u w=0.42u l=0.13u
X703 VGND.t40 VPWR.t1473 VGND.t40 VGND.t1461 sg13_lv_nmos ad=0.1428p pd=1.52u as=0 ps=0 w=0.42u l=1u
X704 a_25066_1093# a_25509_849# a_24806_870# VGND.t328 sg13_lv_nmos ad=79.8f pd=0.8u as=0.1296p ps=1.52u w=0.42u l=0.13u
X705 a_1870_7947# a_1985_7946# VGND.t121 VGND.t459 sg13_lv_nmos ad=0.1428p pd=1.52u as=0.1426p ps=1.16u w=0.42u l=0.5u
X706 VPWR.t916 sg13cmos5l_dlygate4sd3_1_30.A a_3896_6209# VPWR.t7 sg13_lv_pmos ad=0.1523p pd=1.38u as=0.1428p ps=1.52u w=0.42u l=0.13u
X707 a_8004_2395# a_7716_2700# a_7942_2395# VGND.t612 sg13_lv_nmos ad=0.1428p pd=1.52u as=37.8f ps=0.6u w=0.42u l=0.13u
X708 a_19716_883# a_19947_992# a_19402_1093# VGND.t1149 sg13_lv_nmos ad=0.2373p pd=1.97u as=79.8f ps=0.8u w=0.42u l=0.13u
X709 a_25257_3191# a_24900_3148# VPWR.t1049 VPWR.t10 sg13_lv_pmos ad=63f pd=0.72u as=0.1563p ps=1.22u w=0.42u l=0.13u
X710 sg13cmos5l_dlygate4sd3_1_51.X a_23958_4680# VGND.t203 VGND.t142 sg13_lv_nmos ad=0.2516p pd=2.16u as=0.1426p ps=1.16u w=0.74u l=0.13u
X711 a_5230_7107# a_5345_7108# VPWR.t849 VPWR.t2 sg13_lv_pmos ad=0.34p pd=2.68u as=0.2254p ps=1.53u w=1u l=0.5u
X712 a_20102_5406# sg13cmos5l_dfrbpq_1_46.D VPWR.t299 VPWR.t7 sg13_lv_pmos ad=79.8f pd=0.8u as=0.1428p ps=1.52u w=0.42u l=0.13u
X713 VGND.t411 a_15322_838# a_15041_1060# VGND.t1123 sg13_lv_nmos ad=79.8f pd=0.8u as=0.1428p ps=1.52u w=0.42u l=0.5u
X714 a_10534_5419# sg13cmos5l_dfrbpq_1_57.RESET_B.t3 VGND.t739 VGND.t331 sg13_lv_nmos ad=37.8f pd=0.6u as=0.1701p ps=1.65u w=0.42u l=0.13u
X715 VPWR.t43 sg13cmos5l_dfrbpq_1_58.RESET_B a_5164_5094# VPWR.t43 sg13_lv_pmos ad=1.3927p pd=8.9u as=79.8f ps=0.8u w=0.42u l=0.13u
X716 VPWR.t691 a_7534_4923# sg13cmos5l_xnor2_1_12.B VPWR.t43 sg13_lv_pmos ad=0.2254p pd=1.53u as=0.4256p ps=3u w=1.12u l=0.13u
X717 sg13cmos5l_dlygate4sd3_1_28.X a_9558_6192# VGND.t630 VGND.t1142 sg13_lv_nmos ad=0.2516p pd=2.16u as=0.1426p ps=1.16u w=0.74u l=0.13u
X718 VGND.t133 a_18572_5370# sg13cmos5l_dfrbpq_1_56.RESET_B VGND.t1367 sg13_lv_nmos ad=0.14875p pd=1.16u as=0.2886p ps=2.26u w=0.74u l=0.13u
X719 a_20972_2680# sg13cmos5l_dfrbpq_1_2.D a_21270_2680# VPWR.t10 sg13_lv_pmos ad=0.3808p pd=2.92u as=0.2128p ps=1.5u w=1.12u l=0.13u
X720 a_19888_2602# sg13cmos5l_buf_1_1.X.t9 VPWR.t91 VPWR.t10 sg13_lv_pmos ad=79.8f pd=0.8u as=1.4003p ps=8.92u w=0.42u l=0.13u
X721 a_6951_8648# a_7103_8700# VPWR.t1 VPWR.t0 sg13_lv_pmos ad=0.3864p pd=2.93u as=1.8922p ps=12.27u w=1.12u l=0.13u
X722 a_24170_8728# sg13cmos5l_dlygate4sd3_1_55.X sg13cmos5l_nand3_1_2.A VPWR.t0 sg13_lv_pmos ad=0.3808p pd=2.92u as=0.2128p ps=1.5u w=1.12u l=0.13u
X723 VGND.t608 sg13cmos5l_dfrbpq_1_13.RESET_B.t9 a_9110_2057# VGND.t870 sg13_lv_nmos ad=0.1701p pd=1.65u as=37.8f ps=0.6u w=0.42u l=0.13u
X724 a_27686_874# a_27416_874# VGND.t176 VGND.t309 sg13_lv_nmos ad=0.1428p pd=1.52u as=79.8f ps=0.8u w=0.42u l=0.5u
X725 VGND.t30 a_20805_4667# a_20907_4667# VGND.t1546 sg13_lv_nmos ad=3.5351p pd=22.08u as=0.2516p ps=2.16u w=0.74u l=0.13u
X726 a_14822_8118# a_15627_7691# a_15082_7648# VPWR.t2 sg13_lv_pmos ad=0.1428p pd=1.52u as=79.8f ps=0.8u w=0.42u l=0.13u
X727 VGND.t332 a_14926_6435# sg13cmos5l_xor2_1_2.B VGND.t95 sg13_lv_nmos ad=0.1426p pd=1.16u as=0.2516p ps=2.16u w=0.74u l=0.13u
X728 VPWR.t43 a_21904_4114# a_21849_4209# VPWR.t43 sg13_lv_pmos ad=1.3927p pd=8.9u as=93.45f ps=0.865u w=0.42u l=0.13u
X729 a_18380_7644# en[2] VPWR.t455 VPWR.t2 sg13_lv_pmos ad=0.2856p pd=2.36u as=0.2114p ps=1.54u w=0.84u l=0.13u
X730 VPWR.t2 a_10725_6897# a_10827_7040# VPWR.t2 sg13_lv_pmos ad=1.34765p pd=8.56u as=0.3864p ps=2.93u w=1.12u l=0.13u
X731 a_16078_4779# a_15820_5094# VPWR.t43 VPWR.t43 sg13_lv_pmos ad=93.45f pd=0.865u as=1.3927p ps=8.9u w=0.42u l=0.13u
X732 a_10791_3231# a_10943_3115# VGND.t50 VGND.t1146 sg13_lv_nmos ad=0.2516p pd=2.16u as=3.8943p ps=24.355u w=0.74u l=0.13u
X733 sg13cmos5l_nor3_1_4.Y sg13cmos5l_nor3_1_4.C VGND.t316 VGND.t1426 sg13_lv_nmos ad=0.2618p pd=2.22u as=0.1463p ps=1.15u w=0.77u l=0.13u
X734 VPWR.t263 a_20192_7093# sg13cmos5l_dlygate4sd3_1_6.A VPWR.t2 sg13_lv_pmos ad=0.2128p pd=1.5u as=0.3808p ps=2.92u w=1.12u l=0.13u
X735 a_7858_6606# sg13cmos5l_dfrbpq_1_58.RESET_B VGND.t418 VGND.t934 sg13_lv_nmos ad=37.8f pd=0.6u as=79.8f ps=0.8u w=0.42u l=0.13u
X736 VPWR.t8 VGND.t65 VPWR.t8 VPWR.t7 sg13_lv_pmos ad=0.19p pd=1.38u as=0 ps=0 w=1u l=1u
X737 a_23872_8728# sg13cmos5l_dfrbpq_1_37.D a_24170_8728# VPWR.t0 sg13_lv_pmos ad=0.3808p pd=2.92u as=0.2128p ps=1.5u w=1.12u l=0.13u
X738 VPWR.t4 VGND.t65 VPWR.t3 VPWR.t2 sg13_lv_pmos ad=0.34p pd=2.68u as=0 ps=0 w=1u l=1u
X739 VGND.t25 sg13cmos5l_dfrbpq_1_58.D sg13cmos5l_nor4_2_5.Y VGND.t1007 sg13_lv_nmos ad=0.2553p pd=2.17u as=0.1406p ps=1.12u w=0.74u l=0.13u
X740 VPWR.t816 sg13cmos5l_dlygate4sd3_1_33.A a_3608_7721# VPWR.t2 sg13_lv_pmos ad=0.1523p pd=1.38u as=0.1428p ps=1.52u w=0.42u l=0.13u
X741 a_20524_8118# a_20311_7644# VPWR.t2 VPWR.t2 sg13_lv_pmos ad=79.8f pd=0.8u as=1.34765p ps=8.56u w=0.42u l=0.13u
X742 VPWR.t90 sg13cmos5l_dfrbpq_1_55.RESET_B a_13834_2605# VPWR.t10 sg13_lv_pmos ad=0.1563p pd=1.22u as=0.147p ps=1.54u w=0.42u l=0.13u
X743 VGND.t478 a_10112_2557# sg13cmos5l_dfrbpq_1_22.Q VGND.t1547 sg13_lv_nmos ad=0.1406p pd=1.12u as=0.2516p ps=2.16u w=0.74u l=0.13u
X744 a_13713_4216# sg13cmos5l_xor2_1_2.A VPWR.t829 VPWR.t43 sg13_lv_pmos ad=0.1225p pd=1.245u as=0.36p ps=2.72u w=1u l=0.13u
X745 a_1979_6964# sg13cmos5l_xnor2_1_9.A VGND.t280 VGND.t1023 sg13_lv_nmos ad=78.39999f pd=0.885u as=0.2272p ps=1.99u w=0.64u l=0.13u
X746 a_5207_1261# sg13cmos5l_dlygate4sd3_1_22.X a_5954_870# VGND.t1199 sg13_lv_nmos ad=0.1428p pd=1.52u as=60.89999f ps=0.71u w=0.42u l=0.13u
X747 VPWR.t429 sg13cmos5l_xnor2_1_2.A a_11639_6215# VPWR.t7 sg13_lv_pmos ad=0.1428p pd=1.52u as=79.8f ps=0.8u w=0.42u l=0.13u
X748 a_7932_1993# a_8063_1603# a_7351_1596# VPWR.t15 sg13_lv_pmos ad=0.34p pd=2.68u as=0.2048p ps=1.63u w=1u l=0.13u
X749 a_27878_2386# a_27608_2386# VGND.t11 VGND.t386 sg13_lv_nmos ad=0.1428p pd=1.52u as=79.8f ps=0.8u w=0.42u l=0.5u
X750 a_11733_2540# a_10791_2600# a_11639_2773# VPWR.t10 sg13_lv_pmos ad=79.8f pd=0.8u as=0.1428p ps=1.52u w=0.42u l=0.13u
X751 VGND.t86 sg13cmos5l_dfrbpq_1_57.RESET_B.t1 a_10538_5094# VGND.t85 sg13_lv_nmos ad=79.8f pd=0.8u as=37.8f ps=0.6u w=0.42u l=0.13u
X752 VPWR.t948 a_14235_6922# sg13cmos5l_buf_8_10.A VPWR.t2 sg13_lv_pmos ad=0.3864p pd=2.93u as=0.2128p ps=1.5u w=1.12u l=0.13u
X753 a_15322_6132# sg13cmos5l_dlygate4sd3_1_57.A VPWR.t1084 VPWR.t7 sg13_lv_pmos ad=0.1428p pd=1.52u as=0.1523p ps=1.38u w=0.42u l=0.13u
X754 a_8853_1679# a_7911_1719# a_8759_1679# VPWR.t15 sg13_lv_pmos ad=79.8f pd=0.8u as=0.1428p ps=1.52u w=0.42u l=0.13u
X755 a_15434_8430# a_15127_8394# a_15340_8430# VGND.t1404 sg13_lv_nmos ad=37.8f pd=0.6u as=0.1428p ps=1.52u w=0.42u l=0.13u
X756 VPWR.t1084 a_15322_6132# a_15041_6434# VPWR.t7 sg13_lv_pmos ad=0.1523p pd=1.38u as=0.34p ps=2.68u w=1u l=0.5u
X757 VGND.t179 a_13642_5374# sg13cmos5l_and2_1_3.A VGND.t527 sg13_lv_nmos ad=0.1406p pd=1.12u as=0.1406p ps=1.12u w=0.74u l=0.13u
X758 VGND.t203 sg13cmos5l_dlygate4sd3_1_51.A a_23576_4697# VGND.t142 sg13_lv_nmos ad=79.8f pd=0.8u as=0.1428p ps=1.52u w=0.42u l=0.13u
X759 VPWR.t352 a_14926_1059# sg13cmos5l_dfrbpq_1_12.D VPWR.t15 sg13_lv_pmos ad=0.2254p pd=1.53u as=0.4256p ps=3u w=1.12u l=0.13u
X760 a_7534_4923# a_7649_4922# VPWR.t691 VPWR.t43 sg13_lv_pmos ad=0.34p pd=2.68u as=0.2254p ps=1.53u w=1u l=0.5u
X761 VGND.t137 a_23846_1632# a_23958_1656# VGND.t158 sg13_lv_nmos ad=0.1426p pd=1.16u as=0.1428p ps=1.52u w=0.42u l=0.5u
X762 a_10116_2070# sg13cmos5l_dfrbpq_1_12.D a_10022_2070# VGND.t1232 sg13_lv_nmos ad=60.89999f pd=0.71u as=0.1428p ps=1.52u w=0.42u l=0.13u
X763 VGND.t17 a_21934_2571# sg13cmos5l_nor4_2_1.A VGND.t866 sg13_lv_nmos ad=0.1426p pd=1.16u as=0.2516p ps=2.16u w=0.74u l=0.13u
X764 a_7749_7691# sg13cmos5l_dfrbpq_1_32.CLK VGND.t0 VGND.t1207 sg13_lv_nmos ad=0.2516p pd=2.16u as=3.2221p ps=20.04u w=0.74u l=0.13u
X765 sg13cmos5l_dlygate4sd3_1_19.A a_5802_4192# VPWR.t272 VPWR.t43 sg13_lv_pmos ad=0.3808p pd=2.92u as=0.2128p ps=1.5u w=1.12u l=0.13u
X766 a_25478_5406# a_26283_5528# a_25738_5629# VPWR.t7 sg13_lv_pmos ad=0.1428p pd=1.52u as=79.8f ps=0.8u w=0.42u l=0.13u
X767 VPWR.t284 a_27195_3514# sg13cmos5l_dfrbpq_1_0.CLK VPWR.t10 sg13_lv_pmos ad=0.3864p pd=2.93u as=0.2128p ps=1.5u w=1.12u l=0.13u
X768 VGND.t50 a_9446_3144# a_9558_3168# VGND.t1247 sg13_lv_nmos ad=0.1426p pd=1.16u as=0.1428p ps=1.52u w=0.42u l=0.5u
X769 sg13cmos5l_buf_8_10.A a_14235_6922# VPWR.t944 VPWR.t2 sg13_lv_pmos ad=0.2128p pd=1.5u as=0.2128p ps=1.5u w=1.12u l=0.13u
X770 VPWR.t586 sg13cmos5l_dfrbpq_1_53.RESET_B.t10 a_25738_8653# VPWR.t0 sg13_lv_pmos ad=0.1563p pd=1.22u as=0.147p ps=1.54u w=0.42u l=0.13u
X771 VPWR.t990 a_5135_3505# a_5802_3144# VPWR.t10 sg13_lv_pmos ad=0.2128p pd=1.5u as=0.3864p ps=2.93u w=1.12u l=0.13u
X772 VGND.t77 a_14277_2361# a_14379_2504# VGND.t1686 sg13_lv_nmos ad=3.25012p pd=20.49u as=0.2516p ps=2.16u w=0.74u l=0.13u
X773 VPWR.t871 sg13cmos5l_dlygate4sd3_1_35.A a_1784_8434# VPWR.t0 sg13_lv_pmos ad=0.1523p pd=1.38u as=0.1428p ps=1.52u w=0.42u l=0.13u
X774 VPWR.t879 a_18363_6922# sg13cmos5l_dfrbpq_1_56.CLK VPWR.t2 sg13_lv_pmos ad=0.3864p pd=2.93u as=0.2128p ps=1.5u w=1.12u l=0.13u
X775 a_15538_3582# sg13cmos5l_dfrbpq_1_55.RESET_B VGND.t316 VGND.t574 sg13_lv_nmos ad=37.8f pd=0.6u as=79.8f ps=0.8u w=0.42u l=0.13u
X776 a_6951_1088# a_7103_1140# VGND.t35 VGND.t1671 sg13_lv_nmos ad=0.2516p pd=2.16u as=5.40863p ps=35.155u w=0.74u l=0.13u
X777 a_27442_8430# sg13cmos5l_dfrbpq_1_53.RESET_B.t9 VGND.t273 VGND.t72 sg13_lv_nmos ad=37.8f pd=0.6u as=79.8f ps=0.8u w=0.42u l=0.13u
X778 a_8848_7922# sg13cmos5l_dfrbpq_1_21.RESET_B.t9 VPWR.t2 VPWR.t2 sg13_lv_pmos ad=79.8f pd=0.8u as=1.31957p ps=8.38u w=0.42u l=0.13u
X779 VGND.t203 sg13cmos5l_nand3_1_2.Y a_25236_5452# VGND.t142 sg13_lv_nmos ad=0.2272p pd=1.99u as=78.39999f ps=0.885u w=0.64u l=0.13u
X780 a_5207_1261# a_4511_1140# a_5301_1028# VGND.t36 sg13_lv_nmos ad=0.1296p pd=1.52u as=79.8f ps=0.8u w=0.42u l=0.13u
X781 sg13cmos5l_xnor2_1_2.Y a_16320_1671# a_16469_2002# VGND.t153 sg13_lv_nmos ad=0.2516p pd=2.16u as=0.1406p ps=1.12u w=0.74u l=0.13u
X782 VGND.t54 VPWR.t79 VGND.t54 VGND.t53 sg13_lv_nmos ad=79.8f pd=0.8u as=0 ps=0 w=0.42u l=1u
X783 sg13cmos5l_dfrbpq_1_56.CLK a_18363_6922# VPWR.t875 VPWR.t2 sg13_lv_pmos ad=0.2128p pd=1.5u as=0.2128p ps=1.5u w=1.12u l=0.13u
X784 a_28570_5374# sg13cmos5l_dlygate4sd3_1_40.A VGND.t1159 VGND.t200 sg13_lv_nmos ad=0.1428p pd=1.52u as=79.8f ps=0.8u w=0.42u l=0.13u
X785 a_2016_4695# sg13cmos5l_xnor2_1_13.A VPWR.t1409 VPWR.t43 sg13_lv_pmos ad=0.1596p pd=1.22u as=0.4536p ps=2.76u w=0.84u l=0.13u
X786 VGND.t358 a_5392_8650# a_5041_8507# VGND.t673 sg13_lv_nmos ad=79.8f pd=0.8u as=0.1428p ps=1.52u w=0.42u l=0.13u
X787 a_20102_6606# sg13cmos5l_dlygate4sd3_1_51.X VPWR.t267 VPWR.t7 sg13_lv_pmos ad=79.8f pd=0.8u as=0.1428p ps=1.52u w=0.42u l=0.13u
X788 VPWR.t361 a_18144_4695# sg13cmos5l_xnor2_1_3.B VPWR.t43 sg13_lv_pmos ad=0.3808p pd=2.92u as=0.2408p ps=1.55u w=1.12u l=0.13u
X789 VGND.t77 sg13cmos5l_dfrbpq_1_0.CLK a_25439_1603# VGND.t1630 sg13_lv_nmos ad=3.06955p pd=19.355u as=0.2516p ps=2.16u w=0.74u l=0.13u
X790 sg13cmos5l_and2_1_3.A a_13642_5374# VPWR.t487 VPWR.t7 sg13_lv_pmos ad=0.2128p pd=1.5u as=0.2128p ps=1.5u w=1.12u l=0.13u
X791 a_26290_6606# sg13cmos5l_buf_1_0.X.t4 VGND.t126 VGND.t484 sg13_lv_nmos ad=37.8f pd=0.6u as=79.8f ps=0.8u w=0.42u l=0.13u
X792 a_16367_8041# a_15525_7691# a_16273_8041# VGND.t918 sg13_lv_nmos ad=0.12665p pd=1.145u as=0.1428p ps=1.52u w=0.42u l=0.13u
X793 a_9446_5410# a_9176_5410# VGND.t131 VGND.t1221 sg13_lv_nmos ad=0.1428p pd=1.52u as=79.8f ps=0.8u w=0.42u l=0.5u
X794 VGND.t160 a_22330_838# a_22049_1060# VGND.t1622 sg13_lv_nmos ad=79.8f pd=0.8u as=0.1428p ps=1.52u w=0.42u l=0.5u
X795 a_10596_8443# a_10827_8552# a_10282_8653# VGND.t89 sg13_lv_nmos ad=0.2373p pd=1.97u as=79.8f ps=0.8u w=0.42u l=0.13u
X796 sg13cmos5l_nand3_1_0.A sg13cmos5l_dfrbpq_1_0.D VGND.t17 VGND.t805 sg13_lv_nmos ad=0.1406p pd=1.12u as=0.3293p ps=1.63u w=0.74u l=0.13u
X797 VGND.t150 VPWR.t1452 VGND.t150 VGND.t1522 sg13_lv_nmos ad=79.8f pd=0.8u as=0 ps=0 w=0.42u l=1u
X798 VGND.t197 a_27963_6538# sg13cmos5l_dfrbpq_1_53.CLK VGND.t1562 sg13_lv_nmos ad=0.1406p pd=1.12u as=0.1406p ps=1.12u w=0.74u l=0.13u
X799 VGND.t96 sg13cmos5l_dfrbpq_1_57.RESET_B.t6 a_13867_6964# VGND.t95 sg13_lv_nmos ad=0.1331p pd=1.12u as=0.1216p ps=1.02u w=0.64u l=0.13u
X800 a_5207_1261# sg13cmos5l_dfrbpq_1_13.RESET_B.t5 VPWR.t351 VPWR.t15 sg13_lv_pmos ad=79.8f pd=0.8u as=0.36237p ps=2.605u w=0.42u l=0.13u
X801 a_6862_1185# a_6604_870# VPWR.t105 VPWR.t15 sg13_lv_pmos ad=93.45f pd=0.865u as=1.50275p ps=9.57u w=0.42u l=0.13u
X802 a_8842_6886# sg13cmos5l_buf_8_10.A VGND.t630 VGND.t1083 sg13_lv_nmos ad=0.2553p pd=2.17u as=0.1406p ps=1.12u w=0.74u l=0.13u
X803 a_10112_3431# a_10231_3108# VPWR.t603 VPWR.t10 sg13_lv_pmos ad=0.3864p pd=2.93u as=0.2128p ps=1.5u w=1.12u l=0.13u
X804 a_25380_7684# a_25354_7648# VPWR.t6 VPWR.t2 sg13_lv_pmos ad=0.34p pd=2.68u as=0.36237p ps=2.605u w=1u l=0.13u
X805 VPWR.t849 a_5230_7107# sg13cmos5l_nor3_1_2.C VPWR.t2 sg13_lv_pmos ad=0.2254p pd=1.53u as=0.4256p ps=3u w=1.12u l=0.13u
X806 a_5422_5094# a_5164_5094# VGND.t52 VGND.t30 sg13_lv_nmos ad=0.1428p pd=1.52u as=79.8f ps=0.8u w=0.42u l=0.13u
X807 a_16198_6593# sg13cmos5l_dfrbpq_1_56.RESET_B VGND.t25 VGND.t832 sg13_lv_nmos ad=37.8f pd=0.6u as=0.1701p ps=1.65u w=0.42u l=0.13u
X808 VPWR.t166 VGND.t20 VPWR.t167 VPWR.t0 sg13_lv_pmos ad=0.19p pd=1.38u as=0 ps=0 w=1u l=1u
X809 a_24874_3112# a_25317_3155# a_24614_3582# VGND.t1176 sg13_lv_nmos ad=79.8f pd=0.8u as=0.1296p ps=1.52u w=0.42u l=0.13u
X810 VPWR.t410 a_6972_3858# a_7995_4285# VPWR.t43 sg13_lv_pmos ad=0.1563p pd=1.22u as=63f ps=0.72u w=0.42u l=0.13u
X811 VPWR.t256 a_20687_947# a_21354_1168# VPWR.t15 sg13_lv_pmos ad=0.2128p pd=1.5u as=0.3864p ps=2.93u w=1.12u l=0.13u
X812 VPWR.t214 sg13cmos5l_dfrbpq_1_55.D a_15191_1679# VPWR.t15 sg13_lv_pmos ad=0.1428p pd=1.52u as=79.8f ps=0.8u w=0.42u l=0.13u
X813 a_13860_3148# a_14379_3155# a_15119_3505# VGND.t1632 sg13_lv_nmos ad=0.3473p pd=2.71u as=0.12665p ps=1.145u w=0.74u l=0.13u
X814 a_5392_4114# sg13cmos5l_dfrbpq_1_21.RESET_B.t7 VPWR.t43 VPWR.t43 sg13_lv_pmos ad=79.8f pd=0.8u as=1.36105p ps=8.695u w=0.42u l=0.13u
X815 a_7716_2700# a_7690_2605# VPWR.t560 VPWR.t10 sg13_lv_pmos ad=0.34p pd=2.68u as=0.36237p ps=2.605u w=1u l=0.13u
X816 a_17715_1632# sg13cmos5l_nand3_1_0.Y VPWR.t191 VPWR.t15 sg13_lv_pmos ad=0.1428p pd=1.375u as=0.2891p ps=1.695u w=1.12u l=0.13u
X817 sg13cmos5l_nor4_2_3.Y sg13cmos5l_dlygate4sd3_1_21.X VGND.t50 VGND.t544 sg13_lv_nmos ad=0.1406p pd=1.12u as=0.3293p ps=1.63u w=0.74u l=0.13u
X818 a_19055_3971# a_18213_3873# a_17796_4212# VPWR.t43 sg13_lv_pmos ad=0.2048p pd=1.63u as=0.34p ps=2.68u w=1u l=0.13u
X819 VGND.t630 a_8842_6886# sg13cmos5l_dfrbpq_1_57.CLK VGND.t1075 sg13_lv_nmos ad=0.1406p pd=1.12u as=0.1406p ps=1.12u w=0.74u l=0.13u
X820 a_7439_6529# a_6597_6179# a_7345_6529# VGND.t1286 sg13_lv_nmos ad=0.12665p pd=1.145u as=0.1428p ps=1.52u w=0.42u l=0.13u
X821 VGND.t11 a_25679_2459# a_26346_2680# VGND.t10 sg13_lv_nmos ad=0.1406p pd=1.12u as=0.2516p ps=2.16u w=0.74u l=0.13u
X822 VGND.t254 a_5135_3505# a_5802_3144# VGND.t674 sg13_lv_nmos ad=0.1406p pd=1.12u as=0.2516p ps=2.16u w=0.74u l=0.13u
X823 a_12386_8118# sg13cmos5l_dfrbpq_1_57.RESET_B.t11 VGND.t40 VGND.t776 sg13_lv_nmos ad=60.89999f pd=0.71u as=0.1626p ps=1.415u w=0.42u l=0.13u
X824 a_26724_6931# a_26955_7040# a_26410_7141# VGND.t426 sg13_lv_nmos ad=0.2373p pd=1.97u as=79.8f ps=0.8u w=0.42u l=0.13u
X825 VGND.t50 sg13cmos5l_nor3_1_1.Y a_8898_3510# VGND.t1111 sg13_lv_nmos ad=0.2886p pd=2.26u as=0.1406p ps=1.12u w=0.74u l=0.13u
X826 VPWR.t43 a_26704_4114# a_26649_4209# VPWR.t43 sg13_lv_pmos ad=1.3927p pd=8.9u as=93.45f ps=0.865u w=0.42u l=0.13u
X827 a_20805_5385# sg13cmos5l_dfrbpq_1_46.CLK VGND.t30 VGND.t29 sg13_lv_nmos ad=0.2516p pd=2.16u as=3.5351p ps=22.08u w=0.74u l=0.13u
X828 VGND.t150 a_3680_2557# sg13cmos5l_dfrbpq_1_21.Q VGND.t551 sg13_lv_nmos ad=0.1406p pd=1.12u as=0.2516p ps=2.16u w=0.74u l=0.13u
X829 VPWR.t579 a_9446_6168# a_9558_6192# VPWR.t7 sg13_lv_pmos ad=0.2254p pd=1.53u as=0.34p ps=2.68u w=1u l=0.5u
X830 a_8150_883# a_6972_834# a_7754_1028# VGND.t555 sg13_lv_nmos ad=37.8f pd=0.6u as=0.1428p ps=1.52u w=0.42u l=0.13u
X831 a_26608_1090# a_26351_947# a_26770_870# VGND.t307 sg13_lv_nmos ad=0.1428p pd=1.52u as=37.8f ps=0.6u w=0.42u l=0.13u
X832 VGND.t71 a_19888_2602# a_19537_2459# VGND.t8 sg13_lv_nmos ad=79.8f pd=0.8u as=0.1428p ps=1.52u w=0.42u l=0.13u
X833 a_14217_2773# a_13860_2700# VPWR.t90 VPWR.t10 sg13_lv_pmos ad=63f pd=0.72u as=0.1563p ps=1.22u w=0.42u l=0.13u
X834 a_20192_7093# a_20311_6882# VGND.t145 VGND.t313 sg13_lv_nmos ad=0.2516p pd=2.16u as=0.1406p ps=1.12u w=0.74u l=0.13u
X835 a_4164_3569# a_3876_3148# a_4102_3569# VGND.t188 sg13_lv_nmos ad=0.1428p pd=1.52u as=37.8f ps=0.6u w=0.42u l=0.13u
X836 sg13cmos5l_nor3_1_1.A a_14742_3962# VGND.t316 VGND.t1453 sg13_lv_nmos ad=0.2516p pd=2.16u as=0.1426p ps=1.16u w=0.74u l=0.13u
X837 sg13cmos5l_nor4_2_3.Y sg13cmos5l_dfrbpq_1_12.D VGND.t50 VGND.t1228 sg13_lv_nmos ad=0.1406p pd=1.12u as=0.1406p ps=1.12u w=0.74u l=0.13u
X838 VGND.t254 a_5392_3386# a_5041_3505# VGND.t674 sg13_lv_nmos ad=79.8f pd=0.8u as=0.1428p ps=1.52u w=0.42u l=0.13u
X839 VGND.t25 a_16389_6179# a_16491_6179# VGND.t47 sg13_lv_nmos ad=3.51837p pd=21.815u as=0.2516p ps=2.16u w=0.74u l=0.13u
X840 VPWR.t91 a_15376_3386# a_15321_3267# VPWR.t10 sg13_lv_pmos ad=1.43285p pd=9.125u as=93.45f ps=0.865u w=0.42u l=0.13u
X841 sg13cmos5l_buf_8_2.X a_21435_3514# VGND.t54 VGND.t53 sg13_lv_nmos ad=0.1406p pd=1.12u as=0.1406p ps=1.12u w=0.74u l=0.13u
X842 VGND.t133 a_18843_5410# sg13cmos5l_and2_1_1.A VGND.t1395 sg13_lv_nmos ad=0.1406p pd=1.12u as=0.1406p ps=1.12u w=0.74u l=0.13u
X843 a_24642_3902# sg13cmos5l_nand3_1_2.B a_24540_3902# VGND.t202 sg13_lv_nmos ad=0.1406p pd=1.12u as=0.1406p ps=1.12u w=0.74u l=0.13u
X844 a_8546_8430# sg13cmos5l_dfrbpq_1_21.RESET_B.t13 VGND.t803 VGND.t859 sg13_lv_nmos ad=60.89999f pd=0.71u as=0.1626p ps=1.415u w=0.42u l=0.13u
X845 VPWR.t2 a_7749_7691# a_7851_7691# VPWR.t2 sg13_lv_pmos ad=1.34765p pd=8.56u as=0.3864p ps=2.93u w=1.12u l=0.13u
X846 a_20805_6179# sg13cmos5l_dfrbpq_1_46.CLK VPWR.t7 VPWR.t7 sg13_lv_pmos ad=0.4088p pd=2.97u as=1.42587p ps=9.11u w=1.12u l=0.13u
X847 a_10596_6931# a_10308_7236# a_10534_6931# VGND.t654 sg13_lv_nmos ad=0.1428p pd=1.52u as=37.8f ps=0.6u w=0.42u l=0.13u
X848 a_28174_5595# a_28289_5596# VPWR.t1214 VPWR.t7 sg13_lv_pmos ad=0.34p pd=2.68u as=0.2254p ps=1.53u w=1u l=0.5u
X849 a_18862_2070# a_19103_1603# a_18391_1596# VGND.t399 sg13_lv_nmos ad=0.1428p pd=1.52u as=0.12665p ps=1.145u w=0.42u l=0.13u
X850 a_5319_1719# a_5471_1603# VGND.t77 VGND.t223 sg13_lv_nmos ad=0.2516p pd=2.16u as=3.25012p ps=20.49u w=0.74u l=0.13u
X851 VGND.t324 sg13cmos5l_dfrbpq_1_55.RESET_B a_13668_2382# VGND.t6 sg13_lv_nmos ad=0.1626p pd=1.415u as=60.89999f ps=0.71u w=0.42u l=0.13u
X852 a_28980_3492# sg13cmos5l_xnor2_1_4.B a_28524_3410# VGND.t1191 sg13_lv_nmos ad=78.39999f pd=0.885u as=0.2176p ps=1.96u w=0.64u l=0.13u
X853 VGND.t54 a_21435_3514# sg13cmos5l_buf_8_2.X VGND.t53 sg13_lv_nmos ad=0.1406p pd=1.12u as=0.1406p ps=1.12u w=0.74u l=0.13u
X854 VPWR.t1350 sg13cmos5l_buf_8_4.A a_6250_3108# VPWR.t10 sg13_lv_pmos ad=0.2128p pd=1.5u as=0.2128p ps=1.5u w=1.12u l=0.13u
X855 a_25764_8748# a_25738_8653# VGND.t299 VGND.t865 sg13_lv_nmos ad=0.2516p pd=2.16u as=0.1626p ps=1.415u w=0.74u l=0.13u
X856 a_4663_7644# a_5223_7767# a_5134_7803# VPWR.t2 sg13_lv_pmos ad=0.2048p pd=1.63u as=93.45f ps=0.865u w=0.42u l=0.13u
X857 VGND.t45 a_27963_6538# sg13cmos5l_dfrbpq_1_53.CLK VGND.t1558 sg13_lv_nmos ad=0.1406p pd=1.12u as=0.1406p ps=1.12u w=0.74u l=0.13u
X858 a_10112_3431# a_10231_3108# VGND.t50 VGND.t1440 sg13_lv_nmos ad=0.2516p pd=2.16u as=0.1406p ps=1.12u w=0.74u l=0.13u
X859 VGND.t62 sg13cmos5l_dfrbpq_1_53.RESET_B.t8 a_25188_8118# VGND.t297 sg13_lv_nmos ad=0.1626p pd=1.415u as=60.89999f ps=0.71u w=0.42u l=0.13u
X860 VPWR.t527 a_11733_2540# a_10812_2346# VPWR.t10 sg13_lv_pmos ad=0.36237p pd=2.605u as=0.34p ps=2.68u w=1u l=0.13u
X861 a_15686_6606# a_16491_6179# a_15946_6136# VPWR.t7 sg13_lv_pmos ad=0.1428p pd=1.52u as=79.8f ps=0.8u w=0.42u l=0.13u
X862 VGND.t20 sg13cmos5l_buf_1_0.X.t12 a_22070_8105# VGND.t134 sg13_lv_nmos ad=0.1701p pd=1.65u as=37.8f ps=0.6u w=0.42u l=0.13u
X863 a_5988_6606# sg13cmos5l_nor4_2_5.D a_5894_6606# VGND.t455 sg13_lv_nmos ad=60.89999f pd=0.71u as=0.1428p ps=1.52u w=0.42u l=0.13u
X864 VPWR.t644 a_5724_5370# a_6747_5797# VPWR.t7 sg13_lv_pmos ad=0.1563p pd=1.22u as=63f ps=0.72u w=0.42u l=0.13u
X865 VPWR.t216 sg13cmos5l_dlygate4sd3_1_50.A a_13592_4697# VPWR.t43 sg13_lv_pmos ad=0.1523p pd=1.38u as=0.1428p ps=1.52u w=0.42u l=0.13u
X866 a_21647_8507# a_20805_8409# a_21553_8507# VGND.t2 sg13_lv_nmos ad=0.12665p pd=1.145u as=0.1428p ps=1.52u w=0.42u l=0.13u
X867 VGND.t65 sg13cmos5l_buf_1_0.X.t9 a_23652_6918# VGND.t129 sg13_lv_nmos ad=0.1626p pd=1.415u as=60.89999f ps=0.71u w=0.42u l=0.13u
X868 sg13cmos5l_dlygate4sd3_1_11.A a_26538_6168# VGND.t126 VGND.t247 sg13_lv_nmos ad=0.2516p pd=2.16u as=0.1406p ps=1.12u w=0.74u l=0.13u
X869 VPWR.t40 VGND.t121 VPWR.t38 VPWR.t2 sg13_lv_pmos ad=0.19p pd=1.38u as=0 ps=0 w=1u l=1u
X870 VGND.t30 sg13cmos5l_dfrbpq_1_57.CLK a_10943_4627# VGND.t1102 sg13_lv_nmos ad=3.32715p pd=20.78u as=0.2516p ps=2.16u w=0.74u l=0.13u
X871 VPWR.t184 a_23846_1632# a_23958_1656# VPWR.t15 sg13_lv_pmos ad=0.2254p pd=1.53u as=0.34p ps=2.68u w=1u l=0.5u
X872 a_26853_6897# sg13cmos5l_dfrbpq_1_53.CLK VGND.t25 VGND.t1076 sg13_lv_nmos ad=0.2516p pd=2.16u as=3.31142p ps=20.535u w=0.74u l=0.13u
X873 a_16454_3144# a_16184_3185# VGND.t50 VGND.t1327 sg13_lv_nmos ad=0.1428p pd=1.52u as=79.8f ps=0.8u w=0.42u l=0.5u
X874 a_10231_6132# a_10791_6255# a_10702_6291# VPWR.t7 sg13_lv_pmos ad=0.2048p pd=1.63u as=93.45f ps=0.865u w=0.42u l=0.13u
X875 a_27963_6538# sg13cmos5l_buf_8_11.A VGND.t45 VGND.t999 sg13_lv_nmos ad=0.1406p pd=1.12u as=0.1406p ps=1.12u w=0.74u l=0.13u
X876 sg13cmos5l_dfrbpq_1_11.Q a_12234_1168# VPWR.t157 VPWR.t15 sg13_lv_pmos ad=0.3808p pd=2.92u as=0.2128p ps=1.5u w=1.12u l=0.13u
X877 VPWR.t14 VGND.t150 VPWR.t12 VPWR.t10 sg13_lv_pmos ad=0.19p pd=1.38u as=0 ps=0 w=1u l=1u
X878 VGND.t268 a_28646_3898# a_28758_3962# VGND.t518 sg13_lv_nmos ad=0.1426p pd=1.16u as=0.1428p ps=1.52u w=0.42u l=0.5u
X879 a_11824_7138# a_11567_6995# a_11986_6918# VGND.t1043 sg13_lv_nmos ad=0.1428p pd=1.52u as=37.8f ps=0.6u w=0.42u l=0.13u
X880 sg13cmos5l_dfrbpq_1_29.Q a_12234_8728# VGND.t40 VGND.t39 sg13_lv_nmos ad=0.2516p pd=2.16u as=0.1406p ps=1.12u w=0.74u l=0.13u
X881 VGND.t25 a_5626_6886# a_5345_7108# VGND.t949 sg13_lv_nmos ad=79.8f pd=0.8u as=0.1428p ps=1.52u w=0.42u l=0.5u
X882 VPWR.t220 sg13cmos5l_xnor2_1_5.Y a_2016_5721# VPWR.t7 sg13_lv_pmos ad=0.2891p pd=1.695u as=0.1596p ps=1.22u w=0.84u l=0.13u
X883 VPWR.t91 a_5135_3505# a_5392_3386# VPWR.t10 sg13_lv_pmos ad=1.43285p pd=9.125u as=79.8f ps=0.8u w=0.42u l=0.13u
X884 VGND.t191 a_17327_6995# a_17994_7216# VGND.t244 sg13_lv_nmos ad=0.1406p pd=1.12u as=0.2516p ps=2.16u w=0.74u l=0.13u
X885 VPWR.t332 sg13cmos5l_dfrbpq_1_57.RESET_B.t3 a_10282_5629# VPWR.t7 sg13_lv_pmos ad=0.1563p pd=1.22u as=0.147p ps=1.54u w=0.42u l=0.13u
X886 VPWR.t7 a_7439_6529# a_7696_6410# VPWR.t7 sg13_lv_pmos ad=1.46065p pd=9.335u as=79.8f ps=0.8u w=0.42u l=0.13u
X887 a_17541_1168# sg13cmos5l_nor3_1_0.A VPWR.t191 VPWR.t15 sg13_lv_pmos ad=0.2464p pd=1.56u as=0.3808p ps=2.92u w=1.12u l=0.13u
X888 VGND.t54 VPWR.t76 VGND.t54 VGND.t202 sg13_lv_nmos ad=0.1428p pd=1.52u as=0 ps=0 w=0.42u l=1u
X889 VGND.t1016 a_18874_8398# a_18593_8620# VGND.t0 sg13_lv_nmos ad=79.8f pd=0.8u as=0.1428p ps=1.52u w=0.42u l=0.5u
X890 a_20805_5385# sg13cmos5l_dfrbpq_1_46.CLK VPWR.t7 VPWR.t7 sg13_lv_pmos ad=0.4088p pd=2.97u as=1.42587p ps=9.11u w=1.12u l=0.13u
X891 sg13cmos5l_nand3_1_2.A sg13cmos5l_dlygate4sd3_1_55.X VGND.t286 VGND.t492 sg13_lv_nmos ad=0.1406p pd=1.12u as=0.3293p ps=1.63u w=0.74u l=0.13u
X892 VPWR.t184 sg13cmos5l_dfrbpq_1_3.D a_23660_1168# VPWR.t15 sg13_lv_pmos ad=0.3808p pd=2.92u as=0.2128p ps=1.5u w=1.12u l=0.13u
X893 VPWR.t681 sg13cmos5l_dfrbpq_1_21.RESET_B.t4 a_3850_3112# VPWR.t10 sg13_lv_pmos ad=0.1563p pd=1.22u as=0.147p ps=1.54u w=0.42u l=0.13u
X894 VPWR.t41 VGND.t30 VPWR.t246 VPWR.t7 sg13_lv_pmos ad=0.34p pd=2.68u as=0 ps=0 w=1u l=1u
X895 a_5230_1755# a_4972_2070# VPWR.t105 VPWR.t15 sg13_lv_pmos ad=93.45f pd=0.865u as=1.50275p ps=9.57u w=0.42u l=0.13u
X896 a_7690_2605# a_8133_2361# a_8073_2773# VPWR.t10 sg13_lv_pmos ad=79.8f pd=0.8u as=63f ps=0.72u w=0.42u l=0.13u
X897 a_21647_8507# a_20805_8409# a_20388_8748# VPWR.t0 sg13_lv_pmos ad=0.2048p pd=1.63u as=0.34p ps=2.68u w=1u l=0.13u
X898 VGND.t115 a_6250_2350# sg13cmos5l_dfrbpq_1_13.CLK VGND.t1387 sg13_lv_nmos ad=0.1406p pd=1.12u as=0.1406p ps=1.12u w=0.74u l=0.13u
X899 a_15119_3505# a_14277_3155# a_15025_3505# VGND.t1363 sg13_lv_nmos ad=0.12665p pd=1.145u as=0.1428p ps=1.52u w=0.42u l=0.13u
X900 a_26410_7141# a_26853_6897# a_26793_7309# VPWR.t2 sg13_lv_pmos ad=79.8f pd=0.8u as=63f ps=0.72u w=0.42u l=0.13u
X901 a_21813_7727# a_20871_7767# a_21674_7960# VGND.t920 sg13_lv_nmos ad=79.8f pd=0.8u as=0.2373p ps=1.97u w=0.42u l=0.13u
X902 a_21647_6529# a_20805_6179# a_20388_6172# VPWR.t7 sg13_lv_pmos ad=0.2048p pd=1.63u as=0.34p ps=2.68u w=1u l=0.13u
X903 a_3799_834# a_4359_1088# a_4270_1185# VPWR.t15 sg13_lv_pmos ad=0.2048p pd=1.63u as=93.45f ps=0.865u w=0.42u l=0.13u
X904 a_7332_7684# a_7851_7691# a_8591_8041# VGND.t433 sg13_lv_nmos ad=0.3473p pd=2.71u as=0.12665p ps=1.145u w=0.74u l=0.13u
X905 sg13cmos5l_nand3_1_2.A sg13cmos5l_dfrbpq_1_37.D VGND.t286 VGND.t974 sg13_lv_nmos ad=0.1406p pd=1.12u as=0.1406p ps=1.12u w=0.74u l=0.13u
X906 VGND.t133 a_18843_5410# sg13cmos5l_and2_1_1.A VGND.t1391 sg13_lv_nmos ad=0.1406p pd=1.12u as=0.1406p ps=1.12u w=0.74u l=0.13u
X907 a_20388_4660# a_20362_4624# VPWR.t1093 VPWR.t43 sg13_lv_pmos ad=0.34p pd=2.68u as=0.36237p ps=2.605u w=1u l=0.13u
X908 a_4640_1919# a_4759_1596# VPWR.t371 VPWR.t15 sg13_lv_pmos ad=0.3864p pd=2.93u as=0.2128p ps=1.5u w=1.12u l=0.13u
X909 VPWR.t392 a_7439_6529# a_8106_6168# VPWR.t7 sg13_lv_pmos ad=0.2128p pd=1.5u as=0.3864p ps=2.93u w=1.12u l=0.13u
X910 sg13cmos5l_dlygate4sd3_1_5.A a_20298_2680# VGND.t71 VGND.t8 sg13_lv_nmos ad=0.2516p pd=2.16u as=0.1406p ps=1.12u w=0.74u l=0.13u
X911 a_13668_3582# sg13cmos5l_nor3_1_1.C a_13574_3582# VGND.t1181 sg13_lv_nmos ad=60.89999f pd=0.71u as=0.1428p ps=1.52u w=0.42u l=0.13u
X912 VGND.t30 a_16581_5385# a_16683_5528# VGND.t1359 sg13_lv_nmos ad=3.5351p pd=22.08u as=0.2516p ps=2.16u w=0.74u l=0.13u
X913 VGND.t119 a_11567_947# a_12234_1168# VGND.t232 sg13_lv_nmos ad=0.1406p pd=1.12u as=0.2516p ps=2.16u w=0.74u l=0.13u
X914 a_25572_8430# sg13cmos5l_dlygate4sd3_1_4.X a_25478_8430# VGND.t246 sg13_lv_nmos ad=60.89999f pd=0.71u as=0.1428p ps=1.52u w=0.42u l=0.13u
X915 VPWR.t860 sg13cmos5l_nor4_2_9.D a_6551_5797# VPWR.t7 sg13_lv_pmos ad=0.1428p pd=1.52u as=79.8f ps=0.8u w=0.42u l=0.13u
X916 sg13cmos5l_buf_1_1.X.t0 a_17032_908# VPWR.t191 VPWR.t15 sg13_lv_pmos ad=0.42p pd=2.99u as=0.2114p ps=1.54u w=1.12u l=0.13u
X917 a_17702_3144# a_17432_3185# VPWR.t1257 VPWR.t10 sg13_lv_pmos ad=0.34p pd=2.68u as=0.1523p ps=1.38u w=1u l=0.5u
X918 sg13cmos5l_dfrbpq_1_52.Q a_17034_7680# VGND.t3 VGND.t443 sg13_lv_nmos ad=0.2516p pd=2.16u as=0.1406p ps=1.12u w=0.74u l=0.13u
X919 VPWR.t8 sg13cmos5l_dfrbpq_1_46.D a_23712_6207# VPWR.t7 sg13_lv_pmos ad=0.2891p pd=1.695u as=0.1596p ps=1.22u w=0.84u l=0.13u
X920 a_25092_1188# a_25066_1093# VPWR.t203 VPWR.t15 sg13_lv_pmos ad=0.34p pd=2.68u as=0.36237p ps=2.605u w=1u l=0.13u
X921 sg13cmos5l_dfrbpq_1_13.CLK a_6250_2350# VGND.t115 VGND.t1384 sg13_lv_nmos ad=0.1406p pd=1.12u as=0.1406p ps=1.12u w=0.74u l=0.13u
X922 VGND.t50 a_9562_3862# a_9281_4084# VGND.t790 sg13_lv_nmos ad=79.8f pd=0.8u as=0.1428p ps=1.52u w=0.42u l=0.5u
X923 a_18010_8398# sg13cmos5l_dfrbpq_1_47.Q VPWR.t797 VPWR.t0 sg13_lv_pmos ad=0.1428p pd=1.52u as=0.1523p ps=1.38u w=0.42u l=0.13u
X924 a_18900_916# sg13cmos5l_xnor2_1_3.B a_18444_1060# VGND.t757 sg13_lv_nmos ad=78.39999f pd=0.885u as=0.2176p ps=1.96u w=0.64u l=0.13u
X925 a_24614_3582# a_25419_3155# a_24874_3112# VPWR.t10 sg13_lv_pmos ad=0.1428p pd=1.52u as=79.8f ps=0.8u w=0.42u l=0.13u
X926 a_18843_5410# sg13cmos5l_buf_8_0.X VGND.t133 VGND.t183 sg13_lv_nmos ad=0.1406p pd=1.12u as=0.1406p ps=1.12u w=0.74u l=0.13u
X927 sg13cmos5l_buf_8_4.A a_7594_5374# VGND.t131 VGND.t1164 sg13_lv_nmos ad=0.1406p pd=1.12u as=0.1406p ps=1.12u w=0.74u l=0.13u
X928 a_15878_5406# a_16683_5528# a_16138_5629# VPWR.t7 sg13_lv_pmos ad=0.1428p pd=1.52u as=79.8f ps=0.8u w=0.42u l=0.13u
X929 a_24394_2605# a_24837_2361# a_24134_2382# VGND.t75 sg13_lv_nmos ad=79.8f pd=0.8u as=0.1296p ps=1.52u w=0.42u l=0.13u
X930 a_10702_2382# a_10444_2382# VGND.t478 VGND.t1570 sg13_lv_nmos ad=0.1428p pd=1.52u as=79.8f ps=0.8u w=0.42u l=0.13u
X931 a_6468_6593# a_6699_6179# a_6154_6136# VGND.t337 sg13_lv_nmos ad=0.2373p pd=1.97u as=79.8f ps=0.8u w=0.42u l=0.13u
X932 VGND.t172 sg13cmos5l_xnor2_1_0.A a_16212_916# VGND.t677 sg13_lv_nmos ad=0.2272p pd=1.99u as=78.39999f ps=0.885u w=0.64u l=0.13u
X933 a_24420_6606# sg13cmos5l_dfrbpq_1_37.D a_24326_6606# VGND.t64 sg13_lv_nmos ad=60.89999f pd=0.71u as=0.1428p ps=1.52u w=0.42u l=0.13u
X934 sg13cmos5l_nor3_1_4.Y sg13cmos5l_nor3_1_4.A VGND.t316 VGND.t1039 sg13_lv_nmos ad=0.1694p pd=1.21u as=0.2618p ps=2.22u w=0.77u l=0.13u
X935 a_17327_6995# a_16485_6897# a_16068_7236# VPWR.t2 sg13_lv_pmos ad=0.2048p pd=1.63u as=0.34p ps=2.68u w=1u l=0.13u
X936 VGND.t312 sg13cmos5l_dfrbpq_1_21.RESET_B.t11 a_6422_8105# VGND.t735 sg13_lv_nmos ad=0.1701p pd=1.65u as=37.8f ps=0.6u w=0.42u l=0.13u
X937 VGND.t191 a_18382_6435# sg13cmos5l_dfrbpq_1_56.D VGND.t623 sg13_lv_nmos ad=0.1426p pd=1.16u as=0.2516p ps=2.16u w=0.74u l=0.13u
X938 a_10444_2382# a_10231_2346# VPWR.t91 VPWR.t10 sg13_lv_pmos ad=79.8f pd=0.8u as=1.43285p ps=9.125u w=0.42u l=0.13u
X939 a_4970_8118# a_4663_7644# a_4876_8118# VGND.t437 sg13_lv_nmos ad=37.8f pd=0.6u as=0.1428p ps=1.52u w=0.42u l=0.13u
X940 a_19642_6132# sg13cmos5l_dfrbpq_1_39.Q VPWR.t1248 VPWR.t7 sg13_lv_pmos ad=0.1428p pd=1.52u as=0.1523p ps=1.38u w=0.42u l=0.13u
X941 a_17366_5081# a_16188_5017# a_16970_4936# VGND.t1376 sg13_lv_nmos ad=37.8f pd=0.6u as=0.1428p ps=1.52u w=0.42u l=0.13u
X942 a_16068_7236# a_16042_7141# VGND.t25 VGND.t1188 sg13_lv_nmos ad=0.2516p pd=2.16u as=0.1626p ps=1.415u w=0.74u l=0.13u
X943 VGND.t861 sg13cmos5l_nand3_1_3.Y a_2165_3898# VGND.t1428 sg13_lv_nmos ad=0.1898p pd=1.36u as=0.2516p ps=2.16u w=0.74u l=0.13u
X944 sg13cmos5l_xnor2_1_12.Y a_1248_4695# a_1397_5026# VGND.t30 sg13_lv_nmos ad=0.2516p pd=2.16u as=0.1406p ps=1.12u w=0.74u l=0.13u
X945 VPWR.t77 VGND.t54 VPWR.t76 VPWR.t43 sg13_lv_pmos ad=0.34p pd=2.68u as=0 ps=0 w=1u l=1u
X946 a_5135_3505# a_4293_3155# a_5041_3505# VGND.t674 sg13_lv_nmos ad=0.12665p pd=1.145u as=0.1428p ps=1.52u w=0.42u l=0.13u
X947 a_18380_7644# en[2] VGND.t491 VGND.t0 sg13_lv_nmos ad=0.187p pd=1.78u as=0.14875p ps=1.16u w=0.55u l=0.13u
X948 VGND.t93 sg13cmos5l_dfrbpq_1_57.RESET_B.t10 a_14916_8118# VGND.t94 sg13_lv_nmos ad=0.1626p pd=1.415u as=60.89999f ps=0.71u w=0.42u l=0.13u
X949 VPWR.t7 a_25871_6529# a_26128_6410# VPWR.t7 sg13_lv_pmos ad=1.46065p pd=9.335u as=79.8f ps=0.8u w=0.42u l=0.13u
X950 sg13cmos5l_and2_1_1.A a_18843_5410# VPWR.t1237 VPWR.t7 sg13_lv_pmos ad=0.2128p pd=1.5u as=0.2128p ps=1.5u w=1.12u l=0.13u
X951 a_7046_8118# a_7851_7691# a_7306_7648# VPWR.t2 sg13_lv_pmos ad=0.1428p pd=1.52u as=79.8f ps=0.8u w=0.42u l=0.13u
X952 a_7594_5374# sg13cmos5l_buf_8_9.A VPWR.t1039 VPWR.t7 sg13_lv_pmos ad=0.2128p pd=1.5u as=0.2128p ps=1.5u w=1.12u l=0.13u
X953 a_6518_2057# a_5340_1993# a_6122_1912# VGND.t475 sg13_lv_nmos ad=37.8f pd=0.6u as=0.1428p ps=1.52u w=0.42u l=0.13u
X954 VPWR.t1214 a_28174_5595# sg13cmos5l_dfrbpq_1_37.D VPWR.t7 sg13_lv_pmos ad=0.2254p pd=1.53u as=0.4256p ps=3u w=1.12u l=0.13u
X955 a_25103_6995# a_24261_6897# a_23844_7236# VPWR.t2 sg13_lv_pmos ad=0.2048p pd=1.63u as=0.34p ps=2.68u w=1u l=0.13u
X956 a_25509_849# sg13cmos5l_dfrbpq_1_0.CLK VPWR.t153 VPWR.t15 sg13_lv_pmos ad=0.4088p pd=2.97u as=1.46697p ps=9.345u w=1.12u l=0.13u
X957 a_28532_2680# a_28506_2578# sg13cmos5l_xnor2_1_3.A VPWR.t10 sg13_lv_pmos ad=0.2128p pd=1.5u as=0.3808p ps=2.92u w=1.12u l=0.13u
X958 VPWR.t935 sg13cmos5l_dfrbpq_1_21.RESET_B.t4 a_3590_3582# VPWR.t10 sg13_lv_pmos ad=0.36237p pd=2.605u as=79.8f ps=0.8u w=0.42u l=0.13u
X959 VGND.t137 sg13cmos5l_dfrbpq_1_2.Q a_23576_1673# VGND.t404 sg13_lv_nmos ad=79.8f pd=0.8u as=0.1428p ps=1.52u w=0.42u l=0.13u
X960 a_18153_4285# a_17796_4212# VPWR.t212 VPWR.t43 sg13_lv_pmos ad=63f pd=0.72u as=0.1563p ps=1.22u w=0.42u l=0.13u
X961 VGND.t50 a_4293_3873# a_4395_4016# VGND.t537 sg13_lv_nmos ad=3.8943p pd=24.355u as=0.2516p ps=2.16u w=0.74u l=0.13u
X962 sg13cmos5l_nand3_1_1.A sg13cmos5l_dfrbpq_1_57.D VGND.t238 VGND.t434 sg13_lv_nmos ad=0.1406p pd=1.12u as=0.3293p ps=1.63u w=0.74u l=0.13u
X963 a_6645_5564# sg13cmos5l_dfrbpq_1_58.RESET_B VPWR.t644 VPWR.t7 sg13_lv_pmos ad=0.147p pd=1.54u as=0.1563p ps=1.22u w=0.42u l=0.13u
X964 VPWR.t211 sg13cmos5l_buf_8_0.X a_18843_5410# VPWR.t7 sg13_lv_pmos ad=0.2128p pd=1.5u as=0.2128p ps=1.5u w=1.12u l=0.13u
X965 VPWR.t1037 a_7594_5374# sg13cmos5l_buf_8_4.A VPWR.t7 sg13_lv_pmos ad=0.2128p pd=1.5u as=0.2128p ps=1.5u w=1.12u l=0.13u
X966 a_13642_5374# sg13cmos5l_buf_8_0.X VGND.t179 VGND.t181 sg13_lv_nmos ad=0.2553p pd=2.17u as=0.1406p ps=1.12u w=0.74u l=0.13u
X967 VPWR.t718 sg13cmos5l_buf_1_4.X.t8 a_17510_3894# VPWR.t43 sg13_lv_pmos ad=0.36237p pd=2.605u as=79.8f ps=0.8u w=0.42u l=0.13u
X968 a_11488_4192# sg13cmos5l_dfrbpq_1_22.D a_11786_4192# VPWR.t43 sg13_lv_pmos ad=0.3808p pd=2.92u as=0.2128p ps=1.5u w=1.12u l=0.13u
X969 VGND.t0 a_10725_8409# a_10827_8552# VGND.t342 sg13_lv_nmos ad=3.41162p pd=21.215u as=0.2516p ps=2.16u w=0.74u l=0.13u
X970 VPWR.t7 a_16581_5385# a_16683_5528# VPWR.t7 sg13_lv_pmos ad=1.46065p pd=9.335u as=0.3864p ps=2.93u w=1.12u l=0.13u
X971 a_13676_6168# sg13cmos5l_dlygate4sd3_1_52.X VPWR.t632 VPWR.t7 sg13_lv_pmos ad=0.2128p pd=1.5u as=0.3864p ps=2.93u w=1.12u l=0.13u
X972 a_3680_5609# sg13cmos5l_and2_1_3.A a_3817_5452# VGND.t194 sg13_lv_nmos ad=0.2176p pd=1.96u as=0.1216p ps=1.02u w=0.64u l=0.13u
X973 a_3904_4656# sg13cmos5l_dlygate4sd3_1_23.X a_3692_4656# VPWR.t43 sg13_lv_pmos ad=0.2128p pd=1.5u as=0.2128p ps=1.5u w=1.12u l=0.13u
X974 sg13cmos5l_dfrbpq_1_11.CLK a_13563_874# VPWR.t469 VPWR.t15 sg13_lv_pmos ad=0.2128p pd=1.5u as=0.2128p ps=1.5u w=1.12u l=0.13u
X975 sg13cmos5l_dlygate4sd3_1_35.A a_5802_8728# VGND.t312 VGND.t1047 sg13_lv_nmos ad=0.2516p pd=2.16u as=0.1406p ps=1.12u w=0.74u l=0.13u
X976 VPWR.t425 a_11733_7727# a_10812_8041# VPWR.t2 sg13_lv_pmos ad=0.36237p pd=2.605u as=0.34p ps=2.68u w=1u l=0.13u
X977 a_21915_7309# a_21023_7188# a_21813_7076# VPWR.t2 sg13_lv_pmos ad=63f pd=0.72u as=79.8f ps=0.8u w=0.42u l=0.13u
X978 a_27225_8745# a_26283_8552# a_27023_8507# VPWR.t0 sg13_lv_pmos ad=93.45f pd=0.865u as=0.2048p ps=1.63u w=0.42u l=0.13u
X979 sg13cmos5l_dfrbpq_1_46.CLK a_18922_7644# VGND.t1015 VGND.t0 sg13_lv_nmos ad=0.1406p pd=1.12u as=0.2516p ps=2.16u w=0.74u l=0.13u
X980 VPWR.t288 sg13cmos5l_buf_1_0.X.t15 a_20362_8653# VPWR.t0 sg13_lv_pmos ad=0.1563p pd=1.22u as=0.147p ps=1.54u w=0.42u l=0.13u
X981 sg13cmos5l_dfrbpq_1_13.CLK a_6250_2350# VGND.t115 VGND.t1380 sg13_lv_nmos ad=0.1406p pd=1.12u as=0.2516p ps=2.16u w=0.74u l=0.13u
X982 VGND.t179 a_13642_5374# sg13cmos5l_and2_1_3.A VGND.t533 sg13_lv_nmos ad=0.1406p pd=1.12u as=0.1406p ps=1.12u w=0.74u l=0.13u
X983 VGND.t293 sg13cmos5l_buf_1_4.X.t4 a_24708_3582# VGND.t1279 sg13_lv_nmos ad=0.1626p pd=1.415u as=60.89999f ps=0.71u w=0.42u l=0.13u
X984 a_11276_4192# sg13cmos5l_dlygate4sd3_1_18.X a_11488_4192# VPWR.t43 sg13_lv_pmos ad=0.2128p pd=1.5u as=0.3808p ps=2.92u w=1.12u l=0.13u
X985 a_17231_6529# a_16389_6179# a_15972_6172# VPWR.t7 sg13_lv_pmos ad=0.2048p pd=1.63u as=0.34p ps=2.68u w=1u l=0.13u
X986 VGND.t35 sg13cmos5l_dfrbpq_1_13.CLK a_7103_1140# VGND.t752 sg13_lv_nmos ad=4.86777p pd=31.64u as=0.2516p ps=2.16u w=0.74u l=0.13u
X987 sg13cmos5l_buf_2_0.X a_19609_6942# VGND.t145 VGND.t1195 sg13_lv_nmos ad=0.1406p pd=1.12u as=0.1371p ps=1.12u w=0.74u l=0.13u
X988 VPWR.t496 sg13cmos5l_dfrbpq_1_2.D a_18144_4695# VPWR.t43 sg13_lv_pmos ad=0.2891p pd=1.695u as=0.1596p ps=1.22u w=0.84u l=0.13u
X989 VGND.t150 VPWR.t1450 VGND.t150 VGND.t1530 sg13_lv_nmos ad=0.1428p pd=1.52u as=0 ps=0 w=0.42u l=1u
X990 VPWR.t7 sg13cmos5l_dfrbpq_1_58.RESET_B a_5356_5406# VPWR.t7 sg13_lv_pmos ad=1.42587p pd=9.11u as=79.8f ps=0.8u w=0.42u l=0.13u
X991 VPWR.t214 sg13cmos5l_nor3_1_1.A a_16643_1168# VPWR.t15 sg13_lv_pmos ad=0.3808p pd=2.92u as=0.2464p ps=1.56u w=1.12u l=0.13u
X992 VGND.t465 sg13cmos5l_xnor2_1_2.A a_16469_2002# VGND.t153 sg13_lv_nmos ad=0.1898p pd=1.36u as=0.2516p ps=2.16u w=0.74u l=0.13u
X993 a_22066_8430# sg13cmos5l_buf_1_0.X.t14 VGND.t20 VGND.t146 sg13_lv_nmos ad=37.8f pd=0.6u as=79.8f ps=0.8u w=0.42u l=0.13u
X994 a_27442_5406# sg13cmos5l_dfrbpq_1_53.RESET_B.t3 VGND.t341 VGND.t200 sg13_lv_nmos ad=37.8f pd=0.6u as=79.8f ps=0.8u w=0.42u l=0.13u
X995 sg13cmos5l_xnor2_1_0.A sg13cmos5l_xor2_1_1.B a_1434_3502# VGND.t1122 sg13_lv_nmos ad=0.1628p pd=1.18u as=88.8f ps=0.98u w=0.74u l=0.13u
X996 a_2016_4209# sg13cmos5l_xnor2_1_0.Y a_1979_3940# VGND.t1442 sg13_lv_nmos ad=0.2176p pd=1.96u as=78.39999f ps=0.885u w=0.64u l=0.13u
X997 a_15850_3862# osc VPWR.t1000 VPWR.t43 sg13_lv_pmos ad=0.2128p pd=1.5u as=0.2128p ps=1.5u w=1.12u l=0.13u
X998 VGND.t572 sg13cmos5l_dfrbpq_1_22.D sg13cmos5l_nand3_1_3.B VGND.t718 sg13_lv_nmos ad=0.3293p pd=1.63u as=0.1406p ps=1.12u w=0.74u l=0.13u
X999 a_11567_5483# a_10725_5385# a_10308_5724# VPWR.t7 sg13_lv_pmos ad=0.2048p pd=1.63u as=0.34p ps=2.68u w=1u l=0.13u
X1000 a_11733_4703# a_10791_4743# a_11639_4703# VPWR.t43 sg13_lv_pmos ad=79.8f pd=0.8u as=0.1428p ps=1.52u w=0.42u l=0.13u
X1001 VGND.t30 VPWR.t1464 VGND.t30 VGND.t1489 sg13_lv_nmos ad=0.1428p pd=1.52u as=0 ps=0 w=0.42u l=1u
X1002 VGND.t273 a_26896_7922# a_26545_8041# VGND.t300 sg13_lv_nmos ad=79.8f pd=0.8u as=0.1428p ps=1.52u w=0.42u l=0.13u
X1003 VGND.t363 a_5301_1028# a_4380_834# VGND.t362 sg13_lv_nmos ad=0.1626p pd=1.415u as=0.2516p ps=2.16u w=0.74u l=0.13u
X1004 a_26830_2571# a_26945_2572# VPWR.t129 VPWR.t10 sg13_lv_pmos ad=0.34p pd=2.68u as=0.2254p ps=1.53u w=1u l=0.5u
X1005 a_10791_6255# a_10943_6139# VPWR.t7 VPWR.t7 sg13_lv_pmos ad=0.3864p pd=2.93u as=1.46065p ps=9.335u w=1.12u l=0.13u
X1006 a_13783_1596# a_14343_1719# a_14364_1993# VGND.t151 sg13_lv_nmos ad=0.12665p pd=1.145u as=0.3473p ps=2.71u w=0.74u l=0.13u
X1007 a_17518_7947# a_17633_7946# VGND.t874 VGND.t0 sg13_lv_nmos ad=0.1428p pd=1.52u as=0.1426p ps=1.16u w=0.42u l=0.5u
X1008 VPWR.t939 a_8768_6427# sg13cmos5l_buf_8_9.A VPWR.t7 sg13_lv_pmos ad=0.1918p pd=1.5u as=0.3808p ps=2.92u w=1.12u l=0.13u
X1009 sg13cmos5l_nand3_1_3.B sg13cmos5l_dlygate4sd3_1_18.X VGND.t572 VGND.t1202 sg13_lv_nmos ad=0.1406p pd=1.12u as=0.3293p ps=1.63u w=0.74u l=0.13u
X1010 a_20192_7967# a_20311_7644# VPWR.t766 VPWR.t2 sg13_lv_pmos ad=0.3864p pd=2.93u as=0.2128p ps=1.5u w=1.12u l=0.13u
X1011 a_25797_7691# sg13cmos5l_dfrbpq_1_53.CLK VGND.t0 VGND.t1311 sg13_lv_nmos ad=0.2516p pd=2.16u as=3.2221p ps=20.04u w=0.74u l=0.13u
X1012 a_10534_6931# sg13cmos5l_dfrbpq_1_57.RESET_B.t8 VGND.t558 VGND.t654 sg13_lv_nmos ad=37.8f pd=0.6u as=0.1701p ps=1.65u w=0.42u l=0.13u
X1013 a_5258_5094# a_4951_4620# a_5164_5094# VGND.t30 sg13_lv_nmos ad=37.8f pd=0.6u as=0.1428p ps=1.52u w=0.42u l=0.13u
X1014 a_19833_2697# a_18891_2504# a_19631_2459# VPWR.t10 sg13_lv_pmos ad=93.45f pd=0.865u as=0.2048p ps=1.63u w=0.42u l=0.13u
X1015 a_24900_6593# a_25131_6179# a_24586_6136# VGND.t1658 sg13_lv_nmos ad=0.2373p pd=1.97u as=79.8f ps=0.8u w=0.42u l=0.13u
X1016 a_27280_4898# sg13cmos5l_dfrbpq_1_53.RESET_B.t1 VPWR.t43 VPWR.t43 sg13_lv_pmos ad=79.8f pd=0.8u as=1.3927p ps=8.9u w=0.42u l=0.13u
X1017 VPWR.t43 a_21647_3971# a_21904_4114# VPWR.t43 sg13_lv_pmos ad=1.3927p pd=8.9u as=79.8f ps=0.8u w=0.42u l=0.13u
X1018 VPWR.t122 a_3878_7680# a_3990_7704# VPWR.t2 sg13_lv_pmos ad=0.2254p pd=1.53u as=0.34p ps=2.68u w=1u l=0.5u
X1019 VGND.t58 a_27195_3514# sg13cmos5l_dfrbpq_1_0.CLK VGND.t263 sg13_lv_nmos ad=0.1406p pd=1.12u as=0.1406p ps=1.12u w=0.74u l=0.13u
X1020 a_13642_5374# sg13cmos5l_buf_8_0.X VPWR.t206 VPWR.t7 sg13_lv_pmos ad=0.2128p pd=1.5u as=0.2128p ps=1.5u w=1.12u l=0.13u
X1021 VGND.t25 a_20805_6179# a_20907_6179# VGND.t1300 sg13_lv_nmos ad=3.51837p pd=21.815u as=0.2516p ps=2.16u w=0.74u l=0.13u
X1022 VGND.t40 VPWR.t1476 VGND.t40 VGND.t1462 sg13_lv_nmos ad=79.8f pd=0.8u as=0 ps=0 w=0.42u l=1u
X1023 a_5134_8118# a_4876_8118# VGND.t358 VGND.t1048 sg13_lv_nmos ad=0.1428p pd=1.52u as=79.8f ps=0.8u w=0.42u l=0.13u
X1024 a_6180_6172# a_6154_6136# VGND.t25 VGND.t1271 sg13_lv_nmos ad=0.2516p pd=2.16u as=0.1626p ps=1.415u w=0.74u l=0.13u
X1025 a_11769_1185# a_10827_992# a_11567_947# VPWR.t15 sg13_lv_pmos ad=93.45f pd=0.865u as=0.2048p ps=1.63u w=0.42u l=0.13u
X1026 VPWR.t1174 sg13cmos5l_buf_8_5.A a_9915_3898# VPWR.t43 sg13_lv_pmos ad=0.2128p pd=1.5u as=0.3808p ps=2.92u w=1.12u l=0.13u
X1027 a_8842_6886# sg13cmos5l_buf_8_10.A VPWR.t960 VPWR.t2 sg13_lv_pmos ad=0.2128p pd=1.5u as=0.2128p ps=1.5u w=1.12u l=0.13u
X1028 VPWR.t7 a_21904_5626# a_21849_5721# VPWR.t7 sg13_lv_pmos ad=1.46065p pd=9.335u as=93.45f ps=0.865u w=0.42u l=0.13u
X1029 sg13cmos5l_buf_1_0.A.t0 a_1384_8468# VPWR.t158 VPWR.t0 sg13_lv_pmos ad=0.42p pd=2.99u as=0.2114p ps=1.54u w=1.12u l=0.13u
X1030 VPWR.t8 VGND.t203 VPWR.t8 VPWR.t7 sg13_lv_pmos ad=0.19p pd=1.38u as=0 ps=0 w=1u l=1u
X1031 a_23846_1632# a_23576_1673# VPWR.t184 VPWR.t15 sg13_lv_pmos ad=0.34p pd=2.68u as=0.1523p ps=1.38u w=1u l=0.5u
X1032 a_10725_849# sg13cmos5l_dfrbpq_1_11.CLK VGND.t35 VGND.t1346 sg13_lv_nmos ad=0.2516p pd=2.16u as=5.40863p ps=35.155u w=0.74u l=0.13u
X1033 a_26181_4667# sg13cmos5l_dfrbpq_1_53.CLK VPWR.t43 VPWR.t43 sg13_lv_pmos ad=0.4088p pd=2.97u as=1.3927p ps=8.9u w=1.12u l=0.13u
X1034 a_18293_5026# sg13cmos5l_dfrbpq_1_2.D VGND.t133 VGND.t539 sg13_lv_nmos ad=0.1406p pd=1.12u as=0.1898p ps=1.36u w=0.74u l=0.13u
X1035 sg13cmos5l_dlygate4sd3_1_15.A a_22314_4192# VGND.t54 VGND.t202 sg13_lv_nmos ad=0.2516p pd=2.16u as=0.1406p ps=1.12u w=0.74u l=0.13u
X1036 VGND.t278 VPWR.t1471 VGND.t278 VGND.t1474 sg13_lv_nmos ad=0.1428p pd=1.52u as=0 ps=0 w=0.42u l=1u
X1037 VGND.t179 a_13862_4656# a_13974_4680# VGND.t656 sg13_lv_nmos ad=0.1426p pd=1.16u as=0.1428p ps=1.52u w=0.42u l=0.5u
X1038 VGND.t143 a_21904_4898# a_21553_5017# VGND.t142 sg13_lv_nmos ad=79.8f pd=0.8u as=0.1428p ps=1.52u w=0.42u l=0.13u
X1039 a_10231_3108# a_10791_3231# a_10812_3505# VGND.t693 sg13_lv_nmos ad=0.12665p pd=1.145u as=0.3473p ps=2.71u w=0.74u l=0.13u
X1040 a_17584_7138# a_17327_6995# a_17746_6918# VGND.t243 sg13_lv_nmos ad=0.1428p pd=1.52u as=37.8f ps=0.6u w=0.42u l=0.13u
X1041 VPWR.t1080 a_9446_3144# a_9558_3168# VPWR.t10 sg13_lv_pmos ad=0.2254p pd=1.53u as=0.34p ps=2.68u w=1u l=0.5u
X1042 VPWR.t542 a_24608_1919# sg13cmos5l_dlygate4sd3_1_16.A VPWR.t15 sg13_lv_pmos ad=0.2128p pd=1.5u as=0.3808p ps=2.92u w=1.12u l=0.13u
X1043 VGND.t11 a_28262_1632# a_28374_1656# VGND.t162 sg13_lv_nmos ad=0.1426p pd=1.16u as=0.1428p ps=1.52u w=0.42u l=0.5u
X1044 a_11639_2773# sg13cmos5l_dfrbpq_1_55.RESET_B VPWR.t527 VPWR.t10 sg13_lv_pmos ad=79.8f pd=0.8u as=0.36237p ps=2.605u w=0.42u l=0.13u
X1045 a_20973_3492# sg13cmos5l_and2_1_1.A VPWR.t881 VPWR.t10 sg13_lv_pmos ad=0.1596p pd=1.22u as=0.2856p ps=2.36u w=0.84u l=0.13u
X1046 a_7995_8821# a_7103_8700# a_7893_8588# VPWR.t0 sg13_lv_pmos ad=63f pd=0.72u as=79.8f ps=0.8u w=0.42u l=0.13u
X1047 VPWR.t191 a_17472_1671# sg13cmos5l_xnor2_1_1.Y VPWR.t15 sg13_lv_pmos ad=0.3808p pd=2.92u as=0.2408p ps=1.55u w=1.12u l=0.13u
X1048 a_13574_2382# a_14379_2504# a_13834_2605# VPWR.t10 sg13_lv_pmos ad=0.1428p pd=1.52u as=79.8f ps=0.8u w=0.42u l=0.13u
X1049 a_18144_4695# sg13cmos5l_dfrbpq_1_2.D a_18107_5004# VGND.t538 sg13_lv_nmos ad=0.2176p pd=1.96u as=78.39999f ps=0.885u w=0.64u l=0.13u
X1050 a_7799_4285# a_7103_4164# a_7893_4052# VGND.t1682 sg13_lv_nmos ad=0.1296p pd=1.52u as=79.8f ps=0.8u w=0.42u l=0.13u
X1051 a_10702_8118# a_10943_7651# a_10231_7644# VGND.t797 sg13_lv_nmos ad=0.1428p pd=1.52u as=0.12665p ps=1.145u w=0.42u l=0.13u
X1052 a_18778_6132# sg13cmos5l_dfrbpq_1_38.Q VGND.t145 VGND.t1297 sg13_lv_nmos ad=0.1428p pd=1.52u as=79.8f ps=0.8u w=0.42u l=0.13u
X1053 a_6555_4703# a_5663_4627# a_6453_4703# VPWR.t43 sg13_lv_pmos ad=63f pd=0.72u as=79.8f ps=0.8u w=0.42u l=0.13u
X1054 VGND.t77 sg13cmos5l_dfrbpq_1_11.CLK a_14495_1603# VGND.t1347 sg13_lv_nmos ad=3.06955p pd=19.355u as=0.2516p ps=2.16u w=0.74u l=0.13u
X1055 a_8763_8434# sg13cmos5l_buf_8_4.A VGND.t741 VGND.t89 sg13_lv_nmos ad=0.1406p pd=1.12u as=0.1406p ps=1.12u w=0.74u l=0.13u
X1056 a_7332_7684# a_7306_7648# VGND.t856 VGND.t431 sg13_lv_nmos ad=0.2516p pd=2.16u as=0.1626p ps=1.415u w=0.74u l=0.13u
X1057 VGND.t350 sg13cmos5l_dfrbpq_1_56.RESET_B a_15972_5406# VGND.t835 sg13_lv_nmos ad=0.1626p pd=1.415u as=60.89999f ps=0.71u w=0.42u l=0.13u
X1058 sg13cmos5l_buf_8_3.A a_9915_3898# VGND.t50 VGND.t1579 sg13_lv_nmos ad=0.1406p pd=1.12u as=0.1406p ps=1.12u w=0.74u l=0.13u
X1059 a_3799_2346# a_4359_2600# a_4380_2346# VGND.t269 sg13_lv_nmos ad=0.12665p pd=1.145u as=0.3473p ps=2.71u w=0.74u l=0.13u
X1060 VPWR.t522 a_10812_3505# a_11835_3191# VPWR.t10 sg13_lv_pmos ad=0.1563p pd=1.22u as=63f ps=0.72u w=0.42u l=0.13u
X1061 sg13cmos5l_buf_1_11.A a_1000_8468# VGND.t121 VGND.t1218 sg13_lv_nmos ad=0.2886p pd=2.26u as=0.14875p ps=1.16u w=0.74u l=0.13u
X1062 a_8591_8041# a_7749_7691# a_7332_7684# VPWR.t2 sg13_lv_pmos ad=0.2048p pd=1.63u as=0.34p ps=2.68u w=1u l=0.13u
X1063 a_25360_7138# a_25103_6995# a_25522_6918# VGND.t1633 sg13_lv_nmos ad=0.1428p pd=1.52u as=37.8f ps=0.6u w=0.42u l=0.13u
X1064 a_6363_1679# a_5471_1603# a_6261_1679# VPWR.t15 sg13_lv_pmos ad=63f pd=0.72u as=79.8f ps=0.8u w=0.42u l=0.13u
X1065 VPWR.t91 a_9232_2602# a_9177_2697# VPWR.t10 sg13_lv_pmos ad=1.43285p pd=9.125u as=93.45f ps=0.865u w=0.42u l=0.13u
X1066 a_20388_8748# a_20362_8653# VGND.t325 VGND.t0 sg13_lv_nmos ad=0.2516p pd=2.16u as=0.1626p ps=1.415u w=0.74u l=0.13u
X1067 a_19246_6435# a_19361_6434# VGND.t145 VGND.t208 sg13_lv_nmos ad=0.1428p pd=1.52u as=0.1426p ps=1.16u w=0.42u l=0.5u
X1068 VGND.t96 sg13cmos5l_dfrbpq_1_57.RESET_B.t4 a_11990_6593# VGND.t97 sg13_lv_nmos ad=0.1701p pd=1.65u as=37.8f ps=0.6u w=0.42u l=0.13u
X1069 a_20745_4285# a_20388_4212# VPWR.t148 VPWR.t43 sg13_lv_pmos ad=63f pd=0.72u as=0.1563p ps=1.22u w=0.42u l=0.13u
X1070 a_4544_7967# a_4663_7644# VPWR.t349 VPWR.t2 sg13_lv_pmos ad=0.3864p pd=2.93u as=0.2128p ps=1.5u w=1.12u l=0.13u
X1071 a_11824_7138# sg13cmos5l_dfrbpq_1_57.RESET_B.t7 VPWR.t2 VPWR.t2 sg13_lv_pmos ad=79.8f pd=0.8u as=1.31957p ps=8.38u w=0.42u l=0.13u
X1072 a_11567_6995# a_10725_6897# a_11473_6995# VGND.t924 sg13_lv_nmos ad=0.12665p pd=1.145u as=0.1428p ps=1.52u w=0.42u l=0.13u
X1073 VGND.t630 sg13cmos5l_dlygate4sd3_1_28.A a_9176_6209# VGND.t789 sg13_lv_nmos ad=79.8f pd=0.8u as=0.1428p ps=1.52u w=0.42u l=0.13u
X1074 sg13cmos5l_and2_1_3.A a_13642_5374# VPWR.t489 VPWR.t7 sg13_lv_pmos ad=0.2128p pd=1.5u as=0.2128p ps=1.5u w=1.12u l=0.13u
X1075 a_7716_2700# a_8235_2504# a_8975_2459# VGND.t1412 sg13_lv_nmos ad=0.3473p pd=2.71u as=0.12665p ps=1.145u w=0.74u l=0.13u
X1076 a_5207_2773# a_4511_2652# a_5301_2540# VGND.t270 sg13_lv_nmos ad=0.1296p pd=1.52u as=79.8f ps=0.8u w=0.42u l=0.13u
X1077 a_20362_8653# a_20805_8409# a_20102_8430# VGND.t0 sg13_lv_nmos ad=79.8f pd=0.8u as=0.1296p ps=1.52u w=0.42u l=0.13u
X1078 sg13cmos5l_dfrbpq_1_57.CLK a_8842_6886# VPWR.t956 VPWR.t2 sg13_lv_pmos ad=0.2128p pd=1.5u as=0.2128p ps=1.5u w=1.12u l=0.13u
X1079 a_24708_2395# a_24420_2700# a_24646_2395# VGND.t344 sg13_lv_nmos ad=0.1428p pd=1.52u as=37.8f ps=0.6u w=0.42u l=0.13u
X1080 a_10231_3108# a_10791_3231# a_10702_3267# VPWR.t10 sg13_lv_pmos ad=0.2048p pd=1.63u as=93.45f ps=0.865u w=0.42u l=0.13u
X1081 VGND.t197 a_27963_6538# sg13cmos5l_dfrbpq_1_53.CLK VGND.t1564 sg13_lv_nmos ad=0.2516p pd=2.16u as=0.1406p ps=1.12u w=0.74u l=0.13u
X1082 a_25478_5094# sg13cmos5l_dlygate4sd3_1_17.X VPWR.t1403 VPWR.t43 sg13_lv_pmos ad=79.8f pd=0.8u as=0.1428p ps=1.52u w=0.42u l=0.13u
X1083 a_23846_3144# a_23576_3185# VGND.t54 VGND.t53 sg13_lv_nmos ad=0.1428p pd=1.52u as=79.8f ps=0.8u w=0.42u l=0.5u
X1084 a_17211_4703# a_16319_4627# a_17109_4703# VPWR.t43 sg13_lv_pmos ad=63f pd=0.72u as=79.8f ps=0.8u w=0.42u l=0.13u
X1085 sg13cmos5l_dlygate4sd3_1_50.A a_12234_5704# VGND.t83 VGND.t523 sg13_lv_nmos ad=0.2516p pd=2.16u as=0.1406p ps=1.12u w=0.74u l=0.13u
X1086 VPWR.t153 a_26608_1090# a_26553_1185# VPWR.t15 sg13_lv_pmos ad=1.50275p pd=9.57u as=93.45f ps=0.865u w=0.42u l=0.13u
X1087 VPWR.t19 VGND.t150 VPWR.t17 VPWR.t15 sg13_lv_pmos ad=0.19p pd=1.38u as=0 ps=0 w=1u l=1u
X1088 a_3850_3112# a_4293_3155# a_3590_3582# VGND.t536 sg13_lv_nmos ad=79.8f pd=0.8u as=0.1296p ps=1.52u w=0.42u l=0.13u
X1089 a_26853_6897# sg13cmos5l_dfrbpq_1_53.CLK VPWR.t2 VPWR.t2 sg13_lv_pmos ad=0.4088p pd=2.97u as=1.31957p ps=8.38u w=1.12u l=0.13u
X1090 sg13cmos5l_dlygate4sd3_1_6.X a_21174_1656# VPWR.t95 VPWR.t15 sg13_lv_pmos ad=0.4256p pd=3u as=0.2254p ps=1.53u w=1.12u l=0.13u
X1091 VPWR.t839 sg13cmos5l_dfrbpq_1_58.RESET_B a_5894_6606# VPWR.t7 sg13_lv_pmos ad=0.36237p pd=2.605u as=79.8f ps=0.8u w=0.42u l=0.13u
X1092 a_27022_6435# a_27137_6434# VGND.t45 VGND.t543 sg13_lv_nmos ad=0.1428p pd=1.52u as=0.1426p ps=1.16u w=0.42u l=0.5u
X1093 VGND.t52 a_4832_4943# sg13cmos5l_dfrbpq_1_58.Q VGND.t30 sg13_lv_nmos ad=0.1406p pd=1.12u as=0.2516p ps=2.16u w=0.74u l=0.13u
X1094 sg13cmos5l_dfrbpq_1_11.Q a_12234_1168# VGND.t119 VGND.t118 sg13_lv_nmos ad=0.2516p pd=2.16u as=0.1406p ps=1.12u w=0.74u l=0.13u
X1095 sg13cmos5l_nand3_1_2.B sg13cmos5l_nor4_2_7.D a_24170_5704# VPWR.t7 sg13_lv_pmos ad=0.2128p pd=1.5u as=0.3808p ps=2.92u w=1.12u l=0.13u
X1096 VPWR.t129 a_26830_2571# sg13cmos5l_nor4_2_0.B VPWR.t10 sg13_lv_pmos ad=0.2254p pd=1.53u as=0.4256p ps=3u w=1.12u l=0.13u
X1097 VPWR.t156 a_2054_8434# a_2166_8498# VPWR.t0 sg13_lv_pmos ad=0.2254p pd=1.53u as=0.34p ps=2.68u w=1u l=0.5u
X1098 VPWR.t7 a_27023_5483# a_27280_5626# VPWR.t7 sg13_lv_pmos ad=1.46065p pd=9.335u as=79.8f ps=0.8u w=0.42u l=0.13u
X1099 VPWR.t44 VGND.t30 VPWR.t247 VPWR.t43 sg13_lv_pmos ad=0.34p pd=2.68u as=0 ps=0 w=1u l=1u
X1100 VGND.t728 sg13cmos5l_dlygate4sd3_1_33.A a_3608_7721# VGND.t931 sg13_lv_nmos ad=79.8f pd=0.8u as=0.1428p ps=1.52u w=0.42u l=0.13u
X1101 a_10444_6606# a_10231_6132# VPWR.t7 VPWR.t7 sg13_lv_pmos ad=79.8f pd=0.8u as=1.46065p ps=9.335u w=0.42u l=0.13u
X1102 sg13cmos5l_nor4_2_1.D a_17814_3168# VPWR.t602 VPWR.t10 sg13_lv_pmos ad=0.4256p pd=3u as=0.2254p ps=1.53u w=1.12u l=0.13u
X1103 a_20676_5081# a_20907_4667# a_20362_4624# VGND.t708 sg13_lv_nmos ad=0.2373p pd=1.97u as=79.8f ps=0.8u w=0.42u l=0.13u
X1104 sg13cmos5l_dfrbpq_1_53.CLK a_27963_6538# VPWR.t1315 VPWR.t7 sg13_lv_pmos ad=0.2128p pd=1.5u as=0.2128p ps=1.5u w=1.12u l=0.13u
X1105 a_15488_4943# a_15607_4620# VGND.t350 VGND.t1377 sg13_lv_nmos ad=0.2516p pd=2.16u as=0.1406p ps=1.12u w=0.74u l=0.13u
X1106 VPWR.t699 a_6250_2350# sg13cmos5l_dfrbpq_1_13.CLK VPWR.t10 sg13_lv_pmos ad=0.2128p pd=1.5u as=0.2128p ps=1.5u w=1.12u l=0.13u
X1107 a_6862_3894# a_6604_3894# VGND.t50 VGND.t193 sg13_lv_nmos ad=0.1428p pd=1.52u as=79.8f ps=0.8u w=0.42u l=0.13u
X1108 sg13cmos5l_dlygate4sd3_1_53.A a_8202_7216# VGND.t418 VGND.t954 sg13_lv_nmos ad=0.2516p pd=2.16u as=0.1406p ps=1.12u w=0.74u l=0.13u
X1109 sg13cmos5l_dlygate4sd3_1_51.A a_22314_5704# VPWR.t8 VPWR.t7 sg13_lv_pmos ad=0.3808p pd=2.92u as=0.2128p ps=1.5u w=1.12u l=0.13u
X1110 a_24170_5704# sg13cmos5l_dlygate4sd3_1_9.X a_23872_5704# VPWR.t7 sg13_lv_pmos ad=0.2128p pd=1.5u as=0.2128p ps=1.5u w=1.12u l=0.13u
X1111 sg13cmos5l_xnor2_1_0.Y a_15756_1060# VPWR.t214 VPWR.t15 sg13_lv_pmos ad=0.2408p pd=1.55u as=0.3808p ps=2.92u w=1.12u l=0.13u
X1112 VGND.t332 a_14235_6922# sg13cmos5l_buf_8_10.A VGND.t95 sg13_lv_nmos ad=0.1406p pd=1.12u as=0.1406p ps=1.12u w=0.74u l=0.13u
X1113 a_5337_3267# a_4395_3155# a_5135_3505# VPWR.t10 sg13_lv_pmos ad=93.45f pd=0.865u as=0.2048p ps=1.63u w=0.42u l=0.13u
X1114 VGND.t90 sg13cmos5l_dfrbpq_1_57.RESET_B.t14 a_10116_8430# VGND.t89 sg13_lv_nmos ad=0.1626p pd=1.415u as=60.89999f ps=0.71u w=0.42u l=0.13u
X1115 a_9446_6168# a_9176_6209# VPWR.t719 VPWR.t7 sg13_lv_pmos ad=0.34p pd=2.68u as=0.1523p ps=1.38u w=1u l=0.5u
X1116 a_17614_8619# a_17729_8620# VGND.t874 VGND.t0 sg13_lv_nmos ad=0.1428p pd=1.52u as=0.1426p ps=1.16u w=0.42u l=0.5u
X1117 a_20196_8430# sg13cmos5l_dlygate4sd3_1_6.X a_20102_8430# VGND.t0 sg13_lv_nmos ad=60.89999f pd=0.71u as=0.1428p ps=1.52u w=0.42u l=0.13u
X1118 a_1623_7216# sg13cmos5l_nor3_1_2.B a_1509_7216# VPWR.t2 sg13_lv_pmos ad=0.2128p pd=1.5u as=0.2464p ps=1.56u w=1.12u l=0.13u
X1119 a_7641_6291# a_6699_6179# a_7439_6529# VPWR.t7 sg13_lv_pmos ad=93.45f pd=0.865u as=0.2048p ps=1.63u w=0.42u l=0.13u
X1120 a_11639_3191# sg13cmos5l_dfrbpq_1_17.D a_12386_3582# VGND.t1194 sg13_lv_nmos ad=0.1428p pd=1.52u as=60.89999f ps=0.71u w=0.42u l=0.13u
X1121 sg13cmos5l_buf_8_3.A a_9915_3898# VGND.t50 VGND.t1575 sg13_lv_nmos ad=0.1406p pd=1.12u as=0.1406p ps=1.12u w=0.74u l=0.13u
X1122 a_25572_5406# sg13cmos5l_dlygate4sd3_1_11.X a_25478_5406# VGND.t142 sg13_lv_nmos ad=60.89999f pd=0.71u as=0.1428p ps=1.52u w=0.42u l=0.13u
X1123 VPWR.t737 sg13cmos5l_xnor2_1_3.A a_18444_1060# VPWR.t15 sg13_lv_pmos ad=0.4536p pd=2.76u as=0.1596p ps=1.22u w=0.84u l=0.13u
X1124 a_4640_1919# a_4759_1596# VGND.t205 VGND.t1663 sg13_lv_nmos ad=0.2516p pd=2.16u as=0.1406p ps=1.12u w=0.74u l=0.13u
X1125 a_10538_2382# a_10231_2346# a_10444_2382# VGND.t1544 sg13_lv_nmos ad=37.8f pd=0.6u as=0.1428p ps=1.52u w=0.42u l=0.13u
X1126 a_11639_3191# sg13cmos5l_dfrbpq_1_55.RESET_B VPWR.t521 VPWR.t10 sg13_lv_pmos ad=79.8f pd=0.8u as=0.36237p ps=2.605u w=0.42u l=0.13u
X1127 a_13916_4192# sg13cmos5l_xor2_1_2.B VPWR.t621 VPWR.t43 sg13_lv_pmos ad=0.2128p pd=1.5u as=0.2128p ps=1.5u w=1.12u l=0.13u
X1128 a_18213_3873# sg13cmos5l_dfrbpq_1_2.CLK VPWR.t43 VPWR.t43 sg13_lv_pmos ad=0.4088p pd=2.97u as=1.36105p ps=8.695u w=1.12u l=0.13u
X1129 VPWR.t34 VGND.t40 VPWR.t36 VPWR.t2 sg13_lv_pmos ad=0.19p pd=1.38u as=0 ps=0 w=1u l=1u
X1130 VPWR.t200 a_8853_1679# a_7932_1993# VPWR.t15 sg13_lv_pmos ad=0.36237p pd=2.605u as=0.34p ps=2.68u w=1u l=0.13u
X1131 sg13cmos5l_dfrbpq_1_13.CLK a_6250_2350# VPWR.t1229 VPWR.t10 sg13_lv_pmos ad=0.2128p pd=1.5u as=0.2128p ps=1.5u w=1.12u l=0.13u
X1132 VGND.t393 a_11824_1874# a_11473_1993# VGND.t392 sg13_lv_nmos ad=79.8f pd=0.8u as=0.1428p ps=1.52u w=0.42u l=0.13u
X1133 a_26121_4703# a_25764_4660# VPWR.t312 VPWR.t43 sg13_lv_pmos ad=63f pd=0.72u as=0.1563p ps=1.22u w=0.42u l=0.13u
X1134 sg13cmos5l_dlygate4sd3_1_2.A a_27114_4192# VGND.t58 VGND.t727 sg13_lv_nmos ad=0.2516p pd=2.16u as=0.1406p ps=1.12u w=0.74u l=0.13u
X1135 a_14235_6922# sg13cmos5l_and2_1_4.X VGND.t332 VGND.t95 sg13_lv_nmos ad=0.1406p pd=1.12u as=0.1406p ps=1.12u w=0.74u l=0.13u
X1136 sg13cmos5l_dfrbpq_1_58.D a_4470_5474# VGND.t52 VGND.t195 sg13_lv_nmos ad=0.2516p pd=2.16u as=0.1426p ps=1.16u w=0.74u l=0.13u
X1137 VGND.t203 VPWR.t8 VGND.t203 VGND.t142 sg13_lv_nmos ad=79.8f pd=0.8u as=0 ps=0 w=0.42u l=1u
X1138 a_7046_8118# sg13cmos5l_nor4_2_5.C VPWR.t979 VPWR.t2 sg13_lv_pmos ad=79.8f pd=0.8u as=0.1428p ps=1.52u w=0.42u l=0.13u
X1139 VGND.t145 a_18363_6922# sg13cmos5l_dfrbpq_1_56.CLK VGND.t980 sg13_lv_nmos ad=0.1406p pd=1.12u as=0.1406p ps=1.12u w=0.74u l=0.13u
X1140 VPWR.t1 a_20805_8409# a_20907_8552# VPWR.t0 sg13_lv_pmos ad=1.8922p pd=12.27u as=0.3864p ps=2.93u w=1.12u l=0.13u
X1141 VGND.t30 sg13cmos5l_dfrbpq_1_23.D a_1397_5026# VGND.t30 sg13_lv_nmos ad=0.1898p pd=1.36u as=0.2516p ps=2.16u w=0.74u l=0.13u
X1142 VGND.t11 sg13cmos5l_dfrbpq_1_0.D a_28662_2398# VGND.t804 sg13_lv_nmos ad=0.15245p pd=1.17u as=88.8f ps=0.98u w=0.74u l=0.13u
X1143 sg13cmos5l_nor4_2_0.C a_23958_3962# VGND.t851 VGND.t202 sg13_lv_nmos ad=0.2516p pd=2.16u as=0.1426p ps=1.16u w=0.74u l=0.13u
X1144 a_17796_4212# a_17770_4117# VPWR.t718 VPWR.t43 sg13_lv_pmos ad=0.34p pd=2.68u as=0.36237p ps=2.605u w=1u l=0.13u
X1145 VPWR.t221 sg13cmos5l_nand3_1_2.Y a_24780_5596# VPWR.t7 sg13_lv_pmos ad=0.4536p pd=2.76u as=0.1596p ps=1.22u w=0.84u l=0.13u
X1146 a_24586_6136# a_25029_6179# a_24969_6215# VPWR.t7 sg13_lv_pmos ad=79.8f pd=0.8u as=63f ps=0.72u w=0.42u l=0.13u
X1147 VGND.t112 sg13cmos5l_buf_1_1.X.t4 a_25034_2070# VGND.t111 sg13_lv_nmos ad=79.8f pd=0.8u as=37.8f ps=0.6u w=0.42u l=0.13u
X1148 a_17842_5406# sg13cmos5l_dfrbpq_1_56.RESET_B VGND.t824 VGND.t831 sg13_lv_nmos ad=37.8f pd=0.6u as=79.8f ps=0.8u w=0.42u l=0.13u
X1149 a_21849_4779# a_20907_4667# a_21647_5017# VPWR.t43 sg13_lv_pmos ad=93.45f pd=0.865u as=0.2048p ps=1.63u w=0.42u l=0.13u
X1150 a_18278_3582# a_19083_3155# a_18538_3112# VPWR.t10 sg13_lv_pmos ad=0.1428p pd=1.52u as=79.8f ps=0.8u w=0.42u l=0.13u
X1151 a_18363_6922# sg13cmos5l_buf_8_10.A VGND.t191 VGND.t1084 sg13_lv_nmos ad=0.1406p pd=1.12u as=0.1406p ps=1.12u w=0.74u l=0.13u
X1152 a_19893_1679# a_18951_1719# a_19754_1912# VGND.t401 sg13_lv_nmos ad=79.8f pd=0.8u as=0.2373p ps=1.97u w=0.42u l=0.13u
X1153 a_4293_8409# sg13cmos5l_dfrbpq_1_32.CLK VPWR.t1 VPWR.t0 sg13_lv_pmos ad=0.4088p pd=2.97u as=1.82695p ps=11.845u w=1.12u l=0.13u
X1154 a_15127_8394# a_15687_8648# a_15708_8394# VGND.t925 sg13_lv_nmos ad=0.12665p pd=1.145u as=0.3473p ps=2.71u w=0.74u l=0.13u
X1155 VPWR.t79 VGND.t54 VPWR.t79 VPWR.t10 sg13_lv_pmos ad=0.34p pd=2.68u as=0 ps=0 w=1u l=1u
X1156 VPWR.t79 a_21435_3514# sg13cmos5l_buf_8_2.X VPWR.t10 sg13_lv_pmos ad=0.2128p pd=1.5u as=0.2128p ps=1.5u w=1.12u l=0.13u
X1157 sg13cmos5l_dlygate4sd3_1_13.A a_20490_3144# VPWR.t815 VPWR.t10 sg13_lv_pmos ad=0.3808p pd=2.92u as=0.2128p ps=1.5u w=1.12u l=0.13u
X1158 a_6633_7309# a_6276_7236# VPWR.t836 VPWR.t2 sg13_lv_pmos ad=63f pd=0.72u as=0.1563p ps=1.22u w=0.42u l=0.13u
X1159 sg13cmos5l_nor4_2_9.Y sg13cmos5l_dlygate4sd3_1_23.X VGND.t52 VGND.t30 sg13_lv_nmos ad=0.1406p pd=1.12u as=0.3293p ps=1.63u w=0.74u l=0.13u
X1160 VPWR.t926 a_11567_6995# a_12234_7216# VPWR.t2 sg13_lv_pmos ad=0.2128p pd=1.5u as=0.3864p ps=2.93u w=1.12u l=0.13u
X1161 VPWR.t197 a_28262_1632# a_28374_1656# VPWR.t15 sg13_lv_pmos ad=0.2254p pd=1.53u as=0.34p ps=2.68u w=1u l=0.5u
X1162 a_15447_4192# sg13cmos5l_nor3_1_4.B a_15333_4192# VPWR.t43 sg13_lv_pmos ad=0.2128p pd=1.5u as=0.2464p ps=1.56u w=1.12u l=0.13u
X1163 a_10308_5724# a_10282_5629# VGND.t739 VGND.t331 sg13_lv_nmos ad=0.2516p pd=2.16u as=0.1626p ps=1.415u w=0.74u l=0.13u
X1164 a_1190_1632# a_920_1673# VPWR.t738 VPWR.t15 sg13_lv_pmos ad=0.34p pd=2.68u as=0.1523p ps=1.38u w=1u l=0.5u
X1165 a_18564_3148# a_18538_3112# VPWR.t417 VPWR.t10 sg13_lv_pmos ad=0.34p pd=2.68u as=0.36237p ps=2.605u w=1u l=0.13u
X1166 a_14277_3155# sg13cmos5l_dfrbpq_1_11.CLK VGND.t50 VGND.t1349 sg13_lv_nmos ad=0.2516p pd=2.16u as=3.63467p ps=22.73u w=0.74u l=0.13u
X1167 a_14542_4923# a_14657_4922# VPWR.t814 VPWR.t43 sg13_lv_pmos ad=0.34p pd=2.68u as=0.2254p ps=1.53u w=1u l=0.5u
X1168 a_10665_1261# a_10308_1188# VPWR.t108 VPWR.t15 sg13_lv_pmos ad=63f pd=0.72u as=0.1563p ps=1.22u w=0.42u l=0.13u
X1169 VGND.t20 a_21813_7727# a_20892_8041# VGND.t469 sg13_lv_nmos ad=0.1626p pd=1.415u as=0.2516p ps=2.16u w=0.74u l=0.13u
X1170 VGND.t25 sg13cmos5l_dfrbpq_1_57.CLK a_10943_6139# VGND.t1098 sg13_lv_nmos ad=3.31142p pd=20.535u as=0.2516p ps=2.16u w=0.74u l=0.13u
X1171 a_16624_7922# a_16367_8041# a_16786_8118# VGND.t87 sg13_lv_nmos ad=0.1428p pd=1.52u as=37.8f ps=0.6u w=0.42u l=0.13u
X1172 sg13cmos5l_buf_8_2.X a_21435_3514# VPWR.t79 VPWR.t10 sg13_lv_pmos ad=0.2128p pd=1.5u as=0.2128p ps=1.5u w=1.12u l=0.13u
X1173 a_28570_5374# sg13cmos5l_dlygate4sd3_1_40.A VPWR.t1115 VPWR.t7 sg13_lv_pmos ad=0.1428p pd=1.52u as=0.1523p ps=1.38u w=0.42u l=0.13u
X1174 a_25545_4285# a_25188_4212# VPWR.t696 VPWR.t43 sg13_lv_pmos ad=63f pd=0.72u as=0.1563p ps=1.22u w=0.42u l=0.13u
X1175 a_10282_5629# a_10725_5385# a_10022_5406# VGND.t331 sg13_lv_nmos ad=79.8f pd=0.8u as=0.1296p ps=1.52u w=0.42u l=0.13u
X1176 sg13cmos5l_nor4_2_9.Y sg13cmos5l_dfrbpq_1_23.D VGND.t52 VGND.t30 sg13_lv_nmos ad=0.1406p pd=1.12u as=0.2553p ps=2.17u w=0.74u l=0.13u
X1177 a_16167_4743# a_16319_4627# VPWR.t43 VPWR.t43 sg13_lv_pmos ad=0.3864p pd=2.93u as=1.3927p ps=8.9u w=1.12u l=0.13u
X1178 sg13cmos5l_dlygate4sd3_1_17.X a_27990_2450# VPWR.t436 VPWR.t10 sg13_lv_pmos ad=0.4256p pd=3u as=0.2254p ps=1.53u w=1.12u l=0.13u
X1179 VGND.t50 a_6250_3108# sg13cmos5l_dfrbpq_1_21.CLK VGND.t674 sg13_lv_nmos ad=0.1406p pd=1.12u as=0.1406p ps=1.12u w=0.74u l=0.13u
X1180 VGND.t30 a_10725_5385# a_10827_5528# VGND.t725 sg13_lv_nmos ad=3.5351p pd=22.08u as=0.2516p ps=2.16u w=0.74u l=0.13u
X1181 a_26052_8443# a_26283_8552# a_25738_8653# VGND.t912 sg13_lv_nmos ad=0.2373p pd=1.97u as=79.8f ps=0.8u w=0.42u l=0.13u
X1182 a_26073_6291# a_25131_6179# a_25871_6529# VPWR.t7 sg13_lv_pmos ad=93.45f pd=0.865u as=0.2048p ps=1.63u w=0.42u l=0.13u
X1183 VGND.t11 a_26229_1679# a_25308_1993# VGND.t161 sg13_lv_nmos ad=0.1626p pd=1.415u as=0.2516p ps=2.16u w=0.74u l=0.13u
X1184 a_16541_1168# sg13cmos5l_nor3_1_1.C sg13cmos5l_nor3_1_1.Y VPWR.t15 sg13_lv_pmos ad=0.2128p pd=1.5u as=0.3808p ps=2.92u w=1.12u l=0.13u
X1185 a_18951_1719# a_19103_1603# VGND.t77 VGND.t400 sg13_lv_nmos ad=0.2516p pd=2.16u as=3.25012p ps=20.49u w=0.74u l=0.13u
X1186 a_2054_8434# a_1784_8434# VGND.t121 VGND.t1091 sg13_lv_nmos ad=0.1428p pd=1.52u as=79.8f ps=0.8u w=0.42u l=0.5u
X1187 a_3896_6926# sg13cmos5l_nor4_2_5.Y a_3794_6926# VGND.t1025 sg13_lv_nmos ad=0.1406p pd=1.12u as=0.1406p ps=1.12u w=0.74u l=0.13u
X1188 a_2054_3144# a_1784_3185# VGND.t632 VGND.t1657 sg13_lv_nmos ad=0.1428p pd=1.52u as=79.8f ps=0.8u w=0.42u l=0.5u
X1189 VPWR.t157 a_11567_1993# a_12234_1632# VPWR.t15 sg13_lv_pmos ad=0.2128p pd=1.5u as=0.3864p ps=2.93u w=1.12u l=0.13u
X1190 sg13cmos5l_dfrbpq_1_13.CLK a_6250_2350# VPWR.t1226 VPWR.t10 sg13_lv_pmos ad=0.2128p pd=1.5u as=0.3864p ps=2.93u w=1.12u l=0.13u
X1191 VGND.t996 sg13cmos5l_buf_8_11.A a_18922_7644# VGND.t0 sg13_lv_nmos ad=0.1406p pd=1.12u as=0.1406p ps=1.12u w=0.74u l=0.13u
X1192 VPWR.t889 sg13cmos5l_buf_8_11.A a_27963_6538# VPWR.t7 sg13_lv_pmos ad=0.2128p pd=1.5u as=0.3808p ps=2.92u w=1.12u l=0.13u
X1193 VGND.t1159 a_28570_5374# a_28289_5596# VGND.t200 sg13_lv_nmos ad=79.8f pd=0.8u as=0.1428p ps=1.52u w=0.42u l=0.5u
X1194 a_14148_2395# a_13860_2700# a_14086_2395# VGND.t6 sg13_lv_nmos ad=0.1428p pd=1.52u as=37.8f ps=0.6u w=0.42u l=0.13u
X1195 a_3850_8653# a_4293_8409# a_3590_8430# VGND.t81 sg13_lv_nmos ad=79.8f pd=0.8u as=0.1296p ps=1.52u w=0.42u l=0.13u
X1196 a_18084_3907# a_17796_4212# a_18022_3907# VGND.t185 sg13_lv_nmos ad=0.1428p pd=1.52u as=37.8f ps=0.6u w=0.42u l=0.13u
X1197 VPWR.t306 sg13cmos5l_dlygate4sd3_1_52.A a_9176_4697# VPWR.t43 sg13_lv_pmos ad=0.1523p pd=1.38u as=0.1428p ps=1.52u w=0.42u l=0.13u
X1198 VGND.t35 a_25509_849# a_25611_992# VGND.t329 sg13_lv_nmos ad=5.40863p pd=35.155u as=0.2516p ps=2.16u w=0.74u l=0.13u
X1199 a_6391_3858# a_6951_4112# a_6972_3858# VGND.t193 sg13_lv_nmos ad=0.12665p pd=1.145u as=0.3473p ps=2.71u w=0.74u l=0.13u
X1200 sg13cmos5l_buf_1_4.X.t0 a_8776_908# VPWR.t566 VPWR.t15 sg13_lv_pmos ad=0.42p pd=2.99u as=0.2114p ps=1.54u w=1.12u l=0.13u
X1201 VPWR.t200 sg13cmos5l_dfrbpq_1_18.D a_8759_1679# VPWR.t15 sg13_lv_pmos ad=0.1428p pd=1.52u as=79.8f ps=0.8u w=0.42u l=0.13u
X1202 a_13888_6168# sg13cmos5l_dfrbpq_1_56.D a_14186_6168# VPWR.t7 sg13_lv_pmos ad=0.3808p pd=2.92u as=0.2128p ps=1.5u w=1.12u l=0.13u
X1203 a_22066_5406# sg13cmos5l_buf_1_0.X.t2 VGND.t143 VGND.t142 sg13_lv_nmos ad=37.8f pd=0.6u as=79.8f ps=0.8u w=0.42u l=0.13u
X1204 a_25990_5081# sg13cmos5l_dfrbpq_1_53.RESET_B.t2 VGND.t203 VGND.t301 sg13_lv_nmos ad=37.8f pd=0.6u as=0.1701p ps=1.65u w=0.42u l=0.13u
X1205 a_3590_3582# a_4395_3155# a_3850_3112# VPWR.t10 sg13_lv_pmos ad=0.1428p pd=1.52u as=79.8f ps=0.8u w=0.42u l=0.13u
X1206 VGND.t874 a_17614_8619# sg13cmos5l_nor4_2_4.D VGND.t0 sg13_lv_nmos ad=0.1426p pd=1.16u as=0.2516p ps=2.16u w=0.74u l=0.13u
X1207 VGND.t150 a_2266_1596# a_1985_1898# VGND.t474 sg13_lv_nmos ad=79.8f pd=0.8u as=0.1428p ps=1.52u w=0.42u l=0.5u
X1208 a_26416_3386# a_26159_3505# a_26578_3582# VGND.t206 sg13_lv_nmos ad=0.1428p pd=1.52u as=37.8f ps=0.6u w=0.42u l=0.13u
X1209 sg13cmos5l_dfrbpq_1_46.CLK a_18922_7644# VGND.t800 VGND.t0 sg13_lv_nmos ad=0.1406p pd=1.12u as=0.1406p ps=1.12u w=0.74u l=0.13u
X1210 a_6597_6179# sg13cmos5l_dfrbpq_1_32.CLK VPWR.t7 VPWR.t7 sg13_lv_pmos ad=0.4088p pd=2.97u as=1.46065p ps=9.335u w=1.12u l=0.13u
X1211 a_20388_6172# a_20907_6179# a_21647_6529# VGND.t744 sg13_lv_nmos ad=0.3473p pd=2.71u as=0.12665p ps=1.145u w=0.74u l=0.13u
X1212 a_10596_2057# a_10827_1643# a_10282_1600# VGND.t319 sg13_lv_nmos ad=0.2373p pd=1.97u as=79.8f ps=0.8u w=0.42u l=0.13u
X1213 a_26229_1679# a_25287_1719# a_26135_1679# VPWR.t15 sg13_lv_pmos ad=79.8f pd=0.8u as=0.1428p ps=1.52u w=0.42u l=0.13u
X1214 a_11786_4192# sg13cmos5l_dfrbpq_1_17.D sg13cmos5l_nand3_1_3.B VPWR.t43 sg13_lv_pmos ad=0.3808p pd=2.92u as=0.2128p ps=1.5u w=1.12u l=0.13u
X1215 VGND.t93 a_15008_8605# sg13cmos5l_dlygate4sd3_1_57.A VGND.t318 sg13_lv_nmos ad=0.1406p pd=1.12u as=0.2516p ps=2.16u w=0.74u l=0.13u
X1216 a_19799_1679# sg13cmos5l_buf_1_1.X.t5 VPWR.t147 VPWR.t15 sg13_lv_pmos ad=79.8f pd=0.8u as=0.36237p ps=2.605u w=0.42u l=0.13u
X1217 a_5066_2070# a_4759_1596# a_4972_2070# VGND.t1664 sg13_lv_nmos ad=37.8f pd=0.6u as=0.1428p ps=1.52u w=0.42u l=0.13u
X1218 a_28114_6918# sg13cmos5l_dfrbpq_1_53.RESET_B.t5 VGND.t45 VGND.t651 sg13_lv_nmos ad=37.8f pd=0.6u as=79.8f ps=0.8u w=0.42u l=0.13u
X1219 sg13cmos5l_dlygate4sd3_1_13.A a_20490_3144# VGND.t106 VGND.t901 sg13_lv_nmos ad=0.2516p pd=2.16u as=0.1406p ps=1.12u w=0.74u l=0.13u
X1220 a_10791_3231# a_10943_3115# VPWR.t91 VPWR.t10 sg13_lv_pmos ad=0.3864p pd=2.93u as=1.43285p ps=9.125u w=1.12u l=0.13u
X1221 VPWR.t218 a_7893_4052# a_6972_3858# VPWR.t43 sg13_lv_pmos ad=0.36237p pd=2.605u as=0.34p ps=2.68u w=1u l=0.13u
X1222 a_16629_8588# a_15687_8648# a_16535_8821# VPWR.t0 sg13_lv_pmos ad=79.8f pd=0.8u as=0.1428p ps=1.52u w=0.42u l=0.13u
X1223 a_6862_8745# a_6604_8430# VPWR.t1 VPWR.t0 sg13_lv_pmos ad=93.45f pd=0.865u as=1.8922p ps=12.27u w=0.42u l=0.13u
X1224 sg13cmos5l_nor3_1_0.B a_23958_3168# VGND.t851 VGND.t53 sg13_lv_nmos ad=0.2516p pd=2.16u as=0.1426p ps=1.16u w=0.74u l=0.13u
X1225 a_23558_6918# a_24363_7040# a_23818_7141# VPWR.t2 sg13_lv_pmos ad=0.1428p pd=1.52u as=79.8f ps=0.8u w=0.42u l=0.13u
X1226 a_17770_4117# a_18213_3873# a_18153_4285# VPWR.t43 sg13_lv_pmos ad=79.8f pd=0.8u as=63f ps=0.72u w=0.42u l=0.13u
X1227 VGND.t800 a_18922_7644# sg13cmos5l_dfrbpq_1_46.CLK VGND.t0 sg13_lv_nmos ad=0.1406p pd=1.12u as=0.1406p ps=1.12u w=0.74u l=0.13u
X1228 VPWR.t571 a_18382_6435# sg13cmos5l_dfrbpq_1_56.D VPWR.t7 sg13_lv_pmos ad=0.2254p pd=1.53u as=0.4256p ps=3u w=1.12u l=0.13u
X1229 sg13cmos5l_xnor2_1_1.Y sg13cmos5l_xnor2_1_1.B a_17715_1632# VPWR.t15 sg13_lv_pmos ad=0.2408p pd=1.55u as=0.1428p ps=1.375u w=1.12u l=0.13u
X1230 a_20242_3582# sg13cmos5l_buf_1_1.X.t12 VGND.t106 VGND.t446 sg13_lv_nmos ad=37.8f pd=0.6u as=79.8f ps=0.8u w=0.42u l=0.13u
X1231 a_21904_4898# sg13cmos5l_buf_1_4.X.t9 VPWR.t43 VPWR.t43 sg13_lv_pmos ad=79.8f pd=0.8u as=1.36105p ps=8.695u w=0.42u l=0.13u
X1232 a_20192_7967# a_20311_7644# VGND.t325 VGND.t843 sg13_lv_nmos ad=0.2516p pd=2.16u as=0.1406p ps=1.12u w=0.74u l=0.13u
X1233 a_5703_5624# a_5855_5676# VGND.t30 VGND.t854 sg13_lv_nmos ad=0.2516p pd=2.16u as=3.5351p ps=22.08u w=0.74u l=0.13u
X1234 VPWR.t173 a_20892_6882# a_21915_7309# VPWR.t2 sg13_lv_pmos ad=0.1563p pd=1.22u as=63f ps=0.72u w=0.42u l=0.13u
X1235 VGND.t203 a_24526_4923# sg13cmos5l_dlygate4sd3_1_55.X VGND.t142 sg13_lv_nmos ad=0.1426p pd=1.16u as=0.2516p ps=2.16u w=0.74u l=0.13u
X1236 VGND.t572 sg13cmos5l_dfrbpq_1_17.D sg13cmos5l_nand3_1_3.B VGND.t1193 sg13_lv_nmos ad=0.2516p pd=2.16u as=0.1406p ps=1.12u w=0.74u l=0.13u
X1237 VGND.t312 a_6165_7727# a_5244_8041# VGND.t932 sg13_lv_nmos ad=0.1626p pd=1.415u as=0.2516p ps=2.16u w=0.74u l=0.13u
X1238 VPWR.t138 sg13cmos5l_dfrbpq_1_57.RESET_B.t10 a_15082_7648# VPWR.t2 sg13_lv_pmos ad=0.1563p pd=1.22u as=0.147p ps=1.54u w=0.42u l=0.13u
X1239 VPWR.t7 a_10725_5385# a_10827_5528# VPWR.t7 sg13_lv_pmos ad=1.46065p pd=9.335u as=0.3864p ps=2.93u w=1.12u l=0.13u
X1240 sg13cmos5l_xor2_1_2.A a_14166_8498# VGND.t238 VGND.t237 sg13_lv_nmos ad=0.2516p pd=2.16u as=0.1426p ps=1.16u w=0.74u l=0.13u
X1241 VPWR.t1396 a_10112_6455# sg13cmos5l_dlygate4sd3_1_28.A VPWR.t7 sg13_lv_pmos ad=0.2128p pd=1.5u as=0.3808p ps=2.92u w=1.12u l=0.13u
X1242 a_1340_3144# sg13cmos5l_xor2_1_1.B VPWR.t1002 VPWR.t10 sg13_lv_pmos ad=0.2128p pd=1.5u as=0.2128p ps=1.5u w=1.12u l=0.13u
X1243 VPWR.t3 sg13cmos5l_dlygate4sd3_1_55.X a_21719_7309# VPWR.t2 sg13_lv_pmos ad=0.1428p pd=1.52u as=79.8f ps=0.8u w=0.42u l=0.13u
X1244 VPWR.t76 VGND.t203 VPWR.t76 VPWR.t43 sg13_lv_pmos ad=0.19p pd=1.38u as=0 ps=0 w=1u l=1u
X1245 VPWR.t191 sg13cmos5l_xnor2_1_1.B a_17472_1671# VPWR.t15 sg13_lv_pmos ad=0.2891p pd=1.695u as=0.1596p ps=1.22u w=0.84u l=0.13u
X1246 a_26882_2070# sg13cmos5l_buf_1_1.X.t3 VGND.t11 VGND.t110 sg13_lv_nmos ad=60.89999f pd=0.71u as=0.1626p ps=1.415u w=0.42u l=0.13u
X1247 a_26841_7803# a_25899_7691# a_26639_8041# VPWR.t2 sg13_lv_pmos ad=93.45f pd=0.865u as=0.2048p ps=1.63u w=0.42u l=0.13u
X1248 sg13cmos5l_buf_1_4.X a_8776_908# VGND.t508 VGND.t1609 sg13_lv_nmos ad=0.2886p pd=2.26u as=0.14875p ps=1.16u w=0.74u l=0.13u
X1249 VPWR.t1170 a_5024_5581# sg13cmos5l_dlygate4sd3_1_30.A VPWR.t7 sg13_lv_pmos ad=0.2128p pd=1.5u as=0.3808p ps=2.92u w=1.12u l=0.13u
X1250 a_11769_1755# a_10827_1643# a_11567_1993# VPWR.t15 sg13_lv_pmos ad=93.45f pd=0.865u as=0.2048p ps=1.63u w=0.42u l=0.13u
X1251 sg13cmos5l_dlygate4sd3_1_11.X a_28758_3962# VGND.t268 VGND.t783 sg13_lv_nmos ad=0.2516p pd=2.16u as=0.1426p ps=1.16u w=0.74u l=0.13u
X1252 VGND.t58 a_27598_4083# sg13cmos5l_dlygate4sd3_1_9.X VGND.t1355 sg13_lv_nmos ad=0.1426p pd=1.16u as=0.2516p ps=2.16u w=0.74u l=0.13u
X1253 a_17015_4703# sg13cmos5l_dfrbpq_1_56.D a_17762_5094# VGND.t1588 sg13_lv_nmos ad=0.1428p pd=1.52u as=60.89999f ps=0.71u w=0.42u l=0.13u
X1254 VPWR.t191 sg13cmos5l_buf_1_4.A.t1 a_17032_908# VPWR.t15 sg13_lv_pmos ad=0.2114p pd=1.54u as=0.2856p ps=2.36u w=0.84u l=0.13u
X1255 a_15376_2602# sg13cmos5l_dfrbpq_1_55.RESET_B VPWR.t91 VPWR.t10 sg13_lv_pmos ad=79.8f pd=0.8u as=1.4003p ps=8.92u w=0.42u l=0.13u
X1256 VGND.t35 sg13cmos5l_dlygate4sd3_1_22.A a_1784_874# VGND.t501 sg13_lv_nmos ad=79.8f pd=0.8u as=0.1428p ps=1.52u w=0.42u l=0.13u
X1257 VPWR.t407 sg13cmos5l_dfrbpq_1_57.D a_11639_4703# VPWR.t43 sg13_lv_pmos ad=0.1428p pd=1.52u as=79.8f ps=0.8u w=0.42u l=0.13u
X1258 a_10702_7803# a_10444_8118# VPWR.t2 VPWR.t2 sg13_lv_pmos ad=93.45f pd=0.865u as=1.34765p ps=8.56u w=0.42u l=0.13u
X1259 a_26181_8409# sg13cmos5l_dfrbpq_1_53.CLK VGND.t0 VGND.t272 sg13_lv_nmos ad=0.2516p pd=2.16u as=3.2221p ps=20.04u w=0.74u l=0.13u
X1260 a_6165_7727# a_5223_7767# a_6026_7960# VGND.t1013 sg13_lv_nmos ad=79.8f pd=0.8u as=0.2373p ps=1.97u w=0.42u l=0.13u
X1261 a_7930_4620# sg13cmos5l_dlygate4sd3_1_58.A VPWR.t774 VPWR.t43 sg13_lv_pmos ad=0.1428p pd=1.52u as=0.1523p ps=1.38u w=0.42u l=0.13u
X1262 VGND.t50 sg13cmos5l_dfrbpq_1_55.RESET_B a_10538_3582# VGND.t575 sg13_lv_nmos ad=79.8f pd=0.8u as=37.8f ps=0.6u w=0.42u l=0.13u
X1263 a_16390_5419# sg13cmos5l_dfrbpq_1_56.RESET_B VGND.t350 VGND.t825 sg13_lv_nmos ad=37.8f pd=0.6u as=0.1701p ps=1.65u w=0.42u l=0.13u
X1264 sg13cmos5l_dfrbpq_1_11.CLK a_13563_874# VPWR.t469 VPWR.t15 sg13_lv_pmos ad=0.2128p pd=1.5u as=0.2128p ps=1.5u w=1.12u l=0.13u
X1265 VPWR.t91 a_8133_2361# a_8235_2504# VPWR.t10 sg13_lv_pmos ad=1.43285p pd=9.125u as=0.3864p ps=2.93u w=1.12u l=0.13u
X1266 a_5334_6168# sg13cmos5l_dfrbpq_1_58.D VPWR.t896 VPWR.t7 sg13_lv_pmos ad=0.2128p pd=1.5u as=0.3808p ps=2.92u w=1.12u l=0.13u
X1267 VGND.t137 a_24608_1919# sg13cmos5l_dlygate4sd3_1_16.A VGND.t883 sg13_lv_nmos ad=0.1406p pd=1.12u as=0.2516p ps=2.16u w=0.74u l=0.13u
X1268 a_7799_1261# a_7103_1140# a_7893_1028# VGND.t1672 sg13_lv_nmos ad=0.1296p pd=1.52u as=79.8f ps=0.8u w=0.42u l=0.13u
X1269 VGND.t1619 a_7893_1028# a_6972_834# VGND.t1673 sg13_lv_nmos ad=0.1626p pd=1.415u as=0.2516p ps=2.16u w=0.74u l=0.13u
X1270 a_10702_5094# a_10943_4627# a_10231_4620# VGND.t1419 sg13_lv_nmos ad=0.1428p pd=1.52u as=0.12665p ps=1.145u w=0.42u l=0.13u
X1271 a_13676_7680# sg13cmos5l_xnor2_1_2.A VPWR.t427 VPWR.t2 sg13_lv_pmos ad=0.2128p pd=1.5u as=0.3864p ps=2.93u w=1.12u l=0.13u
X1272 VPWR.t7 a_17423_5483# a_17680_5626# VPWR.t7 sg13_lv_pmos ad=1.46065p pd=9.335u as=79.8f ps=0.8u w=0.42u l=0.13u
X1273 VPWR.t153 sg13cmos5l_dfrbpq_1_0.CLK a_25439_1603# VPWR.t15 sg13_lv_pmos ad=1.46697p pd=9.345u as=0.4088p ps=2.97u w=1.12u l=0.13u
X1274 a_7893_1028# sg13cmos5l_dfrbpq_1_13.RESET_B.t3 VPWR.t508 VPWR.t15 sg13_lv_pmos ad=0.147p pd=1.54u as=0.1563p ps=1.22u w=0.42u l=0.13u
X1275 VGND.t1014 a_8763_8434# sg13cmos5l_dfrbpq_1_32.CLK VGND.t89 sg13_lv_nmos ad=0.2516p pd=2.16u as=0.1406p ps=1.12u w=0.74u l=0.13u
X1276 sg13cmos5l_dfrbpq_1_53.Q a_27690_4656# VGND.t259 VGND.t200 sg13_lv_nmos ad=0.2516p pd=2.16u as=0.1406p ps=1.12u w=0.74u l=0.13u
X1277 VPWR.t200 a_9446_874# a_9558_938# VPWR.t15 sg13_lv_pmos ad=0.2254p pd=1.53u as=0.34p ps=2.68u w=1u l=0.5u
X1278 a_2266_1596# sg13cmos5l_dlygate4sd3_1_20.A VPWR.t16 VPWR.t15 sg13_lv_pmos ad=0.1428p pd=1.52u as=0.1523p ps=1.38u w=0.42u l=0.13u
X1279 a_5334_6168# sg13cmos5l_nor4_2_5.B a_5036_6168# VPWR.t7 sg13_lv_pmos ad=0.2128p pd=1.5u as=0.2128p ps=1.5u w=1.12u l=0.13u
X1280 VPWR.t193 sg13cmos5l_dlygate4sd3_1_6.A a_20792_1673# VPWR.t15 sg13_lv_pmos ad=0.1523p pd=1.38u as=0.1428p ps=1.52u w=0.42u l=0.13u
X1281 VGND.t572 sg13cmos5l_dfrbpq_1_55.RESET_B a_11990_3569# VGND.t571 sg13_lv_nmos ad=0.1701p pd=1.65u as=37.8f ps=0.6u w=0.42u l=0.13u
X1282 a_10665_7309# a_10308_7236# VPWR.t600 VPWR.t2 sg13_lv_pmos ad=63f pd=0.72u as=0.1563p ps=1.22u w=0.42u l=0.13u
X1283 a_11835_6215# a_10943_6139# a_11733_6215# VPWR.t7 sg13_lv_pmos ad=63f pd=0.72u as=79.8f ps=0.8u w=0.42u l=0.13u
X1284 VPWR.t146 a_18972_1993# a_19995_1679# VPWR.t15 sg13_lv_pmos ad=0.1563p pd=1.22u as=63f ps=0.72u w=0.42u l=0.13u
X1285 a_5703_5624# a_5855_5676# VPWR.t7 VPWR.t7 sg13_lv_pmos ad=0.3864p pd=2.93u as=1.46065p ps=9.335u w=1.12u l=0.13u
X1286 a_15972_5406# sg13cmos5l_nor3_1_4.C a_15878_5406# VGND.t1425 sg13_lv_nmos ad=60.89999f pd=0.71u as=0.1428p ps=1.52u w=0.42u l=0.13u
X1287 VGND.t203 sg13cmos5l_nor4_2_7.B sg13cmos5l_nand3_1_2.B VGND.t142 sg13_lv_nmos ad=0.1406p pd=1.12u as=0.1406p ps=1.12u w=0.74u l=0.13u
X1288 VPWR.t153 a_25509_849# a_25611_992# VPWR.t15 sg13_lv_pmos ad=1.50275p pd=9.57u as=0.3864p ps=2.93u w=1.12u l=0.13u
X1289 a_20666_2680# sg13cmos5l_nor4_2_1.D sg13cmos5l_nand3_1_0.A VPWR.t10 sg13_lv_pmos ad=0.3808p pd=2.92u as=0.2128p ps=1.5u w=1.12u l=0.13u
X1290 VGND.t359 a_16666_2350# a_16385_2572# VGND.t147 sg13_lv_nmos ad=79.8f pd=0.8u as=0.1428p ps=1.52u w=0.42u l=0.5u
X1291 VGND.t608 a_8975_2459# a_9642_2680# VGND.t1417 sg13_lv_nmos ad=0.1406p pd=1.12u as=0.2516p ps=2.16u w=0.74u l=0.13u
X1292 VPWR.t91 a_20080_3386# a_20025_3267# VPWR.t10 sg13_lv_pmos ad=1.43285p pd=9.125u as=93.45f ps=0.865u w=0.42u l=0.13u
X1293 sg13cmos5l_dfrbpq_1_32.CLK a_8763_8434# VGND.t357 VGND.t89 sg13_lv_nmos ad=0.1406p pd=1.12u as=0.1406p ps=1.12u w=0.74u l=0.13u
X1294 sg13cmos5l_dfrbpq_1_29.Q a_12234_8728# VPWR.t107 VPWR.t0 sg13_lv_pmos ad=0.3808p pd=2.92u as=0.2128p ps=1.5u w=1.12u l=0.13u
X1295 a_10022_870# sg13cmos5l_dlygate4sd3_1_18.X VPWR.t108 VPWR.t15 sg13_lv_pmos ad=79.8f pd=0.8u as=0.1428p ps=1.52u w=0.42u l=0.13u
X1296 a_4544_7967# a_4663_7644# VGND.t358 VGND.t1038 sg13_lv_nmos ad=0.2516p pd=2.16u as=0.1406p ps=1.12u w=0.74u l=0.13u
X1297 VGND.t286 a_23835_8050# sg13cmos5l_buf_8_11.A VGND.t889 sg13_lv_nmos ad=0.1406p pd=1.12u as=0.1406p ps=1.12u w=0.74u l=0.13u
X1298 a_20102_5094# sg13cmos5l_nor3_1_0.C VPWR.t1185 VPWR.t43 sg13_lv_pmos ad=79.8f pd=0.8u as=0.1428p ps=1.52u w=0.42u l=0.13u
X1299 VPWR.t43 sg13cmos5l_dfrbpq_1_21.RESET_B.t6 a_6604_3894# VPWR.t43 sg13_lv_pmos ad=1.36105p pd=8.695u as=79.8f ps=0.8u w=0.42u l=0.13u
X1300 sg13cmos5l_nor4_2_5.B a_4278_6192# VPWR.t918 VPWR.t7 sg13_lv_pmos ad=0.4256p pd=3u as=0.2254p ps=1.53u w=1.12u l=0.13u
X1301 VPWR.t221 sg13cmos5l_dfrbpq_1_53.RESET_B.t4 a_25478_5406# VPWR.t7 sg13_lv_pmos ad=0.36237p pd=2.605u as=79.8f ps=0.8u w=0.42u l=0.13u
X1302 VPWR.t105 sg13cmos5l_dfrbpq_1_55.RESET_B a_13996_2070# VPWR.t15 sg13_lv_pmos ad=1.50275p pd=9.57u as=79.8f ps=0.8u w=0.42u l=0.13u
X1303 VPWR.t682 a_2266_2350# a_1985_2572# VPWR.t10 sg13_lv_pmos ad=0.1523p pd=1.38u as=0.34p ps=2.68u w=1u l=0.5u
X1304 a_16356_6931# a_16068_7236# a_16294_6931# VGND.t239 sg13_lv_nmos ad=0.1428p pd=1.52u as=37.8f ps=0.6u w=0.42u l=0.13u
X1305 a_17650_6606# sg13cmos5l_dfrbpq_1_56.RESET_B VGND.t191 VGND.t833 sg13_lv_nmos ad=37.8f pd=0.6u as=79.8f ps=0.8u w=0.42u l=0.13u
X1306 a_26351_947# a_25509_849# a_25092_1188# VPWR.t15 sg13_lv_pmos ad=0.2048p pd=1.63u as=0.34p ps=2.68u w=1u l=0.13u
X1307 VGND.t449 sg13cmos5l_buf_1_1.X.t11 a_21067_3492# VGND.t53 sg13_lv_nmos ad=0.1331p pd=1.12u as=0.1216p ps=1.02u w=0.64u l=0.13u
X1308 a_13862_4656# a_13592_4697# VPWR.t216 VPWR.t43 sg13_lv_pmos ad=0.34p pd=2.68u as=0.1523p ps=1.38u w=1u l=0.5u
X1309 a_4270_2382# a_4012_2382# VGND.t205 VGND.t209 sg13_lv_nmos ad=0.1428p pd=1.52u as=79.8f ps=0.8u w=0.42u l=0.13u
X1310 VPWR.t1254 sg13cmos5l_dlygate4sd3_1_6.X a_23660_8728# VPWR.t0 sg13_lv_pmos ad=0.3808p pd=2.92u as=0.2128p ps=1.5u w=1.12u l=0.13u
X1311 VPWR.t290 a_28652_7644# sg13cmos5l_buf_1_4.A.t0 VPWR.t2 sg13_lv_pmos ad=0.2114p pd=1.54u as=0.42p ps=2.99u w=1.12u l=0.13u
X1312 a_25034_2070# a_24727_1596# a_24940_2070# VGND.t593 sg13_lv_nmos ad=37.8f pd=0.6u as=0.1428p ps=1.52u w=0.42u l=0.13u
X1313 a_4359_2600# a_4511_2652# VPWR.t91 VPWR.t10 sg13_lv_pmos ad=0.3864p pd=2.93u as=1.43285p ps=9.125u w=1.12u l=0.13u
X1314 a_25380_7684# a_25354_7648# VGND.t62 VGND.t848 sg13_lv_nmos ad=0.2516p pd=2.16u as=0.1626p ps=1.415u w=0.74u l=0.13u
X1315 VGND.t58 a_27195_3514# sg13cmos5l_dfrbpq_1_0.CLK VGND.t265 sg13_lv_nmos ad=0.1406p pd=1.12u as=0.1406p ps=1.12u w=0.74u l=0.13u
X1316 VPWR.t38 VGND.t121 VPWR.t37 VPWR.t2 sg13_lv_pmos ad=0.34p pd=2.68u as=0 ps=0 w=1u l=1u
X1317 a_4012_2382# a_3799_2346# VPWR.t91 VPWR.t10 sg13_lv_pmos ad=79.8f pd=0.8u as=1.43285p ps=9.125u w=0.42u l=0.13u
X1318 a_15607_4620# a_16167_4743# a_16078_4779# VPWR.t43 sg13_lv_pmos ad=0.2048p pd=1.63u as=93.45f ps=0.865u w=0.42u l=0.13u
X1319 VPWR.t230 a_26159_3505# a_26826_3144# VPWR.t10 sg13_lv_pmos ad=0.2128p pd=1.5u as=0.3864p ps=2.93u w=1.12u l=0.13u
X1320 a_23835_8050# sg13cmos5l_and2_1_1.X VGND.t286 VGND.t1264 sg13_lv_nmos ad=0.1406p pd=1.12u as=0.1406p ps=1.12u w=0.74u l=0.13u
X1321 VPWR.t2 sg13cmos5l_buf_1_0.X.t11 a_20524_6918# VPWR.t2 sg13_lv_pmos ad=1.31957p pd=8.38u as=79.8f ps=0.8u w=0.42u l=0.13u
X1322 a_14926_6435# a_15041_6434# VPWR.t333 VPWR.t7 sg13_lv_pmos ad=0.34p pd=2.68u as=0.2254p ps=1.53u w=1u l=0.5u
X1323 VPWR.t7 a_21647_5483# a_21904_5626# VPWR.t7 sg13_lv_pmos ad=1.46065p pd=9.335u as=79.8f ps=0.8u w=0.42u l=0.13u
X1324 a_2259_4192# sg13cmos5l_nand3_1_3.Y VPWR.t1271 VPWR.t43 sg13_lv_pmos ad=0.1428p pd=1.375u as=0.2891p ps=1.695u w=1.12u l=0.13u
X1325 a_17621_2002# sg13cmos5l_xnor2_1_1.B VGND.t154 VGND.t153 sg13_lv_nmos ad=0.1406p pd=1.12u as=0.1898p ps=1.36u w=0.74u l=0.13u
X1326 a_26639_8041# a_25797_7691# a_25380_7684# VPWR.t2 sg13_lv_pmos ad=0.2048p pd=1.63u as=0.34p ps=2.68u w=1u l=0.13u
X1327 a_26896_7922# sg13cmos5l_dfrbpq_1_53.RESET_B.t7 VPWR.t2 VPWR.t2 sg13_lv_pmos ad=79.8f pd=0.8u as=1.31957p ps=8.38u w=0.42u l=0.13u
X1328 a_21647_6529# a_20805_6179# a_21553_6529# VGND.t1301 sg13_lv_nmos ad=0.12665p pd=1.145u as=0.1428p ps=1.52u w=0.42u l=0.13u
X1329 a_18826_4620# sg13cmos5l_buf_8_2.X VGND.t133 VGND.t778 sg13_lv_nmos ad=0.1406p pd=1.12u as=0.1406p ps=1.12u w=0.74u l=0.13u
X1330 VPWR.t846 a_5532_5017# a_6555_4703# VPWR.t43 sg13_lv_pmos ad=0.1563p pd=1.22u as=63f ps=0.72u w=0.42u l=0.13u
X1331 sg13cmos5l_buf_8_10.A a_14235_6922# VPWR.t942 VPWR.t2 sg13_lv_pmos ad=0.2128p pd=1.5u as=0.2128p ps=1.5u w=1.12u l=0.13u
X1332 sg13cmos5l_dlygate4sd3_1_4.A a_28362_7216# VPWR.t635 VPWR.t2 sg13_lv_pmos ad=0.3808p pd=2.92u as=0.2128p ps=1.5u w=1.12u l=0.13u
X1333 a_10444_3582# a_10231_3108# VPWR.t91 VPWR.t10 sg13_lv_pmos ad=79.8f pd=0.8u as=1.43285p ps=9.125u w=0.42u l=0.13u
X1334 a_10112_4943# a_10231_4620# VGND.t739 VGND.t1315 sg13_lv_nmos ad=0.2516p pd=2.16u as=0.1406p ps=1.12u w=0.74u l=0.13u
X1335 sg13cmos5l_dfrbpq_1_57.D a_13974_4680# VGND.t179 VGND.t1405 sg13_lv_nmos ad=0.2516p pd=2.16u as=0.1426p ps=1.16u w=0.74u l=0.13u
X1336 a_20745_6215# a_20388_6172# VPWR.t396 VPWR.t7 sg13_lv_pmos ad=63f pd=0.72u as=0.1563p ps=1.22u w=0.42u l=0.13u
X1337 VGND.t150 VPWR.t17 VGND.t150 VGND.t1521 sg13_lv_nmos ad=0.1428p pd=1.52u as=0 ps=0 w=0.42u l=1u
X1338 a_5626_6886# sg13cmos5l_dlygate4sd3_1_38.A VGND.t25 VGND.t1103 sg13_lv_nmos ad=0.1428p pd=1.52u as=79.8f ps=0.8u w=0.42u l=0.13u
X1339 a_6862_3894# a_7103_4164# a_6391_3858# VGND.t193 sg13_lv_nmos ad=0.1428p pd=1.52u as=0.12665p ps=1.145u w=0.42u l=0.13u
X1340 VPWR.t439 a_5340_1993# a_6363_1679# VPWR.t15 sg13_lv_pmos ad=0.1563p pd=1.22u as=63f ps=0.72u w=0.42u l=0.13u
X1341 sg13cmos5l_and2_1_1.X a_23661_2428# VGND.t137 VGND.t471 sg13_lv_nmos ad=0.2516p pd=2.16u as=0.1331p ps=1.12u w=0.74u l=0.13u
X1342 VPWR.t1418 a_8763_8434# sg13cmos5l_dfrbpq_1_32.CLK VPWR.t0 sg13_lv_pmos ad=0.2128p pd=1.5u as=0.2128p ps=1.5u w=1.12u l=0.13u
X1343 a_24132_6931# a_23844_7236# a_24070_6931# VGND.t127 sg13_lv_nmos ad=0.1428p pd=1.52u as=37.8f ps=0.6u w=0.42u l=0.13u
X1344 VGND.t739 sg13cmos5l_dfrbpq_1_57.RESET_B.t3 a_10116_5406# VGND.t331 sg13_lv_nmos ad=0.1626p pd=1.415u as=60.89999f ps=0.71u w=0.42u l=0.13u
X1345 a_20196_5406# sg13cmos5l_dfrbpq_1_46.D a_20102_5406# VGND.t289 sg13_lv_nmos ad=60.89999f pd=0.71u as=0.1428p ps=1.52u w=0.42u l=0.13u
X1346 VGND.t133 a_18826_4620# sg13cmos5l_dfrbpq_1_2.CLK VGND.t1139 sg13_lv_nmos ad=0.1406p pd=1.12u as=0.1406p ps=1.12u w=0.74u l=0.13u
X1347 sg13cmos5l_dfrbpq_1_0.CLK a_27195_3514# VPWR.t278 VPWR.t10 sg13_lv_pmos ad=0.2128p pd=1.5u as=0.2128p ps=1.5u w=1.12u l=0.13u
X1348 VGND.t50 a_9915_3898# sg13cmos5l_buf_8_3.A VGND.t1582 sg13_lv_nmos ad=0.2516p pd=2.16u as=0.1406p ps=1.12u w=0.74u l=0.13u
X1349 a_20362_4117# a_20805_3873# a_20745_4285# VPWR.t43 sg13_lv_pmos ad=79.8f pd=0.8u as=63f ps=0.72u w=0.42u l=0.13u
X1350 VPWR.t941 sg13cmos5l_and2_1_4.X a_14235_6922# VPWR.t2 sg13_lv_pmos ad=0.2128p pd=1.5u as=0.2128p ps=1.5u w=1.12u l=0.13u
X1351 a_12386_6606# sg13cmos5l_dfrbpq_1_57.RESET_B.t4 VGND.t96 VGND.t98 sg13_lv_nmos ad=60.89999f pd=0.71u as=0.1626p ps=1.415u w=0.42u l=0.13u
X1352 sg13cmos5l_dfrbpq_1_0.D a_28374_1656# VGND.t11 VGND.t406 sg13_lv_nmos ad=0.2516p pd=2.16u as=0.1426p ps=1.16u w=0.74u l=0.13u
X1353 a_25029_6179# sg13cmos5l_dfrbpq_1_53.CLK VGND.t25 VGND.t1308 sg13_lv_nmos ad=0.2516p pd=2.16u as=3.31142p ps=20.535u w=0.74u l=0.13u
X1354 VGND.t365 a_14926_1059# sg13cmos5l_dfrbpq_1_12.D VGND.t364 sg13_lv_nmos ad=0.1426p pd=1.16u as=0.2516p ps=2.16u w=0.74u l=0.13u
X1355 a_10812_3505# a_10943_3115# a_10231_3108# VPWR.t10 sg13_lv_pmos ad=0.34p pd=2.68u as=0.2048p ps=1.63u w=1u l=0.13u
X1356 VPWR.t1030 a_9446_4656# a_9558_4680# VPWR.t43 sg13_lv_pmos ad=0.2254p pd=1.53u as=0.34p ps=2.68u w=1u l=0.5u
X1357 VPWR.t214 sg13cmos5l_xnor2_1_0.A a_15930_1168# VPWR.t15 sg13_lv_pmos ad=0.2891p pd=1.695u as=0.1428p ps=1.375u w=1.12u l=0.13u
X1358 a_15542_2057# a_14364_1993# a_15146_1912# VGND.t394 sg13_lv_nmos ad=37.8f pd=0.6u as=0.1428p ps=1.52u w=0.42u l=0.13u
X1359 a_5319_1719# a_5471_1603# VPWR.t105 VPWR.t15 sg13_lv_pmos ad=0.3864p pd=2.93u as=1.50275p ps=9.57u w=1.12u l=0.13u
X1360 VPWR.t485 sg13cmos5l_nor4_2_3.Y sg13cmos5l_nand3_1_3.Y VPWR.t10 sg13_lv_pmos ad=0.2128p pd=1.5u as=0.3808p ps=2.92u w=1.12u l=0.13u
X1361 a_20805_3873# sg13cmos5l_dfrbpq_1_0.CLK VGND.t50 VGND.t1148 sg13_lv_nmos ad=0.2516p pd=2.16u as=3.63467p ps=22.73u w=0.74u l=0.13u
X1362 VGND.t50 sg13cmos5l_dfrbpq_1_21.CLK a_7103_4164# VGND.t1336 sg13_lv_nmos ad=3.63467p pd=22.73u as=0.2516p ps=2.16u w=0.74u l=0.13u
X1363 a_11824_8650# a_11567_8507# a_11986_8430# VGND.t700 sg13_lv_nmos ad=0.1428p pd=1.52u as=37.8f ps=0.6u w=0.42u l=0.13u
X1364 VPWR.t140 sg13cmos5l_dfrbpq_1_57.RESET_B.t6 a_13773_6964# VPWR.t2 sg13_lv_pmos ad=0.1918p pd=1.5u as=0.1596p ps=1.22u w=0.84u l=0.13u
X1365 sg13cmos5l_dfrbpq_1_56.CLK a_18363_6922# VPWR.t873 VPWR.t2 sg13_lv_pmos ad=0.2128p pd=1.5u as=0.2128p ps=1.5u w=1.12u l=0.13u
X1366 sg13cmos5l_nor4_2_5.Y sg13cmos5l_nor4_2_5.D VGND.t453 VGND.t452 sg13_lv_nmos ad=0.1406p pd=1.12u as=0.2516p ps=2.16u w=0.74u l=0.13u
X1367 VPWR.t3 sg13cmos5l_xnor2_1_10.Y a_21719_7727# VPWR.t2 sg13_lv_pmos ad=0.1428p pd=1.52u as=79.8f ps=0.8u w=0.42u l=0.13u
X1368 VGND.t332 a_14235_6922# sg13cmos5l_buf_8_10.A VGND.t95 sg13_lv_nmos ad=0.2516p pd=2.16u as=0.1406p ps=1.12u w=0.74u l=0.13u
X1369 VGND.t88 a_16624_7922# a_16273_8041# VGND.t87 sg13_lv_nmos ad=79.8f pd=0.8u as=0.1428p ps=1.52u w=0.42u l=0.13u
X1370 VGND.t83 VPWR.t1461 VGND.t1493 VGND.t1492 sg13_lv_nmos ad=79.8f pd=0.8u as=0 ps=0 w=0.42u l=1u
X1371 VPWR.t277 sg13cmos5l_buf_8_2.X a_27195_3514# VPWR.t10 sg13_lv_pmos ad=0.2128p pd=1.5u as=0.2128p ps=1.5u w=1.12u l=0.13u
X1372 VPWR.t309 a_25103_6995# a_25770_7216# VPWR.t2 sg13_lv_pmos ad=0.2128p pd=1.5u as=0.3864p ps=2.93u w=1.12u l=0.13u
X1373 VPWR.t937 sg13cmos5l_and2_1_3.A a_3680_5609# VPWR.t7 sg13_lv_pmos ad=0.2856p pd=2.36u as=0.1596p ps=1.22u w=0.84u l=0.13u
X1374 a_23846_3898# a_23576_3898# VPWR.t227 VPWR.t43 sg13_lv_pmos ad=0.34p pd=2.68u as=0.1523p ps=1.38u w=1u l=0.5u
X1375 VPWR.t749 a_16188_5017# a_17211_4703# VPWR.t43 sg13_lv_pmos ad=0.1563p pd=1.22u as=63f ps=0.72u w=0.42u l=0.13u
X1376 a_27598_4083# a_27713_4084# VGND.t58 VGND.t1637 sg13_lv_nmos ad=0.1428p pd=1.52u as=0.1426p ps=1.16u w=0.42u l=0.5u
X1377 sg13cmos5l_dfrbpq_1_5.Q a_19722_4192# VPWR.t224 VPWR.t43 sg13_lv_pmos ad=0.3808p pd=2.92u as=0.2128p ps=1.5u w=1.12u l=0.13u
X1378 a_15525_7691# sg13cmos5l_dfrbpq_1_56.CLK VGND.t0 VGND.t369 sg13_lv_nmos ad=0.2516p pd=2.16u as=3.2221p ps=20.04u w=0.74u l=0.13u
X1379 a_1211_5004# sg13cmos5l_dfrbpq_1_23.D VGND.t30 VGND.t30 sg13_lv_nmos ad=78.39999f pd=0.885u as=0.2272p ps=1.99u w=0.64u l=0.13u
X1380 VPWR.t907 a_18922_7644# sg13cmos5l_dfrbpq_1_46.CLK VPWR.t2 sg13_lv_pmos ad=0.2128p pd=1.5u as=0.2128p ps=1.5u w=1.12u l=0.13u
X1381 VPWR.t221 sg13cmos5l_buf_1_0.X.t5 a_24586_6136# VPWR.t7 sg13_lv_pmos ad=0.1563p pd=1.22u as=0.147p ps=1.54u w=0.42u l=0.13u
X1382 VPWR.t214 sg13cmos5l_xnor2_1_0.A a_15756_1060# VPWR.t15 sg13_lv_pmos ad=0.4536p pd=2.76u as=0.1596p ps=1.22u w=0.84u l=0.13u
X1383 sg13cmos5l_xnor2_1_9.A sg13cmos5l_nor4_2_9.Y VPWR.t893 VPWR.t2 sg13_lv_pmos ad=0.3808p pd=2.92u as=0.2128p ps=1.5u w=1.12u l=0.13u
X1384 VPWR.t872 sg13cmos5l_buf_8_10.A a_18363_6922# VPWR.t2 sg13_lv_pmos ad=0.2128p pd=1.5u as=0.2128p ps=1.5u w=1.12u l=0.13u
X1385 VGND.t30 a_26181_4667# a_26283_4667# VGND.t335 sg13_lv_nmos ad=3.5351p pd=22.08u as=0.2516p ps=2.16u w=0.74u l=0.13u
X1386 sg13cmos5l_buf_8_10.A a_14235_6922# VGND.t332 VGND.t95 sg13_lv_nmos ad=0.1406p pd=1.12u as=0.1406p ps=1.12u w=0.74u l=0.13u
X1387 a_2165_6922# sg13cmos5l_xnor2_1_13.Y VGND.t278 VGND.t1002 sg13_lv_nmos ad=0.1406p pd=1.12u as=0.1898p ps=1.36u w=0.74u l=0.13u
X1388 a_6250_7141# a_6693_6897# a_5990_6918# VGND.t909 sg13_lv_nmos ad=79.8f pd=0.8u as=0.1296p ps=1.52u w=0.42u l=0.13u
X1389 sg13cmos5l_nor4_2_3.Y sg13cmos5l_dlygate4sd3_1_21.X a_8042_3144# VPWR.t10 sg13_lv_pmos ad=0.2128p pd=1.5u as=0.3808p ps=2.92u w=1.12u l=0.13u
X1390 VPWR.t692 sg13cmos5l_xnor2_1_3.A a_18618_1168# VPWR.t15 sg13_lv_pmos ad=0.2891p pd=1.695u as=0.1428p ps=1.375u w=1.12u l=0.13u
X1391 VGND.t58 a_26159_3505# a_26826_3144# VGND.t207 sg13_lv_nmos ad=0.1406p pd=1.12u as=0.2516p ps=2.16u w=0.74u l=0.13u
X1392 VGND.t145 a_18363_6922# sg13cmos5l_dfrbpq_1_56.CLK VGND.t986 sg13_lv_nmos ad=0.2516p pd=2.16u as=0.1406p ps=1.12u w=0.74u l=0.13u
X1393 a_19888_2602# a_19631_2459# a_20050_2382# VGND.t8 sg13_lv_nmos ad=0.1428p pd=1.52u as=37.8f ps=0.6u w=0.42u l=0.13u
X1394 VGND.t40 VPWR.t1476 VGND.t40 VGND.t1461 sg13_lv_nmos ad=0.1428p pd=1.52u as=0 ps=0 w=0.42u l=1u
X1395 sg13cmos5l_dfrbpq_1_46.CLK a_18922_7644# VPWR.t903 VPWR.t2 sg13_lv_pmos ad=0.2128p pd=1.5u as=0.2128p ps=1.5u w=1.12u l=0.13u
X1396 VPWR.t6 a_23835_8050# sg13cmos5l_buf_8_11.A VPWR.t2 sg13_lv_pmos ad=0.3864p pd=2.93u as=0.2128p ps=1.5u w=1.12u l=0.13u
X1397 a_19799_1679# sg13cmos5l_dfrbpq_1_3.D a_20546_2070# VGND.t487 sg13_lv_nmos ad=0.1428p pd=1.52u as=60.89999f ps=0.71u w=0.42u l=0.13u
X1398 VGND.t137 VPWR.t79 VGND.t17 VGND.t1526 sg13_lv_nmos ad=0.1428p pd=1.52u as=0 ps=0 w=0.42u l=1u
X1399 VGND.t25 a_6597_6179# a_6699_6179# VGND.t1285 sg13_lv_nmos ad=3.51837p pd=21.815u as=0.2516p ps=2.16u w=0.74u l=0.13u
X1400 a_24881_8484# sg13cmos5l_dfrbpq_1_37.D VGND.t62 VGND.t973 sg13_lv_nmos ad=0.17462p pd=1.185u as=0.374p ps=2.46u w=0.55u l=0.13u
X1401 VPWR.t662 a_17423_5483# a_18090_5704# VPWR.t7 sg13_lv_pmos ad=0.2128p pd=1.5u as=0.3864p ps=2.93u w=1.12u l=0.13u
X1402 VGND.t96 a_11733_6215# a_10812_6529# VGND.t1353 sg13_lv_nmos ad=0.1626p pd=1.415u as=0.2516p ps=2.16u w=0.74u l=0.13u
X1403 a_8042_3144# sg13cmos5l_dfrbpq_1_12.D a_7744_3144# VPWR.t10 sg13_lv_pmos ad=0.2128p pd=1.5u as=0.2128p ps=1.5u w=1.12u l=0.13u
X1404 a_7351_1596# a_7911_1719# a_7932_1993# VGND.t872 sg13_lv_nmos ad=0.12665p pd=1.145u as=0.3473p ps=2.71u w=0.74u l=0.13u
X1405 sg13cmos5l_dlygate4sd3_1_35.A a_5802_8728# VPWR.t319 VPWR.t0 sg13_lv_pmos ad=0.3808p pd=2.92u as=0.2128p ps=1.5u w=1.12u l=0.13u
X1406 VGND.t350 sg13cmos5l_dfrbpq_1_56.RESET_B a_15914_5094# VGND.t834 sg13_lv_nmos ad=79.8f pd=0.8u as=37.8f ps=0.6u w=0.42u l=0.13u
X1407 VPWR.t329 sg13cmos5l_buf_1_4.X.t2 a_25066_1093# VPWR.t15 sg13_lv_pmos ad=0.1563p pd=1.22u as=0.147p ps=1.54u w=0.42u l=0.13u
X1408 a_20102_3894# sg13cmos5l_nor4_2_1.A VPWR.t617 VPWR.t43 sg13_lv_pmos ad=79.8f pd=0.8u as=0.1428p ps=1.52u w=0.42u l=0.13u
X1409 sg13cmos5l_dfrbpq_1_56.CLK a_18363_6922# VGND.t145 VGND.t983 sg13_lv_nmos ad=0.1406p pd=1.12u as=0.1406p ps=1.12u w=0.74u l=0.13u
X1410 sg13cmos5l_buf_8_11.A a_23835_8050# VPWR.t6 VPWR.t2 sg13_lv_pmos ad=0.2128p pd=1.5u as=0.2128p ps=1.5u w=1.12u l=0.13u
X1411 VGND.t280 VPWR.t1468 VGND.t280 VGND.t1481 sg13_lv_nmos ad=79.8f pd=0.8u as=0 ps=0 w=0.42u l=1u
X1412 sg13cmos5l_dlygate4sd3_1_52.X a_9558_4680# VGND.t535 VGND.t534 sg13_lv_nmos ad=0.2516p pd=2.16u as=0.1426p ps=1.16u w=0.74u l=0.13u
X1413 VPWR.t1414 a_8763_8434# sg13cmos5l_dfrbpq_1_32.CLK VPWR.t0 sg13_lv_pmos ad=0.2128p pd=1.5u as=0.2128p ps=1.5u w=1.12u l=0.13u
X1414 a_25094_8118# sg13cmos5l_nor4_2_7.D VPWR.t6 VPWR.t2 sg13_lv_pmos ad=79.8f pd=0.8u as=0.1428p ps=1.52u w=0.42u l=0.13u
X1415 VGND.t52 sg13cmos5l_nor4_2_9.D sg13cmos5l_nor4_2_9.Y VGND.t30 sg13_lv_nmos ad=0.2516p pd=2.16u as=0.1406p ps=1.12u w=0.74u l=0.13u
X1416 a_25738_4624# a_26181_4667# a_26121_4703# VPWR.t43 sg13_lv_pmos ad=79.8f pd=0.8u as=63f ps=0.72u w=0.42u l=0.13u
X1417 VGND.t77 a_8133_2361# a_8235_2504# VGND.t226 sg13_lv_nmos ad=3.25012p pd=20.49u as=0.2516p ps=2.16u w=0.74u l=0.13u
X1418 a_6250_3108# sg13cmos5l_buf_8_4.A VGND.t50 VGND.t674 sg13_lv_nmos ad=0.2553p pd=2.17u as=0.1406p ps=1.12u w=0.74u l=0.13u
X1419 a_17231_6529# a_16389_6179# a_17137_6529# VGND.t48 sg13_lv_nmos ad=0.12665p pd=1.145u as=0.1428p ps=1.52u w=0.42u l=0.13u
X1420 a_19845_849# sg13cmos5l_dfrbpq_1_2.CLK VPWR.t105 VPWR.t15 sg13_lv_pmos ad=0.4088p pd=2.97u as=1.46697p ps=9.345u w=1.12u l=0.13u
X1421 VPWR.t105 sg13cmos5l_dfrbpq_1_13.RESET_B.t10 a_7564_2070# VPWR.t15 sg13_lv_pmos ad=1.46697p pd=9.345u as=79.8f ps=0.8u w=0.42u l=0.13u
X1422 sg13cmos5l_nor4_2_3.Y sg13cmos5l_xnor2_1_6.B VGND.t50 VGND.t1549 sg13_lv_nmos ad=0.1406p pd=1.12u as=0.3293p ps=1.63u w=0.74u l=0.13u
X1423 a_20871_7136# a_21023_7188# VGND.t25 VGND.t1029 sg13_lv_nmos ad=0.2516p pd=2.16u as=3.51837p ps=21.815u w=0.74u l=0.13u
X1424 VPWR.t401 sg13cmos5l_dfrbpq_1_53.RESET_B.t6 a_26410_7141# VPWR.t2 sg13_lv_pmos ad=0.1563p pd=1.22u as=0.147p ps=1.54u w=0.42u l=0.13u
X1425 a_10022_2070# sg13cmos5l_dfrbpq_1_12.D VPWR.t108 VPWR.t15 sg13_lv_pmos ad=79.8f pd=0.8u as=0.1428p ps=1.52u w=0.42u l=0.13u
X1426 a_17274_2680# sg13cmos5l_xnor2_1_2.Y sg13cmos5l_xnor2_1_5.Y VPWR.t10 sg13_lv_pmos ad=0.1428p pd=1.375u as=0.2408p ps=1.55u w=1.12u l=0.13u
X1427 a_15598_8430# a_15340_8430# VGND.t93 VGND.t366 sg13_lv_nmos ad=0.1428p pd=1.52u as=79.8f ps=0.8u w=0.42u l=0.13u
X1428 VPWR.t190 a_3790_1899# sg13cmos5l_dlygate4sd3_1_19.X VPWR.t15 sg13_lv_pmos ad=0.2254p pd=1.53u as=0.4256p ps=3u w=1.12u l=0.13u
X1429 a_7799_4285# sg13cmos5l_dfrbpq_1_21.RESET_B.t5 VPWR.t218 VPWR.t43 sg13_lv_pmos ad=79.8f pd=0.8u as=0.36237p ps=2.605u w=0.42u l=0.13u
X1430 VGND.t191 a_17231_6529# a_17898_6168# VGND.t1155 sg13_lv_nmos ad=0.1406p pd=1.12u as=0.2516p ps=2.16u w=0.74u l=0.13u
X1431 a_14254_2070# a_13996_2070# VGND.t324 VGND.t323 sg13_lv_nmos ad=0.1428p pd=1.52u as=79.8f ps=0.8u w=0.42u l=0.13u
X1432 a_16624_7922# sg13cmos5l_dfrbpq_1_57.RESET_B.t9 VPWR.t2 VPWR.t2 sg13_lv_pmos ad=79.8f pd=0.8u as=1.31957p ps=8.38u w=0.42u l=0.13u
X1433 VPWR.t8 a_21647_6529# a_22314_6168# VPWR.t7 sg13_lv_pmos ad=0.2128p pd=1.5u as=0.3864p ps=2.93u w=1.12u l=0.13u
X1434 a_20311_7644# a_20871_7767# a_20892_8041# VGND.t919 sg13_lv_nmos ad=0.12665p pd=1.145u as=0.3473p ps=2.71u w=0.74u l=0.13u
X1435 VGND.t52 sg13cmos5l_dlygate4sd3_1_19.X sg13cmos5l_nor4_2_9.Y VGND.t30 sg13_lv_nmos ad=0.3293p pd=1.63u as=0.1406p ps=1.12u w=0.74u l=0.13u
X1436 a_17036_1596# sg13cmos5l_buf_1_2.A VPWR.t191 VPWR.t15 sg13_lv_pmos ad=0.2856p pd=2.36u as=0.2114p ps=1.54u w=0.84u l=0.13u
X1437 VGND.t393 a_11567_1993# a_12234_1632# VGND.t482 sg13_lv_nmos ad=0.1406p pd=1.12u as=0.2516p ps=2.16u w=0.74u l=0.13u
X1438 a_5990_6918# sg13cmos5l_nor4_2_5.B VPWR.t851 VPWR.t2 sg13_lv_pmos ad=79.8f pd=0.8u as=0.1428p ps=1.52u w=0.42u l=0.13u
X1439 sg13cmos5l_dlygate4sd3_1_22.X a_2166_938# VGND.t32 VGND.t1607 sg13_lv_nmos ad=0.2516p pd=2.16u as=0.1426p ps=1.16u w=0.74u l=0.13u
X1440 sg13cmos5l_nor4_2_3.Y sg13cmos5l_xnor2_1_6.A VGND.t50 VGND.t1431 sg13_lv_nmos ad=0.1406p pd=1.12u as=0.2553p ps=2.17u w=0.74u l=0.13u
X1441 a_6453_4703# sg13cmos5l_dfrbpq_1_58.RESET_B VPWR.t846 VPWR.t43 sg13_lv_pmos ad=0.147p pd=1.54u as=0.1563p ps=1.22u w=0.42u l=0.13u
X1442 VPWR.t420 sg13cmos5l_nor3_1_2.B a_6071_7727# VPWR.t2 sg13_lv_pmos ad=0.1428p pd=1.52u as=79.8f ps=0.8u w=0.42u l=0.13u
X1443 a_6645_5564# a_5703_5624# a_6506_5564# VGND.t256 sg13_lv_nmos ad=79.8f pd=0.8u as=0.2373p ps=1.97u w=0.42u l=0.13u
X1444 sg13cmos5l_dfrbpq_1_57.RESET_B a_8776_5444# VGND.t131 VGND.t1287 sg13_lv_nmos ad=0.2886p pd=2.26u as=0.14875p ps=1.16u w=0.74u l=0.13u
X1445 a_1979_5452# sg13cmos5l_nand3_1_1.Y VGND.t30 VGND.t194 sg13_lv_nmos ad=78.39999f pd=0.885u as=0.2272p ps=1.99u w=0.64u l=0.13u
X1446 a_21647_5017# a_20805_4667# a_20388_4660# VPWR.t43 sg13_lv_pmos ad=0.2048p pd=1.63u as=0.34p ps=2.68u w=1u l=0.13u
X1447 a_19312_4114# sg13cmos5l_buf_1_4.X.t7 VPWR.t43 VPWR.t43 sg13_lv_pmos ad=79.8f pd=0.8u as=1.36105p ps=8.695u w=0.42u l=0.13u
X1448 VGND.t54 a_21435_3514# sg13cmos5l_buf_8_2.X VGND.t53 sg13_lv_nmos ad=0.1406p pd=1.12u as=0.1406p ps=1.12u w=0.74u l=0.13u
X1449 VPWR.t631 a_6250_3108# sg13cmos5l_dfrbpq_1_21.CLK VPWR.t10 sg13_lv_pmos ad=0.2128p pd=1.5u as=0.2128p ps=1.5u w=1.12u l=0.13u
X1450 a_20871_7767# a_21023_7651# VPWR.t2 VPWR.t2 sg13_lv_pmos ad=0.3864p pd=2.93u as=1.34765p ps=8.56u w=1.12u l=0.13u
X1451 a_23844_7236# a_24363_7040# a_25103_6995# VGND.t5 sg13_lv_nmos ad=0.3473p pd=2.71u as=0.12665p ps=1.145u w=0.74u l=0.13u
X1452 VGND.t50 osc a_15850_3862# VGND.t1447 sg13_lv_nmos ad=0.1406p pd=1.12u as=0.1406p ps=1.12u w=0.74u l=0.13u
X1453 VPWR.t221 sg13cmos5l_nand3_1_2.Y a_24954_5704# VPWR.t7 sg13_lv_pmos ad=0.2891p pd=1.695u as=0.1428p ps=1.375u w=1.12u l=0.13u
X1454 VGND.t235 a_21934_1059# sg13cmos5l_nor3_1_0.A VGND.t517 sg13_lv_nmos ad=0.1426p pd=1.16u as=0.2516p ps=2.16u w=0.74u l=0.13u
X1455 a_27994_3862# sg13cmos5l_dlygate4sd3_1_9.A VGND.t58 VGND.t375 sg13_lv_nmos ad=0.1428p pd=1.52u as=79.8f ps=0.8u w=0.42u l=0.13u
X1456 VGND.t197 sg13cmos5l_dlygate4sd3_1_4.X sg13cmos5l_nand3_1_2.C VGND.t1206 sg13_lv_nmos ad=0.1463p pd=1.15u as=0.2618p ps=2.22u w=0.77u l=0.13u
X1457 a_6261_1679# sg13cmos5l_dfrbpq_1_13.RESET_B.t11 VPWR.t439 VPWR.t15 sg13_lv_pmos ad=0.147p pd=1.54u as=0.1563p ps=1.22u w=0.42u l=0.13u
X1458 VPWR.t91 a_26159_3505# a_26416_3386# VPWR.t10 sg13_lv_pmos ad=1.43285p pd=9.125u as=79.8f ps=0.8u w=0.42u l=0.13u
X1459 VPWR.t212 sg13cmos5l_buf_1_4.X.t8 a_17770_4117# VPWR.t43 sg13_lv_pmos ad=0.1563p pd=1.22u as=0.147p ps=1.54u w=0.42u l=0.13u
X1460 a_24900_3148# a_24874_3112# VGND.t293 VGND.t1279 sg13_lv_nmos ad=0.2516p pd=2.16u as=0.1626p ps=1.415u w=0.74u l=0.13u
X1461 a_10282_1093# a_10725_849# a_10665_1261# VPWR.t15 sg13_lv_pmos ad=79.8f pd=0.8u as=63f ps=0.72u w=0.42u l=0.13u
X1462 VGND.t856 sg13cmos5l_dfrbpq_1_21.RESET_B.t10 a_7140_8118# VGND.t431 sg13_lv_nmos ad=0.1626p pd=1.415u as=60.89999f ps=0.71u w=0.42u l=0.13u
X1463 a_21435_3514# sg13cmos5l_and2_1_0.X VGND.t54 VGND.t53 sg13_lv_nmos ad=0.1406p pd=1.12u as=0.1406p ps=1.12u w=0.74u l=0.13u
X1464 sg13cmos5l_dfrbpq_1_21.CLK a_6250_3108# VPWR.t627 VPWR.t10 sg13_lv_pmos ad=0.2128p pd=1.5u as=0.2128p ps=1.5u w=1.12u l=0.13u
X1465 a_20676_8443# a_20388_8748# a_20614_8443# VGND.t0 sg13_lv_nmos ad=0.1428p pd=1.52u as=37.8f ps=0.6u w=0.42u l=0.13u
X1466 VGND.t664 a_7534_4923# sg13cmos5l_xnor2_1_12.B VGND.t754 sg13_lv_nmos ad=0.1426p pd=1.16u as=0.2516p ps=2.16u w=0.74u l=0.13u
X1467 VGND.t50 sg13cmos5l_nor3_1_4.Y a_17250_3902# VGND.t561 sg13_lv_nmos ad=0.2886p pd=2.26u as=0.1406p ps=1.12u w=0.74u l=0.13u
X1468 a_5392_8650# a_5135_8507# a_5554_8430# VGND.t310 sg13_lv_nmos ad=0.1428p pd=1.52u as=37.8f ps=0.6u w=0.42u l=0.13u
X1469 VPWR.t1049 sg13cmos5l_buf_1_4.X.t4 a_24874_3112# VPWR.t10 sg13_lv_pmos ad=0.1563p pd=1.22u as=0.147p ps=1.54u w=0.42u l=0.13u
X1470 VGND.t77 sg13cmos5l_dfrbpq_1_13.CLK a_8063_1603# VGND.t226 sg13_lv_nmos ad=3.06955p pd=19.355u as=0.2516p ps=2.16u w=0.74u l=0.13u
X1471 a_4359_2600# a_4511_2652# VGND.t77 VGND.t618 sg13_lv_nmos ad=0.2516p pd=2.16u as=3.25012p ps=20.49u w=0.74u l=0.13u
X1472 a_25162_4117# a_25605_3873# a_25545_4285# VPWR.t43 sg13_lv_pmos ad=79.8f pd=0.8u as=63f ps=0.72u w=0.42u l=0.13u
X1473 sg13cmos5l_buf_8_3.A a_9915_3898# VPWR.t1333 VPWR.t43 sg13_lv_pmos ad=0.2128p pd=1.5u as=0.2128p ps=1.5u w=1.12u l=0.13u
X1474 a_11769_8745# a_10827_8552# a_11567_8507# VPWR.t0 sg13_lv_pmos ad=93.45f pd=0.865u as=0.2048p ps=1.63u w=0.42u l=0.13u
X1475 a_15780_6606# sg13cmos5l_nor3_1_4.A a_15686_6606# VGND.t95 sg13_lv_nmos ad=60.89999f pd=0.71u as=0.1428p ps=1.52u w=0.42u l=0.13u
X1476 a_27695_6995# a_26853_6897# a_26436_7236# VPWR.t2 sg13_lv_pmos ad=0.2048p pd=1.63u as=0.34p ps=2.68u w=1u l=0.13u
X1477 a_2054_874# a_1784_874# VGND.t35 VGND.t645 sg13_lv_nmos ad=0.1428p pd=1.52u as=79.8f ps=0.8u w=0.42u l=0.5u
X1478 VGND.t77 a_10725_1643# a_10827_1643# VGND.t480 sg13_lv_nmos ad=3.25012p pd=20.49u as=0.2516p ps=2.16u w=0.74u l=0.13u
X1479 a_25198_2070# a_25439_1603# a_24727_1596# VGND.t495 sg13_lv_nmos ad=0.1428p pd=1.52u as=0.12665p ps=1.145u w=0.42u l=0.13u
X1480 sg13cmos5l_dfrbpq_1_59.Q a_15786_2680# VGND.t396 VGND.t147 sg13_lv_nmos ad=0.2516p pd=2.16u as=0.1406p ps=1.12u w=0.74u l=0.13u
X1481 a_25605_3873# sg13cmos5l_dfrbpq_1_0.CLK VGND.t50 VGND.t1223 sg13_lv_nmos ad=0.2516p pd=2.16u as=3.63467p ps=22.73u w=0.74u l=0.13u
X1482 VGND.t145 sg13cmos5l_and2_1_1.A a_19609_6942# VGND.t987 sg13_lv_nmos ad=0.1371p pd=1.12u as=0.2176p ps=1.96u w=0.64u l=0.13u
X1483 a_3850_4117# a_4293_3873# a_4233_4285# VPWR.t43 sg13_lv_pmos ad=79.8f pd=0.8u as=63f ps=0.72u w=0.42u l=0.13u
X1484 VGND.t17 a_21062_1632# a_21174_1656# VGND.t1667 sg13_lv_nmos ad=0.1426p pd=1.16u as=0.1428p ps=1.52u w=0.42u l=0.5u
X1485 a_11733_3191# sg13cmos5l_dfrbpq_1_55.RESET_B VPWR.t522 VPWR.t10 sg13_lv_pmos ad=0.147p pd=1.54u as=0.1563p ps=1.22u w=0.42u l=0.13u
X1486 sg13cmos5l_and2_1_4.X a_13773_6964# VGND.t96 VGND.t95 sg13_lv_nmos ad=0.2516p pd=2.16u as=0.1331p ps=1.12u w=0.74u l=0.13u
X1487 a_26436_7236# a_26410_7141# VGND.t126 VGND.t426 sg13_lv_nmos ad=0.2516p pd=2.16u as=0.1626p ps=1.415u w=0.74u l=0.13u
X1488 VPWR.t43 sg13cmos5l_dfrbpq_1_57.RESET_B.t1 a_10444_5094# VPWR.t43 sg13_lv_pmos ad=1.3927p pd=8.9u as=79.8f ps=0.8u w=0.42u l=0.13u
X1489 sg13cmos5l_buf_8_11.A a_23835_8050# VPWR.t6 VPWR.t2 sg13_lv_pmos ad=0.2128p pd=1.5u as=0.2128p ps=1.5u w=1.12u l=0.13u
X1490 a_15119_2459# a_14277_2361# a_15025_2459# VGND.t147 sg13_lv_nmos ad=0.12665p pd=1.145u as=0.1428p ps=1.52u w=0.42u l=0.13u
X1491 a_28646_3898# a_28376_3898# VPWR.t1107 VPWR.t43 sg13_lv_pmos ad=0.34p pd=2.68u as=0.1523p ps=1.38u w=1u l=0.5u
X1492 sg13cmos5l_dlygate4sd3_1_40.A a_25770_7216# VGND.t126 VGND.t1005 sg13_lv_nmos ad=0.2516p pd=2.16u as=0.1406p ps=1.12u w=0.74u l=0.13u
X1493 sg13cmos5l_buf_8_4.A a_7594_5374# VGND.t664 VGND.t1162 sg13_lv_nmos ad=0.1406p pd=1.12u as=0.1406p ps=1.12u w=0.74u l=0.13u
X1494 a_17423_5483# a_16581_5385# a_17329_5483# VGND.t1360 sg13_lv_nmos ad=0.12665p pd=1.145u as=0.1428p ps=1.52u w=0.42u l=0.13u
X1495 VGND.t396 a_15285_1679# a_14364_1993# VGND.t395 sg13_lv_nmos ad=0.1626p pd=1.415u as=0.2516p ps=2.16u w=0.74u l=0.13u
X1496 VPWR.t79 VGND.t17 VPWR.t79 VPWR.t10 sg13_lv_pmos ad=0.34p pd=2.68u as=0 ps=0 w=1u l=1u
X1497 a_6747_5797# a_5855_5676# a_6645_5564# VPWR.t7 sg13_lv_pmos ad=63f pd=0.72u as=79.8f ps=0.8u w=0.42u l=0.13u
X1498 a_2259_4656# sg13cmos5l_xnor2_1_13.A VPWR.t1199 VPWR.t43 sg13_lv_pmos ad=0.1428p pd=1.375u as=0.2891p ps=1.695u w=1.12u l=0.13u
X1499 VPWR.t292 a_1870_6435# sg13cmos5l_dlygate4sd3_1_31.X VPWR.t7 sg13_lv_pmos ad=0.2254p pd=1.53u as=0.4256p ps=3u w=1.12u l=0.13u
X1500 VPWR.t7 a_17231_6529# a_17488_6410# VPWR.t7 sg13_lv_pmos ad=1.46065p pd=9.335u as=79.8f ps=0.8u w=0.42u l=0.13u
X1501 sg13cmos5l_xnor2_1_13.A sg13cmos5l_nor4_2_9.D a_1530_5422# VGND.t339 sg13_lv_nmos ad=0.1628p pd=1.18u as=88.8f ps=0.98u w=0.74u l=0.13u
X1502 a_20102_5406# a_20907_5528# a_20362_5629# VPWR.t7 sg13_lv_pmos ad=0.1428p pd=1.52u as=79.8f ps=0.8u w=0.42u l=0.13u
X1503 sg13cmos5l_nand3_1_2.A sg13cmos5l_dfrbpq_1_46.D VGND.t286 VGND.t285 sg13_lv_nmos ad=0.1406p pd=1.12u as=0.3293p ps=1.63u w=0.74u l=0.13u
X1504 VGND.t160 VPWR.t183 VGND.t160 VGND.t1541 sg13_lv_nmos ad=79.8f pd=0.8u as=0 ps=0 w=0.42u l=1u
X1505 a_27897_7233# a_26955_7040# a_27695_6995# VPWR.t2 sg13_lv_pmos ad=93.45f pd=0.865u as=0.2048p ps=1.63u w=0.42u l=0.13u
X1506 a_26181_5385# sg13cmos5l_dfrbpq_1_53.CLK VGND.t30 VGND.t1310 sg13_lv_nmos ad=0.2516p pd=2.16u as=3.32715p ps=20.78u w=0.74u l=0.13u
X1507 VPWR.t711 a_18826_4620# sg13cmos5l_dfrbpq_1_2.CLK VPWR.t43 sg13_lv_pmos ad=0.2128p pd=1.5u as=0.2128p ps=1.5u w=1.12u l=0.13u
X1508 a_18086_2382# sg13cmos5l_xnor2_1_1.Y VPWR.t188 VPWR.t10 sg13_lv_pmos ad=79.8f pd=0.8u as=0.1428p ps=1.52u w=0.42u l=0.13u
X1509 a_10596_6931# a_10827_7040# a_10282_7141# VGND.t654 sg13_lv_nmos ad=0.2373p pd=1.97u as=79.8f ps=0.8u w=0.42u l=0.13u
X1510 VPWR.t214 a_15322_838# a_15041_1060# VPWR.t15 sg13_lv_pmos ad=0.1523p pd=1.38u as=0.34p ps=2.68u w=1u l=0.5u
X1511 VGND.t11 a_27226_2350# a_26945_2572# VGND.t305 sg13_lv_nmos ad=79.8f pd=0.8u as=0.1428p ps=1.52u w=0.42u l=0.5u
X1512 a_10725_849# sg13cmos5l_dfrbpq_1_11.CLK VPWR.t105 VPWR.t15 sg13_lv_pmos ad=0.4088p pd=2.97u as=1.46697p ps=9.345u w=1.12u l=0.13u
X1513 sg13cmos5l_nor3_1_2.Y sg13cmos5l_nor3_1_2.C VGND.t280 VGND.t1078 sg13_lv_nmos ad=0.2618p pd=2.22u as=0.1463p ps=1.15u w=0.77u l=0.13u
X1514 sg13cmos5l_nand3_1_1.B sg13cmos5l_nor4_2_4.D VGND.t332 VGND.t95 sg13_lv_nmos ad=0.1406p pd=1.12u as=0.3293p ps=1.63u w=0.74u l=0.13u
X1515 sg13cmos5l_xnor2_1_13.A a_1265_5460# a_1436_5704# VPWR.t7 sg13_lv_pmos ad=0.3808p pd=2.92u as=0.2128p ps=1.5u w=1.12u l=0.13u
X1516 VPWR.t28 VGND.t119 VPWR.t28 VPWR.t15 sg13_lv_pmos ad=0.19p pd=1.38u as=0 ps=0 w=1u l=1u
X1517 VGND.t131 sg13cmos5l_dlygate4sd3_1_53.A a_8312_4697# VGND.t965 sg13_lv_nmos ad=79.8f pd=0.8u as=0.1428p ps=1.52u w=0.42u l=0.13u
X1518 a_4759_1596# a_5319_1719# a_5230_1755# VPWR.t15 sg13_lv_pmos ad=0.2048p pd=1.63u as=93.45f ps=0.865u w=0.42u l=0.13u
X1519 sg13cmos5l_buf_1_11.A a_1000_8468# VPWR.t1079 VPWR.t0 sg13_lv_pmos ad=0.42p pd=2.99u as=0.2114p ps=1.54u w=1.12u l=0.13u
X1520 a_14822_8118# sg13cmos5l_xor2_1_2.A VPWR.t830 VPWR.t2 sg13_lv_pmos ad=79.8f pd=0.8u as=0.1428p ps=1.52u w=0.42u l=0.13u
X1521 a_15285_1679# a_14343_1719# a_15191_1679# VPWR.t15 sg13_lv_pmos ad=79.8f pd=0.8u as=0.1428p ps=1.52u w=0.42u l=0.13u
X1522 VGND.t50 a_15850_3862# sg13cmos5l_buf_8_0.X VGND.t1117 sg13_lv_nmos ad=0.1406p pd=1.12u as=0.1406p ps=1.12u w=0.74u l=0.13u
X1523 sg13cmos5l_nand3_1_2.A sg13cmos5l_dlygate4sd3_1_6.X VGND.t20 VGND.t1408 sg13_lv_nmos ad=0.1406p pd=1.12u as=0.2553p ps=2.17u w=0.74u l=0.13u
X1524 VPWR.t35 VGND.t40 VPWR.t34 VPWR.t2 sg13_lv_pmos ad=0.34p pd=2.68u as=0 ps=0 w=1u l=1u
X1525 a_27023_8507# a_26181_8409# a_26929_8507# VGND.t72 sg13_lv_nmos ad=0.12665p pd=1.145u as=0.1428p ps=1.52u w=0.42u l=0.13u
X1526 VGND.t197 sg13cmos5l_dlygate4sd3_1_11.X sg13cmos5l_nand3_1_2.C VGND.t196 sg13_lv_nmos ad=0.2618p pd=2.22u as=0.1694p ps=1.21u w=0.77u l=0.13u
X1527 a_5392_3386# a_5135_3505# a_5554_3582# VGND.t674 sg13_lv_nmos ad=0.1428p pd=1.52u as=37.8f ps=0.6u w=0.42u l=0.13u
X1528 VGND.t842 a_17914_7644# a_17633_7946# VGND.t0 sg13_lv_nmos ad=79.8f pd=0.8u as=0.1428p ps=1.52u w=0.42u l=0.5u
X1529 sg13cmos5l_dfrbpq_1_2.CLK a_18826_4620# VPWR.t1015 VPWR.t43 sg13_lv_pmos ad=0.2128p pd=1.5u as=0.2128p ps=1.5u w=1.12u l=0.13u
X1530 a_25764_5724# a_25738_5629# VPWR.t221 VPWR.t7 sg13_lv_pmos ad=0.34p pd=2.68u as=0.36237p ps=2.605u w=1u l=0.13u
X1531 a_17702_3144# a_17432_3185# VGND.t50 VGND.t1410 sg13_lv_nmos ad=0.1428p pd=1.52u as=79.8f ps=0.8u w=0.42u l=0.5u
X1532 a_26866_3894# sg13cmos5l_buf_1_4.X.t5 VGND.t58 VGND.t57 sg13_lv_nmos ad=37.8f pd=0.6u as=79.8f ps=0.8u w=0.42u l=0.13u
X1533 VPWR.t6 VGND.t65 VPWR.t4 VPWR.t2 sg13_lv_pmos ad=0.19p pd=1.38u as=0 ps=0 w=1u l=1u
X1534 a_10308_1188# a_10282_1093# VGND.t165 VGND.t164 sg13_lv_nmos ad=0.2516p pd=2.16u as=0.1626p ps=1.415u w=0.74u l=0.13u
X1535 VPWR.t125 a_19631_2459# a_20298_2680# VPWR.t10 sg13_lv_pmos ad=0.2128p pd=1.5u as=0.3864p ps=2.93u w=1.12u l=0.13u
X1536 VGND.t453 a_4166_6168# a_4278_6192# VGND.t1270 sg13_lv_nmos ad=0.1426p pd=1.16u as=0.1428p ps=1.52u w=0.42u l=0.5u
X1537 a_7822_2070# a_7564_2070# VGND.t115 VGND.t817 sg13_lv_nmos ad=0.1428p pd=1.52u as=79.8f ps=0.8u w=0.42u l=0.13u
X1538 sg13cmos5l_dfrbpq_1_21.CLK a_6250_3108# VPWR.t624 VPWR.t10 sg13_lv_pmos ad=0.2128p pd=1.5u as=0.3864p ps=2.93u w=1.12u l=0.13u
X1539 sg13cmos5l_buf_8_0.X a_15850_3862# VGND.t50 VGND.t1114 sg13_lv_nmos ad=0.1406p pd=1.12u as=0.1406p ps=1.12u w=0.74u l=0.13u
X1540 a_1870_6435# a_1985_6434# VPWR.t292 VPWR.t7 sg13_lv_pmos ad=0.34p pd=2.68u as=0.2254p ps=1.53u w=1u l=0.5u
X1541 VPWR.t544 sg13cmos5l_nand3_1_1.A sg13cmos5l_nand3_1_1.Y VPWR.t43 sg13_lv_pmos ad=0.2128p pd=1.5u as=0.3808p ps=2.92u w=1.12u l=0.13u
X1542 sg13cmos5l_buf_8_3.A a_9915_3898# VPWR.t1176 VPWR.t43 sg13_lv_pmos ad=0.2128p pd=1.5u as=0.2128p ps=1.5u w=1.12u l=0.13u
X1543 VGND.t20 a_21904_8650# a_21553_8507# VGND.t1401 sg13_lv_nmos ad=79.8f pd=0.8u as=0.1428p ps=1.52u w=0.42u l=0.13u
X1544 a_13888_7680# sg13cmos5l_xor2_1_2.A a_14186_7680# VPWR.t2 sg13_lv_pmos ad=0.3808p pd=2.92u as=0.2128p ps=1.5u w=1.12u l=0.13u
X1545 a_6902_5419# a_5724_5370# a_6506_5564# VGND.t256 sg13_lv_nmos ad=37.8f pd=0.6u as=0.1428p ps=1.52u w=0.42u l=0.13u
X1546 sg13cmos5l_nor3_1_4.C a_15414_5474# VPWR.t575 VPWR.t7 sg13_lv_pmos ad=0.4256p pd=3u as=0.2254p ps=1.53u w=1.12u l=0.13u
X1547 a_28174_4923# a_28289_4922# VGND.t201 VGND.t200 sg13_lv_nmos ad=0.1428p pd=1.52u as=0.1426p ps=1.16u w=0.42u l=0.5u
X1548 VPWR.t1128 sg13cmos5l_buf_1_4.X.t4 a_24614_3582# VPWR.t10 sg13_lv_pmos ad=0.36237p pd=2.605u as=79.8f ps=0.8u w=0.42u l=0.13u
X1549 a_28662_2398# sg13cmos5l_dlygate4sd3_1_0.X sg13cmos5l_xnor2_1_3.A VGND.t303 sg13_lv_nmos ad=88.8f pd=0.98u as=0.1628p ps=1.18u w=0.74u l=0.13u
X1550 sg13cmos5l_xnor2_1_2.A a_9558_5474# VGND.t535 VGND.t534 sg13_lv_nmos ad=0.2516p pd=2.16u as=0.1426p ps=1.16u w=0.74u l=0.13u
X1551 a_18790_3569# sg13cmos5l_buf_1_1.X.t13 VGND.t50 VGND.t447 sg13_lv_nmos ad=37.8f pd=0.6u as=0.1701p ps=1.65u w=0.42u l=0.13u
X1552 VGND.t30 sg13cmos5l_dfrbpq_1_56.CLK a_16319_4627# VGND.t371 sg13_lv_nmos ad=3.32715p pd=20.78u as=0.2516p ps=2.16u w=0.74u l=0.13u
X1553 VGND.t861 VPWR.t1458 VGND.t861 VGND.t1505 sg13_lv_nmos ad=0.1428p pd=1.52u as=0 ps=0 w=0.42u l=1u
X1554 VPWR.t176 sg13cmos5l_buf_1_0.X.t3 a_20102_5406# VPWR.t7 sg13_lv_pmos ad=0.36237p pd=2.605u as=79.8f ps=0.8u w=0.42u l=0.13u
X1555 VGND.t332 a_15322_6132# a_15041_6434# VGND.t95 sg13_lv_nmos ad=79.8f pd=0.8u as=0.1428p ps=1.52u w=0.42u l=0.5u
X1556 a_5422_4779# a_5164_5094# VPWR.t43 VPWR.t43 sg13_lv_pmos ad=93.45f pd=0.865u as=1.3927p ps=8.9u w=0.42u l=0.13u
X1557 a_26229_1679# sg13cmos5l_buf_1_1.X.t3 VPWR.t152 VPWR.t15 sg13_lv_pmos ad=0.147p pd=1.54u as=0.1563p ps=1.22u w=0.42u l=0.13u
X1558 a_20388_6172# a_20362_6136# VGND.t145 VGND.t1133 sg13_lv_nmos ad=0.2516p pd=2.16u as=0.1626p ps=1.415u w=0.74u l=0.13u
X1559 VPWR.t91 a_19631_2459# a_19888_2602# VPWR.t10 sg13_lv_pmos ad=1.43285p pd=9.125u as=79.8f ps=0.8u w=0.42u l=0.13u
X1560 VPWR.t209 sg13cmos5l_buf_8_0.X a_18843_5410# VPWR.t7 sg13_lv_pmos ad=0.2128p pd=1.5u as=0.3808p ps=2.92u w=1.12u l=0.13u
X1561 a_27214_1899# a_27329_1898# VGND.t11 VGND.t896 sg13_lv_nmos ad=0.1428p pd=1.52u as=0.1426p ps=1.16u w=0.42u l=0.5u
X1562 VPWR.t1035 a_7594_5374# sg13cmos5l_buf_8_4.A VPWR.t7 sg13_lv_pmos ad=0.2128p pd=1.5u as=0.2128p ps=1.5u w=1.12u l=0.13u
X1563 a_16629_8588# sg13cmos5l_dfrbpq_1_56.RESET_B VPWR.t446 VPWR.t0 sg13_lv_pmos ad=0.147p pd=1.54u as=0.1563p ps=1.22u w=0.42u l=0.13u
X1564 VGND.t73 a_28652_7644# sg13cmos5l_buf_1_4.A VGND.t276 sg13_lv_nmos ad=0.14875p pd=1.16u as=0.2886p ps=2.26u w=0.74u l=0.13u
X1565 a_17584_7138# sg13cmos5l_dfrbpq_1_56.RESET_B VPWR.t2 VPWR.t2 sg13_lv_pmos ad=79.8f pd=0.8u as=1.34765p ps=8.56u w=0.42u l=0.13u
X1566 VGND.t632 sg13cmos5l_xor2_1_1.B a_1169_3502# VGND.t1121 sg13_lv_nmos ad=0.15245p pd=1.17u as=0.17462p ps=1.185u w=0.55u l=0.13u
X1567 VPWR.t79 a_22330_2350# a_22049_2572# VPWR.t10 sg13_lv_pmos ad=0.1523p pd=1.38u as=0.34p ps=2.68u w=1u l=0.5u
X1568 a_17327_6995# a_16485_6897# a_17233_6995# VGND.t124 sg13_lv_nmos ad=0.12665p pd=1.145u as=0.1428p ps=1.52u w=0.42u l=0.13u
X1569 a_26181_5385# sg13cmos5l_dfrbpq_1_53.CLK VPWR.t7 VPWR.t7 sg13_lv_pmos ad=0.4088p pd=2.97u as=1.42587p ps=9.11u w=1.12u l=0.13u
X1570 a_15191_1679# a_14495_1603# a_15285_1679# VGND.t152 sg13_lv_nmos ad=0.1296p pd=1.52u as=79.8f ps=0.8u w=0.42u l=0.13u
X1571 VPWR.t765 a_17914_7644# a_17633_7946# VPWR.t2 sg13_lv_pmos ad=0.1523p pd=1.38u as=0.34p ps=2.68u w=1u l=0.5u
X1572 VGND.t96 VPWR.t1470 VGND.t96 VGND.t95 sg13_lv_nmos ad=79.8f pd=0.8u as=0 ps=0 w=0.42u l=1u
X1573 VPWR.t566 sg13cmos5l_buf_1_4.A.t2 a_8776_908# VPWR.t15 sg13_lv_pmos ad=0.2114p pd=1.54u as=0.2856p ps=2.36u w=0.84u l=0.13u
X1574 a_6551_5797# sg13cmos5l_nor4_2_9.D a_7298_5406# VGND.t962 sg13_lv_nmos ad=0.1428p pd=1.52u as=60.89999f ps=0.71u w=0.42u l=0.13u
X1575 a_1115_916# sg13cmos5l_xnor2_1_6.A VGND.t35 VGND.t1434 sg13_lv_nmos ad=78.39999f pd=0.885u as=0.2272p ps=1.99u w=0.64u l=0.13u
X1576 sg13cmos5l_nand3_1_1.A sg13cmos5l_xnor2_1_2.B VGND.t40 VGND.t1088 sg13_lv_nmos ad=0.1406p pd=1.12u as=0.3293p ps=1.63u w=0.74u l=0.13u
X1577 a_15938_2070# sg13cmos5l_dfrbpq_1_55.RESET_B VGND.t396 VGND.t547 sg13_lv_nmos ad=60.89999f pd=0.71u as=0.1626p ps=1.415u w=0.42u l=0.13u
X1578 VPWR.t373 a_10112_7967# sg13cmos5l_dlygate4sd3_1_52.A VPWR.t2 sg13_lv_pmos ad=0.2128p pd=1.5u as=0.3808p ps=2.92u w=1.12u l=0.13u
X1579 VGND.t25 a_24261_6897# a_24363_7040# VGND.t24 sg13_lv_nmos ad=3.51837p pd=21.815u as=0.2516p ps=2.16u w=0.74u l=0.13u
X1580 VPWR.t2 sg13cmos5l_buf_1_0.X.t13 a_20524_8118# VPWR.t2 sg13_lv_pmos ad=1.31957p pd=8.38u as=79.8f ps=0.8u w=0.42u l=0.13u
X1581 VPWR.t645 a_2016_4209# sg13cmos5l_dfrbpq_1_18.D VPWR.t43 sg13_lv_pmos ad=0.3808p pd=2.92u as=0.2408p ps=1.55u w=1.12u l=0.13u
X1582 a_18391_1596# a_18951_1719# a_18862_1755# VPWR.t15 sg13_lv_pmos ad=0.2048p pd=1.63u as=93.45f ps=0.865u w=0.42u l=0.13u
X1583 VPWR.t105 sg13cmos5l_dfrbpq_1_11.CLK a_14495_1603# VPWR.t15 sg13_lv_pmos ad=1.46697p pd=9.345u as=0.4088p ps=2.97u w=1.12u l=0.13u
X1584 a_5614_5406# a_5855_5676# a_5143_5370# VGND.t1156 sg13_lv_nmos ad=0.1428p pd=1.52u as=0.12665p ps=1.145u w=0.42u l=0.13u
X1585 a_10282_7141# a_10725_6897# a_10665_7309# VPWR.t2 sg13_lv_pmos ad=79.8f pd=0.8u as=63f ps=0.72u w=0.42u l=0.13u
X1586 VPWR.t88 VGND.t280 VPWR.t86 VPWR.t7 sg13_lv_pmos ad=0.19p pd=1.38u as=0 ps=0 w=1u l=1u
X1587 a_11835_2773# a_10943_2652# a_11733_2540# VPWR.t10 sg13_lv_pmos ad=63f pd=0.72u as=79.8f ps=0.8u w=0.42u l=0.13u
X1588 a_10702_5094# a_10444_5094# VGND.t86 VGND.t85 sg13_lv_nmos ad=0.1428p pd=1.52u as=79.8f ps=0.8u w=0.42u l=0.13u
X1589 a_8955_1679# a_8063_1603# a_8853_1679# VPWR.t15 sg13_lv_pmos ad=63f pd=0.72u as=79.8f ps=0.8u w=0.42u l=0.13u
X1590 sg13cmos5l_and2_1_3.A a_13642_5374# VGND.t179 VGND.t528 sg13_lv_nmos ad=0.1406p pd=1.12u as=0.1406p ps=1.12u w=0.74u l=0.13u
X1591 a_23846_4656# a_23576_4697# VGND.t203 VGND.t142 sg13_lv_nmos ad=0.1428p pd=1.52u as=79.8f ps=0.8u w=0.42u l=0.5u
X1592 a_11824_5626# a_11567_5483# a_11986_5406# VGND.t710 sg13_lv_nmos ad=0.1428p pd=1.52u as=37.8f ps=0.6u w=0.42u l=0.13u
X1593 a_4832_4943# a_4951_4620# VPWR.t121 VPWR.t43 sg13_lv_pmos ad=0.3864p pd=2.93u as=0.2128p ps=1.5u w=1.12u l=0.13u
X1594 a_24727_1596# a_25287_1719# a_25308_1993# VGND.t21 sg13_lv_nmos ad=0.12665p pd=1.145u as=0.3473p ps=2.71u w=0.74u l=0.13u
X1595 VGND.t50 a_18213_3873# a_18315_4016# VGND.t1342 sg13_lv_nmos ad=3.8943p pd=24.355u as=0.2516p ps=2.16u w=0.74u l=0.13u
X1596 a_6180_6172# a_6699_6179# a_7439_6529# VGND.t338 sg13_lv_nmos ad=0.3473p pd=2.71u as=0.12665p ps=1.145u w=0.74u l=0.13u
X1597 a_16188_5017# a_16319_4627# a_15607_4620# VPWR.t43 sg13_lv_pmos ad=0.34p pd=2.68u as=0.2048p ps=1.63u w=1u l=0.13u
X1598 a_25738_5629# a_26181_5385# a_25478_5406# VGND.t334 sg13_lv_nmos ad=79.8f pd=0.8u as=0.1296p ps=1.52u w=0.42u l=0.13u
X1599 VPWR.t95 a_21062_1632# a_21174_1656# VPWR.t15 sg13_lv_pmos ad=0.2254p pd=1.53u as=0.34p ps=2.68u w=1u l=0.5u
X1600 VPWR.t65 VGND.t861 VPWR.t64 VPWR.t43 sg13_lv_pmos ad=0.34p pd=2.68u as=0 ps=0 w=1u l=1u
X1601 VGND.t35 sg13cmos5l_dfrbpq_1_13.CLK a_4511_1140# VGND.t747 sg13_lv_nmos ad=4.86777p pd=31.64u as=0.2516p ps=2.16u w=0.74u l=0.13u
X1602 VPWR.t2 a_25360_7138# a_25305_7233# VPWR.t2 sg13_lv_pmos ad=1.34765p pd=8.56u as=93.45f ps=0.865u w=0.42u l=0.13u
X1603 sg13cmos5l_xnor2_1_2.A a_9558_5474# VPWR.t494 VPWR.t7 sg13_lv_pmos ad=0.4256p pd=3u as=0.2254p ps=1.53u w=1.12u l=0.13u
X1604 VGND.t741 a_8848_7922# a_8497_8041# VGND.t355 sg13_lv_nmos ad=79.8f pd=0.8u as=0.1428p ps=1.52u w=0.42u l=0.13u
X1605 sg13cmos5l_xnor2_1_5.Y a_17100_2572# VPWR.t572 VPWR.t10 sg13_lv_pmos ad=0.2408p pd=1.55u as=0.3808p ps=2.92u w=1.12u l=0.13u
X1606 sg13cmos5l_dfrbpq_1_16.Q a_5802_3144# VPWR.t990 VPWR.t10 sg13_lv_pmos ad=0.3808p pd=2.92u as=0.2128p ps=1.5u w=1.12u l=0.13u
X1607 a_15302_5410# a_15032_5410# VPWR.t344 VPWR.t7 sg13_lv_pmos ad=0.34p pd=2.68u as=0.1523p ps=1.38u w=1u l=0.5u
X1608 a_22330_838# sg13cmos5l_dlygate4sd3_1_16.A VGND.t160 VGND.t159 sg13_lv_nmos ad=0.1428p pd=1.52u as=79.8f ps=0.8u w=0.42u l=0.13u
X1609 a_5724_5370# a_5855_5676# a_5143_5370# VPWR.t7 sg13_lv_pmos ad=0.34p pd=2.68u as=0.2048p ps=1.63u w=1u l=0.13u
X1610 a_20666_2680# sg13cmos5l_dfrbpq_1_0.D a_20972_2680# VPWR.t10 sg13_lv_pmos ad=0.2128p pd=1.5u as=0.3808p ps=2.92u w=1.12u l=0.13u
X1611 a_19142_870# sg13cmos5l_dfrbpq_1_2.D VPWR.t497 VPWR.t15 sg13_lv_pmos ad=79.8f pd=0.8u as=0.1428p ps=1.52u w=0.42u l=0.13u
X1612 VPWR.t1 a_5135_8507# a_5392_8650# VPWR.t0 sg13_lv_pmos ad=1.8922p pd=12.27u as=79.8f ps=0.8u w=0.42u l=0.13u
X1613 a_10665_8821# a_10308_8748# VPWR.t136 VPWR.t0 sg13_lv_pmos ad=63f pd=0.72u as=0.1563p ps=1.22u w=0.42u l=0.13u
X1614 a_20362_6136# a_20805_6179# a_20745_6215# VPWR.t7 sg13_lv_pmos ad=79.8f pd=0.8u as=63f ps=0.72u w=0.42u l=0.13u
X1615 a_17135_2386# sg13cmos5l_xnor2_1_5.A VGND.t156 VGND.t147 sg13_lv_nmos ad=0.2516p pd=2.16u as=0.1898p ps=1.36u w=0.74u l=0.13u
X1616 VPWR.t1 a_27280_8650# a_27225_8745# VPWR.t0 sg13_lv_pmos ad=1.8922p pd=12.27u as=93.45f ps=0.865u w=0.42u l=0.13u
X1617 a_11824_5626# sg13cmos5l_dfrbpq_1_57.RESET_B.t2 VPWR.t7 VPWR.t7 sg13_lv_pmos ad=79.8f pd=0.8u as=1.42587p ps=9.11u w=0.42u l=0.13u
X1618 a_11824_1090# a_11567_947# a_11986_870# VGND.t231 sg13_lv_nmos ad=0.1428p pd=1.52u as=37.8f ps=0.6u w=0.42u l=0.13u
X1619 VPWR.t877 a_18363_6922# sg13cmos5l_dfrbpq_1_56.CLK VPWR.t2 sg13_lv_pmos ad=0.2128p pd=1.5u as=0.2128p ps=1.5u w=1.12u l=0.13u
X1620 sg13cmos5l_nor4_2_1.D a_17814_3168# VGND.t50 VGND.t1458 sg13_lv_nmos ad=0.2516p pd=2.16u as=0.1426p ps=1.16u w=0.74u l=0.13u
X1621 a_5554_8430# sg13cmos5l_dfrbpq_1_21.RESET_B.t15 VGND.t358 VGND.t673 sg13_lv_nmos ad=37.8f pd=0.6u as=79.8f ps=0.8u w=0.42u l=0.13u
X1622 VGND.t0 sg13cmos5l_dfrbpq_1_56.CLK a_15839_8700# VGND.t369 sg13_lv_nmos ad=3.2221p pd=20.04u as=0.2516p ps=2.16u w=0.74u l=0.13u
X1623 VPWR.t397 sg13cmos5l_buf_1_0.X.t7 a_20102_6606# VPWR.t7 sg13_lv_pmos ad=0.36237p pd=2.605u as=79.8f ps=0.8u w=0.42u l=0.13u
X1624 VGND.t50 a_25317_3155# a_25419_3155# VGND.t1177 sg13_lv_nmos ad=3.8943p pd=24.355u as=0.2516p ps=2.16u w=0.74u l=0.13u
X1625 VPWR.t489 a_13642_5374# sg13cmos5l_and2_1_3.A VPWR.t7 sg13_lv_pmos ad=0.2128p pd=1.5u as=0.2128p ps=1.5u w=1.12u l=0.13u
X1626 a_11986_6918# sg13cmos5l_dfrbpq_1_57.RESET_B.t7 VGND.t96 VGND.t793 sg13_lv_nmos ad=37.8f pd=0.6u as=79.8f ps=0.8u w=0.42u l=0.13u
X1627 VPWR.t7 a_25029_6179# a_25131_6179# VPWR.t7 sg13_lv_pmos ad=1.46065p pd=9.335u as=0.3864p ps=2.93u w=1.12u l=0.13u
X1628 VGND.t17 sg13cmos5l_dfrbpq_1_0.D sg13cmos5l_nand3_1_0.A VGND.t806 sg13_lv_nmos ad=0.1406p pd=1.12u as=0.1406p ps=1.12u w=0.74u l=0.13u
X1629 a_25764_8748# a_26283_8552# a_27023_8507# VGND.t72 sg13_lv_nmos ad=0.3473p pd=2.71u as=0.12665p ps=1.145u w=0.74u l=0.13u
X1630 VGND.t25 sg13cmos5l_nor4_2_5.B sg13cmos5l_nor4_2_5.Y VGND.t952 sg13_lv_nmos ad=0.3293p pd=1.63u as=0.1406p ps=1.12u w=0.74u l=0.13u
X1631 VGND.t365 a_13563_874# sg13cmos5l_dfrbpq_1_11.CLK VGND.t510 sg13_lv_nmos ad=0.1406p pd=1.12u as=0.1406p ps=1.12u w=0.74u l=0.13u
X1632 VGND.t205 a_5301_2540# a_4380_2346# VGND.t795 sg13_lv_nmos ad=0.1626p pd=1.415u as=0.2516p ps=2.16u w=0.74u l=0.13u
X1633 VGND.t316 a_14630_3898# a_14742_3962# VGND.t758 sg13_lv_nmos ad=0.1426p pd=1.16u as=0.1428p ps=1.52u w=0.42u l=0.5u
X1634 VPWR.t105 a_11824_1090# a_11769_1185# VPWR.t15 sg13_lv_pmos ad=1.50275p pd=9.57u as=93.45f ps=0.865u w=0.42u l=0.13u
X1635 VGND.t508 sg13cmos5l_buf_1_4.A.t2 a_8776_908# VGND.t619 sg13_lv_nmos ad=0.14875p pd=1.16u as=0.187p ps=1.78u w=0.55u l=0.13u
X1636 a_21813_7076# sg13cmos5l_buf_1_0.X.t10 VPWR.t173 VPWR.t2 sg13_lv_pmos ad=0.147p pd=1.54u as=0.1563p ps=1.22u w=0.42u l=0.13u
X1637 sg13cmos5l_nor4_2_5.Y sg13cmos5l_nor4_2_5.C VGND.t453 VGND.t1095 sg13_lv_nmos ad=0.1406p pd=1.12u as=0.3293p ps=1.63u w=0.74u l=0.13u
X1638 a_21849_6291# a_20907_6179# a_21647_6529# VPWR.t7 sg13_lv_pmos ad=93.45f pd=0.865u as=0.2048p ps=1.63u w=0.42u l=0.13u
X1639 a_20871_7136# a_21023_7188# VPWR.t2 VPWR.t2 sg13_lv_pmos ad=0.3864p pd=2.93u as=1.34765p ps=8.56u w=1.12u l=0.13u
X1640 a_25188_3569# a_25419_3155# a_24874_3112# VGND.t643 sg13_lv_nmos ad=0.2373p pd=1.97u as=79.8f ps=0.8u w=0.42u l=0.13u
X1641 sg13cmos5l_dfrbpq_1_2.Q a_21354_1168# VPWR.t256 VPWR.t15 sg13_lv_pmos ad=0.3808p pd=2.92u as=0.2128p ps=1.5u w=1.12u l=0.13u
X1642 VPWR.t325 a_15008_8605# sg13cmos5l_dlygate4sd3_1_57.A VPWR.t0 sg13_lv_pmos ad=0.2128p pd=1.5u as=0.3808p ps=2.92u w=1.12u l=0.13u
X1643 VGND.t50 sg13cmos5l_dlygate4sd3_1_21.X sg13cmos5l_nor4_2_3.Y VGND.t545 sg13_lv_nmos ad=0.2516p pd=2.16u as=0.1406p ps=1.12u w=0.74u l=0.13u
X1644 a_8842_6886# sg13cmos5l_buf_8_10.A VGND.t630 VGND.t1081 sg13_lv_nmos ad=0.1406p pd=1.12u as=0.1406p ps=1.12u w=0.74u l=0.13u
X1645 sg13cmos5l_dlygate4sd3_1_1.A a_26346_2680# VGND.t11 VGND.t217 sg13_lv_nmos ad=0.2516p pd=2.16u as=0.1406p ps=1.12u w=0.74u l=0.13u
X1646 a_24996_3894# sg13cmos5l_nor3_1_0.B a_24902_3894# VGND.t202 sg13_lv_nmos ad=60.89999f pd=0.71u as=0.1428p ps=1.52u w=0.42u l=0.13u
X1647 a_17036_1596# sg13cmos5l_buf_1_2.A VGND.t467 VGND.t466 sg13_lv_nmos ad=0.187p pd=1.78u as=0.14875p ps=1.16u w=0.55u l=0.13u
X1648 sg13cmos5l_dfrbpq_1_16.Q a_5802_3144# VGND.t254 VGND.t674 sg13_lv_nmos ad=0.2516p pd=2.16u as=0.1406p ps=1.12u w=0.74u l=0.13u
X1649 a_23712_6207# sg13cmos5l_dfrbpq_1_46.D a_23675_6516# VGND.t64 sg13_lv_nmos ad=0.2176p pd=1.96u as=78.39999f ps=0.885u w=0.64u l=0.13u
X1650 a_9446_4656# a_9176_4697# VPWR.t306 VPWR.t43 sg13_lv_pmos ad=0.34p pd=2.68u as=0.1523p ps=1.38u w=1u l=0.5u
X1651 a_6951_8648# a_7103_8700# VGND.t0 VGND.t1211 sg13_lv_nmos ad=0.2516p pd=2.16u as=3.41162p ps=21.215u w=0.74u l=0.13u
X1652 a_3680_2557# a_3799_2346# VGND.t150 VGND.t382 sg13_lv_nmos ad=0.2516p pd=2.16u as=0.1406p ps=1.12u w=0.74u l=0.13u
X1653 VPWR.t436 a_27878_2386# a_27990_2450# VPWR.t10 sg13_lv_pmos ad=0.2254p pd=1.53u as=0.34p ps=2.68u w=1u l=0.5u
X1654 a_13574_2382# sg13cmos5l_nor3_1_1.A VPWR.t213 VPWR.t10 sg13_lv_pmos ad=79.8f pd=0.8u as=0.1428p ps=1.52u w=0.42u l=0.13u
X1655 a_27214_1899# a_27329_1898# VPWR.t385 VPWR.t15 sg13_lv_pmos ad=0.34p pd=2.68u as=0.2254p ps=1.53u w=1u l=0.5u
X1656 VGND.t50 sg13cmos5l_dfrbpq_1_12.D sg13cmos5l_nor4_2_3.Y VGND.t1231 sg13_lv_nmos ad=0.3293p pd=1.63u as=0.1406p ps=1.12u w=0.74u l=0.13u
X1657 a_5554_3582# sg13cmos5l_dfrbpq_1_21.RESET_B.t3 VGND.t254 VGND.t674 sg13_lv_nmos ad=37.8f pd=0.6u as=79.8f ps=0.8u w=0.42u l=0.13u
X1658 a_15376_3386# sg13cmos5l_dfrbpq_1_55.RESET_B VPWR.t91 VPWR.t10 sg13_lv_pmos ad=79.8f pd=0.8u as=1.4003p ps=8.92u w=0.42u l=0.13u
X1659 a_24838_6593# sg13cmos5l_buf_1_0.X.t5 VGND.t128 VGND.t485 sg13_lv_nmos ad=37.8f pd=0.6u as=0.1701p ps=1.65u w=0.42u l=0.13u
X1660 sg13cmos5l_dfrbpq_1_39.Q a_18090_5704# VGND.t30 VGND.t1366 sg13_lv_nmos ad=0.2516p pd=2.16u as=0.1406p ps=1.12u w=0.74u l=0.13u
X1661 a_20676_5419# a_20388_5724# a_20614_5419# VGND.t667 sg13_lv_nmos ad=0.1428p pd=1.52u as=37.8f ps=0.6u w=0.42u l=0.13u
X1662 VPWR.t91 a_24837_2361# a_24939_2504# VPWR.t10 sg13_lv_pmos ad=1.43285p pd=9.125u as=0.3864p ps=2.93u w=1.12u l=0.13u
X1663 VGND.t54 a_21435_3514# sg13cmos5l_buf_8_2.X VGND.t53 sg13_lv_nmos ad=0.2516p pd=2.16u as=0.1406p ps=1.12u w=0.74u l=0.13u
X1664 VGND.t54 VPWR.t76 VGND.t54 VGND.t202 sg13_lv_nmos ad=79.8f pd=0.8u as=0 ps=0 w=0.42u l=1u
X1665 VGND.t96 VPWR.t1465 VGND.t96 VGND.t95 sg13_lv_nmos ad=79.8f pd=0.8u as=0 ps=0 w=0.42u l=1u
X1666 VPWR.t142 a_11733_6215# a_10812_6529# VPWR.t7 sg13_lv_pmos ad=0.36237p pd=2.605u as=0.34p ps=2.68u w=1u l=0.13u
X1667 a_2266_1596# sg13cmos5l_dlygate4sd3_1_20.A VGND.t150 VGND.t794 sg13_lv_nmos ad=0.1428p pd=1.52u as=79.8f ps=0.8u w=0.42u l=0.13u
X1668 VGND.t293 sg13cmos5l_nand3_1_2.C a_24642_3902# VGND.t202 sg13_lv_nmos ad=0.2886p pd=2.26u as=0.1406p ps=1.12u w=0.74u l=0.13u
X1669 a_14277_3155# sg13cmos5l_dfrbpq_1_11.CLK VPWR.t91 VPWR.t10 sg13_lv_pmos ad=0.4088p pd=2.97u as=1.4003p ps=8.92u w=1.12u l=0.13u
X1670 VGND.t17 sg13cmos5l_dlygate4sd3_1_6.A a_20792_1673# VGND.t296 sg13_lv_nmos ad=79.8f pd=0.8u as=0.1428p ps=1.52u w=0.42u l=0.13u
X1671 a_8848_7922# a_8591_8041# a_9010_8118# VGND.t355 sg13_lv_nmos ad=0.1428p pd=1.52u as=37.8f ps=0.6u w=0.42u l=0.13u
X1672 sg13cmos5l_buf_8_2.X a_21435_3514# VGND.t54 VGND.t53 sg13_lv_nmos ad=0.1406p pd=1.12u as=0.1406p ps=1.12u w=0.74u l=0.13u
X1673 a_7893_8588# a_6951_8648# a_7754_8588# VGND.t221 sg13_lv_nmos ad=79.8f pd=0.8u as=0.2373p ps=1.97u w=0.42u l=0.13u
X1674 sg13cmos5l_dfrbpq_1_53.CLK a_27963_6538# VGND.t45 VGND.t1559 sg13_lv_nmos ad=0.1406p pd=1.12u as=0.1406p ps=1.12u w=0.74u l=0.13u
X1675 a_26361_3267# a_25419_3155# a_26159_3505# VPWR.t10 sg13_lv_pmos ad=93.45f pd=0.865u as=0.2048p ps=1.63u w=0.42u l=0.13u
X1676 VPWR.t117 sg13cmos5l_dfrbpq_1_37.D a_25052_8728# VPWR.t0 sg13_lv_pmos ad=0.2128p pd=1.5u as=0.3808p ps=2.92u w=1.12u l=0.13u
X1677 VGND.t52 sg13cmos5l_dfrbpq_1_58.RESET_B a_5450_5406# VGND.t51 sg13_lv_nmos ad=79.8f pd=0.8u as=37.8f ps=0.6u w=0.42u l=0.13u
X1678 a_18951_1719# a_19103_1603# VPWR.t105 VPWR.t15 sg13_lv_pmos ad=0.3864p pd=2.93u as=1.50275p ps=9.57u w=1.12u l=0.13u
X1679 a_23660_5704# sg13cmos5l_nor4_2_7.B a_23872_5704# VPWR.t7 sg13_lv_pmos ad=0.2128p pd=1.5u as=0.3808p ps=2.92u w=1.12u l=0.13u
X1680 VPWR.t483 a_11567_5483# a_12234_5704# VPWR.t7 sg13_lv_pmos ad=0.2128p pd=1.5u as=0.3864p ps=2.93u w=1.12u l=0.13u
X1681 a_6272_4069# a_6391_3858# VPWR.t649 VPWR.t43 sg13_lv_pmos ad=0.3864p pd=2.93u as=0.2128p ps=1.5u w=1.12u l=0.13u
X1682 a_3876_8748# a_3850_8653# VGND.t728 VGND.t81 sg13_lv_nmos ad=0.2516p pd=2.16u as=0.1626p ps=1.415u w=0.74u l=0.13u
X1683 a_20892_8041# a_21023_7651# a_20311_7644# VPWR.t2 sg13_lv_pmos ad=0.34p pd=2.68u as=0.2048p ps=1.63u w=1u l=0.13u
X1684 a_6537_6215# a_6180_6172# VPWR.t840 VPWR.t7 sg13_lv_pmos ad=63f pd=0.72u as=0.1563p ps=1.22u w=0.42u l=0.13u
X1685 VGND.t45 sg13cmos5l_buf_8_11.A a_27963_6538# VGND.t1000 sg13_lv_nmos ad=0.1406p pd=1.12u as=0.1406p ps=1.12u w=0.74u l=0.13u
X1686 VGND.t254 a_5135_3971# a_5802_4192# VGND.t193 sg13_lv_nmos ad=0.1406p pd=1.12u as=0.2516p ps=2.16u w=0.74u l=0.13u
X1687 VPWR.t1183 a_2016_4695# sg13cmos5l_xnor2_1_13.Y VPWR.t43 sg13_lv_pmos ad=0.3808p pd=2.92u as=0.2408p ps=1.55u w=1.12u l=0.13u
X1688 a_3876_3148# a_4395_3155# a_5135_3505# VGND.t674 sg13_lv_nmos ad=0.3473p pd=2.71u as=0.12665p ps=1.145u w=0.74u l=0.13u
X1689 VGND.t69 a_3878_7680# a_3990_7704# VGND.t68 sg13_lv_nmos ad=0.1426p pd=1.16u as=0.1428p ps=1.52u w=0.42u l=0.5u
X1690 VGND.t0 a_15525_7691# a_15627_7691# VGND.t369 sg13_lv_nmos ad=3.41162p pd=21.215u as=0.2516p ps=2.16u w=0.74u l=0.13u
X1691 VPWR.t818 a_27790_7947# sg13cmos5l_nor4_2_7.B VPWR.t2 sg13_lv_pmos ad=0.2254p pd=1.53u as=0.4256p ps=3u w=1.12u l=0.13u
X1692 sg13cmos5l_dfrbpq_1_57.CLK a_8842_6886# VGND.t630 VGND.t1072 sg13_lv_nmos ad=0.1406p pd=1.12u as=0.1406p ps=1.12u w=0.74u l=0.13u
X1693 a_6468_6593# a_6180_6172# a_6406_6593# VGND.t1272 sg13_lv_nmos ad=0.1428p pd=1.52u as=37.8f ps=0.6u w=0.42u l=0.13u
X1694 a_7893_8588# sg13cmos5l_dfrbpq_1_21.RESET_B.t13 VPWR.t779 VPWR.t0 sg13_lv_pmos ad=0.147p pd=1.54u as=0.1563p ps=1.22u w=0.42u l=0.13u
X1695 VGND.t52 a_4358_5410# a_4470_5474# VGND.t194 sg13_lv_nmos ad=0.1426p pd=1.16u as=0.1428p ps=1.52u w=0.42u l=0.5u
X1696 a_23660_5704# sg13cmos5l_dlygate4sd3_1_51.X VPWR.t8 VPWR.t7 sg13_lv_pmos ad=0.2128p pd=1.5u as=0.3864p ps=2.93u w=1.12u l=0.13u
X1697 sg13cmos5l_dfrbpq_1_47.Q a_17994_7216# VGND.t191 VGND.t1623 sg13_lv_nmos ad=0.2516p pd=2.16u as=0.1406p ps=1.12u w=0.74u l=0.13u
X1698 a_21904_6410# sg13cmos5l_buf_1_0.X.t6 VPWR.t7 VPWR.t7 sg13_lv_pmos ad=79.8f pd=0.8u as=1.42587p ps=9.11u w=0.42u l=0.13u
X1699 a_20618_8118# a_20311_7644# a_20524_8118# VGND.t140 sg13_lv_nmos ad=37.8f pd=0.6u as=0.1428p ps=1.52u w=0.42u l=0.13u
X1700 VGND.t286 sg13cmos5l_dlygate4sd3_1_55.X sg13cmos5l_nand3_1_2.A VGND.t493 sg13_lv_nmos ad=0.2516p pd=2.16u as=0.1406p ps=1.12u w=0.74u l=0.13u
X1701 VPWR.t708 a_10812_8041# a_11835_7727# VPWR.t2 sg13_lv_pmos ad=0.1563p pd=1.22u as=63f ps=0.72u w=0.42u l=0.13u
X1702 a_17433_6291# a_16491_6179# a_17231_6529# VPWR.t7 sg13_lv_pmos ad=93.45f pd=0.865u as=0.2048p ps=1.63u w=0.42u l=0.13u
X1703 a_7658_2070# a_7351_1596# a_7564_2070# VGND.t817 sg13_lv_nmos ad=37.8f pd=0.6u as=0.1428p ps=1.52u w=0.42u l=0.13u
X1704 a_7430_2382# a_8235_2504# a_7690_2605# VPWR.t10 sg13_lv_pmos ad=0.1428p pd=1.52u as=79.8f ps=0.8u w=0.42u l=0.13u
X1705 a_20388_5724# a_20362_5629# VPWR.t176 VPWR.t7 sg13_lv_pmos ad=0.34p pd=2.68u as=0.36237p ps=2.605u w=1u l=0.13u
X1706 VGND.t174 sg13cmos5l_buf_1_4.X.t2 a_24900_870# VGND.t1236 sg13_lv_nmos ad=0.1626p pd=1.415u as=60.89999f ps=0.71u w=0.42u l=0.13u
X1707 VPWR.t440 a_7232_1919# sg13cmos5l_dlygate4sd3_1_20.A VPWR.t15 sg13_lv_pmos ad=0.2128p pd=1.5u as=0.3808p ps=2.92u w=1.12u l=0.13u
X1708 VGND.t83 VPWR.t1461 VGND.t83 VGND.t1491 sg13_lv_nmos ad=0.1428p pd=1.52u as=0 ps=0 w=0.42u l=1u
X1709 VGND.t203 a_24922_4620# a_24641_4922# VGND.t142 sg13_lv_nmos ad=79.8f pd=0.8u as=0.1428p ps=1.52u w=0.42u l=0.5u
X1710 a_4102_8443# sg13cmos5l_dfrbpq_1_21.RESET_B.t16 VGND.t728 VGND.t81 sg13_lv_nmos ad=37.8f pd=0.6u as=0.1701p ps=1.65u w=0.42u l=0.13u
X1711 a_21719_7309# sg13cmos5l_dlygate4sd3_1_55.X a_22466_6918# VGND.t64 sg13_lv_nmos ad=0.1428p pd=1.52u as=60.89999f ps=0.71u w=0.42u l=0.13u
X1712 a_6972_834# a_7103_1140# a_6391_834# VPWR.t15 sg13_lv_pmos ad=0.34p pd=2.68u as=0.2048p ps=1.63u w=1u l=0.13u
X1713 VPWR.t91 a_5392_3386# a_5337_3267# VPWR.t10 sg13_lv_pmos ad=1.43285p pd=9.125u as=93.45f ps=0.865u w=0.42u l=0.13u
X1714 VPWR.t76 VGND.t54 VPWR.t76 VPWR.t43 sg13_lv_pmos ad=0.19p pd=1.38u as=0 ps=0 w=1u l=1u
X1715 a_26150_6918# a_26955_7040# a_26410_7141# VPWR.t2 sg13_lv_pmos ad=0.1428p pd=1.52u as=79.8f ps=0.8u w=0.42u l=0.13u
X1716 VPWR.t536 a_27023_5017# a_27690_4656# VPWR.t43 sg13_lv_pmos ad=0.2128p pd=1.5u as=0.3864p ps=2.93u w=1.12u l=0.13u
X1717 a_10022_8430# sg13cmos5l_xnor2_1_8.Y VPWR.t165 VPWR.t0 sg13_lv_pmos ad=79.8f pd=0.8u as=0.1428p ps=1.52u w=0.42u l=0.13u
X1718 a_21719_7727# a_21023_7651# a_21813_7727# VGND.t1042 sg13_lv_nmos ad=0.1296p pd=1.52u as=79.8f ps=0.8u w=0.42u l=0.13u
X1719 VGND.t286 sg13cmos5l_dfrbpq_1_37.D sg13cmos5l_nand3_1_2.A VGND.t975 sg13_lv_nmos ad=0.3293p pd=1.63u as=0.1406p ps=1.12u w=0.74u l=0.13u
X1720 a_6502_6931# sg13cmos5l_dfrbpq_1_58.RESET_B VGND.t25 VGND.t938 sg13_lv_nmos ad=37.8f pd=0.6u as=0.1701p ps=1.65u w=0.42u l=0.13u
X1721 a_7942_2395# sg13cmos5l_dfrbpq_1_13.RESET_B.t14 VGND.t115 VGND.t612 sg13_lv_nmos ad=37.8f pd=0.6u as=0.1701p ps=1.65u w=0.42u l=0.13u
X1722 VPWR.t1337 a_9915_3898# sg13cmos5l_buf_8_3.A VPWR.t43 sg13_lv_pmos ad=0.3864p pd=2.93u as=0.2128p ps=1.5u w=1.12u l=0.13u
X1723 sg13cmos5l_dlygate4sd3_1_58.A a_8106_6168# VPWR.t392 VPWR.t7 sg13_lv_pmos ad=0.3808p pd=2.92u as=0.2128p ps=1.5u w=1.12u l=0.13u
X1724 sg13cmos5l_and2_1_1.A a_18843_5410# VGND.t133 VGND.t1392 sg13_lv_nmos ad=0.1406p pd=1.12u as=0.1406p ps=1.12u w=0.74u l=0.13u
X1725 VGND.t143 a_21904_5626# a_21553_5483# VGND.t142 sg13_lv_nmos ad=79.8f pd=0.8u as=0.1428p ps=1.52u w=0.42u l=0.13u
X1726 a_7594_5374# sg13cmos5l_buf_8_9.A VGND.t131 VGND.t1567 sg13_lv_nmos ad=0.1406p pd=1.12u as=0.1406p ps=1.12u w=0.74u l=0.13u
X1727 VGND.t996 a_19526_8434# a_19638_8498# VGND.t0 sg13_lv_nmos ad=0.1426p pd=1.16u as=0.1428p ps=1.52u w=0.42u l=0.5u
X1728 a_1248_4695# sg13cmos5l_dfrbpq_1_23.D VPWR.t654 VPWR.t43 sg13_lv_pmos ad=0.1596p pd=1.22u as=0.4536p ps=2.76u w=0.84u l=0.13u
X1729 VPWR.t51 VGND.t632 VPWR.t50 VPWR.t43 sg13_lv_pmos ad=0.34p pd=2.68u as=0 ps=0 w=1u l=1u
X1730 a_13574_3582# sg13cmos5l_nor3_1_1.C VPWR.t1050 VPWR.t10 sg13_lv_pmos ad=79.8f pd=0.8u as=0.1428p ps=1.52u w=0.42u l=0.13u
X1731 VPWR.t227 sg13cmos5l_nand3_1_2.A sg13cmos5l_nand3_1_2.Y VPWR.t43 sg13_lv_pmos ad=0.2128p pd=1.5u as=0.3808p ps=2.92u w=1.12u l=0.13u
X1732 a_21813_7727# a_20871_7767# a_21719_7727# VPWR.t2 sg13_lv_pmos ad=79.8f pd=0.8u as=0.1428p ps=1.52u w=0.42u l=0.13u
X1733 VPWR.t309 sg13cmos5l_dfrbpq_1_53.RESET_B.t6 a_26150_6918# VPWR.t2 sg13_lv_pmos ad=0.36237p pd=2.605u as=79.8f ps=0.8u w=0.42u l=0.13u
X1734 sg13cmos5l_dfrbpq_1_18.D sg13cmos5l_xnor2_1_0.Y a_2259_4192# VPWR.t43 sg13_lv_pmos ad=0.2408p pd=1.55u as=0.1428p ps=1.375u w=1.12u l=0.13u
X1735 a_9166_4083# a_9281_4084# VPWR.t111 VPWR.t43 sg13_lv_pmos ad=0.34p pd=2.68u as=0.2254p ps=1.53u w=1u l=0.5u
X1736 a_15782_6918# sg13cmos5l_nor3_1_4.B VPWR.t597 VPWR.t2 sg13_lv_pmos ad=79.8f pd=0.8u as=0.1428p ps=1.52u w=0.42u l=0.13u
X1737 a_21062_1632# a_20792_1673# VPWR.t193 VPWR.t15 sg13_lv_pmos ad=0.34p pd=2.68u as=0.1523p ps=1.38u w=1u l=0.5u
X1738 a_24806_870# a_25611_992# a_25066_1093# VPWR.t15 sg13_lv_pmos ad=0.1428p pd=1.52u as=79.8f ps=0.8u w=0.42u l=0.13u
X1739 VGND.t121 en[4].t0 a_1384_8468# VGND.t1273 sg13_lv_nmos ad=0.14875p pd=1.16u as=0.187p ps=1.78u w=0.55u l=0.13u
X1740 a_6710_5081# a_5532_5017# a_6314_4936# VGND.t944 sg13_lv_nmos ad=37.8f pd=0.6u as=0.1428p ps=1.52u w=0.42u l=0.13u
X1741 VGND.t133 sg13cmos5l_buf_8_0.X a_18843_5410# VGND.t184 sg13_lv_nmos ad=0.1406p pd=1.12u as=0.1406p ps=1.12u w=0.74u l=0.13u
X1742 a_24708_2395# a_24939_2504# a_24394_2605# VGND.t281 sg13_lv_nmos ad=0.2373p pd=1.97u as=79.8f ps=0.8u w=0.42u l=0.13u
X1743 a_3684_8430# sg13cmos5l_dlygate4sd3_1_31.X a_3590_8430# VGND.t559 sg13_lv_nmos ad=60.89999f pd=0.71u as=0.1428p ps=1.52u w=0.42u l=0.13u
X1744 VGND.t131 a_7594_5374# sg13cmos5l_buf_8_4.A VGND.t1165 sg13_lv_nmos ad=0.1406p pd=1.12u as=0.1406p ps=1.12u w=0.74u l=0.13u
X1745 a_16138_5629# a_16581_5385# a_15878_5406# VGND.t1358 sg13_lv_nmos ad=79.8f pd=0.8u as=0.1296p ps=1.52u w=0.42u l=0.13u
X1746 a_18372_3582# sg13cmos5l_nor4_2_1.D a_18278_3582# VGND.t1126 sg13_lv_nmos ad=60.89999f pd=0.71u as=0.1428p ps=1.52u w=0.42u l=0.13u
X1747 sg13cmos5l_buf_8_2.X a_21435_3514# VPWR.t79 VPWR.t10 sg13_lv_pmos ad=0.2128p pd=1.5u as=0.2128p ps=1.5u w=1.12u l=0.13u
X1748 a_2016_7233# sg13cmos5l_xnor2_1_9.A VPWR.t911 VPWR.t2 sg13_lv_pmos ad=0.1596p pd=1.22u as=0.4536p ps=2.76u w=0.84u l=0.13u
X1749 sg13cmos5l_and2_1_1.A a_18843_5410# VPWR.t1241 VPWR.t7 sg13_lv_pmos ad=0.2128p pd=1.5u as=0.2128p ps=1.5u w=1.12u l=0.13u
X1750 a_16666_2350# sg13cmos5l_dfrbpq_1_59.Q VGND.t359 VGND.t147 sg13_lv_nmos ad=0.1428p pd=1.52u as=79.8f ps=0.8u w=0.42u l=0.13u
X1751 VPWR.t91 sg13cmos5l_dfrbpq_1_55.RESET_B a_10444_2382# VPWR.t10 sg13_lv_pmos ad=1.4003p pd=8.92u as=79.8f ps=0.8u w=0.42u l=0.13u
X1752 a_6453_4703# a_5511_4743# a_6314_4936# VGND.t1200 sg13_lv_nmos ad=79.8f pd=0.8u as=0.2373p ps=1.97u w=0.42u l=0.13u
X1753 VPWR.t43 a_21904_4898# a_21849_4779# VPWR.t43 sg13_lv_pmos ad=1.3927p pd=8.9u as=93.45f ps=0.865u w=0.42u l=0.13u
X1754 a_11567_947# a_10725_849# a_11473_947# VGND.t230 sg13_lv_nmos ad=0.12665p pd=1.145u as=0.1428p ps=1.52u w=0.42u l=0.13u
X1755 sg13cmos5l_dlygate4sd3_1_6.X a_21174_1656# VGND.t17 VGND.t16 sg13_lv_nmos ad=0.2516p pd=2.16u as=0.1426p ps=1.16u w=0.74u l=0.13u
X1756 a_15791_874# a_15756_1060# sg13cmos5l_xnor2_1_0.Y VGND.t1120 sg13_lv_nmos ad=0.1406p pd=1.12u as=0.2516p ps=2.16u w=0.74u l=0.13u
X1757 a_14254_2070# a_14495_1603# a_13783_1596# VGND.t283 sg13_lv_nmos ad=0.1428p pd=1.52u as=0.12665p ps=1.145u w=0.42u l=0.13u
X1758 a_5244_8041# a_5375_7651# a_4663_7644# VPWR.t2 sg13_lv_pmos ad=0.34p pd=2.68u as=0.2048p ps=1.63u w=1u l=0.13u
X1759 VGND.t133 sg13cmos5l_buf_1_4.X.t10 a_20196_5094# VGND.t139 sg13_lv_nmos ad=0.1626p pd=1.415u as=60.89999f ps=0.71u w=0.42u l=0.13u
X1760 a_10665_1679# a_10308_1636# VPWR.t108 VPWR.t15 sg13_lv_pmos ad=63f pd=0.72u as=0.1563p ps=1.22u w=0.42u l=0.13u
X1761 a_18598_2395# sg13cmos5l_buf_1_1.X.t10 VGND.t77 VGND.t445 sg13_lv_nmos ad=37.8f pd=0.6u as=0.1701p ps=1.65u w=0.42u l=0.13u
X1762 a_23558_6918# sg13cmos5l_nor4_2_7.B VPWR.t6 VPWR.t2 sg13_lv_pmos ad=79.8f pd=0.8u as=0.1428p ps=1.52u w=0.42u l=0.13u
X1763 VGND.t83 sg13cmos5l_dfrbpq_1_57.RESET_B.t0 a_11990_5081# VGND.t82 sg13_lv_nmos ad=0.1701p pd=1.65u as=37.8f ps=0.6u w=0.42u l=0.13u
X1764 VPWR.t113 sg13cmos5l_and2_1_0.X a_21435_3514# VPWR.t10 sg13_lv_pmos ad=0.2128p pd=1.5u as=0.3808p ps=2.92u w=1.12u l=0.13u
X1765 VGND.t50 a_6272_4069# sg13cmos5l_dfrbpq_1_23.Q VGND.t193 sg13_lv_nmos ad=0.1406p pd=1.12u as=0.2516p ps=2.16u w=0.74u l=0.13u
X1766 VGND.t0 sg13cmos5l_dfrbpq_1_46.CLK a_21023_7651# VGND.t27 sg13_lv_nmos ad=3.2221p pd=20.04u as=0.2516p ps=2.16u w=0.74u l=0.13u
X1767 VPWR.t1239 a_18843_5410# sg13cmos5l_and2_1_1.A VPWR.t7 sg13_lv_pmos ad=0.2128p pd=1.5u as=0.2128p ps=1.5u w=1.12u l=0.13u
X1768 a_10538_5094# a_10231_4620# a_10444_5094# VGND.t85 sg13_lv_nmos ad=37.8f pd=0.6u as=0.1428p ps=1.52u w=0.42u l=0.13u
X1769 a_18104_878# sg13cmos5l_nand3_1_0.B a_18002_878# VGND.t170 sg13_lv_nmos ad=0.1406p pd=1.12u as=0.1406p ps=1.12u w=0.74u l=0.13u
X1770 VPWR.t1323 sg13cmos5l_buf_8_9.A a_7594_5374# VPWR.t7 sg13_lv_pmos ad=0.2128p pd=1.5u as=0.2128p ps=1.5u w=1.12u l=0.13u
X1771 a_11567_5483# a_10725_5385# a_11473_5483# VGND.t726 sg13_lv_nmos ad=0.12665p pd=1.145u as=0.1428p ps=1.52u w=0.42u l=0.13u
X1772 VPWR.t1048 a_10112_4943# sg13cmos5l_dfrbpq_1_57.Q VPWR.t43 sg13_lv_pmos ad=0.2128p pd=1.5u as=0.3808p ps=2.92u w=1.12u l=0.13u
X1773 sg13cmos5l_dlygate4sd3_1_9.A a_27690_5704# VPWR.t276 VPWR.t7 sg13_lv_pmos ad=0.3808p pd=2.92u as=0.2128p ps=1.5u w=1.12u l=0.13u
X1774 VGND.t176 a_26351_947# a_27018_1168# VGND.t308 sg13_lv_nmos ad=0.1406p pd=1.12u as=0.2516p ps=2.16u w=0.74u l=0.13u
X1775 a_7306_7648# a_7749_7691# a_7046_8118# VGND.t352 sg13_lv_nmos ad=79.8f pd=0.8u as=0.1296p ps=1.52u w=0.42u l=0.13u
X1776 sg13cmos5l_nor4_2_9.Y sg13cmos5l_nor4_2_9.D a_4202_4656# VPWR.t43 sg13_lv_pmos ad=0.2128p pd=1.5u as=0.3808p ps=2.92u w=1.12u l=0.13u
X1777 VPWR.t405 a_1870_7947# sg13cmos5l_nor3_1_2.B VPWR.t2 sg13_lv_pmos ad=0.2254p pd=1.53u as=0.4256p ps=3u w=1.12u l=0.13u
X1778 VGND.t90 a_10112_7967# sg13cmos5l_dlygate4sd3_1_52.A VGND.t356 sg13_lv_nmos ad=0.1406p pd=1.12u as=0.2516p ps=2.16u w=0.74u l=0.13u
X1779 a_14926_1059# a_15041_1060# VPWR.t352 VPWR.t15 sg13_lv_pmos ad=0.34p pd=2.68u as=0.2254p ps=1.53u w=1u l=0.5u
X1780 VPWR.t313 sg13cmos5l_dlygate4sd3_1_0.X a_28532_2680# VPWR.t10 sg13_lv_pmos ad=0.2128p pd=1.5u as=0.2128p ps=1.5u w=1.12u l=0.13u
X1781 VPWR.t1248 a_19642_6132# a_19361_6434# VPWR.t7 sg13_lv_pmos ad=0.1523p pd=1.38u as=0.34p ps=2.68u w=1u l=0.5u
X1782 a_4663_7644# a_5223_7767# a_5244_8041# VGND.t1012 sg13_lv_nmos ad=0.12665p pd=1.145u as=0.3473p ps=2.71u w=0.74u l=0.13u
X1783 VPWR.t2 a_24261_6897# a_24363_7040# VPWR.t2 sg13_lv_pmos ad=1.34765p pd=8.56u as=0.3864p ps=2.93u w=1.12u l=0.13u
X1784 VGND.t238 sg13cmos5l_dfrbpq_1_57.D sg13cmos5l_nand3_1_1.A VGND.t435 sg13_lv_nmos ad=0.2516p pd=2.16u as=0.1406p ps=1.12u w=0.74u l=0.13u
X1785 a_23846_1632# a_23576_1673# VGND.t137 VGND.t490 sg13_lv_nmos ad=0.1428p pd=1.52u as=79.8f ps=0.8u w=0.42u l=0.5u
X1786 sg13cmos5l_and2_1_1.A a_18843_5410# VPWR.t211 VPWR.t7 sg13_lv_pmos ad=0.2128p pd=1.5u as=0.2128p ps=1.5u w=1.12u l=0.13u
X1787 VPWR.t7 sg13cmos5l_dfrbpq_1_53.RESET_B.t4 a_25738_5629# VPWR.t7 sg13_lv_pmos ad=0.1563p pd=1.22u as=0.147p ps=1.54u w=0.42u l=0.13u
X1788 a_20889_1185# a_19947_992# a_20687_947# VPWR.t15 sg13_lv_pmos ad=93.45f pd=0.865u as=0.2048p ps=1.63u w=0.42u l=0.13u
X1789 VPWR.t2 sg13cmos5l_dfrbpq_1_57.CLK a_10943_7651# VPWR.t2 sg13_lv_pmos ad=1.31957p pd=8.38u as=0.4088p ps=2.97u w=1.12u l=0.13u
X1790 sg13cmos5l_buf_8_4.A a_7594_5374# VPWR.t1037 VPWR.t7 sg13_lv_pmos ad=0.2128p pd=1.5u as=0.2128p ps=1.5u w=1.12u l=0.13u
X1791 VGND.t316 sg13cmos5l_dfrbpq_1_12.Q a_14360_3898# VGND.t668 sg13_lv_nmos ad=79.8f pd=0.8u as=0.1428p ps=1.52u w=0.42u l=0.13u
X1792 VPWR.t633 sg13cmos5l_dlygate4sd3_1_52.X a_13676_6168# VPWR.t7 sg13_lv_pmos ad=0.3808p pd=2.92u as=0.2128p ps=1.5u w=1.12u l=0.13u
X1793 a_4202_4656# sg13cmos5l_dlygate4sd3_1_19.X a_3904_4656# VPWR.t43 sg13_lv_pmos ad=0.2128p pd=1.5u as=0.2128p ps=1.5u w=1.12u l=0.13u
X1794 a_17109_4703# a_16167_4743# a_16970_4936# VGND.t380 sg13_lv_nmos ad=79.8f pd=0.8u as=0.2373p ps=1.97u w=0.42u l=0.13u
X1795 VGND.t77 a_24837_2361# a_24939_2504# VGND.t76 sg13_lv_nmos ad=3.25012p pd=20.49u as=0.2516p ps=2.16u w=0.74u l=0.13u
X1796 a_3684_3582# sg13cmos5l_dlygate4sd3_1_23.X a_3590_3582# VGND.t70 sg13_lv_nmos ad=60.89999f pd=0.71u as=0.1428p ps=1.52u w=0.42u l=0.13u
X1797 VPWR.t577 a_21647_3971# a_22314_4192# VPWR.t43 sg13_lv_pmos ad=0.2128p pd=1.5u as=0.3864p ps=2.93u w=1.12u l=0.13u
X1798 a_18604_2070# a_18391_1596# VPWR.t105 VPWR.t15 sg13_lv_pmos ad=79.8f pd=0.8u as=1.50275p ps=9.57u w=0.42u l=0.13u
X1799 a_10702_3582# a_10943_3115# a_10231_3108# VGND.t1145 sg13_lv_nmos ad=0.1428p pd=1.52u as=0.12665p ps=1.145u w=0.42u l=0.13u
X1800 VPWR.t665 sg13cmos5l_dfrbpq_1_21.RESET_B.t16 a_3590_8430# VPWR.t0 sg13_lv_pmos ad=0.36237p pd=2.605u as=79.8f ps=0.8u w=0.42u l=0.13u
X1801 VPWR.t1 a_26181_8409# a_26283_8552# VPWR.t0 sg13_lv_pmos ad=1.8922p pd=12.27u as=0.3864p ps=2.93u w=1.12u l=0.13u
X1802 VGND.t273 a_27023_8507# a_27690_8728# VGND.t72 sg13_lv_nmos ad=0.1406p pd=1.12u as=0.2516p ps=2.16u w=0.74u l=0.13u
X1803 VGND.t115 a_6250_2350# sg13cmos5l_dfrbpq_1_13.CLK VGND.t1381 sg13_lv_nmos ad=0.1406p pd=1.12u as=0.1406p ps=1.12u w=0.74u l=0.13u
X1804 VPWR.t69 VGND.t861 VPWR.t68 VPWR.t10 sg13_lv_pmos ad=0.34p pd=2.68u as=0 ps=0 w=1u l=1u
X1805 a_13642_5374# sg13cmos5l_buf_8_0.X VGND.t179 VGND.t178 sg13_lv_nmos ad=0.1406p pd=1.12u as=0.1406p ps=1.12u w=0.74u l=0.13u
X1806 a_19428_1188# a_19947_992# a_20687_947# VGND.t1150 sg13_lv_nmos ad=0.3473p pd=2.71u as=0.12665p ps=1.145u w=0.74u l=0.13u
X1807 a_21647_3971# a_20805_3873# a_20388_4212# VPWR.t43 sg13_lv_pmos ad=0.2048p pd=1.63u as=0.34p ps=2.68u w=1u l=0.13u
X1808 a_11488_4192# sg13cmos5l_dlygate4sd3_1_18.X a_11276_4192# VPWR.t43 sg13_lv_pmos ad=0.2128p pd=1.5u as=0.2128p ps=1.5u w=1.12u l=0.13u
X1809 a_17135_2386# a_17100_2572# sg13cmos5l_xnor2_1_5.Y VGND.t147 sg13_lv_nmos ad=0.1406p pd=1.12u as=0.2516p ps=2.16u w=0.74u l=0.13u
X1810 VPWR.t834 a_27418_6132# a_27137_6434# VPWR.t7 sg13_lv_pmos ad=0.1523p pd=1.38u as=0.34p ps=2.68u w=1u l=0.5u
X1811 a_11990_6593# a_10812_6529# a_11594_6448# VGND.t772 sg13_lv_nmos ad=37.8f pd=0.6u as=0.1428p ps=1.52u w=0.42u l=0.13u
X1812 a_5614_5721# a_5356_5406# VPWR.t7 VPWR.t7 sg13_lv_pmos ad=93.45f pd=0.865u as=1.46065p ps=9.335u w=0.42u l=0.13u
X1813 sg13cmos5l_dfrbpq_1_11.CLK a_13563_874# VGND.t365 VGND.t511 sg13_lv_nmos ad=0.1406p pd=1.12u as=0.1406p ps=1.12u w=0.74u l=0.13u
X1814 VGND.t17 VPWR.t182 VGND.t137 VGND.t1534 sg13_lv_nmos ad=79.8f pd=0.8u as=0 ps=0 w=0.42u l=1u
X1815 VGND.t137 sg13cmos5l_buf_1_0.X.t1 a_23755_2428# VGND.t136 sg13_lv_nmos ad=0.1331p pd=1.12u as=0.1216p ps=1.02u w=0.64u l=0.13u
X1816 VGND.t20 VPWR.t4 VGND.t20 VGND.t1464 sg13_lv_nmos ad=0.1428p pd=1.52u as=0 ps=0 w=0.42u l=1u
X1817 VPWR.t221 a_23712_6207# sg13cmos5l_xnor2_1_4.B VPWR.t7 sg13_lv_pmos ad=0.3808p pd=2.92u as=0.2408p ps=1.55u w=1.12u l=0.13u
X1818 a_20388_4212# a_20362_4117# VGND.t106 VGND.t105 sg13_lv_nmos ad=0.2516p pd=2.16u as=0.1626p ps=1.415u w=0.74u l=0.13u
X1819 VPWR.t1289 osc a_15850_3862# VPWR.t43 sg13_lv_pmos ad=0.2128p pd=1.5u as=0.2128p ps=1.5u w=1.12u l=0.13u
X1820 VGND.t803 a_7893_8588# a_6972_8394# VGND.t802 sg13_lv_nmos ad=0.1626p pd=1.415u as=0.2516p ps=2.16u w=0.74u l=0.13u
X1821 a_14086_3569# sg13cmos5l_dfrbpq_1_55.RESET_B VGND.t316 VGND.t579 sg13_lv_nmos ad=37.8f pd=0.6u as=0.1701p ps=1.65u w=0.42u l=0.13u
X1822 VGND.t54 sg13cmos5l_dfrbpq_1_5.Q a_23576_3898# VGND.t202 sg13_lv_nmos ad=79.8f pd=0.8u as=0.1428p ps=1.52u w=0.42u l=0.13u
X1823 a_5135_3971# a_4293_3873# a_5041_3971# VGND.t193 sg13_lv_nmos ad=0.12665p pd=1.145u as=0.1428p ps=1.52u w=0.42u l=0.13u
X1824 a_17282_8430# sg13cmos5l_dfrbpq_1_56.RESET_B VGND.t3 VGND.t0 sg13_lv_nmos ad=60.89999f pd=0.71u as=0.1626p ps=1.415u w=0.42u l=0.13u
X1825 a_27023_8507# a_26181_8409# a_25764_8748# VPWR.t0 sg13_lv_pmos ad=0.2048p pd=1.63u as=0.34p ps=2.68u w=1u l=0.13u
X1826 a_11835_4703# a_10943_4627# a_11733_4703# VPWR.t43 sg13_lv_pmos ad=63f pd=0.72u as=79.8f ps=0.8u w=0.42u l=0.13u
X1827 VGND.t365 sg13cmos5l_buf_8_3.A a_13563_874# VGND.t765 sg13_lv_nmos ad=0.1406p pd=1.12u as=0.2553p ps=2.17u w=0.74u l=0.13u
X1828 VPWR.t570 sg13cmos5l_xnor2_1_5.A a_17274_2680# VPWR.t10 sg13_lv_pmos ad=0.2891p pd=1.695u as=0.1428p ps=1.375u w=1.12u l=0.13u
X1829 a_1265_5460# sg13cmos5l_nor4_2_9.D a_1233_5728# VPWR.t7 sg13_lv_pmos ad=0.34p pd=2.68u as=0.1225p ps=1.245u w=1u l=0.13u
X1830 a_10596_883# a_10308_1188# a_10534_883# VGND.t41 sg13_lv_nmos ad=0.1428p pd=1.52u as=37.8f ps=0.6u w=0.42u l=0.13u
X1831 VPWR.t1382 VGND.t96 VPWR.t1384 VPWR.t7 sg13_lv_pmos ad=0.19p pd=1.38u as=0 ps=0 w=1u l=1u
X1832 a_8768_6427# sg13cmos5l_and2_1_3.A VPWR.t939 VPWR.t7 sg13_lv_pmos ad=0.1596p pd=1.22u as=0.1918p ps=1.5u w=0.84u l=0.13u
X1833 sg13cmos5l_nand3_1_0.Y sg13cmos5l_nand3_1_0.A a_18104_878# VGND.t589 sg13_lv_nmos ad=0.2516p pd=2.16u as=0.1406p ps=1.12u w=0.74u l=0.13u
X1834 VGND.t572 sg13cmos5l_dlygate4sd3_1_18.X sg13cmos5l_nand3_1_3.B VGND.t1203 sg13_lv_nmos ad=0.1406p pd=1.12u as=0.1406p ps=1.12u w=0.74u l=0.13u
X1835 a_25764_5724# a_26283_5528# a_27023_5483# VGND.t200 sg13_lv_nmos ad=0.3473p pd=2.71u as=0.12665p ps=1.145u w=0.74u l=0.13u
X1836 a_19716_883# a_19428_1188# a_19654_883# VGND.t899 sg13_lv_nmos ad=0.1428p pd=1.52u as=37.8f ps=0.6u w=0.42u l=0.13u
X1837 a_18618_1168# sg13cmos5l_xnor2_1_3.B sg13cmos5l_xnor2_1_1.B VPWR.t15 sg13_lv_pmos ad=0.1428p pd=1.375u as=0.2408p ps=1.55u w=1.12u l=0.13u
X1838 a_8793_7803# a_7851_7691# a_8591_8041# VPWR.t2 sg13_lv_pmos ad=93.45f pd=0.865u as=0.2048p ps=1.63u w=0.42u l=0.13u
X1839 a_24134_2382# sg13cmos5l_nor4_2_0.B VPWR.t79 VPWR.t10 sg13_lv_pmos ad=79.8f pd=0.8u as=0.1428p ps=1.52u w=0.42u l=0.13u
X1840 a_5337_8745# a_4395_8552# a_5135_8507# VPWR.t0 sg13_lv_pmos ad=93.45f pd=0.865u as=0.2048p ps=1.63u w=0.42u l=0.13u
X1841 VGND.t0 sg13cmos5l_dfrbpq_1_32.CLK a_5375_7651# VGND.t1209 sg13_lv_nmos ad=3.2221p pd=20.04u as=0.2516p ps=2.16u w=0.74u l=0.13u
X1842 a_25764_4660# a_25738_4624# VGND.t203 VGND.t585 sg13_lv_nmos ad=0.2516p pd=2.16u as=0.1626p ps=1.415u w=0.74u l=0.13u
X1843 VPWR.t43 a_27023_5017# a_27280_4898# VPWR.t43 sg13_lv_pmos ad=1.3927p pd=8.9u as=79.8f ps=0.8u w=0.42u l=0.13u
X1844 VPWR.t111 a_9166_4083# sg13cmos5l_xor2_1_1.B VPWR.t43 sg13_lv_pmos ad=0.2254p pd=1.53u as=0.4256p ps=3u w=1.12u l=0.13u
X1845 a_16283_1980# sg13cmos5l_xnor2_1_2.A VGND.t462 VGND.t155 sg13_lv_nmos ad=78.39999f pd=0.885u as=0.2272p ps=1.99u w=0.64u l=0.13u
X1846 sg13cmos5l_dfrbpq_1_0.CLK a_27195_3514# VGND.t58 VGND.t264 sg13_lv_nmos ad=0.1406p pd=1.12u as=0.1406p ps=1.12u w=0.74u l=0.13u
X1847 a_7799_1261# sg13cmos5l_xnor2_1_6.B a_8546_870# VGND.t1553 sg13_lv_nmos ad=0.1428p pd=1.52u as=60.89999f ps=0.71u w=0.42u l=0.13u
X1848 VPWR.t28 VGND.t119 VPWR.t28 VPWR.t15 sg13_lv_pmos ad=0.34p pd=2.68u as=0 ps=0 w=1u l=1u
X1849 sg13cmos5l_nand3_1_1.A sg13cmos5l_xor2_1_2.A VGND.t238 VGND.t927 sg13_lv_nmos ad=0.1406p pd=1.12u as=0.1406p ps=1.12u w=0.74u l=0.13u
X1850 VPWR.t43 a_20805_4667# a_20907_4667# VPWR.t43 sg13_lv_pmos ad=1.3927p pd=8.9u as=0.3864p ps=2.93u w=1.12u l=0.13u
X1851 VGND.t280 VPWR.t1468 VGND.t280 VGND.t1480 sg13_lv_nmos ad=0.1428p pd=1.52u as=0 ps=0 w=0.42u l=1u
X1852 sg13cmos5l_xnor2_1_3.B a_18144_4695# a_18293_5026# VGND.t374 sg13_lv_nmos ad=0.2516p pd=2.16u as=0.1406p ps=1.12u w=0.74u l=0.13u
X1853 VPWR.t105 a_11824_1874# a_11769_1755# VPWR.t15 sg13_lv_pmos ad=1.50275p pd=9.57u as=93.45f ps=0.865u w=0.42u l=0.13u
X1854 VPWR.t882 sg13cmos5l_and2_1_1.A a_19609_6942# VPWR.t2 sg13_lv_pmos ad=0.2086p pd=1.5u as=0.34p ps=2.68u w=1u l=0.13u
X1855 a_3799_834# a_4359_1088# a_4380_834# VGND.t360 sg13_lv_nmos ad=0.12665p pd=1.145u as=0.3473p ps=2.71u w=0.74u l=0.13u
X1856 VGND.t608 a_8853_1679# a_7932_1993# VGND.t875 sg13_lv_nmos ad=0.1626p pd=1.415u as=0.2516p ps=2.16u w=0.74u l=0.13u
X1857 VGND.t145 sg13cmos5l_buf_1_0.X.t11 a_20618_6918# VGND.t144 sg13_lv_nmos ad=79.8f pd=0.8u as=37.8f ps=0.6u w=0.42u l=0.13u
X1858 a_20745_4703# a_20388_4660# VPWR.t612 VPWR.t43 sg13_lv_pmos ad=63f pd=0.72u as=0.1563p ps=1.22u w=0.42u l=0.13u
X1859 VPWR.t469 sg13cmos5l_buf_8_3.A a_13563_874# VPWR.t15 sg13_lv_pmos ad=0.2128p pd=1.5u as=0.3808p ps=2.92u w=1.12u l=0.13u
X1860 a_20944_1090# sg13cmos5l_buf_1_1.X.t1 VPWR.t105 VPWR.t15 sg13_lv_pmos ad=79.8f pd=0.8u as=1.46697p ps=9.345u w=0.42u l=0.13u
X1861 sg13cmos5l_dfrbpq_1_55.D a_16566_3168# VPWR.t563 VPWR.t10 sg13_lv_pmos ad=0.4256p pd=3u as=0.2254p ps=1.53u w=1.12u l=0.13u
X1862 VGND.t478 sg13cmos5l_dfrbpq_1_13.RESET_B.t8 a_10116_2070# VGND.t1214 sg13_lv_nmos ad=0.1626p pd=1.415u as=60.89999f ps=0.71u w=0.42u l=0.13u
X1863 a_9446_874# a_9176_874# VPWR.t200 VPWR.t15 sg13_lv_pmos ad=0.34p pd=2.68u as=0.1523p ps=1.38u w=1u l=0.5u
X1864 sg13cmos5l_and2_1_3.A a_13642_5374# VGND.t179 VGND.t530 sg13_lv_nmos ad=0.1406p pd=1.12u as=0.1406p ps=1.12u w=0.74u l=0.13u
X1865 a_11276_4192# sg13cmos5l_dlygate4sd3_1_22.X VPWR.t1062 VPWR.t43 sg13_lv_pmos ad=0.2128p pd=1.5u as=0.3864p ps=2.93u w=1.12u l=0.13u
X1866 a_10282_8653# a_10725_8409# a_10665_8821# VPWR.t0 sg13_lv_pmos ad=79.8f pd=0.8u as=63f ps=0.72u w=0.42u l=0.13u
X1867 a_1530_5422# sg13cmos5l_dlygate4sd3_1_19.X VGND.t30 VGND.t339 sg13_lv_nmos ad=88.8f pd=0.98u as=0.15245p ps=1.17u w=0.74u l=0.13u
X1868 a_4106_870# a_3799_834# a_4012_870# VGND.t504 sg13_lv_nmos ad=37.8f pd=0.6u as=0.1428p ps=1.52u w=0.42u l=0.13u
X1869 VPWR.t658 sg13cmos5l_dfrbpq_1_22.D a_11639_2773# VPWR.t10 sg13_lv_pmos ad=0.1428p pd=1.52u as=79.8f ps=0.8u w=0.42u l=0.13u
X1870 VPWR.t419 sg13cmos5l_buf_1_1.X.t11 a_20973_3492# VPWR.t10 sg13_lv_pmos ad=0.1918p pd=1.5u as=0.1596p ps=1.22u w=0.84u l=0.13u
X1871 a_24608_1919# a_24727_1596# VPWR.t542 VPWR.t15 sg13_lv_pmos ad=0.3864p pd=2.93u as=0.2128p ps=1.5u w=1.12u l=0.13u
X1872 VGND.t179 a_14542_4923# sg13cmos5l_dfrbpq_1_17.D VGND.t1354 sg13_lv_nmos ad=0.1426p pd=1.16u as=0.2516p ps=2.16u w=0.74u l=0.13u
X1873 VGND.t154 sg13cmos5l_xnor2_1_5.A a_17556_2428# VGND.t147 sg13_lv_nmos ad=0.2272p pd=1.99u as=78.39999f ps=0.885u w=0.64u l=0.13u
X1874 a_13834_2605# a_14277_2361# a_13574_2382# VGND.t6 sg13_lv_nmos ad=79.8f pd=0.8u as=0.1296p ps=1.52u w=0.42u l=0.13u
X1875 a_18852_3569# a_19083_3155# a_18538_3112# VGND.t1226 sg13_lv_nmos ad=0.2373p pd=1.97u as=79.8f ps=0.8u w=0.42u l=0.13u
X1876 VPWR.t153 sg13cmos5l_buf_1_1.X.t4 a_24940_2070# VPWR.t15 sg13_lv_pmos ad=1.46697p pd=9.345u as=79.8f ps=0.8u w=0.42u l=0.13u
X1877 VPWR.t998 a_15850_3862# sg13cmos5l_buf_8_0.X VPWR.t43 sg13_lv_pmos ad=0.2128p pd=1.5u as=0.2128p ps=1.5u w=1.12u l=0.13u
X1878 sg13cmos5l_xnor2_1_13.Y sg13cmos5l_xnor2_1_12.Y a_2259_4656# VPWR.t43 sg13_lv_pmos ad=0.2408p pd=1.55u as=0.1428p ps=1.375u w=1.12u l=0.13u
X1879 VPWR.t521 a_11733_3191# a_10812_3505# VPWR.t10 sg13_lv_pmos ad=0.36237p pd=2.605u as=0.34p ps=2.68u w=1u l=0.13u
X1880 VGND.t572 VPWR.t1454 VGND.t1510 VGND.t1516 sg13_lv_nmos ad=79.8f pd=0.8u as=0 ps=0 w=0.42u l=1u
X1881 VPWR.t853 a_7535_6995# a_8202_7216# VPWR.t2 sg13_lv_pmos ad=0.2128p pd=1.5u as=0.3864p ps=2.93u w=1.12u l=0.13u
X1882 VGND.t137 sg13cmos5l_buf_1_1.X.t8 a_24228_2382# VGND.t1275 sg13_lv_nmos ad=0.1626p pd=1.415u as=60.89999f ps=0.71u w=0.42u l=0.13u
X1883 a_7749_7691# sg13cmos5l_dfrbpq_1_32.CLK VPWR.t2 VPWR.t2 sg13_lv_pmos ad=0.4088p pd=2.97u as=1.31957p ps=8.38u w=1.12u l=0.13u
X1884 sg13cmos5l_buf_1_1.X a_17032_908# VGND.t172 VGND.t850 sg13_lv_nmos ad=0.2886p pd=2.26u as=0.14875p ps=1.16u w=0.74u l=0.13u
X1885 a_6084_6918# sg13cmos5l_nor4_2_5.B a_5990_6918# VGND.t950 sg13_lv_nmos ad=60.89999f pd=0.71u as=0.1428p ps=1.52u w=0.42u l=0.13u
X1886 VPWR.t1215 sg13cmos5l_dfrbpq_1_22.Q a_9176_3185# VPWR.t10 sg13_lv_pmos ad=0.1523p pd=1.38u as=0.1428p ps=1.52u w=0.42u l=0.13u
X1887 sg13cmos5l_buf_8_0.X a_15850_3862# VPWR.t994 VPWR.t43 sg13_lv_pmos ad=0.2128p pd=1.5u as=0.2128p ps=1.5u w=1.12u l=0.13u
X1888 VGND.t3 sg13cmos5l_dfrbpq_1_56.RESET_B a_16886_8443# VGND.t0 sg13_lv_nmos ad=0.1701p pd=1.65u as=37.8f ps=0.6u w=0.42u l=0.13u
X1889 a_9232_2602# sg13cmos5l_dfrbpq_1_13.RESET_B.t13 VPWR.t91 VPWR.t10 sg13_lv_pmos ad=79.8f pd=0.8u as=1.43285p ps=9.125u w=0.42u l=0.13u
X1890 sg13cmos5l_nand3_1_3.B sg13cmos5l_dlygate4sd3_1_22.X VGND.t50 VGND.t1197 sg13_lv_nmos ad=0.1406p pd=1.12u as=0.2553p ps=2.17u w=0.74u l=0.13u
X1891 a_28829_7216# sg13cmos5l_dlygate4sd3_1_4.X sg13cmos5l_nand3_1_2.C VPWR.t2 sg13_lv_pmos ad=0.2128p pd=1.5u as=0.3808p ps=2.92u w=1.12u l=0.13u
X1892 VGND.t77 sg13cmos5l_buf_1_1.X.t6 a_18698_2070# VGND.t108 sg13_lv_nmos ad=79.8f pd=0.8u as=37.8f ps=0.6u w=0.42u l=0.13u
X1893 VPWR.t664 a_26447_3971# a_27114_4192# VPWR.t43 sg13_lv_pmos ad=0.2128p pd=1.5u as=0.3864p ps=2.93u w=1.12u l=0.13u
X1894 a_5626_6886# sg13cmos5l_dlygate4sd3_1_38.A VPWR.t850 VPWR.t2 sg13_lv_pmos ad=0.1428p pd=1.52u as=0.1523p ps=1.38u w=0.42u l=0.13u
X1895 a_20388_4660# a_20907_4667# a_21647_5017# VGND.t142 sg13_lv_nmos ad=0.3473p pd=2.71u as=0.12665p ps=1.145u w=0.74u l=0.13u
X1896 a_24922_4620# sg13cmos5l_dlygate4sd3_1_55.A VPWR.t227 VPWR.t43 sg13_lv_pmos ad=0.1428p pd=1.52u as=0.1523p ps=1.38u w=0.42u l=0.13u
X1897 a_9446_6168# a_9176_6209# VGND.t630 VGND.t1585 sg13_lv_nmos ad=0.1428p pd=1.52u as=79.8f ps=0.8u w=0.42u l=0.5u
X1898 sg13cmos5l_dfrbpq_1_0.CLK a_27195_3514# VGND.t58 VGND.t260 sg13_lv_nmos ad=0.1406p pd=1.12u as=0.1406p ps=1.12u w=0.74u l=0.13u
X1899 a_20676_8443# a_20907_8552# a_20362_8653# VGND.t0 sg13_lv_nmos ad=0.2373p pd=1.97u as=79.8f ps=0.8u w=0.42u l=0.13u
X1900 VGND.t96 VPWR.t1470 VGND.t96 VGND.t95 sg13_lv_nmos ad=0.1428p pd=1.52u as=0 ps=0 w=0.42u l=1u
X1901 VPWR.t491 a_13642_5374# sg13cmos5l_and2_1_3.A VPWR.t7 sg13_lv_pmos ad=0.2128p pd=1.5u as=0.2128p ps=1.5u w=1.12u l=0.13u
X1902 a_26447_3971# a_25605_3873# a_25188_4212# VPWR.t43 sg13_lv_pmos ad=0.2048p pd=1.63u as=0.34p ps=2.68u w=1u l=0.13u
X1903 a_10725_8409# sg13cmos5l_dfrbpq_1_57.CLK VPWR.t1 VPWR.t0 sg13_lv_pmos ad=0.4088p pd=2.97u as=1.8922p ps=12.27u w=1.12u l=0.13u
X1904 a_6272_1045# a_6391_834# VPWR.t198 VPWR.t15 sg13_lv_pmos ad=0.3864p pd=2.93u as=0.2128p ps=1.5u w=1.12u l=0.13u
X1905 VGND.t1033 sg13cmos5l_dlygate4sd3_1_30.A a_3896_6209# VGND.t1032 sg13_lv_nmos ad=79.8f pd=0.8u as=0.1428p ps=1.52u w=0.42u l=0.13u
X1906 VGND.t119 VPWR.t28 VGND.t119 VGND.t1539 sg13_lv_nmos ad=79.8f pd=0.8u as=0 ps=0 w=0.42u l=1u
X1907 VGND.t851 a_23846_3898# a_23958_3962# VGND.t202 sg13_lv_nmos ad=0.1426p pd=1.16u as=0.1428p ps=1.52u w=0.42u l=0.5u
X1908 VPWR.t30 VGND.t40 VPWR.t31 VPWR.t0 sg13_lv_pmos ad=0.19p pd=1.38u as=0 ps=0 w=1u l=1u
X1909 VPWR.t958 a_8842_6886# sg13cmos5l_dfrbpq_1_57.CLK VPWR.t2 sg13_lv_pmos ad=0.2128p pd=1.5u as=0.2128p ps=1.5u w=1.12u l=0.13u
X1910 a_6272_8605# a_6391_8394# VGND.t312 VGND.t702 sg13_lv_nmos ad=0.2516p pd=2.16u as=0.1406p ps=1.12u w=0.74u l=0.13u
X1911 VGND.t83 a_11733_4703# a_10812_5017# VGND.t1379 sg13_lv_nmos ad=0.1626p pd=1.415u as=0.2516p ps=2.16u w=0.74u l=0.13u
X1912 VPWR.t1341 sg13cmos5l_dfrbpq_1_56.D a_17015_4703# VPWR.t43 sg13_lv_pmos ad=0.1428p pd=1.52u as=79.8f ps=0.8u w=0.42u l=0.13u
X1913 VGND.t50 a_9915_3898# sg13cmos5l_buf_8_3.A VGND.t1580 sg13_lv_nmos ad=0.1406p pd=1.12u as=0.1406p ps=1.12u w=0.74u l=0.13u
X1914 VPWR.t311 sg13cmos5l_dfrbpq_1_53.RESET_B.t2 a_25478_5094# VPWR.t43 sg13_lv_pmos ad=0.36237p pd=2.605u as=79.8f ps=0.8u w=0.42u l=0.13u
X1915 a_26486_2057# a_25308_1993# a_26090_1912# VGND.t886 sg13_lv_nmos ad=37.8f pd=0.6u as=0.1428p ps=1.52u w=0.42u l=0.13u
X1916 sg13cmos5l_dfrbpq_1_3.D a_23958_1656# VGND.t137 VGND.t841 sg13_lv_nmos ad=0.2516p pd=2.16u as=0.1426p ps=1.16u w=0.74u l=0.13u
X1917 VPWR.t362 a_27994_3862# a_27713_4084# VPWR.t43 sg13_lv_pmos ad=0.1523p pd=1.38u as=0.34p ps=2.68u w=1u l=0.5u
X1918 a_26608_1090# sg13cmos5l_buf_1_4.X.t1 VPWR.t153 VPWR.t15 sg13_lv_pmos ad=79.8f pd=0.8u as=1.50275p ps=9.57u w=0.42u l=0.13u
X1919 a_4164_3569# a_4395_3155# a_3850_3112# VGND.t347 sg13_lv_nmos ad=0.2373p pd=1.97u as=79.8f ps=0.8u w=0.42u l=0.13u
X1920 a_25188_4212# a_25162_4117# VGND.t293 VGND.t722 sg13_lv_nmos ad=0.2516p pd=2.16u as=0.1626p ps=1.415u w=0.74u l=0.13u
X1921 VPWR.t2 sg13cmos5l_dfrbpq_1_21.RESET_B.t12 a_4876_8118# VPWR.t2 sg13_lv_pmos ad=1.31957p pd=8.38u as=79.8f ps=0.8u w=0.42u l=0.13u
X1922 VGND.t861 sg13cmos5l_dfrbpq_1_21.RESET_B.t8 a_3684_3894# VGND.t862 sg13_lv_nmos ad=0.1626p pd=1.415u as=60.89999f ps=0.71u w=0.42u l=0.13u
X1923 VGND.t268 sg13cmos5l_dlygate4sd3_1_11.A a_28376_3898# VGND.t1258 sg13_lv_nmos ad=79.8f pd=0.8u as=0.1428p ps=1.52u w=0.42u l=0.13u
X1924 VGND.t131 a_7930_4620# a_7649_4922# VGND.t852 sg13_lv_nmos ad=79.8f pd=0.8u as=0.1428p ps=1.52u w=0.42u l=0.5u
X1925 VPWR.t105 a_11567_947# a_11824_1090# VPWR.t15 sg13_lv_pmos ad=1.50275p pd=9.57u as=79.8f ps=0.8u w=0.42u l=0.13u
X1926 VGND.t58 sg13cmos5l_buf_8_2.X a_27195_3514# VGND.t777 sg13_lv_nmos ad=0.1406p pd=1.12u as=0.2553p ps=2.17u w=0.74u l=0.13u
X1927 sg13cmos5l_nor3_1_1.C a_9558_3168# VGND.t50 VGND.t1219 sg13_lv_nmos ad=0.2516p pd=2.16u as=0.1426p ps=1.16u w=0.74u l=0.13u
X1928 a_26436_7236# a_26410_7141# VPWR.t309 VPWR.t2 sg13_lv_pmos ad=0.34p pd=2.68u as=0.36237p ps=2.605u w=1u l=0.13u
X1929 a_26436_7236# a_26955_7040# a_27695_6995# VGND.t787 sg13_lv_nmos ad=0.3473p pd=2.71u as=0.12665p ps=1.145u w=0.74u l=0.13u
X1930 a_24170_5704# sg13cmos5l_nor4_2_7.D sg13cmos5l_nand3_1_2.B VPWR.t7 sg13_lv_pmos ad=0.3808p pd=2.92u as=0.2128p ps=1.5u w=1.12u l=0.13u
X1931 sg13cmos5l_dfrbpq_1_57.CLK a_8842_6886# VPWR.t954 VPWR.t2 sg13_lv_pmos ad=0.2128p pd=1.5u as=0.2128p ps=1.5u w=1.12u l=0.13u
X1932 a_1190_1632# a_920_1673# VGND.t15 VGND.t869 sg13_lv_nmos ad=0.1428p pd=1.52u as=79.8f ps=0.8u w=0.42u l=0.5u
X1933 a_15376_2602# a_15119_2459# a_15538_2382# VGND.t147 sg13_lv_nmos ad=0.1428p pd=1.52u as=37.8f ps=0.6u w=0.42u l=0.13u
X1934 sg13cmos5l_dfrbpq_1_2.CLK a_18826_4620# VGND.t133 VGND.t1134 sg13_lv_nmos ad=0.1406p pd=1.12u as=0.2516p ps=2.16u w=0.74u l=0.13u
X1935 a_26896_7922# a_26639_8041# a_27058_8118# VGND.t300 sg13_lv_nmos ad=0.1428p pd=1.52u as=37.8f ps=0.6u w=0.42u l=0.13u
X1936 a_3878_7680# a_3608_7721# VGND.t728 VGND.t68 sg13_lv_nmos ad=0.1428p pd=1.52u as=79.8f ps=0.8u w=0.42u l=0.5u
X1937 a_18022_3907# sg13cmos5l_buf_1_4.X.t8 VGND.t50 VGND.t185 sg13_lv_nmos ad=37.8f pd=0.6u as=0.1701p ps=1.65u w=0.42u l=0.13u
X1938 a_11639_7727# sg13cmos5l_xnor2_1_2.B a_12386_8118# VGND.t1087 sg13_lv_nmos ad=0.1428p pd=1.52u as=60.89999f ps=0.71u w=0.42u l=0.13u
X1939 a_6154_6136# a_6597_6179# a_6537_6215# VPWR.t7 sg13_lv_pmos ad=79.8f pd=0.8u as=63f ps=0.72u w=0.42u l=0.13u
X1940 VPWR.t7 sg13cmos5l_dfrbpq_1_57.RESET_B.t5 a_10444_6606# VPWR.t7 sg13_lv_pmos ad=1.42587p pd=9.11u as=79.8f ps=0.8u w=0.42u l=0.13u
X1941 VPWR.t577 a_21647_5017# a_22314_4656# VPWR.t43 sg13_lv_pmos ad=0.2128p pd=1.5u as=0.3864p ps=2.93u w=1.12u l=0.13u
X1942 VGND.t115 a_7232_1919# sg13cmos5l_dlygate4sd3_1_20.A VGND.t476 sg13_lv_nmos ad=0.1406p pd=1.12u as=0.2516p ps=2.16u w=0.74u l=0.13u
X1943 a_22466_8118# sg13cmos5l_buf_1_0.X.t12 VGND.t20 VGND.t135 sg13_lv_nmos ad=60.89999f pd=0.71u as=0.1626p ps=1.415u w=0.42u l=0.13u
X1944 VPWR.t464 a_3680_1045# sg13cmos5l_dlygate4sd3_1_21.A VPWR.t15 sg13_lv_pmos ad=0.2128p pd=1.5u as=0.3808p ps=2.92u w=1.12u l=0.13u
X1945 a_27226_2350# sg13cmos5l_dlygate4sd3_1_15.A VGND.t11 VGND.t317 sg13_lv_nmos ad=0.1428p pd=1.52u as=79.8f ps=0.8u w=0.42u l=0.13u
X1946 a_7893_4052# a_6951_4112# a_7799_4285# VPWR.t43 sg13_lv_pmos ad=79.8f pd=0.8u as=0.1428p ps=1.52u w=0.42u l=0.13u
X1947 VPWR.t1317 a_27963_6538# sg13cmos5l_dfrbpq_1_53.CLK VPWR.t7 sg13_lv_pmos ad=0.2128p pd=1.5u as=0.2128p ps=1.5u w=1.12u l=0.13u
X1948 VPWR.t79 VGND.t54 VPWR.t79 VPWR.t10 sg13_lv_pmos ad=0.19p pd=1.38u as=0 ps=0 w=1u l=1u
X1949 a_23872_5704# sg13cmos5l_dlygate4sd3_1_9.X a_24170_5704# VPWR.t7 sg13_lv_pmos ad=0.3808p pd=2.92u as=0.2128p ps=1.5u w=1.12u l=0.13u
X1950 sg13cmos5l_buf_8_10.A a_14235_6922# VGND.t332 VGND.t95 sg13_lv_nmos ad=0.1406p pd=1.12u as=0.1406p ps=1.12u w=0.74u l=0.13u
X1951 VPWR.t105 sg13cmos5l_dfrbpq_1_13.CLK a_8063_1603# VPWR.t15 sg13_lv_pmos ad=1.46697p pd=9.345u as=0.4088p ps=2.97u w=1.12u l=0.13u
X1952 a_26159_3505# a_25317_3155# a_24900_3148# VPWR.t10 sg13_lv_pmos ad=0.2048p pd=1.63u as=0.34p ps=2.68u w=1u l=0.13u
X1953 VGND.t65 sg13cmos5l_buf_1_0.X.t10 a_22070_6931# VGND.t64 sg13_lv_nmos ad=0.1701p pd=1.65u as=37.8f ps=0.6u w=0.42u l=0.13u
X1954 a_2165_5026# sg13cmos5l_xnor2_1_12.Y VGND.t30 VGND.t30 sg13_lv_nmos ad=0.1406p pd=1.12u as=0.1898p ps=1.36u w=0.74u l=0.13u
X1955 a_1979_3940# sg13cmos5l_nand3_1_3.Y VGND.t632 VGND.t1427 sg13_lv_nmos ad=78.39999f pd=0.885u as=0.2272p ps=1.99u w=0.64u l=0.13u
X1956 VPWR.t105 a_10725_1643# a_10827_1643# VPWR.t15 sg13_lv_pmos ad=1.50275p pd=9.57u as=0.3864p ps=2.93u w=1.12u l=0.13u
X1957 sg13cmos5l_nor3_1_2.Y sg13cmos5l_nor3_1_2.C a_1623_7216# VPWR.t2 sg13_lv_pmos ad=0.3808p pd=2.92u as=0.2128p ps=1.5u w=1.12u l=0.13u
X1958 VGND.t50 a_9915_3898# sg13cmos5l_buf_8_3.A VGND.t1576 sg13_lv_nmos ad=0.1406p pd=1.12u as=0.1406p ps=1.12u w=0.74u l=0.13u
X1959 VPWR.t245 VGND.t278 VPWR.t244 VPWR.t7 sg13_lv_pmos ad=0.34p pd=2.68u as=0 ps=0 w=1u l=1u
X1960 a_18972_1993# a_19103_1603# a_18391_1596# VPWR.t15 sg13_lv_pmos ad=0.34p pd=2.68u as=0.2048p ps=1.63u w=1u l=0.13u
X1961 VPWR.t1058 sg13cmos5l_dfrbpq_1_17.D a_11639_3191# VPWR.t10 sg13_lv_pmos ad=0.1428p pd=1.52u as=79.8f ps=0.8u w=0.42u l=0.13u
X1962 VGND.t411 sg13cmos5l_xnor2_1_6.Y a_15791_874# VGND.t410 sg13_lv_nmos ad=0.1898p pd=1.36u as=0.1406p ps=1.12u w=0.74u l=0.13u
X1963 a_16270_2571# a_16385_2572# VPWR.t578 VPWR.t10 sg13_lv_pmos ad=0.34p pd=2.68u as=0.2254p ps=1.53u w=1u l=0.5u
X1964 sg13cmos5l_xnor2_1_5.A a_13745_3948# a_13916_4192# VPWR.t43 sg13_lv_pmos ad=0.3808p pd=2.92u as=0.2128p ps=1.5u w=1.12u l=0.13u
X1965 sg13cmos5l_dfrbpq_1_46.CLK a_18922_7644# VPWR.t902 VPWR.t2 sg13_lv_pmos ad=0.2128p pd=1.5u as=0.3864p ps=2.93u w=1.12u l=0.13u
X1966 a_15322_6132# sg13cmos5l_dlygate4sd3_1_57.A VGND.t332 VGND.t95 sg13_lv_nmos ad=0.1428p pd=1.52u as=79.8f ps=0.8u w=0.42u l=0.13u
X1967 VPWR.t222 sg13cmos5l_dlygate4sd3_1_11.X a_28931_7216# VPWR.t2 sg13_lv_pmos ad=0.3808p pd=2.92u as=0.2464p ps=1.56u w=1.12u l=0.13u
X1968 a_5954_870# sg13cmos5l_dfrbpq_1_13.RESET_B.t5 VGND.t363 VGND.t1614 sg13_lv_nmos ad=60.89999f pd=0.71u as=0.1626p ps=1.415u w=0.42u l=0.13u
X1969 VGND.t332 sg13cmos5l_and2_1_4.X a_14235_6922# VGND.t95 sg13_lv_nmos ad=0.1406p pd=1.12u as=0.1406p ps=1.12u w=0.74u l=0.13u
X1970 a_4366_7107# a_4481_7108# VGND.t453 VGND.t947 sg13_lv_nmos ad=0.1428p pd=1.52u as=0.1426p ps=1.16u w=0.42u l=0.5u
X1971 a_16042_7141# a_16485_6897# a_15782_6918# VGND.t122 sg13_lv_nmos ad=79.8f pd=0.8u as=0.1296p ps=1.52u w=0.42u l=0.13u
X1972 VGND.t418 a_7439_6529# a_8106_6168# VGND.t417 sg13_lv_nmos ad=0.1406p pd=1.12u as=0.2516p ps=2.16u w=0.74u l=0.13u
X1973 a_6261_1679# a_5319_1719# a_6122_1912# VGND.t1662 sg13_lv_nmos ad=79.8f pd=0.8u as=0.2373p ps=1.97u w=0.42u l=0.13u
X1974 a_7799_8821# sg13cmos5l_nor3_1_2.C a_8546_8430# VGND.t89 sg13_lv_nmos ad=0.1428p pd=1.52u as=60.89999f ps=0.71u w=0.42u l=0.13u
X1975 a_24900_870# sg13cmos5l_nor4_2_0.D a_24806_870# VGND.t847 sg13_lv_nmos ad=60.89999f pd=0.71u as=0.1428p ps=1.52u w=0.42u l=0.13u
X1976 a_16563_1632# sg13cmos5l_xnor2_1_2.A VPWR.t214 VPWR.t15 sg13_lv_pmos ad=0.1428p pd=1.375u as=0.2891p ps=1.695u w=1.12u l=0.13u
X1977 a_7532_3144# sg13cmos5l_xnor2_1_6.B a_7744_3144# VPWR.t10 sg13_lv_pmos ad=0.2128p pd=1.5u as=0.3808p ps=2.92u w=1.12u l=0.13u
X1978 a_17614_8619# a_17729_8620# VPWR.t791 VPWR.t0 sg13_lv_pmos ad=0.34p pd=2.68u as=0.2254p ps=1.53u w=1u l=0.5u
X1979 VPWR.t215 sg13cmos5l_dfrbpq_1_21.RESET_B.t8 a_3850_4117# VPWR.t43 sg13_lv_pmos ad=0.1563p pd=1.22u as=0.147p ps=1.54u w=0.42u l=0.13u
X1980 a_9915_3898# sg13cmos5l_buf_8_5.A VGND.t50 VGND.t1329 sg13_lv_nmos ad=0.1406p pd=1.12u as=0.1406p ps=1.12u w=0.74u l=0.13u
X1981 a_28559_3514# sg13cmos5l_xnor2_1_4.A VGND.t268 VGND.t1450 sg13_lv_nmos ad=0.2516p pd=2.16u as=0.1898p ps=1.36u w=0.74u l=0.13u
X1982 VPWR.t778 sg13cmos5l_dfrbpq_1_21.RESET_B.t10 a_7046_8118# VPWR.t2 sg13_lv_pmos ad=0.36237p pd=2.605u as=79.8f ps=0.8u w=0.42u l=0.13u
X1983 sg13cmos5l_dfrbpq_1_56.CLK a_18363_6922# VGND.t145 VGND.t981 sg13_lv_nmos ad=0.1406p pd=1.12u as=0.1406p ps=1.12u w=0.74u l=0.13u
X1984 a_2016_4695# sg13cmos5l_xnor2_1_12.Y a_1979_5004# VGND.t30 sg13_lv_nmos ad=0.2176p pd=1.96u as=78.39999f ps=0.885u w=0.64u l=0.13u
X1985 sg13cmos5l_dfrbpq_1_1.Q a_27018_1168# VGND.t176 VGND.t646 sg13_lv_nmos ad=0.2516p pd=2.16u as=0.1406p ps=1.12u w=0.74u l=0.13u
X1986 a_5301_2540# a_4359_2600# a_5207_2773# VPWR.t10 sg13_lv_pmos ad=79.8f pd=0.8u as=0.1428p ps=1.52u w=0.42u l=0.13u
X1987 a_2016_4209# sg13cmos5l_nand3_1_3.Y VPWR.t1270 VPWR.t43 sg13_lv_pmos ad=0.1596p pd=1.22u as=0.4536p ps=2.76u w=0.84u l=0.13u
X1988 VPWR.t147 a_19893_1679# a_18972_1993# VPWR.t15 sg13_lv_pmos ad=0.36237p pd=2.605u as=0.34p ps=2.68u w=1u l=0.13u
X1989 VPWR.t758 a_17109_4703# a_16188_5017# VPWR.t43 sg13_lv_pmos ad=0.36237p pd=2.605u as=0.34p ps=2.68u w=1u l=0.13u
X1990 a_15598_8430# a_15839_8700# a_15127_8394# VGND.t819 sg13_lv_nmos ad=0.1428p pd=1.52u as=0.12665p ps=1.145u w=0.42u l=0.13u
X1991 VPWR.t432 a_17132_3108# sg13cmos5l_dfrbpq_1_55.RESET_B VPWR.t10 sg13_lv_pmos ad=0.2114p pd=1.54u as=0.42p ps=2.99u w=1.12u l=0.13u
X1992 a_15708_8394# a_15839_8700# a_15127_8394# VPWR.t0 sg13_lv_pmos ad=0.34p pd=2.68u as=0.2048p ps=1.63u w=1u l=0.13u
X1993 a_25198_2070# a_24940_2070# VGND.t112 VGND.t844 sg13_lv_nmos ad=0.1428p pd=1.52u as=79.8f ps=0.8u w=0.42u l=0.13u
X1994 sg13cmos5l_nand3_1_0.Y sg13cmos5l_nor3_1_0.Y VPWR.t191 VPWR.t15 sg13_lv_pmos ad=0.2128p pd=1.5u as=0.3808p ps=2.92u w=1.12u l=0.13u
X1995 a_13834_3112# a_14277_3155# a_14217_3191# VPWR.t10 sg13_lv_pmos ad=79.8f pd=0.8u as=63f ps=0.72u w=0.42u l=0.13u
X1996 a_7532_3144# sg13cmos5l_xnor2_1_6.A VPWR.t1276 VPWR.t10 sg13_lv_pmos ad=0.2128p pd=1.5u as=0.3864p ps=2.93u w=1.12u l=0.13u
X1997 a_3878_7680# a_3608_7721# VPWR.t816 VPWR.t2 sg13_lv_pmos ad=0.34p pd=2.68u as=0.1523p ps=1.38u w=1u l=0.5u
X1998 a_19799_1679# a_19103_1603# a_19893_1679# VGND.t401 sg13_lv_nmos ad=0.1296p pd=1.52u as=79.8f ps=0.8u w=0.42u l=0.13u
X1999 VGND.t145 sg13cmos5l_buf_8_10.A a_18363_6922# VGND.t1085 sg13_lv_nmos ad=0.1406p pd=1.12u as=0.1406p ps=1.12u w=0.74u l=0.13u
X2000 sg13cmos5l_buf_8_2.X a_21435_3514# VPWR.t79 VPWR.t10 sg13_lv_pmos ad=0.2128p pd=1.5u as=0.2128p ps=1.5u w=1.12u l=0.13u
X2001 a_18479_874# a_18444_1060# sg13cmos5l_xnor2_1_1.B VGND.t1147 sg13_lv_nmos ad=0.1406p pd=1.12u as=0.2516p ps=2.16u w=0.74u l=0.13u
X2002 a_3876_8748# a_3850_8653# VPWR.t665 VPWR.t0 sg13_lv_pmos ad=0.34p pd=2.68u as=0.36237p ps=2.605u w=1u l=0.13u
X2003 a_4233_8821# a_3876_8748# VPWR.t131 VPWR.t0 sg13_lv_pmos ad=63f pd=0.72u as=0.1563p ps=1.22u w=0.42u l=0.13u
X2004 sg13cmos5l_dfrbpq_1_35.Q a_12234_7216# VPWR.t926 VPWR.t2 sg13_lv_pmos ad=0.3808p pd=2.92u as=0.2128p ps=1.5u w=1.12u l=0.13u
X2005 a_11733_6215# a_10791_6255# a_11594_6448# VGND.t1253 sg13_lv_nmos ad=79.8f pd=0.8u as=0.2373p ps=1.97u w=0.42u l=0.13u
X2006 a_5511_4743# a_5663_4627# VGND.t30 VGND.t854 sg13_lv_nmos ad=0.2516p pd=2.16u as=3.5351p ps=22.08u w=0.74u l=0.13u
X2007 VGND.t50 a_6250_3108# sg13cmos5l_dfrbpq_1_21.CLK VGND.t674 sg13_lv_nmos ad=0.1406p pd=1.12u as=0.1406p ps=1.12u w=0.74u l=0.13u
X2008 sg13cmos5l_nor3_1_4.Y sg13cmos5l_nor3_1_4.C a_15447_4192# VPWR.t43 sg13_lv_pmos ad=0.3808p pd=2.92u as=0.2128p ps=1.5u w=1.12u l=0.13u
X2009 sg13cmos5l_xnor2_1_4.B sg13cmos5l_dfrbpq_1_46.D a_23955_6168# VPWR.t7 sg13_lv_pmos ad=0.2408p pd=1.55u as=0.1428p ps=1.375u w=1.12u l=0.13u
X2010 a_21904_4898# a_21647_5017# a_22066_5094# VGND.t142 sg13_lv_nmos ad=0.1428p pd=1.52u as=37.8f ps=0.6u w=0.42u l=0.13u
X2011 a_26121_8821# a_25764_8748# VPWR.t586 VPWR.t0 sg13_lv_pmos ad=63f pd=0.72u as=0.1563p ps=1.22u w=0.42u l=0.13u
X2012 VPWR.t43 a_4293_3873# a_4395_4016# VPWR.t43 sg13_lv_pmos ad=1.3927p pd=8.9u as=0.3864p ps=2.93u w=1.12u l=0.13u
X2013 a_21934_2571# a_22049_2572# VGND.t17 VGND.t74 sg13_lv_nmos ad=0.1428p pd=1.52u as=0.1426p ps=1.16u w=0.42u l=0.5u
X2014 sg13cmos5l_nor3_1_0.Y sg13cmos5l_nor3_1_0.A VGND.t172 VGND.t642 sg13_lv_nmos ad=0.1694p pd=1.21u as=0.2618p ps=2.22u w=0.77u l=0.13u
X2015 a_25668_8105# a_25380_7684# a_25606_8105# VGND.t500 sg13_lv_nmos ad=0.1428p pd=1.52u as=37.8f ps=0.6u w=0.42u l=0.13u
X2016 VPWR.t177 sg13cmos5l_buf_1_0.X.t3 a_20362_5629# VPWR.t7 sg13_lv_pmos ad=0.1563p pd=1.22u as=0.147p ps=1.54u w=0.42u l=0.13u
X2017 VPWR.t79 a_21435_3514# sg13cmos5l_buf_8_2.X VPWR.t10 sg13_lv_pmos ad=0.2128p pd=1.5u as=0.2128p ps=1.5u w=1.12u l=0.13u
X2018 VPWR.t1313 a_27963_6538# sg13cmos5l_dfrbpq_1_53.CLK VPWR.t7 sg13_lv_pmos ad=0.2128p pd=1.5u as=0.2128p ps=1.5u w=1.12u l=0.13u
X2019 a_16164_5724# a_16683_5528# a_17423_5483# VGND.t1242 sg13_lv_nmos ad=0.3473p pd=2.71u as=0.12665p ps=1.145u w=0.74u l=0.13u
X2020 VGND.t365 a_13563_874# sg13cmos5l_dfrbpq_1_11.CLK VGND.t512 sg13_lv_nmos ad=0.1406p pd=1.12u as=0.1406p ps=1.12u w=0.74u l=0.13u
X2021 a_10596_2057# a_10308_1636# a_10534_2057# VGND.t391 sg13_lv_nmos ad=0.1428p pd=1.52u as=37.8f ps=0.6u w=0.42u l=0.13u
X2022 sg13cmos5l_buf_1_5.A a_9640_7680# VPWR.t901 VPWR.t2 sg13_lv_pmos ad=0.42p pd=2.99u as=0.2114p ps=1.54u w=1.12u l=0.13u
X2023 VPWR.t43 sg13cmos5l_dfrbpq_1_57.CLK a_10943_4627# VPWR.t43 sg13_lv_pmos ad=1.3927p pd=8.9u as=0.4088p ps=2.97u w=1.12u l=0.13u
X2024 VPWR.t814 a_14542_4923# sg13cmos5l_dfrbpq_1_17.D VPWR.t43 sg13_lv_pmos ad=0.2254p pd=1.53u as=0.4256p ps=3u w=1.12u l=0.13u
X2025 VPWR.t228 a_4186_1596# a_3905_1898# VPWR.t15 sg13_lv_pmos ad=0.1523p pd=1.38u as=0.34p ps=2.68u w=1u l=0.5u
X2026 a_10596_5419# a_10827_5528# a_10282_5629# VGND.t331 sg13_lv_nmos ad=0.2373p pd=1.97u as=79.8f ps=0.8u w=0.42u l=0.13u
X2027 VGND.t52 sg13cmos5l_dfrbpq_1_23.D sg13cmos5l_nor4_2_9.Y VGND.t30 sg13_lv_nmos ad=0.3293p pd=1.63u as=0.1406p ps=1.12u w=0.74u l=0.13u
X2028 sg13cmos5l_dfrbpq_1_46.D a_19638_8498# VGND.t996 VGND.t0 sg13_lv_nmos ad=0.2516p pd=2.16u as=0.1426p ps=1.16u w=0.74u l=0.13u
X2029 a_6818_8118# sg13cmos5l_dfrbpq_1_21.RESET_B.t11 VGND.t312 VGND.t736 sg13_lv_nmos ad=60.89999f pd=0.71u as=0.1626p ps=1.415u w=0.42u l=0.13u
X2030 a_4359_1088# a_4511_1140# VPWR.t105 VPWR.t15 sg13_lv_pmos ad=0.3864p pd=2.93u as=1.50275p ps=9.57u w=1.12u l=0.13u
X2031 sg13cmos5l_dfrbpq_1_21.CLK a_6250_3108# VGND.t50 VGND.t674 sg13_lv_nmos ad=0.1406p pd=1.12u as=0.1406p ps=1.12u w=0.74u l=0.13u
X2032 a_23872_1168# sg13cmos5l_nor4_2_0.B a_23660_1168# VPWR.t15 sg13_lv_pmos ad=0.2128p pd=1.5u as=0.2128p ps=1.5u w=1.12u l=0.13u
X2033 VPWR.t86 VGND.t280 VPWR.t85 VPWR.t7 sg13_lv_pmos ad=0.34p pd=2.68u as=0 ps=0 w=1u l=1u
X2034 a_4012_870# a_3799_834# VPWR.t105 VPWR.t15 sg13_lv_pmos ad=79.8f pd=0.8u as=1.50275p ps=9.57u w=0.42u l=0.13u
X2035 a_16643_1168# sg13cmos5l_dfrbpq_1_55.D a_16541_1168# VPWR.t15 sg13_lv_pmos ad=0.2464p pd=1.56u as=0.2128p ps=1.5u w=1.12u l=0.13u
X2036 a_13563_874# sg13cmos5l_buf_8_3.A VGND.t365 VGND.t769 sg13_lv_nmos ad=0.1406p pd=1.12u as=0.1406p ps=1.12u w=0.74u l=0.13u
X2037 a_7737_7233# a_6795_7040# a_7535_6995# VPWR.t2 sg13_lv_pmos ad=93.45f pd=0.865u as=0.2048p ps=1.63u w=0.42u l=0.13u
X2038 a_3590_3894# sg13cmos5l_dfrbpq_1_15.D VPWR.t123 VPWR.t43 sg13_lv_pmos ad=79.8f pd=0.8u as=0.1428p ps=1.52u w=0.42u l=0.13u
X2039 a_18981_3155# sg13cmos5l_dfrbpq_1_2.CLK VGND.t50 VGND.t1343 sg13_lv_nmos ad=0.2516p pd=2.16u as=3.63467p ps=22.73u w=0.74u l=0.13u
X2040 VGND.t20 a_21647_8507# a_22314_8728# VGND.t19 sg13_lv_nmos ad=0.1406p pd=1.12u as=0.2516p ps=2.16u w=0.74u l=0.13u
X2041 sg13cmos5l_xnor2_1_9.A sg13cmos5l_nor4_2_9.Y a_3896_6926# VGND.t1003 sg13_lv_nmos ad=0.2516p pd=2.16u as=0.1406p ps=1.12u w=0.74u l=0.13u
X2042 VGND.t350 a_15302_5410# a_15414_5474# VGND.t1388 sg13_lv_nmos ad=0.1426p pd=1.16u as=0.1428p ps=1.52u w=0.42u l=0.5u
X2043 sg13cmos5l_xnor2_1_1.B a_18444_1060# VPWR.t1024 VPWR.t15 sg13_lv_pmos ad=0.2408p pd=1.55u as=0.3808p ps=2.92u w=1.12u l=0.13u
X2044 VGND.t259 a_27023_5483# a_27690_5704# VGND.t200 sg13_lv_nmos ad=0.1406p pd=1.12u as=0.2516p ps=2.16u w=0.74u l=0.13u
X2045 a_21647_5017# a_20805_4667# a_21553_5017# VGND.t142 sg13_lv_nmos ad=0.12665p pd=1.145u as=0.1428p ps=1.52u w=0.42u l=0.13u
X2046 a_28570_4620# sg13cmos5l_dfrbpq_1_7.Q VPWR.t1031 VPWR.t43 sg13_lv_pmos ad=0.1428p pd=1.52u as=0.1523p ps=1.38u w=0.42u l=0.13u
X2047 VPWR.t189 sg13cmos5l_dlygate4sd3_1_1.A a_27992_1673# VPWR.t15 sg13_lv_pmos ad=0.1523p pd=1.38u as=0.1428p ps=1.52u w=0.42u l=0.13u
X2048 sg13cmos5l_dfrbpq_1_12.Q a_12234_1632# VPWR.t157 VPWR.t15 sg13_lv_pmos ad=0.3808p pd=2.92u as=0.2128p ps=1.5u w=1.12u l=0.13u
X2049 a_18922_7644# sg13cmos5l_buf_8_11.A VGND.t996 VGND.t0 sg13_lv_nmos ad=0.2553p pd=2.17u as=0.1406p ps=1.12u w=0.74u l=0.13u
X2050 a_27963_6538# sg13cmos5l_buf_8_11.A VPWR.t889 VPWR.t7 sg13_lv_pmos ad=0.2128p pd=1.5u as=0.2128p ps=1.5u w=1.12u l=0.13u
X2051 VPWR.t1227 a_6250_2350# sg13cmos5l_dfrbpq_1_13.CLK VPWR.t10 sg13_lv_pmos ad=0.2128p pd=1.5u as=0.2128p ps=1.5u w=1.12u l=0.13u
X2052 a_6250_2350# sg13cmos5l_buf_8_3.A VGND.t115 VGND.t768 sg13_lv_nmos ad=0.2553p pd=2.17u as=0.1406p ps=1.12u w=0.74u l=0.13u
X2053 VGND.t316 sg13cmos5l_dfrbpq_1_55.RESET_B a_13668_3582# VGND.t576 sg13_lv_nmos ad=0.1626p pd=1.415u as=60.89999f ps=0.71u w=0.42u l=0.13u
X2054 a_4164_8443# a_4395_8552# a_3850_8653# VGND.t81 sg13_lv_nmos ad=0.2373p pd=1.97u as=79.8f ps=0.8u w=0.42u l=0.13u
X2055 VGND.t150 VPWR.t1452 VGND.t150 VGND.t1521 sg13_lv_nmos ad=0.1428p pd=1.52u as=0 ps=0 w=0.42u l=1u
X2056 VGND.t96 VPWR.t1465 VGND.t96 VGND.t95 sg13_lv_nmos ad=0.1428p pd=1.52u as=0 ps=0 w=0.42u l=1u
X2057 VGND.t13 a_25936_2602# a_25585_2459# VGND.t12 sg13_lv_nmos ad=79.8f pd=0.8u as=0.1428p ps=1.52u w=0.42u l=0.13u
X2058 a_11990_3569# a_10812_3505# a_11594_3424# VGND.t1129 sg13_lv_nmos ad=37.8f pd=0.6u as=0.1428p ps=1.52u w=0.42u l=0.13u
X2059 VPWR.t508 a_6972_834# a_7995_1261# VPWR.t15 sg13_lv_pmos ad=0.1563p pd=1.22u as=63f ps=0.72u w=0.42u l=0.13u
X2060 a_25236_5452# sg13cmos5l_xnor2_1_4.Y a_24780_5596# VGND.t142 sg13_lv_nmos ad=78.39999f pd=0.885u as=0.2176p ps=1.96u w=0.64u l=0.13u
X2061 a_10282_1600# a_10725_1643# a_10665_1679# VPWR.t15 sg13_lv_pmos ad=79.8f pd=0.8u as=63f ps=0.72u w=0.42u l=0.13u
X2062 a_15108_7684# a_15082_7648# VPWR.t139 VPWR.t2 sg13_lv_pmos ad=0.34p pd=2.68u as=0.36237p ps=2.605u w=1u l=0.13u
X2063 a_25354_7648# a_25797_7691# a_25094_8118# VGND.t407 sg13_lv_nmos ad=79.8f pd=0.8u as=0.1296p ps=1.52u w=0.42u l=0.13u
X2064 VGND.t50 a_17132_3108# sg13cmos5l_dfrbpq_1_55.RESET_B VGND.t1298 sg13_lv_nmos ad=0.14875p pd=1.16u as=0.2886p ps=2.26u w=0.74u l=0.13u
X2065 a_18729_2773# a_18372_2700# VPWR.t414 VPWR.t10 sg13_lv_pmos ad=63f pd=0.72u as=0.1563p ps=1.22u w=0.42u l=0.13u
X2066 VGND.t803 sg13cmos5l_dfrbpq_1_21.RESET_B.t13 a_8150_8443# VGND.t858 sg13_lv_nmos ad=0.1701p pd=1.65u as=37.8f ps=0.6u w=0.42u l=0.13u
X2067 VGND.t995 a_18922_7644# sg13cmos5l_dfrbpq_1_46.CLK VGND.t0 sg13_lv_nmos ad=0.1406p pd=1.12u as=0.1406p ps=1.12u w=0.74u l=0.13u
X2068 a_26331_1679# a_25439_1603# a_26229_1679# VPWR.t15 sg13_lv_pmos ad=63f pd=0.72u as=79.8f ps=0.8u w=0.42u l=0.13u
X2069 VPWR.t184 VGND.t137 VPWR.t184 VPWR.t15 sg13_lv_pmos ad=0.34p pd=2.68u as=0 ps=0 w=1u l=1u
X2070 a_15008_8605# a_15127_8394# VGND.t93 VGND.t1403 sg13_lv_nmos ad=0.2516p pd=2.16u as=0.1406p ps=1.12u w=0.74u l=0.13u
X2071 VGND.t128 sg13cmos5l_buf_1_0.X.t5 a_24420_6606# VGND.t485 sg13_lv_nmos ad=0.1626p pd=1.415u as=60.89999f ps=0.71u w=0.42u l=0.13u
X2072 VPWR.t452 sg13cmos5l_dfrbpq_1_3.D a_19799_1679# VPWR.t15 sg13_lv_pmos ad=0.1428p pd=1.52u as=79.8f ps=0.8u w=0.42u l=0.13u
X2073 VGND.t280 a_1870_6435# sg13cmos5l_dlygate4sd3_1_31.X VGND.t279 sg13_lv_nmos ad=0.1426p pd=1.16u as=0.2516p ps=2.16u w=0.74u l=0.13u
X2074 a_13888_6168# sg13cmos5l_dlygate4sd3_1_28.X a_13676_6168# VPWR.t7 sg13_lv_pmos ad=0.2128p pd=1.5u as=0.2128p ps=1.5u w=1.12u l=0.13u
X2075 a_16731_8821# a_15839_8700# a_16629_8588# VPWR.t0 sg13_lv_pmos ad=63f pd=0.72u as=79.8f ps=0.8u w=0.42u l=0.13u
X2076 VGND.t453 a_4366_7107# sg13cmos5l_nor4_2_9.D VGND.t905 sg13_lv_nmos ad=0.1426p pd=1.16u as=0.2516p ps=2.16u w=0.74u l=0.13u
X2077 VPWR.t1 a_11824_8650# a_11769_8745# VPWR.t0 sg13_lv_pmos ad=1.8922p pd=12.27u as=93.45f ps=0.865u w=0.42u l=0.13u
X2078 a_17510_3894# a_18315_4016# a_17770_4117# VPWR.t43 sg13_lv_pmos ad=0.1428p pd=1.52u as=79.8f ps=0.8u w=0.42u l=0.13u
X2079 VGND.t235 a_20687_947# a_21354_1168# VGND.t234 sg13_lv_nmos ad=0.1406p pd=1.12u as=0.2516p ps=2.16u w=0.74u l=0.13u
X2080 VPWR.t505 a_15119_2459# a_15786_2680# VPWR.t10 sg13_lv_pmos ad=0.2128p pd=1.5u as=0.3864p ps=2.93u w=1.12u l=0.13u
X2081 VGND.t50 a_16454_3144# a_16566_3168# VGND.t615 sg13_lv_nmos ad=0.1426p pd=1.16u as=0.1428p ps=1.52u w=0.42u l=0.5u
X2082 VPWR.t43 a_21647_5017# a_21904_4898# VPWR.t43 sg13_lv_pmos ad=1.3927p pd=8.9u as=79.8f ps=0.8u w=0.42u l=0.13u
X2083 VPWR.t1031 a_28570_4620# a_28289_4922# VPWR.t43 sg13_lv_pmos ad=0.1523p pd=1.38u as=0.34p ps=2.68u w=1u l=0.5u
X2084 VPWR.t578 a_16270_2571# sg13cmos5l_dfrbpq_1_22.D VPWR.t10 sg13_lv_pmos ad=0.2254p pd=1.53u as=0.4256p ps=3u w=1.12u l=0.13u
X2085 a_20388_4660# a_20362_4624# VGND.t133 VGND.t1337 sg13_lv_nmos ad=0.2516p pd=2.16u as=0.1626p ps=1.415u w=0.74u l=0.13u
X2086 a_4293_3155# sg13cmos5l_dfrbpq_1_21.CLK VGND.t50 VGND.t1331 sg13_lv_nmos ad=0.2516p pd=2.16u as=3.63467p ps=22.73u w=0.74u l=0.13u
X2087 a_10308_8748# a_10827_8552# a_11567_8507# VGND.t801 sg13_lv_nmos ad=0.3473p pd=2.71u as=0.12665p ps=1.145u w=0.74u l=0.13u
X2088 VPWR.t1060 a_19609_6942# sg13cmos5l_buf_2_0.X VPWR.t2 sg13_lv_pmos ad=0.7336p pd=3.55u as=0.2128p ps=1.5u w=1.12u l=0.13u
X2089 a_10791_2600# a_10943_2652# VPWR.t91 VPWR.t10 sg13_lv_pmos ad=0.3864p pd=2.93u as=1.43285p ps=9.125u w=1.12u l=0.13u
X2090 VPWR.t791 a_17614_8619# sg13cmos5l_nor4_2_4.D VPWR.t0 sg13_lv_pmos ad=0.2254p pd=1.53u as=0.4256p ps=3u w=1.12u l=0.13u
X2091 a_2165_5410# sg13cmos5l_xnor2_1_5.Y VGND.t30 VGND.t195 sg13_lv_nmos ad=0.1406p pd=1.12u as=0.1898p ps=1.36u w=0.74u l=0.13u
X2092 a_9562_3862# sg13cmos5l_dfrbpq_1_17.Q VPWR.t720 VPWR.t43 sg13_lv_pmos ad=0.1428p pd=1.52u as=0.1523p ps=1.38u w=0.42u l=0.13u
X2093 VPWR.t987 a_2266_6132# a_1985_6434# VPWR.t7 sg13_lv_pmos ad=0.1523p pd=1.38u as=0.34p ps=2.68u w=1u l=0.5u
X2094 a_18372_2700# a_18346_2605# VGND.t77 VGND.t621 sg13_lv_nmos ad=0.2516p pd=2.16u as=0.1626p ps=1.415u w=0.74u l=0.13u
X2095 sg13cmos5l_xnor2_1_0.A a_1169_3502# a_1340_3144# VPWR.t10 sg13_lv_pmos ad=0.3808p pd=2.92u as=0.2128p ps=1.5u w=1.12u l=0.13u
X2096 sg13cmos5l_dfrbpq_1_46.D a_19638_8498# VPWR.t1111 VPWR.t0 sg13_lv_pmos ad=0.4256p pd=3u as=0.2254p ps=1.53u w=1.12u l=0.13u
X2097 a_17746_6918# sg13cmos5l_dfrbpq_1_56.RESET_B VGND.t191 VGND.t822 sg13_lv_nmos ad=37.8f pd=0.6u as=79.8f ps=0.8u w=0.42u l=0.13u
X2098 a_25764_5724# a_25738_5629# VGND.t203 VGND.t585 sg13_lv_nmos ad=0.2516p pd=2.16u as=0.1626p ps=1.415u w=0.74u l=0.13u
X2099 VPWR.t343 a_27610_1596# a_27329_1898# VPWR.t15 sg13_lv_pmos ad=0.1523p pd=1.38u as=0.34p ps=2.68u w=1u l=0.5u
X2100 VGND.t322 sg13cmos5l_dfrbpq_1_57.RESET_B.t12 a_10538_8118# VGND.t321 sg13_lv_nmos ad=79.8f pd=0.8u as=37.8f ps=0.6u w=0.42u l=0.13u
X2101 sg13cmos5l_nand3_1_1.B sg13cmos5l_dlygate4sd3_1_28.X VGND.t96 VGND.t95 sg13_lv_nmos ad=0.1406p pd=1.12u as=0.3293p ps=1.63u w=0.74u l=0.13u
X2102 sg13cmos5l_dfrbpq_1_58.D a_4470_5474# VPWR.t1066 VPWR.t7 sg13_lv_pmos ad=0.4256p pd=3u as=0.2254p ps=1.53u w=1.12u l=0.13u
X2103 sg13cmos5l_dfrbpq_1_11.CLK a_13563_874# VPWR.t352 VPWR.t15 sg13_lv_pmos ad=0.2128p pd=1.5u as=0.2128p ps=1.5u w=1.12u l=0.13u
X2104 a_5024_5581# a_5143_5370# VPWR.t1170 VPWR.t7 sg13_lv_pmos ad=0.3864p pd=2.93u as=0.2128p ps=1.5u w=1.12u l=0.13u
X2105 VPWR.t200 sg13cmos5l_dlygate4sd3_1_18.A a_9176_874# VPWR.t15 sg13_lv_pmos ad=0.1523p pd=1.38u as=0.1428p ps=1.52u w=0.42u l=0.13u
X2106 VPWR.t2 a_27952_7138# a_27897_7233# VPWR.t2 sg13_lv_pmos ad=1.34765p pd=8.56u as=93.45f ps=0.865u w=0.42u l=0.13u
X2107 VPWR.t91 a_15119_2459# a_15376_2602# VPWR.t10 sg13_lv_pmos ad=1.43285p pd=9.125u as=79.8f ps=0.8u w=0.42u l=0.13u
X2108 sg13cmos5l_buf_8_0.X a_15850_3862# VGND.t50 VGND.t1112 sg13_lv_nmos ad=0.1406p pd=1.12u as=0.2516p ps=2.16u w=0.74u l=0.13u
X2109 VGND.t0 a_20805_8409# a_20907_8552# VGND.t1 sg13_lv_nmos ad=3.41162p pd=21.215u as=0.2516p ps=2.16u w=0.74u l=0.13u
X2110 VGND.t535 a_9446_5410# a_9558_5474# VGND.t1250 sg13_lv_nmos ad=0.1426p pd=1.16u as=0.1428p ps=1.52u w=0.42u l=0.5u
X2111 a_7106_5094# sg13cmos5l_dfrbpq_1_58.RESET_B VGND.t664 VGND.t946 sg13_lv_nmos ad=60.89999f pd=0.71u as=0.1626p ps=1.415u w=0.42u l=0.13u
X2112 a_11986_8430# sg13cmos5l_dfrbpq_1_57.RESET_B.t13 VGND.t40 VGND.t653 sg13_lv_nmos ad=37.8f pd=0.6u as=79.8f ps=0.8u w=0.42u l=0.13u
X2113 VPWR.t800 a_17518_7947# sg13cmos5l_nor3_1_4.A VPWR.t2 sg13_lv_pmos ad=0.2254p pd=1.53u as=0.4256p ps=3u w=1.12u l=0.13u
X2114 a_10702_3582# a_10444_3582# VGND.t50 VGND.t1132 sg13_lv_nmos ad=0.1428p pd=1.52u as=79.8f ps=0.8u w=0.42u l=0.13u
X2115 a_3876_3148# a_3850_3112# VPWR.t935 VPWR.t10 sg13_lv_pmos ad=0.34p pd=2.68u as=0.36237p ps=2.605u w=1u l=0.13u
X2116 VPWR.t3 a_21813_7727# a_20892_8041# VPWR.t2 sg13_lv_pmos ad=0.36237p pd=2.605u as=0.34p ps=2.68u w=1u l=0.13u
X2117 a_10282_1093# a_10725_849# a_10022_870# VGND.t228 sg13_lv_nmos ad=79.8f pd=0.8u as=0.1296p ps=1.52u w=0.42u l=0.13u
X2118 VPWR.t469 a_13563_874# sg13cmos5l_dfrbpq_1_11.CLK VPWR.t15 sg13_lv_pmos ad=0.2128p pd=1.5u as=0.2128p ps=1.5u w=1.12u l=0.13u
X2119 a_11824_1874# a_11567_1993# a_11986_2070# VGND.t392 sg13_lv_nmos ad=0.1428p pd=1.52u as=37.8f ps=0.6u w=0.42u l=0.13u
X2120 a_2266_6132# sg13cmos5l_dfrbpq_1_23.Q VPWR.t987 VPWR.t7 sg13_lv_pmos ad=0.1428p pd=1.52u as=0.1523p ps=1.38u w=0.42u l=0.13u
X2121 VPWR.t897 sg13cmos5l_dfrbpq_1_58.D a_5334_6168# VPWR.t7 sg13_lv_pmos ad=0.3864p pd=2.93u as=0.2128p ps=1.5u w=1.12u l=0.13u
X2122 a_24608_1919# a_24727_1596# VGND.t137 VGND.t592 sg13_lv_nmos ad=0.2516p pd=2.16u as=0.1406p ps=1.12u w=0.74u l=0.13u
X2123 a_8546_870# sg13cmos5l_dfrbpq_1_13.RESET_B.t3 VGND.t1619 VGND.t1620 sg13_lv_nmos ad=60.89999f pd=0.71u as=0.1626p ps=1.415u w=0.42u l=0.13u
X2124 a_14343_1719# a_14495_1603# VGND.t77 VGND.t284 sg13_lv_nmos ad=0.2516p pd=2.16u as=3.25012p ps=20.49u w=0.74u l=0.13u
X2125 a_4293_8409# sg13cmos5l_dfrbpq_1_32.CLK VGND.t0 VGND.t1036 sg13_lv_nmos ad=0.2516p pd=2.16u as=3.2221p ps=20.04u w=0.74u l=0.13u
X2126 VGND.t312 sg13cmos5l_dfrbpq_1_21.RESET_B.t14 a_6698_8430# VGND.t734 sg13_lv_nmos ad=79.8f pd=0.8u as=37.8f ps=0.6u w=0.42u l=0.13u
X2127 a_6165_7727# a_5223_7767# a_6071_7727# VPWR.t2 sg13_lv_pmos ad=79.8f pd=0.8u as=0.1428p ps=1.52u w=0.42u l=0.13u
X2128 a_11733_7727# sg13cmos5l_dfrbpq_1_57.RESET_B.t11 VPWR.t708 VPWR.t2 sg13_lv_pmos ad=0.147p pd=1.54u as=0.1563p ps=1.22u w=0.42u l=0.13u
X2129 VPWR.t428 sg13cmos5l_xnor2_1_2.A a_13676_7680# VPWR.t2 sg13_lv_pmos ad=0.3808p pd=2.92u as=0.2128p ps=1.5u w=1.12u l=0.13u
X2130 a_6167_1679# sg13cmos5l_dfrbpq_1_13.RESET_B.t11 VPWR.t155 VPWR.t15 sg13_lv_pmos ad=79.8f pd=0.8u as=0.36237p ps=2.605u w=0.42u l=0.13u
X2131 sg13cmos5l_nand3_1_2.B sg13cmos5l_nor4_2_7.D VGND.t203 VGND.t142 sg13_lv_nmos ad=0.1406p pd=1.12u as=0.3293p ps=1.63u w=0.74u l=0.13u
X2132 VPWR.t91 a_25317_3155# a_25419_3155# VPWR.t10 sg13_lv_pmos ad=1.43285p pd=9.125u as=0.3864p ps=2.93u w=1.12u l=0.13u
X2133 VPWR.t12 VGND.t150 VPWR.t11 VPWR.t10 sg13_lv_pmos ad=0.34p pd=2.68u as=0 ps=0 w=1u l=1u
X2134 VGND.t50 sg13cmos5l_dfrbpq_1_22.Q a_9176_3185# VGND.t1375 sg13_lv_nmos ad=79.8f pd=0.8u as=0.1428p ps=1.52u w=0.42u l=0.13u
X2135 a_21647_5483# a_20805_5385# a_20388_5724# VPWR.t7 sg13_lv_pmos ad=0.2048p pd=1.63u as=0.34p ps=2.68u w=1u l=0.13u
X2136 VGND.t35 a_10725_849# a_10827_992# VGND.t229 sg13_lv_nmos ad=5.40863p pd=35.155u as=0.2516p ps=2.16u w=0.74u l=0.13u
X2137 a_18272_1919# a_18391_1596# VPWR.t379 VPWR.t15 sg13_lv_pmos ad=0.3864p pd=2.93u as=0.2128p ps=1.5u w=1.12u l=0.13u
X2138 VGND.t119 a_11824_1090# a_11473_947# VGND.t1674 sg13_lv_nmos ad=79.8f pd=0.8u as=0.1428p ps=1.52u w=0.42u l=0.13u
X2139 a_25936_2602# a_25679_2459# a_26098_2382# VGND.t9 sg13_lv_nmos ad=0.1428p pd=1.52u as=37.8f ps=0.6u w=0.42u l=0.13u
X2140 VGND.t62 a_23835_8050# sg13cmos5l_buf_8_11.A VGND.t893 sg13_lv_nmos ad=0.1406p pd=1.12u as=0.1406p ps=1.12u w=0.74u l=0.13u
X2141 VPWR.t43 sg13cmos5l_dfrbpq_1_56.RESET_B a_15820_5094# VPWR.t43 sg13_lv_pmos ad=1.3927p pd=8.9u as=79.8f ps=0.8u w=0.42u l=0.13u
X2142 VGND.t126 a_25360_7138# a_25009_6995# VGND.t1031 sg13_lv_nmos ad=79.8f pd=0.8u as=0.1428p ps=1.52u w=0.42u l=0.13u
X2143 a_24646_2395# sg13cmos5l_buf_1_1.X.t8 VGND.t137 VGND.t1276 sg13_lv_nmos ad=37.8f pd=0.6u as=0.1701p ps=1.65u w=0.42u l=0.13u
X2144 sg13cmos5l_dlygate4sd3_1_18.A a_9642_2680# VGND.t608 VGND.t1566 sg13_lv_nmos ad=0.2516p pd=2.16u as=0.1406p ps=1.12u w=0.74u l=0.13u
X2145 VGND.t1014 a_8763_8434# sg13cmos5l_dfrbpq_1_32.CLK VGND.t89 sg13_lv_nmos ad=0.1406p pd=1.12u as=0.1406p ps=1.12u w=0.74u l=0.13u
X2146 sg13cmos5l_nand3_1_2.B sg13cmos5l_dlygate4sd3_1_9.X VGND.t203 VGND.t142 sg13_lv_nmos ad=0.1406p pd=1.12u as=0.1406p ps=1.12u w=0.74u l=0.13u
X2147 a_24806_870# sg13cmos5l_nor4_2_0.D VPWR.t769 VPWR.t15 sg13_lv_pmos ad=79.8f pd=0.8u as=0.1428p ps=1.52u w=0.42u l=0.13u
X2148 a_20080_3386# sg13cmos5l_buf_1_1.X.t12 VPWR.t91 VPWR.t10 sg13_lv_pmos ad=79.8f pd=0.8u as=1.4003p ps=8.92u w=0.42u l=0.13u
X2149 a_24815_5410# a_24780_5596# sg13cmos5l_xnor2_1_10.Y VGND.t142 sg13_lv_nmos ad=0.1406p pd=1.12u as=0.2516p ps=2.16u w=0.74u l=0.13u
X2150 VPWR.t108 sg13cmos5l_dfrbpq_1_13.RESET_B.t2 a_10022_870# VPWR.t15 sg13_lv_pmos ad=0.36237p pd=2.605u as=79.8f ps=0.8u w=0.42u l=0.13u
X2151 a_4358_5410# a_4088_5410# VPWR.t341 VPWR.t7 sg13_lv_pmos ad=0.34p pd=2.68u as=0.1523p ps=1.38u w=1u l=0.5u
X2152 a_1491_4656# sg13cmos5l_dfrbpq_1_23.D VPWR.t482 VPWR.t43 sg13_lv_pmos ad=0.1428p pd=1.375u as=0.2891p ps=1.695u w=1.12u l=0.13u
X2153 a_20362_4624# a_20805_4667# a_20745_4703# VPWR.t43 sg13_lv_pmos ad=79.8f pd=0.8u as=63f ps=0.72u w=0.42u l=0.13u
X2154 VPWR.t164 a_18572_5370# sg13cmos5l_dfrbpq_1_56.RESET_B VPWR.t7 sg13_lv_pmos ad=0.2114p pd=1.54u as=0.42p ps=2.99u w=1.12u l=0.13u
X2155 a_6391_834# a_6951_1088# a_6972_834# VGND.t218 sg13_lv_nmos ad=0.12665p pd=1.145u as=0.3473p ps=2.71u w=0.74u l=0.13u
X2156 VGND.t756 sg13cmos5l_xnor2_1_3.A a_18900_916# VGND.t813 sg13_lv_nmos ad=0.2272p pd=1.99u as=78.39999f ps=0.885u w=0.64u l=0.13u
X2157 VPWR.t53 VGND.t1493 VPWR.t52 VPWR.t7 sg13_lv_pmos ad=0.19p pd=1.38u as=0 ps=0 w=1u l=1u
X2158 sg13cmos5l_buf_8_11.A a_23835_8050# VGND.t286 VGND.t890 sg13_lv_nmos ad=0.1406p pd=1.12u as=0.1406p ps=1.12u w=0.74u l=0.13u
X2159 a_1870_1899# a_1985_1898# VGND.t15 VGND.t274 sg13_lv_nmos ad=0.1428p pd=1.52u as=0.1426p ps=1.16u w=0.42u l=0.5u
X2160 VPWR.t1093 sg13cmos5l_buf_1_4.X.t10 a_20102_5094# VPWR.t43 sg13_lv_pmos ad=0.36237p pd=2.605u as=79.8f ps=0.8u w=0.42u l=0.13u
X2161 a_14254_1755# a_13996_2070# VPWR.t105 VPWR.t15 sg13_lv_pmos ad=93.45f pd=0.865u as=1.50275p ps=9.57u w=0.42u l=0.13u
X2162 VGND.t499 sg13cmos5l_dfrbpq_1_0.D a_28506_2578# VGND.t807 sg13_lv_nmos ad=0.374p pd=2.46u as=0.17462p ps=1.185u w=0.55u l=0.13u
X2163 a_6862_4209# a_6604_3894# VPWR.t43 VPWR.t43 sg13_lv_pmos ad=93.45f pd=0.865u as=1.3927p ps=8.9u w=0.42u l=0.13u
X2164 sg13cmos5l_dfrbpq_1_23.D a_8694_4680# VPWR.t585 VPWR.t43 sg13_lv_pmos ad=0.4256p pd=3u as=0.2254p ps=1.53u w=1.12u l=0.13u
X2165 sg13cmos5l_and2_1_0.X a_20973_3492# VGND.t449 VGND.t53 sg13_lv_nmos ad=0.2516p pd=2.16u as=0.1331p ps=1.12u w=0.74u l=0.13u
X2166 VGND.t553 a_15376_2602# a_15025_2459# VGND.t147 sg13_lv_nmos ad=79.8f pd=0.8u as=0.1428p ps=1.52u w=0.42u l=0.13u
X2167 VPWR.t7 a_16389_6179# a_16491_6179# VPWR.t7 sg13_lv_pmos ad=1.46065p pd=9.335u as=0.3864p ps=2.93u w=1.12u l=0.13u
X2168 sg13cmos5l_and2_1_1.X a_23661_2428# VPWR.t79 VPWR.t10 sg13_lv_pmos ad=0.3808p pd=2.92u as=0.1918p ps=1.5u w=1.12u l=0.13u
X2169 a_11769_7233# a_10827_7040# a_11567_6995# VPWR.t2 sg13_lv_pmos ad=93.45f pd=0.865u as=0.2048p ps=1.63u w=0.42u l=0.13u
X2170 VGND.t32 sg13cmos5l_dfrbpq_1_13.RESET_B.t6 a_4106_870# VGND.t1617 sg13_lv_nmos ad=79.8f pd=0.8u as=37.8f ps=0.6u w=0.42u l=0.13u
X2171 sg13cmos5l_dfrbpq_1_0.CLK a_27195_3514# VGND.t58 VGND.t266 sg13_lv_nmos ad=0.1406p pd=1.12u as=0.1406p ps=1.12u w=0.74u l=0.13u
X2172 VPWR.t91 sg13cmos5l_dfrbpq_1_21.RESET_B.t2 a_4012_2382# VPWR.t10 sg13_lv_pmos ad=1.4003p pd=8.92u as=79.8f ps=0.8u w=0.42u l=0.13u
X2173 a_6862_8430# a_7103_8700# a_6391_8394# VGND.t1243 sg13_lv_nmos ad=0.1428p pd=1.52u as=0.12665p ps=1.145u w=0.42u l=0.13u
X2174 a_25797_7691# sg13cmos5l_dfrbpq_1_53.CLK VPWR.t2 VPWR.t2 sg13_lv_pmos ad=0.4088p pd=2.97u as=1.31957p ps=8.38u w=1.12u l=0.13u
X2175 sg13cmos5l_dfrbpq_1_7.Q a_26826_3144# VPWR.t230 VPWR.t10 sg13_lv_pmos ad=0.3808p pd=2.92u as=0.2128p ps=1.5u w=1.12u l=0.13u
X2176 a_6972_8394# a_7103_8700# a_6391_8394# VPWR.t0 sg13_lv_pmos ad=0.34p pd=2.68u as=0.2048p ps=1.63u w=1u l=0.13u
X2177 VGND.t286 sg13cmos5l_and2_1_1.X a_23835_8050# VGND.t1265 sg13_lv_nmos ad=0.1406p pd=1.12u as=0.1406p ps=1.12u w=0.74u l=0.13u
X2178 sg13cmos5l_dfrbpq_1_58.RESET_B a_2920_6956# VGND.t278 VGND.t277 sg13_lv_nmos ad=0.2886p pd=2.26u as=0.14875p ps=1.16u w=0.74u l=0.13u
X2179 a_20782_7233# a_20524_6918# VPWR.t2 VPWR.t2 sg13_lv_pmos ad=93.45f pd=0.865u as=1.34765p ps=8.56u w=0.42u l=0.13u
X2180 sg13cmos5l_xnor2_1_1.Y a_17472_1671# a_17621_2002# VGND.t153 sg13_lv_nmos ad=0.2516p pd=2.16u as=0.1406p ps=1.12u w=0.74u l=0.13u
X2181 VGND.t150 a_3790_1899# sg13cmos5l_dlygate4sd3_1_19.X VGND.t149 sg13_lv_nmos ad=0.1426p pd=1.16u as=0.2516p ps=2.16u w=0.74u l=0.13u
X2182 VPWR.t2 a_26639_8041# a_26896_7922# VPWR.t2 sg13_lv_pmos ad=1.34765p pd=8.56u as=79.8f ps=0.8u w=0.42u l=0.13u
X2183 a_19642_6132# sg13cmos5l_dfrbpq_1_39.Q VGND.t145 VGND.t1413 sg13_lv_nmos ad=0.1428p pd=1.52u as=79.8f ps=0.8u w=0.42u l=0.13u
X2184 VGND.t133 sg13cmos5l_buf_8_2.X a_18826_4620# VGND.t779 sg13_lv_nmos ad=0.1406p pd=1.12u as=0.1406p ps=1.12u w=0.74u l=0.13u
X2185 a_7822_2070# a_8063_1603# a_7351_1596# VGND.t225 sg13_lv_nmos ad=0.1428p pd=1.52u as=0.12665p ps=1.145u w=0.42u l=0.13u
X2186 a_16666_2350# sg13cmos5l_dfrbpq_1_59.Q VPWR.t350 VPWR.t10 sg13_lv_pmos ad=0.1428p pd=1.52u as=0.1523p ps=1.38u w=0.42u l=0.13u
X2187 VPWR.t1302 a_10112_2557# sg13cmos5l_dfrbpq_1_22.Q VPWR.t10 sg13_lv_pmos ad=0.2128p pd=1.5u as=0.3808p ps=2.92u w=1.12u l=0.13u
X2188 a_28174_8619# a_28289_8620# VGND.t73 VGND.t72 sg13_lv_nmos ad=0.1428p pd=1.52u as=0.1426p ps=1.16u w=0.42u l=0.5u
X2189 VPWR.t944 a_14235_6922# sg13cmos5l_buf_8_10.A VPWR.t2 sg13_lv_pmos ad=0.2128p pd=1.5u as=0.2128p ps=1.5u w=1.12u l=0.13u
X2190 a_24612_6172# a_24586_6136# VPWR.t221 VPWR.t7 sg13_lv_pmos ad=0.34p pd=2.68u as=0.36237p ps=2.605u w=1u l=0.13u
X2191 VPWR.t601 a_13862_4656# a_13974_4680# VPWR.t43 sg13_lv_pmos ad=0.2254p pd=1.53u as=0.34p ps=2.68u w=1u l=0.5u
X2192 VPWR.t105 a_11567_1993# a_11824_1874# VPWR.t15 sg13_lv_pmos ad=1.50275p pd=9.57u as=79.8f ps=0.8u w=0.42u l=0.13u
X2193 VPWR.t91 sg13cmos5l_dfrbpq_1_55.RESET_B a_10444_3582# VPWR.t10 sg13_lv_pmos ad=1.4003p pd=8.92u as=79.8f ps=0.8u w=0.42u l=0.13u
X2194 a_4951_4620# a_5511_4743# a_5422_4779# VPWR.t43 sg13_lv_pmos ad=0.2048p pd=1.63u as=93.45f ps=0.865u w=0.42u l=0.13u
X2195 a_10308_1636# a_10282_1600# VGND.t478 VGND.t477 sg13_lv_nmos ad=0.2516p pd=2.16u as=0.1626p ps=1.415u w=0.74u l=0.13u
X2196 VPWR.t195 a_22138_1596# a_21857_1898# VPWR.t15 sg13_lv_pmos ad=0.1523p pd=1.38u as=0.34p ps=2.68u w=1u l=0.5u
X2197 VPWR.t672 a_6165_7727# a_5244_8041# VPWR.t2 sg13_lv_pmos ad=0.36237p pd=2.605u as=0.34p ps=2.68u w=1u l=0.13u
X2198 a_8768_6427# sg13cmos5l_dfrbpq_1_58.RESET_B a_8905_6516# VGND.t942 sg13_lv_nmos ad=0.2176p pd=1.96u as=0.1216p ps=1.02u w=0.64u l=0.13u
X2199 a_15972_6172# a_16491_6179# a_17231_6529# VGND.t764 sg13_lv_nmos ad=0.3473p pd=2.71u as=0.12665p ps=1.145u w=0.74u l=0.13u
X2200 VGND.t137 VPWR.t79 VGND.t137 VGND.t1527 sg13_lv_nmos ad=79.8f pd=0.8u as=0 ps=0 w=0.42u l=1u
X2201 VPWR.t1105 sg13cmos5l_nor4_2_4.D a_16535_8821# VPWR.t0 sg13_lv_pmos ad=0.1428p pd=1.52u as=79.8f ps=0.8u w=0.42u l=0.13u
X2202 a_10534_2057# sg13cmos5l_dfrbpq_1_13.RESET_B.t8 VGND.t478 VGND.t1213 sg13_lv_nmos ad=37.8f pd=0.6u as=0.1701p ps=1.65u w=0.42u l=0.13u
X2203 a_6698_3894# a_6391_3858# a_6604_3894# VGND.t193 sg13_lv_nmos ad=37.8f pd=0.6u as=0.1428p ps=1.52u w=0.42u l=0.13u
X2204 sg13cmos5l_dfrbpq_1_2.CLK a_18826_4620# VGND.t133 VGND.t1140 sg13_lv_nmos ad=0.1406p pd=1.12u as=0.1406p ps=1.12u w=0.74u l=0.13u
X2205 VPWR.t280 a_27195_3514# sg13cmos5l_dfrbpq_1_0.CLK VPWR.t10 sg13_lv_pmos ad=0.2128p pd=1.5u as=0.2128p ps=1.5u w=1.12u l=0.13u
X2206 a_20102_3894# a_20907_4016# a_20362_4117# VPWR.t43 sg13_lv_pmos ad=0.1428p pd=1.52u as=79.8f ps=0.8u w=0.42u l=0.13u
X2207 sg13cmos5l_nand3_1_3.Y sg13cmos5l_nand3_1_3.B VPWR.t485 VPWR.t10 sg13_lv_pmos ad=0.2128p pd=1.5u as=0.2128p ps=1.5u w=1.12u l=0.13u
X2208 VPWR.t887 sg13cmos5l_buf_8_11.A a_18922_7644# VPWR.t2 sg13_lv_pmos ad=0.2128p pd=1.5u as=0.2128p ps=1.5u w=1.12u l=0.13u
X2209 a_11986_870# sg13cmos5l_dfrbpq_1_13.RESET_B.t1 VGND.t119 VGND.t606 sg13_lv_nmos ad=37.8f pd=0.6u as=79.8f ps=0.8u w=0.42u l=0.13u
X2210 VPWR.t158 en[4].t0 a_1384_8468# VPWR.t0 sg13_lv_pmos ad=0.2114p pd=1.54u as=0.2856p ps=2.36u w=0.84u l=0.13u
X2211 VGND.t756 sg13cmos5l_xnor2_1_3.B a_18479_874# VGND.t755 sg13_lv_nmos ad=0.1898p pd=1.36u as=0.1406p ps=1.12u w=0.74u l=0.13u
X2212 VGND.t357 a_8763_8434# sg13cmos5l_dfrbpq_1_32.CLK VGND.t89 sg13_lv_nmos ad=0.1406p pd=1.12u as=0.1406p ps=1.12u w=0.74u l=0.13u
X2213 sg13cmos5l_xor2_1_2.A a_14166_8498# VPWR.t258 VPWR.t0 sg13_lv_pmos ad=0.4256p pd=3u as=0.2254p ps=1.53u w=1.12u l=0.13u
X2214 VPWR.t1383 VGND.t96 VPWR.t1382 VPWR.t7 sg13_lv_pmos ad=0.34p pd=2.68u as=0 ps=0 w=1u l=1u
X2215 a_20676_3907# a_20388_4212# a_20614_3907# VGND.t105 sg13_lv_nmos ad=0.1428p pd=1.52u as=37.8f ps=0.6u w=0.42u l=0.13u
X2216 sg13cmos5l_nor4_2_5.C a_2166_8498# VGND.t117 VGND.t116 sg13_lv_nmos ad=0.2516p pd=2.16u as=0.1426p ps=1.16u w=0.74u l=0.13u
X2217 VPWR.t132 a_11733_4703# a_10812_5017# VPWR.t43 sg13_lv_pmos ad=0.36237p pd=2.605u as=0.34p ps=2.68u w=1u l=0.13u
X2218 sg13cmos5l_dfrbpq_1_46.CLK a_18922_7644# VPWR.t907 VPWR.t2 sg13_lv_pmos ad=0.2128p pd=1.5u as=0.2128p ps=1.5u w=1.12u l=0.13u
X2219 a_27225_5721# a_26283_5528# a_27023_5483# VPWR.t7 sg13_lv_pmos ad=93.45f pd=0.865u as=0.2048p ps=1.63u w=0.42u l=0.13u
X2220 VPWR.t418 sg13cmos5l_buf_1_1.X.t13 a_18538_3112# VPWR.t10 sg13_lv_pmos ad=0.1563p pd=1.22u as=0.147p ps=1.54u w=0.42u l=0.13u
X2221 sg13cmos5l_dfrbpq_1_56.CLK a_18363_6922# VPWR.t872 VPWR.t2 sg13_lv_pmos ad=0.2128p pd=1.5u as=0.2128p ps=1.5u w=1.12u l=0.13u
X2222 VPWR.t214 a_16320_1671# sg13cmos5l_xnor2_1_2.Y VPWR.t15 sg13_lv_pmos ad=0.3808p pd=2.92u as=0.2408p ps=1.55u w=1.12u l=0.13u
X2223 VPWR.t469 a_13664_1919# sg13cmos5l_dfrbpq_1_55.Q VPWR.t15 sg13_lv_pmos ad=0.2128p pd=1.5u as=0.3808p ps=2.92u w=1.12u l=0.13u
X2224 a_16078_5094# a_16319_4627# a_15607_4620# VGND.t1173 sg13_lv_nmos ad=0.1428p pd=1.52u as=0.12665p ps=1.145u w=0.42u l=0.13u
X2225 sg13cmos5l_dfrbpq_1_11.CLK a_13563_874# VGND.t365 VGND.t513 sg13_lv_nmos ad=0.1406p pd=1.12u as=0.1406p ps=1.12u w=0.74u l=0.13u
X2226 a_10791_2600# a_10943_2652# VGND.t77 VGND.t1456 sg13_lv_nmos ad=0.2516p pd=2.16u as=3.25012p ps=20.49u w=0.74u l=0.13u
X2227 a_15333_4192# sg13cmos5l_nor3_1_4.A VPWR.t922 VPWR.t43 sg13_lv_pmos ad=0.2464p pd=1.56u as=0.3808p ps=2.92u w=1.12u l=0.13u
X2228 sg13cmos5l_dfrbpq_1_15.D a_2016_7233# a_2165_6922# VGND.t292 sg13_lv_nmos ad=0.2516p pd=2.16u as=0.1406p ps=1.12u w=0.74u l=0.13u
X2229 a_6564_6931# a_6795_7040# a_6250_7141# VGND.t1105 sg13_lv_nmos ad=0.2373p pd=1.97u as=79.8f ps=0.8u w=0.42u l=0.13u
X2230 a_26135_1679# sg13cmos5l_buf_1_1.X.t3 VPWR.t151 VPWR.t15 sg13_lv_pmos ad=79.8f pd=0.8u as=0.36237p ps=2.605u w=0.42u l=0.13u
X2231 VPWR.t79 sg13cmos5l_buf_1_0.X.t1 a_23661_2428# VPWR.t10 sg13_lv_pmos ad=0.1918p pd=1.5u as=0.1596p ps=1.22u w=0.84u l=0.13u
X2232 VGND.t50 sg13cmos5l_dfrbpq_1_11.CLK a_10943_3115# VGND.t1348 sg13_lv_nmos ad=3.63467p pd=22.73u as=0.2516p ps=2.16u w=0.74u l=0.13u
X2233 a_8042_3144# sg13cmos5l_dlygate4sd3_1_21.X sg13cmos5l_nor4_2_3.Y VPWR.t10 sg13_lv_pmos ad=0.3808p pd=2.92u as=0.2128p ps=1.5u w=1.12u l=0.13u
X2234 sg13cmos5l_dfrbpq_1_7.Q a_26826_3144# VGND.t58 VGND.t1357 sg13_lv_nmos ad=0.2516p pd=2.16u as=0.1406p ps=1.12u w=0.74u l=0.13u
X2235 a_12386_2382# sg13cmos5l_dfrbpq_1_55.RESET_B VGND.t393 VGND.t566 sg13_lv_nmos ad=60.89999f pd=0.71u as=0.1626p ps=1.415u w=0.42u l=0.13u
X2236 VGND.t121 en[0] a_1000_8468# VGND.t1548 sg13_lv_nmos ad=0.14875p pd=1.16u as=0.187p ps=1.78u w=0.55u l=0.13u
X2237 VGND.t453 sg13cmos5l_nor4_2_5.D sg13cmos5l_nor4_2_5.Y VGND.t454 sg13_lv_nmos ad=0.3293p pd=1.63u as=0.1406p ps=1.12u w=0.74u l=0.13u
X2238 VPWR.t905 a_18922_7644# sg13cmos5l_dfrbpq_1_46.CLK VPWR.t2 sg13_lv_pmos ad=0.2128p pd=1.5u as=0.2128p ps=1.5u w=1.12u l=0.13u
X2239 VGND.t365 sg13cmos5l_buf_8_3.A a_13563_874# VGND.t770 sg13_lv_nmos ad=0.1406p pd=1.12u as=0.1406p ps=1.12u w=0.74u l=0.13u
X2240 a_14630_3898# a_14360_3898# VPWR.t323 VPWR.t43 sg13_lv_pmos ad=0.34p pd=2.68u as=0.1523p ps=1.38u w=1u l=0.5u
X2241 VPWR.t732 sg13cmos5l_dfrbpq_1_0.D a_28958_2704# VPWR.t10 sg13_lv_pmos ad=0.36p pd=2.72u as=0.1225p ps=1.245u w=1u l=0.13u
X2242 a_1233_5728# sg13cmos5l_dlygate4sd3_1_19.X VPWR.t637 VPWR.t7 sg13_lv_pmos ad=0.1225p pd=1.245u as=0.36p ps=2.72u w=1u l=0.13u
X2243 sg13cmos5l_xnor2_1_9.A sg13cmos5l_nor3_1_2.Y VPWR.t858 VPWR.t2 sg13_lv_pmos ad=0.2128p pd=1.5u as=0.3808p ps=2.92u w=1.12u l=0.13u
X2244 a_15876_6918# sg13cmos5l_nor3_1_4.B a_15782_6918# VGND.t95 sg13_lv_nmos ad=60.89999f pd=0.71u as=0.1428p ps=1.52u w=0.42u l=0.13u
X2245 a_25881_2697# a_24939_2504# a_25679_2459# VPWR.t10 sg13_lv_pmos ad=93.45f pd=0.865u as=0.2048p ps=1.63u w=0.42u l=0.13u
X2246 sg13cmos5l_nor4_2_5.D a_3990_7704# VPWR.t122 VPWR.t2 sg13_lv_pmos ad=0.4256p pd=3u as=0.2254p ps=1.53u w=1.12u l=0.13u
X2247 a_20676_6593# a_20388_6172# a_20614_6593# VGND.t1201 sg13_lv_nmos ad=0.1428p pd=1.52u as=37.8f ps=0.6u w=0.42u l=0.13u
X2248 a_24815_5410# sg13cmos5l_nand3_1_2.Y VGND.t203 VGND.t142 sg13_lv_nmos ad=0.2516p pd=2.16u as=0.1898p ps=1.36u w=0.74u l=0.13u
X2249 a_7744_3144# sg13cmos5l_dfrbpq_1_12.D a_8042_3144# VPWR.t10 sg13_lv_pmos ad=0.3808p pd=2.92u as=0.2128p ps=1.5u w=1.12u l=0.13u
X2250 VPWR.t149 sg13cmos5l_buf_1_1.X.t15 a_20102_3894# VPWR.t43 sg13_lv_pmos ad=0.36237p pd=2.605u as=79.8f ps=0.8u w=0.42u l=0.13u
X2251 VGND.t145 a_18363_6922# sg13cmos5l_dfrbpq_1_56.CLK VGND.t984 sg13_lv_nmos ad=0.1406p pd=1.12u as=0.1406p ps=1.12u w=0.74u l=0.13u
X2252 VPWR.t286 a_27023_8507# a_27690_8728# VPWR.t0 sg13_lv_pmos ad=0.2128p pd=1.5u as=0.3864p ps=2.93u w=1.12u l=0.13u
X2253 sg13cmos5l_dfrbpq_1_32.CLK a_8763_8434# VPWR.t1414 VPWR.t0 sg13_lv_pmos ad=0.2128p pd=1.5u as=0.2128p ps=1.5u w=1.12u l=0.13u
X2254 VPWR.t6 sg13cmos5l_dfrbpq_1_53.RESET_B.t8 a_25094_8118# VPWR.t2 sg13_lv_pmos ad=0.36237p pd=2.605u as=79.8f ps=0.8u w=0.42u l=0.13u
X2255 a_25478_5094# a_26283_4667# a_25738_4624# VPWR.t43 sg13_lv_pmos ad=0.1428p pd=1.52u as=79.8f ps=0.8u w=0.42u l=0.13u
X2256 a_7822_1755# a_7564_2070# VPWR.t105 VPWR.t15 sg13_lv_pmos ad=93.45f pd=0.865u as=1.50275p ps=9.57u w=0.42u l=0.13u
X2257 VGND.t50 sg13cmos5l_xnor2_1_6.B sg13cmos5l_nor4_2_3.Y VGND.t1550 sg13_lv_nmos ad=0.1406p pd=1.12u as=0.1406p ps=1.12u w=0.74u l=0.13u
X2258 VPWR.t33 VGND.t40 VPWR.t32 VPWR.t0 sg13_lv_pmos ad=0.34p pd=2.68u as=0 ps=0 w=1u l=1u
X2259 sg13cmos5l_buf_1_5.A a_9640_7680# VGND.t1014 VGND.t356 sg13_lv_nmos ad=0.2886p pd=2.26u as=0.14875p ps=1.16u w=0.74u l=0.13u
X2260 sg13cmos5l_dfrbpq_1_2.CLK a_18826_4620# VGND.t133 VGND.t1136 sg13_lv_nmos ad=0.1406p pd=1.12u as=0.1406p ps=1.12u w=0.74u l=0.13u
X2261 VPWR.t108 sg13cmos5l_dfrbpq_1_13.RESET_B.t8 a_10022_2070# VPWR.t15 sg13_lv_pmos ad=0.36237p pd=2.605u as=79.8f ps=0.8u w=0.42u l=0.13u
X2262 VPWR.t7 a_21904_6410# a_21849_6291# VPWR.t7 sg13_lv_pmos ad=1.46065p pd=9.335u as=93.45f ps=0.865u w=0.42u l=0.13u
X2263 VPWR.t653 sg13cmos5l_dfrbpq_1_23.D a_7799_4285# VPWR.t43 sg13_lv_pmos ad=0.1428p pd=1.52u as=79.8f ps=0.8u w=0.42u l=0.13u
X2264 VGND.t143 a_21647_5483# a_22314_5704# VGND.t142 sg13_lv_nmos ad=0.1406p pd=1.12u as=0.2516p ps=2.16u w=0.74u l=0.13u
X2265 VGND.t73 a_28174_8619# sg13cmos5l_nor4_2_7.D VGND.t72 sg13_lv_nmos ad=0.1426p pd=1.16u as=0.2516p ps=2.16u w=0.74u l=0.13u
X2266 sg13cmos5l_dlygate4sd3_1_55.A a_22314_6168# VPWR.t8 VPWR.t7 sg13_lv_pmos ad=0.3808p pd=2.92u as=0.2128p ps=1.5u w=1.12u l=0.13u
X2267 VPWR.t92 a_25679_2459# a_26346_2680# VPWR.t10 sg13_lv_pmos ad=0.2128p pd=1.5u as=0.3864p ps=2.93u w=1.12u l=0.13u
X2268 a_6250_2350# sg13cmos5l_buf_8_3.A VPWR.t700 VPWR.t10 sg13_lv_pmos ad=0.3808p pd=2.92u as=0.2128p ps=1.5u w=1.12u l=0.13u
X2269 VPWR.t1 sg13cmos5l_dfrbpq_1_56.RESET_B a_15340_8430# VPWR.t0 sg13_lv_pmos ad=1.8922p pd=12.27u as=79.8f ps=0.8u w=0.42u l=0.13u
X2270 VPWR.t2 a_16367_8041# a_16624_7922# VPWR.t2 sg13_lv_pmos ad=1.34765p pd=8.56u as=79.8f ps=0.8u w=0.42u l=0.13u
X2271 a_23652_6918# sg13cmos5l_nor4_2_7.B a_23558_6918# VGND.t64 sg13_lv_nmos ad=60.89999f pd=0.71u as=0.1428p ps=1.52u w=0.42u l=0.13u
X2272 VPWR.t1319 a_27963_6538# sg13cmos5l_dfrbpq_1_53.CLK VPWR.t7 sg13_lv_pmos ad=0.3864p pd=2.93u as=0.2128p ps=1.5u w=1.12u l=0.13u
X2273 a_13860_2700# a_13834_2605# VGND.t324 VGND.t6 sg13_lv_nmos ad=0.2516p pd=2.16u as=0.1626p ps=1.415u w=0.74u l=0.13u
X2274 VGND.t325 sg13cmos5l_buf_1_0.X.t15 a_20196_8430# VGND.t0 sg13_lv_nmos ad=0.1626p pd=1.415u as=60.89999f ps=0.71u w=0.42u l=0.13u
X2275 VGND.t83 VPWR.t1463 VGND.t1493 VGND.t1492 sg13_lv_nmos ad=79.8f pd=0.8u as=0 ps=0 w=0.42u l=1u
X2276 sg13cmos5l_dfrbpq_1_12.Q a_12234_1632# VGND.t393 VGND.t818 sg13_lv_nmos ad=0.2516p pd=2.16u as=0.1406p ps=1.12u w=0.74u l=0.13u
X2277 VPWR.t1349 sg13cmos5l_buf_8_4.A a_8763_8434# VPWR.t0 sg13_lv_pmos ad=0.2128p pd=1.5u as=0.2128p ps=1.5u w=1.12u l=0.13u
X2278 VPWR.t1375 a_7893_1028# a_6972_834# VPWR.t15 sg13_lv_pmos ad=0.36237p pd=2.605u as=0.34p ps=2.68u w=1u l=0.13u
X2279 VGND.t572 VPWR.t1454 VGND.t572 VGND.t1515 sg13_lv_nmos ad=0.1428p pd=1.52u as=0 ps=0 w=0.42u l=1u
X2280 a_6250_3108# sg13cmos5l_buf_8_4.A VGND.t50 VGND.t674 sg13_lv_nmos ad=0.1406p pd=1.12u as=0.1406p ps=1.12u w=0.74u l=0.13u
X2281 VPWR.t79 VGND.t137 VPWR.t79 VPWR.t10 sg13_lv_pmos ad=0.19p pd=1.38u as=0 ps=0 w=1u l=1u
X2282 VGND.t50 sg13cmos5l_xnor2_1_6.A sg13cmos5l_nor4_2_3.Y VGND.t1432 sg13_lv_nmos ad=0.3293p pd=1.63u as=0.1406p ps=1.12u w=0.74u l=0.13u
X2283 VGND.t30 VPWR.t1462 VGND.t1490 VGND.t30 sg13_lv_nmos ad=79.8f pd=0.8u as=0 ps=0 w=0.42u l=1u
X2284 VGND.t119 VPWR.t28 VGND.t119 VGND.t1538 sg13_lv_nmos ad=0.1428p pd=1.52u as=0 ps=0 w=0.42u l=1u
X2285 sg13cmos5l_dfrbpq_1_2.Q a_21354_1168# VGND.t235 VGND.t1172 sg13_lv_nmos ad=0.2516p pd=2.16u as=0.1406p ps=1.12u w=0.74u l=0.13u
X2286 a_6693_6897# sg13cmos5l_dfrbpq_1_32.CLK VGND.t25 VGND.t1208 sg13_lv_nmos ad=0.2516p pd=2.16u as=3.31142p ps=20.535u w=0.74u l=0.13u
X2287 VGND.t179 sg13cmos5l_dlygate4sd3_1_50.A a_13592_4697# VGND.t1457 sg13_lv_nmos ad=79.8f pd=0.8u as=0.1428p ps=1.52u w=0.42u l=0.13u
X2288 VPWR.t365 a_3680_2557# sg13cmos5l_dfrbpq_1_21.Q VPWR.t10 sg13_lv_pmos ad=0.2128p pd=1.5u as=0.3808p ps=2.92u w=1.12u l=0.13u
X2289 VGND.t73 a_28186_7644# a_27905_7946# VGND.t291 sg13_lv_nmos ad=79.8f pd=0.8u as=0.1428p ps=1.52u w=0.42u l=0.5u
X2290 a_1870_1899# a_1985_1898# VPWR.t94 VPWR.t15 sg13_lv_pmos ad=0.34p pd=2.68u as=0.2254p ps=1.53u w=1u l=0.5u
X2291 sg13cmos5l_nand3_1_2.C sg13cmos5l_dlygate4sd3_1_17.X VGND.t197 VGND.t1638 sg13_lv_nmos ad=0.1694p pd=1.21u as=0.1463p ps=1.15u w=0.77u l=0.13u
X2292 a_25188_3569# a_24900_3148# a_25126_3569# VGND.t1180 sg13_lv_nmos ad=0.1428p pd=1.52u as=37.8f ps=0.6u w=0.42u l=0.13u
X2293 a_18660_2395# a_18891_2504# a_18346_2605# VGND.t7 sg13_lv_nmos ad=0.2373p pd=1.97u as=79.8f ps=0.8u w=0.42u l=0.13u
X2294 VPWR.t639 sg13cmos5l_dlygate4sd3_1_19.X a_5207_2773# VPWR.t10 sg13_lv_pmos ad=0.1428p pd=1.52u as=79.8f ps=0.8u w=0.42u l=0.13u
X2295 VGND.t58 a_26416_3386# a_26065_3505# VGND.t1144 sg13_lv_nmos ad=79.8f pd=0.8u as=0.1428p ps=1.52u w=0.42u l=0.13u
X2296 a_25738_8653# a_26181_8409# a_26121_8821# VPWR.t0 sg13_lv_pmos ad=79.8f pd=0.8u as=63f ps=0.72u w=0.42u l=0.13u
X2297 VGND.t172 sg13cmos5l_buf_1_4.A.t1 a_17032_908# VGND.t620 sg13_lv_nmos ad=0.14875p pd=1.16u as=0.187p ps=1.78u w=0.55u l=0.13u
X2298 a_25092_1188# a_25611_992# a_26351_947# VGND.t43 sg13_lv_nmos ad=0.3473p pd=2.71u as=0.12665p ps=1.145u w=0.74u l=0.13u
X2299 a_5143_5370# a_5703_5624# a_5724_5370# VGND.t255 sg13_lv_nmos ad=0.12665p pd=1.145u as=0.3473p ps=2.71u w=0.74u l=0.13u
X2300 a_10022_870# a_10827_992# a_10282_1093# VPWR.t15 sg13_lv_pmos ad=0.1428p pd=1.52u as=79.8f ps=0.8u w=0.42u l=0.13u
X2301 a_6391_834# a_6951_1088# a_6862_1185# VPWR.t15 sg13_lv_pmos ad=0.2048p pd=1.63u as=93.45f ps=0.865u w=0.42u l=0.13u
X2302 a_6167_1679# sg13cmos5l_dlygate4sd3_1_21.X a_6914_2070# VGND.t546 sg13_lv_nmos ad=0.1428p pd=1.52u as=60.89999f ps=0.71u w=0.42u l=0.13u
X2303 VGND.t54 sg13cmos5l_and2_1_0.X a_21435_3514# VGND.t53 sg13_lv_nmos ad=0.1406p pd=1.12u as=0.1406p ps=1.12u w=0.74u l=0.13u
X2304 a_26128_6410# a_25871_6529# a_26290_6606# VGND.t562 sg13_lv_nmos ad=0.1428p pd=1.52u as=37.8f ps=0.6u w=0.42u l=0.13u
X2305 a_24902_3894# a_25707_4016# a_25162_4117# VPWR.t43 sg13_lv_pmos ad=0.1428p pd=1.52u as=79.8f ps=0.8u w=0.42u l=0.13u
X2306 VPWR.t30 VGND.t40 VPWR.t29 VPWR.t0 sg13_lv_pmos ad=0.34p pd=2.68u as=0 ps=0 w=1u l=1u
X2307 a_18346_2605# a_18789_2361# a_18729_2773# VPWR.t10 sg13_lv_pmos ad=79.8f pd=0.8u as=63f ps=0.72u w=0.42u l=0.13u
X2308 a_1870_2571# a_1985_2572# VPWR.t1358 VPWR.t10 sg13_lv_pmos ad=0.34p pd=2.68u as=0.2254p ps=1.53u w=1u l=0.5u
X2309 a_4951_4620# a_5511_4743# a_5532_5017# VGND.t30 sg13_lv_nmos ad=0.12665p pd=1.145u as=0.3473p ps=2.71u w=0.74u l=0.13u
X2310 a_6250_7141# a_6693_6897# a_6633_7309# VPWR.t2 sg13_lv_pmos ad=79.8f pd=0.8u as=63f ps=0.72u w=0.42u l=0.13u
X2311 VGND.t45 a_27695_6995# a_28362_7216# VGND.t1261 sg13_lv_nmos ad=0.1406p pd=1.12u as=0.2516p ps=2.16u w=0.74u l=0.13u
X2312 a_2016_5721# sg13cmos5l_nand3_1_1.Y VPWR.t1101 VPWR.t7 sg13_lv_pmos ad=0.1596p pd=1.22u as=0.4536p ps=2.76u w=0.84u l=0.13u
X2313 sg13cmos5l_nand3_1_0.Y sg13cmos5l_nand3_1_0.A VPWR.t191 VPWR.t15 sg13_lv_pmos ad=0.3808p pd=2.92u as=0.2128p ps=1.5u w=1.12u l=0.13u
X2314 a_10308_5724# a_10827_5528# a_11567_5483# VGND.t1185 sg13_lv_nmos ad=0.3473p pd=2.71u as=0.12665p ps=1.145u w=0.74u l=0.13u
X2315 a_3590_3894# a_4395_4016# a_3850_4117# VPWR.t43 sg13_lv_pmos ad=0.1428p pd=1.52u as=79.8f ps=0.8u w=0.42u l=0.13u
X2316 a_16329_6215# a_15972_6172# VPWR.t390 VPWR.t7 sg13_lv_pmos ad=63f pd=0.72u as=0.1563p ps=1.22u w=0.42u l=0.13u
X2317 a_10702_4779# a_10444_5094# VPWR.t43 VPWR.t43 sg13_lv_pmos ad=93.45f pd=0.865u as=1.3927p ps=8.9u w=0.42u l=0.13u
X2318 VPWR.t6 a_23835_8050# sg13cmos5l_buf_8_11.A VPWR.t2 sg13_lv_pmos ad=0.2128p pd=1.5u as=0.2128p ps=1.5u w=1.12u l=0.13u
X2319 a_25936_2602# sg13cmos5l_buf_1_1.X.t7 VPWR.t91 VPWR.t10 sg13_lv_pmos ad=79.8f pd=0.8u as=1.4003p ps=8.92u w=0.42u l=0.13u
X2320 a_7430_2382# sg13cmos5l_xnor2_1_6.A VPWR.t1278 VPWR.t10 sg13_lv_pmos ad=79.8f pd=0.8u as=0.1428p ps=1.52u w=0.42u l=0.13u
X2321 a_18921_3191# a_18564_3148# VPWR.t418 VPWR.t10 sg13_lv_pmos ad=63f pd=0.72u as=0.1563p ps=1.22u w=0.42u l=0.13u
X2322 a_20388_5724# a_20362_5629# VGND.t133 VGND.t1337 sg13_lv_nmos ad=0.2516p pd=2.16u as=0.1626p ps=1.415u w=0.74u l=0.13u
X2323 a_16260_6593# a_15972_6172# a_16198_6593# VGND.t414 sg13_lv_nmos ad=0.1428p pd=1.52u as=37.8f ps=0.6u w=0.42u l=0.13u
X2324 a_25476_3907# a_25188_4212# a_25414_3907# VGND.t761 sg13_lv_nmos ad=0.1428p pd=1.52u as=37.8f ps=0.6u w=0.42u l=0.13u
X2325 a_10538_3582# a_10231_3108# a_10444_3582# VGND.t1441 sg13_lv_nmos ad=37.8f pd=0.6u as=0.1428p ps=1.52u w=0.42u l=0.13u
X2326 a_11733_7727# a_10791_7767# a_11594_7960# VGND.t457 sg13_lv_nmos ad=79.8f pd=0.8u as=0.2373p ps=1.97u w=0.42u l=0.13u
X2327 VGND.t17 a_21742_1899# sg13cmos5l_dfrbpq_1_2.D VGND.t591 sg13_lv_nmos ad=0.1426p pd=1.16u as=0.2516p ps=2.16u w=0.74u l=0.13u
X2328 VPWR.t257 a_21934_1059# sg13cmos5l_nor3_1_0.A VPWR.t15 sg13_lv_pmos ad=0.2254p pd=1.53u as=0.4256p ps=3u w=1.12u l=0.13u
X2329 VPWR.t1335 a_9915_3898# sg13cmos5l_buf_8_3.A VPWR.t43 sg13_lv_pmos ad=0.2128p pd=1.5u as=0.2128p ps=1.5u w=1.12u l=0.13u
X2330 VPWR.t302 a_28186_7644# a_27905_7946# VPWR.t2 sg13_lv_pmos ad=0.1523p pd=1.38u as=0.34p ps=2.68u w=1u l=0.5u
X2331 a_20362_5629# a_20805_5385# a_20102_5406# VGND.t1545 sg13_lv_nmos ad=79.8f pd=0.8u as=0.1296p ps=1.52u w=0.42u l=0.13u
X2332 a_23835_8050# sg13cmos5l_and2_1_1.X VPWR.t6 VPWR.t2 sg13_lv_pmos ad=0.2128p pd=1.5u as=0.2128p ps=1.5u w=1.12u l=0.13u
X2333 VGND.t558 a_10112_6455# sg13cmos5l_dlygate4sd3_1_28.A VGND.t1677 sg13_lv_nmos ad=0.1406p pd=1.12u as=0.2516p ps=2.16u w=0.74u l=0.13u
X2334 VGND.t30 a_20805_5385# a_20907_5528# VGND.t1546 sg13_lv_nmos ad=3.5351p pd=22.08u as=0.2516p ps=2.16u w=0.74u l=0.13u
X2335 a_11986_5406# sg13cmos5l_dfrbpq_1_57.RESET_B.t2 VGND.t83 VGND.t792 sg13_lv_nmos ad=37.8f pd=0.6u as=79.8f ps=0.8u w=0.42u l=0.13u
X2336 a_18826_4620# sg13cmos5l_buf_8_2.X VPWR.t711 VPWR.t43 sg13_lv_pmos ad=0.2128p pd=1.5u as=0.2128p ps=1.5u w=1.12u l=0.13u
X2337 VPWR.t415 sg13cmos5l_buf_1_1.X.t10 a_18086_2382# VPWR.t10 sg13_lv_pmos ad=0.36237p pd=2.605u as=79.8f ps=0.8u w=0.42u l=0.13u
X2338 a_8133_2361# sg13cmos5l_dfrbpq_1_13.CLK VPWR.t91 VPWR.t10 sg13_lv_pmos ad=0.4088p pd=2.97u as=1.43285p ps=9.125u w=1.12u l=0.13u
X2339 VGND.t332 sg13cmos5l_nor4_2_4.D sg13cmos5l_nand3_1_1.B VGND.t95 sg13_lv_nmos ad=0.2516p pd=2.16u as=0.1406p ps=1.12u w=0.74u l=0.13u
X2340 a_15607_4620# a_16167_4743# a_16188_5017# VGND.t379 sg13_lv_nmos ad=0.12665p pd=1.145u as=0.3473p ps=2.71u w=0.74u l=0.13u
X2341 VGND.t106 a_19055_3971# a_19722_4192# VGND.t199 sg13_lv_nmos ad=0.1406p pd=1.12u as=0.2516p ps=2.16u w=0.74u l=0.13u
X2342 a_10308_1188# a_10282_1093# VPWR.t108 VPWR.t15 sg13_lv_pmos ad=0.34p pd=2.68u as=0.36237p ps=2.605u w=1u l=0.13u
X2343 a_8582_4656# a_8312_4697# VGND.t131 VGND.t791 sg13_lv_nmos ad=0.1428p pd=1.52u as=79.8f ps=0.8u w=0.42u l=0.5u
X2344 a_5301_2540# sg13cmos5l_dfrbpq_1_21.RESET_B.t1 VPWR.t668 VPWR.t10 sg13_lv_pmos ad=0.147p pd=1.54u as=0.1563p ps=1.22u w=0.42u l=0.13u
X2345 VPWR.t139 sg13cmos5l_dfrbpq_1_57.RESET_B.t10 a_14822_8118# VPWR.t2 sg13_lv_pmos ad=0.36237p pd=2.605u as=79.8f ps=0.8u w=0.42u l=0.13u
X2346 a_16294_6931# sg13cmos5l_dfrbpq_1_56.RESET_B VGND.t25 VGND.t827 sg13_lv_nmos ad=37.8f pd=0.6u as=0.1701p ps=1.65u w=0.42u l=0.13u
X2347 sg13cmos5l_buf_8_0.X a_15850_3862# VGND.t50 VGND.t1118 sg13_lv_nmos ad=0.1406p pd=1.12u as=0.1406p ps=1.12u w=0.74u l=0.13u
X2348 VGND.t286 sg13cmos5l_dlygate4sd3_1_6.X sg13cmos5l_nand3_1_2.A VGND.t1409 sg13_lv_nmos ad=0.3293p pd=1.63u as=0.1406p ps=1.12u w=0.74u l=0.13u
X2349 sg13cmos5l_dfrbpq_1_38.Q a_17898_6168# VPWR.t1028 VPWR.t7 sg13_lv_pmos ad=0.3808p pd=2.92u as=0.2128p ps=1.5u w=1.12u l=0.13u
X2350 a_19785_1261# a_19428_1188# VPWR.t145 VPWR.t15 sg13_lv_pmos ad=63f pd=0.72u as=0.1563p ps=1.22u w=0.42u l=0.13u
X2351 VGND.t133 sg13cmos5l_buf_8_0.X a_18843_5410# VGND.t182 sg13_lv_nmos ad=0.1406p pd=1.12u as=0.2553p ps=2.17u w=0.74u l=0.13u
X2352 VGND.t632 VPWR.t1459 VGND.t632 VGND.t1504 sg13_lv_nmos ad=0.1428p pd=1.52u as=0 ps=0 w=0.42u l=1u
X2353 VGND.t131 a_7594_5374# sg13cmos5l_buf_8_4.A VGND.t1163 sg13_lv_nmos ad=0.1406p pd=1.12u as=0.1406p ps=1.12u w=0.74u l=0.13u
X2354 VPWR.t231 a_19246_6435# sg13cmos5l_nor3_1_4.B VPWR.t7 sg13_lv_pmos ad=0.2254p pd=1.53u as=0.4256p ps=3u w=1.12u l=0.13u
X2355 VPWR.t1017 a_18826_4620# sg13cmos5l_dfrbpq_1_2.CLK VPWR.t43 sg13_lv_pmos ad=0.2128p pd=1.5u as=0.2128p ps=1.5u w=1.12u l=0.13u
X2356 VPWR.t227 sg13cmos5l_buf_1_4.X.t6 a_24902_3894# VPWR.t43 sg13_lv_pmos ad=0.36237p pd=2.605u as=79.8f ps=0.8u w=0.42u l=0.13u
X2357 a_1152_1185# sg13cmos5l_xnor2_1_6.A VPWR.t738 VPWR.t15 sg13_lv_pmos ad=0.1596p pd=1.22u as=0.4536p ps=2.76u w=0.84u l=0.13u
X2358 VPWR.t7 a_20805_6179# a_20907_6179# VPWR.t7 sg13_lv_pmos ad=1.46065p pd=9.335u as=0.3864p ps=2.93u w=1.12u l=0.13u
X2359 VPWR.t17 VGND.t150 VPWR.t16 VPWR.t15 sg13_lv_pmos ad=0.34p pd=2.68u as=0 ps=0 w=1u l=1u
X2360 sg13cmos5l_dlygate4sd3_1_5.A a_20298_2680# VPWR.t125 VPWR.t10 sg13_lv_pmos ad=0.3808p pd=2.92u as=0.2128p ps=1.5u w=1.12u l=0.13u
X2361 VGND.t117 a_2266_7644# a_1985_7946# VGND.t458 sg13_lv_nmos ad=79.8f pd=0.8u as=0.1428p ps=1.52u w=0.42u l=0.5u
X2362 sg13cmos5l_dfrbpq_1_53.RESET_B.t0 a_2920_7680# VPWR.t675 VPWR.t2 sg13_lv_pmos ad=0.42p pd=2.99u as=0.2114p ps=1.54u w=1.12u l=0.13u
X2363 a_28186_7644# sg13cmos5l_dlygate4sd3_1_47.A VPWR.t302 VPWR.t2 sg13_lv_pmos ad=0.1428p pd=1.52u as=0.1523p ps=1.38u w=0.42u l=0.13u
X2364 VGND.t286 VPWR.t6 VGND.t20 VGND.t1472 sg13_lv_nmos ad=0.1428p pd=1.52u as=0 ps=0 w=0.42u l=1u
X2365 VGND.t30 sg13cmos5l_dfrbpq_1_21.CLK a_5663_4627# VGND.t854 sg13_lv_nmos ad=3.32715p pd=20.78u as=0.2516p ps=2.16u w=0.74u l=0.13u
X2366 VPWR.t625 a_6250_3108# sg13cmos5l_dfrbpq_1_21.CLK VPWR.t10 sg13_lv_pmos ad=0.2128p pd=1.5u as=0.2128p ps=1.5u w=1.12u l=0.13u
X2367 VGND.t50 a_15850_3862# sg13cmos5l_buf_8_0.X VGND.t1115 sg13_lv_nmos ad=0.1406p pd=1.12u as=0.1406p ps=1.12u w=0.74u l=0.13u
X2368 VGND.t254 a_5392_4114# a_5041_3971# VGND.t193 sg13_lv_nmos ad=79.8f pd=0.8u as=0.1428p ps=1.52u w=0.42u l=0.13u
X2369 a_18272_1919# a_18391_1596# VGND.t77 VGND.t397 sg13_lv_nmos ad=0.2516p pd=2.16u as=0.1406p ps=1.12u w=0.74u l=0.13u
X2370 a_6272_8605# a_6391_8394# VPWR.t642 VPWR.t0 sg13_lv_pmos ad=0.3864p pd=2.93u as=0.2128p ps=1.5u w=1.12u l=0.13u
X2371 a_4270_870# a_4012_870# VGND.t32 VGND.t275 sg13_lv_nmos ad=0.1428p pd=1.52u as=79.8f ps=0.8u w=0.42u l=0.13u
X2372 sg13cmos5l_nand3_1_1.Y sg13cmos5l_nand3_1_1.B VPWR.t544 VPWR.t43 sg13_lv_pmos ad=0.2128p pd=1.5u as=0.2128p ps=1.5u w=1.12u l=0.13u
X2373 VPWR.t1331 a_9915_3898# sg13cmos5l_buf_8_3.A VPWR.t43 sg13_lv_pmos ad=0.2128p pd=1.5u as=0.2128p ps=1.5u w=1.12u l=0.13u
X2374 a_27226_2350# sg13cmos5l_dlygate4sd3_1_15.A VPWR.t314 VPWR.t10 sg13_lv_pmos ad=0.1428p pd=1.52u as=0.1523p ps=1.38u w=0.42u l=0.13u
X2375 a_28940_1596# sg13cmos5l_buf_1_0.A.t1 VPWR.t459 VPWR.t15 sg13_lv_pmos ad=0.2856p pd=2.36u as=0.2114p ps=1.54u w=0.84u l=0.13u
X2376 a_9446_3144# a_9176_3185# VPWR.t1215 VPWR.t10 sg13_lv_pmos ad=0.34p pd=2.68u as=0.1523p ps=1.38u w=1u l=0.5u
X2377 a_17655_1168# sg13cmos5l_nor3_1_0.B a_17541_1168# VPWR.t15 sg13_lv_pmos ad=0.2128p pd=1.5u as=0.2464p ps=1.56u w=1.12u l=0.13u
X2378 VPWR.t563 a_16454_3144# a_16566_3168# VPWR.t10 sg13_lv_pmos ad=0.2254p pd=1.53u as=0.34p ps=2.68u w=1u l=0.5u
X2379 a_18789_2361# sg13cmos5l_dfrbpq_1_2.CLK VPWR.t91 VPWR.t10 sg13_lv_pmos ad=0.4088p pd=2.97u as=1.4003p ps=8.92u w=1.12u l=0.13u
X2380 VPWR.t264 a_25871_6529# a_26538_6168# VPWR.t7 sg13_lv_pmos ad=0.2128p pd=1.5u as=0.3864p ps=2.93u w=1.12u l=0.13u
X2381 VPWR.t1 a_11567_8507# a_11824_8650# VPWR.t0 sg13_lv_pmos ad=1.8922p pd=12.27u as=79.8f ps=0.8u w=0.42u l=0.13u
X2382 VPWR.t55 VGND.t1493 VPWR.t54 VPWR.t43 sg13_lv_pmos ad=0.19p pd=1.38u as=0 ps=0 w=1u l=1u
X2383 a_27023_5017# a_26181_4667# a_25764_4660# VPWR.t43 sg13_lv_pmos ad=0.2048p pd=1.63u as=0.34p ps=2.68u w=1u l=0.13u
X2384 sg13cmos5l_dlygate4sd3_1_0.X a_27798_938# VPWR.t204 VPWR.t15 sg13_lv_pmos ad=0.4256p pd=3u as=0.2254p ps=1.53u w=1.12u l=0.13u
X2385 VGND.t350 a_14938_4620# a_14657_4922# VGND.t520 sg13_lv_nmos ad=79.8f pd=0.8u as=0.1428p ps=1.52u w=0.42u l=0.5u
X2386 a_9915_3898# sg13cmos5l_buf_8_5.A VPWR.t1174 VPWR.t43 sg13_lv_pmos ad=0.2128p pd=1.5u as=0.2128p ps=1.5u w=1.12u l=0.13u
X2387 a_13888_7680# sg13cmos5l_xnor2_1_2.B a_13676_7680# VPWR.t2 sg13_lv_pmos ad=0.2128p pd=1.5u as=0.2128p ps=1.5u w=1.12u l=0.13u
X2388 a_15791_874# sg13cmos5l_xnor2_1_0.A VGND.t411 VGND.t678 sg13_lv_nmos ad=0.2516p pd=2.16u as=0.1898p ps=1.36u w=0.74u l=0.13u
X2389 sg13cmos5l_dfrbpq_1_55.D a_16566_3168# VGND.t50 VGND.t1325 sg13_lv_nmos ad=0.2516p pd=2.16u as=0.1426p ps=1.16u w=0.74u l=0.13u
X2390 VPWR.t674 a_1248_4695# sg13cmos5l_xnor2_1_12.Y VPWR.t43 sg13_lv_pmos ad=0.3808p pd=2.92u as=0.2408p ps=1.55u w=1.12u l=0.13u
X2391 a_17625_5721# a_16683_5528# a_17423_5483# VPWR.t7 sg13_lv_pmos ad=93.45f pd=0.865u as=0.2048p ps=1.63u w=0.42u l=0.13u
X2392 VPWR.t2 a_17327_6995# a_17584_7138# VPWR.t2 sg13_lv_pmos ad=1.34765p pd=8.56u as=79.8f ps=0.8u w=0.42u l=0.13u
X2393 a_19246_6435# a_19361_6434# VPWR.t231 VPWR.t7 sg13_lv_pmos ad=0.34p pd=2.68u as=0.2254p ps=1.53u w=1u l=0.5u
X2394 a_10702_2382# a_10943_2652# a_10231_2346# VGND.t1455 sg13_lv_nmos ad=0.1428p pd=1.52u as=0.12665p ps=1.145u w=0.42u l=0.13u
X2395 a_4106_2382# a_3799_2346# a_4012_2382# VGND.t383 sg13_lv_nmos ad=37.8f pd=0.6u as=0.1428p ps=1.52u w=0.42u l=0.13u
X2396 VPWR.t7 a_20805_5385# a_20907_5528# VPWR.t7 sg13_lv_pmos ad=1.46065p pd=9.335u as=0.3864p ps=2.93u w=1.12u l=0.13u
X2397 a_10812_2346# a_10943_2652# a_10231_2346# VPWR.t10 sg13_lv_pmos ad=0.34p pd=2.68u as=0.2048p ps=1.63u w=1u l=0.13u
X2398 VGND.t115 sg13cmos5l_dfrbpq_1_13.RESET_B.t14 a_7524_2382# VGND.t611 sg13_lv_nmos ad=0.1626p pd=1.415u as=60.89999f ps=0.71u w=0.42u l=0.13u
X2399 VPWR.t119 a_15119_3505# a_15786_3144# VPWR.t10 sg13_lv_pmos ad=0.2128p pd=1.5u as=0.3864p ps=2.93u w=1.12u l=0.13u
X2400 a_3692_4656# sg13cmos5l_dlygate4sd3_1_23.X a_3904_4656# VPWR.t43 sg13_lv_pmos ad=0.2128p pd=1.5u as=0.3808p ps=2.92u w=1.12u l=0.13u
X2401 VGND.t393 a_11733_2540# a_10812_2346# VGND.t566 sg13_lv_nmos ad=0.1626p pd=1.415u as=0.2516p ps=2.16u w=0.74u l=0.13u
X2402 a_26052_8443# a_25764_8748# a_25990_8443# VGND.t638 sg13_lv_nmos ad=0.1428p pd=1.52u as=37.8f ps=0.6u w=0.42u l=0.13u
X2403 a_22066_6606# sg13cmos5l_buf_1_0.X.t6 VGND.t65 VGND.t423 sg13_lv_nmos ad=37.8f pd=0.6u as=79.8f ps=0.8u w=0.42u l=0.13u
X2404 sg13cmos5l_nand3_1_1.B sg13cmos5l_dfrbpq_1_56.D VGND.t332 VGND.t95 sg13_lv_nmos ad=0.1406p pd=1.12u as=0.1406p ps=1.12u w=0.74u l=0.13u
X2405 a_26159_3505# a_25317_3155# a_26065_3505# VGND.t1178 sg13_lv_nmos ad=0.12665p pd=1.145u as=0.1428p ps=1.52u w=0.42u l=0.13u
X2406 a_10725_6897# sg13cmos5l_dfrbpq_1_57.CLK VGND.t25 VGND.t1100 sg13_lv_nmos ad=0.2516p pd=2.16u as=3.31142p ps=20.535u w=0.74u l=0.13u
X2407 VPWR.t422 a_2266_7644# a_1985_7946# VPWR.t2 sg13_lv_pmos ad=0.1523p pd=1.38u as=0.34p ps=2.68u w=1u l=0.5u
X2408 VPWR.t187 VGND.t32 VPWR.t17 VPWR.t15 sg13_lv_pmos ad=0.19p pd=1.38u as=0 ps=0 w=1u l=1u
X2409 sg13cmos5l_xnor2_1_2.Y sg13cmos5l_xnor2_1_2.B a_16563_1632# VPWR.t15 sg13_lv_pmos ad=0.2408p pd=1.55u as=0.1428p ps=1.375u w=1.12u l=0.13u
X2410 VPWR.t1358 a_1870_2571# sg13cmos5l_xnor2_1_6.A VPWR.t10 sg13_lv_pmos ad=0.2254p pd=1.53u as=0.4256p ps=3u w=1.12u l=0.13u
X2411 VPWR.t2 a_27695_6995# a_27952_7138# VPWR.t2 sg13_lv_pmos ad=1.34765p pd=8.56u as=79.8f ps=0.8u w=0.42u l=0.13u
X2412 a_20782_7803# a_20524_8118# VPWR.t2 VPWR.t2 sg13_lv_pmos ad=93.45f pd=0.865u as=1.34765p ps=8.56u w=0.42u l=0.13u
X2413 a_16260_6593# a_16491_6179# a_15946_6136# VGND.t763 sg13_lv_nmos ad=0.2373p pd=1.97u as=79.8f ps=0.8u w=0.42u l=0.13u
X2414 a_3692_4656# sg13cmos5l_dfrbpq_1_23.D VPWR.t656 VPWR.t43 sg13_lv_pmos ad=0.2128p pd=1.5u as=0.3864p ps=2.93u w=1.12u l=0.13u
X2415 a_19428_1188# a_19402_1093# VGND.t101 VGND.t1169 sg13_lv_nmos ad=0.2516p pd=2.16u as=0.1626p ps=1.415u w=0.74u l=0.13u
X2416 sg13cmos5l_nor4_2_0.C a_23958_3962# VPWR.t227 VPWR.t43 sg13_lv_pmos ad=0.4256p pd=3u as=0.2254p ps=1.53u w=1.12u l=0.13u
X2417 a_10022_6918# a_10827_7040# a_10282_7141# VPWR.t2 sg13_lv_pmos ad=0.1428p pd=1.52u as=79.8f ps=0.8u w=0.42u l=0.13u
X2418 a_11733_2540# a_10791_2600# a_11594_2540# VGND.t566 sg13_lv_nmos ad=79.8f pd=0.8u as=0.2373p ps=1.97u w=0.42u l=0.13u
X2419 a_20805_3873# sg13cmos5l_dfrbpq_1_0.CLK VPWR.t43 VPWR.t43 sg13_lv_pmos ad=0.4088p pd=2.97u as=1.36105p ps=8.695u w=1.12u l=0.13u
X2420 VPWR.t105 a_20944_1090# a_20889_1185# VPWR.t15 sg13_lv_pmos ad=1.50275p pd=9.57u as=93.45f ps=0.865u w=0.42u l=0.13u
X2421 VPWR.t43 sg13cmos5l_dfrbpq_1_21.CLK a_7103_4164# VPWR.t43 sg13_lv_pmos ad=1.36105p pd=8.695u as=0.4088p ps=2.97u w=1.12u l=0.13u
X2422 a_27022_6435# a_27137_6434# VPWR.t109 VPWR.t7 sg13_lv_pmos ad=0.34p pd=2.68u as=0.2254p ps=1.53u w=1u l=0.5u
X2423 a_25380_883# a_25611_992# a_25066_1093# VGND.t42 sg13_lv_nmos ad=0.2373p pd=1.97u as=79.8f ps=0.8u w=0.42u l=0.13u
X2424 VGND.t365 a_13563_874# sg13cmos5l_dfrbpq_1_11.CLK VGND.t514 sg13_lv_nmos ad=0.1406p pd=1.12u as=0.1406p ps=1.12u w=0.74u l=0.13u
X2425 VGND.t71 sg13cmos5l_buf_1_1.X.t5 a_20150_2057# VGND.t104 sg13_lv_nmos ad=0.1701p pd=1.65u as=37.8f ps=0.6u w=0.42u l=0.13u
X2426 a_6951_4112# a_7103_4164# VGND.t50 VGND.t1681 sg13_lv_nmos ad=0.2516p pd=2.16u as=3.8943p ps=24.355u w=0.74u l=0.13u
X2427 VGND.t179 a_13642_5374# sg13cmos5l_and2_1_3.A VGND.t529 sg13_lv_nmos ad=0.1406p pd=1.12u as=0.1406p ps=1.12u w=0.74u l=0.13u
X2428 sg13cmos5l_buf_8_4.A a_7594_5374# VPWR.t1032 VPWR.t7 sg13_lv_pmos ad=0.2128p pd=1.5u as=0.3864p ps=2.93u w=1.12u l=0.13u
X2429 a_1169_3502# sg13cmos5l_xor2_1_1.B a_1137_3144# VPWR.t10 sg13_lv_pmos ad=0.34p pd=2.68u as=0.1225p ps=1.245u w=1u l=0.13u
X2430 a_8546_3894# sg13cmos5l_dfrbpq_1_21.RESET_B.t5 VGND.t50 VGND.t439 sg13_lv_nmos ad=60.89999f pd=0.71u as=0.1626p ps=1.415u w=0.42u l=0.13u
X2431 a_15914_5094# a_15607_4620# a_15820_5094# VGND.t1378 sg13_lv_nmos ad=37.8f pd=0.6u as=0.1428p ps=1.52u w=0.42u l=0.13u
X2432 a_2165_3898# sg13cmos5l_xnor2_1_0.Y VGND.t861 VGND.t1443 sg13_lv_nmos ad=0.1406p pd=1.12u as=0.1898p ps=1.36u w=0.74u l=0.13u
X2433 VGND.t11 sg13cmos5l_dlygate4sd3_1_1.A a_27992_1673# VGND.t148 sg13_lv_nmos ad=79.8f pd=0.8u as=0.1428p ps=1.52u w=0.42u l=0.13u
X2434 sg13cmos5l_dfrbpq_1_11.CLK a_13563_874# VGND.t365 VGND.t509 sg13_lv_nmos ad=0.1406p pd=1.12u as=0.1406p ps=1.12u w=0.74u l=0.13u
X2435 a_2266_7644# sg13cmos5l_dlygate4sd3_1_34.A VPWR.t422 VPWR.t2 sg13_lv_pmos ad=0.1428p pd=1.52u as=0.1523p ps=1.38u w=0.42u l=0.13u
X2436 a_24940_2070# a_24727_1596# VPWR.t153 VPWR.t15 sg13_lv_pmos ad=79.8f pd=0.8u as=1.50275p ps=9.57u w=0.42u l=0.13u
X2437 VPWR.t141 a_10812_6529# a_11835_6215# VPWR.t7 sg13_lv_pmos ad=0.1563p pd=1.22u as=63f ps=0.72u w=0.42u l=0.13u
X2438 VGND.t664 a_6645_5564# a_5724_5370# VGND.t256 sg13_lv_nmos ad=0.1626p pd=1.415u as=0.2516p ps=2.16u w=0.74u l=0.13u
X2439 a_26052_5419# a_26283_5528# a_25738_5629# VGND.t707 sg13_lv_nmos ad=0.2373p pd=1.97u as=79.8f ps=0.8u w=0.42u l=0.13u
X2440 a_20388_4212# a_20362_4117# VPWR.t149 VPWR.t43 sg13_lv_pmos ad=0.34p pd=2.68u as=0.36237p ps=2.605u w=1u l=0.13u
X2441 a_25360_7138# sg13cmos5l_buf_1_0.X.t8 VPWR.t2 VPWR.t2 sg13_lv_pmos ad=79.8f pd=0.8u as=1.31957p ps=8.38u w=0.42u l=0.13u
X2442 a_9010_8118# sg13cmos5l_dfrbpq_1_21.RESET_B.t9 VGND.t741 VGND.t355 sg13_lv_nmos ad=37.8f pd=0.6u as=79.8f ps=0.8u w=0.42u l=0.13u
X2443 a_25103_6995# a_24261_6897# a_25009_6995# VGND.t420 sg13_lv_nmos ad=0.12665p pd=1.145u as=0.1428p ps=1.52u w=0.42u l=0.13u
X2444 VGND.t350 sg13cmos5l_dfrbpq_1_56.Q a_15032_5410# VGND.t349 sg13_lv_nmos ad=79.8f pd=0.8u as=0.1428p ps=1.52u w=0.42u l=0.13u
X2445 a_20050_2382# sg13cmos5l_buf_1_1.X.t9 VGND.t71 VGND.t8 sg13_lv_nmos ad=37.8f pd=0.6u as=79.8f ps=0.8u w=0.42u l=0.13u
X2446 a_16320_1671# sg13cmos5l_xnor2_1_2.A VPWR.t214 VPWR.t15 sg13_lv_pmos ad=0.1596p pd=1.22u as=0.4536p ps=2.76u w=0.84u l=0.13u
X2447 a_15082_7648# a_15525_7691# a_14822_8118# VGND.t916 sg13_lv_nmos ad=79.8f pd=0.8u as=0.1296p ps=1.52u w=0.42u l=0.13u
X2448 a_10022_6918# sg13cmos5l_dlygate4sd3_1_28.X VPWR.t862 VPWR.t2 sg13_lv_pmos ad=79.8f pd=0.8u as=0.1428p ps=1.52u w=0.42u l=0.13u
X2449 a_20192_7093# a_20311_6882# VPWR.t263 VPWR.t2 sg13_lv_pmos ad=0.3864p pd=2.93u as=0.2128p ps=1.5u w=1.12u l=0.13u
X2450 a_20972_2680# sg13cmos5l_dfrbpq_1_0.D a_20666_2680# VPWR.t10 sg13_lv_pmos ad=0.2128p pd=1.5u as=0.2128p ps=1.5u w=1.12u l=0.13u
X2451 VGND.t203 sg13cmos5l_dfrbpq_1_53.RESET_B.t2 a_25572_5094# VGND.t302 sg13_lv_nmos ad=0.1626p pd=1.415u as=60.89999f ps=0.71u w=0.42u l=0.13u
X2452 a_18002_878# sg13cmos5l_nor3_1_0.Y VGND.t172 VGND.t171 sg13_lv_nmos ad=0.1406p pd=1.12u as=0.2886p ps=2.26u w=0.74u l=0.13u
X2453 VGND.t324 a_13664_1919# sg13cmos5l_dfrbpq_1_55.Q VGND.t1665 sg13_lv_nmos ad=0.1406p pd=1.12u as=0.2516p ps=2.16u w=0.74u l=0.13u
X2454 VGND.t50 a_15119_3505# a_15786_3144# VGND.t1399 sg13_lv_nmos ad=0.1406p pd=1.12u as=0.2516p ps=2.16u w=0.74u l=0.13u
X2455 VGND.t824 sg13cmos5l_dfrbpq_1_56.RESET_B a_17366_5081# VGND.t823 sg13_lv_nmos ad=0.1701p pd=1.65u as=37.8f ps=0.6u w=0.42u l=0.13u
X2456 VPWR.t144 sg13cmos5l_buf_1_1.X.t2 a_19142_870# VPWR.t15 sg13_lv_pmos ad=0.36237p pd=2.605u as=79.8f ps=0.8u w=0.42u l=0.13u
X2457 sg13cmos5l_nand3_1_0.A sg13cmos5l_nor4_2_1.A VGND.t17 VGND.t670 sg13_lv_nmos ad=0.1406p pd=1.12u as=0.3293p ps=1.63u w=0.74u l=0.13u
X2458 a_20102_6606# a_20907_6179# a_20362_6136# VPWR.t7 sg13_lv_pmos ad=0.1428p pd=1.52u as=79.8f ps=0.8u w=0.42u l=0.13u
X2459 a_27280_8650# sg13cmos5l_dfrbpq_1_53.RESET_B.t9 VPWR.t1 VPWR.t0 sg13_lv_pmos ad=79.8f pd=0.8u as=1.8922p ps=12.27u w=0.42u l=0.13u
X2460 VPWR.t561 a_15488_4943# sg13cmos5l_dfrbpq_1_56.Q VPWR.t43 sg13_lv_pmos ad=0.2128p pd=1.5u as=0.3808p ps=2.92u w=1.12u l=0.13u
X2461 a_24420_2700# a_24394_2605# VGND.t137 VGND.t211 sg13_lv_nmos ad=0.2516p pd=2.16u as=0.1626p ps=1.415u w=0.74u l=0.13u
X2462 a_10112_2557# a_10231_2346# VGND.t478 VGND.t1543 sg13_lv_nmos ad=0.2516p pd=2.16u as=0.1406p ps=1.12u w=0.74u l=0.13u
X2463 a_19055_3971# a_18213_3873# a_18961_3971# VGND.t1556 sg13_lv_nmos ad=0.12665p pd=1.145u as=0.1428p ps=1.52u w=0.42u l=0.13u
X2464 VPWR.t257 a_21742_1899# sg13cmos5l_dfrbpq_1_2.D VPWR.t15 sg13_lv_pmos ad=0.2254p pd=1.53u as=0.4256p ps=3u w=1.12u l=0.13u
X2465 a_7799_1261# sg13cmos5l_dfrbpq_1_13.RESET_B.t3 VPWR.t1375 VPWR.t15 sg13_lv_pmos ad=79.8f pd=0.8u as=0.36237p ps=2.605u w=0.42u l=0.13u
X2466 VGND.t115 sg13cmos5l_dfrbpq_1_13.RESET_B.t11 a_6518_2057# VGND.t610 sg13_lv_nmos ad=0.1701p pd=1.65u as=37.8f ps=0.6u w=0.42u l=0.13u
X2467 a_23872_8728# sg13cmos5l_dfrbpq_1_46.D a_23660_8728# VPWR.t0 sg13_lv_pmos ad=0.2128p pd=1.5u as=0.2128p ps=1.5u w=1.12u l=0.13u
X2468 a_5143_5370# a_5703_5624# a_5614_5721# VPWR.t7 sg13_lv_pmos ad=0.2048p pd=1.63u as=93.45f ps=0.865u w=0.42u l=0.13u
X2469 a_3876_4212# a_3850_4117# VGND.t861 VGND.t1400 sg13_lv_nmos ad=0.2516p pd=2.16u as=0.1626p ps=1.415u w=0.74u l=0.13u
X2470 VPWR.t97 a_21647_8507# a_22314_8728# VPWR.t0 sg13_lv_pmos ad=0.2128p pd=1.5u as=0.3864p ps=2.93u w=1.12u l=0.13u
X2471 sg13cmos5l_nand3_1_1.A sg13cmos5l_xnor2_1_2.A VGND.t40 VGND.t463 sg13_lv_nmos ad=0.1406p pd=1.12u as=0.2553p ps=2.17u w=0.74u l=0.13u
X2472 sg13cmos5l_nand3_1_0.A sg13cmos5l_dfrbpq_1_2.D VGND.t17 VGND.t540 sg13_lv_nmos ad=0.1406p pd=1.12u as=0.1406p ps=1.12u w=0.74u l=0.13u
X2473 VPWR.t1 a_5392_8650# a_5337_8745# VPWR.t0 sg13_lv_pmos ad=1.8922p pd=12.27u as=93.45f ps=0.865u w=0.42u l=0.13u
X2474 a_8133_2361# sg13cmos5l_dfrbpq_1_13.CLK VGND.t77 VGND.t226 sg13_lv_nmos ad=0.2516p pd=2.16u as=3.06955p ps=19.355u w=0.74u l=0.13u
X2475 VGND.t273 a_27790_7947# sg13cmos5l_nor4_2_7.B VGND.t904 sg13_lv_nmos ad=0.1426p pd=1.16u as=0.2516p ps=2.16u w=0.74u l=0.13u
X2476 VPWR.t840 sg13cmos5l_dfrbpq_1_58.RESET_B a_6154_6136# VPWR.t7 sg13_lv_pmos ad=0.1563p pd=1.22u as=0.147p ps=1.54u w=0.42u l=0.13u
X2477 VGND.t632 a_1169_3502# sg13cmos5l_xnor2_1_0.A VGND.t1676 sg13_lv_nmos ad=0.3108p pd=2.32u as=0.1628p ps=1.18u w=0.74u l=0.13u
X2478 a_20614_8443# sg13cmos5l_buf_1_0.X.t15 VGND.t141 VGND.t0 sg13_lv_nmos ad=37.8f pd=0.6u as=0.1701p ps=1.65u w=0.42u l=0.13u
X2479 sg13cmos5l_dfrbpq_1_11.CLK a_13563_874# VGND.t365 VGND.t515 sg13_lv_nmos ad=0.1406p pd=1.12u as=0.1406p ps=1.12u w=0.74u l=0.13u
X2480 a_3876_8748# a_4395_8552# a_5135_8507# VGND.t691 sg13_lv_nmos ad=0.3473p pd=2.71u as=0.12665p ps=1.145u w=0.74u l=0.13u
X2481 a_27790_7947# a_27905_7946# VPWR.t818 VPWR.t2 sg13_lv_pmos ad=0.34p pd=2.68u as=0.2254p ps=1.53u w=1u l=0.5u
X2482 VPWR.t946 a_14235_6922# sg13cmos5l_buf_8_10.A VPWR.t2 sg13_lv_pmos ad=0.2128p pd=1.5u as=0.2128p ps=1.5u w=1.12u l=0.13u
X2483 VPWR.t779 a_6972_8394# a_7995_8821# VPWR.t0 sg13_lv_pmos ad=0.1563p pd=1.22u as=63f ps=0.72u w=0.42u l=0.13u
X2484 VGND.t316 a_13745_3948# sg13cmos5l_xnor2_1_5.A VGND.t378 sg13_lv_nmos ad=0.3108p pd=2.32u as=0.1628p ps=1.18u w=0.74u l=0.13u
X2485 VGND.t25 sg13cmos5l_nor4_2_5.C sg13cmos5l_nor4_2_5.Y VGND.t1096 sg13_lv_nmos ad=0.1406p pd=1.12u as=0.1406p ps=1.12u w=0.74u l=0.13u
X2486 VGND.t133 sg13cmos5l_buf_1_0.X.t3 a_20196_5406# VGND.t139 sg13_lv_nmos ad=0.1626p pd=1.415u as=60.89999f ps=0.71u w=0.42u l=0.13u
X2487 a_8853_1679# a_7911_1719# a_8714_1912# VGND.t873 sg13_lv_nmos ad=79.8f pd=0.8u as=0.2373p ps=1.97u w=0.42u l=0.13u
X2488 a_5340_1993# a_5471_1603# a_4759_1596# VPWR.t15 sg13_lv_pmos ad=0.34p pd=2.68u as=0.2048p ps=1.63u w=1u l=0.13u
X2489 a_6276_7236# a_6795_7040# a_7535_6995# VGND.t1106 sg13_lv_nmos ad=0.3473p pd=2.71u as=0.12665p ps=1.145u w=0.74u l=0.13u
X2490 a_11639_6215# sg13cmos5l_xnor2_1_2.A a_12386_6606# VGND.t95 sg13_lv_nmos ad=0.1428p pd=1.52u as=60.89999f ps=0.71u w=0.42u l=0.13u
X2491 a_4102_3907# sg13cmos5l_dfrbpq_1_21.RESET_B.t8 VGND.t861 VGND.t860 sg13_lv_nmos ad=37.8f pd=0.6u as=0.1701p ps=1.65u w=0.42u l=0.13u
X2492 a_15008_8605# a_15127_8394# VPWR.t325 VPWR.t0 sg13_lv_pmos ad=0.3864p pd=2.93u as=0.2128p ps=1.5u w=1.12u l=0.13u
X2493 a_14090_2070# a_13783_1596# a_13996_2070# VGND.t323 sg13_lv_nmos ad=37.8f pd=0.6u as=0.1428p ps=1.52u w=0.42u l=0.13u
X2494 a_28262_1632# a_27992_1673# VPWR.t189 VPWR.t15 sg13_lv_pmos ad=0.34p pd=2.68u as=0.1523p ps=1.38u w=1u l=0.5u
X2495 VPWR.t603 a_10112_3431# sg13cmos5l_dfrbpq_1_17.Q VPWR.t10 sg13_lv_pmos ad=0.2128p pd=1.5u as=0.3808p ps=2.92u w=1.12u l=0.13u
X2496 VPWR.t282 a_27195_3514# sg13cmos5l_dfrbpq_1_0.CLK VPWR.t10 sg13_lv_pmos ad=0.2128p pd=1.5u as=0.2128p ps=1.5u w=1.12u l=0.13u
X2497 sg13cmos5l_buf_8_0.X a_15850_3862# VPWR.t993 VPWR.t43 sg13_lv_pmos ad=0.2128p pd=1.5u as=0.3864p ps=2.93u w=1.12u l=0.13u
X2498 a_18382_6435# a_18497_6434# VGND.t191 VGND.t659 sg13_lv_nmos ad=0.1428p pd=1.52u as=0.1426p ps=1.16u w=0.42u l=0.5u
X2499 VGND.t65 a_21647_6529# a_22314_6168# VGND.t705 sg13_lv_nmos ad=0.1406p pd=1.12u as=0.2516p ps=2.16u w=0.74u l=0.13u
X2500 a_21904_8650# a_21647_8507# a_22066_8430# VGND.t18 sg13_lv_nmos ad=0.1428p pd=1.52u as=37.8f ps=0.6u w=0.42u l=0.13u
X2501 VPWR.t262 a_17327_6995# a_17994_7216# VPWR.t2 sg13_lv_pmos ad=0.2128p pd=1.5u as=0.3864p ps=2.93u w=1.12u l=0.13u
X2502 a_6693_6897# sg13cmos5l_dfrbpq_1_32.CLK VPWR.t2 VPWR.t2 sg13_lv_pmos ad=0.4088p pd=2.97u as=1.31957p ps=8.38u w=1.12u l=0.13u
X2503 VPWR.t518 sg13cmos5l_dfrbpq_1_55.RESET_B a_13574_2382# VPWR.t10 sg13_lv_pmos ad=0.36237p pd=2.605u as=79.8f ps=0.8u w=0.42u l=0.13u
X2504 a_18789_2361# sg13cmos5l_dfrbpq_1_2.CLK VGND.t77 VGND.t399 sg13_lv_nmos ad=0.2516p pd=2.16u as=3.06955p ps=19.355u w=0.74u l=0.13u
X2505 a_16569_7803# a_15627_7691# a_16367_8041# VPWR.t2 sg13_lv_pmos ad=93.45f pd=0.865u as=0.2048p ps=1.63u w=0.42u l=0.13u
X2506 a_21106_870# sg13cmos5l_buf_1_1.X.t1 VGND.t235 VGND.t709 sg13_lv_nmos ad=37.8f pd=0.6u as=79.8f ps=0.8u w=0.42u l=0.13u
X2507 a_18874_8398# sg13cmos5l_dfrbpq_1_29.Q VGND.t1016 VGND.t0 sg13_lv_nmos ad=0.1428p pd=1.52u as=79.8f ps=0.8u w=0.42u l=0.13u
X2508 VPWR.t7 sg13cmos5l_dfrbpq_1_57.CLK a_10943_6139# VPWR.t7 sg13_lv_pmos ad=1.42587p pd=9.11u as=0.4088p ps=2.97u w=1.12u l=0.13u
X2509 VPWR.t91 a_15119_3505# a_15376_3386# VPWR.t10 sg13_lv_pmos ad=1.43285p pd=9.125u as=79.8f ps=0.8u w=0.42u l=0.13u
X2510 a_13860_3148# a_13834_3112# VGND.t316 VGND.t1259 sg13_lv_nmos ad=0.2516p pd=2.16u as=0.1626p ps=1.415u w=0.74u l=0.13u
X2511 VPWR.t91 a_19888_2602# a_19833_2697# VPWR.t10 sg13_lv_pmos ad=1.43285p pd=9.125u as=93.45f ps=0.865u w=0.42u l=0.13u
X2512 a_4270_870# a_4511_1140# a_3799_834# VGND.t33 sg13_lv_nmos ad=0.1428p pd=1.52u as=0.12665p ps=1.145u w=0.42u l=0.13u
X2513 VGND.t0 a_25797_7691# a_25899_7691# VGND.t408 sg13_lv_nmos ad=3.41162p pd=21.215u as=0.2516p ps=2.16u w=0.74u l=0.13u
X2514 sg13cmos5l_dfrbpq_1_53.CLK a_27963_6538# VGND.t197 VGND.t1563 sg13_lv_nmos ad=0.1406p pd=1.12u as=0.1406p ps=1.12u w=0.74u l=0.13u
X2515 VPWR.t524 sg13cmos5l_dfrbpq_1_55.RESET_B a_13834_3112# VPWR.t10 sg13_lv_pmos ad=0.1563p pd=1.22u as=0.147p ps=1.54u w=0.42u l=0.13u
X2516 sg13cmos5l_dlygate4sd3_1_11.X a_28758_3962# VPWR.t478 VPWR.t43 sg13_lv_pmos ad=0.4256p pd=3u as=0.2254p ps=1.53u w=1.12u l=0.13u
X2517 VPWR.t6 VGND.t20 VPWR.t6 VPWR.t2 sg13_lv_pmos ad=0.34p pd=2.68u as=0 ps=0 w=1u l=1u
X2518 VPWR.t73 VGND.t83 VPWR.t53 VPWR.t7 sg13_lv_pmos ad=0.34p pd=2.68u as=0 ps=0 w=1u l=1u
X2519 a_25605_3873# sg13cmos5l_dfrbpq_1_0.CLK VPWR.t43 VPWR.t43 sg13_lv_pmos ad=0.4088p pd=2.97u as=1.36105p ps=8.695u w=1.12u l=0.13u
X2520 VGND.t572 VPWR.t1457 VGND.t572 VGND.t1508 sg13_lv_nmos ad=79.8f pd=0.8u as=0 ps=0 w=0.42u l=1u
X2521 VGND.t165 sg13cmos5l_dfrbpq_1_13.RESET_B.t2 a_10116_870# VGND.t1615 sg13_lv_nmos ad=0.1626p pd=1.415u as=60.89999f ps=0.71u w=0.42u l=0.13u
X2522 a_11733_3191# a_10791_3231# a_11639_3191# VPWR.t10 sg13_lv_pmos ad=79.8f pd=0.8u as=0.1428p ps=1.52u w=0.42u l=0.13u
X2523 VGND.t145 a_20192_7093# sg13cmos5l_dlygate4sd3_1_6.A VGND.t245 sg13_lv_nmos ad=0.1406p pd=1.12u as=0.2516p ps=2.16u w=0.74u l=0.13u
X2524 a_18372_2700# a_18346_2605# VPWR.t415 VPWR.t10 sg13_lv_pmos ad=0.34p pd=2.68u as=0.36237p ps=2.605u w=1u l=0.13u
X2525 a_5894_6606# sg13cmos5l_nor4_2_5.D VPWR.t421 VPWR.t7 sg13_lv_pmos ad=79.8f pd=0.8u as=0.1428p ps=1.52u w=0.42u l=0.13u
X2526 sg13cmos5l_and2_1_3.A a_13642_5374# VPWR.t486 VPWR.t7 sg13_lv_pmos ad=0.2128p pd=1.5u as=0.3864p ps=2.93u w=1.12u l=0.13u
X2527 VGND.t131 a_8582_4656# a_8694_4680# VGND.t1424 sg13_lv_nmos ad=0.1426p pd=1.16u as=0.1428p ps=1.52u w=0.42u l=0.5u
X2528 a_21062_1632# a_20792_1673# VGND.t17 VGND.t157 sg13_lv_nmos ad=0.1428p pd=1.52u as=79.8f ps=0.8u w=0.42u l=0.5u
X2529 a_18372_2700# a_18891_2504# a_19631_2459# VGND.t8 sg13_lv_nmos ad=0.3473p pd=2.71u as=0.12665p ps=1.145u w=0.74u l=0.13u
X2530 VGND.t126 sg13cmos5l_dfrbpq_1_53.RESET_B.t6 a_26244_6918# VGND.t426 sg13_lv_nmos ad=0.1626p pd=1.415u as=60.89999f ps=0.71u w=0.42u l=0.13u
X2531 VGND.t632 VPWR.t1460 VGND.t632 VGND.t1503 sg13_lv_nmos ad=79.8f pd=0.8u as=0 ps=0 w=0.42u l=1u
X2532 VGND.t101 sg13cmos5l_buf_1_1.X.t2 a_19236_870# VGND.t102 sg13_lv_nmos ad=0.1626p pd=1.415u as=60.89999f ps=0.71u w=0.42u l=0.13u
X2533 VGND.t20 VPWR.t166 VGND.t20 VGND.t1464 sg13_lv_nmos ad=0.1428p pd=1.52u as=0 ps=0 w=0.42u l=1u
X2534 a_15525_7691# sg13cmos5l_dfrbpq_1_56.CLK VPWR.t2 VPWR.t2 sg13_lv_pmos ad=0.4088p pd=2.97u as=1.31957p ps=8.38u w=1.12u l=0.13u
X2535 sg13cmos5l_dfrbpq_1_57.CLK a_8842_6886# VPWR.t953 VPWR.t2 sg13_lv_pmos ad=0.2128p pd=1.5u as=0.3864p ps=2.93u w=1.12u l=0.13u
X2536 a_11990_5081# a_10812_5017# a_11594_4936# VGND.t1416 sg13_lv_nmos ad=37.8f pd=0.6u as=0.1428p ps=1.52u w=0.42u l=0.13u
X2537 a_7799_8821# a_7103_8700# a_7893_8588# VGND.t1245 sg13_lv_nmos ad=0.1296p pd=1.52u as=79.8f ps=0.8u w=0.42u l=0.13u
X2538 VGND.t197 a_27963_6538# sg13cmos5l_dfrbpq_1_53.CLK VGND.t1560 sg13_lv_nmos ad=0.1406p pd=1.12u as=0.1406p ps=1.12u w=0.74u l=0.13u
X2539 VPWR.t43 a_26181_4667# a_26283_4667# VPWR.t43 sg13_lv_pmos ad=1.3927p pd=8.9u as=0.3864p ps=2.93u w=1.12u l=0.13u
X2540 a_9446_5410# a_9176_5410# VPWR.t1082 VPWR.t7 sg13_lv_pmos ad=0.34p pd=2.68u as=0.1523p ps=1.38u w=1u l=0.5u
X2541 a_25052_8728# sg13cmos5l_dlygate4sd3_1_39.X VPWR.t117 VPWR.t0 sg13_lv_pmos ad=0.2128p pd=1.5u as=0.2128p ps=1.5u w=1.12u l=0.13u
X2542 a_20196_6606# sg13cmos5l_dlygate4sd3_1_51.X a_20102_6606# VGND.t249 sg13_lv_nmos ad=60.89999f pd=0.71u as=0.1428p ps=1.52u w=0.42u l=0.13u
X2543 VPWR.t43 a_5135_3971# a_5392_4114# VPWR.t43 sg13_lv_pmos ad=1.3927p pd=8.9u as=79.8f ps=0.8u w=0.42u l=0.13u
X2544 a_6604_870# a_6391_834# VPWR.t105 VPWR.t15 sg13_lv_pmos ad=79.8f pd=0.8u as=1.50275p ps=9.57u w=0.42u l=0.13u
X2545 a_18981_3155# sg13cmos5l_dfrbpq_1_2.CLK VPWR.t91 VPWR.t10 sg13_lv_pmos ad=0.4088p pd=2.97u as=1.4003p ps=8.92u w=1.12u l=0.13u
X2546 a_25188_4212# a_25162_4117# VPWR.t227 VPWR.t43 sg13_lv_pmos ad=0.34p pd=2.68u as=0.36237p ps=2.605u w=1u l=0.13u
X2547 a_5614_5406# a_5356_5406# VGND.t52 VGND.t51 sg13_lv_nmos ad=0.1428p pd=1.52u as=79.8f ps=0.8u w=0.42u l=0.13u
X2548 a_11733_4703# a_10791_4743# a_11594_4936# VGND.t1305 sg13_lv_nmos ad=79.8f pd=0.8u as=0.2373p ps=1.97u w=0.42u l=0.13u
X2549 a_14277_2361# sg13cmos5l_dfrbpq_1_11.CLK VPWR.t91 VPWR.t10 sg13_lv_pmos ad=0.4088p pd=2.97u as=1.4003p ps=8.92u w=1.12u l=0.13u
X2550 sg13cmos5l_dlygate4sd3_1_50.A a_12234_5704# VPWR.t483 VPWR.t7 sg13_lv_pmos ad=0.3808p pd=2.92u as=0.2128p ps=1.5u w=1.12u l=0.13u
X2551 VGND.t121 a_1870_7947# sg13cmos5l_nor3_1_2.B VGND.t430 sg13_lv_nmos ad=0.1426p pd=1.16u as=0.2516p ps=2.16u w=0.74u l=0.13u
X2552 a_26704_4114# sg13cmos5l_buf_1_4.X.t5 VPWR.t43 VPWR.t43 sg13_lv_pmos ad=79.8f pd=0.8u as=1.36105p ps=8.695u w=0.42u l=0.13u
X2553 VGND.t50 a_10112_3431# sg13cmos5l_dfrbpq_1_17.Q VGND.t658 sg13_lv_nmos ad=0.1406p pd=1.12u as=0.2516p ps=2.16u w=0.74u l=0.13u
X2554 sg13cmos5l_dfrbpq_1_53.CLK a_27963_6538# VGND.t45 VGND.t1557 sg13_lv_nmos ad=0.1406p pd=1.12u as=0.1406p ps=1.12u w=0.74u l=0.13u
X2555 sg13cmos5l_dlygate4sd3_1_19.A a_5802_4192# VGND.t254 VGND.t193 sg13_lv_nmos ad=0.2516p pd=2.16u as=0.1406p ps=1.12u w=0.74u l=0.13u
X2556 a_15946_6136# a_16389_6179# a_16329_6215# VPWR.t7 sg13_lv_pmos ad=79.8f pd=0.8u as=63f ps=0.72u w=0.42u l=0.13u
X2557 VPWR.t621 sg13cmos5l_xor2_1_2.A a_13916_4192# VPWR.t43 sg13_lv_pmos ad=0.2128p pd=1.5u as=0.3808p ps=2.92u w=1.12u l=0.13u
X2558 VGND.t630 a_8842_6886# sg13cmos5l_dfrbpq_1_57.CLK VGND.t1073 sg13_lv_nmos ad=0.1406p pd=1.12u as=0.1406p ps=1.12u w=0.74u l=0.13u
X2559 sg13cmos5l_dlygate4sd3_1_51.X a_23958_4680# VPWR.t227 VPWR.t43 sg13_lv_pmos ad=0.4256p pd=3u as=0.2254p ps=1.53u w=1.12u l=0.13u
X2560 VPWR.t7 a_21647_6529# a_21904_6410# VPWR.t7 sg13_lv_pmos ad=1.46065p pd=9.335u as=79.8f ps=0.8u w=0.42u l=0.13u
X2561 VPWR.t8 sg13cmos5l_dlygate4sd3_1_51.X a_23660_5704# VPWR.t7 sg13_lv_pmos ad=0.3808p pd=2.92u as=0.2128p ps=1.5u w=1.12u l=0.13u
X2562 VGND.t172 sg13cmos5l_nor3_1_0.B sg13cmos5l_nor3_1_0.Y VGND.t1171 sg13_lv_nmos ad=0.1463p pd=1.15u as=0.1694p ps=1.21u w=0.77u l=0.13u
X2563 a_8796_3510# sg13cmos5l_nor4_2_3.Y sg13cmos5l_nand3_1_3.Y VGND.t550 sg13_lv_nmos ad=0.1406p pd=1.12u as=0.2516p ps=2.16u w=0.74u l=0.13u
X2564 a_10791_7767# a_10943_7651# VGND.t0 VGND.t798 sg13_lv_nmos ad=0.2516p pd=2.16u as=3.41162p ps=21.215u w=0.74u l=0.13u
X2565 VGND.t50 sg13cmos5l_buf_1_4.X.t8 a_17604_3894# VGND.t1277 sg13_lv_nmos ad=0.1626p pd=1.415u as=60.89999f ps=0.71u w=0.42u l=0.13u
X2566 a_22066_3894# sg13cmos5l_buf_1_1.X.t14 VGND.t54 VGND.t202 sg13_lv_nmos ad=37.8f pd=0.6u as=79.8f ps=0.8u w=0.42u l=0.13u
X2567 sg13cmos5l_and2_1_1.A a_18843_5410# VGND.t133 VGND.t1396 sg13_lv_nmos ad=0.1406p pd=1.12u as=0.1406p ps=1.12u w=0.74u l=0.13u
X2568 sg13cmos5l_xnor2_1_12.Y sg13cmos5l_xnor2_1_12.B a_1491_4656# VPWR.t43 sg13_lv_pmos ad=0.2408p pd=1.55u as=0.1428p ps=1.375u w=1.12u l=0.13u
X2569 a_5134_8118# a_5375_7651# a_4663_7644# VGND.t991 sg13_lv_nmos ad=0.1428p pd=1.52u as=0.12665p ps=1.145u w=0.42u l=0.13u
X2570 a_7690_2605# a_8133_2361# a_7430_2382# VGND.t1436 sg13_lv_nmos ad=79.8f pd=0.8u as=0.1296p ps=1.52u w=0.42u l=0.13u
X2571 VPWR.t455 a_18380_7644# sg13cmos5l_buf_1_2.A VPWR.t2 sg13_lv_pmos ad=0.2114p pd=1.54u as=0.42p ps=2.99u w=1.12u l=0.13u
X2572 sg13cmos5l_dfrbpq_1_57.CLK a_8842_6886# VGND.t630 VGND.t1070 sg13_lv_nmos ad=0.1406p pd=1.12u as=0.1406p ps=1.12u w=0.74u l=0.13u
X2573 a_5392_3386# sg13cmos5l_dfrbpq_1_21.RESET_B.t3 VPWR.t91 VPWR.t10 sg13_lv_pmos ad=79.8f pd=0.8u as=1.4003p ps=8.92u w=0.42u l=0.13u
X2574 a_15108_7684# a_15082_7648# VGND.t93 VGND.t403 sg13_lv_nmos ad=0.2516p pd=2.16u as=0.1626p ps=1.415u w=0.74u l=0.13u
X2575 VPWR.t1066 a_4358_5410# a_4470_5474# VPWR.t7 sg13_lv_pmos ad=0.2254p pd=1.53u as=0.34p ps=2.68u w=1u l=0.5u
X2576 VGND.t393 sg13cmos5l_dfrbpq_1_55.RESET_B a_11990_2395# VGND.t566 sg13_lv_nmos ad=0.1701p pd=1.65u as=37.8f ps=0.6u w=0.42u l=0.13u
X2577 VPWR.t56 VGND.t572 VPWR.t58 VPWR.t43 sg13_lv_pmos ad=0.19p pd=1.38u as=0 ps=0 w=1u l=1u
X2578 VPWR.t137 sg13cmos5l_dfrbpq_1_57.RESET_B.t14 a_10022_8430# VPWR.t0 sg13_lv_pmos ad=0.36237p pd=2.605u as=79.8f ps=0.8u w=0.42u l=0.13u
X2579 a_15687_8648# a_15839_8700# VPWR.t1 VPWR.t0 sg13_lv_pmos ad=0.3864p pd=2.93u as=1.8922p ps=12.27u w=1.12u l=0.13u
X2580 a_6250_3108# sg13cmos5l_buf_8_4.A VPWR.t1350 VPWR.t10 sg13_lv_pmos ad=0.3808p pd=2.92u as=0.2128p ps=1.5u w=1.12u l=0.13u
X2581 sg13cmos5l_dfrbpq_1_53.RESET_B a_2920_7680# VGND.t117 VGND.t839 sg13_lv_nmos ad=0.2886p pd=2.26u as=0.14875p ps=1.16u w=0.74u l=0.13u
X2582 VGND.t133 a_18843_5410# sg13cmos5l_and2_1_1.A VGND.t1393 sg13_lv_nmos ad=0.1406p pd=1.12u as=0.1406p ps=1.12u w=0.74u l=0.13u
X2583 VPWR.t204 a_27686_874# a_27798_938# VPWR.t15 sg13_lv_pmos ad=0.2254p pd=1.53u as=0.34p ps=2.68u w=1u l=0.5u
X2584 a_16367_8041# a_15525_7691# a_15108_7684# VPWR.t2 sg13_lv_pmos ad=0.2048p pd=1.63u as=0.34p ps=2.68u w=1u l=0.13u
X2585 VGND.t278 VPWR.t1467 VGND.t278 VGND.t1483 sg13_lv_nmos ad=79.8f pd=0.8u as=0 ps=0 w=0.42u l=1u
X2586 VGND.t131 sg13cmos5l_buf_8_9.A a_7594_5374# VGND.t1568 sg13_lv_nmos ad=0.1406p pd=1.12u as=0.1406p ps=1.12u w=0.74u l=0.13u
X2587 a_18538_3112# a_18981_3155# a_18921_3191# VPWR.t10 sg13_lv_pmos ad=79.8f pd=0.8u as=63f ps=0.72u w=0.42u l=0.13u
X2588 VPWR.t482 sg13cmos5l_xnor2_1_12.B a_1248_4695# VPWR.t43 sg13_lv_pmos ad=0.2891p pd=1.695u as=0.1596p ps=1.22u w=0.84u l=0.13u
X2589 VPWR.t49 VGND.t632 VPWR.t47 VPWR.t43 sg13_lv_pmos ad=0.19p pd=1.38u as=0 ps=0 w=1u l=1u
X2590 a_25308_1993# a_25439_1603# a_24727_1596# VPWR.t15 sg13_lv_pmos ad=0.34p pd=2.68u as=0.2048p ps=1.63u w=1u l=0.13u
X2591 a_10534_883# sg13cmos5l_dfrbpq_1_13.RESET_B.t2 VGND.t165 VGND.t1616 sg13_lv_nmos ad=37.8f pd=0.6u as=0.1701p ps=1.65u w=0.42u l=0.13u
X2592 VPWR.t525 sg13cmos5l_dfrbpq_1_55.RESET_B a_13574_3582# VPWR.t10 sg13_lv_pmos ad=0.36237p pd=2.605u as=79.8f ps=0.8u w=0.42u l=0.13u
X2593 a_4293_3155# sg13cmos5l_dfrbpq_1_21.CLK VPWR.t91 VPWR.t10 sg13_lv_pmos ad=0.4088p pd=2.97u as=1.4003p ps=8.92u w=1.12u l=0.13u
X2594 sg13cmos5l_nand3_1_2.Y sg13cmos5l_nand3_1_2.B VPWR.t227 VPWR.t43 sg13_lv_pmos ad=0.2128p pd=1.5u as=0.2128p ps=1.5u w=1.12u l=0.13u
X2595 VGND.t50 a_7893_4052# a_6972_3858# VGND.t192 sg13_lv_nmos ad=0.1626p pd=1.415u as=0.2516p ps=2.16u w=0.74u l=0.13u
X2596 a_24326_6606# sg13cmos5l_dfrbpq_1_37.D VPWR.t221 VPWR.t7 sg13_lv_pmos ad=79.8f pd=0.8u as=0.1428p ps=1.52u w=0.42u l=0.13u
X2597 a_18572_5370# sg13cmos5l_buf_1_5.A VGND.t133 VGND.t132 sg13_lv_nmos ad=0.187p pd=1.78u as=0.14875p ps=1.16u w=0.55u l=0.13u
X2598 a_21915_7727# a_21023_7651# a_21813_7727# VPWR.t2 sg13_lv_pmos ad=63f pd=0.72u as=79.8f ps=0.8u w=0.42u l=0.13u
X2599 sg13cmos5l_nor3_1_2.Y sg13cmos5l_dlygate4sd3_1_31.X VGND.t280 VGND.t560 sg13_lv_nmos ad=0.1694p pd=1.21u as=0.2618p ps=2.22u w=0.77u l=0.13u
X2600 VPWR.t748 sg13cmos5l_dfrbpq_1_56.RESET_B a_15782_6918# VPWR.t2 sg13_lv_pmos ad=0.36237p pd=2.605u as=79.8f ps=0.8u w=0.42u l=0.13u
X2601 VGND.t145 a_19642_6132# a_19361_6434# VGND.t1402 sg13_lv_nmos ad=79.8f pd=0.8u as=0.1428p ps=1.52u w=0.42u l=0.5u
X2602 a_14938_4620# sg13cmos5l_dfrbpq_1_55.Q VPWR.t360 VPWR.t43 sg13_lv_pmos ad=0.1428p pd=1.52u as=0.1523p ps=1.38u w=0.42u l=0.13u
X2603 a_28940_1596# sg13cmos5l_buf_1_0.A.t1 VGND.t499 VGND.t753 sg13_lv_nmos ad=0.187p pd=1.78u as=0.14875p ps=1.16u w=0.55u l=0.13u
X2604 a_19654_883# sg13cmos5l_buf_1_1.X.t2 VGND.t101 VGND.t100 sg13_lv_nmos ad=37.8f pd=0.6u as=0.1701p ps=1.65u w=0.42u l=0.13u
X2605 VGND.t25 sg13cmos5l_dfrbpq_1_56.RESET_B a_15780_6606# VGND.t826 sg13_lv_nmos ad=0.1626p pd=1.415u as=60.89999f ps=0.71u w=0.42u l=0.13u
X2606 a_21849_8745# a_20907_8552# a_21647_8507# VPWR.t0 sg13_lv_pmos ad=93.45f pd=0.865u as=0.2048p ps=1.63u w=0.42u l=0.13u
X2607 sg13cmos5l_and2_1_1.A a_18843_5410# VGND.t133 VGND.t1390 sg13_lv_nmos ad=0.1406p pd=1.12u as=0.1406p ps=1.12u w=0.74u l=0.13u
X2608 VGND.t824 a_17109_4703# a_16188_5017# VGND.t1251 sg13_lv_nmos ad=0.1626p pd=1.415u as=0.2516p ps=2.16u w=0.74u l=0.13u
X2609 VPWR.t1111 a_19526_8434# a_19638_8498# VPWR.t0 sg13_lv_pmos ad=0.2254p pd=1.53u as=0.34p ps=2.68u w=1u l=0.5u
X2610 sg13cmos5l_buf_8_4.A a_7594_5374# VGND.t131 VGND.t1166 sg13_lv_nmos ad=0.1406p pd=1.12u as=0.1406p ps=1.12u w=0.74u l=0.13u
X2611 a_16452_5419# a_16683_5528# a_16138_5629# VGND.t1241 sg13_lv_nmos ad=0.2373p pd=1.97u as=79.8f ps=0.8u w=0.42u l=0.13u
X2612 a_22330_2350# sg13cmos5l_dlygate4sd3_1_13.A VGND.t17 VGND.t253 sg13_lv_nmos ad=0.1428p pd=1.52u as=79.8f ps=0.8u w=0.42u l=0.13u
X2613 VGND.t65 a_21813_7076# a_20892_6882# VGND.t64 sg13_lv_nmos ad=0.1626p pd=1.415u as=0.2516p ps=2.16u w=0.74u l=0.13u
X2614 VGND.t393 VPWR.t28 VGND.t1525 VGND.t1524 sg13_lv_nmos ad=79.8f pd=0.8u as=0 ps=0 w=0.42u l=1u
X2615 VPWR.t79 a_21435_3514# sg13cmos5l_buf_8_2.X VPWR.t10 sg13_lv_pmos ad=0.2128p pd=1.5u as=0.2128p ps=1.5u w=1.12u l=0.13u
X2616 a_18278_3582# sg13cmos5l_nor4_2_1.D VPWR.t1006 VPWR.t10 sg13_lv_pmos ad=79.8f pd=0.8u as=0.1428p ps=1.52u w=0.42u l=0.13u
X2617 a_10702_2697# a_10444_2382# VPWR.t91 VPWR.t10 sg13_lv_pmos ad=93.45f pd=0.865u as=1.43285p ps=9.125u w=0.42u l=0.13u
X2618 VPWR.t1243 a_18843_5410# sg13cmos5l_and2_1_1.A VPWR.t7 sg13_lv_pmos ad=0.3864p pd=2.93u as=0.2128p ps=1.5u w=1.12u l=0.13u
X2619 VPWR.t347 a_8591_8041# a_9258_7680# VPWR.t2 sg13_lv_pmos ad=0.2128p pd=1.5u as=0.3864p ps=2.93u w=1.12u l=0.13u
X2620 a_6359_4703# a_5663_4627# a_6453_4703# VGND.t855 sg13_lv_nmos ad=0.1296p pd=1.52u as=79.8f ps=0.8u w=0.42u l=0.13u
X2621 VGND.t131 sg13cmos5l_dlygate4sd3_1_52.A a_9176_4697# VGND.t295 sg13_lv_nmos ad=79.8f pd=0.8u as=0.1428p ps=1.52u w=0.42u l=0.13u
X2622 VPWR.t214 a_14364_1993# a_15387_1679# VPWR.t15 sg13_lv_pmos ad=0.1563p pd=1.22u as=63f ps=0.72u w=0.42u l=0.13u
X2623 a_9110_2057# a_7932_1993# a_8714_1912# VGND.t870 sg13_lv_nmos ad=37.8f pd=0.6u as=0.1428p ps=1.52u w=0.42u l=0.13u
X2624 a_19402_1093# a_19845_849# a_19785_1261# VPWR.t15 sg13_lv_pmos ad=79.8f pd=0.8u as=63f ps=0.72u w=0.42u l=0.13u
X2625 a_14217_3191# a_13860_3148# VPWR.t524 VPWR.t10 sg13_lv_pmos ad=63f pd=0.72u as=0.1563p ps=1.22u w=0.42u l=0.13u
X2626 a_7620_8105# a_7332_7684# a_7558_8105# VGND.t431 sg13_lv_nmos ad=0.1428p pd=1.52u as=37.8f ps=0.6u w=0.42u l=0.13u
X2627 a_26052_5419# a_25764_5724# a_25990_5419# VGND.t564 sg13_lv_nmos ad=0.1428p pd=1.52u as=37.8f ps=0.6u w=0.42u l=0.13u
X2628 a_10308_7236# a_10827_7040# a_11567_6995# VGND.t969 sg13_lv_nmos ad=0.3473p pd=2.71u as=0.12665p ps=1.145u w=0.74u l=0.13u
X2629 VPWR.t6 sg13cmos5l_buf_1_0.X.t9 a_23558_6918# VPWR.t2 sg13_lv_pmos ad=0.36237p pd=2.605u as=79.8f ps=0.8u w=0.42u l=0.13u
X2630 sg13cmos5l_nor3_1_0.Y sg13cmos5l_nor3_1_0.C VGND.t172 VGND.t1338 sg13_lv_nmos ad=0.2618p pd=2.22u as=0.1463p ps=1.15u w=0.77u l=0.13u
X2631 a_21435_3514# sg13cmos5l_and2_1_0.X VPWR.t113 VPWR.t10 sg13_lv_pmos ad=0.2128p pd=1.5u as=0.2128p ps=1.5u w=1.12u l=0.13u
X2632 VGND.t20 VPWR.t4 VGND.t20 VGND.t1465 sg13_lv_nmos ad=79.8f pd=0.8u as=0 ps=0 w=0.42u l=1u
X2633 VGND.t45 a_27418_6132# a_27137_6434# VGND.t1254 sg13_lv_nmos ad=79.8f pd=0.8u as=0.1428p ps=1.52u w=0.42u l=0.5u
X2634 a_24261_6897# sg13cmos5l_dfrbpq_1_46.CLK VGND.t25 VGND.t24 sg13_lv_nmos ad=0.2516p pd=2.16u as=3.31142p ps=20.535u w=0.74u l=0.13u
X2635 sg13cmos5l_and2_1_1.A a_18843_5410# VPWR.t1239 VPWR.t7 sg13_lv_pmos ad=0.2128p pd=1.5u as=0.2128p ps=1.5u w=1.12u l=0.13u
X2636 a_9232_2602# a_8975_2459# a_9394_2382# VGND.t607 sg13_lv_nmos ad=0.1428p pd=1.52u as=37.8f ps=0.6u w=0.42u l=0.13u
X2637 VPWR.t7 a_7696_6410# a_7641_6291# VPWR.t7 sg13_lv_pmos ad=1.46065p pd=9.335u as=93.45f ps=0.865u w=0.42u l=0.13u
X2638 a_7594_5374# sg13cmos5l_buf_8_9.A VPWR.t1323 VPWR.t7 sg13_lv_pmos ad=0.3808p pd=2.92u as=0.2128p ps=1.5u w=1.12u l=0.13u
X2639 a_14343_1719# a_14495_1603# VPWR.t105 VPWR.t15 sg13_lv_pmos ad=0.3864p pd=2.93u as=1.50275p ps=9.57u w=1.12u l=0.13u
X2640 a_16425_7309# a_16068_7236# VPWR.t259 VPWR.t2 sg13_lv_pmos ad=63f pd=0.72u as=0.1563p ps=1.22u w=0.42u l=0.13u
X2641 a_20805_4667# sg13cmos5l_dfrbpq_1_2.CLK VGND.t30 VGND.t29 sg13_lv_nmos ad=0.2516p pd=2.16u as=3.5351p ps=22.08u w=0.74u l=0.13u
X2642 VPWR.t225 a_28174_4923# sg13cmos5l_nor3_1_0.C VPWR.t43 sg13_lv_pmos ad=0.2254p pd=1.53u as=0.4256p ps=3u w=1.12u l=0.13u
X2643 VGND.t558 sg13cmos5l_dfrbpq_1_57.RESET_B.t5 a_10538_6606# VGND.t557 sg13_lv_nmos ad=79.8f pd=0.8u as=37.8f ps=0.6u w=0.42u l=0.13u
X2644 VGND.t83 VPWR.t1463 VGND.t83 VGND.t1491 sg13_lv_nmos ad=0.1428p pd=1.52u as=0 ps=0 w=0.42u l=1u
X2645 a_4202_4656# sg13cmos5l_nor4_2_9.D sg13cmos5l_nor4_2_9.Y VPWR.t43 sg13_lv_pmos ad=0.3808p pd=2.92u as=0.2128p ps=1.5u w=1.12u l=0.13u
X2646 a_4972_2070# a_4759_1596# VPWR.t105 VPWR.t15 sg13_lv_pmos ad=79.8f pd=0.8u as=1.50275p ps=9.57u w=0.42u l=0.13u
X2647 a_17529_7233# a_16587_7040# a_17327_6995# VPWR.t2 sg13_lv_pmos ad=93.45f pd=0.865u as=0.2048p ps=1.63u w=0.42u l=0.13u
X2648 a_10725_6897# sg13cmos5l_dfrbpq_1_57.CLK VPWR.t2 VPWR.t2 sg13_lv_pmos ad=0.4088p pd=2.97u as=1.31957p ps=8.38u w=1.12u l=0.13u
X2649 VPWR.t105 sg13cmos5l_dfrbpq_1_13.CLK a_7103_1140# VPWR.t15 sg13_lv_pmos ad=1.46697p pd=9.345u as=0.4088p ps=2.97u w=1.12u l=0.13u
X2650 VGND.t11 a_26830_2571# sg13cmos5l_nor4_2_0.B VGND.t79 sg13_lv_nmos ad=0.1426p pd=1.16u as=0.2516p ps=2.16u w=0.74u l=0.13u
X2651 VPWR.t1377 VGND.t96 VPWR.t1379 VPWR.t2 sg13_lv_pmos ad=0.19p pd=1.38u as=0 ps=0 w=1u l=1u
X2652 a_1397_5026# sg13cmos5l_xnor2_1_12.B VGND.t30 VGND.t30 sg13_lv_nmos ad=0.1406p pd=1.12u as=0.1898p ps=1.36u w=0.74u l=0.13u
X2653 sg13cmos5l_dlygate4sd3_1_17.X a_27990_2450# VGND.t11 VGND.t811 sg13_lv_nmos ad=0.2516p pd=2.16u as=0.1426p ps=1.16u w=0.74u l=0.13u
X2654 a_21813_7076# a_20871_7136# a_21674_7076# VGND.t64 sg13_lv_nmos ad=79.8f pd=0.8u as=0.2373p ps=1.97u w=0.42u l=0.13u
X2655 VPWR.t79 a_21934_2571# sg13cmos5l_nor4_2_1.A VPWR.t10 sg13_lv_pmos ad=0.2254p pd=1.53u as=0.4256p ps=3u w=1.12u l=0.13u
X2656 VGND.t572 a_11733_3191# a_10812_3505# VGND.t1131 sg13_lv_nmos ad=0.1626p pd=1.415u as=0.2516p ps=2.16u w=0.74u l=0.13u
X2657 VPWR.t43 a_18213_3873# a_18315_4016# VPWR.t43 sg13_lv_pmos ad=1.3927p pd=8.9u as=0.3864p ps=2.93u w=1.12u l=0.13u
X2658 VGND.t115 a_6250_2350# sg13cmos5l_dfrbpq_1_13.CLK VGND.t1385 sg13_lv_nmos ad=0.1406p pd=1.12u as=0.1406p ps=1.12u w=0.74u l=0.13u
X2659 VPWR.t4 VGND.t20 VPWR.t3 VPWR.t2 sg13_lv_pmos ad=0.34p pd=2.68u as=0 ps=0 w=1u l=1u
X2660 VPWR.t1039 a_7594_5374# sg13cmos5l_buf_8_4.A VPWR.t7 sg13_lv_pmos ad=0.2128p pd=1.5u as=0.2128p ps=1.5u w=1.12u l=0.13u
X2661 a_19428_1188# a_19402_1093# VPWR.t144 VPWR.t15 sg13_lv_pmos ad=0.34p pd=2.68u as=0.36237p ps=2.605u w=1u l=0.13u
X2662 a_7306_7648# a_7749_7691# a_7689_7727# VPWR.t2 sg13_lv_pmos ad=79.8f pd=0.8u as=63f ps=0.72u w=0.42u l=0.13u
X2663 VPWR.t2 a_7792_7138# a_7737_7233# VPWR.t2 sg13_lv_pmos ad=1.34765p pd=8.56u as=93.45f ps=0.865u w=0.42u l=0.13u
X2664 VGND.t45 a_27952_7138# a_27601_6995# VGND.t1267 sg13_lv_nmos ad=79.8f pd=0.8u as=0.1428p ps=1.52u w=0.42u l=0.13u
X2665 VPWR.t385 a_27214_1899# sg13cmos5l_nor4_2_0.D VPWR.t15 sg13_lv_pmos ad=0.2254p pd=1.53u as=0.4256p ps=3u w=1.12u l=0.13u
X2666 a_3904_4656# sg13cmos5l_dlygate4sd3_1_19.X a_4202_4656# VPWR.t43 sg13_lv_pmos ad=0.3808p pd=2.92u as=0.2128p ps=1.5u w=1.12u l=0.13u
X2667 VPWR.t697 sg13cmos5l_dfrbpq_1_56.RESET_B a_15878_5406# VPWR.t7 sg13_lv_pmos ad=0.36237p pd=2.605u as=79.8f ps=0.8u w=0.42u l=0.13u
X2668 a_17015_4703# a_16319_4627# a_17109_4703# VGND.t1175 sg13_lv_nmos ad=0.1296p pd=1.52u as=79.8f ps=0.8u w=0.42u l=0.13u
X2669 sg13cmos5l_dlygate4sd3_1_15.A a_22314_4192# VPWR.t577 VPWR.t43 sg13_lv_pmos ad=0.3808p pd=2.92u as=0.2128p ps=1.5u w=1.12u l=0.13u
X2670 VGND.t117 sg13cmos5l_buf_1_11.A a_2920_8468# VGND.t737 sg13_lv_nmos ad=0.14875p pd=1.16u as=0.187p ps=1.78u w=0.55u l=0.13u
X2671 VPWR.t105 sg13cmos5l_buf_1_1.X.t6 a_18604_2070# VPWR.t15 sg13_lv_pmos ad=1.46697p pd=9.345u as=79.8f ps=0.8u w=0.42u l=0.13u
X2672 a_3590_3582# sg13cmos5l_dlygate4sd3_1_23.X VPWR.t1300 VPWR.t10 sg13_lv_pmos ad=79.8f pd=0.8u as=0.1428p ps=1.52u w=0.42u l=0.13u
X2673 sg13cmos5l_dfrbpq_1_21.RESET_B a_2920_8468# VGND.t117 VGND.t839 sg13_lv_nmos ad=0.2886p pd=2.26u as=0.14875p ps=1.16u w=0.74u l=0.13u
X2674 a_27280_4898# a_27023_5017# a_27442_5094# VGND.t200 sg13_lv_nmos ad=0.1428p pd=1.52u as=37.8f ps=0.6u w=0.42u l=0.13u
X2675 a_10665_5797# a_10308_5724# VPWR.t332 VPWR.t7 sg13_lv_pmos ad=63f pd=0.72u as=0.1563p ps=1.22u w=0.42u l=0.13u
X2676 a_1152_1185# sg13cmos5l_xnor2_1_6.B a_1115_916# VGND.t1551 sg13_lv_nmos ad=0.2176p pd=1.96u as=78.39999f ps=0.885u w=0.64u l=0.13u
X2677 sg13cmos5l_dfrbpq_1_13.CLK a_6250_2350# VGND.t115 VGND.t1382 sg13_lv_nmos ad=0.1406p pd=1.12u as=0.1406p ps=1.12u w=0.74u l=0.13u
X2678 a_5135_8507# a_4293_8409# a_5041_8507# VGND.t1037 sg13_lv_nmos ad=0.12665p pd=1.145u as=0.1428p ps=1.52u w=0.42u l=0.13u
X2679 a_17510_3894# sg13cmos5l_nor3_1_0.A VPWR.t589 VPWR.t43 sg13_lv_pmos ad=79.8f pd=0.8u as=0.1428p ps=1.52u w=0.42u l=0.13u
X2680 a_25478_8430# sg13cmos5l_dlygate4sd3_1_4.X VPWR.t1067 VPWR.t0 sg13_lv_pmos ad=79.8f pd=0.8u as=0.1428p ps=1.52u w=0.42u l=0.13u
X2681 a_20687_947# a_19845_849# a_19428_1188# VPWR.t15 sg13_lv_pmos ad=0.2048p pd=1.63u as=0.34p ps=2.68u w=1u l=0.13u
X2682 a_25737_7727# a_25380_7684# VPWR.t309 VPWR.t2 sg13_lv_pmos ad=63f pd=0.72u as=0.1563p ps=1.22u w=0.42u l=0.13u
X2683 a_17762_5094# sg13cmos5l_dfrbpq_1_56.RESET_B VGND.t824 VGND.t836 sg13_lv_nmos ad=60.89999f pd=0.71u as=0.1626p ps=1.415u w=0.42u l=0.13u
X2684 a_24394_2605# a_24837_2361# a_24777_2773# VPWR.t10 sg13_lv_pmos ad=79.8f pd=0.8u as=63f ps=0.72u w=0.42u l=0.13u
X2685 a_4233_3191# a_3876_3148# VPWR.t681 VPWR.t10 sg13_lv_pmos ad=63f pd=0.72u as=0.1563p ps=1.22u w=0.42u l=0.13u
X2686 a_25509_849# sg13cmos5l_dfrbpq_1_0.CLK VGND.t35 VGND.t1629 sg13_lv_nmos ad=0.2516p pd=2.16u as=5.40863p ps=35.155u w=0.74u l=0.13u
X2687 a_28174_4923# a_28289_4922# VPWR.t225 VPWR.t43 sg13_lv_pmos ad=0.34p pd=2.68u as=0.2254p ps=1.53u w=1u l=0.5u
X2688 VPWR.t1 a_4293_8409# a_4395_8552# VPWR.t0 sg13_lv_pmos ad=1.8922p pd=12.27u as=0.3864p ps=2.93u w=1.12u l=0.13u
X2689 a_23846_3898# a_23576_3898# VGND.t54 VGND.t202 sg13_lv_nmos ad=0.1428p pd=1.52u as=79.8f ps=0.8u w=0.42u l=0.5u
X2690 a_10308_1636# a_10827_1643# a_11567_1993# VGND.t320 sg13_lv_nmos ad=0.3473p pd=2.71u as=0.12665p ps=1.145u w=0.74u l=0.13u
X2691 VGND.t205 sg13cmos5l_dfrbpq_1_21.RESET_B.t1 a_5558_2395# VGND.t730 sg13_lv_nmos ad=0.1701p pd=1.65u as=37.8f ps=0.6u w=0.42u l=0.13u
X2692 VPWR.t1079 en[0] a_1000_8468# VPWR.t0 sg13_lv_pmos ad=0.2114p pd=1.54u as=0.2856p ps=2.36u w=0.84u l=0.13u
X2693 a_21904_8650# sg13cmos5l_buf_1_0.X.t14 VPWR.t1 VPWR.t0 sg13_lv_pmos ad=79.8f pd=0.8u as=1.8922p ps=12.27u w=0.42u l=0.13u
X2694 VGND.t365 a_13563_874# sg13cmos5l_dfrbpq_1_11.CLK VGND.t516 sg13_lv_nmos ad=0.2516p pd=2.16u as=0.1406p ps=1.12u w=0.74u l=0.13u
X2695 VGND.t167 a_9446_874# a_9558_938# VGND.t556 sg13_lv_nmos ad=0.1426p pd=1.16u as=0.1428p ps=1.52u w=0.42u l=0.5u
X2696 a_7930_4620# sg13cmos5l_dlygate4sd3_1_58.A VGND.t131 VGND.t1600 sg13_lv_nmos ad=0.1428p pd=1.52u as=79.8f ps=0.8u w=0.42u l=0.13u
X2697 a_18144_4695# sg13cmos5l_nor4_2_1.A VPWR.t615 VPWR.t43 sg13_lv_pmos ad=0.1596p pd=1.22u as=0.4536p ps=2.76u w=0.84u l=0.13u
X2698 a_27023_5017# a_26181_4667# a_26929_5017# VGND.t200 sg13_lv_nmos ad=0.12665p pd=1.145u as=0.1428p ps=1.52u w=0.42u l=0.13u
X2699 a_27878_2386# a_27608_2386# VPWR.t369 VPWR.t10 sg13_lv_pmos ad=0.34p pd=2.68u as=0.1523p ps=1.38u w=1u l=0.5u
X2700 a_14277_2361# sg13cmos5l_dfrbpq_1_11.CLK VGND.t77 VGND.t1351 sg13_lv_nmos ad=0.2516p pd=2.16u as=3.06955p ps=19.355u w=0.74u l=0.13u
X2701 a_24900_3148# a_24874_3112# VPWR.t1128 VPWR.t10 sg13_lv_pmos ad=0.34p pd=2.68u as=0.36237p ps=2.605u w=1u l=0.13u
X2702 VGND.t50 a_14277_3155# a_14379_3155# VGND.t1362 sg13_lv_nmos ad=3.8943p pd=24.355u as=0.2516p ps=2.16u w=0.74u l=0.13u
X2703 a_25029_6179# sg13cmos5l_dfrbpq_1_53.CLK VPWR.t7 VPWR.t7 sg13_lv_pmos ad=0.4088p pd=2.97u as=1.42587p ps=9.11u w=1.12u l=0.13u
X2704 a_5135_8507# a_4293_8409# a_3876_8748# VPWR.t0 sg13_lv_pmos ad=0.2048p pd=1.63u as=0.34p ps=2.68u w=1u l=0.13u
X2705 VGND.t160 VPWR.t183 VGND.t160 VGND.t1540 sg13_lv_nmos ad=0.1428p pd=1.52u as=0 ps=0 w=0.42u l=1u
X2706 VGND.t128 sg13cmos5l_dlygate4sd3_1_6.X a_23861_6538# VGND.t64 sg13_lv_nmos ad=0.1898p pd=1.36u as=0.2516p ps=2.16u w=0.74u l=0.13u
X2707 VPWR.t7 a_26128_6410# a_26073_6291# VPWR.t7 sg13_lv_pmos ad=1.46065p pd=9.335u as=93.45f ps=0.865u w=0.42u l=0.13u
X2708 a_2259_7216# sg13cmos5l_xnor2_1_9.A VPWR.t892 VPWR.t2 sg13_lv_pmos ad=0.1428p pd=1.375u as=0.2891p ps=1.695u w=1.12u l=0.13u
X2709 VPWR.t43 sg13cmos5l_dfrbpq_1_56.CLK a_16319_4627# VPWR.t43 sg13_lv_pmos ad=1.3927p pd=8.9u as=0.4088p ps=2.97u w=1.12u l=0.13u
X2710 a_5301_1028# a_4359_1088# a_5207_1261# VPWR.t15 sg13_lv_pmos ad=79.8f pd=0.8u as=0.1428p ps=1.52u w=0.42u l=0.13u
X2711 a_24881_8484# sg13cmos5l_dlygate4sd3_1_39.X a_24849_8752# VPWR.t0 sg13_lv_pmos ad=0.34p pd=2.68u as=0.1225p ps=1.245u w=1u l=0.13u
X2712 VPWR.t79 sg13cmos5l_buf_1_1.X.t8 a_24134_2382# VPWR.t10 sg13_lv_pmos ad=0.36237p pd=2.605u as=79.8f ps=0.8u w=0.42u l=0.13u
X2713 a_13860_2700# a_13834_2605# VPWR.t518 VPWR.t10 sg13_lv_pmos ad=0.34p pd=2.68u as=0.36237p ps=2.605u w=1u l=0.13u
X2714 a_20614_5419# sg13cmos5l_buf_1_0.X.t3 VGND.t133 VGND.t138 sg13_lv_nmos ad=37.8f pd=0.6u as=0.1701p ps=1.65u w=0.42u l=0.13u
X2715 a_25287_1719# a_25439_1603# VGND.t77 VGND.t496 sg13_lv_nmos ad=0.2516p pd=2.16u as=3.25012p ps=20.49u w=0.74u l=0.13u
X2716 VPWR.t84 VGND.t280 VPWR.t83 VPWR.t2 sg13_lv_pmos ad=0.34p pd=2.68u as=0 ps=0 w=1u l=1u
X2717 a_11769_5721# a_10827_5528# a_11567_5483# VPWR.t7 sg13_lv_pmos ad=93.45f pd=0.865u as=0.2048p ps=1.63u w=0.42u l=0.13u
X2718 VPWR.t729 a_7893_8588# a_6972_8394# VPWR.t0 sg13_lv_pmos ad=0.36237p pd=2.605u as=0.34p ps=2.68u w=1u l=0.13u
X2719 a_19631_2459# a_18789_2361# a_19537_2459# VGND.t8 sg13_lv_nmos ad=0.12665p pd=1.145u as=0.1428p ps=1.52u w=0.42u l=0.13u
X2720 VPWR.t529 a_10812_2346# a_11835_2773# VPWR.t10 sg13_lv_pmos ad=0.1563p pd=1.22u as=63f ps=0.72u w=0.42u l=0.13u
X2721 VGND.t238 sg13cmos5l_xor2_1_2.A sg13cmos5l_nand3_1_1.A VGND.t928 sg13_lv_nmos ad=0.3293p pd=1.63u as=0.1406p ps=1.12u w=0.74u l=0.13u
X2722 VPWR.t820 a_4762_6886# a_4481_7108# VPWR.t2 sg13_lv_pmos ad=0.1523p pd=1.38u as=0.34p ps=2.68u w=1u l=0.5u
X2723 VPWR.t766 a_20192_7967# sg13cmos5l_dfrbpq_1_42.Q VPWR.t2 sg13_lv_pmos ad=0.2128p pd=1.5u as=0.3808p ps=2.92u w=1.12u l=0.13u
X2724 sg13cmos5l_nor4_2_5.B a_4278_6192# VGND.t453 VGND.t1035 sg13_lv_nmos ad=0.2516p pd=2.16u as=0.1426p ps=1.16u w=0.74u l=0.13u
X2725 a_20196_3894# sg13cmos5l_nor4_2_1.A a_20102_3894# VGND.t199 sg13_lv_nmos ad=60.89999f pd=0.71u as=0.1428p ps=1.52u w=0.42u l=0.13u
X2726 a_25871_6529# a_25029_6179# a_24612_6172# VPWR.t7 sg13_lv_pmos ad=0.2048p pd=1.63u as=0.34p ps=2.68u w=1u l=0.13u
X2727 a_16629_8588# a_15687_8648# a_16490_8588# VGND.t0 sg13_lv_nmos ad=79.8f pd=0.8u as=0.2373p ps=1.97u w=0.42u l=0.13u
X2728 VGND.t145 a_19609_6942# sg13cmos5l_buf_2_0.X VGND.t1196 sg13_lv_nmos ad=0.2516p pd=2.16u as=0.1406p ps=1.12u w=0.74u l=0.13u
X2729 a_26724_6931# a_26436_7236# a_26662_6931# VGND.t426 sg13_lv_nmos ad=0.1428p pd=1.52u as=37.8f ps=0.6u w=0.42u l=0.13u
X2730 a_27418_6132# sg13cmos5l_dlygate4sd3_1_39.A VPWR.t834 VPWR.t7 sg13_lv_pmos ad=0.1428p pd=1.52u as=0.1523p ps=1.38u w=0.42u l=0.13u
X2731 a_15285_1679# sg13cmos5l_dfrbpq_1_55.RESET_B VPWR.t214 VPWR.t15 sg13_lv_pmos ad=0.147p pd=1.54u as=0.1563p ps=1.22u w=0.42u l=0.13u
X2732 a_15972_6172# a_15946_6136# VPWR.t364 VPWR.t7 sg13_lv_pmos ad=0.34p pd=2.68u as=0.36237p ps=2.605u w=1u l=0.13u
X2733 a_24586_6136# a_25029_6179# a_24326_6606# VGND.t240 sg13_lv_nmos ad=79.8f pd=0.8u as=0.1296p ps=1.52u w=0.42u l=0.13u
X2734 a_13563_874# sg13cmos5l_buf_8_3.A VPWR.t469 VPWR.t15 sg13_lv_pmos ad=0.2128p pd=1.5u as=0.2128p ps=1.5u w=1.12u l=0.13u
X2735 a_20782_6918# a_20524_6918# VGND.t145 VGND.t1004 sg13_lv_nmos ad=0.1428p pd=1.52u as=79.8f ps=0.8u w=0.42u l=0.13u
X2736 VGND.t238 a_14054_8434# a_14166_8498# VGND.t970 sg13_lv_nmos ad=0.1426p pd=1.16u as=0.1428p ps=1.52u w=0.42u l=0.5u
X2737 VPWR.t105 a_20687_947# a_20944_1090# VPWR.t15 sg13_lv_pmos ad=1.50275p pd=9.57u as=79.8f ps=0.8u w=0.42u l=0.13u
X2738 VPWR.t7 a_6597_6179# a_6699_6179# VPWR.t7 sg13_lv_pmos ad=1.46065p pd=9.335u as=0.3864p ps=2.93u w=1.12u l=0.13u
X2739 a_21904_5626# a_21647_5483# a_22066_5406# VGND.t142 sg13_lv_nmos ad=0.1428p pd=1.52u as=37.8f ps=0.6u w=0.42u l=0.13u
X2740 VGND.t137 VPWR.t184 VGND.t137 VGND.t1535 sg13_lv_nmos ad=0.1428p pd=1.52u as=0 ps=0 w=0.42u l=1u
X2741 VGND.t179 a_13642_5374# sg13cmos5l_and2_1_3.A VGND.t531 sg13_lv_nmos ad=0.1406p pd=1.12u as=0.1406p ps=1.12u w=0.74u l=0.13u
X2742 VPWR.t1063 sg13cmos5l_dlygate4sd3_1_22.X a_11276_4192# VPWR.t43 sg13_lv_pmos ad=0.3808p pd=2.92u as=0.2128p ps=1.5u w=1.12u l=0.13u
X2743 a_10022_8430# a_10827_8552# a_10282_8653# VPWR.t0 sg13_lv_pmos ad=0.1428p pd=1.52u as=79.8f ps=0.8u w=0.42u l=0.13u
X2744 VPWR.t478 a_28646_3898# a_28758_3962# VPWR.t43 sg13_lv_pmos ad=0.2254p pd=1.53u as=0.34p ps=2.68u w=1u l=0.5u
X2745 a_6391_8394# a_6951_8648# a_6862_8745# VPWR.t0 sg13_lv_pmos ad=0.2048p pd=1.63u as=93.45f ps=0.865u w=0.42u l=0.13u
X2746 sg13cmos5l_nand3_1_2.B sg13cmos5l_nor4_2_7.B VGND.t203 VGND.t142 sg13_lv_nmos ad=0.1406p pd=1.12u as=0.3293p ps=1.63u w=0.74u l=0.13u
X2747 a_19823_3505# a_18981_3155# a_18564_3148# VPWR.t10 sg13_lv_pmos ad=0.2048p pd=1.63u as=0.34p ps=2.68u w=1u l=0.13u
X2748 VGND.t71 a_19893_1679# a_18972_1993# VGND.t402 sg13_lv_nmos ad=0.1626p pd=1.415u as=0.2516p ps=2.16u w=0.74u l=0.13u
X2749 sg13cmos5l_and2_1_0.X a_20973_3492# VPWR.t419 VPWR.t10 sg13_lv_pmos ad=0.3808p pd=2.92u as=0.1918p ps=1.5u w=1.12u l=0.13u
X2750 VPWR.t148 sg13cmos5l_buf_1_1.X.t15 a_20362_4117# VPWR.t43 sg13_lv_pmos ad=0.1563p pd=1.22u as=0.147p ps=1.54u w=0.42u l=0.13u
X2751 VPWR.t126 a_28570_8398# a_28289_8620# VPWR.t0 sg13_lv_pmos ad=0.1523p pd=1.38u as=0.34p ps=2.68u w=1u l=0.5u
X2752 a_19631_2459# a_18789_2361# a_18372_2700# VPWR.t10 sg13_lv_pmos ad=0.2048p pd=1.63u as=0.34p ps=2.68u w=1u l=0.13u
X2753 a_13834_3112# a_14277_3155# a_13574_3582# VGND.t694 sg13_lv_nmos ad=79.8f pd=0.8u as=0.1296p ps=1.52u w=0.42u l=0.13u
X2754 VPWR.t91 sg13cmos5l_dfrbpq_1_11.CLK a_10943_3115# VPWR.t10 sg13_lv_pmos ad=1.4003p pd=8.92u as=0.4088p ps=2.97u w=1.12u l=0.13u
X2755 a_14148_2395# a_14379_2504# a_13834_2605# VGND.t6 sg13_lv_nmos ad=0.2373p pd=1.97u as=79.8f ps=0.8u w=0.42u l=0.13u
X2756 a_25198_1755# a_24940_2070# VPWR.t153 VPWR.t15 sg13_lv_pmos ad=93.45f pd=0.865u as=1.50275p ps=9.57u w=0.42u l=0.13u
X2757 sg13cmos5l_dlygate4sd3_1_22.X a_2166_938# VPWR.t16 VPWR.t15 sg13_lv_pmos ad=0.4256p pd=3u as=0.2254p ps=1.53u w=1.12u l=0.13u
X2758 a_24837_2361# sg13cmos5l_dfrbpq_1_0.CLK VPWR.t91 VPWR.t10 sg13_lv_pmos ad=0.4088p pd=2.97u as=1.4003p ps=8.92u w=1.12u l=0.13u
X2759 sg13cmos5l_dlygate4sd3_1_28.X a_9558_6192# VPWR.t579 VPWR.t7 sg13_lv_pmos ad=0.4256p pd=3u as=0.2254p ps=1.53u w=1.12u l=0.13u
X2760 VGND.t205 sg13cmos5l_dfrbpq_1_13.RESET_B.t12 a_5066_2070# VGND.t389 sg13_lv_nmos ad=79.8f pd=0.8u as=37.8f ps=0.6u w=0.42u l=0.13u
X2761 sg13cmos5l_buf_8_0.X a_15850_3862# VPWR.t998 VPWR.t43 sg13_lv_pmos ad=0.2128p pd=1.5u as=0.2128p ps=1.5u w=1.12u l=0.13u
X2762 a_4102_3569# sg13cmos5l_dfrbpq_1_21.RESET_B.t4 VGND.t861 VGND.t860 sg13_lv_nmos ad=37.8f pd=0.6u as=0.1701p ps=1.65u w=0.42u l=0.13u
X2763 sg13cmos5l_dlygate4sd3_1_4.X a_28758_938# VPWR.t363 VPWR.t15 sg13_lv_pmos ad=0.4256p pd=3u as=0.2254p ps=1.53u w=1.12u l=0.13u
X2764 a_28186_7644# sg13cmos5l_dlygate4sd3_1_47.A VGND.t73 VGND.t291 sg13_lv_nmos ad=0.1428p pd=1.52u as=79.8f ps=0.8u w=0.42u l=0.13u
X2765 sg13cmos5l_dlygate4sd3_1_53.A a_8202_7216# VPWR.t853 VPWR.t2 sg13_lv_pmos ad=0.3808p pd=2.92u as=0.2128p ps=1.5u w=1.12u l=0.13u
X2766 sg13cmos5l_nand3_1_2.B sg13cmos5l_dlygate4sd3_1_51.X VGND.t203 VGND.t142 sg13_lv_nmos ad=0.1406p pd=1.12u as=0.2553p ps=2.17u w=0.74u l=0.13u
X2767 a_11567_947# a_10725_849# a_10308_1188# VPWR.t15 sg13_lv_pmos ad=0.2048p pd=1.63u as=0.34p ps=2.68u w=1u l=0.13u
X2768 VPWR.t75 VGND.t83 VPWR.t54 VPWR.t43 sg13_lv_pmos ad=0.34p pd=2.68u as=0 ps=0 w=1u l=1u
X2769 VGND.t30 sg13cmos5l_dfrbpq_1_21.CLK a_5855_5676# VGND.t854 sg13_lv_nmos ad=3.32715p pd=20.78u as=0.2516p ps=2.16u w=0.74u l=0.13u
X2770 VPWR.t243 VGND.t278 VPWR.t241 VPWR.t7 sg13_lv_pmos ad=0.19p pd=1.38u as=0 ps=0 w=1u l=1u
X2771 a_18479_874# sg13cmos5l_xnor2_1_3.A VGND.t756 VGND.t812 sg13_lv_nmos ad=0.2516p pd=2.16u as=0.1898p ps=1.36u w=0.74u l=0.13u
X2772 a_26830_2571# a_26945_2572# VGND.t11 VGND.t590 sg13_lv_nmos ad=0.1428p pd=1.52u as=0.1426p ps=1.16u w=0.42u l=0.5u
X2773 a_16389_6179# sg13cmos5l_dfrbpq_1_56.CLK VGND.t25 VGND.t367 sg13_lv_nmos ad=0.2516p pd=2.16u as=3.31142p ps=20.535u w=0.74u l=0.13u
X2774 VPWR.t207 sg13cmos5l_buf_8_0.X a_13642_5374# VPWR.t7 sg13_lv_pmos ad=0.2128p pd=1.5u as=0.2128p ps=1.5u w=1.12u l=0.13u
X2775 VPWR.t1263 a_8975_2459# a_9642_2680# VPWR.t10 sg13_lv_pmos ad=0.2128p pd=1.5u as=0.3864p ps=2.93u w=1.12u l=0.13u
X2776 VPWR.t996 a_15850_3862# sg13cmos5l_buf_8_0.X VPWR.t43 sg13_lv_pmos ad=0.2128p pd=1.5u as=0.2128p ps=1.5u w=1.12u l=0.13u
X2777 VGND.t572 sg13cmos5l_dlygate4sd3_1_22.X sg13cmos5l_nand3_1_3.B VGND.t1198 sg13_lv_nmos ad=0.3293p pd=1.63u as=0.1406p ps=1.12u w=0.74u l=0.13u
X2778 a_20745_8821# a_20388_8748# VPWR.t288 VPWR.t0 sg13_lv_pmos ad=63f pd=0.72u as=0.1563p ps=1.22u w=0.42u l=0.13u
X2779 VGND.t286 sg13cmos5l_and2_1_1.X a_23835_8050# VGND.t1263 sg13_lv_nmos ad=0.1406p pd=1.12u as=0.2553p ps=2.17u w=0.74u l=0.13u
X2780 sg13cmos5l_nor4_2_5.Y sg13cmos5l_nor4_2_5.D a_4730_6168# VPWR.t7 sg13_lv_pmos ad=0.2128p pd=1.5u as=0.3808p ps=2.92u w=1.12u l=0.13u
X2781 a_5450_5406# a_5143_5370# a_5356_5406# VGND.t51 sg13_lv_nmos ad=37.8f pd=0.6u as=0.1428p ps=1.52u w=0.42u l=0.13u
X2782 VPWR.t2 a_26896_7922# a_26841_7803# VPWR.t2 sg13_lv_pmos ad=1.34765p pd=8.56u as=93.45f ps=0.865u w=0.42u l=0.13u
X2783 VPWR.t969 sg13cmos5l_buf_8_10.A a_8842_6886# VPWR.t2 sg13_lv_pmos ad=0.2128p pd=1.5u as=0.2128p ps=1.5u w=1.12u l=0.13u
X2784 a_28931_7216# sg13cmos5l_dlygate4sd3_1_17.X a_28829_7216# VPWR.t2 sg13_lv_pmos ad=0.2464p pd=1.56u as=0.2128p ps=1.5u w=1.12u l=0.13u
X2785 VPWR.t227 sg13cmos5l_dlygate4sd3_1_51.A a_23576_4697# VPWR.t43 sg13_lv_pmos ad=0.1523p pd=1.38u as=0.1428p ps=1.52u w=0.42u l=0.13u
X2786 sg13cmos5l_dlygate4sd3_1_2.A a_27114_4192# VPWR.t664 VPWR.t43 sg13_lv_pmos ad=0.3808p pd=2.92u as=0.2128p ps=1.5u w=1.12u l=0.13u
X2787 a_18862_2070# a_18604_2070# VGND.t77 VGND.t483 sg13_lv_nmos ad=0.1428p pd=1.52u as=79.8f ps=0.8u w=0.42u l=0.13u
X2788 a_4762_6886# sg13cmos5l_dfrbpq_1_58.Q VGND.t453 VGND.t907 sg13_lv_nmos ad=0.1428p pd=1.52u as=79.8f ps=0.8u w=0.42u l=0.13u
X2789 VGND.t216 sg13cmos5l_nor4_2_0.B sg13cmos5l_nand3_1_0.B VGND.t215 sg13_lv_nmos ad=0.1406p pd=1.12u as=0.1406p ps=1.12u w=0.74u l=0.13u
X2790 sg13cmos5l_and2_1_3.A a_13642_5374# VPWR.t491 VPWR.t7 sg13_lv_pmos ad=0.2128p pd=1.5u as=0.2128p ps=1.5u w=1.12u l=0.13u
X2791 VGND.t58 a_27195_3514# sg13cmos5l_dfrbpq_1_0.CLK VGND.t261 sg13_lv_nmos ad=0.1406p pd=1.12u as=0.1406p ps=1.12u w=0.74u l=0.13u
X2792 a_10231_7644# a_10791_7767# a_10702_7803# VPWR.t2 sg13_lv_pmos ad=0.2048p pd=1.63u as=93.45f ps=0.865u w=0.42u l=0.13u
X2793 a_22070_8105# a_20892_8041# a_21674_7960# VGND.t887 sg13_lv_nmos ad=37.8f pd=0.6u as=0.1428p ps=1.52u w=0.42u l=0.13u
X2794 VPWR.t2 a_8591_8041# a_8848_7922# VPWR.t2 sg13_lv_pmos ad=1.34765p pd=8.56u as=79.8f ps=0.8u w=0.42u l=0.13u
X2795 a_10308_8748# a_10282_8653# VPWR.t137 VPWR.t0 sg13_lv_pmos ad=0.34p pd=2.68u as=0.36237p ps=2.605u w=1u l=0.13u
X2796 sg13cmos5l_dfrbpq_1_57.CLK a_8842_6886# VPWR.t958 VPWR.t2 sg13_lv_pmos ad=0.2128p pd=1.5u as=0.2128p ps=1.5u w=1.12u l=0.13u
X2797 a_10116_870# sg13cmos5l_dlygate4sd3_1_18.X a_10022_870# VGND.t1204 sg13_lv_nmos ad=60.89999f pd=0.71u as=0.1428p ps=1.52u w=0.42u l=0.13u
X2798 sg13cmos5l_buf_8_3.A a_9915_3898# VGND.t50 VGND.t1581 sg13_lv_nmos ad=0.1406p pd=1.12u as=0.1406p ps=1.12u w=0.74u l=0.13u
X2799 VGND.t0 a_26181_8409# a_26283_8552# VGND.t272 sg13_lv_nmos ad=3.41162p pd=21.215u as=0.2516p ps=2.16u w=0.74u l=0.13u
X2800 VPWR.t2 a_11824_7138# a_11769_7233# VPWR.t2 sg13_lv_pmos ad=1.34765p pd=8.56u as=93.45f ps=0.865u w=0.42u l=0.13u
X2801 a_5134_7803# a_4876_8118# VPWR.t2 VPWR.t2 sg13_lv_pmos ad=93.45f pd=0.865u as=1.34765p ps=8.56u w=0.42u l=0.13u
X2802 VPWR.t1199 sg13cmos5l_xnor2_1_12.Y a_2016_4695# VPWR.t43 sg13_lv_pmos ad=0.2891p pd=1.695u as=0.1596p ps=1.22u w=0.84u l=0.13u
X2803 VPWR.t153 a_26351_947# a_26608_1090# VPWR.t15 sg13_lv_pmos ad=1.50275p pd=9.57u as=79.8f ps=0.8u w=0.42u l=0.13u
X2804 a_28646_3898# a_28376_3898# VGND.t268 VGND.t1611 sg13_lv_nmos ad=0.1428p pd=1.52u as=79.8f ps=0.8u w=0.42u l=0.5u
X2805 a_27195_3514# sg13cmos5l_buf_8_2.X VGND.t58 VGND.t781 sg13_lv_nmos ad=0.1406p pd=1.12u as=0.1406p ps=1.12u w=0.74u l=0.13u
X2806 a_5337_4209# a_4395_4016# a_5135_3971# VPWR.t43 sg13_lv_pmos ad=93.45f pd=0.865u as=0.2048p ps=1.63u w=0.42u l=0.13u
X2807 a_20944_1090# a_20687_947# a_21106_870# VGND.t233 sg13_lv_nmos ad=0.1428p pd=1.52u as=37.8f ps=0.6u w=0.42u l=0.13u
X2808 a_10791_4743# a_10943_4627# VGND.t30 VGND.t1420 sg13_lv_nmos ad=0.2516p pd=2.16u as=3.5351p ps=22.08u w=0.74u l=0.13u
X2809 sg13cmos5l_dlygate4sd3_1_21.X a_1302_1656# VPWR.t94 VPWR.t15 sg13_lv_pmos ad=0.4256p pd=3u as=0.2254p ps=1.53u w=1.12u l=0.13u
X2810 VPWR.t956 a_8842_6886# sg13cmos5l_dfrbpq_1_57.CLK VPWR.t2 sg13_lv_pmos ad=0.2128p pd=1.5u as=0.2128p ps=1.5u w=1.12u l=0.13u
X2811 a_4270_2382# a_4511_2652# a_3799_2346# VGND.t617 sg13_lv_nmos ad=0.1428p pd=1.52u as=0.12665p ps=1.145u w=0.42u l=0.13u
X2812 a_4380_2346# a_4511_2652# a_3799_2346# VPWR.t10 sg13_lv_pmos ad=0.34p pd=2.68u as=0.2048p ps=1.63u w=1u l=0.13u
X2813 a_16452_5419# a_16164_5724# a_16390_5419# VGND.t825 sg13_lv_nmos ad=0.1428p pd=1.52u as=37.8f ps=0.6u w=0.42u l=0.13u
X2814 a_6862_870# a_7103_1140# a_6391_834# VGND.t1670 sg13_lv_nmos ad=0.1428p pd=1.52u as=0.12665p ps=1.145u w=0.42u l=0.13u
X2815 VGND.t133 a_18826_4620# sg13cmos5l_dfrbpq_1_2.CLK VGND.t1135 sg13_lv_nmos ad=0.1406p pd=1.12u as=0.1406p ps=1.12u w=0.74u l=0.13u
X2816 a_11567_1993# a_10725_1643# a_11473_1993# VGND.t481 sg13_lv_nmos ad=0.12665p pd=1.145u as=0.1428p ps=1.52u w=0.42u l=0.13u
X2817 VGND.t150 a_2266_2350# a_1985_2572# VGND.t474 sg13_lv_nmos ad=79.8f pd=0.8u as=0.1428p ps=1.52u w=0.42u l=0.5u
X2818 VPWR.t1061 sg13cmos5l_dlygate4sd3_1_22.X a_5207_1261# VPWR.t15 sg13_lv_pmos ad=0.1428p pd=1.52u as=79.8f ps=0.8u w=0.42u l=0.13u
X2819 a_5894_6606# a_6699_6179# a_6154_6136# VPWR.t7 sg13_lv_pmos ad=0.1428p pd=1.52u as=79.8f ps=0.8u w=0.42u l=0.13u
X2820 a_10702_6291# a_10444_6606# VPWR.t7 VPWR.t7 sg13_lv_pmos ad=93.45f pd=0.865u as=1.46065p ps=9.335u w=0.42u l=0.13u
X2821 sg13cmos5l_dlygate4sd3_1_10.A a_22314_4656# VPWR.t577 VPWR.t43 sg13_lv_pmos ad=0.3808p pd=2.92u as=0.2128p ps=1.5u w=1.12u l=0.13u
X2822 VGND.t205 a_4186_1596# a_3905_1898# VGND.t387 sg13_lv_nmos ad=79.8f pd=0.8u as=0.1428p ps=1.52u w=0.42u l=0.5u
X2823 a_3680_1045# a_3799_834# VPWR.t464 VPWR.t15 sg13_lv_pmos ad=0.3864p pd=2.93u as=0.2128p ps=1.5u w=1.12u l=0.13u
X2824 a_19312_4114# a_19055_3971# a_19474_3894# VGND.t198 sg13_lv_nmos ad=0.1428p pd=1.52u as=37.8f ps=0.6u w=0.42u l=0.13u
X2825 a_7995_4285# a_7103_4164# a_7893_4052# VPWR.t43 sg13_lv_pmos ad=63f pd=0.72u as=79.8f ps=0.8u w=0.42u l=0.13u
X2826 VGND.t491 a_18380_7644# sg13cmos5l_buf_1_2.A VGND.t0 sg13_lv_nmos ad=0.14875p pd=1.16u as=0.2886p ps=2.26u w=0.74u l=0.13u
X2827 a_23861_6538# sg13cmos5l_dfrbpq_1_46.D VGND.t128 VGND.t64 sg13_lv_nmos ad=0.1406p pd=1.12u as=0.1898p ps=1.36u w=0.74u l=0.13u
X2828 VGND.t332 a_14235_6922# sg13cmos5l_buf_8_10.A VGND.t95 sg13_lv_nmos ad=0.1406p pd=1.12u as=0.1406p ps=1.12u w=0.74u l=0.13u
X2829 VGND.t861 VPWR.t1455 VGND.t861 VGND.t1506 sg13_lv_nmos ad=79.8f pd=0.8u as=0 ps=0 w=0.42u l=1u
X2830 a_11639_7727# sg13cmos5l_dfrbpq_1_57.RESET_B.t11 VPWR.t425 VPWR.t2 sg13_lv_pmos ad=79.8f pd=0.8u as=0.36237p ps=2.605u w=0.42u l=0.13u
X2831 VPWR.t7 sg13cmos5l_dfrbpq_1_21.CLK a_5855_5676# VPWR.t7 sg13_lv_pmos ad=1.46065p pd=9.335u as=0.4088p ps=2.97u w=1.12u l=0.13u
X2832 sg13cmos5l_xnor2_1_13.Y a_2016_4695# a_2165_5026# VGND.t30 sg13_lv_nmos ad=0.2516p pd=2.16u as=0.1406p ps=1.12u w=0.74u l=0.13u
X2833 VGND.t608 a_9232_2602# a_8881_2459# VGND.t607 sg13_lv_nmos ad=79.8f pd=0.8u as=0.1428p ps=1.52u w=0.42u l=0.13u
X2834 sg13cmos5l_buf_8_3.A a_9915_3898# VGND.t50 VGND.t1577 sg13_lv_nmos ad=0.1406p pd=1.12u as=0.1406p ps=1.12u w=0.74u l=0.13u
X2835 VGND.t50 sg13cmos5l_dfrbpq_1_21.RESET_B.t5 a_8150_3907# VGND.t440 sg13_lv_nmos ad=0.1701p pd=1.65u as=37.8f ps=0.6u w=0.42u l=0.13u
X2836 a_23844_7236# a_23818_7141# VPWR.t6 VPWR.t2 sg13_lv_pmos ad=0.34p pd=2.68u as=0.36237p ps=2.605u w=1u l=0.13u
X2837 a_24526_4923# a_24641_4922# VGND.t203 VGND.t142 sg13_lv_nmos ad=0.1428p pd=1.52u as=0.1426p ps=1.16u w=0.42u l=0.5u
X2838 VPWR.t414 sg13cmos5l_buf_1_1.X.t10 a_18346_2605# VPWR.t10 sg13_lv_pmos ad=0.1563p pd=1.22u as=0.147p ps=1.54u w=0.42u l=0.13u
X2839 VGND.t40 sg13cmos5l_dfrbpq_1_35.Q a_13784_8434# VGND.t113 sg13_lv_nmos ad=79.8f pd=0.8u as=0.1428p ps=1.52u w=0.42u l=0.13u
X2840 a_2266_7644# sg13cmos5l_dlygate4sd3_1_34.A VGND.t117 VGND.t1246 sg13_lv_nmos ad=0.1428p pd=1.52u as=79.8f ps=0.8u w=0.42u l=0.13u
X2841 VPWR.t836 sg13cmos5l_dfrbpq_1_58.RESET_B a_6250_7141# VPWR.t2 sg13_lv_pmos ad=0.1563p pd=1.22u as=0.147p ps=1.54u w=0.42u l=0.13u
X2842 a_16356_6931# a_16587_7040# a_16042_7141# VGND.t1026 sg13_lv_nmos ad=0.2373p pd=1.97u as=79.8f ps=0.8u w=0.42u l=0.13u
X2843 sg13cmos5l_dlygate4sd3_1_58.A a_8106_6168# VGND.t418 VGND.t549 sg13_lv_nmos ad=0.2516p pd=2.16u as=0.1406p ps=1.12u w=0.74u l=0.13u
X2844 a_6167_1679# a_5471_1603# a_6261_1679# VGND.t224 sg13_lv_nmos ad=0.1296p pd=1.52u as=79.8f ps=0.8u w=0.42u l=0.13u
X2845 a_9506_2070# sg13cmos5l_dfrbpq_1_13.RESET_B.t9 VGND.t608 VGND.t1292 sg13_lv_nmos ad=60.89999f pd=0.71u as=0.1626p ps=1.415u w=0.42u l=0.13u
X2846 a_16581_5385# sg13cmos5l_dfrbpq_1_56.CLK VGND.t30 VGND.t372 sg13_lv_nmos ad=0.2516p pd=2.16u as=3.32715p ps=20.78u w=0.74u l=0.13u
X2847 a_7744_3144# sg13cmos5l_xnor2_1_6.B a_7532_3144# VPWR.t10 sg13_lv_pmos ad=0.2128p pd=1.5u as=0.2128p ps=1.5u w=1.12u l=0.13u
X2848 VGND.t50 sg13cmos5l_buf_8_5.A a_9915_3898# VGND.t1330 sg13_lv_nmos ad=0.1406p pd=1.12u as=0.1406p ps=1.12u w=0.74u l=0.13u
X2849 a_5403_2773# a_4511_2652# a_5301_2540# VPWR.t10 sg13_lv_pmos ad=63f pd=0.72u as=79.8f ps=0.8u w=0.42u l=0.13u
X2850 VPWR.t91 sg13cmos5l_dfrbpq_1_21.CLK a_4511_2652# VPWR.t10 sg13_lv_pmos ad=1.4003p pd=8.92u as=0.4088p ps=2.97u w=1.12u l=0.13u
X2851 VPWR.t918 a_4166_6168# a_4278_6192# VPWR.t7 sg13_lv_pmos ad=0.2254p pd=1.53u as=0.34p ps=2.68u w=1u l=0.5u
X2852 a_11733_6215# sg13cmos5l_dfrbpq_1_57.RESET_B.t4 VPWR.t141 VPWR.t7 sg13_lv_pmos ad=0.147p pd=1.54u as=0.1563p ps=1.22u w=0.42u l=0.13u
X2853 a_4832_4943# a_4951_4620# VGND.t52 VGND.t30 sg13_lv_nmos ad=0.2516p pd=2.16u as=0.1406p ps=1.12u w=0.74u l=0.13u
X2854 VPWR.t108 sg13cmos5l_dfrbpq_1_13.RESET_B.t2 a_10282_1093# VPWR.t15 sg13_lv_pmos ad=0.1563p pd=1.22u as=0.147p ps=1.54u w=0.42u l=0.13u
X2855 sg13cmos5l_dfrbpq_1_23.D a_8694_4680# VGND.t131 VGND.t637 sg13_lv_nmos ad=0.2516p pd=2.16u as=0.1426p ps=1.16u w=0.74u l=0.13u
X2856 a_10812_8041# a_10943_7651# a_10231_7644# VPWR.t2 sg13_lv_pmos ad=0.34p pd=2.68u as=0.2048p ps=1.63u w=1u l=0.13u
X2857 VPWR.t696 sg13cmos5l_buf_1_4.X.t6 a_25162_4117# VPWR.t43 sg13_lv_pmos ad=0.1563p pd=1.22u as=0.147p ps=1.54u w=0.42u l=0.13u
X2858 a_6422_8105# a_5244_8041# a_6026_7960# VGND.t1605 sg13_lv_nmos ad=37.8f pd=0.6u as=0.1428p ps=1.52u w=0.42u l=0.13u
X2859 a_19893_1679# a_18951_1719# a_19799_1679# VPWR.t15 sg13_lv_pmos ad=79.8f pd=0.8u as=0.1428p ps=1.52u w=0.42u l=0.13u
X2860 VPWR.t1277 sg13cmos5l_xnor2_1_6.A a_7532_3144# VPWR.t10 sg13_lv_pmos ad=0.3808p pd=2.92u as=0.2128p ps=1.5u w=1.12u l=0.13u
X2861 VGND.t357 a_8591_8041# a_9258_7680# VGND.t356 sg13_lv_nmos ad=0.1406p pd=1.12u as=0.2516p ps=2.16u w=0.74u l=0.13u
X2862 a_13574_3582# a_14379_3155# a_13834_3112# VPWR.t10 sg13_lv_pmos ad=0.1428p pd=1.52u as=79.8f ps=0.8u w=0.42u l=0.13u
X2863 VPWR.t797 a_18010_8398# a_17729_8620# VPWR.t0 sg13_lv_pmos ad=0.1523p pd=1.38u as=0.34p ps=2.68u w=1u l=0.5u
X2864 a_16164_5724# a_16138_5629# VPWR.t697 VPWR.t7 sg13_lv_pmos ad=0.34p pd=2.68u as=0.36237p ps=2.605u w=1u l=0.13u
X2865 sg13cmos5l_dfrbpq_1_56.CLK a_18363_6922# VGND.t145 VGND.t979 sg13_lv_nmos ad=0.1406p pd=1.12u as=0.1406p ps=1.12u w=0.74u l=0.13u
X2866 VPWR.t344 sg13cmos5l_dfrbpq_1_56.Q a_15032_5410# VPWR.t7 sg13_lv_pmos ad=0.1523p pd=1.38u as=0.1428p ps=1.52u w=0.42u l=0.13u
X2867 VPWR.t79 a_21435_3514# sg13cmos5l_buf_8_2.X VPWR.t10 sg13_lv_pmos ad=0.3864p pd=2.93u as=0.2128p ps=1.5u w=1.12u l=0.13u
X2868 VPWR.t1347 sg13cmos5l_buf_8_4.A a_8763_8434# VPWR.t0 sg13_lv_pmos ad=0.2128p pd=1.5u as=0.3808p ps=2.92u w=1.12u l=0.13u
X2869 a_11639_6215# a_10943_6139# a_11733_6215# VGND.t584 sg13_lv_nmos ad=0.1296p pd=1.52u as=79.8f ps=0.8u w=0.42u l=0.13u
X2870 VGND.t172 sg13cmos5l_nor3_1_1.C sg13cmos5l_nor3_1_1.Y VGND.t1182 sg13_lv_nmos ad=0.1463p pd=1.15u as=0.2618p ps=2.22u w=0.77u l=0.13u
X2871 sg13cmos5l_dfrbpq_1_21.CLK a_6250_3108# VGND.t50 VGND.t674 sg13_lv_nmos ad=0.1406p pd=1.12u as=0.1406p ps=1.12u w=0.74u l=0.13u
X2872 VGND.t508 sg13cmos5l_dlygate4sd3_1_18.A a_9176_874# VGND.t1454 sg13_lv_nmos ad=79.8f pd=0.8u as=0.1428p ps=1.52u w=0.42u l=0.13u
X2873 sg13cmos5l_nand3_1_0.B sg13cmos5l_nor4_2_0.D a_24170_1168# VPWR.t15 sg13_lv_pmos ad=0.2128p pd=1.5u as=0.3808p ps=2.92u w=1.12u l=0.13u
X2874 VPWR.t7 a_27280_5626# a_27225_5721# VPWR.t7 sg13_lv_pmos ad=1.46065p pd=9.335u as=93.45f ps=0.865u w=0.42u l=0.13u
X2875 a_24261_6897# sg13cmos5l_dfrbpq_1_46.CLK VPWR.t2 VPWR.t2 sg13_lv_pmos ad=0.4088p pd=2.97u as=1.31957p ps=8.38u w=1.12u l=0.13u
X2876 VGND.t32 VPWR.t17 VGND.t32 VGND.t1537 sg13_lv_nmos ad=79.8f pd=0.8u as=0 ps=0 w=0.42u l=1u
X2877 a_17472_1671# sg13cmos5l_xnor2_1_1.B a_17435_1980# VGND.t155 sg13_lv_nmos ad=0.2176p pd=1.96u as=78.39999f ps=0.885u w=0.64u l=0.13u
X2878 VPWR.t1231 a_6250_2350# sg13cmos5l_dfrbpq_1_13.CLK VPWR.t10 sg13_lv_pmos ad=0.2128p pd=1.5u as=0.2128p ps=1.5u w=1.12u l=0.13u
X2879 sg13cmos5l_buf_8_2.X a_21435_3514# VPWR.t79 VPWR.t10 sg13_lv_pmos ad=0.2128p pd=1.5u as=0.2128p ps=1.5u w=1.12u l=0.13u
X2880 VPWR.t815 a_19823_3505# a_20490_3144# VPWR.t10 sg13_lv_pmos ad=0.2128p pd=1.5u as=0.3864p ps=2.93u w=1.12u l=0.13u
X2881 VGND.t874 a_17518_7947# sg13cmos5l_nor3_1_4.A VGND.t0 sg13_lv_nmos ad=0.1426p pd=1.16u as=0.2516p ps=2.16u w=0.74u l=0.13u
X2882 sg13cmos5l_dfrbpq_1_53.CLK a_27963_6538# VPWR.t1313 VPWR.t7 sg13_lv_pmos ad=0.2128p pd=1.5u as=0.2128p ps=1.5u w=1.12u l=0.13u
X2883 VGND.t50 a_20805_3873# a_20907_4016# VGND.t1148 sg13_lv_nmos ad=3.8943p pd=24.355u as=0.2516p ps=2.16u w=0.74u l=0.13u
X2884 VPWR.t173 a_20892_8041# a_21915_7727# VPWR.t2 sg13_lv_pmos ad=0.1563p pd=1.22u as=63f ps=0.72u w=0.42u l=0.13u
X2885 a_7535_6995# a_6693_6897# a_6276_7236# VPWR.t2 sg13_lv_pmos ad=0.2048p pd=1.63u as=0.34p ps=2.68u w=1u l=0.13u
X2886 VGND.t341 a_27280_4898# a_26929_5017# VGND.t200 sg13_lv_nmos ad=79.8f pd=0.8u as=0.1428p ps=1.52u w=0.42u l=0.13u
X2887 a_11986_2070# sg13cmos5l_dfrbpq_1_13.RESET_B.t7 VGND.t393 VGND.t392 sg13_lv_nmos ad=37.8f pd=0.6u as=79.8f ps=0.8u w=0.42u l=0.13u
X2888 VGND.t11 a_27610_1596# a_27329_1898# VGND.t1217 sg13_lv_nmos ad=79.8f pd=0.8u as=0.1428p ps=1.52u w=0.42u l=0.5u
X2889 VGND.t50 a_6250_3108# sg13cmos5l_dfrbpq_1_21.CLK VGND.t674 sg13_lv_nmos ad=0.1406p pd=1.12u as=0.1406p ps=1.12u w=0.74u l=0.13u
X2890 a_24837_2361# sg13cmos5l_dfrbpq_1_0.CLK VGND.t77 VGND.t76 sg13_lv_nmos ad=0.2516p pd=2.16u as=3.06955p ps=19.355u w=0.74u l=0.13u
X2891 a_16485_6897# sg13cmos5l_dfrbpq_1_56.CLK VGND.t25 VGND.t368 sg13_lv_nmos ad=0.2516p pd=2.16u as=3.31142p ps=20.535u w=0.74u l=0.13u
X2892 a_24170_1168# sg13cmos5l_nor4_2_0.C a_23872_1168# VPWR.t15 sg13_lv_pmos ad=0.2128p pd=1.5u as=0.2128p ps=1.5u w=1.12u l=0.13u
X2893 VGND.t203 VPWR.t76 VGND.t143 VGND.t142 sg13_lv_nmos ad=0.1428p pd=1.52u as=0 ps=0 w=0.42u l=1u
X2894 VPWR.t105 sg13cmos5l_dfrbpq_1_13.RESET_B.t6 a_4012_870# VPWR.t15 sg13_lv_pmos ad=1.46697p pd=9.345u as=79.8f ps=0.8u w=0.42u l=0.13u
X2895 a_4186_1596# sg13cmos5l_dlygate4sd3_1_19.A VPWR.t228 VPWR.t15 sg13_lv_pmos ad=0.1428p pd=1.52u as=0.1523p ps=1.38u w=0.42u l=0.13u
X2896 VPWR.t389 a_26639_8041# a_27306_7680# VPWR.t2 sg13_lv_pmos ad=0.2128p pd=1.5u as=0.3864p ps=2.93u w=1.12u l=0.13u
X2897 a_6276_7236# a_6250_7141# VGND.t25 VGND.t908 sg13_lv_nmos ad=0.2516p pd=2.16u as=0.1626p ps=1.415u w=0.74u l=0.13u
X2898 sg13cmos5l_dlygate4sd3_1_47.A a_22314_8728# VGND.t20 VGND.t340 sg13_lv_nmos ad=0.2516p pd=2.16u as=0.1406p ps=1.12u w=0.74u l=0.13u
X2899 VPWR.t2 a_15525_7691# a_15627_7691# VPWR.t2 sg13_lv_pmos ad=1.34765p pd=8.56u as=0.3864p ps=2.93u w=1.12u l=0.13u
X2900 a_3790_1899# a_3905_1898# VGND.t150 VGND.t815 sg13_lv_nmos ad=0.1428p pd=1.52u as=0.1426p ps=1.16u w=0.42u l=0.5u
X2901 VPWR.t891 sg13cmos5l_buf_8_11.A a_27963_6538# VPWR.t7 sg13_lv_pmos ad=0.2128p pd=1.5u as=0.2128p ps=1.5u w=1.12u l=0.13u
X2902 sg13cmos5l_dfrbpq_1_13.CLK a_6250_2350# VPWR.t1227 VPWR.t10 sg13_lv_pmos ad=0.2128p pd=1.5u as=0.2128p ps=1.5u w=1.12u l=0.13u
X2903 a_4293_3873# sg13cmos5l_dfrbpq_1_21.CLK VGND.t50 VGND.t1331 sg13_lv_nmos ad=0.2516p pd=2.16u as=3.63467p ps=22.73u w=0.74u l=0.13u
X2904 a_20102_8430# sg13cmos5l_dlygate4sd3_1_6.X VPWR.t1253 VPWR.t0 sg13_lv_pmos ad=79.8f pd=0.8u as=0.1428p ps=1.52u w=0.42u l=0.13u
X2905 a_7140_8118# sg13cmos5l_nor4_2_5.C a_7046_8118# VGND.t1094 sg13_lv_nmos ad=60.89999f pd=0.71u as=0.1428p ps=1.52u w=0.42u l=0.13u
X2906 sg13cmos5l_dfrbpq_1_57.RESET_B a_8776_5444# VPWR.t163 VPWR.t7 sg13_lv_pmos ad=0.42p pd=2.99u as=0.2114p ps=1.54u w=1.12u l=0.13u
X2907 a_12386_5094# sg13cmos5l_dfrbpq_1_57.RESET_B.t0 VGND.t83 VGND.t84 sg13_lv_nmos ad=60.89999f pd=0.71u as=0.1626p ps=1.415u w=0.42u l=0.13u
X2908 a_10725_8409# sg13cmos5l_dfrbpq_1_57.CLK VGND.t0 VGND.t1097 sg13_lv_nmos ad=0.2516p pd=2.16u as=3.2221p ps=20.04u w=0.74u l=0.13u
X2909 a_16581_5385# sg13cmos5l_dfrbpq_1_56.CLK VPWR.t7 VPWR.t7 sg13_lv_pmos ad=0.4088p pd=2.97u as=1.42587p ps=9.11u w=1.12u l=0.13u
X2910 VGND.t572 VPWR.t1457 VGND.t572 VGND.t1507 sg13_lv_nmos ad=0.1428p pd=1.52u as=0 ps=0 w=0.42u l=1u
X2911 a_28652_7644# en[3] VPWR.t290 VPWR.t2 sg13_lv_pmos ad=0.2856p pd=2.36u as=0.2114p ps=1.54u w=0.84u l=0.13u
X2912 a_24326_6606# a_25131_6179# a_24586_6136# VPWR.t7 sg13_lv_pmos ad=0.1428p pd=1.52u as=79.8f ps=0.8u w=0.42u l=0.13u
X2913 VGND.t278 a_2266_6132# a_1985_6434# VGND.t1104 sg13_lv_nmos ad=79.8f pd=0.8u as=0.1428p ps=1.52u w=0.42u l=0.5u
X2914 sg13cmos5l_nand3_1_1.B sg13cmos5l_nor4_2_4.D a_14186_6168# VPWR.t7 sg13_lv_pmos ad=0.2128p pd=1.5u as=0.3808p ps=2.92u w=1.12u l=0.13u
X2915 VPWR.t317 a_26351_947# a_27018_1168# VPWR.t15 sg13_lv_pmos ad=0.2128p pd=1.5u as=0.3864p ps=2.93u w=1.12u l=0.13u
X2916 a_10022_2070# a_10827_1643# a_10282_1600# VPWR.t15 sg13_lv_pmos ad=0.1428p pd=1.52u as=79.8f ps=0.8u w=0.42u l=0.13u
X2917 a_3794_6926# sg13cmos5l_nor3_1_2.Y VGND.t278 VGND.t960 sg13_lv_nmos ad=0.1406p pd=1.12u as=0.2886p ps=2.26u w=0.74u l=0.13u
X2918 VPWR.t575 a_15302_5410# a_15414_5474# VPWR.t7 sg13_lv_pmos ad=0.2254p pd=1.53u as=0.34p ps=2.68u w=1u l=0.5u
X2919 a_7351_1596# a_7911_1719# a_7822_1755# VPWR.t15 sg13_lv_pmos ad=0.2048p pd=1.63u as=93.45f ps=0.865u w=0.42u l=0.13u
X2920 VPWR.t155 a_6261_1679# a_5340_1993# VPWR.t15 sg13_lv_pmos ad=0.36237p pd=2.605u as=0.34p ps=2.68u w=1u l=0.13u
X2921 a_7799_8821# sg13cmos5l_dfrbpq_1_21.RESET_B.t13 VPWR.t729 VPWR.t0 sg13_lv_pmos ad=79.8f pd=0.8u as=0.36237p ps=2.605u w=0.42u l=0.13u
X2922 a_25668_8105# a_25899_7691# a_25354_7648# VGND.t897 sg13_lv_nmos ad=0.2373p pd=1.97u as=79.8f ps=0.8u w=0.42u l=0.13u
X2923 a_23818_7141# a_24261_6897# a_23558_6918# VGND.t4 sg13_lv_nmos ad=79.8f pd=0.8u as=0.1296p ps=1.52u w=0.42u l=0.13u
X2924 a_18922_7644# sg13cmos5l_buf_8_11.A VGND.t995 VGND.t0 sg13_lv_nmos ad=0.1406p pd=1.12u as=0.1406p ps=1.12u w=0.74u l=0.13u
X2925 a_6250_2350# sg13cmos5l_buf_8_3.A VGND.t115 VGND.t766 sg13_lv_nmos ad=0.1406p pd=1.12u as=0.1406p ps=1.12u w=0.74u l=0.13u
X2926 a_13745_3948# sg13cmos5l_xor2_1_2.B a_13713_4216# VPWR.t43 sg13_lv_pmos ad=0.34p pd=2.68u as=0.1225p ps=1.245u w=1u l=0.13u
X2927 a_16042_7141# a_16485_6897# a_16425_7309# VPWR.t2 sg13_lv_pmos ad=79.8f pd=0.8u as=63f ps=0.72u w=0.42u l=0.13u
X2928 VPWR.t62 VGND.t1510 VPWR.t61 VPWR.t43 sg13_lv_pmos ad=0.34p pd=2.68u as=0 ps=0 w=1u l=1u
X2929 a_25354_7648# a_25797_7691# a_25737_7727# VPWR.t2 sg13_lv_pmos ad=79.8f pd=0.8u as=63f ps=0.72u w=0.42u l=0.13u
X2930 VPWR.t535 a_3680_5609# sg13cmos5l_buf_8_5.A VPWR.t7 sg13_lv_pmos ad=0.1918p pd=1.5u as=0.3808p ps=2.92u w=1.12u l=0.13u
X2931 sg13cmos5l_nor4_2_5.D a_3990_7704# VGND.t69 VGND.t68 sg13_lv_nmos ad=0.2516p pd=2.16u as=0.1426p ps=1.16u w=0.74u l=0.13u
X2932 a_23675_6516# sg13cmos5l_dlygate4sd3_1_6.X VGND.t65 VGND.t64 sg13_lv_nmos ad=78.39999f pd=0.885u as=0.2272p ps=1.99u w=0.64u l=0.13u
X2933 sg13cmos5l_dfrbpq_1_59.Q a_15786_2680# VPWR.t505 VPWR.t10 sg13_lv_pmos ad=0.3808p pd=2.92u as=0.2128p ps=1.5u w=1.12u l=0.13u
X2934 a_5223_7767# a_5375_7651# VGND.t0 VGND.t992 sg13_lv_nmos ad=0.2516p pd=2.16u as=3.41162p ps=21.215u w=0.74u l=0.13u
X2935 a_7716_2700# a_7690_2605# VGND.t115 VGND.t746 sg13_lv_nmos ad=0.2516p pd=2.16u as=0.1626p ps=1.415u w=0.74u l=0.13u
X2936 a_17770_4117# a_18213_3873# a_17510_3894# VGND.t59 sg13_lv_nmos ad=79.8f pd=0.8u as=0.1296p ps=1.52u w=0.42u l=0.13u
X2937 a_27610_1596# sg13cmos5l_dlygate4sd3_1_2.A VPWR.t343 VPWR.t15 sg13_lv_pmos ad=0.1428p pd=1.52u as=0.1523p ps=1.38u w=0.42u l=0.13u
X2938 a_18874_8398# sg13cmos5l_dfrbpq_1_29.Q VPWR.t1151 VPWR.t0 sg13_lv_pmos ad=0.1428p pd=1.52u as=0.1523p ps=1.38u w=0.42u l=0.13u
X2939 VGND.t25 sg13cmos5l_dfrbpq_1_46.CLK a_21023_7188# VGND.t26 sg13_lv_nmos ad=3.31142p pd=20.535u as=0.2516p ps=2.16u w=0.74u l=0.13u
X2940 VGND.t106 a_19823_3505# a_20490_3144# VGND.t901 sg13_lv_nmos ad=0.1406p pd=1.12u as=0.2516p ps=2.16u w=0.74u l=0.13u
X2941 a_10116_6918# sg13cmos5l_dlygate4sd3_1_28.X a_10022_6918# VGND.t966 sg13_lv_nmos ad=60.89999f pd=0.71u as=0.1428p ps=1.52u w=0.42u l=0.13u
X2942 sg13cmos5l_xnor2_1_8.Y a_2016_5721# a_2165_5410# VGND.t195 sg13_lv_nmos ad=0.2516p pd=2.16u as=0.1406p ps=1.12u w=0.74u l=0.13u
X2943 a_21647_5483# a_20805_5385# a_21553_5483# VGND.t142 sg13_lv_nmos ad=0.12665p pd=1.145u as=0.1428p ps=1.52u w=0.42u l=0.13u
X2944 VGND.t203 a_23846_4656# a_23958_4680# VGND.t142 sg13_lv_nmos ad=0.1426p pd=1.16u as=0.1428p ps=1.52u w=0.42u l=0.5u
X2945 VPWR.t303 a_2016_7233# sg13cmos5l_dfrbpq_1_15.D VPWR.t2 sg13_lv_pmos ad=0.3808p pd=2.92u as=0.2408p ps=1.55u w=1.12u l=0.13u
X2946 a_10282_5629# a_10725_5385# a_10665_5797# VPWR.t7 sg13_lv_pmos ad=79.8f pd=0.8u as=63f ps=0.72u w=0.42u l=0.13u
X2947 VGND.t145 a_19246_6435# sg13cmos5l_nor3_1_4.B VGND.t1368 sg13_lv_nmos ad=0.1426p pd=1.16u as=0.2516p ps=2.16u w=0.74u l=0.13u
X2948 VGND.t299 sg13cmos5l_dfrbpq_1_53.RESET_B.t10 a_25572_8430# VGND.t647 sg13_lv_nmos ad=0.1626p pd=1.415u as=60.89999f ps=0.71u w=0.42u l=0.13u
X2949 VGND.t65 a_21904_6410# a_21553_6529# VGND.t423 sg13_lv_nmos ad=79.8f pd=0.8u as=0.1428p ps=1.52u w=0.42u l=0.13u
X2950 VGND.t325 a_20192_7967# sg13cmos5l_dfrbpq_1_42.Q VGND.t0 sg13_lv_nmos ad=0.1406p pd=1.12u as=0.2516p ps=2.16u w=0.74u l=0.13u
X2951 VGND.t630 a_9446_6168# a_9558_6192# VGND.t629 sg13_lv_nmos ad=0.1426p pd=1.16u as=0.1428p ps=1.52u w=0.42u l=0.5u
X2952 a_10702_8118# a_10444_8118# VGND.t322 VGND.t321 sg13_lv_nmos ad=0.1428p pd=1.52u as=79.8f ps=0.8u w=0.42u l=0.13u
X2953 VGND.t35 sg13cmos5l_xnor2_1_6.A a_1301_874# VGND.t1435 sg13_lv_nmos ad=0.1898p pd=1.36u as=0.2516p ps=2.16u w=0.74u l=0.13u
X2954 VPWR.t352 a_13563_874# sg13cmos5l_dfrbpq_1_11.CLK VPWR.t15 sg13_lv_pmos ad=0.3864p pd=2.93u as=0.2128p ps=1.5u w=1.12u l=0.13u
X2955 a_20805_6179# sg13cmos5l_dfrbpq_1_46.CLK VGND.t25 VGND.t28 sg13_lv_nmos ad=0.2516p pd=2.16u as=3.31142p ps=20.535u w=0.74u l=0.13u
X2956 a_20687_947# a_19845_849# a_20593_947# VGND.t1153 sg13_lv_nmos ad=0.12665p pd=1.145u as=0.1428p ps=1.52u w=0.42u l=0.13u
X2957 VGND.t50 a_15850_3862# sg13cmos5l_buf_8_0.X VGND.t1113 sg13_lv_nmos ad=0.1406p pd=1.12u as=0.1406p ps=1.12u w=0.74u l=0.13u
X2958 a_27695_6995# a_26853_6897# a_27601_6995# VGND.t1077 sg13_lv_nmos ad=0.12665p pd=1.145u as=0.1428p ps=1.52u w=0.42u l=0.13u
X2959 a_20676_5081# a_20388_4660# a_20614_5081# VGND.t667 sg13_lv_nmos ad=0.1428p pd=1.52u as=37.8f ps=0.6u w=0.42u l=0.13u
X2960 VPWR.t2 sg13cmos5l_dfrbpq_1_46.CLK a_21023_7651# VPWR.t2 sg13_lv_pmos ad=1.31957p pd=8.38u as=0.4088p ps=2.97u w=1.12u l=0.13u
X2961 VPWR.t57 VGND.t572 VPWR.t56 VPWR.t43 sg13_lv_pmos ad=0.34p pd=2.68u as=0 ps=0 w=1u l=1u
X2962 VPWR.t363 a_28646_874# a_28758_938# VPWR.t15 sg13_lv_pmos ad=0.2254p pd=1.53u as=0.34p ps=2.68u w=1u l=0.5u
X2963 sg13cmos5l_dfrbpq_1_2.CLK a_18826_4620# VPWR.t1012 VPWR.t43 sg13_lv_pmos ad=0.2128p pd=1.5u as=0.3864p ps=2.93u w=1.12u l=0.13u
X2964 VPWR.t1002 sg13cmos5l_dfrbpq_1_12.D a_1340_3144# VPWR.t10 sg13_lv_pmos ad=0.2128p pd=1.5u as=0.3808p ps=2.92u w=1.12u l=0.13u
X2965 VPWR.t600 sg13cmos5l_dfrbpq_1_57.RESET_B.t8 a_10282_7141# VPWR.t2 sg13_lv_pmos ad=0.1563p pd=1.22u as=0.147p ps=1.54u w=0.42u l=0.13u
X2966 VPWR.t2 a_7535_6995# a_7792_7138# VPWR.t2 sg13_lv_pmos ad=1.34765p pd=8.56u as=79.8f ps=0.8u w=0.42u l=0.13u
X2967 VPWR.t1115 a_28570_5374# a_28289_5596# VPWR.t7 sg13_lv_pmos ad=0.1523p pd=1.38u as=0.34p ps=2.68u w=1u l=0.5u
X2968 VGND.t17 a_22138_1596# a_21857_1898# VGND.t1666 sg13_lv_nmos ad=79.8f pd=0.8u as=0.1428p ps=1.52u w=0.42u l=0.5u
X2969 a_10596_883# a_10827_992# a_10282_1093# VGND.t168 sg13_lv_nmos ad=0.2373p pd=1.97u as=79.8f ps=0.8u w=0.42u l=0.13u
X2970 a_26639_8041# a_25797_7691# a_26545_8041# VGND.t409 sg13_lv_nmos ad=0.12665p pd=1.145u as=0.1428p ps=1.52u w=0.42u l=0.13u
X2971 sg13cmos5l_dfrbpq_1_11.CLK a_13563_874# VPWR.t469 VPWR.t15 sg13_lv_pmos ad=0.2128p pd=1.5u as=0.2128p ps=1.5u w=1.12u l=0.13u
X2972 VPWR.t1381 VGND.t96 VPWR.t1380 VPWR.t2 sg13_lv_pmos ad=0.34p pd=2.68u as=0 ps=0 w=1u l=1u
X2973 VGND.t45 a_27022_6435# sg13cmos5l_dlygate4sd3_1_39.X VGND.t44 sg13_lv_nmos ad=0.1426p pd=1.16u as=0.2516p ps=2.16u w=0.74u l=0.13u
X2974 a_28570_8398# sg13cmos5l_dfrbpq_1_53.Q VGND.t73 VGND.t72 sg13_lv_nmos ad=0.1428p pd=1.52u as=79.8f ps=0.8u w=0.42u l=0.13u
X2975 sg13cmos5l_dfrbpq_1_46.CLK a_18922_7644# VGND.t800 VGND.t0 sg13_lv_nmos ad=0.1406p pd=1.12u as=0.1406p ps=1.12u w=0.74u l=0.13u
X2976 a_27225_4779# a_26283_4667# a_27023_5017# VPWR.t43 sg13_lv_pmos ad=93.45f pd=0.865u as=0.2048p ps=1.63u w=0.42u l=0.13u
X2977 sg13cmos5l_nand3_1_0.B sg13cmos5l_nor4_2_0.C VGND.t216 VGND.t720 sg13_lv_nmos ad=0.1406p pd=1.12u as=0.1406p ps=1.12u w=0.74u l=0.13u
X2978 VPWR.t494 a_9446_5410# a_9558_5474# VPWR.t7 sg13_lv_pmos ad=0.2254p pd=1.53u as=0.34p ps=2.68u w=1u l=0.5u
X2979 VGND.t77 sg13cmos5l_dfrbpq_1_21.CLK a_4511_2652# VGND.t618 sg13_lv_nmos ad=3.25012p pd=20.49u as=0.2516p ps=2.16u w=0.74u l=0.13u
X2980 a_6862_8430# a_6604_8430# VGND.t312 VGND.t1064 sg13_lv_nmos ad=0.1428p pd=1.52u as=79.8f ps=0.8u w=0.42u l=0.13u
X2981 a_25738_4624# a_26181_4667# a_25478_5094# VGND.t334 sg13_lv_nmos ad=79.8f pd=0.8u as=0.1296p ps=1.52u w=0.42u l=0.13u
X2982 VPWR.t499 sg13cmos5l_dlygate4sd3_1_21.X a_6167_1679# VPWR.t15 sg13_lv_pmos ad=0.1428p pd=1.52u as=79.8f ps=0.8u w=0.42u l=0.13u
X2983 VGND.t203 sg13cmos5l_nor4_2_7.D sg13cmos5l_nand3_1_2.B VGND.t142 sg13_lv_nmos ad=0.2516p pd=2.16u as=0.1406p ps=1.12u w=0.74u l=0.13u
X2984 a_1979_5004# sg13cmos5l_xnor2_1_13.A VGND.t30 VGND.t30 sg13_lv_nmos ad=78.39999f pd=0.885u as=0.2272p ps=1.99u w=0.64u l=0.13u
X2985 VPWR.t133 a_10812_5017# a_11835_4703# VPWR.t43 sg13_lv_pmos ad=0.1563p pd=1.22u as=63f ps=0.72u w=0.42u l=0.13u
X2986 a_18180_2382# sg13cmos5l_xnor2_1_1.Y a_18086_2382# VGND.t147 sg13_lv_nmos ad=60.89999f pd=0.71u as=0.1428p ps=1.52u w=0.42u l=0.13u
X2987 VGND.t133 sg13cmos5l_nor4_2_1.A a_18293_5026# VGND.t669 sg13_lv_nmos ad=0.1898p pd=1.36u as=0.2516p ps=2.16u w=0.74u l=0.13u
X2988 a_26229_1679# a_25287_1719# a_26090_1912# VGND.t22 sg13_lv_nmos ad=79.8f pd=0.8u as=0.2373p ps=1.97u w=0.42u l=0.13u
X2989 a_14926_1059# a_15041_1060# VGND.t365 VGND.t1124 sg13_lv_nmos ad=0.1428p pd=1.52u as=0.1426p ps=1.16u w=0.42u l=0.5u
X2990 a_9446_3144# a_9176_3185# VGND.t50 VGND.t1370 sg13_lv_nmos ad=0.1428p pd=1.52u as=79.8f ps=0.8u w=0.42u l=0.5u
X2991 sg13cmos5l_nand3_1_0.B sg13cmos5l_dfrbpq_1_3.D VGND.t160 VGND.t488 sg13_lv_nmos ad=0.1406p pd=1.12u as=0.2553p ps=2.17u w=0.74u l=0.13u
X2992 VGND.t50 a_25605_3873# a_25707_4016# VGND.t1223 sg13_lv_nmos ad=3.8943p pd=24.355u as=0.2516p ps=2.16u w=0.74u l=0.13u
X2993 a_6604_8430# a_6391_8394# VPWR.t1 VPWR.t0 sg13_lv_pmos ad=79.8f pd=0.8u as=1.8922p ps=12.27u w=0.42u l=0.13u
X2994 VGND.t393 VPWR.t28 VGND.t393 VGND.t1523 sg13_lv_nmos ad=0.1428p pd=1.52u as=0 ps=0 w=0.42u l=1u
X2995 sg13cmos5l_nor3_1_1.A a_14742_3962# VPWR.t693 VPWR.t43 sg13_lv_pmos ad=0.4256p pd=3u as=0.2254p ps=1.53u w=1.12u l=0.13u
X2996 a_1395_1168# sg13cmos5l_xnor2_1_6.A VPWR.t738 VPWR.t15 sg13_lv_pmos ad=0.1428p pd=1.375u as=0.2891p ps=1.695u w=1.12u l=0.13u
X2997 VGND.t96 a_11567_6995# a_12234_7216# VGND.t1044 sg13_lv_nmos ad=0.1406p pd=1.12u as=0.2516p ps=2.16u w=0.74u l=0.13u
X2998 VGND.t1016 a_18922_7644# sg13cmos5l_dfrbpq_1_46.CLK VGND.t0 sg13_lv_nmos ad=0.1406p pd=1.12u as=0.1406p ps=1.12u w=0.74u l=0.13u
X2999 sg13cmos5l_buf_8_11.A a_23835_8050# VGND.t62 VGND.t894 sg13_lv_nmos ad=0.1406p pd=1.12u as=0.1406p ps=1.12u w=0.74u l=0.13u
X3000 a_25522_6918# sg13cmos5l_buf_1_0.X.t8 VGND.t126 VGND.t125 sg13_lv_nmos ad=37.8f pd=0.6u as=79.8f ps=0.8u w=0.42u l=0.13u
X3001 a_10112_6455# a_10231_6132# VPWR.t1396 VPWR.t7 sg13_lv_pmos ad=0.3864p pd=2.93u as=0.2128p ps=1.5u w=1.12u l=0.13u
X3002 VGND.t52 sg13cmos5l_dfrbpq_1_16.Q a_4088_5410# VGND.t345 sg13_lv_nmos ad=79.8f pd=0.8u as=0.1428p ps=1.52u w=0.42u l=0.13u
X3003 a_10022_5406# sg13cmos5l_dlygate4sd3_1_52.X VPWR.t634 VPWR.t7 sg13_lv_pmos ad=79.8f pd=0.8u as=0.1428p ps=1.52u w=0.42u l=0.13u
X3004 VGND.t50 a_19312_4114# a_18961_3971# VGND.t1374 sg13_lv_nmos ad=79.8f pd=0.8u as=0.1428p ps=1.52u w=0.42u l=0.13u
X3005 VGND.t203 sg13cmos5l_dlygate4sd3_1_9.X sg13cmos5l_nand3_1_2.B VGND.t142 sg13_lv_nmos ad=0.3293p pd=1.63u as=0.1406p ps=1.12u w=0.74u l=0.13u
X3006 VPWR.t91 a_19823_3505# a_20080_3386# VPWR.t10 sg13_lv_pmos ad=1.43285p pd=9.125u as=79.8f ps=0.8u w=0.42u l=0.13u
X3007 VGND.t259 a_27023_5017# a_27690_4656# VGND.t200 sg13_lv_nmos ad=0.1406p pd=1.12u as=0.2516p ps=2.16u w=0.74u l=0.13u
X3008 VPWR.t203 sg13cmos5l_buf_1_4.X.t2 a_24806_870# VPWR.t15 sg13_lv_pmos ad=0.36237p pd=2.605u as=79.8f ps=0.8u w=0.42u l=0.13u
X3009 a_20102_5094# a_20907_4667# a_20362_4624# VPWR.t43 sg13_lv_pmos ad=0.1428p pd=1.52u as=79.8f ps=0.8u w=0.42u l=0.13u
X3010 VGND.t632 VPWR.t1460 VGND.t632 VGND.t1502 sg13_lv_nmos ad=0.1428p pd=1.52u as=0 ps=0 w=0.42u l=1u
X3011 VPWR.t396 sg13cmos5l_buf_1_0.X.t7 a_20362_6136# VPWR.t7 sg13_lv_pmos ad=0.1563p pd=1.22u as=0.147p ps=1.54u w=0.42u l=0.13u
X3012 VPWR.t151 a_26229_1679# a_25308_1993# VPWR.t15 sg13_lv_pmos ad=0.36237p pd=2.605u as=0.34p ps=2.68u w=1u l=0.13u
X3013 a_15322_838# sg13cmos5l_dfrbpq_1_11.Q VPWR.t214 VPWR.t15 sg13_lv_pmos ad=0.1428p pd=1.52u as=0.1523p ps=1.38u w=0.42u l=0.13u
X3014 VGND.t286 a_23835_8050# sg13cmos5l_buf_8_11.A VGND.t891 sg13_lv_nmos ad=0.1406p pd=1.12u as=0.1406p ps=1.12u w=0.74u l=0.13u
X3015 VGND.t30 a_26181_5385# a_26283_5528# VGND.t335 sg13_lv_nmos ad=3.5351p pd=22.08u as=0.2516p ps=2.16u w=0.74u l=0.13u
X3016 a_6071_7727# a_5375_7651# a_6165_7727# VGND.t993 sg13_lv_nmos ad=0.1296p pd=1.52u as=79.8f ps=0.8u w=0.42u l=0.13u
X3017 sg13cmos5l_nand3_1_1.B sg13cmos5l_dlygate4sd3_1_52.X VGND.t96 VGND.t95 sg13_lv_nmos ad=0.1406p pd=1.12u as=0.2553p ps=2.17u w=0.74u l=0.13u
X3018 VPWR.t105 a_10725_849# a_10827_992# VPWR.t15 sg13_lv_pmos ad=1.50275p pd=9.57u as=0.3864p ps=2.93u w=1.12u l=0.13u
X3019 a_15538_2382# sg13cmos5l_dfrbpq_1_55.RESET_B VGND.t553 VGND.t147 sg13_lv_nmos ad=37.8f pd=0.6u as=79.8f ps=0.8u w=0.42u l=0.13u
X3020 a_27058_8118# sg13cmos5l_dfrbpq_1_53.RESET_B.t7 VGND.t273 VGND.t300 sg13_lv_nmos ad=37.8f pd=0.6u as=79.8f ps=0.8u w=0.42u l=0.13u
X3021 a_3790_1899# a_3905_1898# VPWR.t190 VPWR.t15 sg13_lv_pmos ad=0.34p pd=2.68u as=0.2254p ps=1.53u w=1u l=0.5u
X3022 a_14054_8434# a_13784_8434# VPWR.t154 VPWR.t0 sg13_lv_pmos ad=0.34p pd=2.68u as=0.1523p ps=1.38u w=1u l=0.5u
X3023 VPWR.t1378 VGND.t96 VPWR.t1377 VPWR.t2 sg13_lv_pmos ad=0.34p pd=2.68u as=0 ps=0 w=1u l=1u
X3024 VPWR.t183 VGND.t160 VPWR.t182 VPWR.t15 sg13_lv_pmos ad=0.34p pd=2.68u as=0 ps=0 w=1u l=1u
X3025 VGND.t268 a_27195_3514# sg13cmos5l_dfrbpq_1_0.CLK VGND.t267 sg13_lv_nmos ad=0.2516p pd=2.16u as=0.1406p ps=1.12u w=0.74u l=0.13u
X3026 VGND.t800 sg13cmos5l_dfrbpq_1_42.Q a_19256_8434# VGND.t0 sg13_lv_nmos ad=79.8f pd=0.8u as=0.1428p ps=1.52u w=0.42u l=0.13u
X3027 a_4270_2697# a_4012_2382# VPWR.t91 VPWR.t10 sg13_lv_pmos ad=93.45f pd=0.865u as=1.43285p ps=9.125u w=0.42u l=0.13u
X3028 a_4366_7107# a_4481_7108# VPWR.t819 VPWR.t2 sg13_lv_pmos ad=0.34p pd=2.68u as=0.2254p ps=1.53u w=1u l=0.5u
X3029 VGND.t377 a_28646_874# a_28758_938# VGND.t1319 sg13_lv_nmos ad=0.1426p pd=1.16u as=0.1428p ps=1.52u w=0.42u l=0.5u
X3030 a_10444_8118# a_10231_7644# VPWR.t2 VPWR.t2 sg13_lv_pmos ad=79.8f pd=0.8u as=1.34765p ps=8.56u w=0.42u l=0.13u
X3031 VPWR.t200 a_7932_1993# a_8955_1679# VPWR.t15 sg13_lv_pmos ad=0.1563p pd=1.22u as=63f ps=0.72u w=0.42u l=0.13u
X3032 a_22330_2350# sg13cmos5l_dlygate4sd3_1_13.A VPWR.t79 VPWR.t10 sg13_lv_pmos ad=0.1428p pd=1.52u as=0.1523p ps=1.38u w=0.42u l=0.13u
X3033 a_18826_4620# sg13cmos5l_buf_8_2.X VGND.t133 VGND.t780 sg13_lv_nmos ad=0.2553p pd=2.17u as=0.1406p ps=1.12u w=0.74u l=0.13u
X3034 VPWR.t2 sg13cmos5l_dfrbpq_1_32.CLK a_5375_7651# VPWR.t2 sg13_lv_pmos ad=1.31957p pd=8.38u as=0.4088p ps=2.97u w=1.12u l=0.13u
X3035 a_10702_3267# a_10444_3582# VPWR.t91 VPWR.t10 sg13_lv_pmos ad=93.45f pd=0.865u as=1.43285p ps=9.125u w=0.42u l=0.13u
X3036 VGND.t40 VPWR.t1475 VGND.t40 VGND.t1463 sg13_lv_nmos ad=0.1428p pd=1.52u as=0 ps=0 w=0.42u l=1u
X3037 a_5036_6168# sg13cmos5l_nor4_2_5.B a_5334_6168# VPWR.t7 sg13_lv_pmos ad=0.3808p pd=2.92u as=0.2128p ps=1.5u w=1.12u l=0.13u
X3038 a_7534_4923# a_7649_4922# VGND.t664 VGND.t1143 sg13_lv_nmos ad=0.1428p pd=1.52u as=0.1426p ps=1.16u w=0.42u l=0.5u
X3039 a_6698_870# a_6391_834# a_6604_870# VGND.t506 sg13_lv_nmos ad=37.8f pd=0.6u as=0.1428p ps=1.52u w=0.42u l=0.13u
X3040 a_26553_1185# a_25611_992# a_26351_947# VPWR.t15 sg13_lv_pmos ad=93.45f pd=0.865u as=0.2048p ps=1.63u w=0.42u l=0.13u
X3041 a_26704_4114# a_26447_3971# a_26866_3894# VGND.t1444 sg13_lv_nmos ad=0.1428p pd=1.52u as=37.8f ps=0.6u w=0.42u l=0.13u
X3042 a_20362_8653# a_20805_8409# a_20745_8821# VPWR.t0 sg13_lv_pmos ad=79.8f pd=0.8u as=63f ps=0.72u w=0.42u l=0.13u
X3043 a_15465_7727# a_15108_7684# VPWR.t138 VPWR.t2 sg13_lv_pmos ad=63f pd=0.72u as=0.1563p ps=1.22u w=0.42u l=0.13u
X3044 VGND.t17 a_22330_2350# a_22049_2572# VGND.t385 sg13_lv_nmos ad=79.8f pd=0.8u as=0.1428p ps=1.52u w=0.42u l=0.5u
X3045 VPWR.t7 a_17680_5626# a_17625_5721# VPWR.t7 sg13_lv_pmos ad=1.46065p pd=9.335u as=93.45f ps=0.865u w=0.42u l=0.13u
X3046 a_15119_3505# a_14277_3155# a_13860_3148# VPWR.t10 sg13_lv_pmos ad=0.2048p pd=1.63u as=0.34p ps=2.68u w=1u l=0.13u
X3047 a_22138_1596# sg13cmos5l_dlygate4sd3_1_5.A VPWR.t195 VPWR.t15 sg13_lv_pmos ad=0.1428p pd=1.52u as=0.1523p ps=1.38u w=0.42u l=0.13u
X3048 sg13cmos5l_dfrbpq_1_0.CLK a_27195_3514# VPWR.t280 VPWR.t10 sg13_lv_pmos ad=0.2128p pd=1.5u as=0.2128p ps=1.5u w=1.12u l=0.13u
X3049 a_28174_8619# a_28289_8620# VPWR.t734 VPWR.t0 sg13_lv_pmos ad=0.34p pd=2.68u as=0.2254p ps=1.53u w=1u l=0.5u
X3050 a_20362_4117# a_20805_3873# a_20102_3894# VGND.t105 sg13_lv_nmos ad=79.8f pd=0.8u as=0.1296p ps=1.52u w=0.42u l=0.13u
X3051 VPWR.t720 a_9562_3862# a_9281_4084# VPWR.t43 sg13_lv_pmos ad=0.1523p pd=1.38u as=0.34p ps=2.68u w=1u l=0.5u
X3052 VGND.t739 a_10112_4943# sg13cmos5l_dfrbpq_1_57.Q VGND.t1179 sg13_lv_nmos ad=0.1406p pd=1.12u as=0.2516p ps=2.16u w=0.74u l=0.13u
X3053 a_5392_4114# a_5135_3971# a_5554_3894# VGND.t193 sg13_lv_nmos ad=0.1428p pd=1.52u as=37.8f ps=0.6u w=0.42u l=0.13u
X3054 a_18572_5370# sg13cmos5l_buf_1_5.A VPWR.t164 VPWR.t7 sg13_lv_pmos ad=0.2856p pd=2.36u as=0.2114p ps=1.54u w=0.84u l=0.13u
X3055 a_18922_7644# sg13cmos5l_buf_8_11.A VPWR.t887 VPWR.t2 sg13_lv_pmos ad=0.3808p pd=2.92u as=0.2128p ps=1.5u w=1.12u l=0.13u
X3056 a_4730_6168# sg13cmos5l_nor4_2_5.C a_5036_6168# VPWR.t7 sg13_lv_pmos ad=0.2128p pd=1.5u as=0.3808p ps=2.92u w=1.12u l=0.13u
X3057 VGND.t664 sg13cmos5l_dfrbpq_1_58.RESET_B a_6902_5419# VGND.t256 sg13_lv_nmos ad=0.1701p pd=1.65u as=37.8f ps=0.6u w=0.42u l=0.13u
X3058 VGND.t15 VPWR.t1453 VGND.t15 VGND.t1520 sg13_lv_nmos ad=79.8f pd=0.8u as=0 ps=0 w=0.42u l=1u
X3059 VPWR.t992 sg13cmos5l_nor3_1_1.Y sg13cmos5l_nand3_1_3.Y VPWR.t10 sg13_lv_pmos ad=0.3808p pd=2.92u as=0.2128p ps=1.5u w=1.12u l=0.13u
X3060 VGND.t630 a_8768_6427# sg13cmos5l_buf_8_9.A VGND.t1572 sg13_lv_nmos ad=0.1331p pd=1.12u as=0.2516p ps=2.16u w=0.74u l=0.13u
X3061 a_27994_3862# sg13cmos5l_dlygate4sd3_1_9.A VPWR.t362 VPWR.t43 sg13_lv_pmos ad=0.1428p pd=1.52u as=0.1523p ps=1.38u w=0.42u l=0.13u
X3062 a_5301_1028# sg13cmos5l_dfrbpq_1_13.RESET_B.t5 VPWR.t130 VPWR.t15 sg13_lv_pmos ad=0.147p pd=1.54u as=0.1563p ps=1.22u w=0.42u l=0.13u
X3063 a_18852_3569# a_18564_3148# a_18790_3569# VGND.t447 sg13_lv_nmos ad=0.1428p pd=1.52u as=37.8f ps=0.6u w=0.42u l=0.13u
X3064 sg13cmos5l_dfrbpq_1_32.CLK a_8763_8434# VGND.t357 VGND.t89 sg13_lv_nmos ad=0.1406p pd=1.12u as=0.1406p ps=1.12u w=0.74u l=0.13u
X3065 VPWR.t47 VGND.t632 VPWR.t46 VPWR.t43 sg13_lv_pmos ad=0.34p pd=2.68u as=0 ps=0 w=1u l=1u
X3066 sg13cmos5l_nor3_1_1.Y sg13cmos5l_dfrbpq_1_55.D VGND.t172 VGND.t548 sg13_lv_nmos ad=0.1694p pd=1.21u as=0.1463p ps=1.15u w=0.77u l=0.13u
X3067 VPWR.t675 sg13cmos5l_buf_1_0.A.t2 a_2920_7680# VPWR.t2 sg13_lv_pmos ad=0.2114p pd=1.54u as=0.2856p ps=2.36u w=0.84u l=0.13u
X3068 a_9446_874# a_9176_874# VGND.t508 VGND.t507 sg13_lv_nmos ad=0.1428p pd=1.52u as=79.8f ps=0.8u w=0.42u l=0.5u
X3069 VPWR.t886 a_18922_7644# sg13cmos5l_dfrbpq_1_46.CLK VPWR.t2 sg13_lv_pmos ad=0.2128p pd=1.5u as=0.2128p ps=1.5u w=1.12u l=0.13u
X3070 a_21934_1059# a_22049_1060# VGND.t235 VGND.t236 sg13_lv_nmos ad=0.1428p pd=1.52u as=0.1426p ps=1.16u w=0.42u l=0.5u
X3071 VPWR.t42 VGND.t1490 VPWR.t41 VPWR.t7 sg13_lv_pmos ad=0.19p pd=1.38u as=0 ps=0 w=1u l=1u
X3072 VPWR.t7 a_26181_5385# a_26283_5528# VPWR.t7 sg13_lv_pmos ad=1.46065p pd=9.335u as=0.3864p ps=2.93u w=1.12u l=0.13u
X3073 a_13664_1919# a_13783_1596# VPWR.t469 VPWR.t15 sg13_lv_pmos ad=0.3864p pd=2.93u as=0.2128p ps=1.5u w=1.12u l=0.13u
X3074 a_26121_5797# a_25764_5724# VPWR.t7 VPWR.t7 sg13_lv_pmos ad=63f pd=0.72u as=0.1563p ps=1.22u w=0.42u l=0.13u
X3075 VPWR.t459 a_28940_1596# sg13cmos5l_buf_1_0.X.t0 VPWR.t15 sg13_lv_pmos ad=0.2114p pd=1.54u as=0.42p ps=2.99u w=1.12u l=0.13u
X3076 VGND.t1594 sg13cmos5l_buf_8_4.A a_8763_8434# VGND.t89 sg13_lv_nmos ad=0.1406p pd=1.12u as=0.1406p ps=1.12u w=0.74u l=0.13u
X3077 VGND.t32 VPWR.t17 VGND.t32 VGND.t1536 sg13_lv_nmos ad=0.1428p pd=1.52u as=0 ps=0 w=0.42u l=1u
X3078 a_1509_7216# sg13cmos5l_dlygate4sd3_1_31.X VPWR.t512 VPWR.t2 sg13_lv_pmos ad=0.2464p pd=1.56u as=0.3808p ps=2.92u w=1.12u l=0.13u
X3079 VGND.t65 VPWR.t4 VGND.t65 VGND.t64 sg13_lv_nmos ad=0.1428p pd=1.52u as=0 ps=0 w=0.42u l=1u
X3080 sg13cmos5l_nand3_1_0.A sg13cmos5l_nor4_2_1.D VGND.t17 VGND.t1127 sg13_lv_nmos ad=0.1406p pd=1.12u as=0.2516p ps=2.16u w=0.74u l=0.13u
X3081 a_20805_8409# sg13cmos5l_dfrbpq_1_46.CLK VPWR.t1 VPWR.t0 sg13_lv_pmos ad=0.4088p pd=2.97u as=1.8922p ps=12.27u w=1.12u l=0.13u
X3082 VPWR.t1 sg13cmos5l_dfrbpq_1_32.CLK a_7103_8700# VPWR.t0 sg13_lv_pmos ad=1.82695p pd=11.845u as=0.4088p ps=2.97u w=1.12u l=0.13u
X3083 VPWR.t390 sg13cmos5l_dfrbpq_1_56.RESET_B a_15946_6136# VPWR.t7 sg13_lv_pmos ad=0.1563p pd=1.22u as=0.147p ps=1.54u w=0.42u l=0.13u
X3084 a_5422_5094# a_5663_4627# a_4951_4620# VGND.t30 sg13_lv_nmos ad=0.1428p pd=1.52u as=0.12665p ps=1.145u w=0.42u l=0.13u
X3085 sg13cmos5l_dfrbpq_1_32.CLK a_8763_8434# VPWR.t1418 VPWR.t0 sg13_lv_pmos ad=0.2128p pd=1.5u as=0.2128p ps=1.5u w=1.12u l=0.13u
X3086 a_27023_5483# a_26181_5385# a_25764_5724# VPWR.t7 sg13_lv_pmos ad=0.2048p pd=1.63u as=0.34p ps=2.68u w=1u l=0.13u
X3087 a_6359_4703# sg13cmos5l_dfrbpq_1_58.RESET_B VPWR.t609 VPWR.t43 sg13_lv_pmos ad=79.8f pd=0.8u as=0.36237p ps=2.605u w=0.42u l=0.13u
X3088 VPWR.t195 a_22330_838# a_22049_1060# VPWR.t15 sg13_lv_pmos ad=0.1523p pd=1.38u as=0.34p ps=2.68u w=1u l=0.5u
X3089 VPWR.t2 a_11567_6995# a_11824_7138# VPWR.t2 sg13_lv_pmos ad=1.34765p pd=8.56u as=79.8f ps=0.8u w=0.42u l=0.13u
X3090 VGND.t17 VPWR.t182 VGND.t17 VGND.t1533 sg13_lv_nmos ad=0.1428p pd=1.52u as=0 ps=0 w=0.42u l=1u
X3091 sg13cmos5l_buf_8_10.A a_14235_6922# VPWR.t941 VPWR.t2 sg13_lv_pmos ad=0.2128p pd=1.5u as=0.2128p ps=1.5u w=1.12u l=0.13u
X3092 a_28559_3514# a_28524_3410# sg13cmos5l_xnor2_1_4.Y VGND.t1645 sg13_lv_nmos ad=0.1406p pd=1.12u as=0.2516p ps=2.16u w=0.74u l=0.13u
X3093 VPWR.t59 VGND.t1510 VPWR.t63 VPWR.t10 sg13_lv_pmos ad=0.19p pd=1.38u as=0 ps=0 w=1u l=1u
X3094 sg13cmos5l_dfrbpq_1_21.RESET_B.t0 a_2920_8468# VPWR.t762 VPWR.t0 sg13_lv_pmos ad=0.42p pd=2.99u as=0.2114p ps=1.54u w=1.12u l=0.13u
X3095 a_19845_849# sg13cmos5l_dfrbpq_1_2.CLK VGND.t35 VGND.t1345 sg13_lv_nmos ad=0.2516p pd=2.16u as=5.40863p ps=35.155u w=0.74u l=0.13u
X3096 a_17796_4212# a_17770_4117# VGND.t50 VGND.t788 sg13_lv_nmos ad=0.2516p pd=2.16u as=0.1626p ps=1.415u w=0.74u l=0.13u
X3097 a_16068_7236# a_16587_7040# a_17327_6995# VGND.t1027 sg13_lv_nmos ad=0.3473p pd=2.71u as=0.12665p ps=1.145u w=0.74u l=0.13u
X3098 VPWR.t1416 a_8763_8434# sg13cmos5l_dfrbpq_1_32.CLK VPWR.t0 sg13_lv_pmos ad=0.2128p pd=1.5u as=0.2128p ps=1.5u w=1.12u l=0.13u
X3099 a_7696_6410# a_7439_6529# a_7858_6606# VGND.t416 sg13_lv_nmos ad=0.1428p pd=1.52u as=37.8f ps=0.6u w=0.42u l=0.13u
X3100 a_16786_8118# sg13cmos5l_dfrbpq_1_57.RESET_B.t9 VGND.t88 VGND.t87 sg13_lv_nmos ad=37.8f pd=0.6u as=79.8f ps=0.8u w=0.42u l=0.13u
X3101 VGND.t133 a_18826_4620# sg13cmos5l_dfrbpq_1_2.CLK VGND.t1137 sg13_lv_nmos ad=0.1406p pd=1.12u as=0.1406p ps=1.12u w=0.74u l=0.13u
X3102 a_21719_7727# sg13cmos5l_xnor2_1_10.Y a_22466_8118# VGND.t1051 sg13_lv_nmos ad=0.1428p pd=1.52u as=60.89999f ps=0.71u w=0.42u l=0.13u
X3103 a_5230_7107# a_5345_7108# VGND.t25 VGND.t1079 sg13_lv_nmos ad=0.1428p pd=1.52u as=0.1426p ps=1.16u w=0.42u l=0.5u
X3104 sg13cmos5l_dlygate4sd3_1_40.A a_25770_7216# VPWR.t309 VPWR.t2 sg13_lv_pmos ad=0.3808p pd=2.92u as=0.2128p ps=1.5u w=1.12u l=0.13u
X3105 a_25679_2459# a_24837_2361# a_24420_2700# VPWR.t10 sg13_lv_pmos ad=0.2048p pd=1.63u as=0.34p ps=2.68u w=1u l=0.13u
X3106 sg13cmos5l_dfrbpq_1_0.CLK a_27195_3514# VPWR.t277 VPWR.t10 sg13_lv_pmos ad=0.2128p pd=1.5u as=0.2128p ps=1.5u w=1.12u l=0.13u
X3107 a_6972_3858# a_7103_4164# a_6391_3858# VPWR.t43 sg13_lv_pmos ad=0.34p pd=2.68u as=0.2048p ps=1.63u w=1u l=0.13u
X3108 VPWR.t762 sg13cmos5l_buf_1_11.A a_2920_8468# VPWR.t0 sg13_lv_pmos ad=0.2114p pd=1.54u as=0.2856p ps=2.36u w=0.84u l=0.13u
X3109 VPWR.t950 sg13cmos5l_and2_1_4.X a_14235_6922# VPWR.t2 sg13_lv_pmos ad=0.2128p pd=1.5u as=0.3808p ps=2.92u w=1.12u l=0.13u
X3110 a_10791_6255# a_10943_6139# VGND.t25 VGND.t583 sg13_lv_nmos ad=0.2516p pd=2.16u as=3.51837p ps=21.815u w=0.74u l=0.13u
X3111 sg13cmos5l_dlygate4sd3_1_51.A a_22314_5704# VGND.t143 VGND.t142 sg13_lv_nmos ad=0.2516p pd=2.16u as=0.1406p ps=1.12u w=0.74u l=0.13u
X3112 VPWR.t668 a_4380_2346# a_5403_2773# VPWR.t10 sg13_lv_pmos ad=0.1563p pd=1.22u as=63f ps=0.72u w=0.42u l=0.13u
X3113 a_18478_8619# a_18593_8620# VGND.t491 VGND.t0 sg13_lv_nmos ad=0.1428p pd=1.52u as=0.1426p ps=1.16u w=0.42u l=0.5u
X3114 a_11733_2540# sg13cmos5l_dfrbpq_1_55.RESET_B VPWR.t529 VPWR.t10 sg13_lv_pmos ad=0.147p pd=1.54u as=0.1563p ps=1.22u w=0.42u l=0.13u
X3115 VGND.t54 a_21904_4114# a_21553_3971# VGND.t202 sg13_lv_nmos ad=79.8f pd=0.8u as=0.1428p ps=1.52u w=0.42u l=0.13u
X3116 a_15598_8745# a_15340_8430# VPWR.t1 VPWR.t0 sg13_lv_pmos ad=93.45f pd=0.865u as=1.8922p ps=12.27u w=0.42u l=0.13u
X3117 VGND.t273 a_26639_8041# a_27306_7680# VGND.t276 sg13_lv_nmos ad=0.1406p pd=1.12u as=0.2516p ps=2.16u w=0.74u l=0.13u
X3118 a_16485_6897# sg13cmos5l_dfrbpq_1_56.CLK VPWR.t2 VPWR.t2 sg13_lv_pmos ad=0.4088p pd=2.97u as=1.31957p ps=8.38u w=1.12u l=0.13u
X3119 sg13cmos5l_dlygate4sd3_1_1.A a_26346_2680# VPWR.t92 VPWR.t10 sg13_lv_pmos ad=0.3808p pd=2.92u as=0.2128p ps=1.5u w=1.12u l=0.13u
X3120 a_8150_8443# a_6972_8394# a_7754_8588# VGND.t1599 sg13_lv_nmos ad=37.8f pd=0.6u as=0.1428p ps=1.52u w=0.42u l=0.13u
X3121 sg13cmos5l_dfrbpq_1_32.CLK a_8763_8434# VPWR.t1349 VPWR.t0 sg13_lv_pmos ad=0.2128p pd=1.5u as=0.2128p ps=1.5u w=1.12u l=0.13u
X3122 a_10725_5385# sg13cmos5l_dfrbpq_1_57.CLK VGND.t30 VGND.t1101 sg13_lv_nmos ad=0.2516p pd=2.16u as=3.32715p ps=20.78u w=0.74u l=0.13u
X3123 VGND.t332 a_14235_6922# sg13cmos5l_buf_8_10.A VGND.t95 sg13_lv_nmos ad=0.1406p pd=1.12u as=0.1406p ps=1.12u w=0.74u l=0.13u
X3124 a_8853_1679# sg13cmos5l_dfrbpq_1_13.RESET_B.t9 VPWR.t200 VPWR.t15 sg13_lv_pmos ad=0.147p pd=1.54u as=0.1563p ps=1.22u w=0.42u l=0.13u
X3125 VGND.t50 sg13cmos5l_buf_8_4.A a_6250_3108# VGND.t674 sg13_lv_nmos ad=0.1406p pd=1.12u as=0.1406p ps=1.12u w=0.74u l=0.13u
X3126 VPWR.t710 sg13cmos5l_buf_8_2.X a_27195_3514# VPWR.t10 sg13_lv_pmos ad=0.2128p pd=1.5u as=0.3808p ps=2.92u w=1.12u l=0.13u
X3127 VPWR.t819 a_4366_7107# sg13cmos5l_nor4_2_9.D VPWR.t2 sg13_lv_pmos ad=0.2254p pd=1.53u as=0.4256p ps=3u w=1.12u l=0.13u
X3128 a_13862_4656# a_13592_4697# VGND.t179 VGND.t189 sg13_lv_nmos ad=0.1428p pd=1.52u as=79.8f ps=0.8u w=0.42u l=0.5u
X3129 a_3680_2557# a_3799_2346# VPWR.t365 VPWR.t10 sg13_lv_pmos ad=0.3864p pd=2.93u as=0.2128p ps=1.5u w=1.12u l=0.13u
X3130 VGND.t0 a_7749_7691# a_7851_7691# VGND.t353 sg13_lv_nmos ad=3.41162p pd=21.215u as=0.2516p ps=2.16u w=0.74u l=0.13u
X3131 sg13cmos5l_dfrbpq_1_15.D sg13cmos5l_xnor2_1_13.Y a_2259_7216# VPWR.t2 sg13_lv_pmos ad=0.2408p pd=1.55u as=0.1428p ps=1.375u w=1.12u l=0.13u
X3132 a_20892_6882# a_21023_7188# a_20311_6882# VPWR.t2 sg13_lv_pmos ad=0.34p pd=2.68u as=0.2048p ps=1.63u w=1u l=0.13u
X3133 a_14086_2395# sg13cmos5l_dfrbpq_1_55.RESET_B VGND.t324 VGND.t6 sg13_lv_nmos ad=37.8f pd=0.6u as=0.1701p ps=1.65u w=0.42u l=0.13u
X3134 a_28652_7644# en[3] VGND.t73 VGND.t1589 sg13_lv_nmos ad=0.187p pd=1.78u as=0.14875p ps=1.16u w=0.55u l=0.13u
X3135 a_17100_2572# sg13cmos5l_xnor2_1_2.Y VPWR.t570 VPWR.t10 sg13_lv_pmos ad=0.1596p pd=1.22u as=0.2891p ps=1.695u w=0.84u l=0.13u
X3136 VPWR.t2 a_16624_7922# a_16569_7803# VPWR.t2 sg13_lv_pmos ad=1.34765p pd=8.56u as=93.45f ps=0.865u w=0.42u l=0.13u
X3137 a_6250_2350# sg13cmos5l_buf_8_3.A VPWR.t699 VPWR.t10 sg13_lv_pmos ad=0.2128p pd=1.5u as=0.2128p ps=1.5u w=1.12u l=0.13u
X3138 VGND.t316 sg13cmos5l_xor2_1_2.B a_13745_3948# VGND.t675 sg13_lv_nmos ad=0.15245p pd=1.17u as=0.17462p ps=1.185u w=0.55u l=0.13u
X3139 VPWR.t967 sg13cmos5l_buf_8_10.A a_18363_6922# VPWR.t2 sg13_lv_pmos ad=0.2128p pd=1.5u as=0.3808p ps=2.92u w=1.12u l=0.13u
X3140 sg13cmos5l_dfrbpq_1_39.Q a_18090_5704# VPWR.t662 VPWR.t7 sg13_lv_pmos ad=0.3808p pd=2.92u as=0.2128p ps=1.5u w=1.12u l=0.13u
X3141 VPWR.t25 VGND.t15 VPWR.t23 VPWR.t10 sg13_lv_pmos ad=0.19p pd=1.38u as=0 ps=0 w=1u l=1u
X3142 a_15686_6606# sg13cmos5l_nor3_1_4.A VPWR.t923 VPWR.t7 sg13_lv_pmos ad=79.8f pd=0.8u as=0.1428p ps=1.52u w=0.42u l=0.13u
X3143 a_26578_3582# sg13cmos5l_buf_1_4.X.t3 VGND.t58 VGND.t1281 sg13_lv_nmos ad=37.8f pd=0.6u as=79.8f ps=0.8u w=0.42u l=0.13u
X3144 a_25478_8430# a_26283_8552# a_25738_8653# VPWR.t0 sg13_lv_pmos ad=0.1428p pd=1.52u as=79.8f ps=0.8u w=0.42u l=0.13u
X3145 a_4166_6168# a_3896_6209# VPWR.t916 VPWR.t7 sg13_lv_pmos ad=0.34p pd=2.68u as=0.1523p ps=1.38u w=1u l=0.5u
X3146 VPWR.t145 sg13cmos5l_buf_1_1.X.t2 a_19402_1093# VPWR.t15 sg13_lv_pmos ad=0.1563p pd=1.22u as=0.147p ps=1.54u w=0.42u l=0.13u
X3147 VPWR.t747 sg13cmos5l_dfrbpq_1_56.RESET_B a_16138_5629# VPWR.t7 sg13_lv_pmos ad=0.1563p pd=1.22u as=0.147p ps=1.54u w=0.42u l=0.13u
X3148 VPWR.t734 a_28174_8619# sg13cmos5l_nor4_2_7.D VPWR.t0 sg13_lv_pmos ad=0.2254p pd=1.53u as=0.4256p ps=3u w=1.12u l=0.13u
X3149 VPWR.t6 a_23835_8050# sg13cmos5l_buf_8_11.A VPWR.t2 sg13_lv_pmos ad=0.2128p pd=1.5u as=0.2128p ps=1.5u w=1.12u l=0.13u
X3150 a_15376_3386# a_15119_3505# a_15538_3582# VGND.t1398 sg13_lv_nmos ad=0.1428p pd=1.52u as=37.8f ps=0.6u w=0.42u l=0.13u
X3151 a_27280_8650# a_27023_8507# a_27442_8430# VGND.t72 sg13_lv_nmos ad=0.1428p pd=1.52u as=37.8f ps=0.6u w=0.42u l=0.13u
X3152 a_13668_2382# sg13cmos5l_nor3_1_1.A a_13574_2382# VGND.t186 sg13_lv_nmos ad=60.89999f pd=0.71u as=0.1428p ps=1.52u w=0.42u l=0.13u
X3153 a_25162_4117# a_25605_3873# a_24902_3894# VGND.t1222 sg13_lv_nmos ad=79.8f pd=0.8u as=0.1296p ps=1.52u w=0.42u l=0.13u
X3154 a_5990_6918# a_6795_7040# a_6250_7141# VPWR.t2 sg13_lv_pmos ad=0.1428p pd=1.52u as=79.8f ps=0.8u w=0.42u l=0.13u
X3155 sg13cmos5l_dlygate4sd3_1_4.A a_28362_7216# VGND.t45 VGND.t690 sg13_lv_nmos ad=0.2516p pd=2.16u as=0.1406p ps=1.12u w=0.74u l=0.13u
X3156 a_25871_6529# a_25029_6179# a_25777_6529# VGND.t242 sg13_lv_nmos ad=0.12665p pd=1.145u as=0.1428p ps=1.52u w=0.42u l=0.13u
X3157 a_3850_8653# a_4293_8409# a_4233_8821# VPWR.t0 sg13_lv_pmos ad=79.8f pd=0.8u as=63f ps=0.72u w=0.42u l=0.13u
X3158 VGND.t40 sg13cmos5l_dfrbpq_1_57.RESET_B.t11 a_11990_8105# VGND.t775 sg13_lv_nmos ad=0.1701p pd=1.65u as=37.8f ps=0.6u w=0.42u l=0.13u
X3159 a_25188_8118# sg13cmos5l_nor4_2_7.D a_25094_8118# VGND.t913 sg13_lv_nmos ad=60.89999f pd=0.71u as=0.1428p ps=1.52u w=0.42u l=0.13u
X3160 a_25990_8443# sg13cmos5l_dfrbpq_1_53.RESET_B.t10 VGND.t299 VGND.t648 sg13_lv_nmos ad=37.8f pd=0.6u as=0.1701p ps=1.65u w=0.42u l=0.13u
X3161 a_17109_4703# sg13cmos5l_dfrbpq_1_56.RESET_B VPWR.t749 VPWR.t43 sg13_lv_pmos ad=0.147p pd=1.54u as=0.1563p ps=1.22u w=0.42u l=0.13u
X3162 a_28524_3410# sg13cmos5l_xnor2_1_4.B VPWR.t1057 VPWR.t10 sg13_lv_pmos ad=0.1596p pd=1.22u as=0.2891p ps=1.695u w=0.84u l=0.13u
X3163 a_11567_8507# a_10725_8409# a_11473_8507# VGND.t343 sg13_lv_nmos ad=0.12665p pd=1.145u as=0.1428p ps=1.52u w=0.42u l=0.13u
X3164 a_10538_8118# a_10231_7644# a_10444_8118# VGND.t321 sg13_lv_nmos ad=37.8f pd=0.6u as=0.1428p ps=1.52u w=0.42u l=0.13u
X3165 a_3850_4117# a_4293_3873# a_3590_3894# VGND.t536 sg13_lv_nmos ad=79.8f pd=0.8u as=0.1296p ps=1.52u w=0.42u l=0.13u
X3166 sg13cmos5l_buf_8_11.A a_23835_8050# VPWR.t6 VPWR.t2 sg13_lv_pmos ad=0.2128p pd=1.5u as=0.2128p ps=1.5u w=1.12u l=0.13u
X3167 VPWR.t91 a_25679_2459# a_25936_2602# VPWR.t10 sg13_lv_pmos ad=1.43285p pd=9.125u as=79.8f ps=0.8u w=0.42u l=0.13u
X3168 VPWR.t2 sg13cmos5l_dfrbpq_1_46.CLK a_21023_7188# VPWR.t2 sg13_lv_pmos ad=1.31957p pd=8.38u as=0.4088p ps=2.97u w=1.12u l=0.13u
X3169 VGND.t15 a_1190_1632# a_1302_1656# VGND.t306 sg13_lv_nmos ad=0.1426p pd=1.16u as=0.1428p ps=1.52u w=0.42u l=0.5u
X3170 VGND.t203 sg13cmos5l_dfrbpq_1_53.RESET_B.t4 a_25572_5406# VGND.t302 sg13_lv_nmos ad=0.1626p pd=1.415u as=60.89999f ps=0.71u w=0.42u l=0.13u
X3171 VPWR.t1057 sg13cmos5l_xnor2_1_4.A a_28698_3144# VPWR.t10 sg13_lv_pmos ad=0.2891p pd=1.695u as=0.1428p ps=1.375u w=1.12u l=0.13u
X3172 VPWR.t822 sg13cmos5l_dfrbpq_1_58.RESET_B a_5990_6918# VPWR.t2 sg13_lv_pmos ad=0.36237p pd=2.605u as=79.8f ps=0.8u w=0.42u l=0.13u
X3173 sg13cmos5l_dfrbpq_1_57.CLK a_8842_6886# VGND.t630 VGND.t1068 sg13_lv_nmos ad=0.1406p pd=1.12u as=0.2516p ps=2.16u w=0.74u l=0.13u
X3174 VGND.t25 sg13cmos5l_dfrbpq_1_58.RESET_B a_5988_6606# VGND.t940 sg13_lv_nmos ad=0.1626p pd=1.415u as=60.89999f ps=0.71u w=0.42u l=0.13u
X3175 VGND.t216 sg13cmos5l_nor4_2_0.C sg13cmos5l_nand3_1_0.B VGND.t721 sg13_lv_nmos ad=0.3293p pd=1.63u as=0.1406p ps=1.12u w=0.74u l=0.13u
X3176 a_6551_5797# a_5855_5676# a_6645_5564# VGND.t256 sg13_lv_nmos ad=0.1296p pd=1.52u as=79.8f ps=0.8u w=0.42u l=0.13u
X3177 a_4759_1596# a_5319_1719# a_5340_1993# VGND.t1661 sg13_lv_nmos ad=0.12665p pd=1.145u as=0.3473p ps=2.71u w=0.74u l=0.13u
X3178 VPWR.t406 sg13cmos5l_dfrbpq_1_21.RESET_B.t10 a_7306_7648# VPWR.t2 sg13_lv_pmos ad=0.1563p pd=1.22u as=0.147p ps=1.54u w=0.42u l=0.13u
X3179 VPWR.t43 a_19055_3971# a_19312_4114# VPWR.t43 sg13_lv_pmos ad=1.3927p pd=8.9u as=79.8f ps=0.8u w=0.42u l=0.13u
X3180 a_6071_7727# sg13cmos5l_nor3_1_2.B a_6818_8118# VGND.t450 sg13_lv_nmos ad=0.1428p pd=1.52u as=60.89999f ps=0.71u w=0.42u l=0.13u
X3181 a_11639_7727# a_10943_7651# a_11733_7727# VGND.t799 sg13_lv_nmos ad=0.1296p pd=1.52u as=79.8f ps=0.8u w=0.42u l=0.13u
X3182 a_20362_6136# a_20805_6179# a_20102_6606# VGND.t1299 sg13_lv_nmos ad=79.8f pd=0.8u as=0.1296p ps=1.52u w=0.42u l=0.13u
X3183 a_15850_3862# osc VGND.t50 VGND.t1448 sg13_lv_nmos ad=0.2553p pd=2.17u as=0.1406p ps=1.12u w=0.74u l=0.13u
X3184 a_20676_5419# a_20907_5528# a_20362_5629# VGND.t708 sg13_lv_nmos ad=0.2373p pd=1.97u as=79.8f ps=0.8u w=0.42u l=0.13u
X3185 VGND.t160 sg13cmos5l_dfrbpq_1_3.D sg13cmos5l_nand3_1_0.B VGND.t489 sg13_lv_nmos ad=0.3293p pd=1.63u as=0.1406p ps=1.12u w=0.74u l=0.13u
X3186 sg13cmos5l_buf_8_3.A a_9915_3898# VPWR.t1335 VPWR.t43 sg13_lv_pmos ad=0.2128p pd=1.5u as=0.2128p ps=1.5u w=1.12u l=0.13u
X3187 sg13cmos5l_nor4_2_5.C a_2166_8498# VPWR.t156 VPWR.t0 sg13_lv_pmos ad=0.4256p pd=3u as=0.2254p ps=1.53u w=1.12u l=0.13u
X3188 VPWR.t6 sg13cmos5l_and2_1_1.X a_23835_8050# VPWR.t2 sg13_lv_pmos ad=0.2128p pd=1.5u as=0.2128p ps=1.5u w=1.12u l=0.13u
X3189 a_10725_5385# sg13cmos5l_dfrbpq_1_57.CLK VPWR.t7 VPWR.t7 sg13_lv_pmos ad=0.4088p pd=2.97u as=1.42587p ps=9.11u w=1.12u l=0.13u
X3190 VGND.t30 VPWR.t1464 VGND.t1490 VGND.t1489 sg13_lv_nmos ad=79.8f pd=0.8u as=0 ps=0 w=0.42u l=1u
X3191 a_5511_4743# a_5663_4627# VPWR.t43 VPWR.t43 sg13_lv_pmos ad=0.3864p pd=2.93u as=1.3927p ps=8.9u w=1.12u l=0.13u
X3192 VGND.t126 a_25103_6995# a_25770_7216# VGND.t1005 sg13_lv_nmos ad=0.1406p pd=1.12u as=0.2516p ps=2.16u w=0.74u l=0.13u
X3193 VGND.t52 sg13cmos5l_dlygate4sd3_1_23.X sg13cmos5l_nor4_2_9.Y VGND.t30 sg13_lv_nmos ad=0.1406p pd=1.12u as=0.1406p ps=1.12u w=0.74u l=0.13u
X3194 VPWR.t712 sg13cmos5l_buf_8_2.X a_18826_4620# VPWR.t43 sg13_lv_pmos ad=0.2128p pd=1.5u as=0.2128p ps=1.5u w=1.12u l=0.13u
X3195 a_24900_3148# a_25419_3155# a_26159_3505# VGND.t644 sg13_lv_nmos ad=0.3473p pd=2.71u as=0.12665p ps=1.145u w=0.74u l=0.13u
X3196 a_2016_7233# sg13cmos5l_xnor2_1_13.Y a_1979_6964# VGND.t1001 sg13_lv_nmos ad=0.2176p pd=1.96u as=78.39999f ps=0.885u w=0.64u l=0.13u
X3197 a_6645_5564# a_5703_5624# a_6551_5797# VPWR.t7 sg13_lv_pmos ad=79.8f pd=0.8u as=0.1428p ps=1.52u w=0.42u l=0.13u
X3198 a_27686_874# a_27416_874# VPWR.t318 VPWR.t15 sg13_lv_pmos ad=0.34p pd=2.68u as=0.1523p ps=1.38u w=1u l=0.5u
X3199 sg13cmos5l_dfrbpq_1_5.Q a_19722_4192# VGND.t106 VGND.t199 sg13_lv_nmos ad=0.2516p pd=2.16u as=0.1406p ps=1.12u w=0.74u l=0.13u
X3200 a_11567_8507# a_10725_8409# a_10308_8748# VPWR.t0 sg13_lv_pmos ad=0.2048p pd=1.63u as=0.34p ps=2.68u w=1u l=0.13u
X3201 a_11733_7727# a_10791_7767# a_11639_7727# VPWR.t2 sg13_lv_pmos ad=79.8f pd=0.8u as=0.1428p ps=1.52u w=0.42u l=0.13u
X3202 a_27790_7947# a_27905_7946# VGND.t273 VGND.t921 sg13_lv_nmos ad=0.1428p pd=1.52u as=0.1426p ps=1.16u w=0.42u l=0.5u
X3203 VGND.t25 a_5230_7107# sg13cmos5l_nor3_1_2.C VGND.t948 sg13_lv_nmos ad=0.1426p pd=1.16u as=0.2516p ps=2.16u w=0.74u l=0.13u
X3204 VPWR.t340 sg13cmos5l_buf_1_1.X.t8 a_24394_2605# VPWR.t10 sg13_lv_pmos ad=0.1563p pd=1.22u as=0.147p ps=1.54u w=0.42u l=0.13u
X3205 VPWR.t629 a_6250_3108# sg13cmos5l_dfrbpq_1_21.CLK VPWR.t10 sg13_lv_pmos ad=0.2128p pd=1.5u as=0.2128p ps=1.5u w=1.12u l=0.13u
X3206 VGND.t50 a_15850_3862# sg13cmos5l_buf_8_0.X VGND.t1119 sg13_lv_nmos ad=0.1406p pd=1.12u as=0.1406p ps=1.12u w=0.74u l=0.13u
X3207 VGND.t176 sg13cmos5l_dlygate4sd3_1_4.A a_28376_874# VGND.t1268 sg13_lv_nmos ad=79.8f pd=0.8u as=0.1428p ps=1.52u w=0.42u l=0.13u
X3208 VPWR.t560 sg13cmos5l_dfrbpq_1_13.RESET_B.t14 a_7430_2382# VPWR.t10 sg13_lv_pmos ad=0.36237p pd=2.605u as=79.8f ps=0.8u w=0.42u l=0.13u
X3209 VGND.t278 sg13cmos5l_buf_1_11.A a_2920_6956# VGND.t1092 sg13_lv_nmos ad=0.14875p pd=1.16u as=0.187p ps=1.78u w=0.55u l=0.13u
X3210 VGND.t453 a_4762_6886# a_4481_7108# VGND.t906 sg13_lv_nmos ad=79.8f pd=0.8u as=0.1428p ps=1.52u w=0.42u l=0.5u
X3211 VGND.t65 VPWR.t8 VGND.t65 VGND.t64 sg13_lv_nmos ad=0.1428p pd=1.52u as=0 ps=0 w=0.42u l=1u
X3212 VGND.t491 a_18478_8619# sg13cmos5l_xnor2_1_2.B VGND.t0 sg13_lv_nmos ad=0.1426p pd=1.16u as=0.2516p ps=2.16u w=0.74u l=0.13u
X3213 sg13cmos5l_dfrbpq_1_2.CLK a_18826_4620# VPWR.t1017 VPWR.t43 sg13_lv_pmos ad=0.2128p pd=1.5u as=0.2128p ps=1.5u w=1.12u l=0.13u
X3214 VPWR.t91 a_14277_3155# a_14379_3155# VPWR.t10 sg13_lv_pmos ad=1.43285p pd=9.125u as=0.3864p ps=2.93u w=1.12u l=0.13u
X3215 VPWR.t152 a_25308_1993# a_26331_1679# VPWR.t15 sg13_lv_pmos ad=0.1563p pd=1.22u as=63f ps=0.72u w=0.42u l=0.13u
X3216 VGND.t418 a_7792_7138# a_7441_6995# VGND.t955 sg13_lv_nmos ad=79.8f pd=0.8u as=0.1428p ps=1.52u w=0.42u l=0.13u
X3217 a_18107_5004# sg13cmos5l_nor4_2_1.A VGND.t30 VGND.t671 sg13_lv_nmos ad=78.39999f pd=0.885u as=0.2272p ps=1.99u w=0.64u l=0.13u
X3218 VPWR.t738 sg13cmos5l_xnor2_1_6.B a_1152_1185# VPWR.t15 sg13_lv_pmos ad=0.2891p pd=1.695u as=0.1596p ps=1.22u w=0.84u l=0.13u
X3219 VPWR.t91 a_26416_3386# a_26361_3267# VPWR.t10 sg13_lv_pmos ad=1.43285p pd=9.125u as=93.45f ps=0.865u w=0.42u l=0.13u
X3220 a_19526_8434# a_19256_8434# VPWR.t728 VPWR.t0 sg13_lv_pmos ad=0.34p pd=2.68u as=0.1523p ps=1.38u w=1u l=0.5u
X3221 sg13cmos5l_dfrbpq_1_21.CLK a_6250_3108# VPWR.t625 VPWR.t10 sg13_lv_pmos ad=0.2128p pd=1.5u as=0.2128p ps=1.5u w=1.12u l=0.13u
X3222 VPWR.t446 a_15708_8394# a_16731_8821# VPWR.t0 sg13_lv_pmos ad=0.1563p pd=1.22u as=63f ps=0.72u w=0.42u l=0.13u
X3223 a_7893_1028# a_6951_1088# a_7799_1261# VPWR.t15 sg13_lv_pmos ad=79.8f pd=0.8u as=0.1428p ps=1.52u w=0.42u l=0.13u
X3224 sg13cmos5l_buf_8_0.X a_15850_3862# VGND.t50 VGND.t1116 sg13_lv_nmos ad=0.1406p pd=1.12u as=0.1406p ps=1.12u w=0.74u l=0.13u
X3225 a_5554_3894# sg13cmos5l_dfrbpq_1_21.RESET_B.t7 VGND.t254 VGND.t193 sg13_lv_nmos ad=37.8f pd=0.6u as=79.8f ps=0.8u w=0.42u l=0.13u
X3226 a_17148_3902# sg13cmos5l_nand3_1_1.A sg13cmos5l_nand3_1_1.Y VGND.t1687 sg13_lv_nmos ad=0.1406p pd=1.12u as=0.2516p ps=2.16u w=0.74u l=0.13u
X3227 VPWR.t513 sg13cmos5l_nor3_1_4.Y sg13cmos5l_nand3_1_1.Y VPWR.t43 sg13_lv_pmos ad=0.3808p pd=2.92u as=0.2128p ps=1.5u w=1.12u l=0.13u
X3228 sg13cmos5l_buf_8_3.A a_9915_3898# VPWR.t1331 VPWR.t43 sg13_lv_pmos ad=0.2128p pd=1.5u as=0.2128p ps=1.5u w=1.12u l=0.13u
X3229 sg13cmos5l_nand3_1_1.A sg13cmos5l_dfrbpq_1_57.D a_14186_7680# VPWR.t2 sg13_lv_pmos ad=0.2128p pd=1.5u as=0.3808p ps=2.92u w=1.12u l=0.13u
X3230 VGND.t143 a_21647_5017# a_22314_4656# VGND.t142 sg13_lv_nmos ad=0.1406p pd=1.12u as=0.2516p ps=2.16u w=0.74u l=0.13u
X3231 a_25287_1719# a_25439_1603# VPWR.t153 VPWR.t15 sg13_lv_pmos ad=0.3864p pd=2.93u as=1.50275p ps=9.57u w=1.12u l=0.13u
X3232 a_15321_2697# a_14379_2504# a_15119_2459# VPWR.t10 sg13_lv_pmos ad=93.45f pd=0.865u as=0.2048p ps=1.63u w=0.42u l=0.13u
X3233 VGND.t58 a_26704_4114# a_26353_3971# VGND.t661 sg13_lv_nmos ad=79.8f pd=0.8u as=0.1428p ps=1.52u w=0.42u l=0.13u
X3234 VPWR.t1 a_21904_8650# a_21849_8745# VPWR.t0 sg13_lv_pmos ad=1.8922p pd=12.27u as=93.45f ps=0.865u w=0.42u l=0.13u
X3235 VPWR.t94 a_1152_1185# sg13cmos5l_xnor2_1_6.Y VPWR.t15 sg13_lv_pmos ad=0.3808p pd=2.92u as=0.2408p ps=1.55u w=1.12u l=0.13u
X3236 sg13cmos5l_dlygate4sd3_1_4.X a_28758_938# VGND.t377 VGND.t376 sg13_lv_nmos ad=0.2516p pd=2.16u as=0.1426p ps=1.16u w=0.74u l=0.13u
X3237 a_28958_2704# sg13cmos5l_dlygate4sd3_1_0.X a_28506_2578# VPWR.t10 sg13_lv_pmos ad=0.1225p pd=1.245u as=0.34p ps=2.68u w=1u l=0.13u
X3238 sg13cmos5l_dlygate4sd3_1_11.A a_26538_6168# VPWR.t264 VPWR.t7 sg13_lv_pmos ad=0.3808p pd=2.92u as=0.2128p ps=1.5u w=1.12u l=0.13u
X3239 a_23846_4656# a_23576_4697# VPWR.t227 VPWR.t43 sg13_lv_pmos ad=0.34p pd=2.68u as=0.1523p ps=1.38u w=1u l=0.5u
X3240 VGND.t25 a_16485_6897# a_16587_7040# VGND.t123 sg13_lv_nmos ad=3.51837p pd=21.815u as=0.2516p ps=2.16u w=0.74u l=0.13u
X3241 VGND.t77 sg13cmos5l_dfrbpq_1_13.CLK a_5471_1603# VGND.t748 sg13_lv_nmos ad=3.06955p pd=19.355u as=0.2516p ps=2.16u w=0.74u l=0.13u
X3242 VGND.t50 a_9166_4083# sg13cmos5l_xor2_1_1.B VGND.t624 sg13_lv_nmos ad=0.1426p pd=1.16u as=0.2516p ps=2.16u w=0.74u l=0.13u
X3243 VPWR.t481 a_18778_6132# a_18497_6434# VPWR.t7 sg13_lv_pmos ad=0.1523p pd=1.38u as=0.34p ps=2.68u w=1u l=0.5u
X3244 VPWR.t1176 sg13cmos5l_buf_8_5.A a_9915_3898# VPWR.t43 sg13_lv_pmos ad=0.2128p pd=1.5u as=0.2128p ps=1.5u w=1.12u l=0.13u
X3245 sg13cmos5l_buf_8_4.A a_7594_5374# VGND.t664 VGND.t1160 sg13_lv_nmos ad=0.1406p pd=1.12u as=0.2516p ps=2.16u w=0.74u l=0.13u
X3246 a_27598_4083# a_27713_4084# VPWR.t1202 VPWR.t43 sg13_lv_pmos ad=0.34p pd=2.68u as=0.2254p ps=1.53u w=1u l=0.5u
X3247 VPWR.t154 sg13cmos5l_dfrbpq_1_35.Q a_13784_8434# VPWR.t0 sg13_lv_pmos ad=0.1523p pd=1.38u as=0.1428p ps=1.52u w=0.42u l=0.13u
X3248 a_20388_8748# a_20907_8552# a_21647_8507# VGND.t880 sg13_lv_nmos ad=0.3473p pd=2.71u as=0.12665p ps=1.145u w=0.74u l=0.13u
X3249 a_10231_6132# a_10791_6255# a_10812_6529# VGND.t1252 sg13_lv_nmos ad=0.12665p pd=1.145u as=0.3473p ps=2.71u w=0.74u l=0.13u
X3250 VPWR.t7 a_17488_6410# a_17433_6291# VPWR.t7 sg13_lv_pmos ad=1.46065p pd=9.335u as=93.45f ps=0.865u w=0.42u l=0.13u
X3251 a_2259_5704# sg13cmos5l_nand3_1_1.Y VPWR.t220 VPWR.t7 sg13_lv_pmos ad=0.1428p pd=1.375u as=0.2891p ps=1.695u w=1.12u l=0.13u
X3252 a_15387_1679# a_14495_1603# a_15285_1679# VPWR.t15 sg13_lv_pmos ad=63f pd=0.72u as=79.8f ps=0.8u w=0.42u l=0.13u
X3253 a_23844_7236# a_23818_7141# VGND.t65 VGND.t210 sg13_lv_nmos ad=0.2516p pd=2.16u as=0.1626p ps=1.415u w=0.74u l=0.13u
X3254 sg13cmos5l_dfrbpq_1_54.Q a_15786_3144# VPWR.t119 VPWR.t10 sg13_lv_pmos ad=0.3808p pd=2.92u as=0.2128p ps=1.5u w=1.12u l=0.13u
X3255 VGND.t25 a_26853_6897# a_26955_7040# VGND.t1076 sg13_lv_nmos ad=3.51837p pd=21.815u as=0.2516p ps=2.16u w=0.74u l=0.13u
X3256 a_14916_8118# sg13cmos5l_xor2_1_2.A a_14822_8118# VGND.t929 sg13_lv_nmos ad=60.89999f pd=0.71u as=0.1428p ps=1.52u w=0.42u l=0.13u
X3257 a_16521_5797# a_16164_5724# VPWR.t747 VPWR.t7 sg13_lv_pmos ad=63f pd=0.72u as=0.1563p ps=1.22u w=0.42u l=0.13u
X3258 a_20614_3907# sg13cmos5l_buf_1_1.X.t15 VGND.t106 VGND.t105 sg13_lv_nmos ad=37.8f pd=0.6u as=0.1701p ps=1.65u w=0.42u l=0.13u
X3259 VPWR.t1096 sg13cmos5l_dfrbpq_1_54.Q a_16184_3185# VPWR.t10 sg13_lv_pmos ad=0.1523p pd=1.38u as=0.1428p ps=1.52u w=0.42u l=0.13u
X3260 VPWR.t673 a_5244_8041# a_6267_7727# VPWR.t2 sg13_lv_pmos ad=0.1563p pd=1.22u as=63f ps=0.72u w=0.42u l=0.13u
X3261 VGND.t141 sg13cmos5l_buf_1_0.X.t13 a_20618_8118# VGND.t140 sg13_lv_nmos ad=79.8f pd=0.8u as=37.8f ps=0.6u w=0.42u l=0.13u
X3262 VGND.t52 a_5024_5581# sg13cmos5l_dlygate4sd3_1_30.A VGND.t1323 sg13_lv_nmos ad=0.1406p pd=1.12u as=0.2516p ps=2.16u w=0.74u l=0.13u
X3263 a_3876_4212# a_4395_4016# a_5135_3971# VGND.t193 sg13_lv_nmos ad=0.3473p pd=2.71u as=0.12665p ps=1.145u w=0.74u l=0.13u
X3264 VGND.t154 sg13cmos5l_nand3_1_0.Y a_17621_2002# VGND.t153 sg13_lv_nmos ad=0.1898p pd=1.36u as=0.2516p ps=2.16u w=0.74u l=0.13u
X3265 VGND.t332 sg13cmos5l_dfrbpq_1_56.D sg13cmos5l_nand3_1_1.B VGND.t95 sg13_lv_nmos ad=0.3293p pd=1.63u as=0.1406p ps=1.12u w=0.74u l=0.13u
X3266 VPWR.t638 sg13cmos5l_dlygate4sd3_1_19.X a_1436_5704# VPWR.t7 sg13_lv_pmos ad=0.2128p pd=1.5u as=0.3808p ps=2.92u w=1.12u l=0.13u
X3267 VGND.t58 a_27994_3862# a_27713_4084# VGND.t1318 sg13_lv_nmos ad=79.8f pd=0.8u as=0.1428p ps=1.52u w=0.42u l=0.5u
X3268 VPWR.t2 a_17584_7138# a_17529_7233# VPWR.t2 sg13_lv_pmos ad=1.34765p pd=8.56u as=93.45f ps=0.865u w=0.42u l=0.13u
X3269 a_18778_6132# sg13cmos5l_dfrbpq_1_38.Q VPWR.t481 VPWR.t7 sg13_lv_pmos ad=0.1428p pd=1.52u as=0.1523p ps=1.38u w=0.42u l=0.13u
X3270 a_6359_4703# sg13cmos5l_dfrbpq_1_58.D a_7106_5094# VGND.t1008 sg13_lv_nmos ad=0.1428p pd=1.52u as=60.89999f ps=0.71u w=0.42u l=0.13u
X3271 a_17423_5483# a_16581_5385# a_16164_5724# VPWR.t7 sg13_lv_pmos ad=0.2048p pd=1.63u as=0.34p ps=2.68u w=1u l=0.13u
X3272 a_4164_8443# a_3876_8748# a_4102_8443# VGND.t81 sg13_lv_nmos ad=0.1428p pd=1.52u as=37.8f ps=0.6u w=0.42u l=0.13u
X3273 VPWR.t657 sg13cmos5l_dfrbpq_1_23.D a_3692_4656# VPWR.t43 sg13_lv_pmos ad=0.3808p pd=2.92u as=0.2128p ps=1.5u w=1.12u l=0.13u
X3274 a_16212_916# sg13cmos5l_xnor2_1_6.Y a_15756_1060# VGND.t412 sg13_lv_nmos ad=78.39999f pd=0.885u as=0.2176p ps=1.96u w=0.64u l=0.13u
X3275 a_15285_1679# a_14343_1719# a_15146_1912# VGND.t152 sg13_lv_nmos ad=79.8f pd=0.8u as=0.2373p ps=1.97u w=0.42u l=0.13u
X3276 VGND.t30 sg13cmos5l_nor4_2_9.D a_1265_5460# VGND.t696 sg13_lv_nmos ad=0.15245p pd=1.17u as=0.17462p ps=1.185u w=0.55u l=0.13u
X3277 sg13cmos5l_dfrbpq_1_2.CLK a_18826_4620# VPWR.t1013 VPWR.t43 sg13_lv_pmos ad=0.2128p pd=1.5u as=0.2128p ps=1.5u w=1.12u l=0.13u
X3278 VPWR.t350 a_16666_2350# a_16385_2572# VPWR.t10 sg13_lv_pmos ad=0.1523p pd=1.38u as=0.34p ps=2.68u w=1u l=0.5u
X3279 a_11733_3191# a_10791_3231# a_11594_3424# VGND.t694 sg13_lv_nmos ad=79.8f pd=0.8u as=0.2373p ps=1.97u w=0.42u l=0.13u
X3280 a_17435_1980# sg13cmos5l_nand3_1_0.Y VGND.t156 VGND.t155 sg13_lv_nmos ad=78.39999f pd=0.885u as=0.2272p ps=1.99u w=0.64u l=0.13u
X3281 a_11639_2773# a_10943_2652# a_11733_2540# VGND.t566 sg13_lv_nmos ad=0.1296p pd=1.52u as=79.8f ps=0.8u w=0.42u l=0.13u
X3282 a_6564_6931# a_6276_7236# a_6502_6931# VGND.t953 sg13_lv_nmos ad=0.1428p pd=1.52u as=37.8f ps=0.6u w=0.42u l=0.13u
X3283 a_24070_6931# sg13cmos5l_buf_1_0.X.t9 VGND.t128 VGND.t127 sg13_lv_nmos ad=37.8f pd=0.6u as=0.1701p ps=1.65u w=0.42u l=0.13u
X3284 VPWR.t94 a_1870_1899# sg13cmos5l_xnor2_1_6.B VPWR.t15 sg13_lv_pmos ad=0.2254p pd=1.53u as=0.4256p ps=3u w=1.12u l=0.13u
X3285 a_2266_2350# sg13cmos5l_dfrbpq_1_13.Q VGND.t150 VGND.t794 sg13_lv_nmos ad=0.1428p pd=1.52u as=79.8f ps=0.8u w=0.42u l=0.13u
X3286 a_7689_7727# a_7332_7684# VPWR.t406 VPWR.t2 sg13_lv_pmos ad=63f pd=0.72u as=0.1563p ps=1.22u w=0.42u l=0.13u
X3287 a_20614_6593# sg13cmos5l_buf_1_0.X.t7 VGND.t145 VGND.t422 sg13_lv_nmos ad=37.8f pd=0.6u as=0.1701p ps=1.65u w=0.42u l=0.13u
X3288 VPWR.t136 sg13cmos5l_dfrbpq_1_57.RESET_B.t14 a_10282_8653# VPWR.t0 sg13_lv_pmos ad=0.1563p pd=1.22u as=0.147p ps=1.54u w=0.42u l=0.13u
X3289 a_4186_1596# sg13cmos5l_dlygate4sd3_1_19.A VGND.t205 VGND.t204 sg13_lv_nmos ad=0.1428p pd=1.52u as=79.8f ps=0.8u w=0.42u l=0.13u
X3290 a_21813_7727# sg13cmos5l_buf_1_0.X.t12 VPWR.t173 VPWR.t2 sg13_lv_pmos ad=0.147p pd=1.54u as=0.1563p ps=1.22u w=0.42u l=0.13u
X3291 VPWR.t109 a_27022_6435# sg13cmos5l_dlygate4sd3_1_39.X VPWR.t7 sg13_lv_pmos ad=0.2254p pd=1.53u as=0.4256p ps=3u w=1.12u l=0.13u
X3292 VPWR.t1033 a_7594_5374# sg13cmos5l_buf_8_4.A VPWR.t7 sg13_lv_pmos ad=0.2128p pd=1.5u as=0.2128p ps=1.5u w=1.12u l=0.13u
X3293 sg13cmos5l_nor3_1_0.B a_23958_3168# VPWR.t79 VPWR.t10 sg13_lv_pmos ad=0.4256p pd=3u as=0.2254p ps=1.53u w=1.12u l=0.13u
X3294 sg13cmos5l_dfrbpq_1_18.D a_2016_4209# a_2165_3898# VGND.t704 sg13_lv_nmos ad=0.2516p pd=2.16u as=0.1406p ps=1.12u w=0.74u l=0.13u
X3295 VPWR.t413 a_16367_8041# a_17034_7680# VPWR.t2 sg13_lv_pmos ad=0.2128p pd=1.5u as=0.3864p ps=2.93u w=1.12u l=0.13u
X3296 a_28262_1632# a_27992_1673# VGND.t11 VGND.t1669 sg13_lv_nmos ad=0.1428p pd=1.52u as=79.8f ps=0.8u w=0.42u l=0.5u
X3297 a_24708_3582# sg13cmos5l_nor4_2_0.C a_24614_3582# VGND.t53 sg13_lv_nmos ad=60.89999f pd=0.71u as=0.1428p ps=1.52u w=0.42u l=0.13u
X3298 a_15396_8105# a_15108_7684# a_15334_8105# VGND.t957 sg13_lv_nmos ad=0.1428p pd=1.52u as=37.8f ps=0.6u w=0.42u l=0.13u
X3299 sg13cmos5l_dlygate4sd3_1_52.X a_9558_4680# VPWR.t1030 VPWR.t43 sg13_lv_pmos ad=0.4256p pd=3u as=0.2254p ps=1.53u w=1.12u l=0.13u
X3300 a_21270_2680# sg13cmos5l_nor4_2_1.A VPWR.t614 VPWR.t10 sg13_lv_pmos ad=0.2128p pd=1.5u as=0.3808p ps=2.92u w=1.12u l=0.13u
X3301 VPWR.t719 sg13cmos5l_dlygate4sd3_1_28.A a_9176_6209# VPWR.t7 sg13_lv_pmos ad=0.1523p pd=1.38u as=0.1428p ps=1.52u w=0.42u l=0.13u
X3302 VGND.t664 sg13cmos5l_dfrbpq_1_58.RESET_B a_6710_5081# VGND.t944 sg13_lv_nmos ad=0.1701p pd=1.65u as=37.8f ps=0.6u w=0.42u l=0.13u
X3303 a_6180_6172# a_6154_6136# VPWR.t839 VPWR.t7 sg13_lv_pmos ad=0.34p pd=2.68u as=0.36237p ps=2.605u w=1u l=0.13u
X3304 VPWR.t2 a_25103_6995# a_25360_7138# VPWR.t2 sg13_lv_pmos ad=1.34765p pd=8.56u as=79.8f ps=0.8u w=0.42u l=0.13u
X3305 VPWR.t94 a_1190_1632# a_1302_1656# VPWR.t15 sg13_lv_pmos ad=0.2254p pd=1.53u as=0.34p ps=2.68u w=1u l=0.5u
X3306 a_24777_2773# a_24420_2700# VPWR.t340 VPWR.t10 sg13_lv_pmos ad=63f pd=0.72u as=0.1563p ps=1.22u w=0.42u l=0.13u
X3307 VGND.t117 sg13cmos5l_buf_1_0.A.t2 a_2920_7680# VGND.t737 sg13_lv_nmos ad=0.14875p pd=1.16u as=0.187p ps=1.78u w=0.55u l=0.13u
X3308 a_15302_5410# a_15032_5410# VGND.t350 VGND.t1624 sg13_lv_nmos ad=0.1428p pd=1.52u as=79.8f ps=0.8u w=0.42u l=0.5u
X3309 VPWR.t121 a_4832_4943# sg13cmos5l_dfrbpq_1_58.Q VPWR.t43 sg13_lv_pmos ad=0.2128p pd=1.5u as=0.3808p ps=2.92u w=1.12u l=0.13u
X3310 a_19402_1093# a_19845_849# a_19142_870# VGND.t1151 sg13_lv_nmos ad=79.8f pd=0.8u as=0.1296p ps=1.52u w=0.42u l=0.13u
X3311 a_26135_1679# sg13cmos5l_dfrbpq_1_0.D a_26882_2070# VGND.t808 sg13_lv_nmos ad=0.1428p pd=1.52u as=60.89999f ps=0.71u w=0.42u l=0.13u
X3312 a_24954_5704# sg13cmos5l_xnor2_1_4.Y sg13cmos5l_xnor2_1_10.Y VPWR.t7 sg13_lv_pmos ad=0.1428p pd=1.375u as=0.2408p ps=1.55u w=1.12u l=0.13u
X3313 VPWR.t45 VGND.t1490 VPWR.t44 VPWR.t43 sg13_lv_pmos ad=0.19p pd=1.38u as=0 ps=0 w=1u l=1u
X3314 a_5164_5094# a_4951_4620# VPWR.t43 VPWR.t43 sg13_lv_pmos ad=79.8f pd=0.8u as=1.3927p ps=8.9u w=0.42u l=0.13u
X3315 VPWR.t214 sg13cmos5l_xnor2_1_2.B a_16320_1671# VPWR.t15 sg13_lv_pmos ad=0.2891p pd=1.695u as=0.1596p ps=1.22u w=0.84u l=0.13u
X3316 VPWR.t191 a_17036_1596# sg13cmos5l_dfrbpq_1_13.RESET_B.t0 VPWR.t15 sg13_lv_pmos ad=0.2114p pd=1.54u as=0.42p ps=2.99u w=1.12u l=0.13u
X3317 a_1169_3502# sg13cmos5l_dfrbpq_1_12.D VGND.t632 VGND.t1230 sg13_lv_nmos ad=0.17462p pd=1.185u as=0.374p ps=2.46u w=0.55u l=0.13u
X3318 a_15396_8105# a_15627_7691# a_15082_7648# VGND.t441 sg13_lv_nmos ad=0.2373p pd=1.97u as=79.8f ps=0.8u w=0.42u l=0.13u
X3319 VPWR.t599 sg13cmos5l_dfrbpq_1_57.RESET_B.t8 a_10022_6918# VPWR.t2 sg13_lv_pmos ad=0.36237p pd=2.605u as=79.8f ps=0.8u w=0.42u l=0.13u
X3320 a_25092_1188# a_25066_1093# VGND.t174 VGND.t173 sg13_lv_nmos ad=0.2516p pd=2.16u as=0.1626p ps=1.415u w=0.74u l=0.13u
X3321 a_13664_1919# a_13783_1596# VGND.t324 VGND.t876 sg13_lv_nmos ad=0.2516p pd=2.16u as=0.1406p ps=1.12u w=0.74u l=0.13u
X3322 a_21270_2680# sg13cmos5l_dfrbpq_1_2.D a_20972_2680# VPWR.t10 sg13_lv_pmos ad=0.2128p pd=1.5u as=0.2128p ps=1.5u w=1.12u l=0.13u
X3323 sg13cmos5l_dfrbpq_1_54.Q a_15786_3144# VGND.t50 VGND.t66 sg13_lv_nmos ad=0.2516p pd=2.16u as=0.1406p ps=1.12u w=0.74u l=0.13u
X3324 sg13cmos5l_nand3_1_2.A sg13cmos5l_dlygate4sd3_1_55.X a_24170_8728# VPWR.t0 sg13_lv_pmos ad=0.2128p pd=1.5u as=0.3808p ps=2.92u w=1.12u l=0.13u
X3325 VGND.t499 a_28940_1596# sg13cmos5l_buf_1_0.X VGND.t498 sg13_lv_nmos ad=0.14875p pd=1.16u as=0.2886p ps=2.26u w=0.74u l=0.13u
X3326 VGND.t17 sg13cmos5l_nor4_2_1.A sg13cmos5l_nand3_1_0.A VGND.t672 sg13_lv_nmos ad=0.2553p pd=2.17u as=0.1406p ps=1.12u w=0.74u l=0.13u
X3327 a_18660_2395# a_18372_2700# a_18598_2395# VGND.t636 sg13_lv_nmos ad=0.1428p pd=1.52u as=37.8f ps=0.6u w=0.42u l=0.13u
X3328 a_10112_7967# a_10231_7644# VPWR.t373 VPWR.t2 sg13_lv_pmos ad=0.3864p pd=2.93u as=0.2128p ps=1.5u w=1.12u l=0.13u
X3329 VGND.t280 VPWR.t1472 VGND.t280 VGND.t1473 sg13_lv_nmos ad=0.1428p pd=1.52u as=0 ps=0 w=0.42u l=1u
X3330 VPWR.t1 a_27023_8507# a_27280_8650# VPWR.t0 sg13_lv_pmos ad=1.8922p pd=12.27u as=79.8f ps=0.8u w=0.42u l=0.13u
X3331 a_15488_4943# a_15607_4620# VPWR.t561 VPWR.t43 sg13_lv_pmos ad=0.3864p pd=2.93u as=0.2128p ps=1.5u w=1.12u l=0.13u
X3332 a_26181_4667# sg13cmos5l_dfrbpq_1_53.CLK VGND.t30 VGND.t1310 sg13_lv_nmos ad=0.2516p pd=2.16u as=3.32715p ps=20.78u w=0.74u l=0.13u
X3333 a_15082_7648# a_15525_7691# a_15465_7727# VPWR.t2 sg13_lv_pmos ad=79.8f pd=0.8u as=63f ps=0.72u w=0.42u l=0.13u
X3334 VPWR.t845 a_6645_5564# a_5724_5370# VPWR.t7 sg13_lv_pmos ad=0.36237p pd=2.605u as=0.34p ps=2.68u w=1u l=0.13u
X3335 a_5532_5017# a_5663_4627# a_4951_4620# VPWR.t43 sg13_lv_pmos ad=0.34p pd=2.68u as=0.2048p ps=1.63u w=1u l=0.13u
X3336 VGND.t268 sg13cmos5l_xnor2_1_4.A a_28980_3492# VGND.t1451 sg13_lv_nmos ad=0.2272p pd=1.99u as=78.39999f ps=0.885u w=0.64u l=0.13u
X3337 VPWR.t1309 sg13cmos5l_xnor2_1_6.B a_7799_1261# VPWR.t15 sg13_lv_pmos ad=0.1428p pd=1.52u as=79.8f ps=0.8u w=0.42u l=0.13u
X3338 VGND.t38 sg13cmos5l_dfrbpq_1_13.RESET_B.t4 a_6698_870# VGND.t1621 sg13_lv_nmos ad=79.8f pd=0.8u as=37.8f ps=0.6u w=0.42u l=0.13u
X3339 VGND.t35 a_19845_849# a_19947_992# VGND.t1152 sg13_lv_nmos ad=5.40863p pd=35.155u as=0.2516p ps=2.16u w=0.74u l=0.13u
X3340 VGND.t316 sg13cmos5l_nor3_1_4.B sg13cmos5l_nor3_1_4.Y VGND.t652 sg13_lv_nmos ad=0.1463p pd=1.15u as=0.1694p ps=1.21u w=0.77u l=0.13u
X3341 VGND.t418 a_7696_6410# a_7345_6529# VGND.t1583 sg13_lv_nmos ad=79.8f pd=0.8u as=0.1428p ps=1.52u w=0.42u l=0.13u
X3342 VPWR.t214 a_15285_1679# a_14364_1993# VPWR.t15 sg13_lv_pmos ad=0.36237p pd=2.605u as=0.34p ps=2.68u w=1u l=0.13u
X3343 sg13cmos5l_dlygate4sd3_1_47.A a_22314_8728# VPWR.t97 VPWR.t0 sg13_lv_pmos ad=0.3808p pd=2.92u as=0.2128p ps=1.5u w=1.12u l=0.13u
X3344 a_24170_8728# sg13cmos5l_dfrbpq_1_37.D a_23872_8728# VPWR.t0 sg13_lv_pmos ad=0.2128p pd=1.5u as=0.2128p ps=1.5u w=1.12u l=0.13u
X3345 VGND.t40 sg13cmos5l_xnor2_1_2.A sg13cmos5l_nand3_1_1.A VGND.t464 sg13_lv_nmos ad=0.3293p pd=1.63u as=0.1406p ps=1.12u w=0.74u l=0.13u
X3346 VPWR.t312 sg13cmos5l_dfrbpq_1_53.RESET_B.t2 a_25738_4624# VPWR.t43 sg13_lv_pmos ad=0.1563p pd=1.22u as=0.147p ps=1.54u w=0.42u l=0.13u
X3347 a_27610_1596# sg13cmos5l_dlygate4sd3_1_2.A VGND.t11 VGND.t348 sg13_lv_nmos ad=0.1428p pd=1.52u as=79.8f ps=0.8u w=0.42u l=0.13u
X3348 VGND.t235 a_20944_1090# a_20593_947# VGND.t1187 sg13_lv_nmos ad=79.8f pd=0.8u as=0.1428p ps=1.52u w=0.42u l=0.13u
X3349 VGND.t17 sg13cmos5l_dfrbpq_1_2.D sg13cmos5l_nand3_1_0.A VGND.t541 sg13_lv_nmos ad=0.3293p pd=1.63u as=0.1406p ps=1.12u w=0.74u l=0.13u
X3350 a_5392_8650# sg13cmos5l_dfrbpq_1_21.RESET_B.t15 VPWR.t1 VPWR.t0 sg13_lv_pmos ad=79.8f pd=0.8u as=1.82695p ps=11.845u w=0.42u l=0.13u
X3351 sg13cmos5l_nor4_2_5.Y sg13cmos5l_dfrbpq_1_58.D VGND.t25 VGND.t1006 sg13_lv_nmos ad=0.1406p pd=1.12u as=0.3293p ps=1.63u w=0.74u l=0.13u
X3352 VGND.t393 VPWR.t1451 VGND.t1525 VGND.t1524 sg13_lv_nmos ad=79.8f pd=0.8u as=0 ps=0 w=0.42u l=1u
X3353 VPWR.t7 a_11824_5626# a_11769_5721# VPWR.t7 sg13_lv_pmos ad=1.46065p pd=9.335u as=93.45f ps=0.865u w=0.42u l=0.13u
X3354 a_6597_6179# sg13cmos5l_dfrbpq_1_32.CLK VGND.t25 VGND.t1212 sg13_lv_nmos ad=0.2516p pd=2.16u as=3.31142p ps=20.535u w=0.74u l=0.13u
X3355 a_20025_3267# a_19083_3155# a_19823_3505# VPWR.t10 sg13_lv_pmos ad=93.45f pd=0.865u as=0.2048p ps=1.63u w=0.42u l=0.13u
X3356 VGND.t11 sg13cmos5l_dlygate4sd3_1_17.A a_27608_2386# VGND.t956 sg13_lv_nmos ad=79.8f pd=0.8u as=0.1428p ps=1.52u w=0.42u l=0.13u
X3357 a_11639_6215# sg13cmos5l_dfrbpq_1_57.RESET_B.t4 VPWR.t142 VPWR.t7 sg13_lv_pmos ad=79.8f pd=0.8u as=0.36237p ps=2.605u w=0.42u l=0.13u
X3358 a_18538_3112# a_18981_3155# a_18278_3582# VGND.t1639 sg13_lv_nmos ad=79.8f pd=0.8u as=0.1296p ps=1.52u w=0.42u l=0.13u
X3359 VGND.t278 sg13cmos5l_xnor2_1_9.A a_2165_6922# VGND.t1024 sg13_lv_nmos ad=0.1898p pd=1.36u as=0.2516p ps=2.16u w=0.74u l=0.13u
X3360 sg13cmos5l_buf_8_10.A a_14235_6922# VPWR.t946 VPWR.t2 sg13_lv_pmos ad=0.2128p pd=1.5u as=0.2128p ps=1.5u w=1.12u l=0.13u
X3361 VGND.t96 a_11824_7138# a_11473_6995# VGND.t1045 sg13_lv_nmos ad=79.8f pd=0.8u as=0.1428p ps=1.52u w=0.42u l=0.13u
X3362 sg13cmos5l_and2_1_3.A a_13642_5374# VGND.t179 VGND.t526 sg13_lv_nmos ad=0.1406p pd=1.12u as=0.2516p ps=2.16u w=0.74u l=0.13u
X3363 VGND.t20 VPWR.t166 VGND.t20 VGND.t1465 sg13_lv_nmos ad=79.8f pd=0.8u as=0 ps=0 w=0.42u l=1u
X3364 sg13cmos5l_nor4_2_5.Y sg13cmos5l_nor4_2_5.B VGND.t25 VGND.t951 sg13_lv_nmos ad=0.1406p pd=1.12u as=0.1406p ps=1.12u w=0.74u l=0.13u
X3365 VPWR.t1202 a_27598_4083# sg13cmos5l_dlygate4sd3_1_9.X VPWR.t43 sg13_lv_pmos ad=0.2254p pd=1.53u as=0.4256p ps=3u w=1.12u l=0.13u
X3366 a_8759_1679# a_8063_1603# a_8853_1679# VGND.t227 sg13_lv_nmos ad=0.1296p pd=1.52u as=79.8f ps=0.8u w=0.42u l=0.13u
X3367 a_11990_2395# a_10812_2346# a_11594_2540# VGND.t566 sg13_lv_nmos ad=37.8f pd=0.6u as=0.1428p ps=1.52u w=0.42u l=0.13u
X3368 a_9166_4083# a_9281_4084# VGND.t50 VGND.t49 sg13_lv_nmos ad=0.1428p pd=1.52u as=0.1426p ps=1.16u w=0.42u l=0.5u
X3369 a_24922_4620# sg13cmos5l_dlygate4sd3_1_55.A VGND.t203 VGND.t142 sg13_lv_nmos ad=0.1428p pd=1.52u as=79.8f ps=0.8u w=0.42u l=0.13u
X3370 a_24228_2382# sg13cmos5l_nor4_2_0.B a_24134_2382# VGND.t213 sg13_lv_nmos ad=60.89999f pd=0.71u as=0.1428p ps=1.52u w=0.42u l=0.13u
X3371 VPWR.t272 a_5135_3971# a_5802_4192# VPWR.t43 sg13_lv_pmos ad=0.2128p pd=1.5u as=0.3864p ps=2.93u w=1.12u l=0.13u
X3372 a_25738_5629# a_26181_5385# a_26121_5797# VPWR.t7 sg13_lv_pmos ad=79.8f pd=0.8u as=63f ps=0.72u w=0.42u l=0.13u
X3373 a_6165_7727# sg13cmos5l_dfrbpq_1_21.RESET_B.t11 VPWR.t673 VPWR.t2 sg13_lv_pmos ad=0.147p pd=1.54u as=0.1563p ps=1.22u w=0.42u l=0.13u
X3374 sg13cmos5l_dfrbpq_1_0.CLK a_27195_3514# VPWR.t282 VPWR.t10 sg13_lv_pmos ad=0.2128p pd=1.5u as=0.2128p ps=1.5u w=1.12u l=0.13u
X3375 VPWR.t994 a_15850_3862# sg13cmos5l_buf_8_0.X VPWR.t43 sg13_lv_pmos ad=0.2128p pd=1.5u as=0.2128p ps=1.5u w=1.12u l=0.13u
X3376 a_25126_3569# sg13cmos5l_buf_1_4.X.t4 VGND.t293 VGND.t1280 sg13_lv_nmos ad=37.8f pd=0.6u as=0.1701p ps=1.65u w=0.42u l=0.13u
X3377 a_25318_883# sg13cmos5l_buf_1_4.X.t2 VGND.t174 VGND.t1235 sg13_lv_nmos ad=37.8f pd=0.6u as=0.1701p ps=1.65u w=0.42u l=0.13u
X3378 sg13cmos5l_dlygate4sd3_1_55.A a_22314_6168# VGND.t65 VGND.t64 sg13_lv_nmos ad=0.2516p pd=2.16u as=0.1406p ps=1.12u w=0.74u l=0.13u
X3379 a_3684_3894# sg13cmos5l_dfrbpq_1_15.D a_3590_3894# VGND.t70 sg13_lv_nmos ad=60.89999f pd=0.71u as=0.1428p ps=1.52u w=0.42u l=0.13u
X3380 a_25414_3907# sg13cmos5l_buf_1_4.X.t6 VGND.t293 VGND.t1283 sg13_lv_nmos ad=37.8f pd=0.6u as=0.1701p ps=1.65u w=0.42u l=0.13u
X3381 sg13cmos5l_dfrbpq_1_47.Q a_17994_7216# VPWR.t262 VPWR.t2 sg13_lv_pmos ad=0.3808p pd=2.92u as=0.2128p ps=1.5u w=1.12u l=0.13u
X3382 a_4762_6886# sg13cmos5l_dfrbpq_1_58.Q VPWR.t820 VPWR.t2 sg13_lv_pmos ad=0.1428p pd=1.52u as=0.1523p ps=1.38u w=0.42u l=0.13u
X3383 sg13cmos5l_dfrbpq_1_56.CLK a_18363_6922# VPWR.t877 VPWR.t2 sg13_lv_pmos ad=0.2128p pd=1.5u as=0.2128p ps=1.5u w=1.12u l=0.13u
X3384 a_24727_1596# a_25287_1719# a_25198_1755# VPWR.t15 sg13_lv_pmos ad=0.2048p pd=1.63u as=93.45f ps=0.865u w=0.42u l=0.13u
X3385 a_1301_874# sg13cmos5l_xnor2_1_6.B VGND.t35 VGND.t1552 sg13_lv_nmos ad=0.1406p pd=1.12u as=0.1898p ps=1.36u w=0.74u l=0.13u
X3386 sg13cmos5l_dlygate4sd3_1_18.X a_9558_938# VPWR.t200 VPWR.t15 sg13_lv_pmos ad=0.4256p pd=3u as=0.2254p ps=1.53u w=1.12u l=0.13u
X3387 a_14148_3569# a_13860_3148# a_14086_3569# VGND.t1130 sg13_lv_nmos ad=0.1428p pd=1.52u as=37.8f ps=0.6u w=0.42u l=0.13u
X3388 VGND.t316 a_15376_3386# a_15025_3505# VGND.t1364 sg13_lv_nmos ad=79.8f pd=0.8u as=0.1428p ps=1.52u w=0.42u l=0.13u
X3389 a_6276_7236# a_6250_7141# VPWR.t822 VPWR.t2 sg13_lv_pmos ad=0.34p pd=2.68u as=0.36237p ps=2.605u w=1u l=0.13u
X3390 VPWR.t8 VGND.t65 VPWR.t8 VPWR.t7 sg13_lv_pmos ad=0.34p pd=2.68u as=0 ps=0 w=1u l=1u
X3391 VPWR.t738 sg13cmos5l_dlygate4sd3_1_21.A a_920_1673# VPWR.t15 sg13_lv_pmos ad=0.1523p pd=1.38u as=0.1428p ps=1.52u w=0.42u l=0.13u
X3392 VGND.t273 a_27280_8650# a_26929_8507# VGND.t72 sg13_lv_nmos ad=79.8f pd=0.8u as=0.1428p ps=1.52u w=0.42u l=0.13u
X3393 a_24612_6172# a_24586_6136# VGND.t128 VGND.t485 sg13_lv_nmos ad=0.2516p pd=2.16u as=0.1626p ps=1.415u w=0.74u l=0.13u
X3394 VPWR.t2 a_8848_7922# a_8793_7803# VPWR.t2 sg13_lv_pmos ad=1.34765p pd=8.56u as=93.45f ps=0.865u w=0.42u l=0.13u
X3395 a_2266_6132# sg13cmos5l_dfrbpq_1_23.Q VGND.t278 VGND.t1656 sg13_lv_nmos ad=0.1428p pd=1.52u as=79.8f ps=0.8u w=0.42u l=0.13u
X3396 a_5301_1028# a_4359_1088# a_5162_1028# VGND.t361 sg13_lv_nmos ad=79.8f pd=0.8u as=0.2373p ps=1.97u w=0.42u l=0.13u
X3397 a_10308_8748# a_10282_8653# VGND.t90 VGND.t89 sg13_lv_nmos ad=0.2516p pd=2.16u as=0.1626p ps=1.415u w=0.74u l=0.13u
X3398 a_20782_8118# a_21023_7651# a_20311_7644# VGND.t1040 sg13_lv_nmos ad=0.1428p pd=1.52u as=0.12665p ps=1.145u w=0.42u l=0.13u
X3399 a_27280_5626# a_27023_5483# a_27442_5406# VGND.t200 sg13_lv_nmos ad=0.1428p pd=1.52u as=37.8f ps=0.6u w=0.42u l=0.13u
X3400 a_16469_2002# sg13cmos5l_xnor2_1_2.B VGND.t465 VGND.t153 sg13_lv_nmos ad=0.1406p pd=1.12u as=0.1898p ps=1.36u w=0.74u l=0.13u
X3401 a_4876_8118# a_4663_7644# VPWR.t2 VPWR.t2 sg13_lv_pmos ad=79.8f pd=0.8u as=1.34765p ps=8.56u w=0.42u l=0.13u
X3402 VPWR.t875 a_18363_6922# sg13cmos5l_dfrbpq_1_56.CLK VPWR.t2 sg13_lv_pmos ad=0.2128p pd=1.5u as=0.2128p ps=1.5u w=1.12u l=0.13u
X3403 VGND.t363 sg13cmos5l_dfrbpq_1_13.RESET_B.t5 a_5558_883# VGND.t1613 sg13_lv_nmos ad=0.1701p pd=1.65u as=37.8f ps=0.6u w=0.42u l=0.13u
X3404 a_11835_3191# a_10943_3115# a_11733_3191# VPWR.t10 sg13_lv_pmos ad=63f pd=0.72u as=79.8f ps=0.8u w=0.42u l=0.13u
X3405 a_11733_4703# sg13cmos5l_dfrbpq_1_57.RESET_B.t0 VPWR.t133 VPWR.t43 sg13_lv_pmos ad=0.147p pd=1.54u as=0.1563p ps=1.22u w=0.42u l=0.13u
X3406 a_11824_1090# sg13cmos5l_dfrbpq_1_13.RESET_B.t1 VPWR.t105 VPWR.t15 sg13_lv_pmos ad=79.8f pd=0.8u as=1.46697p ps=9.345u w=0.42u l=0.13u
X3407 a_11639_2773# sg13cmos5l_dfrbpq_1_22.D a_12386_2382# VGND.t719 sg13_lv_nmos ad=0.1428p pd=1.52u as=60.89999f ps=0.71u w=0.42u l=0.13u
X3408 sg13cmos5l_dlygate4sd3_1_23.X a_2166_3168# VPWR.t1081 VPWR.t10 sg13_lv_pmos ad=0.4256p pd=3u as=0.2254p ps=1.53u w=1.12u l=0.13u
X3409 VPWR.t487 a_13642_5374# sg13cmos5l_and2_1_3.A VPWR.t7 sg13_lv_pmos ad=0.2128p pd=1.5u as=0.2128p ps=1.5u w=1.12u l=0.13u
X3410 a_25990_5419# sg13cmos5l_dfrbpq_1_53.RESET_B.t4 VGND.t203 VGND.t301 sg13_lv_nmos ad=37.8f pd=0.6u as=0.1701p ps=1.65u w=0.42u l=0.13u
X3411 VPWR.t227 a_24922_4620# a_24641_4922# VPWR.t43 sg13_lv_pmos ad=0.1523p pd=1.38u as=0.34p ps=2.68u w=1u l=0.5u
X3412 sg13cmos5l_xnor2_1_4.A sg13cmos5l_dlygate4sd3_1_39.X a_25146_8446# VGND.t63 sg13_lv_nmos ad=0.1628p pd=1.18u as=88.8f ps=0.98u w=0.74u l=0.13u
X3413 a_28570_8398# sg13cmos5l_dfrbpq_1_53.Q VPWR.t126 VPWR.t0 sg13_lv_pmos ad=0.1428p pd=1.52u as=0.1523p ps=1.38u w=0.42u l=0.13u
X3414 VGND.t126 a_26128_6410# a_25777_6529# VGND.t484 sg13_lv_nmos ad=79.8f pd=0.8u as=0.1428p ps=1.52u w=0.42u l=0.13u
X3415 VGND.t131 sg13cmos5l_dfrbpq_1_57.Q a_9176_5410# VGND.t295 sg13_lv_nmos ad=79.8f pd=0.8u as=0.1428p ps=1.52u w=0.42u l=0.13u
X3416 a_18564_3148# a_18538_3112# VGND.t50 VGND.t447 sg13_lv_nmos ad=0.2516p pd=2.16u as=0.1626p ps=1.415u w=0.74u l=0.13u
X3417 a_10282_8653# a_10725_8409# a_10022_8430# VGND.t89 sg13_lv_nmos ad=79.8f pd=0.8u as=0.1296p ps=1.52u w=0.42u l=0.13u
X3418 VPWR.t954 a_8842_6886# sg13cmos5l_dfrbpq_1_57.CLK VPWR.t2 sg13_lv_pmos ad=0.2128p pd=1.5u as=0.2128p ps=1.5u w=1.12u l=0.13u
X3419 VGND.t25 sg13cmos5l_dfrbpq_1_56.RESET_B a_15876_6918# VGND.t830 sg13_lv_nmos ad=0.1626p pd=1.415u as=60.89999f ps=0.71u w=0.42u l=0.13u
X3420 VGND.t30 a_17423_5483# a_18090_5704# VGND.t724 sg13_lv_nmos ad=0.1406p pd=1.12u as=0.2516p ps=2.16u w=0.74u l=0.13u
X3421 sg13cmos5l_dfrbpq_1_53.CLK a_27963_6538# VGND.t197 VGND.t1561 sg13_lv_nmos ad=0.1406p pd=1.12u as=0.1406p ps=1.12u w=0.74u l=0.13u
X3422 a_13867_6964# sg13cmos5l_and2_1_3.A a_13773_6964# VGND.t95 sg13_lv_nmos ad=0.1216p pd=1.02u as=0.2176p ps=1.96u w=0.64u l=0.13u
X3423 VPWR.t105 sg13cmos5l_dfrbpq_1_13.RESET_B.t4 a_6604_870# VPWR.t15 sg13_lv_pmos ad=1.46697p pd=9.345u as=79.8f ps=0.8u w=0.42u l=0.13u
X3424 a_7911_1719# a_8063_1603# VGND.t77 VGND.t226 sg13_lv_nmos ad=0.2516p pd=2.16u as=3.25012p ps=20.49u w=0.74u l=0.13u
X3425 sg13cmos5l_xnor2_1_4.A a_24881_8484# a_25052_8728# VPWR.t0 sg13_lv_pmos ad=0.3808p pd=2.92u as=0.2128p ps=1.5u w=1.12u l=0.13u
X3426 a_10725_1643# sg13cmos5l_dfrbpq_1_13.CLK VGND.t77 VGND.t751 sg13_lv_nmos ad=0.2516p pd=2.16u as=3.06955p ps=19.355u w=0.74u l=0.13u
X3427 VGND.t630 sg13cmos5l_buf_8_10.A a_8842_6886# VGND.t1082 sg13_lv_nmos ad=0.1406p pd=1.12u as=0.1406p ps=1.12u w=0.74u l=0.13u
X3428 a_28646_874# a_28376_874# VGND.t176 VGND.t614 sg13_lv_nmos ad=0.1428p pd=1.52u as=79.8f ps=0.8u w=0.42u l=0.5u
X3429 a_21934_1059# a_22049_1060# VPWR.t257 VPWR.t15 sg13_lv_pmos ad=0.34p pd=2.68u as=0.2254p ps=1.53u w=1u l=0.5u
X3430 VGND.t201 a_28174_4923# sg13cmos5l_nor3_1_0.C VGND.t200 sg13_lv_nmos ad=0.1426p pd=1.16u as=0.2516p ps=2.16u w=0.74u l=0.13u
X3431 VGND.t73 a_28570_8398# a_28289_8620# VGND.t72 sg13_lv_nmos ad=79.8f pd=0.8u as=0.1428p ps=1.52u w=0.42u l=0.5u
X3432 a_11639_4703# a_10943_4627# a_11733_4703# VGND.t1421 sg13_lv_nmos ad=0.1296p pd=1.52u as=79.8f ps=0.8u w=0.42u l=0.13u
X3433 VGND.t62 sg13cmos5l_dlygate4sd3_1_39.X a_24881_8484# VGND.t61 sg13_lv_nmos ad=0.15245p pd=1.17u as=0.17462p ps=1.185u w=0.55u l=0.13u
X3434 VGND.t52 sg13cmos5l_dfrbpq_1_58.RESET_B a_5258_5094# VGND.t30 sg13_lv_nmos ad=79.8f pd=0.8u as=37.8f ps=0.6u w=0.42u l=0.13u
X3435 VPWR.t43 a_26447_3971# a_26704_4114# VPWR.t43 sg13_lv_pmos ad=1.3927p pd=8.9u as=79.8f ps=0.8u w=0.42u l=0.13u
X3436 VPWR.t341 sg13cmos5l_dfrbpq_1_16.Q a_4088_5410# VPWR.t7 sg13_lv_pmos ad=0.1523p pd=1.38u as=0.1428p ps=1.52u w=0.42u l=0.13u
X3437 VPWR.t27 VGND.t1525 VPWR.t26 VPWR.t10 sg13_lv_pmos ad=0.19p pd=1.38u as=0 ps=0 w=1u l=1u
X3438 VPWR.t43 a_5392_4114# a_5337_4209# VPWR.t43 sg13_lv_pmos ad=1.3927p pd=8.9u as=93.45f ps=0.865u w=0.42u l=0.13u
X3439 a_15191_1679# sg13cmos5l_dfrbpq_1_55.RESET_B VPWR.t214 VPWR.t15 sg13_lv_pmos ad=79.8f pd=0.8u as=0.36237p ps=2.605u w=0.42u l=0.13u
X3440 sg13cmos5l_xnor2_1_6.Y sg13cmos5l_xnor2_1_6.B a_1395_1168# VPWR.t15 sg13_lv_pmos ad=0.2408p pd=1.55u as=0.1428p ps=1.375u w=1.12u l=0.13u
X3441 VPWR.t318 sg13cmos5l_dfrbpq_1_1.Q a_27416_874# VPWR.t15 sg13_lv_pmos ad=0.1523p pd=1.38u as=0.1428p ps=1.52u w=0.42u l=0.13u
X3442 sg13cmos5l_dfrbpq_1_57.CLK a_8842_6886# VGND.t630 VGND.t1074 sg13_lv_nmos ad=0.1406p pd=1.12u as=0.1406p ps=1.12u w=0.74u l=0.13u
X3443 VGND.t32 a_3680_1045# sg13cmos5l_dlygate4sd3_1_21.A VGND.t554 sg13_lv_nmos ad=0.1406p pd=1.12u as=0.2516p ps=2.16u w=0.74u l=0.13u
X3444 VGND.t11 a_27214_1899# sg13cmos5l_nor4_2_0.D VGND.t405 sg13_lv_nmos ad=0.1426p pd=1.16u as=0.2516p ps=2.16u w=0.74u l=0.13u
X3445 a_8898_3510# sg13cmos5l_nand3_1_3.B a_8796_3510# VGND.t525 sg13_lv_nmos ad=0.1406p pd=1.12u as=0.1406p ps=1.12u w=0.74u l=0.13u
X3446 a_26410_7141# a_26853_6897# a_26150_6918# VGND.t426 sg13_lv_nmos ad=79.8f pd=0.8u as=0.1296p ps=1.52u w=0.42u l=0.13u
X3447 VPWR.t649 a_6272_4069# sg13cmos5l_dfrbpq_1_23.Q VPWR.t43 sg13_lv_pmos ad=0.2128p pd=1.5u as=0.3808p ps=2.92u w=1.12u l=0.13u
X3448 a_16078_5094# a_15820_5094# VGND.t350 VGND.t1365 sg13_lv_nmos ad=0.1428p pd=1.52u as=79.8f ps=0.8u w=0.42u l=0.13u
X3449 VPWR.t323 sg13cmos5l_dfrbpq_1_12.Q a_14360_3898# VPWR.t43 sg13_lv_pmos ad=0.1523p pd=1.38u as=0.1428p ps=1.52u w=0.42u l=0.13u
X3450 VGND.t133 a_18843_5410# sg13cmos5l_and2_1_1.A VGND.t1397 sg13_lv_nmos ad=0.2516p pd=2.16u as=0.1406p ps=1.12u w=0.74u l=0.13u
X3451 a_10308_1636# a_10282_1600# VPWR.t108 VPWR.t15 sg13_lv_pmos ad=0.34p pd=2.68u as=0.36237p ps=2.605u w=1u l=0.13u
X3452 VGND.t54 VPWR.t79 VGND.t54 VGND.t53 sg13_lv_nmos ad=0.1428p pd=1.52u as=0 ps=0 w=0.42u l=1u
X3453 a_19257_4209# a_18315_4016# a_19055_3971# VPWR.t43 sg13_lv_pmos ad=93.45f pd=0.865u as=0.2048p ps=1.63u w=0.42u l=0.13u
X3454 a_8004_2395# a_8235_2504# a_7690_2605# VGND.t1411 sg13_lv_nmos ad=0.2373p pd=1.97u as=79.8f ps=0.8u w=0.42u l=0.13u
X3455 a_10116_8430# sg13cmos5l_xnor2_1_8.Y a_10022_8430# VGND.t89 sg13_lv_nmos ad=60.89999f pd=0.71u as=0.1428p ps=1.52u w=0.42u l=0.13u
X3456 VGND.t11 a_27878_2386# a_27990_2450# VGND.t472 sg13_lv_nmos ad=0.1426p pd=1.16u as=0.1428p ps=1.52u w=0.42u l=0.5u
X3457 VPWR.t728 sg13cmos5l_dfrbpq_1_42.Q a_19256_8434# VPWR.t0 sg13_lv_pmos ad=0.1523p pd=1.38u as=0.1428p ps=1.52u w=0.42u l=0.13u
X3458 VGND.t630 a_8842_6886# sg13cmos5l_dfrbpq_1_57.CLK VGND.t1071 sg13_lv_nmos ad=0.1406p pd=1.12u as=0.1406p ps=1.12u w=0.74u l=0.13u
X3459 a_1870_7947# a_1985_7946# VPWR.t405 VPWR.t2 sg13_lv_pmos ad=0.34p pd=2.68u as=0.2254p ps=1.53u w=1u l=0.5u
X3460 sg13cmos5l_nand3_1_0.B sg13cmos5l_nor4_2_0.D VGND.t216 VGND.t845 sg13_lv_nmos ad=0.1406p pd=1.12u as=0.3293p ps=1.63u w=0.74u l=0.13u
X3461 a_12386_3582# sg13cmos5l_dfrbpq_1_55.RESET_B VGND.t572 VGND.t577 sg13_lv_nmos ad=60.89999f pd=0.71u as=0.1626p ps=1.415u w=0.42u l=0.13u
X3462 a_3876_3148# a_3850_3112# VGND.t861 VGND.t1400 sg13_lv_nmos ad=0.2516p pd=2.16u as=0.1626p ps=1.415u w=0.74u l=0.13u
X3463 VPWR.t259 sg13cmos5l_dfrbpq_1_56.RESET_B a_16042_7141# VPWR.t2 sg13_lv_pmos ad=0.1563p pd=1.22u as=0.147p ps=1.54u w=0.42u l=0.13u
X3464 a_28174_5595# a_28289_5596# VGND.t201 VGND.t200 sg13_lv_nmos ad=0.1428p pd=1.52u as=0.1426p ps=1.16u w=0.42u l=0.5u
X3465 a_22138_1596# sg13cmos5l_dlygate4sd3_1_5.A VGND.t17 VGND.t809 sg13_lv_nmos ad=0.1428p pd=1.52u as=79.8f ps=0.8u w=0.42u l=0.13u
X3466 sg13cmos5l_dfrbpq_1_38.Q a_17898_6168# VGND.t191 VGND.t1184 sg13_lv_nmos ad=0.2516p pd=2.16u as=0.1406p ps=1.12u w=0.74u l=0.13u
X3467 VGND.t54 a_21435_3514# sg13cmos5l_buf_8_2.X VGND.t53 sg13_lv_nmos ad=0.1406p pd=1.12u as=0.1406p ps=1.12u w=0.74u l=0.13u
R0 en[4] en[4].t0 106.088
R1 VPWR.n637 VPWR.t126 17.4859
R2 VPWR.n161 VPWR.t329 17.3693
R3 VPWR.n163 VPWR.t152 17.3693
R4 VPWR.n141 VPWR.t508 17.3693
R5 VPWR.n133 VPWR.t130 17.3693
R6 VPWR.n137 VPWR.t439 17.3693
R7 VPWR.n253 VPWR.t340 17.3693
R8 VPWR.n276 VPWR.t1049 17.3693
R9 VPWR.n287 VPWR.t414 17.3693
R10 VPWR.n314 VPWR.t90 17.3693
R11 VPWR.n314 VPWR.t524 17.3693
R12 VPWR.n285 VPWR.t418 17.3693
R13 VPWR.n236 VPWR.t559 17.3693
R14 VPWR.n227 VPWR.t668 17.3693
R15 VPWR.n226 VPWR.t681 17.3693
R16 VPWR.n39 VPWR.t529 17.3693
R17 VPWR.n39 VPWR.t522 17.3693
R18 VPWR.n833 VPWR.t696 17.3693
R19 VPWR.n828 VPWR.t312 17.3693
R20 VPWR.n769 VPWR.t410 17.3693
R21 VPWR.n341 VPWR.t215 17.3693
R22 VPWR.n337 VPWR.t846 17.3693
R23 VPWR.n799 VPWR.t133 17.3693
R24 VPWR.n861 VPWR.t212 17.3693
R25 VPWR.n871 VPWR.t749 17.3693
R26 VPWR.n6 VPWR.t148 17.3693
R27 VPWR.n6 VPWR.t612 17.3693
R28 VPWR.n722 VPWR.t747 17.3693
R29 VPWR.n724 VPWR.t390 17.3693
R30 VPWR.n448 VPWR.t177 17.3693
R31 VPWR.n448 VPWR.t396 17.3693
R32 VPWR.n421 VPWR.t332 17.3693
R33 VPWR.n402 VPWR.t644 17.3693
R34 VPWR.n401 VPWR.t840 17.3693
R35 VPWR.n422 VPWR.t141 17.3693
R36 VPWR.n566 VPWR.t259 17.3693
R37 VPWR.n50 VPWR.t138 17.3693
R38 VPWR.n682 VPWR.t401 17.3693
R39 VPWR.n526 VPWR.t600 17.3693
R40 VPWR.n500 VPWR.t836 17.3693
R41 VPWR.n498 VPWR.t673 17.3693
R42 VPWR.n507 VPWR.t406 17.3693
R43 VPWR.n527 VPWR.t708 17.3693
R44 VPWR.n641 VPWR.t586 17.3693
R45 VPWR.n652 VPWR.t288 17.3693
R46 VPWR.n666 VPWR.t446 17.3693
R47 VPWR.n603 VPWR.t136 17.3693
R48 VPWR.n622 VPWR.t779 17.3693
R49 VPWR.n624 VPWR.t131 17.3693
R50 VPWR.n148 VPWR.t145 17.3693
R51 VPWR.n150 VPWR.t146 17.3693
R52 VPWR.n159 VPWR.t769 17.3517
R53 VPWR.n165 VPWR.t730 17.3517
R54 VPWR.n142 VPWR.t1309 17.3517
R55 VPWR.n134 VPWR.t1061 17.3517
R56 VPWR.n138 VPWR.t499 17.3517
R57 VPWR.n251 VPWR.t659 17.3517
R58 VPWR.n292 VPWR.t188 17.3517
R59 VPWR.n317 VPWR.t213 17.3517
R60 VPWR.n316 VPWR.t1050 17.3517
R61 VPWR.n289 VPWR.t1006 17.3517
R62 VPWR.n231 VPWR.t1278 17.3517
R63 VPWR.n207 VPWR.t639 17.3517
R64 VPWR.n223 VPWR.t1300 17.3517
R65 VPWR.n247 VPWR.t658 17.3517
R66 VPWR.n246 VPWR.t1058 17.3517
R67 VPWR.n830 VPWR.t1403 17.3517
R68 VPWR.n772 VPWR.t653 17.3517
R69 VPWR.n757 VPWR.t123 17.3517
R70 VPWR.n765 VPWR.t898 17.3517
R71 VPWR.n326 VPWR.t407 17.3517
R72 VPWR.n867 VPWR.t589 17.3517
R73 VPWR.n864 VPWR.t1341 17.3517
R74 VPWR.n840 VPWR.t617 17.3517
R75 VPWR.n839 VPWR.t1185 17.3517
R76 VPWR.n726 VPWR.t1269 17.3517
R77 VPWR.n729 VPWR.t923 17.3517
R78 VPWR.n696 VPWR.t299 17.3517
R79 VPWR.n695 VPWR.t267 17.3517
R80 VPWR.n418 VPWR.t634 17.3517
R81 VPWR.n375 VPWR.t860 17.3517
R82 VPWR.n398 VPWR.t421 17.3517
R83 VPWR.n426 VPWR.t429 17.3517
R84 VPWR.n568 VPWR.t597 17.3517
R85 VPWR.n575 VPWR.t830 17.3517
R86 VPWR.n523 VPWR.t862 17.3517
R87 VPWR.n453 VPWR.t851 17.3517
R88 VPWR.n502 VPWR.t420 17.3517
R89 VPWR.n504 VPWR.t979 17.3517
R90 VPWR.n531 VPWR.t975 17.3517
R91 VPWR.n643 VPWR.t1067 17.3517
R92 VPWR.n653 VPWR.t1253 17.3517
R93 VPWR.n664 VPWR.t1105 17.3517
R94 VPWR.n605 VPWR.t165 17.3517
R95 VPWR.n619 VPWR.t962 17.3517
R96 VPWR.n625 VPWR.t511 17.3517
R97 VPWR.n146 VPWR.t497 17.3517
R98 VPWR.n151 VPWR.t452 17.3517
R99 VPWR.n180 VPWR.t562 17.3326
R100 VPWR.n172 VPWR.t318 17.3326
R101 VPWR.n174 VPWR.t343 17.3326
R102 VPWR.n178 VPWR.t189 17.3326
R103 VPWR.n130 VPWR.t228 17.3326
R104 VPWR.n22 VPWR.t369 17.3326
R105 VPWR.n262 VPWR.t314 17.3326
R106 VPWR.n307 VPWR.t350 17.3326
R107 VPWR.n311 VPWR.t1096 17.3326
R108 VPWR.n299 VPWR.t1257 17.3326
R109 VPWR.n9 VPWR.t682 17.3326
R110 VPWR.n220 VPWR.t580 17.3326
R111 VPWR.n193 VPWR.t1215 17.3326
R112 VPWR.n817 VPWR.t1107 17.3326
R113 VPWR.n821 VPWR.t362 17.3326
R114 VPWR.n815 VPWR.t1031 17.3326
R115 VPWR.n779 VPWR.t720 17.3326
R116 VPWR.n770 VPWR.t774 17.3326
R117 VPWR.n333 VPWR.t721 17.3326
R118 VPWR.n778 VPWR.t306 17.3326
R119 VPWR.n896 VPWR.t323 17.3326
R120 VPWR.n902 VPWR.t216 17.3326
R121 VPWR.n890 VPWR.t360 17.3326
R122 VPWR.n736 VPWR.t344 17.3326
R123 VPWR.n734 VPWR.t1084 17.3326
R124 VPWR.n714 VPWR.t481 17.3326
R125 VPWR.n702 VPWR.t1248 17.3326
R126 VPWR.n432 VPWR.t834 17.3326
R127 VPWR.n444 VPWR.t1115 17.3326
R128 VPWR.n361 VPWR.t987 17.3326
R129 VPWR.n392 VPWR.t341 17.3326
R130 VPWR.n391 VPWR.t916 17.3326
R131 VPWR.n414 VPWR.t1082 17.3326
R132 VPWR.n414 VPWR.t719 17.3326
R133 VPWR.n535 VPWR.t765 17.3326
R134 VPWR.n687 VPWR.t302 17.3326
R135 VPWR.n479 VPWR.t422 17.3326
R136 VPWR.n496 VPWR.t850 17.3326
R137 VPWR.n457 VPWR.t820 17.3326
R138 VPWR.n460 VPWR.t816 17.3326
R139 VPWR.n658 VPWR.t728 17.3326
R140 VPWR.n659 VPWR.t1151 17.3326
R141 VPWR.n661 VPWR.t797 17.3326
R142 VPWR.n670 VPWR.t154 17.3326
R143 VPWR.n674 VPWR.t871 17.3326
R144 VPWR.n154 VPWR.t193 17.3326
R145 VPWR.n559 VPWR.t882 17.2438
R146 VPWR.n182 VPWR.t459 17.2247
R147 VPWR.t200 VPWR.t566 17.2247
R148 VPWR.n270 VPWR.t313 17.2247
R149 VPWR.n303 VPWR.t432 17.2247
R150 VPWR.n218 VPWR.t1002 17.2247
R151 VPWR.n900 VPWR.t621 17.2247
R152 VPWR.n716 VPWR.t164 17.2247
R153 VPWR.n350 VPWR.t638 17.2247
R154 VPWR.n412 VPWR.t163 17.2247
R155 VPWR.n539 VPWR.t455 17.2247
R156 VPWR.n691 VPWR.t290 17.2247
R157 VPWR.n482 VPWR.t291 17.2247
R158 VPWR.n482 VPWR.t675 17.2247
R159 VPWR.n520 VPWR.t901 17.2247
R160 VPWR.n646 VPWR.t117 17.2247
R161 VPWR.n627 VPWR.t762 17.2247
R162 VPWR.n675 VPWR.t158 17.2247
R163 VPWR.n36 VPWR.t1079 17.3525
R164 VPWR.t91 VPWR.n275 17.053
R165 VPWR.t2 VPWR.n471 17.0068
R166 VPWR.t105 VPWR.n112 17.0005
R167 VPWR.t153 VPWR.n181 17.0005
R168 VPWR.t153 VPWR.n177 17.0005
R169 VPWR.t153 VPWR.n169 17.0005
R170 VPWR.n159 VPWR.t203 17.0005
R171 VPWR.n165 VPWR.t151 17.0005
R172 VPWR.t105 VPWR.n125 17.0005
R173 VPWR.t105 VPWR.n129 17.0005
R174 VPWR.n142 VPWR.t1375 17.0005
R175 VPWR.t105 VPWR.n69 5.64879
R176 VPWR.n134 VPWR.t351 17.0005
R177 VPWR.n138 VPWR.t155 17.0005
R178 VPWR.n28 VPWR.n27 0.0360754
R179 VPWR.t91 VPWR.n191 17.0005
R180 VPWR.t91 VPWR.n209 17.0005
R181 VPWR.t91 VPWR.n210 17.0005
R182 VPWR.t91 VPWR.n294 17.0005
R183 VPWR.t91 VPWR.n298 17.0005
R184 VPWR.t91 VPWR.n304 17.0005
R185 VPWR.t91 VPWR.n271 17.0005
R186 VPWR.t91 VPWR.n265 17.0005
R187 VPWR.t91 VPWR.n17 2.29781
R188 VPWR.t91 VPWR.n258 17.0005
R189 VPWR.n251 VPWR.t1128 17.0005
R190 VPWR.n292 VPWR.t415 17.0005
R191 VPWR.n317 VPWR.t518 17.0005
R192 VPWR.n316 VPWR.t525 17.0005
R193 VPWR.n289 VPWR.t417 17.0005
R194 VPWR.t91 VPWR.n212 17.0005
R195 VPWR.n231 VPWR.t560 17.0005
R196 VPWR.n207 VPWR.t667 17.0005
R197 VPWR.n223 VPWR.t935 17.0005
R198 VPWR.n247 VPWR.t527 17.0005
R199 VPWR.n246 VPWR.t521 17.0005
R200 VPWR.t43 VPWR.n75 17.0005
R201 VPWR.n908 VPWR.t43 17.0005
R202 VPWR.t43 VPWR.n838 17.0005
R203 VPWR.n836 VPWR.t43 17.0005
R204 VPWR.t43 VPWR.n23 8.47142
R205 VPWR.n60 VPWR.n23 0.0601683
R206 VPWR.t77 VPWR.n8 0.228992
R207 VPWR.t43 VPWR.n844 17.0005
R208 VPWR.t43 VPWR.n891 17.0005
R209 VPWR.t43 VPWR.n895 17.0005
R210 VPWR.t43 VPWR.n903 17.0005
R211 VPWR.t43 VPWR.n832 17.0005
R212 VPWR.t43 VPWR.n820 17.0005
R213 VPWR.n830 VPWR.t311 17.0005
R214 VPWR.t43 VPWR.n328 17.0005
R215 VPWR.t43 VPWR.n785 17.0005
R216 VPWR.t43 VPWR.n329 17.0005
R217 VPWR.t43 VPWR.n330 17.0005
R218 VPWR.t43 VPWR.n777 17.0005
R219 VPWR.t43 VPWR.n771 17.0005
R220 VPWR.n772 VPWR.t218 17.0005
R221 VPWR.t43 VPWR.n77 5.64741
R222 VPWR.t43 VPWR.n804 17.0005
R223 VPWR.t43 VPWR.n813 17.0005
R224 VPWR.t43 VPWR.n805 17.0005
R225 VPWR.n757 VPWR.t781 17.0005
R226 VPWR.n765 VPWR.t609 17.0005
R227 VPWR.n326 VPWR.t132 17.0005
R228 VPWR.n867 VPWR.t718 17.0005
R229 VPWR.n864 VPWR.t758 17.0005
R230 VPWR.n840 VPWR.t149 17.0005
R231 VPWR.n839 VPWR.t1093 17.0005
R232 VPWR.n33 VPWR.n32 0.0360754
R233 VPWR.t7 VPWR.n363 17.0005
R234 VPWR.t7 VPWR.n425 17.0005
R235 VPWR.t7 VPWR.n420 17.0005
R236 VPWR.t7 VPWR.n413 17.0005
R237 VPWR.t7 VPWR.n366 17.0005
R238 VPWR.t7 VPWR.n369 17.0005
R239 VPWR.t7 VPWR.n407 17.0005
R240 VPWR.t7 VPWR.n390 17.0005
R241 VPWR.t7 VPWR.n388 17.0005
R242 VPWR.t7 VPWR.n731 17.0005
R243 VPWR.t7 VPWR.n707 17.0005
R244 VPWR.t7 VPWR.n709 17.0005
R245 VPWR.t7 VPWR.n713 17.0005
R246 VPWR.n726 VPWR.t697 17.0005
R247 VPWR.n729 VPWR.t364 17.0005
R248 VPWR.n696 VPWR.t176 17.0005
R249 VPWR.n695 VPWR.t397 17.0005
R250 VPWR.t7 VPWR.n439 17.0005
R251 VPWR.t7 VPWR.n437 17.0005
R252 VPWR.n2 VPWR.t7 1.35464
R253 VPWR.t7 VPWR.n348 17.0005
R254 VPWR.n418 VPWR.t677 17.0005
R255 VPWR.n375 VPWR.t845 17.0005
R256 VPWR.n398 VPWR.t839 17.0005
R257 VPWR.n426 VPWR.t142 17.0005
R258 VPWR.t2 VPWR.n530 17.0005
R259 VPWR.t2 VPWR.n525 17.0005
R260 VPWR.t2 VPWR.n89 3.48615
R261 VPWR.t2 VPWR.n499 17.0005
R262 VPWR.t2 VPWR.n574 17.0005
R263 VPWR.t2 VPWR.n577 17.0005
R264 VPWR.t2 VPWR.n590 17.0005
R265 VPWR.t2 VPWR.n562 17.0005
R266 VPWR.t2 VPWR.n560 17.0005
R267 VPWR.t2 VPWR.n558 17.0005
R268 VPWR.t2 VPWR.n540 17.0005
R269 VPWR.t2 VPWR.n536 17.0005
R270 VPWR.n568 VPWR.t748 17.0005
R271 VPWR.n575 VPWR.t139 17.0005
R272 VPWR.t2 VPWR.n487 17.0005
R273 VPWR.t2 VPWR.n480 17.0005
R274 VPWR.t2 VPWR.n468 17.0005
R275 VPWR.t2 VPWR.n64 5.61512
R276 VPWR.n523 VPWR.t599 17.0005
R277 VPWR.n453 VPWR.t822 17.0005
R278 VPWR.n502 VPWR.t672 17.0005
R279 VPWR.n504 VPWR.t778 17.0005
R280 VPWR.n531 VPWR.t425 17.0005
R281 VPWR.n37 VPWR.n34 3.30706
R282 VPWR.t1 VPWR.n628 17.0005
R283 VPWR.n45 VPWR.t1 2.72082
R284 VPWR.n679 VPWR.t1 17.0005
R285 VPWR.t1 VPWR.n597 17.0005
R286 VPWR.n643 VPWR.t592 17.0005
R287 VPWR.n653 VPWR.t328 17.0005
R288 VPWR.n664 VPWR.t89 17.0005
R289 VPWR.n605 VPWR.t137 17.0005
R290 VPWR.n619 VPWR.t729 17.0005
R291 VPWR.n625 VPWR.t665 17.0005
R292 VPWR.n146 VPWR.t144 17.0005
R293 VPWR.n151 VPWR.t147 17.0005
R294 VPWR.n905 VPWR.t1456 15.2621
R295 VPWR.n802 VPWR.t1459 15.2621
R296 VPWR.n591 VPWR.t1469 15.2621
R297 VPWR.n472 VPWR.t1472 15.2621
R298 VPWR.n484 VPWR.t1471 15.2621
R299 VPWR.n629 VPWR.t1475 15.2621
R300 VPWR.n127 VPWR.t1450 15.2617
R301 VPWR.n386 VPWR.t1466 15.2617
R302 VPWR.n929 VPWR.n928 9.0005
R303 VPWR.n932 VPWR.n931 9.0005
R304 VPWR.n915 VPWR.n914 9.0005
R305 VPWR.n916 VPWR.n915 9.0005
R306 VPWR.n923 VPWR.n186 9.0005
R307 VPWR.n919 VPWR.n186 9.0005
R308 VPWR.n808 VPWR.t654 8.86892
R309 VPWR.n814 VPWR.t478 8.85359
R310 VPWR.n297 VPWR.t784 8.84404
R311 VPWR.n344 VPWR.t1270 8.84404
R312 VPWR.n357 VPWR.t1101 8.84404
R313 VPWR.n476 VPWR.t911 8.84404
R314 VPWR.n109 VPWR.t737 8.84404
R315 VPWR.n275 VPWR.t1293 8.84304
R316 VPWR.n344 VPWR.t1409 8.84304
R317 VPWR.n862 VPWR.t615 8.84304
R318 VPWR.n803 VPWR.t674 8.79392
R319 VPWR.n183 VPWR.t363 8.76154
R320 VPWR.n176 VPWR.t204 8.76154
R321 VPWR.t113 VPWR.t614 8.76154
R322 VPWR.n264 VPWR.t436 8.76154
R323 VPWR.n257 VPWR.t129 8.76154
R324 VPWR.n305 VPWR.t572 8.76154
R325 VPWR.n310 VPWR.t578 8.76154
R326 VPWR.n219 VPWR.t1358 8.76154
R327 VPWR.n203 VPWR.t1227 8.76154
R328 VPWR.n201 VPWR.t1229 8.76154
R329 VPWR.n199 VPWR.t1231 8.76154
R330 VPWR.n197 VPWR.t699 8.76154
R331 VPWR.n229 VPWR.t700 8.76154
R332 VPWR.n825 VPWR.t1202 8.76154
R333 VPWR.n797 VPWR.t1063 8.76154
R334 VPWR.n791 VPWR.t1335 8.76154
R335 VPWR.n789 VPWR.t1333 8.76154
R336 VPWR.n787 VPWR.t1331 8.76154
R337 VPWR.n786 VPWR.t1176 8.76154
R338 VPWR.n782 VPWR.t1174 8.76154
R339 VPWR.n776 VPWR.t111 8.76154
R340 VPWR.n0 VPWR.t645 8.76154
R341 VPWR.n875 VPWR.t1289 8.76154
R342 VPWR.n877 VPWR.t1000 8.76154
R343 VPWR.n879 VPWR.t998 8.76154
R344 VPWR.n881 VPWR.t996 8.76154
R345 VPWR.n883 VPWR.t994 8.76154
R346 VPWR.n892 VPWR.t693 8.76154
R347 VPWR.n701 VPWR.t1241 8.76154
R348 VPWR.n704 VPWR.t1239 8.76154
R349 VPWR.n706 VPWR.t1237 8.76154
R350 VPWR.n710 VPWR.t211 8.76154
R351 VPWR.n712 VPWR.t209 8.76154
R352 VPWR.n732 VPWR.t575 8.76154
R353 VPWR.n740 VPWR.t207 8.76154
R354 VPWR.n742 VPWR.t206 8.76154
R355 VPWR.n744 VPWR.t491 8.76154
R356 VPWR.n746 VPWR.t489 8.76154
R357 VPWR.n749 VPWR.t487 8.76154
R358 VPWR.n438 VPWR.t1214 8.76154
R359 VPWR.n347 VPWR.t1345 8.76154
R360 VPWR.n408 VPWR.t1323 8.76154
R361 VPWR.n368 VPWR.t1039 8.76154
R362 VPWR.n406 VPWR.t1037 8.76154
R363 VPWR.n404 VPWR.t1035 8.76154
R364 VPWR.n371 VPWR.t1033 8.76154
R365 VPWR.n380 VPWR.t1066 8.76154
R366 VPWR.n389 VPWR.t937 8.76154
R367 VPWR.n385 VPWR.t535 8.76154
R368 VPWR.n415 VPWR.t494 8.76154
R369 VPWR.n563 VPWR.t1060 8.76154
R370 VPWR.n552 VPWR.t877 8.76154
R371 VPWR.n549 VPWR.t875 8.76154
R372 VPWR.n546 VPWR.t873 8.76154
R373 VPWR.n543 VPWR.t872 8.76154
R374 VPWR.n541 VPWR.t967 8.76154
R375 VPWR.n571 VPWR.t946 8.76154
R376 VPWR.n573 VPWR.t944 8.76154
R377 VPWR.n578 VPWR.t942 8.76154
R378 VPWR.n580 VPWR.t941 8.76154
R379 VPWR.n582 VPWR.t950 8.76154
R380 VPWR.n584 VPWR.t140 8.76154
R381 VPWR.n587 VPWR.t938 8.76154
R382 VPWR.n478 VPWR.t303 8.76154
R383 VPWR.n519 VPWR.t969 8.76154
R384 VPWR.n518 VPWR.t960 8.76154
R385 VPWR.n516 VPWR.t958 8.76154
R386 VPWR.n513 VPWR.t956 8.76154
R387 VPWR.n511 VPWR.t954 8.76154
R388 VPWR.n495 VPWR.t849 8.76154
R389 VPWR.n492 VPWR.t819 8.76154
R390 VPWR.n638 VPWR.t734 8.76154
R391 VPWR.t167 VPWR.t1254 8.76154
R392 VPWR.n656 VPWR.t1111 8.76154
R393 VPWR.n634 VPWR.t866 8.76154
R394 VPWR.n662 VPWR.t791 8.76154
R395 VPWR.n669 VPWR.t258 8.76154
R396 VPWR.n610 VPWR.t1418 8.76154
R397 VPWR.n612 VPWR.t1416 8.76154
R398 VPWR.n614 VPWR.t1414 8.76154
R399 VPWR.n616 VPWR.t1349 8.76154
R400 VPWR.n617 VPWR.t1347 8.76154
R401 VPWR.n676 VPWR.t156 8.76154
R402 VPWR.n111 VPWR.t1024 8.76154
R403 VPWR.n170 VPWR.t385 8.76054
R404 VPWR.n184 VPWR.t197 8.76054
R405 VPWR.n124 VPWR.t190 8.76054
R406 VPWR.n261 VPWR.t710 8.76054
R407 VPWR.n21 VPWR.t277 8.76054
R408 VPWR.n22 VPWR.t278 8.76054
R409 VPWR.n20 VPWR.t280 8.76054
R410 VPWR.n16 VPWR.t282 8.76054
R411 VPWR.n268 VPWR.t1410 8.76054
R412 VPWR.n272 VPWR.t1057 8.76054
R413 VPWR.n301 VPWR.t570 8.76054
R414 VPWR.n308 VPWR.t563 8.76054
R415 VPWR.n295 VPWR.t602 8.76054
R416 VPWR.n280 VPWR.t881 8.76054
R417 VPWR.n278 VPWR.t419 8.76054
R418 VPWR.n222 VPWR.t1081 8.76054
R419 VPWR.n203 VPWR.t625 8.76054
R420 VPWR.n201 VPWR.t627 8.76054
R421 VPWR.n199 VPWR.t629 8.76054
R422 VPWR.n197 VPWR.t631 8.76054
R423 VPWR.n229 VPWR.t1350 8.76054
R424 VPWR.n234 VPWR.t1277 8.76054
R425 VPWR.n241 VPWR.t1080 8.76054
R426 VPWR.n819 VPWR.t225 8.76054
R427 VPWR.n812 VPWR.t482 8.76054
R428 VPWR.n345 VPWR.t1271 8.76054
R429 VPWR.n345 VPWR.t1199 8.76054
R430 VPWR.n0 VPWR.t1183 8.76054
R431 VPWR.n760 VPWR.t657 8.76054
R432 VPWR.n767 VPWR.t691 8.76054
R433 VPWR.n774 VPWR.t585 8.76054
R434 VPWR.n781 VPWR.t1030 8.76054
R435 VPWR.n898 VPWR.t601 8.76054
R436 VPWR.n894 VPWR.t814 8.76054
R437 VPWR.n859 VPWR.t496 8.76054
R438 VPWR.n857 VPWR.t361 8.76054
R439 VPWR.n853 VPWR.t1013 8.76054
R440 VPWR.n851 VPWR.t1015 8.76054
R441 VPWR.n849 VPWR.t1017 8.76054
R442 VPWR.n847 VPWR.t711 8.76054
R443 VPWR.n845 VPWR.t712 8.76054
R444 VPWR.n748 VPWR.t633 8.76054
R445 VPWR.n738 VPWR.t333 8.76054
R446 VPWR.n718 VPWR.t571 8.76054
R447 VPWR.n708 VPWR.t231 8.76054
R448 VPWR.n430 VPWR.t109 8.76054
R449 VPWR.n436 VPWR.t889 8.76054
R450 VPWR.n440 VPWR.t891 8.76054
R451 VPWR.n442 VPWR.t1313 8.76054
R452 VPWR.n444 VPWR.t1315 8.76054
R453 VPWR.n446 VPWR.t1317 8.76054
R454 VPWR.n360 VPWR.t220 8.76054
R455 VPWR.n358 VPWR.t292 8.76054
R456 VPWR.n382 VPWR.t918 8.76054
R457 VPWR.n395 VPWR.t896 8.76054
R458 VPWR.n409 VPWR.t939 8.76054
R459 VPWR.n411 VPWR.t841 8.76054
R460 VPWR.n415 VPWR.t579 8.76054
R461 VPWR.n586 VPWR.t428 8.76054
R462 VPWR.n534 VPWR.t800 8.76054
R463 VPWR.n548 VPWR.t903 8.76054
R464 VPWR.n551 VPWR.t905 8.76054
R465 VPWR.n554 VPWR.t907 8.76054
R466 VPWR.n557 VPWR.t886 8.76054
R467 VPWR.n561 VPWR.t887 8.76054
R468 VPWR.n685 VPWR.t818 8.76054
R469 VPWR.n466 VPWR.t892 8.76054
R470 VPWR.n475 VPWR.t405 8.76054
R471 VPWR.n490 VPWR.t122 8.76054
R472 VPWR.n145 VPWR.t692 8.76054
R473 VPWR.n155 VPWR.t95 8.76054
R474 VPWR.n873 VPWR.t544 8.73192
R475 VPWR.n488 VPWR.t893 8.73192
R476 VPWR.n238 VPWR.t485 8.73093
R477 VPWR.n182 VPWR.t153 8.57856
R478 VPWR.n57 VPWR.t153 1.99425
R479 VPWR.n128 VPWR.n69 0.0296542
R480 VPWR.n803 VPWR.n77 0.0317231
R481 VPWR.n35 VPWR.n34 0.00881127
R482 VPWR.t0 VPWR.n35 0.604901
R483 VPWR.n35 VPWR.n96 0.00911485
R484 VPWR.n96 VPWR.n97 0.00169968
R485 VPWR.n98 VPWR.n97 0.00166651
R486 VPWR.n630 VPWR.n92 0.127069
R487 VPWR.n48 VPWR.n47 0.0332013
R488 VPWR.n51 VPWR.t15 2.72093
R489 VPWR.t256 VPWR.n51 0.235242
R490 VPWR.t105 VPWR.n108 8.47111
R491 VPWR.t153 VPWR.n157 8.47111
R492 VPWR.t153 VPWR.n173 8.47111
R493 VPWR.t153 VPWR.n167 8.47111
R494 VPWR.t105 VPWR.n120 8.47111
R495 VPWR.t105 VPWR.n105 8.47111
R496 VPWR.t91 VPWR.n250 8.47111
R497 VPWR.t91 VPWR.n240 8.47111
R498 VPWR.t91 VPWR.n235 8.47111
R499 VPWR.t91 VPWR.n196 8.47111
R500 VPWR.t91 VPWR.n198 8.47111
R501 VPWR.t91 VPWR.n200 8.47111
R502 VPWR.t91 VPWR.n202 8.47111
R503 VPWR.t91 VPWR.n204 8.47111
R504 VPWR.t91 VPWR.n206 8.47111
R505 VPWR.t91 VPWR.n286 8.47111
R506 VPWR.t91 VPWR.n291 8.47111
R507 VPWR.t91 VPWR.n300 8.47111
R508 VPWR.t91 VPWR.n302 8.47111
R509 VPWR.t91 VPWR.n279 8.47111
R510 VPWR.t91 VPWR.n283 8.47111
R511 VPWR.t91 VPWR.n269 8.47111
R512 VPWR.t91 VPWR.n267 8.47111
R513 VPWR.n17 VPWR.n16 0.0570732
R514 VPWR.n16 VPWR.n20 0.116495
R515 VPWR.n20 VPWR.n22 0.119605
R516 VPWR.t91 VPWR.n263 8.47111
R517 VPWR.t43 VPWR.n848 8.47111
R518 VPWR.t43 VPWR.n850 8.47111
R519 VPWR.t43 VPWR.n852 8.47111
R520 VPWR.t43 VPWR.n854 8.47111
R521 VPWR.t43 VPWR.n856 8.47111
R522 VPWR.t43 VPWR.n863 8.47111
R523 VPWR.t43 VPWR.n869 8.47111
R524 VPWR.t43 VPWR.n872 8.47111
R525 VPWR.t43 VPWR.n876 8.47111
R526 VPWR.t43 VPWR.n878 8.47111
R527 VPWR.t43 VPWR.n880 8.47111
R528 VPWR.t43 VPWR.n882 8.47111
R529 VPWR.t43 VPWR.n884 8.47111
R530 VPWR.t43 VPWR.n889 8.47111
R531 VPWR.t43 VPWR.n899 8.47111
R532 VPWR.t43 VPWR.n816 8.47111
R533 VPWR.t43 VPWR.n824 8.47111
R534 VPWR.t43 VPWR.n325 8.47111
R535 VPWR.t43 VPWR.n796 8.47111
R536 VPWR.t43 VPWR.n794 8.47111
R537 VPWR.t43 VPWR.n792 8.47111
R538 VPWR.t43 VPWR.n790 8.47111
R539 VPWR.t43 VPWR.n788 8.47111
R540 VPWR.t43 VPWR.n332 8.47111
R541 VPWR.t43 VPWR.n761 8.47111
R542 VPWR.n1 VPWR.n0 0.173292
R543 VPWR.t7 VPWR.n429 8.47111
R544 VPWR.t7 VPWR.n367 8.47111
R545 VPWR.t7 VPWR.n54 3.48229
R546 VPWR.t7 VPWR.n370 8.47111
R547 VPWR.t7 VPWR.n372 8.47111
R548 VPWR.t7 VPWR.n374 8.47111
R549 VPWR.t7 VPWR.n400 8.47111
R550 VPWR.t7 VPWR.n396 8.47111
R551 VPWR.n80 VPWR.n395 0.30351
R552 VPWR.t7 VPWR.n381 8.47111
R553 VPWR.t7 VPWR.n393 8.47111
R554 VPWR.t7 VPWR.n384 8.47111
R555 VPWR.t7 VPWR.n723 8.47111
R556 VPWR.t7 VPWR.n728 8.47111
R557 VPWR.t7 VPWR.n733 8.47111
R558 VPWR.t7 VPWR.n737 8.47111
R559 VPWR.t7 VPWR.n741 8.47111
R560 VPWR.t7 VPWR.n743 8.47111
R561 VPWR.t7 VPWR.n745 8.47111
R562 VPWR.t7 VPWR.n747 8.47111
R563 VPWR.t7 VPWR.n750 8.47111
R564 VPWR.t7 VPWR.n698 8.47111
R565 VPWR.t7 VPWR.n700 8.47111
R566 VPWR.t7 VPWR.n703 8.47111
R567 VPWR.t7 VPWR.n705 8.47111
R568 VPWR.t7 VPWR.n711 8.47111
R569 VPWR.t7 VPWR.n717 8.47111
R570 VPWR.t7 VPWR.n719 8.47111
R571 VPWR.t7 VPWR.n721 8.47111
R572 VPWR.t7 VPWR.n445 8.47111
R573 VPWR.t7 VPWR.n443 8.47111
R574 VPWR.t7 VPWR.n441 8.47111
R575 VPWR.t7 VPWR.n362 8.47111
R576 VPWR.t7 VPWR.n351 8.47111
R577 VPWR.t2 VPWR.n521 8.47111
R578 VPWR.t2 VPWR.n517 8.47111
R579 VPWR.t2 VPWR.n514 8.47111
R580 VPWR.t2 VPWR.n512 8.47111
R581 VPWR.t2 VPWR.n506 8.47111
R582 VPWR.t2 VPWR.n494 8.47111
R583 VPWR.t2 VPWR.n491 8.47111
R584 VPWR.t2 VPWR.n459 8.47111
R585 VPWR.t2 VPWR.n570 8.47111
R586 VPWR.t2 VPWR.n572 8.47111
R587 VPWR.t2 VPWR.n579 8.47111
R588 VPWR.t2 VPWR.n581 8.47111
R589 VPWR.t2 VPWR.n585 8.47111
R590 VPWR.t2 VPWR.n588 8.47111
R591 VPWR.t2 VPWR.n5 1.48377
R592 VPWR.t2 VPWR.n556 8.47111
R593 VPWR.t2 VPWR.n553 8.47111
R594 VPWR.t2 VPWR.n550 8.47111
R595 VPWR.t2 VPWR.n547 8.47111
R596 VPWR.t2 VPWR.n544 8.47111
R597 VPWR.t2 VPWR.n542 8.47111
R598 VPWR.t2 VPWR.n84 2.09123
R599 VPWR.t2 VPWR.n690 8.47111
R600 VPWR.t2 VPWR.n688 8.47111
R601 VPWR.t2 VPWR.n465 8.47111
R602 VPWR.n64 VPWR.n473 0.229165
R603 VPWR.t2 VPWR.n469 8.47111
R604 VPWR.n91 VPWR.n34 4.177
R605 VPWR.n674 VPWR.n37 0.302996
R606 VPWR.n677 VPWR.n96 8.47111
R607 VPWR.n97 VPWR.n678 8.47111
R608 VPWR.n672 VPWR.n98 8.47111
R609 VPWR.t1 VPWR.n618 8.47111
R610 VPWR.t1 VPWR.n615 8.47111
R611 VPWR.t1 VPWR.n613 8.47111
R612 VPWR.t1 VPWR.n611 8.47111
R613 VPWR.t1 VPWR.n609 8.47111
R614 VPWR.t1 VPWR.n607 8.47111
R615 VPWR.t1 VPWR.n48 4.22738
R616 VPWR.t1 VPWR.n599 8.47111
R617 VPWR.n26 VPWR.t1451 7.62628
R618 VPWR.n214 VPWR.t1453 7.62628
R619 VPWR.n10 VPWR.t1452 7.62628
R620 VPWR.n323 VPWR.t1457 7.62628
R621 VPWR.n807 VPWR.t1460 7.62628
R622 VPWR.n0 VPWR.t1458 7.62628
R623 VPWR.n31 VPWR.t1463 7.62628
R624 VPWR.n2 VPWR.t1464 7.62628
R625 VPWR.n5 VPWR.t1470 7.62628
R626 VPWR.n46 VPWR.t1476 7.62628
R627 VPWR.n25 VPWR.t1454 7.62594
R628 VPWR.n10 VPWR.t1455 7.62594
R629 VPWR.n58 VPWR.t1461 7.62594
R630 VPWR.n0 VPWR.t1462 7.62594
R631 VPWR.n30 VPWR.t1465 7.62594
R632 VPWR.n354 VPWR.t1468 7.62594
R633 VPWR.n2 VPWR.t1467 7.62594
R634 VPWR.n5 VPWR.t1473 7.62594
R635 VPWR.n61 VPWR.t1474 7.62594
R636 VPWR.n692 VPWR.t222 6.15821
R637 VPWR.n213 VPWR.t22 6.07803
R638 VPWR.n806 VPWR.t46 6.07803
R639 VPWR.n356 VPWR.t85 6.07759
R640 VPWR.n447 VPWR.t1319 6.07559
R641 VPWR.n355 VPWR.t637 5.99801
R642 VPWR.n215 VPWR.t1087 5.99757
R643 VPWR.n168 VPWR.t317 5.98925
R644 VPWR.n121 VPWR.t198 5.98925
R645 VPWR.n126 VPWR.t464 5.98925
R646 VPWR.n242 VPWR.t1263 5.98925
R647 VPWR.n284 VPWR.t125 5.98925
R648 VPWR.n255 VPWR.t92 5.98925
R649 VPWR.n313 VPWR.t505 5.98925
R650 VPWR.n225 VPWR.t365 5.98925
R651 VPWR.n243 VPWR.t1302 5.98925
R652 VPWR.n843 VPWR.t224 5.98925
R653 VPWR.n827 VPWR.t664 5.98925
R654 VPWR.n763 VPWR.t649 5.98925
R655 VPWR.n762 VPWR.t272 5.98925
R656 VPWR.n424 VPWR.t483 5.98925
R657 VPWR.n720 VPWR.t662 5.98925
R658 VPWR.n434 VPWR.t276 5.98925
R659 VPWR.n394 VPWR.t1170 5.98925
R660 VPWR.n529 VPWR.t926 5.98925
R661 VPWR.n537 VPWR.t262 5.98925
R662 VPWR.n564 VPWR.t263 5.98925
R663 VPWR.n689 VPWR.t635 5.98925
R664 VPWR.n508 VPWR.t853 5.98925
R665 VPWR.n601 VPWR.t107 5.98925
R666 VPWR.n650 VPWR.t97 5.98925
R667 VPWR.n639 VPWR.t286 5.98925
R668 VPWR.n668 VPWR.t325 5.98925
R669 VPWR.n595 VPWR.t642 5.98925
R670 VPWR.n623 VPWR.t319 5.98925
R671 VPWR.n158 VPWR.t542 5.98882
R672 VPWR.n131 VPWR.t371 5.98882
R673 VPWR.n118 VPWR.t440 5.98882
R674 VPWR.n259 VPWR.t230 5.98882
R675 VPWR.n313 VPWR.t119 5.98882
R676 VPWR.n282 VPWR.t815 5.98882
R677 VPWR.n228 VPWR.t990 5.98882
R678 VPWR.n243 VPWR.t603 5.98882
R679 VPWR.n823 VPWR.t536 5.98882
R680 VPWR.n339 VPWR.t121 5.98882
R681 VPWR.n784 VPWR.t1048 5.98882
R682 VPWR.n886 VPWR.t561 5.98882
R683 VPWR.n78 VPWR.t1028 5.98882
R684 VPWR.n18 VPWR.t264 6.03507
R685 VPWR.n405 VPWR.t392 5.98882
R686 VPWR.n417 VPWR.t1396 5.98882
R687 VPWR.n565 VPWR.t413 5.98882
R688 VPWR.n564 VPWR.t766 5.98882
R689 VPWR.n683 VPWR.t389 5.98882
R690 VPWR.n493 VPWR.t349 5.98882
R691 VPWR.n515 VPWR.t347 5.98882
R692 VPWR.n522 VPWR.t373 5.98882
R693 VPWR.n113 VPWR.t379 5.98882
R694 VPWR.n274 VPWR.t732 5.97212
R695 VPWR.n205 VPWR.t1226 5.97212
R696 VPWR.n795 VPWR.t1062 5.97212
R697 VPWR.n793 VPWR.t1337 5.97212
R698 VPWR.n885 VPWR.t993 5.97212
R699 VPWR.n888 VPWR.t922 5.97212
R700 VPWR.n904 VPWR.t829 5.97212
R701 VPWR.n699 VPWR.t1243 5.97212
R702 VPWR.n752 VPWR.t486 5.97212
R703 VPWR.n373 VPWR.t1032 5.97212
R704 VPWR.n555 VPWR.t879 5.97212
R705 VPWR.n50 VPWR.t948 5.97212
R706 VPWR.n474 VPWR.t512 5.97212
R707 VPWR.n510 VPWR.t953 5.97212
R708 VPWR.n648 VPWR.t867 5.97212
R709 VPWR.n608 VPWR.t1420 5.97212
R710 VPWR.n266 VPWR.t284 5.97169
R711 VPWR.n205 VPWR.t624 5.97169
R712 VPWR.n233 VPWR.t1276 5.97169
R713 VPWR.n759 VPWR.t656 5.97169
R714 VPWR.n855 VPWR.t1012 5.97169
R715 VPWR.n751 VPWR.t632 5.97169
R716 VPWR.n397 VPWR.t897 5.97169
R717 VPWR.n589 VPWR.t427 5.97169
R718 VPWR.n545 VPWR.t902 5.97169
R719 VPWR.n103 VPWR.t187 5.97001
R720 VPWR.n320 VPWR.t26 5.97001
R721 VPWR.n216 VPWR.t25 5.97001
R722 VPWR.n10 VPWR.t11 5.97001
R723 VPWR.n10 VPWR.t14 5.97001
R724 VPWR.n249 VPWR.t964 5.97001
R725 VPWR.n59 VPWR.t58 5.97001
R726 VPWR.n800 VPWR.t57 5.97001
R727 VPWR.n809 VPWR.t49 5.97001
R728 VPWR.n0 VPWR.t64 5.97001
R729 VPWR.n0 VPWR.t67 5.97001
R730 VPWR.n754 VPWR.t52 5.97001
R731 VPWR.n2 VPWR.t246 5.97001
R732 VPWR.n2 VPWR.t42 5.97001
R733 VPWR.n428 VPWR.t73 5.97001
R734 VPWR.n5 VPWR.t1379 5.97001
R735 VPWR.n5 VPWR.t1378 5.97001
R736 VPWR.n592 VPWR.t29 5.97001
R737 VPWR.n600 VPWR.t31 5.97001
R738 VPWR.n103 VPWR.t19 5.96957
R739 VPWR.n320 VPWR.t63 5.96957
R740 VPWR.n10 VPWR.t68 5.96957
R741 VPWR.n10 VPWR.t71 5.96957
R742 VPWR.n249 VPWR.t60 5.96957
R743 VPWR.n837 VPWR.t55 5.96957
R744 VPWR.n0 VPWR.t247 5.96957
R745 VPWR.n0 VPWR.t45 5.96957
R746 VPWR.n322 VPWR.t75 5.96957
R747 VPWR.n754 VPWR.t1384 5.96957
R748 VPWR.n352 VPWR.t88 5.96957
R749 VPWR.n2 VPWR.t240 5.96957
R750 VPWR.n2 VPWR.t243 5.96957
R751 VPWR.n428 VPWR.t1383 5.96957
R752 VPWR.n5 VPWR.t36 5.96957
R753 VPWR.n470 VPWR.t37 5.96957
R754 VPWR.n473 VPWR.t40 5.96957
R755 VPWR.n5 VPWR.t35 5.96957
R756 VPWR.n67 VPWR.t153 2.07686
R757 VPWR.n68 VPWR.t105 2.87172
R758 VPWR.t157 VPWR.n52 0.841509
R759 VPWR.n70 VPWR.t105 2.0911
R760 VPWR.n71 VPWR.t91 0.487459
R761 VPWR.n73 VPWR.t91 2.42694
R762 VPWR.n885 VPWR.n76 0.0805152
R763 VPWR.n53 VPWR.t43 3.48259
R764 VPWR.n54 VPWR.n404 0.0819426
R765 VPWR.t309 VPWR.n86 0.436757
R766 VPWR.n88 VPWR.t2 1.43814
R767 VPWR.n85 VPWR.t2 1.43829
R768 VPWR.n90 VPWR.t2 2.4269
R769 VPWR.t1 VPWR.n93 0.496969
R770 VPWR.n94 VPWR.t1 0.498063
R771 VPWR.t469 VPWR.n99 0.50266
R772 VPWR.n835 VPWR.t62 5.96091
R773 VPWR.n811 VPWR.t50 5.96091
R774 VPWR.n5 VPWR.t1381 5.96091
R775 VPWR.n471 VPWR.t83 5.96091
R776 VPWR.n486 VPWR.t238 5.96091
R777 VPWR.n598 VPWR.t33 5.96091
R778 VPWR.n104 VPWR.t20 5.96047
R779 VPWR.n2 VPWR.t244 5.96047
R780 VPWR.n870 VPWR.t513 5.94251
R781 VPWR.n461 VPWR.t858 5.94251
R782 VPWR.n239 VPWR.t992 5.94207
R783 VPWR.n25 VPWR.t59 5.65005
R784 VPWR.n26 VPWR.t27 5.65005
R785 VPWR.n214 VPWR.t23 5.65005
R786 VPWR.n10 VPWR.t69 5.65005
R787 VPWR.n10 VPWR.t12 5.65005
R788 VPWR.n58 VPWR.t54 5.65005
R789 VPWR.n323 VPWR.t56 5.65005
R790 VPWR.n807 VPWR.t47 5.65005
R791 VPWR.n0 VPWR.t44 5.65005
R792 VPWR.n0 VPWR.t65 5.65005
R793 VPWR.n30 VPWR.t1382 5.65005
R794 VPWR.n31 VPWR.t53 5.65005
R795 VPWR.n354 VPWR.t86 5.65005
R796 VPWR.n2 VPWR.t241 5.65005
R797 VPWR.n2 VPWR.t41 5.65005
R798 VPWR.n5 VPWR.t34 5.65005
R799 VPWR.n5 VPWR.t1377 5.65005
R800 VPWR.n61 VPWR.t38 5.65005
R801 VPWR.n46 VPWR.t30 5.65005
R802 VPWR.t2 VPWR.n462 5.6473
R803 VPWR.n127 VPWR.t21 5.64493
R804 VPWR.n905 VPWR.t61 5.64493
R805 VPWR.n802 VPWR.t51 5.64493
R806 VPWR.n386 VPWR.t245 5.64493
R807 VPWR.n591 VPWR.t1380 5.64493
R808 VPWR.n472 VPWR.t84 5.64493
R809 VPWR.n484 VPWR.t239 5.64493
R810 VPWR.n629 VPWR.t32 5.64493
R811 VPWR.t91 VPWR.n28 4.2275
R812 VPWR.t91 VPWR.n217 5.64096
R813 VPWR.t43 VPWR.n810 5.64096
R814 VPWR.t7 VPWR.n33 4.2275
R815 VPWR.t7 VPWR.n353 5.64096
R816 VPWR.t7 VPWR.n447 5.62311
R817 VPWR.t91 VPWR.n213 5.62104
R818 VPWR.t43 VPWR.n806 5.62104
R819 VPWR.t7 VPWR.n356 5.62104
R820 VPWR.t195 VPWR.n66 0.118193
R821 VPWR.n924 VPWR.t15 5.61485
R822 VPWR.t105 VPWR.n106 5.61485
R823 VPWR.t105 VPWR.n110 5.61485
R824 VPWR.t153 VPWR.n175 5.61485
R825 VPWR.t153 VPWR.n171 5.61485
R826 VPWR.t105 VPWR.n116 5.61485
R827 VPWR.t105 VPWR.n119 5.61485
R828 VPWR.t105 VPWR.n122 5.61485
R829 VPWR.t91 VPWR.n194 5.61485
R830 VPWR.t91 VPWR.n195 5.61485
R831 VPWR.t91 VPWR.n230 5.61485
R832 VPWR.t91 VPWR.n56 2.42717
R833 VPWR.t91 VPWR.n288 5.61485
R834 VPWR.t91 VPWR.n306 5.61485
R835 VPWR.t91 VPWR.n277 5.61485
R836 VPWR.t91 VPWR.n273 5.61485
R837 VPWR.t91 VPWR.n72 0.78067
R838 VPWR.t91 VPWR.n10 1.23069
R839 VPWR.t43 VPWR.n842 5.61485
R840 VPWR.t43 VPWR.n858 5.61485
R841 VPWR.t43 VPWR.n860 5.61485
R842 VPWR.t43 VPWR.n866 5.61485
R843 VPWR.t43 VPWR.n76 2.85958
R844 VPWR.t43 VPWR.n887 5.61485
R845 VPWR.t43 VPWR.n897 5.61485
R846 VPWR.t43 VPWR.n901 5.61485
R847 VPWR.t43 VPWR.n818 5.61485
R848 VPWR.t43 VPWR.n822 5.61485
R849 VPWR.t43 VPWR.n74 0.858165
R850 VPWR.t43 VPWR.n783 5.61485
R851 VPWR.t43 VPWR.n331 5.61485
R852 VPWR.t43 VPWR.n775 5.61485
R853 VPWR.t43 VPWR.n334 5.61485
R854 VPWR.t43 VPWR.n65 0.837472
R855 VPWR.t43 VPWR.n342 5.61485
R856 VPWR.t43 VPWR.n1 0.89793
R857 VPWR.t43 VPWR.n343 5.61485
R858 VPWR.t7 VPWR.n79 2.42717
R859 VPWR.t7 VPWR.n364 5.61485
R860 VPWR.t7 VPWR.n365 5.61485
R861 VPWR.t7 VPWR.n410 5.61485
R862 VPWR.t7 VPWR.n80 2.09517
R863 VPWR.t7 VPWR.n383 5.61485
R864 VPWR.t7 VPWR.n725 5.61485
R865 VPWR.t7 VPWR.n735 5.61485
R866 VPWR.t7 VPWR.n715 5.61485
R867 VPWR.t7 VPWR.n435 5.61485
R868 VPWR.t7 VPWR.n359 5.61485
R869 VPWR.t2 VPWR.n450 5.61485
R870 VPWR.t2 VPWR.n455 5.61485
R871 VPWR.t2 VPWR.n489 5.61485
R872 VPWR.t2 VPWR.n82 0.632645
R873 VPWR.t2 VPWR.n538 5.61485
R874 VPWR.t2 VPWR.n463 5.61485
R875 VPWR.t2 VPWR.n483 5.61485
R876 VPWR.t2 VPWR.n464 5.61485
R877 VPWR.t2 VPWR.n467 5.61485
R878 VPWR.t1 VPWR.n95 0.496969
R879 VPWR.n94 VPWR.n595 0.815978
R880 VPWR.t1 VPWR.n596 5.61485
R881 VPWR.t1 VPWR.n602 5.61485
R882 VPWR.t1 VPWR.n92 3.33203
R883 VPWR.t1 VPWR.n55 0.497715
R884 VPWR.t1 VPWR.n632 5.61485
R885 VPWR.t1 VPWR.n636 5.61485
R886 VPWR.t1 VPWR.n651 5.61485
R887 VPWR.n673 VPWR.n346 5.16578
R888 VPWR.n693 VPWR.t166 5.16578
R889 VPWR.n681 VPWR.n680 5.16578
R890 VPWR.t182 VPWR.n923 4.9845
R891 VPWR.n914 VPWR.t28 4.9845
R892 VPWR.n481 VPWR.n346 4.5005
R893 VPWR.n755 VPWR.n2 4.5005
R894 VPWR.n0 VPWR.n756 4.5005
R895 VPWR.n10 VPWR.n19 4.5005
R896 VPWR.n926 VPWR.t16 4.5005
R897 VPWR.n693 VPWR.t3 4.5005
R898 VPWR.t8 VPWR.n694 4.5005
R899 VPWR.n834 VPWR.n188 4.5005
R900 VPWR.n918 VPWR.t79 4.5005
R901 VPWR.n5 VPWR.n681 4.5005
R902 VPWR.n29 VPWR.n321 4.5005
R903 VPWR.n910 VPWR.n909 4.5005
R904 VPWR.n24 VPWR.n917 4.5005
R905 VPWR.n927 VPWR.n100 4.49573
R906 VPWR.n932 VPWR.n101 4.49046
R907 VPWR.n930 VPWR.n929 4.49046
R908 VPWR.n913 VPWR.n102 4.49046
R909 VPWR.n915 VPWR.n912 4.49046
R910 VPWR.n911 VPWR.n102 4.49046
R911 VPWR.n922 VPWR.n187 4.49046
R912 VPWR.n921 VPWR.n186 4.49046
R913 VPWR.n920 VPWR.n187 4.49046
R914 VPWR.n36 VPWR.n34 2.08411
R915 VPWR.t105 VPWR.t17 4.2275
R916 VPWR.t105 VPWR.n132 4.17719
R917 VPWR.t91 VPWR.n244 4.17719
R918 VPWR.t43 VPWR.n801 4.17719
R919 VPWR.t43 VPWR.n780 4.17719
R920 VPWR.t43 VPWR.n768 4.17719
R921 VPWR.t43 VPWR.n764 4.17719
R922 VPWR.t7 VPWR.n379 4.17719
R923 VPWR.t7 VPWR.n349 4.17719
R924 VPWR.t2 VPWR.n501 4.17719
R925 VPWR.t2 VPWR.n452 4.17719
R926 VPWR.t2 VPWR.n456 4.17719
R927 VPWR.t1 VPWR.n594 4.17719
R928 VPWR.t1 VPWR.n633 4.17719
R929 VPWR.t1 VPWR.n660 4.17719
R930 VPWR.t1 VPWR.n647 4.17719
R931 VPWR.t1 VPWR.n645 4.17719
R932 VPWR.t1 VPWR.n640 4.17719
R933 VPWR.t153 VPWR.n185 4.17712
R934 VPWR.t43 VPWR.n907 4.17712
R935 VPWR.t43 VPWR.n893 4.17712
R936 VPWR.t7 VPWR.n18 0.734447
R937 VPWR.t153 VPWR.n179 4.177
R938 VPWR.t91 VPWR.n296 4.177
R939 VPWR.t91 VPWR.n312 4.177
R940 VPWR.t91 VPWR.n281 4.177
R941 VPWR.t91 VPWR.n260 4.177
R942 VPWR.t43 VPWR.n874 4.177
R943 VPWR.t7 VPWR.n739 4.177
R944 VPWR.t2 VPWR.n583 4.177
R945 VPWR.t2 VPWR.n533 4.177
R946 VPWR.t2 VPWR.n684 4.177
R947 VPWR.t43 VPWR.n846 3.48227
R948 VPWR.t43 VPWR.n814 3.3644
R949 VPWR.t2 VPWR.n692 3.31976
R950 VPWR.t105 VPWR.n153 3.30723
R951 VPWR.t105 VPWR.n107 3.30723
R952 VPWR.t105 VPWR.n149 3.30723
R953 VPWR.t105 VPWR.n144 3.30723
R954 VPWR.t105 VPWR.n136 3.30723
R955 VPWR.t91 VPWR.n245 3.30723
R956 VPWR.n10 VPWR.n224 0.383934
R957 VPWR.t91 VPWR.n211 3.30723
R958 VPWR.t91 VPWR.n221 3.30723
R959 VPWR.t43 VPWR.n335 3.30723
R960 VPWR.t43 VPWR.n336 3.30723
R961 VPWR.n0 VPWR.n758 0.483594
R962 VPWR.t7 VPWR.n416 3.30723
R963 VPWR.t7 VPWR.n377 3.30723
R964 VPWR.t7 VPWR.n403 3.30723
R965 VPWR.t7 VPWR.n378 3.30723
R966 VPWR.t2 VPWR.n509 3.30723
R967 VPWR.t2 VPWR.n451 3.30723
R968 VPWR.t2 VPWR.n497 3.30723
R969 VPWR.t2 VPWR.n477 3.30723
R970 VPWR.t1 VPWR.n593 3.30723
R971 VPWR.t1 VPWR.n621 3.30723
R972 VPWR.t1 VPWR.n604 3.30723
R973 VPWR.t1 VPWR.n671 3.30723
R974 VPWR.t1 VPWR.n667 3.30723
R975 VPWR.t1 VPWR.n663 3.30723
R976 VPWR.t1 VPWR.n635 3.30723
R977 VPWR.t1 VPWR.n657 3.30723
R978 VPWR.t1 VPWR.n655 3.30723
R979 VPWR.t1 VPWR.n642 3.30723
R980 VPWR.t2 VPWR.n532 3.30715
R981 VPWR.t91 VPWR.n315 3.30706
R982 VPWR.t91 VPWR.n309 3.30706
R983 VPWR.n15 VPWR.n833 0.571389
R984 VPWR.t2 VPWR.n49 3.30706
R985 VPWR.t91 VPWR.n319 3.30688
R986 VPWR.t91 VPWR.n254 3.30688
R987 VPWR.t43 VPWR.n829 3.30688
R988 VPWR.t7 VPWR.n753 3.30688
R989 VPWR.n14 VPWR.n697 0.567911
R990 VPWR.t7 VPWR.n431 3.30688
R991 VPWR.t2 VPWR.n458 2.85955
R992 VPWR.n42 VPWR.n313 0.738798
R993 VPWR.t7 VPWR.n433 2.85935
R994 VPWR.t43 VPWR.n798 2.72142
R995 VPWR.n57 VPWR.t183 0.0904675
R996 VPWR.t91 VPWR.n256 2.42878
R997 VPWR.t7 VPWR.n423 2.42693
R998 VPWR.t2 VPWR.n528 2.42693
R999 VPWR.t43 VPWR.n338 2.42689
R1000 VPWR.t43 VPWR.n826 2.41665
R1001 VPWR.t1 VPWR.n631 2.29824
R1002 VPWR.n83 VPWR.t2 0.619734
R1003 VPWR.n929 VPWR.n102 2.17938
R1004 VPWR.n915 VPWR.n186 2.17938
R1005 VPWR.t91 VPWR.n192 2.09503
R1006 VPWR.t105 VPWR.n925 2.09111
R1007 VPWR.t105 VPWR.n140 2.07686
R1008 VPWR.t153 VPWR.n164 2.07673
R1009 VPWR.t2 VPWR.n686 2.07673
R1010 VPWR.t2 VPWR.t4 2.02174
R1011 VPWR.t43 VPWR.n340 1.97699
R1012 VPWR.t91 VPWR.n237 1.72397
R1013 VPWR.t1 VPWR.n637 1.65247
R1014 VPWR.t105 VPWR.n114 1.58866
R1015 VPWR.t1 VPWR.n649 1.51895
R1016 VPWR.t1 VPWR.n449 1.38228
R1017 VPWR.t2 VPWR.n86 1.01957
R1018 VPWR.t105 VPWR.n123 1.28807
R1019 VPWR.t105 VPWR.n117 1.28784
R1020 VPWR.t2 VPWR.n567 1.28704
R1021 VPWR.t153 VPWR.n156 1.20498
R1022 VPWR.t105 VPWR.n115 1.2045
R1023 VPWR.t153 VPWR.n162 1.20445
R1024 VPWR.t352 VPWR.t469 1.14748
R1025 VPWR.t105 VPWR.n99 0.851798
R1026 VPWR.n190 VPWR.t91 1.08231
R1027 VPWR.t214 VPWR.t191 1.07861
R1028 VPWR.t7 VPWR.n14 0.751177
R1029 VPWR.n52 VPWR.t108 1.12592
R1030 VPWR.t214 VPWR.t352 1.04102
R1031 VPWR.t191 VPWR.n113 1.04011
R1032 VPWR.n87 VPWR.t6 0.860361
R1033 VPWR.t173 VPWR.n83 0.12204
R1034 VPWR.t16 VPWR.t94 0.982645
R1035 VPWR.n603 VPWR.n44 0.971457
R1036 VPWR.n652 VPWR.n43 0.971457
R1037 VPWR.t7 VPWR.n11 0.352019
R1038 VPWR.n252 VPWR.n189 0.938181
R1039 VPWR.t43 VPWR.t76 0.850126
R1040 VPWR.n40 VPWR.n39 1.01123
R1041 VPWR.n314 VPWR.n42 1.0129
R1042 VPWR.t91 VPWR.n41 0.884415
R1043 VPWR.t7 VPWR.n13 0.884415
R1044 VPWR.t2 VPWR.n81 0.884415
R1045 VPWR.t221 VPWR.n11 0.673673
R1046 VPWR.n601 VPWR.n44 0.820551
R1047 VPWR.n650 VPWR.n43 0.820551
R1048 VPWR.n94 VPWR.n622 0.978658
R1049 VPWR.n666 VPWR.n55 0.978117
R1050 VPWR.t91 VPWR.n40 0.421453
R1051 VPWR.n95 VPWR.n624 0.971457
R1052 VPWR.n93 VPWR.n641 0.971457
R1053 VPWR.t91 VPWR.n42 0.42113
R1054 VPWR.t79 VPWR.n189 0.799373
R1055 VPWR.n41 VPWR.n226 0.770459
R1056 VPWR.n421 VPWR.n13 0.770459
R1057 VPWR.n526 VPWR.n81 0.770459
R1058 VPWR.t43 VPWR.n7 0.710674
R1059 VPWR.n41 VPWR.n227 0.763515
R1060 VPWR.n422 VPWR.n13 0.763515
R1061 VPWR.n527 VPWR.n81 0.763515
R1062 VPWR.n722 VPWR.n12 0.961931
R1063 VPWR.n82 VPWR.n564 0.0236783
R1064 VPWR.n190 VPWR.t79 0.735409
R1065 VPWR.t738 VPWR.t94 0.729113
R1066 VPWR.n190 VPWR.t113 0.708552
R1067 VPWR.t184 VPWR.n156 0.701965
R1068 VPWR.n11 VPWR.t8 0.299705
R1069 VPWR.n158 VPWR.n156 0.692556
R1070 VPWR.t200 VPWR.n115 0.684688
R1071 VPWR.n276 VPWR.n72 0.785812
R1072 VPWR.n756 VPWR.n19 0.66578
R1073 VPWR.n756 VPWR.n755 0.66578
R1074 VPWR.n755 VPWR.n346 0.66578
R1075 VPWR.n918 VPWR.n188 0.66578
R1076 VPWR.n694 VPWR.n188 0.66578
R1077 VPWR.n694 VPWR.n693 0.66578
R1078 VPWR.n917 VPWR.n910 0.66578
R1079 VPWR.n910 VPWR.n321 0.66578
R1080 VPWR.n681 VPWR.n321 0.66578
R1081 VPWR.t7 VPWR.n12 0.487927
R1082 VPWR.n71 VPWR.n285 0.963224
R1083 VPWR.n115 VPWR.t108 0.637404
R1084 VPWR.n162 VPWR.n161 0.633019
R1085 VPWR.n163 VPWR.n162 0.632757
R1086 VPWR.n74 VPWR.n828 0.740921
R1087 VPWR.n649 VPWR.n648 0.595336
R1088 VPWR.t167 VPWR.n649 0.5802
R1089 VPWR.n682 VPWR.n86 0.758761
R1090 VPWR.t91 VPWR.n189 0.568095
R1091 VPWR.n449 VPWR.t167 0.567389
R1092 VPWR.n87 VPWR.t309 1.09091
R1093 VPWR.t2 VPWR.n87 0.892987
R1094 VPWR.n567 VPWR.n566 0.529232
R1095 VPWR.n141 VPWR.n117 0.528758
R1096 VPWR.n133 VPWR.n123 0.528363
R1097 VPWR.t28 VPWR.n99 0.619174
R1098 VPWR.n238 VPWR.n237 0.52114
R1099 VPWR.t105 VPWR.t94 0.520557
R1100 VPWR.t28 VPWR.n114 0.509438
R1101 VPWR.t105 VPWR.n52 0.401161
R1102 VPWR.t105 VPWR.t191 0.504762
R1103 VPWR.t1 VPWR.n44 0.496968
R1104 VPWR.t1 VPWR.n43 0.496968
R1105 VPWR.n340 VPWR.n339 0.48673
R1106 VPWR.n927 VPWR.n926 0.4845
R1107 VPWR.n237 VPWR.n236 0.484463
R1108 VPWR.n131 VPWR.n123 0.448707
R1109 VPWR.n118 VPWR.n117 0.448207
R1110 VPWR.n567 VPWR.n565 0.44776
R1111 VPWR.t166 VPWR.n449 0.439604
R1112 VPWR.n669 VPWR.n631 0.43834
R1113 VPWR.n668 VPWR.n631 0.434336
R1114 VPWR.t3 VPWR.n83 0.706614
R1115 VPWR.n341 VPWR.n340 0.430756
R1116 VPWR VPWR.n932 0.42994
R1117 VPWR.t4 VPWR.t6 0.425778
R1118 VPWR.n164 VPWR.n163 0.413758
R1119 VPWR.n140 VPWR.n139 0.410567
R1120 VPWR.n638 VPWR.n637 0.408736
R1121 VPWR.n339 VPWR.n65 0.586877
R1122 VPWR.t105 VPWR.t352 0.38768
R1123 VPWR.t184 VPWR.n57 0.280534
R1124 VPWR.n798 VPWR.n797 0.366592
R1125 VPWR.n924 VPWR.t195 0.360811
R1126 VPWR.n926 VPWR 0.3525
R1127 VPWR.n686 VPWR.n685 0.348758
R1128 VPWR.n925 VPWR.n154 0.340259
R1129 VPWR.n153 VPWR.n150 0.336433
R1130 VPWR.n136 VPWR.n133 0.336433
R1131 VPWR.n144 VPWR.n141 0.336433
R1132 VPWR.n245 VPWR.n39 0.336433
R1133 VPWR.n337 VPWR.n336 0.336433
R1134 VPWR.n402 VPWR.n377 0.336433
R1135 VPWR.n624 VPWR.n593 0.336433
R1136 VPWR.n604 VPWR.n603 0.336433
R1137 VPWR.n655 VPWR.n652 0.336433
R1138 VPWR.n642 VPWR.n641 0.336433
R1139 VPWR.n566 VPWR.n532 0.336223
R1140 VPWR.n276 VPWR.n254 0.335808
R1141 VPWR.n14 VPWR.n448 0.0770774
R1142 VPWR.n7 VPWR.n6 0.0729678
R1143 VPWR.n829 VPWR.n828 0.335799
R1144 VPWR.t182 VPWR.t183 0.335609
R1145 VPWR.n315 VPWR.n314 0.335496
R1146 VPWR.n149 VPWR.n148 0.335195
R1147 VPWR.n401 VPWR.n378 0.335195
R1148 VPWR.n507 VPWR.n451 0.335195
R1149 VPWR.n622 VPWR.n621 0.335195
R1150 VPWR.n667 VPWR.n666 0.335195
R1151 VPWR.n149 VPWR.n147 0.332683
R1152 VPWR.n399 VPWR.n378 0.332683
R1153 VPWR.n505 VPWR.n451 0.332683
R1154 VPWR.n621 VPWR.n620 0.332683
R1155 VPWR.n667 VPWR.n665 0.332683
R1156 VPWR.n318 VPWR.n315 0.332368
R1157 VPWR.n841 VPWR.n7 0.571643
R1158 VPWR.n831 VPWR.n829 0.332058
R1159 VPWR.t227 VPWR.n15 0.0739556
R1160 VPWR.n569 VPWR.n532 0.331641
R1161 VPWR.n153 VPWR.n152 0.331445
R1162 VPWR.n136 VPWR.n135 0.331445
R1163 VPWR.n144 VPWR.n143 0.331445
R1164 VPWR.n248 VPWR.n245 0.331445
R1165 VPWR.n766 VPWR.n336 0.331445
R1166 VPWR.n377 VPWR.n376 0.331445
R1167 VPWR.n626 VPWR.n593 0.331445
R1168 VPWR.n606 VPWR.n604 0.331445
R1169 VPWR.n655 VPWR.n654 0.331445
R1170 VPWR.n644 VPWR.n642 0.331445
R1171 VPWR.n827 VPWR.n826 0.327696
R1172 VPWR.n509 VPWR.n508 0.320183
R1173 VPWR.n799 VPWR.n798 0.317361
R1174 VPWR.n416 VPWR.n414 0.303933
R1175 VPWR.n663 VPWR.n661 0.303933
R1176 VPWR.n659 VPWR.n635 0.303933
R1177 VPWR.n432 VPWR.n431 0.303299
R1178 VPWR.n770 VPWR.n335 0.302695
R1179 VPWR.n497 VPWR.n496 0.302695
R1180 VPWR.n671 VPWR.n670 0.302695
R1181 VPWR.n658 VPWR.n657 0.302695
R1182 VPWR.t257 VPWR.n924 0.301114
R1183 VPWR.n193 VPWR.n192 0.298193
R1184 VPWR.t3 VPWR.t4 0.297048
R1185 VPWR.n221 VPWR.n220 0.292695
R1186 VPWR.n477 VPWR.n474 0.292683
R1187 VPWR.n477 VPWR.n476 0.290195
R1188 VPWR.n161 VPWR.n67 0.414316
R1189 VPWR.n647 VPWR.n646 0.28028
R1190 VPWR.n256 VPWR.n255 0.279974
R1191 VPWR.n801 VPWR.n799 0.27778
R1192 VPWR.n241 VPWR.n192 0.27687
R1193 VPWR.n454 VPWR.n452 0.27403
R1194 VPWR.n503 VPWR.n501 0.273261
R1195 VPWR.n219 VPWR.n211 0.271433
R1196 VPWR.n767 VPWR.n335 0.271433
R1197 VPWR.n497 VPWR.n495 0.271433
R1198 VPWR.n671 VPWR.n669 0.271433
R1199 VPWR.n657 VPWR.n656 0.271433
R1200 VPWR.n310 VPWR.n309 0.271118
R1201 VPWR.n431 VPWR.n430 0.270808
R1202 VPWR.n309 VPWR.n308 0.270496
R1203 VPWR.n692 VPWR.n691 0.270417
R1204 VPWR.n222 VPWR.n211 0.270195
R1205 VPWR.n416 VPWR.n415 0.270195
R1206 VPWR.n663 VPWR.n662 0.270195
R1207 VPWR.n635 VPWR.n634 0.270195
R1208 VPWR.n380 VPWR.n379 0.26778
R1209 VPWR.n634 VPWR.n633 0.26778
R1210 VPWR.n640 VPWR.n638 0.26778
R1211 VPWR.n430 VPWR.n18 0.470177
R1212 VPWR.n739 VPWR.n738 0.267394
R1213 VPWR.n534 VPWR.n533 0.267394
R1214 VPWR.n685 VPWR.n684 0.267394
R1215 VPWR.n185 VPWR.n184 0.267261
R1216 VPWR.n768 VPWR.n767 0.267011
R1217 VPWR.n495 VPWR.n456 0.267011
R1218 VPWR.n319 VPWR.n318 0.264549
R1219 VPWR.n49 VPWR.n569 0.264246
R1220 VPWR.n753 VPWR.n752 0.263299
R1221 VPWR.n510 VPWR.n509 0.262695
R1222 VPWR.n244 VPWR.n242 0.26153
R1223 VPWR.n764 VPWR.n762 0.26153
R1224 VPWR.n595 VPWR.n594 0.26153
R1225 VPWR.n148 VPWR.n107 0.261433
R1226 VPWR.n403 VPWR.n401 0.261433
R1227 VPWR.n85 VPWR.n507 0.468865
R1228 VPWR.n313 VPWR.n312 0.261144
R1229 VPWR.n282 VPWR.n281 0.261144
R1230 VPWR.n260 VPWR.n259 0.261144
R1231 VPWR.n565 VPWR.n533 0.261144
R1232 VPWR.n684 VPWR.n683 0.261144
R1233 VPWR.n50 VPWR.n49 0.261118
R1234 VPWR.n907 VPWR.n904 0.261011
R1235 VPWR.n88 VPWR.n682 0.468431
R1236 VPWR.n254 VPWR.n253 0.260799
R1237 VPWR.n132 VPWR.n131 0.260761
R1238 VPWR.n244 VPWR.n243 0.260761
R1239 VPWR.n764 VPWR.n763 0.260761
R1240 VPWR.n394 VPWR.n379 0.260761
R1241 VPWR.n623 VPWR.n594 0.260761
R1242 VPWR.n640 VPWR.n639 0.260761
R1243 VPWR.n150 VPWR.n107 0.260195
R1244 VPWR.n403 VPWR.n402 0.260195
R1245 VPWR.n221 VPWR.n218 0.258933
R1246 VPWR.n114 VPWR.t157 0.254805
R1247 VPWR.n140 VPWR.n137 0.25301
R1248 VPWR.n584 VPWR.n583 0.251144
R1249 VPWR.n424 VPWR.n423 0.24999
R1250 VPWR.n529 VPWR.n528 0.24999
R1251 VPWR.n166 VPWR.n164 0.249875
R1252 VPWR.n320 VPWR.n319 0.249558
R1253 VPWR.n754 VPWR.n753 0.249558
R1254 VPWR.n257 VPWR.n256 0.249342
R1255 VPWR.n763 VPWR.n338 0.249335
R1256 VPWR.n423 VPWR.n422 0.24649
R1257 VPWR.n528 VPWR.n527 0.24649
R1258 VPWR.n780 VPWR.n778 0.24528
R1259 VPWR.n179 VPWR.n178 0.244894
R1260 VPWR.n780 VPWR.n779 0.244511
R1261 VPWR.n907 VPWR.n906 0.243773
R1262 VPWR.n874 VPWR.n873 0.242394
R1263 VPWR.n91 VPWR.n675 0.254894
R1264 VPWR.n678 VPWR.n677 0.241078
R1265 VPWR.n51 VPWR.t257 0.235599
R1266 VPWR.n8 VPWR.t577 0.0111109
R1267 VPWR.n815 VPWR.n814 0.235634
R1268 VPWR.n132 VPWR.n130 0.23528
R1269 VPWR.n457 VPWR.n456 0.23528
R1270 VPWR.n660 VPWR.n658 0.23528
R1271 VPWR.n180 VPWR.n179 0.234894
R1272 VPWR.n312 VPWR.n311 0.234894
R1273 VPWR.n661 VPWR.n633 0.234511
R1274 VPWR.n660 VPWR.n659 0.234511
R1275 VPWR.n925 VPWR.n155 0.233708
R1276 VPWR.n297 VPWR.n296 0.232394
R1277 VPWR.n357 VPWR.n349 0.232011
R1278 VPWR.n130 VPWR.n70 0.340888
R1279 VPWR.n84 VPWR.n534 0.308103
R1280 VPWR.n434 VPWR.n433 0.224782
R1281 VPWR.n493 VPWR.n458 0.224192
R1282 VPWR.n687 VPWR.n686 0.221125
R1283 VPWR.n901 VPWR.n900 0.220486
R1284 VPWR.n288 VPWR.n287 0.218325
R1285 VPWR.n769 VPWR.n334 0.218325
R1286 VPWR.n648 VPWR.n647 0.218261
R1287 VPWR.n236 VPWR.n195 0.217986
R1288 VPWR.n342 VPWR.n341 0.217986
R1289 VPWR.n725 VPWR.n724 0.217986
R1290 VPWR.n868 VPWR.n866 0.214575
R1291 VPWR.n727 VPWR.n725 0.214575
R1292 VPWR.n290 VPWR.n288 0.214236
R1293 VPWR.n866 VPWR.n865 0.214236
R1294 VPWR.n281 VPWR.n280 0.213644
R1295 VPWR.n185 VPWR.n183 0.212523
R1296 VPWR.n894 VPWR.n893 0.212523
R1297 VPWR.n296 VPWR.n295 0.212394
R1298 VPWR.n893 VPWR.n892 0.212261
R1299 VPWR.n774 VPWR.n331 0.208325
R1300 VPWR.n783 VPWR.n781 0.208325
R1301 VPWR.n415 VPWR.n364 0.208325
R1302 VPWR.n662 VPWR.n632 0.208325
R1303 VPWR.n898 VPWR.n897 0.207986
R1304 VPWR.n776 VPWR.n331 0.207986
R1305 VPWR.n656 VPWR.n636 0.207986
R1306 VPWR.n768 VPWR.n766 0.20653
R1307 VPWR.n645 VPWR.n644 0.20653
R1308 VPWR.n846 VPWR.n845 0.205245
R1309 VPWR.n501 VPWR.n500 0.20278
R1310 VPWR.n103 VPWR.t17 0.202255
R1311 VPWR.n843 VPWR.n842 0.202075
R1312 VPWR.n823 VPWR.n822 0.202075
R1313 VPWR.n435 VPWR.n434 0.202075
R1314 VPWR.n538 VPWR.n537 0.202075
R1315 VPWR.n498 VPWR.n452 0.202011
R1316 VPWR.n122 VPWR.n121 0.201736
R1317 VPWR.n119 VPWR.n118 0.201736
R1318 VPWR.n887 VPWR.n886 0.201736
R1319 VPWR.n602 VPWR.n601 0.201736
R1320 VPWR.n651 VPWR.n650 0.201736
R1321 VPWR.n651 VPWR.t166 0.200825
R1322 VPWR.n483 VPWR.n481 0.200825
R1323 VPWR.n350 VPWR.n349 0.20028
R1324 VPWR.n261 VPWR.n260 0.199894
R1325 VPWR.n875 VPWR.n874 0.199894
R1326 VPWR.n740 VPWR.n739 0.199894
R1327 VPWR.n583 VPWR.n582 0.199894
R1328 VPWR.n646 VPWR.n645 0.199511
R1329 VPWR.n826 VPWR.n825 0.199225
R1330 VPWR.n801 VPWR.n800 0.198261
R1331 VPWR.n859 VPWR.n858 0.197075
R1332 VPWR.n1 VPWR.n345 0.957728
R1333 VPWR.n482 VPWR.n463 0.195825
R1334 VPWR.n539 VPWR.n538 0.195486
R1335 VPWR.n306 VPWR.n305 0.193325
R1336 VPWR.n478 VPWR.n464 0.193325
R1337 VPWR.n278 VPWR.n277 0.192075
R1338 VPWR.n410 VPWR.n409 0.191736
R1339 VPWR.n234 VPWR.n195 0.190825
R1340 VPWR.n760 VPWR.n342 0.190825
R1341 VPWR.n277 VPWR.t113 0.190486
R1342 VPWR.n28 VPWR.n320 0.202255
R1343 VPWR.n217 VPWR.n216 0.190118
R1344 VPWR.n810 VPWR.n809 0.190118
R1345 VPWR.n33 VPWR.n754 0.202255
R1346 VPWR.n353 VPWR.n352 0.190118
R1347 VPWR.n344 VPWR.n343 0.188325
R1348 VPWR.n110 VPWR.n109 0.187986
R1349 VPWR.n902 VPWR.n901 0.185825
R1350 VPWR.n392 VPWR.n383 0.185825
R1351 VPWR.n736 VPWR.n735 0.185825
R1352 VPWR.n822 VPWR.n821 0.185486
R1353 VPWR.n735 VPWR.n734 0.185486
R1354 VPWR.n715 VPWR.n714 0.185486
R1355 VPWR.n489 VPWR.n488 0.183325
R1356 VPWR.n672 VPWR.n628 0.180789
R1357 VPWR.n45 VPWR.n627 0.370699
R1358 VPWR.n64 VPWR.n63 0.119663
R1359 VPWR.n172 VPWR.n171 0.175825
R1360 VPWR.n175 VPWR.n174 0.175825
R1361 VPWR.n897 VPWR.n896 0.175825
R1362 VPWR.n496 VPWR.n455 0.175825
R1363 VPWR.n670 VPWR.n92 0.25959
R1364 VPWR.n154 VPWR.n106 0.175486
R1365 VPWR.n194 VPWR.n193 0.175486
R1366 VPWR.n307 VPWR.n306 0.175486
R1367 VPWR.n818 VPWR.n817 0.175486
R1368 VPWR.n334 VPWR.n333 0.175486
R1369 VPWR.n414 VPWR.n365 0.175486
R1370 VPWR.n888 VPWR.n887 0.174575
R1371 VPWR.n5 VPWR.n3 0.258222
R1372 VPWR.n338 VPWR.n337 0.172165
R1373 VPWR.n48 VPWR.n600 0.202132
R1374 VPWR.n858 VPWR.n857 0.167986
R1375 VPWR.n128 VPWR.n127 0.16689
R1376 VPWR.n387 VPWR.n386 0.16689
R1377 VPWR.n803 VPWR.n802 0.166554
R1378 VPWR.n485 VPWR.n484 0.166554
R1379 VPWR.n630 VPWR.n629 0.166554
R1380 VPWR.n716 VPWR.n715 0.165825
R1381 VPWR.n116 VPWR.t200 0.165486
R1382 VPWR.n483 VPWR.n482 0.165486
R1383 VPWR.n145 VPWR.n110 0.164575
R1384 VPWR.n860 VPWR.n859 0.164575
R1385 VPWR.n273 VPWR.n272 0.164236
R1386 VPWR.n345 VPWR.n343 0.164236
R1387 VPWR.n360 VPWR.n359 0.164236
R1388 VPWR.n467 VPWR.n466 0.164236
R1389 VPWR.n239 VPWR.n194 0.163325
R1390 VPWR.n470 VPWR.n469 0.162039
R1391 VPWR.n229 VPWR.n196 0.160789
R1392 VPWR.n876 VPWR.n875 0.160789
R1393 VPWR.n408 VPWR.n367 0.160789
R1394 VPWR.n741 VPWR.n740 0.160789
R1395 VPWR.n712 VPWR.n711 0.160789
R1396 VPWR.n351 VPWR.n350 0.160789
R1397 VPWR.n582 VPWR.n581 0.160789
R1398 VPWR.n542 VPWR.n541 0.160789
R1399 VPWR.n618 VPWR.n617 0.160789
R1400 VPWR.n481 VPWR.n464 0.160486
R1401 VPWR.n56 VPWR.n225 0.249642
R1402 VPWR.n243 VPWR.n40 0.739807
R1403 VPWR.n274 VPWR.n273 0.159575
R1404 VPWR.n255 VPWR.n72 0.650747
R1405 VPWR.n74 VPWR.n827 0.612243
R1406 VPWR.n80 VPWR.n394 0.282821
R1407 VPWR.n417 VPWR.n79 0.249642
R1408 VPWR.n522 VPWR.n90 0.249335
R1409 VPWR.n683 VPWR.n88 0.40437
R1410 VPWR.n95 VPWR.n623 0.820553
R1411 VPWR.n639 VPWR.n93 0.820553
R1412 VPWR.n886 VPWR.n76 0.224011
R1413 VPWR.n286 VPWR.n285 0.158289
R1414 VPWR.n723 VPWR.n722 0.158289
R1415 VPWR.n205 VPWR.n204 0.155789
R1416 VPWR.n885 VPWR.n884 0.155789
R1417 VPWR.n855 VPWR.n854 0.155789
R1418 VPWR.n793 VPWR.n792 0.155789
R1419 VPWR.n373 VPWR.n372 0.155789
R1420 VPWR.n700 VPWR.n699 0.155789
R1421 VPWR.n512 VPWR.n510 0.155789
R1422 VPWR.n609 VPWR.n608 0.155789
R1423 VPWR.n411 VPWR.n365 0.154575
R1424 VPWR.n293 VPWR.n291 0.154539
R1425 VPWR.n773 VPWR.n332 0.154539
R1426 VPWR.n730 VPWR.n728 0.154539
R1427 VPWR.n819 VPWR.n818 0.153325
R1428 VPWR.n359 VPWR.n358 0.153325
R1429 VPWR.n475 VPWR.n467 0.153325
R1430 VPWR.n171 VPWR.n170 0.152986
R1431 VPWR.n176 VPWR.n175 0.152986
R1432 VPWR.n775 VPWR.n774 0.152986
R1433 VPWR.n383 VPWR.n382 0.152986
R1434 VPWR.n490 VPWR.n489 0.152986
R1435 VPWR.n160 VPWR.n159 0.152808
R1436 VPWR.n166 VPWR.n165 0.152808
R1437 VPWR.n143 VPWR.n142 0.152808
R1438 VPWR.n135 VPWR.n134 0.152808
R1439 VPWR.n139 VPWR.n138 0.152808
R1440 VPWR.n252 VPWR.n251 0.152808
R1441 VPWR.n293 VPWR.n292 0.152808
R1442 VPWR.n318 VPWR.n317 0.152808
R1443 VPWR.n318 VPWR.n316 0.152808
R1444 VPWR.n290 VPWR.n289 0.152808
R1445 VPWR.n232 VPWR.n231 0.152808
R1446 VPWR.n208 VPWR.n207 0.152808
R1447 VPWR.n224 VPWR.n223 0.152808
R1448 VPWR.n248 VPWR.n247 0.152808
R1449 VPWR.n248 VPWR.n246 0.152808
R1450 VPWR.n831 VPWR.n830 0.152808
R1451 VPWR.n773 VPWR.n772 0.152808
R1452 VPWR.n758 VPWR.n757 0.152808
R1453 VPWR.n766 VPWR.n765 0.152808
R1454 VPWR.n327 VPWR.n326 0.152808
R1455 VPWR.n868 VPWR.n867 0.152808
R1456 VPWR.n865 VPWR.n864 0.152808
R1457 VPWR.n841 VPWR.n840 0.152808
R1458 VPWR.n841 VPWR.n839 0.152808
R1459 VPWR.n727 VPWR.n726 0.152808
R1460 VPWR.n730 VPWR.n729 0.152808
R1461 VPWR.n697 VPWR.n696 0.152808
R1462 VPWR.n697 VPWR.n695 0.152808
R1463 VPWR.n419 VPWR.n418 0.152808
R1464 VPWR.n376 VPWR.n375 0.152808
R1465 VPWR.n399 VPWR.n398 0.152808
R1466 VPWR.n427 VPWR.n426 0.152808
R1467 VPWR.n569 VPWR.n568 0.152808
R1468 VPWR.n576 VPWR.n575 0.152808
R1469 VPWR.n524 VPWR.n523 0.152808
R1470 VPWR.n454 VPWR.n453 0.152808
R1471 VPWR.n503 VPWR.n502 0.152808
R1472 VPWR.n505 VPWR.n504 0.152808
R1473 VPWR.n4 VPWR.n531 0.152808
R1474 VPWR.n644 VPWR.n643 0.152808
R1475 VPWR.n654 VPWR.n653 0.152808
R1476 VPWR.n665 VPWR.n664 0.152808
R1477 VPWR.n606 VPWR.n605 0.152808
R1478 VPWR.n620 VPWR.n619 0.152808
R1479 VPWR.n626 VPWR.n625 0.152808
R1480 VPWR.n147 VPWR.n146 0.152808
R1481 VPWR.n152 VPWR.n151 0.152808
R1482 VPWR.n447 VPWR.n446 0.15223
R1483 VPWR.n382 VPWR.n381 0.148289
R1484 VPWR.n719 VPWR.n718 0.148289
R1485 VPWR.n491 VPWR.n490 0.148289
R1486 VPWR.n492 VPWR.n491 0.148289
R1487 VPWR.n677 VPWR.n676 0.148289
R1488 VPWR.n155 VPWR.t256 0.148289
R1489 VPWR.n152 VPWR.n106 0.147075
R1490 VPWR.n135 VPWR.n122 0.147075
R1491 VPWR.n139 VPWR.n119 0.147075
R1492 VPWR.n143 VPWR.n116 0.147075
R1493 VPWR.n775 VPWR.n773 0.147075
R1494 VPWR.n654 VPWR.n636 0.147075
R1495 VPWR.n280 VPWR.n279 0.147039
R1496 VPWR.n389 VPWR.n384 0.147039
R1497 VPWR.n232 VPWR.n230 0.146736
R1498 VPWR.n842 VPWR.n841 0.146736
R1499 VPWR.n419 VPWR.n364 0.146736
R1500 VPWR.n455 VPWR.n454 0.146736
R1501 VPWR.n524 VPWR.n450 0.146736
R1502 VPWR.n620 VPWR.n596 0.146736
R1503 VPWR.n665 VPWR.n632 0.146736
R1504 VPWR.n198 VPWR.n197 0.145789
R1505 VPWR.n235 VPWR.n233 0.145789
R1506 VPWR.n22 VPWR.n21 0.145789
R1507 VPWR.n878 VPWR.n877 0.145789
R1508 VPWR.n848 VPWR.n847 0.145789
R1509 VPWR.n761 VPWR.n759 0.145789
R1510 VPWR.n53 VPWR.n786 0.189519
R1511 VPWR.n796 VPWR.n795 0.145789
R1512 VPWR.n397 VPWR.n396 0.145789
R1513 VPWR.n751 VPWR.n750 0.145789
R1514 VPWR.n743 VPWR.n742 0.145789
R1515 VPWR.n441 VPWR.n440 0.145789
R1516 VPWR.n518 VPWR.n517 0.145789
R1517 VPWR.n589 VPWR.n588 0.145789
R1518 VPWR.n580 VPWR.n579 0.145789
R1519 VPWR.n544 VPWR.n543 0.145789
R1520 VPWR.n557 VPWR.n556 0.145789
R1521 VPWR.n616 VPWR.n615 0.145789
R1522 VPWR.n861 VPWR.n860 0.142986
R1523 VPWR.n284 VPWR.n283 0.142039
R1524 VPWR.n78 VPWR.n721 0.142039
R1525 VPWR.n720 VPWR.n719 0.142039
R1526 VPWR.n494 VPWR.n493 0.142039
R1527 VPWR.n690 VPWR.n689 0.142039
R1528 VPWR.n230 VPWR.n229 0.140825
R1529 VPWR.n410 VPWR.n408 0.140825
R1530 VPWR.n519 VPWR.n450 0.140825
R1531 VPWR.n617 VPWR.n596 0.140825
R1532 VPWR.n203 VPWR.n202 0.140789
R1533 VPWR.n883 VPWR.n882 0.140789
R1534 VPWR.n853 VPWR.n852 0.140789
R1535 VPWR.n791 VPWR.n790 0.140789
R1536 VPWR.n371 VPWR.n370 0.140789
R1537 VPWR.n446 VPWR.n445 0.140789
R1538 VPWR.n572 VPWR.n571 0.140789
R1539 VPWR.n673 VPWR.n672 0.140789
R1540 VPWR.n611 VPWR.n610 0.140789
R1541 VPWR.n66 VPWR.t182 0.318103
R1542 VPWR.n783 VPWR.n782 0.140486
R1543 VPWR.n436 VPWR.n435 0.140486
R1544 VPWR.n602 VPWR.n592 0.139575
R1545 VPWR.n240 VPWR.n239 0.138289
R1546 VPWR.n302 VPWR.n301 0.137039
R1547 VPWR.n362 VPWR.n360 0.137039
R1548 VPWR.n466 VPWR.n465 0.137039
R1549 VPWR.n228 VPWR.n73 0.249989
R1550 VPWR.n762 VPWR.n65 0.585004
R1551 VPWR.n85 VPWR.n508 0.404003
R1552 VPWR.n717 VPWR.n716 0.135789
R1553 VPWR.n691 VPWR.n690 0.135789
R1554 VPWR.n668 VPWR.n55 0.816459
R1555 VPWR.n268 VPWR.n267 0.133289
R1556 VPWR.n857 VPWR.n856 0.133289
R1557 VPWR.n347 VPWR.n2 0.195144
R1558 VPWR.n906 VPWR.n905 0.133174
R1559 VPWR.n3 VPWR.n591 0.133174
R1560 VPWR.n62 VPWR.n472 0.133174
R1561 VPWR.n200 VPWR.n199 0.130789
R1562 VPWR.n880 VPWR.n879 0.130789
R1563 VPWR.n850 VPWR.n849 0.130789
R1564 VPWR.n788 VPWR.n787 0.130789
R1565 VPWR.n748 VPWR.n747 0.130789
R1566 VPWR.n745 VPWR.n744 0.130789
R1567 VPWR.n706 VPWR.n705 0.130789
R1568 VPWR.n443 VPWR.n442 0.130789
R1569 VPWR.n586 VPWR.n585 0.130789
R1570 VPWR.n547 VPWR.n546 0.130789
R1571 VPWR.n554 VPWR.n553 0.130789
R1572 VPWR.n614 VPWR.n613 0.130789
R1573 VPWR.n82 VPWR.n563 0.303682
R1574 VPWR.n27 VPWR.n25 0.12922
R1575 VPWR.n32 VPWR.n30 0.12922
R1576 VPWR.n355 VPWR.n354 0.12922
R1577 VPWR.n27 VPWR.n26 0.128884
R1578 VPWR.n215 VPWR.n214 0.128884
R1579 VPWR.n808 VPWR.n807 0.128884
R1580 VPWR.n32 VPWR.n31 0.128884
R1581 VPWR.n47 VPWR.n46 0.128884
R1582 VPWR.n889 VPWR.n888 0.127039
R1583 VPWR.n486 VPWR.n463 0.126736
R1584 VPWR.n173 VPWR.n172 0.125789
R1585 VPWR.n174 VPWR.n173 0.125789
R1586 VPWR.n201 VPWR.n200 0.125789
R1587 VPWR.n881 VPWR.n880 0.125789
R1588 VPWR.n851 VPWR.n850 0.125789
R1589 VPWR.n817 VPWR.n816 0.125789
R1590 VPWR.n816 VPWR.n815 0.125789
R1591 VPWR.n333 VPWR.n332 0.125789
R1592 VPWR.n789 VPWR.n788 0.125789
R1593 VPWR.n393 VPWR.n391 0.125789
R1594 VPWR.n746 VPWR.n745 0.125789
R1595 VPWR.n705 VPWR.n704 0.125789
R1596 VPWR.n703 VPWR.n702 0.125789
R1597 VPWR.n444 VPWR.n443 0.125789
R1598 VPWR.n362 VPWR.n361 0.125789
R1599 VPWR.n460 VPWR.n459 0.125789
R1600 VPWR.n514 VPWR.n513 0.125789
R1601 VPWR.n535 VPWR.n84 0.265875
R1602 VPWR.n479 VPWR.n465 0.125789
R1603 VPWR.n613 VPWR.n612 0.125789
R1604 VPWR.n458 VPWR.n457 0.120342
R1605 VPWR.n215 VPWR.n213 0.119294
R1606 VPWR.n808 VPWR.n806 0.119294
R1607 VPWR.n356 VPWR.n355 0.119294
R1608 VPWR.n240 VPWR.n238 0.118289
R1609 VPWR.n873 VPWR.n872 0.118289
R1610 VPWR.n488 VPWR.n459 0.118289
R1611 VPWR.n62 VPWR.n469 0.117039
R1612 VPWR.t16 VPWR.t17 0.116075
R1613 VPWR.n202 VPWR.n201 0.115789
R1614 VPWR.n300 VPWR.n299 0.115789
R1615 VPWR.n263 VPWR.n262 0.115789
R1616 VPWR.n890 VPWR.n889 0.115789
R1617 VPWR.n882 VPWR.n881 0.115789
R1618 VPWR.n852 VPWR.n851 0.115789
R1619 VPWR.n790 VPWR.n789 0.115789
R1620 VPWR.n393 VPWR.n392 0.115789
R1621 VPWR.n404 VPWR.n370 0.115789
R1622 VPWR.n747 VPWR.n746 0.115789
R1623 VPWR.n737 VPWR.n736 0.115789
R1624 VPWR.n734 VPWR.n733 0.115789
R1625 VPWR.n704 VPWR.n703 0.115789
R1626 VPWR.n445 VPWR.n444 0.115789
R1627 VPWR.n573 VPWR.n572 0.115789
R1628 VPWR.n550 VPWR.n549 0.115789
R1629 VPWR.n551 VPWR.n550 0.115789
R1630 VPWR.n688 VPWR.n687 0.115789
R1631 VPWR.n91 VPWR.n674 0.234894
R1632 VPWR.n612 VPWR.n611 0.115789
R1633 VPWR.n836 VPWR.n835 0.11425
R1634 VPWR.n811 VPWR.n804 0.11425
R1635 VPWR.n487 VPWR.n486 0.11425
R1636 VPWR.n598 VPWR.n597 0.11425
R1637 VPWR.n109 VPWR.n108 0.113289
R1638 VPWR.n863 VPWR.n862 0.113289
R1639 VPWR.n199 VPWR.n198 0.110789
R1640 VPWR.n235 VPWR.n234 0.110789
R1641 VPWR.n879 VPWR.n878 0.110789
R1642 VPWR.n849 VPWR.n848 0.110789
R1643 VPWR.n761 VPWR.n760 0.110789
R1644 VPWR.n797 VPWR.n796 0.110789
R1645 VPWR.n396 VPWR.n395 0.110789
R1646 VPWR.n744 VPWR.n743 0.110789
R1647 VPWR.n442 VPWR.n441 0.110789
R1648 VPWR.n517 VPWR.n516 0.110789
R1649 VPWR.n579 VPWR.n578 0.110789
R1650 VPWR.n615 VPWR.n614 0.110789
R1651 VPWR.n563 VPWR.n562 0.1105
R1652 VPWR.n433 VPWR.n432 0.109723
R1653 VPWR.n279 VPWR.n278 0.109539
R1654 VPWR.n385 VPWR.n384 0.109539
R1655 VPWR.n585 VPWR.n584 0.109539
R1656 VPWR.n59 VPWR.n75 0.10925
R1657 VPWR.n837 VPWR.n836 0.10925
R1658 VPWR.n111 VPWR.n68 0.17542
R1659 VPWR.n269 VPWR.n268 0.108289
R1660 VPWR.n303 VPWR.n302 0.105789
R1661 VPWR.n521 VPWR.n520 0.105789
R1662 VPWR.n675 VPWR.n36 0.345236
R1663 VPWR.n462 VPWR.n461 0.10561
R1664 VPWR.t0 VPWR.t1 0.0642722
R1665 VPWR.n301 VPWR.n300 0.104539
R1666 VPWR.n560 VPWR.n559 0.10425
R1667 VPWR.n60 VPWR.n58 0.103337
R1668 VPWR.n63 VPWR.n61 0.103337
R1669 VPWR.n870 VPWR.n869 0.103289
R1670 VPWR.n324 VPWR.n323 0.103002
R1671 VPWR.n249 VPWR.n191 0.10175
R1672 VPWR.n800 VPWR.n328 0.10175
R1673 VPWR.n908 VPWR.n322 0.10175
R1674 VPWR.n428 VPWR.n363 0.10175
R1675 VPWR.n679 VPWR.n592 0.10175
R1676 VPWR.n204 VPWR.n203 0.100789
R1677 VPWR.n884 VPWR.n883 0.100789
R1678 VPWR.n854 VPWR.n853 0.100789
R1679 VPWR.n792 VPWR.n791 0.100789
R1680 VPWR.n372 VPWR.n371 0.100789
R1681 VPWR.n750 VPWR.n749 0.100789
R1682 VPWR.n701 VPWR.n700 0.100789
R1683 VPWR.n512 VPWR.n511 0.100789
R1684 VPWR.n571 VPWR.n570 0.100789
R1685 VPWR.n548 VPWR.n547 0.100789
R1686 VPWR.n553 VPWR.n552 0.100789
R1687 VPWR.n678 VPWR.n673 0.100789
R1688 VPWR.n610 VPWR.n609 0.100789
R1689 VPWR.n271 VPWR.n270 0.1005
R1690 VPWR.n218 VPWR.n212 0.1005
R1691 VPWR.n782 VPWR.n329 0.1005
R1692 VPWR.n437 VPWR.n436 0.1005
R1693 VPWR.n561 VPWR.n560 0.1005
R1694 VPWR.n158 VPWR.n157 0.099539
R1695 VPWR.n168 VPWR.n167 0.099539
R1696 VPWR.n121 VPWR.n120 0.099539
R1697 VPWR.n283 VPWR.n282 0.099539
R1698 VPWR.n824 VPWR.n823 0.099539
R1699 VPWR.n721 VPWR.n720 0.099539
R1700 VPWR.n515 VPWR.n514 0.099539
R1701 VPWR.n689 VPWR.n688 0.099539
R1702 VPWR.n226 VPWR.n56 0.246865
R1703 VPWR.n227 VPWR.n73 0.24649
R1704 VPWR.n79 VPWR.n421 0.246865
R1705 VPWR.n499 VPWR.n498 0.098
R1706 VPWR.n500 VPWR.n499 0.098
R1707 VPWR.n90 VPWR.n526 0.247166
R1708 VPWR.n197 VPWR.n196 0.095789
R1709 VPWR.n21 VPWR.n263 0.095789
R1710 VPWR.n877 VPWR.n876 0.095789
R1711 VPWR.n795 VPWR.n794 0.095789
R1712 VPWR.n400 VPWR.n397 0.095789
R1713 VPWR.n368 VPWR.n367 0.095789
R1714 VPWR.n742 VPWR.n741 0.095789
R1715 VPWR.n711 VPWR.n710 0.095789
R1716 VPWR.n521 VPWR.n518 0.095789
R1717 VPWR.n581 VPWR.n580 0.095789
R1718 VPWR.n543 VPWR.n542 0.095789
R1719 VPWR.n618 VPWR.n616 0.095789
R1720 VPWR.n266 VPWR.n265 0.0955
R1721 VPWR.n588 VPWR.n587 0.094539
R1722 VPWR.n67 VPWR.n160 0.249261
R1723 VPWR.n224 VPWR.n210 0.09425
R1724 VPWR.n209 VPWR.n208 0.09425
R1725 VPWR.n328 VPWR.n327 0.09425
R1726 VPWR.n420 VPWR.n419 0.09425
R1727 VPWR.n427 VPWR.n425 0.09425
R1728 VPWR.n525 VPWR.n524 0.09425
R1729 VPWR.n4 VPWR.n530 0.09425
R1730 VPWR.n576 VPWR.n574 0.09425
R1731 VPWR.n124 VPWR.n70 0.233044
R1732 VPWR.n899 VPWR.n898 0.093289
R1733 VPWR.n825 VPWR.n824 0.093289
R1734 VPWR.n381 VPWR.n380 0.093289
R1735 VPWR.n738 VPWR.n737 0.093289
R1736 VPWR.n733 VPWR.n732 0.093289
R1737 VPWR.n718 VPWR.n717 0.093289
R1738 VPWR.n494 VPWR.n492 0.093289
R1739 VPWR.n676 VPWR.n37 0.271118
R1740 VPWR.n129 VPWR.n128 0.093
R1741 VPWR.n388 VPWR.n387 0.093
R1742 VPWR.n170 VPWR.n169 0.088
R1743 VPWR.n177 VPWR.n176 0.088
R1744 VPWR.n125 VPWR.n124 0.088
R1745 VPWR.n295 VPWR.n294 0.088
R1746 VPWR.n265 VPWR.n264 0.088
R1747 VPWR.n895 VPWR.n894 0.088
R1748 VPWR.n892 VPWR.n891 0.088
R1749 VPWR.n820 VPWR.n819 0.088
R1750 VPWR.n732 VPWR.n731 0.088
R1751 VPWR.n709 VPWR.n708 0.088
R1752 VPWR.n438 VPWR.n437 0.088
R1753 VPWR.n147 VPWR.n108 0.087039
R1754 VPWR.n160 VPWR.n157 0.087039
R1755 VPWR.n167 VPWR.n166 0.087039
R1756 VPWR.n208 VPWR.n206 0.087039
R1757 VPWR.n250 VPWR.n248 0.087039
R1758 VPWR.n291 VPWR.n290 0.087039
R1759 VPWR.n869 VPWR.n868 0.087039
R1760 VPWR.n865 VPWR.n863 0.087039
R1761 VPWR.n327 VPWR.n325 0.087039
R1762 VPWR.n400 VPWR.n399 0.087039
R1763 VPWR.n376 VPWR.n374 0.087039
R1764 VPWR.n429 VPWR.n427 0.087039
R1765 VPWR.n728 VPWR.n727 0.087039
R1766 VPWR.n698 VPWR.n697 0.087039
R1767 VPWR.n506 VPWR.n503 0.087039
R1768 VPWR.n506 VPWR.n505 0.087039
R1769 VPWR.n607 VPWR.n606 0.087039
R1770 VPWR.n69 VPWR.n104 0.172055
R1771 VPWR.n804 VPWR.n803 0.08675
R1772 VPWR.n413 VPWR.n411 0.08675
R1773 VPWR.n487 VPWR.n485 0.08675
R1774 VPWR.n630 VPWR.n597 0.08675
R1775 VPWR.n206 VPWR.n205 0.085789
R1776 VPWR.n267 VPWR.n266 0.085789
R1777 VPWR.n856 VPWR.n855 0.085789
R1778 VPWR.n794 VPWR.n793 0.085789
R1779 VPWR.n374 VPWR.n373 0.085789
R1780 VPWR.n699 VPWR.n698 0.085789
R1781 VPWR.n545 VPWR.n544 0.085789
R1782 VPWR.n556 VPWR.n555 0.085789
R1783 VPWR.n608 VPWR.n607 0.085789
R1784 VPWR.n369 VPWR.n368 0.0855
R1785 VPWR.n710 VPWR.n709 0.0855
R1786 VPWR.n137 VPWR.n120 0.083289
R1787 VPWR.n287 VPWR.n286 0.083289
R1788 VPWR.n872 VPWR.n871 0.083289
R1789 VPWR.n724 VPWR.n723 0.083289
R1790 VPWR.n169 VPWR.n168 0.08175
R1791 VPWR.n129 VPWR.n126 0.08175
R1792 VPWR.n225 VPWR.n210 0.08175
R1793 VPWR.n228 VPWR.n209 0.08175
R1794 VPWR.n784 VPWR.n329 0.08175
R1795 VPWR.n405 VPWR.n369 0.08175
R1796 VPWR.n420 VPWR.n417 0.08175
R1797 VPWR.n425 VPWR.n424 0.08175
R1798 VPWR.n525 VPWR.n522 0.08175
R1799 VPWR.n530 VPWR.n529 0.08175
R1800 VPWR.n270 VPWR.n269 0.080789
R1801 VPWR.n900 VPWR.n899 0.080789
R1802 VPWR.n511 VPWR.n89 0.16741
R1803 VPWR.n834 VPWR.t77 0.0805
R1804 VPWR.n250 VPWR.n249 0.079539
R1805 VPWR.n429 VPWR.n428 0.079539
R1806 VPWR.n68 VPWR.n145 0.190616
R1807 VPWR.n272 VPWR.n271 0.07675
R1808 VPWR.n813 VPWR.n812 0.07675
R1809 VPWR.n8 VPWR.t43 0.710301
R1810 VPWR.n54 VPWR.n406 0.175245
R1811 VPWR.n304 VPWR.n303 0.0755
R1812 VPWR.n413 VPWR.n412 0.0755
R1813 VPWR.n112 VPWR.n111 0.073
R1814 VPWR.n105 VPWR.n103 0.072039
R1815 VPWR.n352 VPWR.n351 0.072039
R1816 VPWR.n600 VPWR.n599 0.072039
R1817 VPWR.n253 VPWR.n252 0.07175
R1818 VPWR.n388 VPWR.n385 0.07175
R1819 VPWR.n578 VPWR.n577 0.0705
R1820 VPWR.n298 VPWR.n297 0.068
R1821 VPWR.n105 VPWR.n104 0.067039
R1822 VPWR.n599 VPWR.n598 0.067039
R1823 VPWR.n474 VPWR.n468 0.06675
R1824 VPWR.n181 VPWR.n180 0.0655
R1825 VPWR.n299 VPWR.n298 0.0655
R1826 VPWR.n896 VPWR.n895 0.0655
R1827 VPWR.n891 VPWR.n890 0.0655
R1828 VPWR.n574 VPWR.n573 0.0655
R1829 VPWR.n3 VPWR.n590 0.06425
R1830 VPWR.n680 VPWR.n47 0.0634996
R1831 VPWR.n325 VPWR.n324 0.062039
R1832 VPWR.n24 VPWR.n191 0.0605
R1833 VPWR.n27 VPWR.n24 0.0605
R1834 VPWR.n909 VPWR.n908 0.0605
R1835 VPWR.n909 VPWR.n75 0.0605
R1836 VPWR.n29 VPWR.n363 0.0605
R1837 VPWR.n32 VPWR.n29 0.0605
R1838 VPWR.n680 VPWR.n679 0.0605
R1839 VPWR.n906 VPWR.n838 0.05675
R1840 VPWR.n178 VPWR.n177 0.0555
R1841 VPWR.n903 VPWR.n902 0.0555
R1842 VPWR.n871 VPWR.n870 0.0555
R1843 VPWR.n821 VPWR.n820 0.0555
R1844 VPWR.n771 VPWR.n770 0.0555
R1845 VPWR.n778 VPWR.n777 0.0555
R1846 VPWR.n779 VPWR.n330 0.0555
R1847 VPWR.n391 VPWR.n390 0.0555
R1848 VPWR.n714 VPWR.n713 0.0555
R1849 VPWR.n361 VPWR.n348 0.0555
R1850 VPWR.n513 VPWR.n89 0.0900241
R1851 VPWR.n520 VPWR.n519 0.0555
R1852 VPWR.n536 VPWR.n535 0.0555
R1853 VPWR.n480 VPWR.n479 0.0555
R1854 VPWR.n931 VPWR.n19 0.05506
R1855 VPWR.n919 VPWR.n918 0.05506
R1856 VPWR.n917 VPWR.n916 0.05506
R1857 VPWR.n77 VPWR.n344 0.114943
R1858 VPWR.n847 VPWR.n846 0.0519425
R1859 VPWR.n407 VPWR.n406 0.0505
R1860 VPWR.n707 VPWR.n706 0.0505
R1861 VPWR.n409 VPWR.n366 0.04925
R1862 VPWR.n305 VPWR.n304 0.048
R1863 VPWR.n348 VPWR.n347 0.048
R1864 VPWR.n480 VPWR.n478 0.048
R1865 VPWR.n262 VPWR.n261 0.0455
R1866 VPWR.n862 VPWR.n861 0.0455
R1867 VPWR.n412 VPWR.n366 0.0455
R1868 VPWR.n540 VPWR.n539 0.0455
R1869 VPWR.n628 VPWR.n627 0.0455
R1870 VPWR.n812 VPWR.n805 0.04425
R1871 VPWR.n930 VPWR.n101 0.0436411
R1872 VPWR.n913 VPWR.n912 0.0436411
R1873 VPWR.n922 VPWR.n921 0.0436411
R1874 VPWR.n921 VPWR.n920 0.0436411
R1875 VPWR.n912 VPWR.n911 0.0436411
R1876 VPWR.n183 VPWR.n182 0.043
R1877 VPWR.n928 VPWR.n927 0.04274
R1878 VPWR.n217 VPWR.n215 0.0423097
R1879 VPWR.n810 VPWR.n808 0.0423097
R1880 VPWR.n355 VPWR.n353 0.0423097
R1881 VPWR.t76 VPWR.n834 0.0405
R1882 VPWR.n113 VPWR.n112 0.03925
R1883 VPWR.n126 VPWR.n125 0.03925
R1884 VPWR.n71 VPWR.n284 0.631685
R1885 VPWR.n259 VPWR.n258 0.03925
R1886 VPWR.n904 VPWR.n903 0.03925
R1887 VPWR.n844 VPWR.n843 0.03925
R1888 VPWR.n785 VPWR.n784 0.03925
R1889 VPWR.n407 VPWR.n405 0.03925
R1890 VPWR.n12 VPWR.n78 0.632851
R1891 VPWR.n570 VPWR.n50 0.158289
R1892 VPWR.n63 VPWR.n62 0.0655
R1893 VPWR.n537 VPWR.n536 0.03925
R1894 VPWR.n787 VPWR.n53 0.0676815
R1895 VPWR.n786 VPWR.n785 0.0355
R1896 VPWR.n440 VPWR.n439 0.0355
R1897 VPWR.n358 VPWR.n357 0.0355
R1898 VPWR.n590 VPWR.n589 0.0355
R1899 VPWR.n558 VPWR.n557 0.0355
R1900 VPWR.n476 VPWR.n475 0.0355
R1901 VPWR.n390 VPWR.n389 0.03425
R1902 VPWR.n184 VPWR.n181 0.033
R1903 VPWR.n311 VPWR.n310 0.033
R1904 VPWR.n308 VPWR.n307 0.033
R1905 VPWR.n258 VPWR.n257 0.033
R1906 VPWR.n264 VPWR.n17 0.383903
R1907 VPWR.n220 VPWR.n219 0.033
R1908 VPWR.n9 VPWR.n222 0.033
R1909 VPWR.n777 VPWR.n776 0.033
R1910 VPWR.n781 VPWR.n330 0.033
R1911 VPWR.n708 VPWR.n707 0.033
R1912 VPWR.n439 VPWR.n438 0.033
R1913 VPWR.n485 VPWR.n462 0.0320537
R1914 VPWR.n516 VPWR.n515 0.03175
R1915 VPWR.n275 VPWR.n274 0.02925
R1916 VPWR.n294 VPWR.n293 0.02675
R1917 VPWR.n832 VPWR.n831 0.02675
R1918 VPWR.n731 VPWR.n730 0.02675
R1919 VPWR.n577 VPWR.n576 0.02675
R1920 VPWR.n45 VPWR.n626 0.321949
R1921 VPWR.n38 VPWR.t153 0.00759893
R1922 VPWR.t91 VPWR.t10 0.0614324
R1923 VPWR.n546 VPWR.n545 0.0255
R1924 VPWR.n549 VPWR.n548 0.0255
R1925 VPWR.n552 VPWR.n551 0.0255
R1926 VPWR.n555 VPWR.n554 0.0255
R1927 VPWR.n833 VPWR.n832 0.023
R1928 VPWR.n771 VPWR.n769 0.023
R1929 VPWR.n928 VPWR.n101 0.0220706
R1930 VPWR.n931 VPWR.n930 0.0220706
R1931 VPWR.n916 VPWR.n911 0.0220706
R1932 VPWR.n923 VPWR.n922 0.0220706
R1933 VPWR.n920 VPWR.n919 0.0220706
R1934 VPWR.n914 VPWR.n913 0.0220706
R1935 VPWR.n915 VPWR.n102 0.02162
R1936 VPWR.n187 VPWR.n186 0.02162
R1937 VPWR.n845 VPWR.n844 0.0205
R1938 VPWR.n713 VPWR.n712 0.0205
R1939 VPWR.n541 VPWR.n540 0.0205
R1940 VPWR.n562 VPWR.n561 0.0205
R1941 VPWR.n324 VPWR.n322 0.018
R1942 VPWR.n587 VPWR.n586 0.01675
R1943 VPWR.n559 VPWR.n558 0.01675
R1944 VPWR.n702 VPWR.n701 0.0155
R1945 VPWR.n461 VPWR.n460 0.013
R1946 VPWR.n471 VPWR.n470 0.013
R1947 VPWR.n60 VPWR.n59 0.013
R1948 VPWR.n216 VPWR.n212 0.01175
R1949 VPWR.n838 VPWR.n837 0.01175
R1950 VPWR.n809 VPWR.n805 0.01175
R1951 VPWR.n473 VPWR.n468 0.01175
R1952 VPWR.n929 VPWR.n100 0.0115476
R1953 VPWR.n932 VPWR.n100 0.0115476
R1954 VPWR.n752 VPWR.n751 0.0105
R1955 VPWR.n749 VPWR.n748 0.0105
R1956 VPWR.t15 VPWR.t105 0.00994663
R1957 VPWR.n233 VPWR.n232 0.00925
R1958 VPWR.n759 VPWR.n758 0.00925
R1959 VPWR.n98 VPWR.t1 0.00832954
R1960 VPWR.n242 VPWR.n241 0.00675
R1961 VPWR.n23 VPWR.n835 0.0664183
R1962 VPWR.n813 VPWR.n811 0.00675
R1963 VPWR.n38 VPWR.t15 0.00677304
R1964 VPWR.n38 VPWR.n66 3.30757
R1965 VPWR.t43 VPWR.n15 1.61513
R1966 VPWR.n10 VPWR.n9 1.15134
R1967 VPWR.n387 VPWR.n2 1.06413
R1968 VPWR.n5 VPWR.n4 1.04562
R1969 VGND.t152 VGND.t147 2.364e+06
R1970 VGND.n314 VGND.t657 1.99549e+06
R1971 VGND.n277 VGND.n276 1.923e+06
R1972 VGND.t89 VGND.t354 66082.9
R1973 VGND.n808 VGND.t1419 64574.3
R1974 VGND.n522 VGND.t582 64574.3
R1975 VGND.n571 VGND.t797 64574.3
R1976 VGND.n597 VGND.t1040 64574.3
R1977 VGND.n331 VGND.t481 64397.8
R1978 VGND.n704 VGND.t1301 64397.8
R1979 VGND.n376 VGND.n375 64129.4
R1980 VGND.n712 VGND.n711 64129.4
R1981 VGND.n806 VGND.n805 63952.9
R1982 VGND.n520 VGND.n519 63952.9
R1983 VGND.n581 VGND.n577 63952.9
R1984 VGND.n606 VGND.n602 63952.9
R1985 VGND.t8 VGND.t401 58500
R1986 VGND.t48 VGND.n736 54408.1
R1987 VGND.n661 VGND.t1286 54408.1
R1988 VGND.n436 VGND.n435 52736.8
R1989 VGND.t918 VGND.t442 45492.3
R1990 VGND.t819 VGND.n594 45130.6
R1991 VGND.t194 VGND.t1156 44027.1
R1992 VGND.t399 VGND.n387 43058.8
R1993 VGND.t1178 VGND.n496 34841.9
R1994 VGND.n297 VGND.n296 28058.8
R1995 VGND.n702 VGND.n701 28058.8
R1996 VGND.t921 VGND.t409 26205.5
R1997 VGND.n682 VGND.t4 23882.1
R1998 VGND.n300 VGND.t59 23882.1
R1999 VGND.n771 VGND.n770 23229
R2000 VGND.n677 VGND.n676 22494.4
R2001 VGND.n655 VGND.n654 22494.4
R2002 VGND.n563 VGND.n562 19058.8
R2003 VGND.n781 VGND.t1173 18994.7
R2004 VGND.t495 VGND.n452 18549.2
R2005 VGND.n458 VGND.n457 17470.6
R2006 VGND.t1038 VGND.t991 14049.6
R2007 VGND.t1663 VGND.t222 13152.7
R2008 VGND.n558 VGND.t1037 12884
R2009 VGND.t1641 VGND.t988 11719.1
R2010 VGND.t543 VGND.t242 11719.1
R2011 VGND.n439 VGND.t362 10731.5
R2012 VGND.t1200 VGND.t855 9883.84
R2013 VGND.t1436 VGND.t1411 9589.09
R2014 VGND.t873 VGND.t227 9562.77
R2015 VGND.n737 VGND.t48 7250
R2016 VGND.t1286 VGND.n660 7250
R2017 VGND.n827 VGND.t283 7037.65
R2018 VGND.n502 VGND.n500 6205.48
R2019 VGND.n82 VGND.n823 6057.61
R2020 VGND.n823 VGND.n822 5906.25
R2021 VGND.n822 VGND.t200 5906.25
R2022 VGND.t200 VGND.n507 5906.25
R2023 VGND.t72 VGND.n507 5906.25
R2024 VGND.n779 VGND.t762 4917.01
R2025 VGND.n815 VGND.t1200 4734.38
R2026 VGND.n569 VGND.n568 4726.03
R2027 VGND.n339 VGND.t1411 4477.83
R2028 VGND.n370 VGND.t873 4477.83
R2029 VGND.n632 VGND.n631 4232.88
R2030 VGND.n595 VGND.t819 3845.3
R2031 VGND.n596 VGND.t918 3845.3
R2032 VGND.n0 VGND.t1156 3625
R2033 VGND.n637 VGND.t848 3494.97
R2034 VGND.t270 VGND.n359 2714.25
R2035 VGND.n342 VGND.t225 2506.55
R2036 VGND.t1438 VGND.n338 2287.68
R2037 VGND.n497 VGND.t644 2083.33
R2038 VGND.n635 VGND.t898 1562.5
R2039 VGND.n637 VGND.t297 1140.62
R2040 VGND.n362 VGND.t1664 1109.79
R2041 VGND.t68 VGND.t437 1109.79
R2042 VGND.n453 VGND.t844 1045.35
R2043 VGND.t1365 VGND.n780 1012.99
R2044 VGND.n779 VGND.t835 941.558
R2045 VGND.t68 VGND.t1048 877.36
R2046 VGND.n557 VGND.t673 877.36
R2047 VGND.n360 VGND.t730 876.155
R2048 VGND.t362 VGND.t1614 865.169
R2049 VGND.n362 VGND.t389 859.519
R2050 VGND.t105 VGND.t446 854.015
R2051 VGND.t484 VGND.t426 854.015
R2052 VGND.t730 VGND.t270 804.067
R2053 VGND.n67 VGND.t589 718.193
R2054 VGND.n341 VGND.t817 715.596
R2055 VGND.n371 VGND.t607 715.596
R2056 VGND.t677 VGND.n73 710.804
R2057 VGND.n66 VGND.t813 710.804
R2058 VGND.t721 VGND.n223 585.188
R2059 VGND.n443 VGND.t512 701.971
R2060 VGND.n437 VGND.t360 690.595
R2061 VGND.t35 VGND.t1454 61.8302
R2062 VGND.n181 VGND.t159 61.8299
R2063 VGND.t501 VGND.n85 673.859
R2064 VGND.t1610 VGND.n72 673.859
R2065 VGND.t511 VGND.n427 672.414
R2066 VGND.t170 VGND.n422 672.414
R2067 VGND.n339 VGND.t611 665.139
R2068 VGND.n370 VGND.t1292 665.139
R2069 VGND.t43 VGND.n171 34.9573
R2070 VGND.t169 VGND.n174 34.9573
R2071 VGND.n177 VGND.t1153 114.987
R2072 VGND.t513 VGND.n426 657.635
R2073 VGND.t215 VGND.n825 657.635
R2074 VGND.n815 VGND.t946 654.135
R2075 VGND.n84 VGND.t1435 651.692
R2076 VGND.n69 VGND.t678 651.692
R2077 VGND.t812 VGND.n76 651.692
R2078 VGND.t1552 VGND.n433 650.246
R2079 VGND.t410 VGND.n425 650.246
R2080 VGND.t548 VGND.n231 206.998
R2081 VGND.n447 VGND.t755 650.246
R2082 VGND.n74 VGND.t171 644.303
R2083 VGND.t1609 VGND.n201 71.9094
R2084 VGND.t34 VGND.n92 90.4102
R2085 VGND.t35 VGND.n149 0.333543
R2086 VGND.n132 VGND.t35 0.333543
R2087 VGND.t35 VGND.n165 0.333543
R2088 VGND.n78 VGND.t1152 90.4096
R2089 VGND.n442 VGND.t510 628.08
R2090 VGND.t33 VGND.n91 625.139
R2091 VGND.n85 VGND.t594 622.135
R2092 VGND.n72 VGND.t1120 622.135
R2093 VGND.t1147 VGND.n67 622.135
R2094 VGND.n444 VGND.t514 613.301
R2095 VGND.t720 VGND.n824 613.301
R2096 VGND.t1126 VGND.n302 609.375
R2097 VGND.t646 VGND.n180 98.5059
R2098 VGND.t163 VGND.n196 98.5052
R2099 VGND.t118 VGND.n197 98.5126
R2100 VGND.n179 VGND.t1172 98.5127
R2101 VGND.n434 VGND.t275 601.486
R2102 VGND.t35 VGND.n187 1.8118
R2103 VGND.t330 VGND.n81 597.779
R2104 VGND.n88 VGND.t1670 597.779
R2105 VGND.n96 VGND.t230 597.779
R2106 VGND.n79 VGND.t1153 597.779
R2107 VGND.t175 VGND.n198 114.008
R2108 VGND.t376 VGND.n190 595.241
R2109 VGND.n203 VGND.t31 155.251
R2110 VGND.t556 VGND.n199 155.252
R2111 VGND.t509 VGND.n428 583.745
R2112 VGND.t364 VGND.n182 114.002
R2113 VGND.n196 VGND.t505 125.862
R2114 VGND.t308 VGND.n180 125.862
R2115 VGND.n197 VGND.t232 125.862
R2116 VGND.t35 VGND.n179 2.14035
R2117 VGND.t503 VGND.n90 577.799
R2118 VGND.t37 VGND.n175 98.8794
R2119 VGND.t1187 VGND.n178 98.8788
R2120 VGND.n300 VGND.t1277 570.312
R2121 VGND.n682 VGND.t129 570.312
R2122 VGND.t515 VGND.n184 573.193
R2123 VGND.n436 VGND.n431 556.932
R2124 VGND.t164 VGND.n170 106.858
R2125 VGND.n115 VGND.t102 273.892
R2126 VGND.n169 VGND.t173 106.858
R2127 VGND.n230 VGND.t35 1.42503
R2128 VGND.n94 VGND.t619 555.633
R2129 VGND.t323 VGND.t6 546.091
R2130 VGND.n331 VGND.t392 542.591
R2131 VGND.t1635 VGND.t53 542.591
R2132 VGND.n808 VGND.t85 542.591
R2133 VGND.t1254 VGND.t562 542.591
R2134 VGND.n704 VGND.t423 542.591
R2135 VGND.n522 VGND.t557 542.591
R2136 VGND.n571 VGND.t321 542.591
R2137 VGND.n596 VGND.t87 542.591
R2138 VGND.n597 VGND.t140 542.591
R2139 VGND.t35 VGND.n184 12.3852
R2140 VGND.t35 VGND.n202 12.3852
R2141 VGND.n200 VGND.t35 12.3852
R2142 VGND.n188 VGND.t847 134.572
R2143 VGND.t1553 VGND.n94 540.855
R2144 VGND.t542 VGND.n66 540.855
R2145 VGND.t1434 VGND.t1551 539.747
R2146 VGND.n441 VGND.t770 539.409
R2147 VGND.n445 VGND.t412 539.409
R2148 VGND.t757 VGND.n420 539.409
R2149 VGND.t548 VGND.n424 517.241
R2150 VGND.n446 VGND.t1171 517.241
R2151 VGND.n190 VGND.t1319 151.153
R2152 VGND.t1124 VGND.n182 155.252
R2153 VGND.t517 VGND.n185 114.008
R2154 VGND.t848 VGND.t298 500
R2155 VGND.n435 VGND.n432 497.526
R2156 VGND.t769 VGND.n235 500.993
R2157 VGND.n91 VGND.t747 491.474
R2158 VGND.n81 VGND.t1629 491.466
R2159 VGND.t752 VGND.n88 491.466
R2160 VGND.t1346 VGND.n96 491.466
R2161 VGND.t1345 VGND.n79 491.466
R2162 VGND.n73 VGND.t1182 489.13
R2163 VGND.t1338 VGND.n74 489.13
R2164 VGND.t35 VGND.n235 10.6945
R2165 VGND.t1617 VGND.t504 460.397
R2166 VGND.n193 VGND.t36 467.161
R2167 VGND.t80 VGND.t1613 460.397
R2168 VGND.t35 VGND.n191 0.220239
R2169 VGND.n86 VGND.t645 174.816
R2170 VGND.t35 VGND.t309 174.839
R2171 VGND.t35 VGND.n183 0.242118
R2172 VGND.n181 VGND.t35 0.220383
R2173 VGND.n189 VGND.t846 166.537
R2174 VGND.t103 VGND.t399 450.868
R2175 VGND.t307 VGND.t1289 439.716
R2176 VGND.t506 VGND.t1621 439.716
R2177 VGND.t231 VGND.t606 439.716
R2178 VGND.t233 VGND.t709 439.716
R2179 VGND.n193 VGND.t35 9.84939
R2180 VGND.n440 VGND.t1620 430.411
R2181 VGND.n200 VGND.t1615 434.637
R2182 VGND.n448 VGND.t102 430.411
R2183 VGND.t1236 VGND.n188 434.637
R2184 VGND.t1243 VGND.n552 429.031
R2185 VGND.t719 VGND.n137 77.2398
R2186 VGND.n150 VGND.t50 14.0579
R2187 VGND.t292 VGND.t25 367.755
R2188 VGND.t0 VGND.n157 12.256
R2189 VGND.n58 VGND.t1687 424.017
R2190 VGND.t431 VGND.n552 423.077
R2191 VGND.t89 VGND.t859 423.077
R2192 VGND.n438 VGND.n430 420.05
R2193 VGND.n764 VGND.t671 418.56
R2194 VGND.t825 VGND.t762 415.584
R2195 VGND.n823 VGND.n474 411.43
R2196 VGND.n241 VGND.t1520 242.846
R2197 VGND.n822 VGND.n506 411.43
R2198 VGND.n700 VGND.n507 411.43
R2199 VGND.t550 VGND.n269 408.31
R2200 VGND.t1202 VGND.n260 408.31
R2201 VGND.t263 VGND.n484 407.144
R2202 VGND.n791 VGND.t530 407.144
R2203 VGND.n696 VGND.t1560 407.144
R2204 VGND.t982 VGND.n721 407.144
R2205 VGND.t35 VGND.t1538 182.042
R2206 VGND.n252 VGND.t1427 402.858
R2207 VGND.n506 VGND.t1451 402.858
R2208 VGND.t440 VGND.n222 53.1692
R2209 VGND.n322 VGND.t1632 399.714
R2210 VGND.t269 VGND.n364 398.572
R2211 VGND.t1242 VGND.n768 398.572
R2212 VGND.t1077 VGND.n155 75.2357
R2213 VGND.n734 VGND.t1027 398.572
R2214 VGND.t1106 VGND.n530 398.572
R2215 VGND.n61 VGND.t668 398.228
R2216 VGND.t0 VGND.n205 15.2046
R2217 VGND.n153 VGND.t404 26.8307
R2218 VGND.t295 VGND.n1 41.1568
R2219 VGND.t978 VGND.n162 26.8307
R2220 VGND.n22 VGND.t317 397.132
R2221 VGND.t148 VGND.n24 397.132
R2222 VGND.t631 VGND.n47 397.132
R2223 VGND.n352 VGND.t1384 395.834
R2224 VGND.n273 VGND.t525 391.118
R2225 VGND.n280 VGND.t1577 391.118
R2226 VGND.n724 VGND.t981 390
R2227 VGND.t1025 VGND.n166 391.803
R2228 VGND.t890 VGND.n620 390
R2229 VGND.n377 VGND.t1554 387.5
R2230 VGND.t1185 VGND.n798 387.5
R2231 VGND.t333 VGND.n708 387.5
R2232 VGND.t969 VGND.n512 387.5
R2233 VGND.t801 VGND.n578 387.5
R2234 VGND.t880 VGND.n603 387.5
R2235 VGND.t471 VGND.n410 385.714
R2236 VGND.t1428 VGND.n46 384.274
R2237 VGND.t1024 VGND.n37 384.274
R2238 VGND.n282 VGND.t1579 382.522
R2239 VGND.n285 VGND.t1203 382.522
R2240 VGND.n317 VGND.t1115 382.522
R2241 VGND.n316 VGND.t1240 382.522
R2242 VGND.n304 VGND.t1429 382.522
R2243 VGND.t540 VGND.n395 381.43
R2244 VGND.n407 VGND.t253 381.43
R2245 VGND.t204 VGND.n365 381.43
R2246 VGND.t1122 VGND.n247 381.43
R2247 VGND.n480 VGND.t1258 381.43
R2248 VGND.n792 VGND.t529 381.43
R2249 VGND.n147 VGND.t349 387.327
R2250 VGND.t1163 VGND.n812 381.43
R2251 VGND.t1600 VGND.n811 381.43
R2252 VGND.t1297 VGND.n722 381.43
R2253 VGND.t983 VGND.n720 381.43
R2254 VGND.n647 VGND.t1032 381.43
R2255 VGND.t907 VGND.n541 381.43
R2256 VGND.n651 VGND.t1103 381.43
R2257 VGND.t1071 VGND.n526 381.43
R2258 VGND.n666 VGND.t789 381.43
R2259 VGND.n587 VGND.t113 381.43
R2260 VGND.n588 VGND.t1089 381.43
R2261 VGND.t892 VGND.n612 381.43
R2262 VGND.n52 VGND.t1111 381.036
R2263 VGND.n127 VGND.t537 57.3413
R2264 VGND.n126 VGND.t335 57.3413
R2265 VGND.t30 VGND.n130 0.359558
R2266 VGND.t1039 VGND.n321 378.224
R2267 VGND.t539 VGND.n759 377.144
R2268 VGND.n646 VGND.t1002 377.144
R2269 VGND.t1146 VGND.n55 376.738
R2270 VGND.t1298 VGND.n306 373.926
R2271 VGND.n548 VGND.t1218 372.858
R2272 VGND.n163 VGND.t120 46.0246
R2273 VGND.n204 VGND.t737 83.63
R2274 VGND.t1672 VGND.n148 379.442
R2275 VGND.t1618 VGND.t555 372.747
R2276 VGND.t1616 VGND.t41 372.747
R2277 VGND.t228 VGND.n164 379.442
R2278 VGND.t100 VGND.t899 372.747
R2279 VGND.t326 VGND.t1235 372.747
R2280 VGND.t746 VGND.t1436 371.56
R2281 VGND.t227 VGND.t875 371.56
R2282 VGND.t447 VGND.n291 370.788
R2283 VGND.t485 VGND.n683 370.788
R2284 VGND.t1450 VGND.n477 368.572
R2285 VGND.n761 VGND.t669 368.572
R2286 VGND.t1139 VGND.t1392 368.572
R2287 VGND.t855 VGND.t663 365.414
R2288 VGND.t1576 VGND.n265 365.329
R2289 VGND.t1198 VGND.n261 365.329
R2290 VGND.t1118 VGND.n311 365.329
R2291 VGND.t561 VGND.n304 365.329
R2292 VGND.n399 VGND.t670 364.286
R2293 VGND.n752 VGND.t1391 364.286
R2294 VGND.t1140 VGND.n749 364.286
R2295 VGND.t532 VGND.n787 364.286
R2296 VGND.n818 VGND.t1166 364.286
R2297 VGND.n667 VGND.t1074 364.286
R2298 VGND.t464 VGND.n109 367.074
R2299 VGND.t1409 VGND.n614 364.286
R2300 VGND.t1686 VGND.n828 362.07
R2301 VGND.n740 VGND.t123 362.07
R2302 VGND.n657 VGND.t910 362.07
R2303 VGND.n325 VGND.t1362 361.033
R2304 VGND.t1580 VGND.n262 356.735
R2305 VGND.t717 VGND.n259 356.735
R2306 VGND.t675 VGND.n328 356.735
R2307 VGND.n318 VGND.t1114 356.735
R2308 VGND.t304 VGND.n471 355.714
R2309 VGND.t806 VGND.n394 355.714
R2310 VGND.t1121 VGND.n250 355.714
R2311 VGND.t265 VGND.n482 355.714
R2312 VGND.n816 VGND.t1162 355.714
R2313 VGND.t1096 VGND.n540 355.714
R2314 VGND.t927 VGND.n585 355.714
R2315 VGND.n623 VGND.t893 355.714
R2316 VGND.n625 VGND.t61 355.714
R2317 VGND.n109 VGND.t0 13.564
R2318 VGND.t42 VGND.n131 139.087
R2319 VGND.n168 VGND.t1149 139.087
R2320 VGND.t35 VGND.n164 9.83319
R2321 VGND.n148 VGND.t219 139.087
R2322 VGND.n455 VGND.t496 352.449
R2323 VGND.n323 VGND.t1363 352.437
R2324 VGND.t617 VGND.n363 351.43
R2325 VGND.t1566 VGND.n145 60.3116
R2326 VGND.n495 VGND.t1224 351.43
R2327 VGND.n491 VGND.t1357 351.43
R2328 VGND.n479 VGND.t1645 351.43
R2329 VGND.n770 VGND.n767 351.43
R2330 VGND.n762 VGND.t1366 351.43
R2331 VGND.t374 VGND.n758 351.43
R2332 VGND.t690 VGND.n695 351.43
R2333 VGND.n735 VGND.t124 351.43
R2334 VGND.n161 VGND.t1623 60.3116
R2335 VGND.n659 VGND.t911 351.43
R2336 VGND.n209 VGND.t549 73.433
R2337 VGND.t1047 VGND.n555 349.546
R2338 VGND.t661 VGND.n492 347.144
R2339 VGND.t190 VGND.n731 347.144
R2340 VGND.n663 VGND.t1583 347.144
R2341 VGND.n354 VGND.t1382 345.834
R2342 VGND.t1228 VGND.n254 345.834
R2343 VGND.t1578 VGND.t1132 343.841
R2344 VGND.n677 VGND.n670 343.75
R2345 VGND.n655 VGND.n533 343.75
R2346 VGND.n561 VGND.t760 341.668
R2347 VGND.n63 VGND.t1445 341.418
R2348 VGND.n38 VGND.t1155 341.418
R2349 VGND.t417 VGND.n33 341.418
R2350 VGND.t78 VGND.n454 341.341
R2351 VGND.n257 VGND.t1431 339.543
R2352 VGND.t1131 VGND.n286 339.543
R2353 VGND.n330 VGND.t1259 339.543
R2354 VGND.n324 VGND.t1453 339.543
R2355 VGND.t1119 VGND.n310 339.543
R2356 VGND.t406 VGND.n469 338.572
R2357 VGND.t16 VGND.n397 338.572
R2358 VGND.n400 VGND.t672 338.572
R2359 VGND.n401 VGND.t591 338.572
R2360 VGND.n403 VGND.t866 338.572
R2361 VGND.t14 VGND.n213 67.9072
R2362 VGND.t473 VGND.n138 70.2448
R2363 VGND.n487 VGND.t260 338.572
R2364 VGND.n753 VGND.t1390 338.572
R2365 VGND.t1141 VGND.n748 338.572
R2366 VGND.t533 VGND.n786 338.572
R2367 VGND.n820 VGND.t637 338.572
R2368 VGND.t534 VGND.n141 70.2298
R2369 VGND.t1557 VGND.n693 338.572
R2370 VGND.n726 VGND.t979 338.572
R2371 VGND.t1368 VGND.n719 338.572
R2372 VGND.t1007 VGND.n538 338.572
R2373 VGND.t1075 VGND.n524 338.572
R2374 VGND.t430 VGND.n546 338.572
R2375 VGND.t116 VGND.n545 338.572
R2376 VGND.n639 VGND.t237 338.572
R2377 VGND.t1408 VGND.n210 346.435
R2378 VGND.t1251 VGND.n766 338.572
R2379 VGND.n373 VGND.t1570 337.5
R2380 VGND.t1183 VGND.n796 337.5
R2381 VGND.n714 VGND.t1004 337.5
R2382 VGND.t1045 VGND.n510 337.5
R2383 VGND.n583 VGND.t1389 337.5
R2384 VGND.n608 VGND.t1401 337.5
R2385 VGND.n300 VGND.n291 337.079
R2386 VGND.n683 VGND.n682 337.079
R2387 VGND.t1537 VGND.t35 183.806
R2388 VGND.t1541 VGND.t35 183.812
R2389 VGND.t989 VGND.n153 335.433
R2390 VGND.n775 VGND.t1359 334.178
R2391 VGND.t1174 VGND.n775 334.178
R2392 VGND.t644 VGND.t1178 333.334
R2393 VGND.t401 VGND.t402 332.37
R2394 VGND.n384 VGND.t397 332.336
R2395 VGND.n11 VGND.t1403 332.336
R2396 VGND.n283 VGND.t1581 330.947
R2397 VGND.n834 VGND.t718 330.947
R2398 VGND.n319 VGND.t1113 330.947
R2399 VGND.t795 VGND.n356 330.084
R2400 VGND.t266 VGND.n481 330
R2401 VGND.n794 VGND.t527 330
R2402 VGND.t279 VGND.t1023 330
R2403 VGND.n541 VGND.t1095 330
R2404 VGND.t0 VGND.n204 1.55743
R2405 VGND.n133 VGND.t161 66.1984
R2406 VGND.n134 VGND.t1275 167.082
R2407 VGND.t114 VGND.n350 329.168
R2408 VGND.n35 VGND.t1092 328.841
R2409 VGND.t382 VGND.n369 325.714
R2410 VGND.t816 VGND.n344 325.714
R2411 VGND.t1417 VGND.n336 325.714
R2412 VGND.t1261 VGND.n694 325.714
R2413 VGND.n729 VGND.t244 325.714
R2414 VGND.n664 VGND.t1108 325.714
R2415 VGND.t844 VGND.t21 322.197
R2416 VGND.n215 VGND.t1181 77.4658
R2417 VGND.t50 VGND.t1112 321.486
R2418 VGND.t1077 VGND.t933 321.43
R2419 VGND.t1582 VGND.n54 320.865
R2420 VGND.t378 VGND.n61 320.865
R2421 VGND.t30 VGND.t526 320.637
R2422 VGND.n119 VGND.t559 55.8107
R2423 VGND.t77 VGND.n232 12.2561
R2424 VGND.t70 VGND.n233 77.2391
R2425 VGND.t77 VGND.n144 12.2558
R2426 VGND.n142 VGND.t689 77.2374
R2427 VGND.n140 VGND.t249 77.2374
R2428 VGND.t0 VGND.n159 12.2558
R2429 VGND.n99 VGND.t862 162.888
R2430 VGND.n128 VGND.t585 64.5956
R2431 VGND.t139 VGND.n118 162.888
R2432 VGND.t1188 VGND.n673 320.271
R2433 VGND.t908 VGND.n536 320.271
R2434 VGND.t1397 VGND.n744 319.99
R2435 VGND.n744 VGND.t289 319.99
R2436 VGND.t962 VGND.n3 319.99
R2437 VGND.t986 VGND.n39 319.99
R2438 VGND.n34 VGND.t966 319.99
R2439 VGND.t35 VGND.t1540 182.036
R2440 VGND.t35 VGND.t1539 183.806
R2441 VGND.t1536 VGND.t35 182.042
R2442 VGND.n438 VGND.n202 321.962
R2443 VGND.t531 VGND.t1405 317.144
R2444 VGND.t10 VGND.n461 316.668
R2445 VGND.n414 VGND.t592 316.668
R2446 VGND.t788 VGND.t59 316.406
R2447 VGND.t4 VGND.t210 316.406
R2448 VGND.t1432 VGND.t1681 313.755
R2449 VGND.t468 VGND.n305 313.755
R2450 VGND.n474 VGND.t753 312.858
R2451 VGND.t766 VGND.n347 312.858
R2452 VGND.n488 VGND.t782 312.858
R2453 VGND.n763 VGND.t538 312.858
R2454 VGND.t132 VGND.n757 312.858
R2455 VGND.n754 VGND.t184 312.858
R2456 VGND.t778 VGND.n747 312.858
R2457 VGND.t178 VGND.n785 312.858
R2458 VGND.n819 VGND.t1567 312.858
R2459 VGND.t1000 VGND.n692 312.858
R2460 VGND.n727 VGND.t1085 312.858
R2461 VGND.t1548 VGND.n234 319.575
R2462 VGND.n240 VGND.t1273 328.56
R2463 VGND.n7 VGND.t450 312.745
R2464 VGND.t826 VGND.t95 312.5
R2465 VGND.t950 VGND.t940 312.5
R2466 VGND.t1375 VGND.t624 309.457
R2467 VGND.t1219 VGND.t1422 309.457
R2468 VGND.t1167 VGND.t965 308.572
R2469 VGND.t948 VGND.t951 308.572
R2470 VGND.t193 VGND.t50 0.669307
R2471 VGND.n221 VGND.t1223 5.27736
R2472 VGND.t200 VGND.t30 0.669513
R2473 VGND.t674 VGND.n835 305.159
R2474 VGND.t716 VGND.n269 305.159
R2475 VGND.n303 VGND.t641 305.159
R2476 VGND.t199 VGND.n295 305.159
R2477 VGND.t1005 VGND.n688 305.159
R2478 VGND.n391 VGND.t487 304.286
R2479 VGND.t213 VGND.n411 304.286
R2480 VGND.t546 VGND.n348 304.286
R2481 VGND.n344 VGND.t1433 304.286
R2482 VGND.t257 VGND.n336 304.286
R2483 VGND.t1339 VGND.t1443 304.286
R2484 VGND.t267 VGND.n480 304.286
R2485 VGND.n757 VGND.t1134 304.286
R2486 VGND.n700 VGND.t1564 304.286
R2487 VGND.n651 VGND.t455 304.286
R2488 VGND.t895 VGND.n611 304.286
R2489 VGND.t652 VGND.n320 300.861
R2490 VGND.t451 VGND.n644 300
R2491 VGND.n193 VGND.t361 172.076
R2492 VGND.t1640 VGND.t1374 296.562
R2493 VGND.t241 VGND.t1031 296.562
R2494 VGND.t196 VGND.t1563 295.714
R2495 VGND.n736 VGND.n733 295.714
R2496 VGND.n662 VGND.n661 295.714
R2497 VGND.t612 VGND.t746 293.579
R2498 VGND.t875 VGND.t870 293.579
R2499 VGND.n274 VGND.t49 292.264
R2500 VGND.t1247 VGND.n267 292.264
R2501 VGND.t615 VGND.n309 292.264
R2502 VGND.t379 VGND.t1365 292.209
R2503 VGND.n636 VGND.t865 291.514
R2504 VGND.t896 VGND.n465 291.43
R2505 VGND.n468 VGND.t472 291.43
R2506 VGND.t1668 VGND.n401 291.43
R2507 VGND.t74 VGND.n403 291.43
R2508 VGND.n411 VGND.t158 291.43
R2509 VGND.t306 VGND.n213 304.37
R2510 VGND.t274 VGND.n138 93.433
R2511 VGND.n369 VGND.t815 291.43
R2512 VGND.t1220 VGND.n245 291.43
R2513 VGND.t1355 VGND.t261 291.43
R2514 VGND.n485 VGND.t1637 291.43
R2515 VGND.t518 VGND.n476 291.43
R2516 VGND.t656 VGND.n789 291.43
R2517 VGND.t1388 VGND.n782 291.43
R2518 VGND.t1143 VGND.n813 291.43
R2519 VGND.t1250 VGND.n141 93.4328
R2520 VGND.t1269 VGND.n643 291.43
R2521 VGND.t1270 VGND.n543 291.43
R2522 VGND.t947 VGND.n543 291.43
R2523 VGND.n539 VGND.t1079 291.43
R2524 VGND.n668 VGND.t629 291.43
R2525 VGND.n639 VGND.t970 291.43
R2526 VGND.n54 VGND.t1348 290.779
R2527 VGND.t1078 VGND.n36 289.99
R2528 VGND.t663 VGND.t944 288.723
R2529 VGND.t89 VGND.t355 288.534
R2530 VGND.n278 VGND.t1329 287.966
R2531 VGND.t930 VGND.n327 287.966
R2532 VGND.t804 VGND.n470 287.144
R2533 VGND.t541 VGND.t1667 287.144
R2534 VGND.t767 VGND.n346 287.144
R2535 VGND.n249 VGND.t1229 287.144
R2536 VGND.n489 VGND.t781 287.144
R2537 VGND.n755 VGND.t183 287.144
R2538 VGND.t779 VGND.n746 287.144
R2539 VGND.t180 VGND.n784 287.144
R2540 VGND.n728 VGND.t1084 287.144
R2541 VGND.t1094 VGND.t220 284.519
R2542 VGND.t1264 VGND.t285 282.858
R2543 VGND.t1265 VGND.t287 282.858
R2544 VGND.t888 VGND.t974 282.858
R2545 VGND.t889 VGND.t975 282.858
R2546 VGND.t35 VGND.t1189 61.8302
R2547 VGND.t614 VGND.n191 174.839
R2548 VGND.n86 VGND.t501 68.096
R2549 VGND.t35 VGND.t507 174.839
R2550 VGND.t1123 VGND.n183 174.816
R2551 VGND.n181 VGND.t1622 174.839
R2552 VGND.n287 VGND.t1192 279.37
R2553 VGND.t1128 VGND.n392 278.572
R2554 VGND.t454 VGND.n542 278.572
R2555 VGND.t1572 VGND.t1068 278.572
R2556 VGND.t1069 VGND.t1054 278.572
R2557 VGND.t942 VGND.t1070 278.572
R2558 VGND.t492 VGND.n613 278.572
R2559 VGND.t1328 VGND.n50 277.885
R2560 VGND.t1448 VGND.n58 277.885
R2561 VGND.n2 VGND.t1569 277.132
R2562 VGND.n34 VGND.t1083 277.132
R2563 VGND.t1263 VGND.n615 277.132
R2564 VGND.t1350 VGND.n378 275.863
R2565 VGND.n380 VGND.t751 275.863
R2566 VGND.t1347 VGND.n829 275.863
R2567 VGND.n831 VGND.t1351 275.863
R2568 VGND.n127 VGND.t50 0.359454
R2569 VGND.n126 VGND.t30 0.359455
R2570 VGND.t1102 VGND.n800 275.863
R2571 VGND.t1101 VGND.n799 275.863
R2572 VGND.t26 VGND.n680 275.863
R2573 VGND.n706 VGND.t28 275.863
R2574 VGND.n739 VGND.t367 275.863
R2575 VGND.n658 VGND.t1212 275.863
R2576 VGND.t1098 VGND.n514 275.863
R2577 VGND.t1100 VGND.n513 275.863
R2578 VGND.t1099 VGND.n573 275.863
R2579 VGND.n575 VGND.t1097 275.863
R2580 VGND.t27 VGND.n598 275.863
R2581 VGND.n600 VGND.t23 275.863
R2582 VGND.n835 VGND.t1336 275.072
R2583 VGND.n324 VGND.t1349 275.072
R2584 VGND.n295 VGND.t1343 275.072
R2585 VGND.n688 VGND.t1308 275.072
R2586 VGND.n559 VGND.t1209 275.072
R2587 VGND.t992 VGND.t311 275.072
R2588 VGND.n717 VGND.t1195 274.286
R2589 VGND.t1627 VGND.n221 289.62
R2590 VGND.n51 VGND.t1370 273.587
R2591 VGND.t790 VGND.n51 273.587
R2592 VGND.t1624 VGND.n151 94.8677
R2593 VGND.n152 VGND.t1034 94.8677
R2594 VGND.n17 VGND.t474 104.716
R2595 VGND.t30 VGND.n147 10.4539
R2596 VGND.n189 VGND.t845 486.553
R2597 VGND.t1217 VGND.n22 272.846
R2598 VGND.n24 VGND.t386 272.846
R2599 VGND.t621 VGND.t1606 270.834
R2600 VGND.n271 VGND.t544 270.834
R2601 VGND.t318 VGND.t403 270.834
R2602 VGND.t1413 VGND.t1196 270
R2603 VGND.n772 VGND.n771 269.279
R2604 VGND.n779 VGND.n778 269.279
R2605 VGND.t435 VGND.n158 95.9749
R2606 VGND.t25 VGND.t452 269.183
R2607 VGND.n473 VGND.t1630 268.531
R2608 VGND.n358 VGND.t748 267.409
R2609 VGND.t1207 VGND.n549 267.409
R2610 VGND.t575 VGND.t1441 266.476
R2611 VGND.t1129 VGND.t571 266.476
R2612 VGND.t579 VGND.t1130 266.476
R2613 VGND.t1234 VGND.t198 266.476
R2614 VGND.t125 VGND.t1633 266.476
R2615 VGND.t383 VGND.t732 265.714
R2616 VGND.t1281 VGND.t206 265.714
R2617 VGND.t833 VGND.t1154 265.714
R2618 VGND.t822 VGND.t243 265.714
R2619 VGND.t934 VGND.t416 265.714
R2620 VGND.t1107 VGND.t939 265.714
R2621 VGND.n39 VGND.t987 264.274
R2622 VGND.t768 VGND.n345 261.43
R2623 VGND.n490 VGND.t777 261.43
R2624 VGND.n756 VGND.t182 261.43
R2625 VGND.t780 VGND.n745 261.43
R2626 VGND.t1620 VGND.n156 273.892
R2627 VGND.t1615 VGND.n170 273.892
R2628 VGND.n169 VGND.t1236 273.892
R2629 VGND.t765 VGND.n235 162.68
R2630 VGND.n112 VGND.t1311 79.0594
R2631 VGND.t497 VGND.n460 258.334
R2632 VGND.n415 VGND.t75 258.334
R2633 VGND.n355 VGND.t224 258.334
R2634 VGND.t475 VGND.t610 258.334
R2635 VGND.t479 VGND.n374 258.334
R2636 VGND.t636 VGND.t445 258.334
R2637 VGND.t108 VGND.t398 258.334
R2638 VGND.t440 VGND.t786 258.334
R2639 VGND.t1421 VGND.n797 258.334
R2640 VGND.t1299 VGND.n710 258.334
R2641 VGND.t584 VGND.n511 258.334
R2642 VGND.n560 VGND.t993 258.334
R2643 VGND.t1605 VGND.t735 258.334
R2644 VGND.t799 VGND.n580 258.334
R2645 VGND.t957 VGND.t92 258.334
R2646 VGND.t1404 VGND.t821 258.334
R2647 VGND.t1042 VGND.n605 258.334
R2648 VGND.t315 VGND.n325 257.88
R2649 VGND.t1327 VGND.n312 257.88
R2650 VGND.n297 VGND.n292 257.88
R2651 VGND.n701 VGND.n686 257.88
R2652 VGND.t1666 VGND.n404 257.144
R2653 VGND.t869 VGND.n340 257.144
R2654 VGND.n367 VGND.t387 257.144
R2655 VGND.n817 VGND.t852 257.144
R2656 VGND.t791 VGND.n809 257.144
R2657 VGND.n725 VGND.t521 257.144
R2658 VGND.n645 VGND.t1104 257.144
R2659 VGND.t1585 VGND.n525 257.144
R2660 VGND.t1306 VGND.n586 257.144
R2661 VGND.t1012 VGND.t1048 254.718
R2662 VGND.t673 VGND.t691 254.718
R2663 VGND.t480 VGND.n333 254.31
R2664 VGND.t1456 VGND.n332 254.31
R2665 VGND.n832 VGND.t284 254.31
R2666 VGND.n801 VGND.t725 254.31
R2667 VGND.n803 VGND.t1420 254.31
R2668 VGND.n707 VGND.t1300 254.31
R2669 VGND.t1029 VGND.n705 254.31
R2670 VGND.n515 VGND.t923 254.31
R2671 VGND.n517 VGND.t583 254.31
R2672 VGND.t342 VGND.n572 254.31
R2673 VGND.n576 VGND.t798 254.31
R2674 VGND.t1 VGND.n15 265.065
R2675 VGND.n601 VGND.t1041 254.31
R2676 VGND.n165 VGND.t1346 253.906
R2677 VGND.n78 VGND.t1345 253.906
R2678 VGND.t1330 VGND.t658 253.583
R2679 VGND.t1440 VGND.t1575 253.583
R2680 VGND.n288 VGND.t1193 253.583
R2681 VGND.n289 VGND.t577 253.583
R2682 VGND.t1127 VGND.n391 252.857
R2683 VGND.t836 VGND.n765 252.857
R2684 VGND.t1377 VGND.t626 252.857
R2685 VGND.n622 VGND.t493 252.857
R2686 VGND.t77 VGND.t1519 252.066
R2687 VGND.n48 VGND.t1502 108.639
R2688 VGND.t0 VGND.n234 9.63524
R2689 VGND.n19 VGND.t1526 251.417
R2690 VGND.t860 VGND.t188 251.351
R2691 VGND.t301 VGND.t564 251.351
R2692 VGND.t334 VGND.n136 257.877
R2693 VGND.t138 VGND.t667 251.351
R2694 VGND.t414 VGND.t832 251.351
R2695 VGND.t827 VGND.t239 251.351
R2696 VGND.t1272 VGND.t941 251.351
R2697 VGND.t938 VGND.t953 251.351
R2698 VGND.n463 VGND.t110 250.952
R2699 VGND.t1275 VGND.n412 250.952
R2700 VGND.t609 VGND.n349 250.952
R2701 VGND.t94 VGND.n159 255.048
R2702 VGND.n570 VGND.n569 250.696
R2703 VGND.t409 VGND.t898 250
R2704 VGND.t185 VGND.t788 250
R2705 VGND.t210 VGND.t127 250
R2706 VGND.t1661 VGND.t389 249.538
R2707 VGND.t77 VGND.t1662 249.522
R2708 VGND.t310 VGND.n557 249.285
R2709 VGND.n233 VGND.t862 253.246
R2710 VGND.n743 VGND.t139 249.151
R2711 VGND.n389 VGND.t7 249.002
R2712 VGND.t1013 VGND.n8 249.002
R2713 VGND.t441 VGND.n12 249.002
R2714 VGND.t1588 VGND.t723 248.571
R2715 VGND.t446 VGND.t1227 246.351
R2716 VGND.t1659 VGND.t484 246.351
R2717 VGND.t1543 VGND.t477 245.833
R2718 VGND.n272 VGND.t545 245.833
R2719 VGND.t1379 VGND.t711 245.833
R2720 VGND.t313 VGND.t1133 245.833
R2721 VGND.t1353 VGND.t1044 245.833
R2722 VGND.t701 VGND.t461 245.833
R2723 VGND.t19 VGND.t469 245.833
R2724 VGND.n315 VGND.n314 244.987
R2725 VGND.t1360 VGND.t1376 244.286
R2726 VGND.t1206 VGND.t1561 244.286
R2727 VGND.t1638 VGND.t1562 244.286
R2728 VGND.t1492 VGND.t30 109.987
R2729 VGND.n139 VGND.t347 93.3947
R2730 VGND.t708 VGND.n129 93.3947
R2731 VGND.n136 VGND.t30 9.79177
R2732 VGND.n20 VGND.t1534 242.846
R2733 VGND.t391 VGND.t1544 241.667
R2734 VGND.t710 VGND.t1416 241.667
R2735 VGND.t314 VGND.t1201 241.667
R2736 VGND.t1043 VGND.t772 241.667
R2737 VGND.t700 VGND.t1604 241.667
R2738 VGND.t18 VGND.t887 241.667
R2739 VGND.t168 VGND.n164 139.087
R2740 VGND.n168 VGND.t1151 379.442
R2741 VGND.t328 VGND.n131 379.442
R2742 VGND.t1191 VGND.t783 240
R2743 VGND.n48 VGND.t1230 238.84
R2744 VGND.t217 VGND.t886 237.5
R2745 VGND.t344 VGND.t883 237.5
R2746 VGND.t1182 VGND.n424 236.453
R2747 VGND.n446 VGND.t1338 236.453
R2748 VGND.n407 VGND.t1533 235.714
R2749 VGND.t77 VGND.t1521 108.993
R2750 VGND.t77 VGND.t1523 108.984
R2751 VGND.t57 VGND.t207 235.714
R2752 VGND.n160 VGND.t30 12.256
R2753 VGND.t1482 VGND.n35 108.635
R2754 VGND.t0 VGND.t1461 108.993
R2755 VGND.t0 VGND.t1464 108.993
R2756 VGND.t22 VGND.n459 233.333
R2757 VGND.n416 VGND.t281 233.333
R2758 VGND.t319 VGND.n334 233.333
R2759 VGND.n804 VGND.t1305 233.333
R2760 VGND.t743 VGND.n709 233.333
R2761 VGND.n518 VGND.t1253 233.333
R2762 VGND.t457 VGND.n579 233.333
R2763 VGND.t920 VGND.n604 233.333
R2764 VGND.n439 VGND.n93 231.573
R2765 VGND.n496 VGND.t1144 231.429
R2766 VGND.t754 VGND.t1160 231.429
R2767 VGND.n435 VGND.n90 230.51
R2768 VGND.t1549 VGND.t1324 229.167
R2769 VGND.t1682 VGND.t1550 229.167
R2770 VGND.t21 VGND.t495 229.118
R2771 VGND.t1664 VGND.t1663 229.118
R2772 VGND.t437 VGND.t1038 229.118
R2773 VGND.n223 VGND.t845 245.287
R2774 VGND.t1280 VGND.t1180 228.782
R2775 VGND.t1176 VGND.n503 228.782
R2776 VGND.n630 VGND.t407 228.782
R2777 VGND.n500 VGND.n499 227.56
R2778 VGND.n631 VGND.n627 227.56
R2779 VGND.t385 VGND.t809 227.143
R2780 VGND.n27 VGND.t1527 243.171
R2781 VGND.t77 VGND.t1522 109.986
R2782 VGND.n251 VGND.t1503 227.143
R2783 VGND.t50 VGND.t1506 109.986
R2784 VGND.t264 VGND.t1318 227.143
R2785 VGND.n240 VGND.t1467 242.846
R2786 VGND.t0 VGND.t1462 109.986
R2787 VGND.t763 VGND.n671 227.028
R2788 VGND.n678 VGND.t1026 227.028
R2789 VGND.t337 VGND.n534 227.028
R2790 VGND.n656 VGND.t1105 227.028
R2791 VGND.t859 VGND.t802 225.627
R2792 VGND.t177 VGND.n198 155.252
R2793 VGND.t236 VGND.n185 155.252
R2794 VGND.t35 VGND.n182 0.980585
R2795 VGND.n190 VGND.t35 5.11497
R2796 VGND.t35 VGND.n203 0.980641
R2797 VGND.n215 VGND.t926 227.593
R2798 VGND.n472 VGND.t807 222.857
R2799 VGND.t1611 VGND.t1190 222.857
R2800 VGND.n214 VGND.t1509 103.004
R2801 VGND.t25 VGND.n124 96.0412
R2802 VGND.n167 VGND.t551 60.3195
R2803 VGND.t960 VGND.n166 40.3451
R2804 VGND.t77 VGND.n27 0.325637
R2805 VGND.n47 VGND.t1504 221.417
R2806 VGND.n87 VGND.t1672 220.464
R2807 VGND.n95 VGND.t228 220.464
R2808 VGND.n77 VGND.t1151 220.464
R2809 VGND.t328 VGND.n80 220.464
R2810 VGND.t1426 VGND.t1398 219.198
R2811 VGND.t1447 VGND.t1325 214.9
R2812 VGND.n441 VGND.t769 214.286
R2813 VGND.t1082 VGND.t1142 214.286
R2814 VGND.n774 VGND.t380 212.389
R2815 VGND.t1241 VGND.n776 212.389
R2816 VGND.t985 VGND.t208 210
R2817 VGND.t949 VGND.t1006 210
R2818 VGND.t352 VGND.n551 209.933
R2819 VGND.n567 VGND.t1245 209.933
R2820 VGND.t1173 VGND.t379 207.792
R2821 VGND.t47 VGND.n670 206.898
R2822 VGND.t1285 VGND.n533 206.898
R2823 VGND.t897 VGND.n628 206.643
R2824 VGND.t817 VGND.t872 206.423
R2825 VGND.t607 VGND.t1412 206.423
R2826 VGND.n214 VGND.t694 214.168
R2827 VGND.n27 VGND.t1535 110.704
R2828 VGND.t136 VGND.t490 205.714
R2829 VGND.t77 VGND.t1530 111.02
R2830 VGND.t1474 VGND.t25 111.02
R2831 VGND.t1463 VGND.t0 110.709
R2832 VGND.t1472 VGND.n210 102.707
R2833 VGND.n93 VGND.t80 201.87
R2834 VGND.t189 VGND.t528 201.429
R2835 VGND.n146 VGND.t50 86.9811
R2836 VGND.t50 VGND.t1516 201.143
R2837 VGND.t77 VGND.t1524 109.986
R2838 VGND.t1481 VGND.t25 109.96
R2839 VGND.t1465 VGND.t0 109.986
R2840 VGND.t1527 VGND.n20 199.989
R2841 VGND.n635 VGND.t300 199.656
R2842 VGND.t1267 VGND.t998 197.143
R2843 VGND.t999 VGND.t651 197.143
R2844 VGND.n359 VGND.n358 196.38
R2845 VGND.t1226 VGND.t60 196.297
R2846 VGND.t5 VGND.t1658 196.297
R2847 VGND.t130 VGND.t1424 192.857
R2848 VGND.n146 VGND.t1515 22.3041
R2849 VGND.t1507 VGND.t50 192.548
R2850 VGND.t1171 VGND.n229 206.998
R2851 VGND.t1505 VGND.t50 108.993
R2852 VGND.t1491 VGND.t30 108.993
R2853 VGND.t1480 VGND.n124 12.9755
R2854 VGND.n387 VGND.t639 191.667
R2855 VGND.n594 VGND.t916 191.667
R2856 VGND.t1533 VGND.n19 191.417
R2857 VGND.t1214 VGND.t1547 190.952
R2858 VGND.t523 VGND.t84 190.952
R2859 VGND.t245 VGND.t421 190.952
R2860 VGND.t39 VGND.t776 190.952
R2861 VGND.t340 VGND.t135 190.952
R2862 VGND.t408 VGND.t271 189.633
R2863 VGND.n457 VGND.t12 188.811
R2864 VGND.t1230 VGND.n248 188.571
R2865 VGND.t623 VGND.t1080 188.571
R2866 VGND.t277 VGND.t1483 188.571
R2867 VGND.n624 VGND.t973 188.571
R2868 VGND.t1551 VGND.n84 186.174
R2869 VGND.t412 VGND.n69 186.174
R2870 VGND.n76 VGND.t757 186.174
R2871 VGND.n276 VGND.n270 184.815
R2872 VGND.t1199 VGND.n202 134.572
R2873 VGND.n440 VGND.t1553 184.73
R2874 VGND.n200 VGND.t1204 134.572
R2875 VGND.t516 VGND.n184 134.572
R2876 VGND.n448 VGND.t542 184.73
R2877 VGND.t590 VGND.t808 184.286
R2878 VGND.t305 VGND.t405 184.286
R2879 VGND.t811 VGND.t1669 184.286
R2880 VGND.t867 VGND.t162 184.286
R2881 VGND.n390 VGND.t8 184.286
R2882 VGND.t1534 VGND.n381 184.286
R2883 VGND.n340 VGND.t1520 184.286
R2884 VGND.t1503 VGND.n248 184.286
R2885 VGND.t1483 VGND.n641 184.286
R2886 VGND.n547 VGND.t1467 184.286
R2887 VGND.t81 VGND.t0 1.71467
R2888 VGND.t991 VGND.t1012 181.132
R2889 VGND.t691 VGND.t1037 181.132
R2890 VGND.n827 VGND.t6 181.035
R2891 VGND.t976 VGND.t913 180
R2892 VGND.n452 VGND.t111 179.167
R2893 VGND.t1639 VGND.t1556 177.779
R2894 VGND.t420 VGND.t240 177.779
R2895 VGND.t222 VGND.t1661 177.45
R2896 VGND.t805 VGND.t157 175.714
R2897 VGND.t1526 VGND.n381 175.714
R2898 VGND.t1466 VGND.n234 99.5818
R2899 VGND.t1227 VGND.t1641 175.183
R2900 VGND.t242 VGND.t1659 175.183
R2901 VGND.n458 VGND.t1293 175
R2902 VGND.n676 VGND.t46 174.325
R2903 VGND.n654 VGND.t1284 174.325
R2904 VGND.n89 VGND.n436 172.167
R2905 VGND.t854 VGND.n815 171.875
R2906 VGND.n60 VGND.t315 170.435
R2907 VGND.t157 VGND.n393 169.989
R2908 VGND.n405 VGND.t1666 169.989
R2909 VGND.n406 VGND.t385 169.989
R2910 VGND.n18 VGND.t869 169.989
R2911 VGND.t1221 VGND.n1 104.718
R2912 VGND.t619 VGND.n201 184.661
R2913 VGND.t770 VGND.n428 169.952
R2914 VGND.n230 VGND.t620 138.269
R2915 VGND.t368 VGND.n738 168.103
R2916 VGND.t1208 VGND.n531 168.103
R2917 VGND.n314 VGND.n313 167.623
R2918 VGND.t784 VGND.t1177 166.877
R2919 VGND.n460 VGND.t22 166.667
R2920 VGND.t281 VGND.n415 166.667
R2921 VGND.n374 VGND.t319 166.667
R2922 VGND.t7 VGND.n388 166.667
R2923 VGND.t1324 VGND.n255 166.667
R2924 VGND.t1305 VGND.n797 166.667
R2925 VGND.n710 VGND.t743 166.667
R2926 VGND.t1253 VGND.n511 166.667
R2927 VGND.n560 VGND.t1013 166.667
R2928 VGND.n580 VGND.t457 166.667
R2929 VGND.n593 VGND.t441 166.667
R2930 VGND.n605 VGND.t920 166.667
R2931 VGND.t555 VGND.n87 166.356
R2932 VGND.t41 VGND.n95 166.356
R2933 VGND.t899 VGND.n77 166.356
R2934 VGND.n80 VGND.t326 166.356
R2935 VGND.t226 VGND.n339 162.562
R2936 VGND.n370 VGND.t226 162.562
R2937 VGND.n139 VGND.t536 257.877
R2938 VGND.n136 VGND.t707 93.3947
R2939 VGND.t1545 VGND.n129 257.877
R2940 VGND.t1026 VGND.n671 162.162
R2941 VGND.t1105 VGND.n534 162.162
R2942 VGND.t1193 VGND.n287 159.026
R2943 VGND.t577 VGND.n286 159.026
R2944 VGND.t576 VGND.n330 159.026
R2945 VGND.n392 VGND.t1127 158.571
R2946 VGND.t1442 VGND.t1657 158.571
R2947 VGND.t434 VGND.n158 284.634
R2948 VGND.t256 VGND.t1008 156.25
R2949 VGND.n434 VGND.t1617 155.941
R2950 VGND.t638 VGND.n632 154.982
R2951 VGND.t1370 VGND.n268 154.728
R2952 VGND.n275 VGND.t790 154.728
R2953 VGND.t1410 VGND.n290 154.728
R2954 VGND.n465 VGND.t305 154.286
R2955 VGND.t1669 VGND.n468 154.286
R2956 VGND.t490 VGND.n408 154.286
R2957 VGND.n343 VGND.n342 154.286
R2958 VGND.n338 VGND.n337 154.286
R2959 VGND.t1657 VGND.n246 154.286
R2960 VGND.t1318 VGND.n483 154.286
R2961 VGND.n478 VGND.t1611 154.286
R2962 VGND.n793 VGND.t189 154.286
R2963 VGND.t520 VGND.n147 94.8676
R2964 VGND.t373 VGND.n151 387.327
R2965 VGND.t1402 VGND.n717 154.286
R2966 VGND.t1104 VGND.n642 154.286
R2967 VGND.n152 VGND.t1003 413.041
R2968 VGND.t906 VGND.n542 154.286
R2969 VGND.n650 VGND.t949 154.286
R2970 VGND.t1091 VGND.n546 154.286
R2971 VGND.t458 VGND.n545 154.286
R2972 VGND.t493 VGND.t891 154.286
R2973 VGND.t246 VGND.t63 154.286
R2974 VGND.n372 VGND.t1214 154.167
R2975 VGND.n382 VGND.t444 154.167
R2976 VGND.t439 VGND.n272 154.167
R2977 VGND.t84 VGND.n795 154.167
R2978 VGND.t421 VGND.n715 154.167
R2979 VGND.n509 VGND.t98 154.167
R2980 VGND.n564 VGND.t736 154.167
R2981 VGND.t776 VGND.n584 154.167
R2982 VGND.n591 VGND.t94 154.167
R2983 VGND.t135 VGND.n609 154.167
R2984 VGND.n127 VGND.t1331 100.582
R2985 VGND.n130 VGND.t29 100.585
R2986 VGND.n49 VGND.t536 153.474
R2987 VGND.n821 VGND.t334 153.474
R2988 VGND.n742 VGND.t1545 153.474
R2989 VGND.t1209 VGND.n9 153.243
R2990 VGND.n499 VGND.t784 151.708
R2991 VGND.t380 VGND.n773 151.708
R2992 VGND.n777 VGND.t1241 151.708
R2993 VGND.n634 VGND.t912 151.708
R2994 VGND.n278 VGND.t1328 150.43
R2995 VGND.n308 VGND.t1448 150.43
R2996 VGND.n457 VGND.n456 150
R2997 VGND.t807 VGND.t498 150
R2998 VGND.n451 VGND.n417 150
R2999 VGND.t302 VGND.n128 162.888
R3000 VGND.n784 VGND.t181 150
R3001 VGND.n781 VGND.t1425 150
R3002 VGND.t852 VGND.t1164 150
R3003 VGND.t1569 VGND.n809 150
R3004 VGND.t998 VGND.n691 150
R3005 VGND.t1080 VGND.n728 150
R3006 VGND.t1083 VGND.n523 150
R3007 VGND.t1088 VGND.t1306 150
R3008 VGND.n616 VGND.t1263 150
R3009 VGND.n10 VGND.t1207 149.377
R3010 VGND.t1289 VGND.n172 162.607
R3011 VGND.t1621 VGND.n175 162.607
R3012 VGND.t606 VGND.n173 162.607
R3013 VGND.t709 VGND.n178 162.607
R3014 VGND.n57 VGND.n297 148.851
R3015 VGND.n701 VGND.n29 148.851
R3016 VGND.n298 VGND.t1226 148.149
R3017 VGND.t1658 VGND.n685 148.149
R3018 VGND.n236 VGND.t503 161.649
R3019 VGND.t234 VGND.n179 125.862
R3020 VGND.n630 VGND.t897 147.601
R3021 VGND.t872 VGND.t225 146.79
R3022 VGND.t1412 VGND.t1438 146.79
R3023 VGND.n678 VGND.n677 145.946
R3024 VGND.n656 VGND.n655 145.946
R3025 VGND.t1519 VGND.t814 145.714
R3026 VGND.n832 VGND.t547 144.624
R3027 VGND.t166 VGND.n199 114.002
R3028 VGND.n203 VGND.t1607 114.01
R3029 VGND.n82 VGND.t376 141.839
R3030 VGND.n461 VGND.t497 141.667
R3031 VGND.t75 VGND.n414 141.667
R3032 VGND.t639 VGND.n386 141.667
R3033 VGND.n258 VGND.t1682 141.667
R3034 VGND.t993 VGND.n554 141.667
R3035 VGND.t734 VGND.n563 141.667
R3036 VGND.t916 VGND.n589 141.667
R3037 VGND.t181 VGND.t900 141.429
R3038 VGND.t973 VGND.t894 141.429
R3039 VGND.n504 VGND.t1176 140.974
R3040 VGND.n501 VGND.t1222 140.974
R3041 VGND.t1458 VGND.t1126 140.625
R3042 VGND.n444 VGND.t515 140.394
R3043 VGND.n824 VGND.t721 140.394
R3044 VGND.n379 VGND.t1350 137.931
R3045 VGND.t751 VGND.n379 137.931
R3046 VGND.n830 VGND.t1347 137.931
R3047 VGND.t1351 VGND.n830 137.931
R3048 VGND.n802 VGND.t1102 137.931
R3049 VGND.n802 VGND.t1101 137.931
R3050 VGND.n681 VGND.t26 137.931
R3051 VGND.t28 VGND.n681 137.931
R3052 VGND.t367 VGND.n679 137.931
R3053 VGND.n739 VGND.t368 137.931
R3054 VGND.t1212 VGND.n532 137.931
R3055 VGND.n658 VGND.t1208 137.931
R3056 VGND.n516 VGND.t1098 137.931
R3057 VGND.n516 VGND.t1100 137.931
R3058 VGND.n574 VGND.t1099 137.931
R3059 VGND.t1097 VGND.n574 137.931
R3060 VGND.n599 VGND.t27 137.931
R3061 VGND.t23 VGND.n599 137.931
R3062 VGND.t46 VGND.n672 137.839
R3063 VGND.n675 VGND.t122 137.839
R3064 VGND.t1284 VGND.n535 137.839
R3065 VGND.n653 VGND.t909 137.839
R3066 VGND.n257 VGND.t1336 137.536
R3067 VGND.t1343 VGND.n294 137.536
R3068 VGND.t1308 VGND.n687 137.536
R3069 VGND.t399 VGND.t879 137.5
R3070 VGND.n807 VGND.n806 137.5
R3071 VGND.n521 VGND.n520 137.5
R3072 VGND.n582 VGND.n581 137.5
R3073 VGND.n595 VGND.t925 137.5
R3074 VGND.n607 VGND.n606 137.5
R3075 VGND.n697 VGND.t1206 137.143
R3076 VGND.t1195 VGND.n716 137.143
R3077 VGND.n644 VGND.t1078 137.143
R3078 VGND.t459 VGND.t1091 137.143
R3079 VGND.t977 VGND.t458 137.143
R3080 VGND.n498 VGND.t1627 136.915
R3081 VGND.t1282 VGND.n505 136.531
R3082 VGND.t0 VGND.t459 136.327
R3083 VGND.t77 VGND.n138 1.0478
R3084 VGND.t900 VGND.t30 136.327
R3085 VGND.t77 VGND.t590 136.327
R3086 VGND.t162 VGND.t77 136.327
R3087 VGND.t30 VGND.n141 1.04758
R3088 VGND.t0 VGND.t977 136.327
R3089 VGND.n169 VGND.t35 3.26622
R3090 VGND.n115 VGND.t1169 106.858
R3091 VGND.t35 VGND.n170 3.26622
R3092 VGND.n156 VGND.t1673 106.858
R3093 VGND.t758 VGND.n56 136.05
R3094 VGND.t158 VGND.n26 135.703
R3095 VGND.t815 VGND.n368 135.703
R3096 VGND.t1424 VGND.n2 135.703
R3097 VGND.t432 VGND.n551 135.44
R3098 VGND.n567 VGND.t221 135.44
R3099 VGND.t748 VGND.n357 133.706
R3100 VGND.n375 VGND.n335 133.333
R3101 VGND.n713 VGND.n712 133.333
R3102 VGND.n833 VGND.t1192 133.238
R3103 VGND.t1117 VGND.t1327 133.238
R3104 VGND.n648 VGND.t454 132.857
R3105 VGND.t1073 VGND.t1585 132.857
R3106 VGND.n638 VGND.t434 132.857
R3107 VGND.n621 VGND.t492 132.857
R3108 VGND.n633 VGND.n631 132.841
R3109 VGND.n222 VGND.t544 144.835
R3110 VGND.t1175 VGND.n772 128.952
R3111 VGND.n778 VGND.t1358 128.952
R3112 VGND.t271 VGND.n627 128.952
R3113 VGND.t1194 VGND.t1507 128.94
R3114 VGND.t1196 VGND.t25 127.755
R3115 VGND.t988 VGND.t901 126.022
R3116 VGND.n299 VGND.t1639 125.927
R3117 VGND.t240 VGND.n684 125.927
R3118 VGND.n442 VGND.t509 125.617
R3119 VGND.t488 VGND.n187 113.177
R3120 VGND.t407 VGND.n629 125.462
R3121 VGND.n568 VGND.t1599 125.349
R3122 VGND.t657 VGND.t1458 125.001
R3123 VGND.t1329 VGND.n266 124.642
R3124 VGND.n328 VGND.t930 124.642
R3125 VGND.n309 VGND.t1447 124.642
R3126 VGND.t956 VGND.t1217 124.287
R3127 VGND.t386 VGND.t348 124.287
R3128 VGND.n471 VGND.t804 124.287
R3129 VGND.n347 VGND.t767 124.287
R3130 VGND.t818 VGND.t566 124.287
R3131 VGND.t6 VGND.t1665 124.287
R3132 VGND.n250 VGND.t1229 124.287
R3133 VGND.t781 VGND.n488 124.287
R3134 VGND.n819 VGND.t1568 124.287
R3135 VGND.t331 VGND.t1179 124.287
R3136 VGND.n668 VGND.t1082 124.287
R3137 VGND.t654 VGND.t1677 124.287
R3138 VGND.n617 VGND.t1264 124.287
R3139 VGND.n625 VGND.t976 124.287
R3140 VGND.t35 VGND.n175 2.92707
R3141 VGND.t327 VGND.n172 98.8788
R3142 VGND.n173 VGND.t1674 98.8788
R3143 VGND.t35 VGND.n178 2.92705
R3144 VGND.n566 VGND.t431 121.897
R3145 VGND.n569 VGND.n550 121.897
R3146 VGND.t1630 VGND.t282 121.678
R3147 VGND.t455 VGND.n537 121.496
R3148 VGND.n773 VGND.t372 121.365
R3149 VGND.t371 VGND.n777 121.365
R3150 VGND.n112 VGND.t912 217.589
R3151 VGND.n568 VGND.t353 121.171
R3152 VGND.t49 VGND.n268 120.344
R3153 VGND.n275 VGND.t1247 120.344
R3154 VGND.t554 VGND.n236 97.9134
R3155 VGND.t35 VGND.n180 2.1402
R3156 VGND.t35 VGND.n196 2.14019
R3157 VGND.n466 VGND.t896 120.001
R3158 VGND.t472 VGND.n467 120.001
R3159 VGND.t1667 VGND.n396 120.001
R3160 VGND.n402 VGND.t1668 120.001
R3161 VGND.n404 VGND.t74 120.001
R3162 VGND.n241 VGND.t306 135.703
R3163 VGND.n253 VGND.t1220 120.001
R3164 VGND.n477 VGND.t518 120.001
R3165 VGND.n790 VGND.t656 120.001
R3166 VGND.t659 VGND.n727 120.001
R3167 VGND.t208 VGND.n718 120.001
R3168 VGND.n562 VGND.t1064 117.156
R3169 VGND.t188 VGND.n49 116.987
R3170 VGND.t564 VGND.n821 116.987
R3171 VGND.t667 VGND.n742 116.987
R3172 VGND.n736 VGND.n732 115.715
R3173 VGND.t1079 VGND.t952 115.715
R3174 VGND.n661 VGND.n529 115.715
R3175 VGND.t400 VGND.t104 115.608
R3176 VGND.n566 VGND.t352 115.124
R3177 VGND.t1245 VGND.n550 115.124
R3178 VGND.t1283 VGND.t643 114.391
R3179 VGND.t643 VGND.t761 114.391
R3180 VGND.n46 VGND.t1442 114.275
R3181 VGND.n37 VGND.t1001 114.275
R3182 VGND.t372 VGND.t1175 113.781
R3183 VGND.t1358 VGND.t371 113.781
R3184 VGND.t481 VGND.t320 112.019
R3185 VGND.t482 VGND.t392 112.019
R3186 VGND.t283 VGND.t151 112.019
R3187 VGND.t876 VGND.t323 112.019
R3188 VGND.t901 VGND.t1635 112.019
R3189 VGND.t1304 VGND.t1419 112.019
R3190 VGND.t85 VGND.t1315 112.019
R3191 VGND.t44 VGND.t543 112.019
R3192 VGND.t562 VGND.t247 112.019
R3193 VGND.t744 VGND.t1301 112.019
R3194 VGND.t423 VGND.t705 112.019
R3195 VGND.t1252 VGND.t582 112.019
R3196 VGND.t557 VGND.t1631 112.019
R3197 VGND.t456 VGND.t797 112.019
R3198 VGND.t321 VGND.t390 112.019
R3199 VGND.t443 VGND.t87 112.019
R3200 VGND.t919 VGND.t1040 112.019
R3201 VGND.t140 VGND.t843 112.019
R3202 VGND.n698 VGND.t1638 111.43
R3203 VGND.n143 VGND.t451 125.846
R3204 VGND.t275 VGND.n431 111.386
R3205 VGND.t35 VGND.t307 108.791
R3206 VGND.t35 VGND.t233 108.791
R3207 VGND.t35 VGND.t231 108.791
R3208 VGND.t35 VGND.t506 108.79
R3209 VGND.t1386 VGND.t609 108.334
R3210 VGND.n270 VGND.t716 107.451
R3211 VGND.n834 VGND.t1129 107.451
R3212 VGND.n289 VGND.t1194 107.451
R3213 VGND.t1130 VGND.n326 107.451
R3214 VGND.n326 VGND.t378 107.451
R3215 VGND.t641 VGND.n290 107.451
R3216 VGND.t808 VGND.n463 107.144
R3217 VGND.n469 VGND.t867 107.144
R3218 VGND.t487 VGND.n390 107.144
R3219 VGND.t1433 VGND.n343 107.144
R3220 VGND.n337 VGND.t257 107.144
R3221 VGND.t1232 VGND.n144 77.2374
R3222 VGND.t818 VGND.n137 64.096
R3223 VGND.t186 VGND.n232 77.2391
R3224 VGND.t1676 VGND.n247 107.144
R3225 VGND.n497 VGND.n495 107.144
R3226 VGND.n481 VGND.t267 107.144
R3227 VGND.n771 VGND.n741 107.144
R3228 VGND.t1376 VGND.n741 107.144
R3229 VGND.t1134 VGND.n756 107.144
R3230 VGND.n745 VGND.t1397 107.144
R3231 VGND.t289 VGND.n743 107.144
R3232 VGND.n160 VGND.t436 77.2385
R3233 VGND.n242 VGND.t962 122.078
R3234 VGND.t1160 VGND.n813 107.144
R3235 VGND.t1254 VGND.n690 107.144
R3236 VGND.t1564 VGND.n699 107.144
R3237 VGND.n737 VGND.n735 107.144
R3238 VGND.t521 VGND.t980 107.144
R3239 VGND.n718 VGND.t986 107.144
R3240 VGND.n660 VGND.n659 107.144
R3241 VGND.t1068 VGND.n527 107.144
R3242 VGND.n669 VGND.t966 107.144
R3243 VGND.t1087 VGND.n157 77.2385
R3244 VGND.t929 VGND.n159 77.2374
R3245 VGND.n154 VGND.t340 64.0962
R3246 VGND.n624 VGND.t895 107.144
R3247 VGND.t913 VGND.n610 107.144
R3248 VGND.t395 VGND.t152 106.614
R3249 VGND.n132 VGND.t329 90.4096
R3250 VGND.t747 VGND.n92 253.906
R3251 VGND.t1671 VGND.n149 90.4096
R3252 VGND.t229 VGND.n165 90.4096
R3253 VGND.t30 VGND.t834 105.308
R3254 VGND.t450 VGND.n553 104.603
R3255 VGND.n565 VGND.t1094 104.603
R3256 VGND.t223 VGND.t731 104.457
R3257 VGND.n570 VGND.t1599 104.457
R3258 VGND.t886 VGND.n462 104.168
R3259 VGND.n413 VGND.t344 104.168
R3260 VGND.t1380 VGND.n355 104.168
R3261 VGND.n353 VGND.t475 104.168
R3262 VGND.n385 VGND.t636 104.168
R3263 VGND.t202 VGND.t1279 104.168
R3264 VGND.n592 VGND.t957 104.168
R3265 VGND.n437 VGND.t33 103.96
R3266 VGND.t594 VGND.n433 103.448
R3267 VGND.t1120 VGND.n425 103.448
R3268 VGND.n447 VGND.t1147 103.448
R3269 VGND.t296 VGND.t1128 102.858
R3270 VGND.n496 VGND.t785 102.858
R3271 VGND.n454 VGND.n453 102.18
R3272 VGND.t298 VGND.t297 101.562
R3273 VGND.n674 VGND.t414 101.352
R3274 VGND.t239 VGND.n672 101.352
R3275 VGND.n652 VGND.t1272 101.352
R3276 VGND.t953 VGND.n535 101.352
R3277 VGND.t1614 VGND.n438 101.124
R3278 VGND.n360 VGND.n359 100.279
R3279 VGND.n563 VGND.t932 100.001
R3280 VGND.n171 VGND.t330 114.987
R3281 VGND.t1670 VGND.n176 114.987
R3282 VGND.t230 VGND.n174 114.987
R3283 VGND.n279 VGND.t1330 98.8544
R3284 VGND.n310 VGND.t1446 98.8544
R3285 VGND.n472 VGND.t753 98.5719
R3286 VGND.n348 VGND.t766 98.5719
R3287 VGND.t1504 VGND.t1676 98.5719
R3288 VGND.t782 VGND.n487 98.5719
R3289 VGND.t1637 VGND.t262 98.5719
R3290 VGND.n476 VGND.t1191 98.5719
R3291 VGND.n758 VGND.t132 98.5719
R3292 VGND.n786 VGND.t178 98.5719
R3293 VGND.t1378 VGND.n781 98.5719
R3294 VGND.t1567 VGND.n810 98.5719
R3295 VGND.n820 VGND.t130 98.5719
R3296 VGND.n693 VGND.t1000 98.5719
R3297 VGND.t1085 VGND.n726 98.5719
R3298 VGND.t1092 VGND.n641 98.5719
R3299 VGND.t1081 VGND.n524 98.5719
R3300 VGND.n548 VGND.t1548 98.5719
R3301 VGND.t1273 VGND.n163 112.825
R3302 VGND.n618 VGND.t1265 98.5719
R3303 VGND.t489 VGND.n187 83.171
R3304 VGND.t504 VGND.n432 96.5352
R3305 VGND.t514 VGND.n426 96.0596
R3306 VGND.n825 VGND.t720 96.0596
R3307 VGND.t1356 VGND.t836 94.2862
R3308 VGND.t447 VGND.n299 92.5931
R3309 VGND.n684 VGND.t485 92.5931
R3310 VGND.t500 VGND.n636 92.2514
R3311 VGND.n633 VGND.t638 92.2514
R3312 VGND.t1455 VGND.n376 91.6672
R3313 VGND.n805 VGND.t726 91.6672
R3314 VGND.n711 VGND.t1028 91.6672
R3315 VGND.n519 VGND.t924 91.6672
R3316 VGND.t343 VGND.n577 91.6672
R3317 VGND.t2 VGND.n602 91.6672
R3318 VGND.n0 VGND.t51 90.9451
R3319 VGND.n281 VGND.t575 90.2584
R3320 VGND.n320 VGND.t574 90.2584
R3321 VGND.t1435 VGND.n83 90.1151
R3322 VGND.t678 VGND.n70 90.1151
R3323 VGND.n75 VGND.t812 90.1151
R3324 VGND.t732 VGND.n367 90.0005
R3325 VGND.t387 VGND.t209 90.0005
R3326 VGND.t476 VGND.t768 90.0005
R3327 VGND.n493 VGND.t1281 90.0005
R3328 VGND.n492 VGND.t57 90.0005
R3329 VGND.t777 VGND.t727 90.0005
R3330 VGND.n765 VGND.t831 90.0005
R3331 VGND.t651 VGND.n691 90.0005
R3332 VGND.n730 VGND.t822 90.0005
R3333 VGND.t939 VGND.n528 90.0005
R3334 VGND.t77 VGND.n213 3.41063
R3335 VGND.t77 VGND.t811 89.1846
R3336 VGND.t405 VGND.t77 89.1846
R3337 VGND.t626 VGND.t30 89.1846
R3338 VGND.t25 VGND.t1035 89.1846
R3339 VGND.t25 VGND.t623 89.1836
R3340 VGND.t25 VGND.t905 89.1836
R3341 VGND.t624 VGND.n52 88.7727
R3342 VGND.n398 VGND.t16 88.5605
R3343 VGND.n3 VGND.t754 88.5605
R3344 VGND.n36 VGND.t279 88.5605
R3345 VGND.t1293 VGND.n456 87.5005
R3346 VGND.t111 VGND.n417 87.5005
R3347 VGND.n373 VGND.t578 87.5005
R3348 VGND.n386 VGND.t108 87.5005
R3349 VGND.t792 VGND.n796 87.5005
R3350 VGND.t144 VGND.n714 87.5005
R3351 VGND.t793 VGND.n510 87.5005
R3352 VGND.n564 VGND.t734 87.5005
R3353 VGND.t653 VGND.n583 87.5005
R3354 VGND.t821 VGND.n589 87.5005
R3355 VGND.t146 VGND.n608 87.5005
R3356 VGND.n134 VGND.t211 66.199
R3357 VGND.t477 VGND.t77 87.1423
R3358 VGND.t1133 VGND.t25 87.1423
R3359 VGND.n133 VGND.t77 3.4198
R3360 VGND.t30 VGND.t1379 87.1413
R3361 VGND.t25 VGND.t1353 87.1413
R3362 VGND.t461 VGND.t0 87.1413
R3363 VGND.t469 VGND.t0 87.1413
R3364 VGND.n279 VGND.t1440 85.9604
R3365 VGND.t1399 VGND.n319 85.9604
R3366 VGND.t311 VGND.n555 85.9604
R3367 VGND.n345 VGND.t816 85.7148
R3368 VGND.n145 VGND.t1417 99.148
R3369 VGND.t1445 VGND.n490 85.7148
R3370 VGND.t724 VGND.n762 85.7148
R3371 VGND.n782 VGND.t1377 85.7148
R3372 VGND.t1155 VGND.n729 85.7148
R3373 VGND.n664 VGND.t417 85.7148
R3374 VGND.n502 VGND.n501 85.6229
R3375 VGND.n99 VGND.t1400 64.5956
R3376 VGND.t1337 VGND.n118 64.5956
R3377 VGND.n128 VGND.t30 3.42969
R3378 VGND.n40 VGND.t1188 84.5541
R3379 VGND.n32 VGND.t908 84.5541
R3380 VGND.t835 VGND.t825 84.4161
R3381 VGND.t9 VGND.n458 83.3338
R3382 VGND.n462 VGND.t10 83.3338
R3383 VGND.t110 VGND.t79 83.3338
R3384 VGND.t592 VGND.n413 83.3338
R3385 VGND.n372 VGND.t1543 83.3338
R3386 VGND.t397 VGND.n383 83.3338
R3387 VGND.t545 VGND.t192 83.3338
R3388 VGND.t711 VGND.n795 83.3338
R3389 VGND.n715 VGND.t313 83.3338
R3390 VGND.t1044 VGND.n509 83.3338
R3391 VGND.n561 VGND.t702 83.3338
R3392 VGND.n584 VGND.t701 83.3338
R3393 VGND.t1403 VGND.n590 83.3338
R3394 VGND.n609 VGND.t19 83.3338
R3395 VGND.t850 VGND.n230 72.389
R3396 VGND.t35 VGND.n201 1.90258
R3397 VGND.t718 VGND.n259 81.6624
R3398 VGND.n394 VGND.t805 81.4291
R3399 VGND.t1135 VGND.n755 81.4291
R3400 VGND.n746 VGND.t1396 81.4291
R3401 VGND.t527 VGND.n793 81.4291
R3402 VGND.n816 VGND.t1161 81.4291
R3403 VGND.t1563 VGND.n698 81.4291
R3404 VGND.n719 VGND.t985 81.4291
R3405 VGND.t1095 VGND.n540 81.4291
R3406 VGND.n665 VGND.t1069 81.4291
R3407 VGND.t928 VGND.n585 81.4291
R3408 VGND.t975 VGND.n619 81.4291
R3409 VGND.t894 VGND.n623 81.4291
R3410 VGND.t510 VGND.n427 81.2813
R3411 VGND.t171 VGND.n422 81.2813
R3412 VGND.t381 VGND.t830 81.0816
R3413 VGND.t937 VGND.t1271 81.0816
R3414 VGND.t25 VGND.t1267 80.6131
R3415 VGND.t209 VGND.n366 79.9891
R3416 VGND.n62 VGND.t661 79.9891
R3417 VGND.n452 VGND.t593 79.1672
R3418 VGND.t1381 VGND.n354 79.1672
R3419 VGND.t1231 VGND.n254 79.1672
R3420 VGND.t1342 VGND.t447 78.7595
R3421 VGND.t485 VGND.t24 78.7595
R3422 VGND.t431 VGND.t1211 78.7595
R3423 VGND.t722 VGND.n504 78.2429
R3424 VGND.t246 VGND.n637 78.1255
R3425 VGND.n828 VGND.n827 77.5867
R3426 VGND.t595 VGND.t468 77.3644
R3427 VGND.n296 VGND.t1234 77.3644
R3428 VGND.n702 VGND.t125 77.3644
R3429 VGND.n408 VGND.t989 77.1434
R3430 VGND.t526 VGND.t1457 77.1434
R3431 VGND.n665 VGND.t942 77.1434
R3432 VGND.n119 VGND.t931 7.90675
R3433 VGND.n676 VGND.n675 77.0275
R3434 VGND.n654 VGND.n653 77.0275
R3435 VGND.n209 VGND.t954 60.3284
R3436 VGND.t77 VGND.n145 2.91846
R3437 VGND.n161 VGND.t25 2.91846
R3438 VGND.t30 VGND.t613 76.3264
R3439 VGND.t187 VGND.n231 66.2758
R3440 VGND.n229 VGND.t642 66.2758
R3441 VGND.t1357 VGND.n63 75.7034
R3442 VGND.n83 VGND.t1552 75.3368
R3443 VGND.n70 VGND.t410 75.3368
R3444 VGND.t755 VGND.n75 75.3368
R3445 VGND.n8 VGND.t1047 74.0025
R3446 VGND.n632 VGND.t648 73.8012
R3447 VGND.t1431 VGND.n256 73.0664
R3448 VGND.t1575 VGND.n265 73.0664
R3449 VGND.t1197 VGND.n261 73.0664
R3450 VGND.n288 VGND.t1131 73.0664
R3451 VGND.t1259 VGND.n329 73.0664
R3452 VGND.t1453 VGND.n323 73.0664
R3453 VGND.n311 VGND.t1119 73.0664
R3454 VGND.t1325 VGND.n308 73.0664
R3455 VGND.t672 VGND.n399 72.8576
R3456 VGND.t591 VGND.n400 72.8576
R3457 VGND.t866 VGND.n402 72.8576
R3458 VGND.n412 VGND.t841 72.8576
R3459 VGND.n167 VGND.t149 86.2905
R3460 VGND.n349 VGND.t1387 72.8576
R3461 VGND.n150 VGND.t1339 75.1515
R3462 VGND.t260 VGND.n486 72.8576
R3463 VGND.n486 VGND.t1355 72.8576
R3464 VGND.t783 VGND.n475 72.8576
R3465 VGND.n767 VGND.t1251 72.8576
R3466 VGND.t1405 VGND.n788 72.8576
R3467 VGND.n787 VGND.t533 72.8576
R3468 VGND.n785 VGND.t1354 72.8576
R3469 VGND.n818 VGND.t1167 72.8576
R3470 VGND.n694 VGND.t1557 72.8576
R3471 VGND.t979 VGND.n725 72.8576
R3472 VGND.n649 VGND.t948 72.8576
R3473 VGND.n650 VGND.t1007 72.8576
R3474 VGND.n667 VGND.t1075 72.8576
R3475 VGND.t1142 VGND.n523 72.8576
R3476 VGND.n162 VGND.t430 74.0048
R3477 VGND.n205 VGND.t116 74.0048
R3478 VGND.n109 VGND.t463 58.1284
R3479 VGND.t237 VGND.n638 72.8576
R3480 VGND.n614 VGND.t1408 72.8576
R3481 VGND.n619 VGND.t888 72.8576
R3482 VGND.t1398 VGND.t50 72.2032
R3483 VGND.t30 VGND.t1378 72.0407
R3484 VGND.n780 VGND.n779 71.4291
R3485 VGND.n25 VGND.t304 71.4177
R3486 VGND.n368 VGND.t383 71.4177
R3487 VGND.t206 VGND.n62 71.4177
R3488 VGND.t723 VGND.n764 71.4177
R3489 VGND.t243 VGND.n38 71.4177
R3490 VGND.n33 VGND.t1107 71.4177
R3491 VGND.t1613 VGND.n430 71.0546
R3492 VGND.n357 VGND.t795 71.0311
R3493 VGND.t802 VGND.n549 71.0311
R3494 VGND.t79 VGND.n133 83.7486
R3495 VGND.n383 VGND.t621 70.8338
R3496 VGND.t192 VGND.n271 70.8338
R3497 VGND.t403 VGND.n590 70.8338
R3498 VGND.t35 VGND.t1618 70.643
R3499 VGND.t35 VGND.t1616 70.642
R3500 VGND.t35 VGND.t100 70.642
R3501 VGND.t1235 VGND.t35 70.642
R3502 VGND.t703 VGND.t0 70.4746
R3503 VGND.t402 VGND.t400 69.3647
R3504 VGND.n673 VGND.t381 68.9194
R3505 VGND.t1271 VGND.n536 68.9194
R3506 VGND.t1581 VGND.t693 68.7684
R3507 VGND.t182 VGND.t1135 68.5719
R3508 VGND.t183 VGND.t1136 68.5719
R3509 VGND.t184 VGND.t1137 68.5719
R3510 VGND.t1390 VGND.t1138 68.5719
R3511 VGND.t1393 VGND.t1141 68.5719
R3512 VGND.t1394 VGND.t778 68.5719
R3513 VGND.t1395 VGND.t779 68.5719
R3514 VGND.t1396 VGND.t780 68.5719
R3515 VGND.t1260 VGND.t999 68.5719
R3516 VGND.n191 VGND.t1268 61.8303
R3517 VGND.n183 VGND.t1610 68.096
R3518 VGND.n126 VGND.t1310 100.582
R3519 VGND.t1362 VGND.n56 67.2827
R3520 VGND.n9 VGND.t992 67.2827
R3521 VGND.t731 VGND.t699 66.8529
R3522 VGND.t444 VGND.t147 66.6672
R3523 VGND.n276 VGND.t439 66.6672
R3524 VGND.t95 VGND.t98 66.6672
R3525 VGND.n562 VGND.t736 66.6672
R3526 VGND.t496 VGND.n21 66.0274
R3527 VGND.t142 VGND.t302 64.8654
R3528 VGND.t830 VGND.t826 64.8654
R3529 VGND.t940 VGND.t937 64.8654
R3530 VGND.t1132 VGND.n263 64.4704
R3531 VGND.t1348 VGND.t1197 64.4704
R3532 VGND.n321 VGND.t1364 64.4704
R3533 VGND.t1374 VGND.n292 64.4704
R3534 VGND.t1031 VGND.n686 64.4704
R3535 VGND.n453 VGND.n451 64.4396
R3536 VGND.t1144 VGND.n494 64.2862
R3537 VGND.n766 VGND.t1356 64.2862
R3538 VGND.n732 VGND.t190 64.2862
R3539 VGND.n731 VGND.t346 64.2862
R3540 VGND.t1583 VGND.n529 64.2862
R3541 VGND.n663 VGND.t955 64.2862
R3542 VGND.t50 VGND.t1432 63.5992
R3543 VGND.t1006 VGND.t25 63.4693
R3544 VGND.t12 VGND.n455 62.9376
R3545 VGND.t670 VGND.n398 62.8462
R3546 VGND.n615 VGND.t1409 62.8462
R3547 VGND.t1064 VGND.n553 62.762
R3548 VGND.n629 VGND.t865 62.7311
R3549 VGND.t1662 VGND.t1380 62.5005
R3550 VGND.t224 VGND.t1381 62.5005
R3551 VGND.t1570 VGND.n335 62.5005
R3552 VGND.n388 VGND.t483 62.5005
R3553 VGND.n807 VGND.t1183 62.5005
R3554 VGND.t1004 VGND.n713 62.5005
R3555 VGND.n521 VGND.t1045 62.5005
R3556 VGND.t1389 VGND.n582 62.5005
R3557 VGND.t366 VGND.n593 62.5005
R3558 VGND.t1401 VGND.n607 62.5005
R3559 VGND.t1177 VGND.n498 61.0611
R3560 VGND.n361 VGND.n360 60.9987
R3561 VGND.t658 VGND.n266 60.1724
R3562 VGND.n283 VGND.t1145 60.1724
R3563 VGND.t1363 VGND.n322 60.1724
R3564 VGND.t66 VGND.n318 60.1724
R3565 VGND.n364 VGND.t617 60.0005
R3566 VGND.n363 VGND.t388 60.0005
R3567 VGND.n346 VGND.t476 60.0005
R3568 VGND.t1547 VGND.n144 64.0964
R3569 VGND.t1665 VGND.n232 64.0961
R3570 VGND.n150 VGND.t704 49.6136
R3571 VGND.t1224 VGND.n494 60.0005
R3572 VGND.t727 VGND.n489 60.0005
R3573 VGND.t1645 VGND.n478 60.0005
R3574 VGND.n770 VGND.n769 60.0005
R3575 VGND.t1366 VGND.n761 60.0005
R3576 VGND.n160 VGND.t523 64.0962
R3577 VGND.t613 VGND.t1388 60.0005
R3578 VGND.t1179 VGND.n142 64.0964
R3579 VGND.t1184 VGND.n161 73.4337
R3580 VGND.n140 VGND.t245 64.0964
R3581 VGND.t1677 VGND.n669 60.0005
R3582 VGND.n157 VGND.t39 64.0962
R3583 VGND.t611 VGND.t612 59.6335
R3584 VGND.t870 VGND.t1292 59.6335
R3585 VGND.t356 VGND.t355 59.1867
R3586 VGND.t1279 VGND.t1282 59.0411
R3587 VGND.n637 VGND.t647 59.0411
R3588 VGND.n473 VGND.t78 58.7418
R3589 VGND.t944 VGND.t946 58.6471
R3590 VGND.n565 VGND.t1243 58.5779
R3591 VGND.n65 VGND.t1450 58.5605
R3592 VGND.t669 VGND.n760 58.5605
R3593 VGND.n377 VGND.t1455 58.3338
R3594 VGND.t1606 VGND.n382 58.3338
R3595 VGND.t726 VGND.n798 58.3338
R3596 VGND.t1028 VGND.n708 58.3338
R3597 VGND.t924 VGND.n512 58.3338
R3598 VGND.t760 VGND.n554 58.3338
R3599 VGND.n578 VGND.t343 58.3338
R3600 VGND.n591 VGND.t318 58.3338
R3601 VGND.n603 VGND.t2 58.3338
R3602 VGND.t1441 VGND.n264 55.8744
R3603 VGND.n282 VGND.t1580 55.8744
R3604 VGND.n285 VGND.t717 55.8744
R3605 VGND.n329 VGND.t675 55.8744
R3606 VGND.t1114 VGND.n317 55.8744
R3607 VGND.t198 VGND.n294 55.8744
R3608 VGND.t1633 VGND.n687 55.8744
R3609 VGND.n395 VGND.t806 55.7148
R3610 VGND.n251 VGND.t1121 55.7148
R3611 VGND.t1444 VGND.n491 55.7148
R3612 VGND.n483 VGND.t265 55.7148
R3613 VGND.t1136 VGND.n754 55.7148
R3614 VGND.n747 VGND.t1395 55.7148
R3615 VGND.t528 VGND.n792 55.7148
R3616 VGND.t1162 VGND.n812 55.7148
R3617 VGND.n692 VGND.t1260 55.7148
R3618 VGND.t1562 VGND.n697 55.7148
R3619 VGND.t1154 VGND.n730 55.7148
R3620 VGND.n720 VGND.t984 55.7148
R3621 VGND.n649 VGND.t1096 55.7148
R3622 VGND.t416 VGND.n528 55.7148
R3623 VGND.t1070 VGND.n526 55.7148
R3624 VGND.n588 VGND.t927 55.7148
R3625 VGND.t974 VGND.n618 55.7148
R3626 VGND.t893 VGND.n612 55.7148
R3627 VGND.t61 VGND.n611 55.7148
R3628 VGND.n204 VGND.t839 46.5775
R3629 VGND.n163 VGND.t0 2.09939
R3630 VGND.t1287 VGND.t30 54.8988
R3631 VGND.n50 VGND.n277 54.3887
R3632 VGND.t498 VGND.n25 54.2748
R3633 VGND.t221 VGND.t432 54.1766
R3634 VGND.n459 VGND.t9 54.1672
R3635 VGND.t593 VGND.n416 54.1672
R3636 VGND.t1382 VGND.n353 54.1672
R3637 VGND.t398 VGND.n385 54.1672
R3638 VGND.n258 VGND.t1228 54.1672
R3639 VGND.n592 VGND.t1404 54.1672
R3640 VGND.t0 VGND.t134 53.8089
R3641 VGND.t0 VGND.t775 53.8089
R3642 VGND.t735 VGND.t0 53.8089
R3643 VGND.t77 VGND.t109 53.8089
R3644 VGND.t30 VGND.t82 53.8089
R3645 VGND.t25 VGND.t97 53.8089
R3646 VGND.t1276 VGND.t77 53.8079
R3647 VGND.t1213 VGND.t77 53.8079
R3648 VGND.t25 VGND.t422 53.8079
R3649 VGND.t858 VGND.n10 53.2771
R3650 VGND.n71 VGND.t511 53.1693
R3651 VGND.n68 VGND.t170 53.1693
R3652 VGND.t445 VGND.n384 53.1692
R3653 VGND.t92 VGND.n11 53.1692
R3654 VGND.t50 VGND.t860 52.776
R3655 VGND.t30 VGND.t301 52.776
R3656 VGND.t30 VGND.t138 52.776
R3657 VGND.t832 VGND.n40 52.1217
R3658 VGND.t941 VGND.n32 52.1217
R3659 VGND.t1556 VGND.n298 51.8524
R3660 VGND.n685 VGND.t420 51.8524
R3661 VGND.n443 VGND.t513 51.7246
R3662 VGND.n186 VGND.t215 67.7872
R3663 VGND.n378 VGND.t480 51.7246
R3664 VGND.n380 VGND.t1456 51.7246
R3665 VGND.n829 VGND.t1686 51.7246
R3666 VGND.t284 VGND.n831 51.7246
R3667 VGND.t725 VGND.n800 51.7246
R3668 VGND.t1420 VGND.n799 51.7246
R3669 VGND.t1300 VGND.n680 51.7246
R3670 VGND.n706 VGND.t1029 51.7246
R3671 VGND.n740 VGND.t47 51.7246
R3672 VGND.t123 VGND.n679 51.7246
R3673 VGND.n657 VGND.t1285 51.7246
R3674 VGND.t910 VGND.n532 51.7246
R3675 VGND.t923 VGND.n514 51.7246
R3676 VGND.t583 VGND.n513 51.7246
R3677 VGND.n573 VGND.t342 51.7246
R3678 VGND.t798 VGND.n575 51.7246
R3679 VGND.n598 VGND.t1 51.7246
R3680 VGND.t1041 VGND.n600 51.7246
R3681 VGND.t1681 VGND.n256 51.5764
R3682 VGND.n284 VGND.t1146 51.5764
R3683 VGND.n146 VGND.t1508 23.2997
R3684 VGND.n293 VGND.t1640 51.5764
R3685 VGND.n703 VGND.t241 51.5764
R3686 VGND.n410 VGND.t136 51.4291
R3687 VGND.t375 VGND.t266 51.4291
R3688 VGND.t1354 VGND.t180 51.4291
R3689 VGND.t1054 VGND.n527 51.4291
R3690 VGND.t1277 VGND.t185 50.7817
R3691 VGND.t127 VGND.t129 50.7817
R3692 VGND.n341 VGND.n339 50.4592
R3693 VGND.n371 VGND.n370 50.4592
R3694 VGND.n356 VGND.t223 50.1398
R3695 VGND.n59 VGND.t1039 50.0907
R3696 VGND.t1385 VGND.t114 50.0005
R3697 VGND.t1190 VGND.n65 49.9891
R3698 VGND.n760 VGND.t539 49.9891
R3699 VGND.t560 VGND.n143 42.9194
R3700 VGND.n815 VGND.n814 49.6246
R3701 VGND.t354 VGND.t1449 48.0893
R3702 VGND.t1111 VGND.n273 47.2784
R3703 VGND.n280 VGND.t1576 47.2784
R3704 VGND.t1145 VGND.t1582 47.2784
R3705 VGND.n284 VGND.t1198 47.2784
R3706 VGND.t1364 VGND.t652 47.2784
R3707 VGND.t574 VGND.t1426 47.2784
R3708 VGND.n312 VGND.t1118 47.2784
R3709 VGND.n305 VGND.t561 47.2784
R3710 VGND.n558 VGND.t310 47.2784
R3711 VGND.t388 VGND.n362 47.1434
R3712 VGND.t261 VGND.n485 47.1434
R3713 VGND.t1391 VGND.n751 47.1434
R3714 VGND.n750 VGND.t1140 47.1434
R3715 VGND.n788 VGND.t532 47.1434
R3716 VGND.t1166 VGND.n811 47.1434
R3717 VGND.n695 VGND.t1558 47.1434
R3718 VGND.t124 VGND.t764 47.1434
R3719 VGND.t980 VGND.n724 47.1434
R3720 VGND.t905 VGND.t1270 47.1434
R3721 VGND.t1035 VGND.t947 47.1434
R3722 VGND.t911 VGND.t338 47.1434
R3723 VGND.t1074 VGND.n525 47.1434
R3724 VGND.n587 VGND.t464 47.1434
R3725 VGND.n620 VGND.t889 47.1434
R3726 VGND.n350 VGND.t1386 45.8338
R3727 VGND.t668 VGND.n60 45.7928
R3728 VGND.n23 VGND.t956 45.7034
R3729 VGND.t348 VGND.n23 45.7034
R3730 VGND.n393 VGND.t296 45.7034
R3731 VGND.t809 VGND.n405 45.7034
R3732 VGND.t253 VGND.n406 45.7034
R3733 VGND.t814 VGND.n18 45.7034
R3734 VGND.n17 VGND.t794 41.1573
R3735 VGND.n366 VGND.t204 45.7034
R3736 VGND.t113 VGND.n13 45.7034
R3737 VGND.t1359 VGND.n774 45.5125
R3738 VGND.n776 VGND.t1174 45.5125
R3739 VGND.n634 VGND.t408 45.5125
R3740 VGND.t320 VGND.t482 45.5081
R3741 VGND.t151 VGND.t876 45.5081
R3742 VGND.t1315 VGND.t1304 45.5081
R3743 VGND.t705 VGND.t744 45.5081
R3744 VGND.t1631 VGND.t1252 45.5081
R3745 VGND.t390 VGND.t456 45.5081
R3746 VGND.t442 VGND.t443 45.5081
R3747 VGND.t843 VGND.t919 45.5081
R3748 VGND.n814 VGND.t256 45.1133
R3749 VGND.t647 VGND.t500 44.2809
R3750 VGND.t303 VGND.t406 42.8576
R3751 VGND.n253 VGND.t1428 42.8576
R3752 VGND.n645 VGND.t1024 42.8576
R3753 VGND.t25 VGND.t1572 42.0655
R3754 VGND.n26 VGND.t471 41.4177
R3755 VGND.t64 VGND.n682 39.063
R3756 VGND.t571 VGND.n833 38.6824
R3757 VGND.n307 VGND.t1298 38.6824
R3758 VGND.n768 VGND.t823 38.5719
R3759 VGND.n759 VGND.t1367 38.5719
R3760 VGND.t1161 VGND.t1143 38.5719
R3761 VGND.t1558 VGND.t1261 38.5719
R3762 VGND.t1559 VGND.t690 38.5719
R3763 VGND.t25 VGND.t277 54.9227
R3764 VGND.t1218 VGND.n547 38.5719
R3765 VGND.t970 VGND.t928 38.5719
R3766 VGND.t360 VGND.n89 38.5043
R3767 VGND.t35 VGND.n171 0.90197
R3768 VGND.n177 VGND.t1150 34.9573
R3769 VGND.t35 VGND.n174 0.90197
R3770 VGND.n176 VGND.t218 34.9564
R3771 VGND.t104 VGND.t103 37.5728
R3772 VGND.t525 VGND.n53 37.1968
R3773 VGND.t262 VGND.n64 37.1319
R3774 VGND.n4 VGND.t1165 37.1319
R3775 VGND.n30 VGND.t1559 37.1319
R3776 VGND.n31 VGND.t1073 37.1319
R3777 VGND.t36 VGND.n439 37.1292
R3778 VGND.n351 VGND.t1385 36.5025
R3779 VGND.n674 VGND.t827 36.487
R3780 VGND.n652 VGND.t938 36.487
R3781 VGND.t291 VGND.t276 36.0675
R3782 VGND.t699 VGND.t77 35.9694
R3783 VGND.n376 VGND.n333 35.2946
R3784 VGND.n332 VGND.n331 35.2946
R3785 VGND.n805 VGND.n803 35.2946
R3786 VGND.n808 VGND.n801 35.2946
R3787 VGND.n705 VGND.n704 35.2946
R3788 VGND.n711 VGND.n707 35.2946
R3789 VGND.n522 VGND.n515 35.2946
R3790 VGND.n519 VGND.n517 35.2946
R3791 VGND.n572 VGND.n571 35.2946
R3792 VGND.n577 VGND.n576 35.2946
R3793 VGND.n15 VGND.n597 2.21537
R3794 VGND.n602 VGND.n601 35.2946
R3795 VGND.n301 VGND.n300 35.1567
R3796 VGND.n277 VGND.t1219 34.3845
R3797 VGND.t841 VGND.t213 34.2862
R3798 VGND.t1387 VGND.t546 34.2862
R3799 VGND.t1443 VGND.n245 34.2862
R3800 VGND.t637 VGND.t1287 34.2862
R3801 VGND.n699 VGND.t196 34.2862
R3802 VGND.t1002 VGND.n642 34.2862
R3803 VGND.n505 VGND.t1280 33.2108
R3804 VGND.n503 VGND.t1283 33.2108
R3805 VGND.t648 VGND.n628 33.2108
R3806 VGND.n738 VGND.n737 31.2505
R3807 VGND.n660 VGND.n531 31.2505
R3808 VGND.n274 VGND.t1375 30.0865
R3809 VGND.t1422 VGND.n267 30.0865
R3810 VGND.t1579 VGND.n263 30.0865
R3811 VGND.t1203 VGND.n260 30.0865
R3812 VGND.t926 VGND.t576 30.0865
R3813 VGND.n327 VGND.t676 30.0865
R3814 VGND.t1115 VGND.n316 30.0865
R3815 VGND.t1429 VGND.n303 30.0865
R3816 VGND.n301 VGND.t1410 30.0865
R3817 VGND.t317 VGND.n466 30.0005
R3818 VGND.n467 VGND.t148 30.0005
R3819 VGND.n470 VGND.t303 30.0005
R3820 VGND.n396 VGND.t540 30.0005
R3821 VGND.n342 VGND.n341 30.0005
R3822 VGND.n371 VGND.n338 30.0005
R3823 VGND.n249 VGND.t1122 30.0005
R3824 VGND.n252 VGND.t631 30.0005
R3825 VGND.t207 VGND.t1444 30.0005
R3826 VGND.n484 VGND.t264 30.0005
R3827 VGND.n482 VGND.t375 30.0005
R3828 VGND.t1258 VGND.n479 30.0005
R3829 VGND.t1137 VGND.n753 30.0005
R3830 VGND.n748 VGND.t1394 30.0005
R3831 VGND.t1457 VGND.n794 30.0005
R3832 VGND.t529 VGND.n791 30.0005
R3833 VGND.t349 VGND.n783 30.0005
R3834 VGND.n783 VGND.t373 30.0005
R3835 VGND.n817 VGND.t1163 30.0005
R3836 VGND.t965 VGND.n810 30.0005
R3837 VGND.t1568 VGND.t791 30.0005
R3838 VGND.t933 VGND.n690 30.0005
R3839 VGND.t1561 VGND.n696 30.0005
R3840 VGND.n723 VGND.t1297 30.0005
R3841 VGND.n721 VGND.t983 30.0005
R3842 VGND.n716 VGND.t1413 30.0005
R3843 VGND.t1473 VGND.n124 15.0001
R3844 VGND.n646 VGND.t1656 30.0005
R3845 VGND.t1656 VGND.t292 30.0005
R3846 VGND.t1032 VGND.n544 30.0005
R3847 VGND.n648 VGND.t907 30.0005
R3848 VGND.t951 VGND.n539 30.0005
R3849 VGND.t1103 VGND.n538 30.0005
R3850 VGND.n666 VGND.t1071 30.0005
R3851 VGND.t1246 VGND.n205 26.8309
R3852 VGND.n119 VGND.t0 32.8605
R3853 VGND.t1089 VGND.n586 30.0005
R3854 VGND.t287 VGND.n617 30.0005
R3855 VGND.n622 VGND.t892 30.0005
R3856 VGND.t63 VGND.n610 30.0005
R3857 VGND.t1180 VGND.t722 29.5208
R3858 VGND.t787 VGND.n155 26.1537
R3859 VGND.t1383 VGND.n352 29.1672
R3860 VGND.t1550 VGND.n255 29.1672
R3861 VGND.t1632 VGND.n59 28.6008
R3862 VGND.t282 VGND.n21 28.2651
R3863 VGND.t220 VGND.n7 28.2266
R3864 VGND.t879 VGND.n389 28.1692
R3865 VGND.t925 VGND.n12 28.1692
R3866 VGND.t60 VGND.n57 26.6284
R3867 VGND.n29 VGND.t5 26.6284
R3868 VGND.t1240 VGND.t1116 25.7885
R3869 VGND.t346 VGND.t833 25.7148
R3870 VGND.t244 VGND.t1184 25.7148
R3871 VGND.t955 VGND.t934 25.7148
R3872 VGND.t1108 VGND.t549 25.7148
R3873 VGND.t789 VGND.t1072 25.7148
R3874 VGND.t786 VGND.t1231 25.0005
R3875 VGND.t122 VGND.t763 24.3248
R3876 VGND.t909 VGND.t337 24.3248
R3877 VGND.t433 VGND.t356 24.0449
R3878 VGND.n186 VGND.t214 22.67
R3879 VGND.t512 VGND.n71 23.6126
R3880 VGND.t589 VGND.n68 23.6126
R3881 VGND.t761 VGND.n502 22.1407
R3882 VGND.t1589 VGND.t921 21.8983
R3883 VGND.t1577 VGND.n264 21.4905
R3884 VGND.t1516 VGND.t694 21.4905
R3885 VGND.t1112 VGND.t1399 21.4905
R3886 VGND.t1113 VGND.t66 21.4905
R3887 VGND.n313 VGND.t1117 21.4905
R3888 VGND.t1446 VGND.t615 21.4905
R3889 VGND.n306 VGND.t595 21.4905
R3890 VGND.t823 VGND.t1360 21.4291
R3891 VGND.t1367 VGND.t374 21.4291
R3892 VGND.n751 VGND.t1139 21.4291
R3893 VGND.t1392 VGND.n750 21.4291
R3894 VGND.n789 VGND.t531 21.4291
R3895 VGND.t981 VGND.n723 21.4291
R3896 VGND.t1001 VGND.t1269 21.4291
R3897 VGND.n647 VGND.t1025 21.4291
R3898 VGND.t629 VGND.t1081 21.4291
R3899 VGND.n621 VGND.t890 21.4291
R3900 VGND.t109 VGND.t217 20.8338
R3901 VGND.t883 VGND.t1276 20.8338
R3902 VGND.t702 VGND.t1605 20.8338
R3903 VGND.t952 VGND.t25 20.6131
R3904 VGND.t50 VGND.t1549 20.4751
R3905 VGND.n53 VGND.t550 20.0048
R3906 VGND.n55 VGND.t1202 20.0048
R3907 VGND.n64 VGND.t263 19.9891
R3908 VGND.t1164 VGND.n4 19.9891
R3909 VGND.t1560 VGND.n30 19.9891
R3910 VGND.t1072 VGND.n31 19.9891
R3911 VGND.n13 VGND.t1088 19.9891
R3912 VGND.t1384 VGND.n351 19.8359
R3913 VGND.t904 VGND.t1589 19.3221
R3914 VGND.t394 VGND.t878 17.6148
R3915 VGND.t1349 VGND.t758 17.1925
R3916 VGND.t831 VGND.t1588 17.1434
R3917 VGND.t834 VGND.t1425 17.1434
R3918 VGND.t984 VGND.t1368 17.1434
R3919 VGND.t35 VGND.n131 9.83319
R3920 VGND.t35 VGND.n188 12.3852
R3921 VGND.t35 VGND.n189 10.3563
R3922 VGND.n223 VGND.t35 0.389775
R3923 VGND.n824 VGND.t35 17.0005
R3924 VGND.n825 VGND.t35 17.0005
R3925 VGND.n186 VGND.t35 0.549987
R3926 VGND.t35 VGND.n198 0.980633
R3927 VGND.t35 VGND.n172 2.92705
R3928 VGND.t0 VGND.n112 11.0749
R3929 VGND.t0 VGND.n634 17.0005
R3930 VGND.t0 VGND.n627 17.0005
R3931 VGND.t0 VGND.n633 17.0005
R3932 VGND.t0 VGND.n628 17.0005
R3933 VGND.t0 VGND.n630 17.0005
R3934 VGND.t0 VGND.n629 17.0005
R3935 VGND.n636 VGND.t0 17.0005
R3936 VGND.t0 VGND.n610 17.0005
R3937 VGND.t0 VGND.n625 17.0005
R3938 VGND.t0 VGND.n611 17.0005
R3939 VGND.t0 VGND.n624 17.0005
R3940 VGND.t0 VGND.n623 17.0005
R3941 VGND.t0 VGND.n612 17.0005
R3942 VGND.t0 VGND.n622 17.0005
R3943 VGND.t0 VGND.n613 17.0005
R3944 VGND.t0 VGND.n621 17.0005
R3945 VGND.n620 VGND.t0 17.0005
R3946 VGND.n619 VGND.t0 17.0005
R3947 VGND.n618 VGND.t0 17.0005
R3948 VGND.n617 VGND.t0 17.0005
R3949 VGND.n616 VGND.t0 17.0005
R3950 VGND.n614 VGND.t0 17.0005
R3951 VGND.n210 VGND.t0 8.48857
R3952 VGND.n154 VGND.t0 12.256
R3953 VGND.n609 VGND.t0 17.0005
R3954 VGND.n608 VGND.t0 17.0005
R3955 VGND.n607 VGND.t0 17.0005
R3956 VGND.n605 VGND.t0 17.0005
R3957 VGND.n604 VGND.t0 17.0005
R3958 VGND.n603 VGND.t0 17.0005
R3959 VGND.n601 VGND.t0 17.0005
R3960 VGND.n600 VGND.t0 17.0005
R3961 VGND.n599 VGND.t0 17.0005
R3962 VGND.n598 VGND.t0 17.0005
R3963 VGND.t0 VGND.n593 17.0005
R3964 VGND.t0 VGND.n589 17.0005
R3965 VGND.t0 VGND.n592 17.0005
R3966 VGND.t0 VGND.n590 17.0005
R3967 VGND.t0 VGND.n591 17.0005
R3968 VGND.t0 VGND.n158 10.2901
R3969 VGND.n638 VGND.t0 17.0005
R3970 VGND.t0 VGND.n639 17.0005
R3971 VGND.t0 VGND.n585 17.0005
R3972 VGND.t0 VGND.n588 17.0005
R3973 VGND.t0 VGND.n586 17.0005
R3974 VGND.t0 VGND.n587 17.0005
R3975 VGND.n584 VGND.t0 17.0005
R3976 VGND.n583 VGND.t0 17.0005
R3977 VGND.n582 VGND.t0 17.0005
R3978 VGND.n580 VGND.t0 17.0005
R3979 VGND.n579 VGND.t0 17.0005
R3980 VGND.n578 VGND.t0 17.0005
R3981 VGND.n576 VGND.t0 17.0005
R3982 VGND.n575 VGND.t0 17.0005
R3983 VGND.n574 VGND.t0 17.0005
R3984 VGND.n573 VGND.t0 17.0005
R3985 VGND.n572 VGND.t0 17.0005
R3986 VGND.t0 VGND.n549 17.0005
R3987 VGND.t0 VGND.n570 17.0005
R3988 VGND.t0 VGND.n550 17.0005
R3989 VGND.t0 VGND.n567 17.0005
R3990 VGND.t0 VGND.n551 17.0005
R3991 VGND.t0 VGND.n566 17.0005
R3992 VGND.t0 VGND.n552 17.0005
R3993 VGND.t0 VGND.n565 17.0005
R3994 VGND.t0 VGND.n553 17.0005
R3995 VGND.t0 VGND.n564 17.0005
R3996 VGND.t0 VGND.n561 17.0005
R3997 VGND.t0 VGND.n554 17.0005
R3998 VGND.t0 VGND.n560 17.0005
R3999 VGND.t0 VGND.n555 17.0005
R4000 VGND.t0 VGND.n559 17.0005
R4001 VGND.t0 VGND.n545 17.0005
R4002 VGND.t0 VGND.n546 17.0005
R4003 VGND.t0 VGND.n162 15.2045
R4004 VGND.t0 VGND.n240 0.649813
R4005 VGND.t0 VGND.n547 17.0005
R4006 VGND.t0 VGND.n548 17.0005
R4007 VGND.t35 VGND.n185 0.980634
R4008 VGND.t35 VGND.n177 0.90197
R4009 VGND.t35 VGND.n168 9.83319
R4010 VGND.t35 VGND.n115 3.26622
R4011 VGND.t35 VGND.n448 17.0005
R4012 VGND.t35 VGND.n420 17.0005
R4013 VGND.t35 VGND.n447 17.0005
R4014 VGND.t35 VGND.n422 17.0005
R4015 VGND.t35 VGND.n446 17.0005
R4016 VGND.t35 VGND.n229 1.73368
R4017 VGND.t35 VGND.n231 1.73368
R4018 VGND.t35 VGND.n424 17.0005
R4019 VGND.t35 VGND.n445 17.0005
R4020 VGND.t35 VGND.n425 17.0005
R4021 VGND.t35 VGND.n444 17.0005
R4022 VGND.t35 VGND.n426 17.0005
R4023 VGND.t35 VGND.n443 17.0005
R4024 VGND.t35 VGND.n427 17.0005
R4025 VGND.t35 VGND.n442 17.0005
R4026 VGND.t35 VGND.n428 17.0005
R4027 VGND.t35 VGND.n441 17.0005
R4028 VGND.t35 VGND.n197 2.14035
R4029 VGND.t35 VGND.n173 2.92705
R4030 VGND.t35 VGND.n199 0.980533
R4031 VGND.t35 VGND.n440 17.0005
R4032 VGND.t35 VGND.n156 3.2662
R4033 VGND.t35 VGND.n148 9.83317
R4034 VGND.t35 VGND.n176 0.901947
R4035 VGND.t35 VGND.n437 17.0005
R4036 VGND.t35 VGND.n431 17.0005
R4037 VGND.t35 VGND.n434 17.0005
R4038 VGND.t35 VGND.n432 17.0005
R4039 VGND.t35 VGND.n236 2.74812
R4040 VGND.t35 VGND.n433 17.0005
R4041 VGND.n392 VGND.t77 17.0005
R4042 VGND.n391 VGND.t77 17.0005
R4043 VGND.n390 VGND.t77 17.0005
R4044 VGND.n388 VGND.t77 17.0005
R4045 VGND.n386 VGND.t77 17.0005
R4046 VGND.n385 VGND.t77 17.0005
R4047 VGND.n383 VGND.t77 17.0005
R4048 VGND.n382 VGND.t77 17.0005
R4049 VGND.n831 VGND.t77 17.0005
R4050 VGND.n830 VGND.t77 17.0005
R4051 VGND.n829 VGND.t77 17.0005
R4052 VGND.n828 VGND.t77 17.0005
R4053 VGND.t77 VGND.n381 17.0005
R4054 VGND.t77 VGND.n407 17.0005
R4055 VGND.n404 VGND.t77 17.0005
R4056 VGND.n403 VGND.t77 17.0005
R4057 VGND.n402 VGND.t77 17.0005
R4058 VGND.n401 VGND.t77 17.0005
R4059 VGND.n400 VGND.t77 17.0005
R4060 VGND.n399 VGND.t77 17.0005
R4061 VGND.n397 VGND.t77 17.0005
R4062 VGND.n396 VGND.t77 17.0005
R4063 VGND.n395 VGND.t77 17.0005
R4064 VGND.n394 VGND.t77 17.0005
R4065 VGND.t77 VGND.n417 17.0005
R4066 VGND.t77 VGND.n416 17.0005
R4067 VGND.t77 VGND.n415 17.0005
R4068 VGND.t77 VGND.n414 17.0005
R4069 VGND.t77 VGND.n413 17.0005
R4070 VGND.t77 VGND.n134 3.41984
R4071 VGND.t77 VGND.n412 17.0005
R4072 VGND.t77 VGND.n411 17.0005
R4073 VGND.t77 VGND.n410 17.0005
R4074 VGND.t77 VGND.n408 17.0005
R4075 VGND.t77 VGND.n153 15.2045
R4076 VGND.t77 VGND.n473 17.0005
R4077 VGND.t77 VGND.n454 17.0005
R4078 VGND.n474 VGND.t77 17.0005
R4079 VGND.t77 VGND.n472 17.0005
R4080 VGND.t77 VGND.n471 17.0005
R4081 VGND.t77 VGND.n470 17.0005
R4082 VGND.t77 VGND.n469 17.0005
R4083 VGND.t77 VGND.n468 17.0005
R4084 VGND.t77 VGND.n467 17.0005
R4085 VGND.t77 VGND.n466 17.0005
R4086 VGND.t77 VGND.n465 17.0005
R4087 VGND.t77 VGND.n463 17.0005
R4088 VGND.t77 VGND.n462 17.0005
R4089 VGND.t77 VGND.n461 17.0005
R4090 VGND.t77 VGND.n460 17.0005
R4091 VGND.t77 VGND.n459 17.0005
R4092 VGND.t77 VGND.n456 17.0005
R4093 VGND.t77 VGND.n455 17.0005
R4094 VGND.t77 VGND.n137 12.2562
R4095 VGND.t77 VGND.n332 17.0005
R4096 VGND.t77 VGND.n380 17.0005
R4097 VGND.t77 VGND.n379 17.0005
R4098 VGND.t77 VGND.n378 17.0005
R4099 VGND.t77 VGND.n333 17.0005
R4100 VGND.t77 VGND.n377 17.0005
R4101 VGND.t77 VGND.n334 17.0005
R4102 VGND.t77 VGND.n374 17.0005
R4103 VGND.t77 VGND.n335 17.0005
R4104 VGND.t77 VGND.n373 17.0005
R4105 VGND.t77 VGND.n372 17.0005
R4106 VGND.t77 VGND.n336 17.0005
R4107 VGND.t77 VGND.n337 17.0005
R4108 VGND.n343 VGND.t77 17.0005
R4109 VGND.n344 VGND.t77 17.0005
R4110 VGND.n345 VGND.t77 17.0005
R4111 VGND.n346 VGND.t77 17.0005
R4112 VGND.n347 VGND.t77 17.0005
R4113 VGND.n348 VGND.t77 17.0005
R4114 VGND.n349 VGND.t77 17.0005
R4115 VGND.n350 VGND.t77 17.0005
R4116 VGND.n352 VGND.t77 17.0005
R4117 VGND.n353 VGND.t77 17.0005
R4118 VGND.n354 VGND.t77 17.0005
R4119 VGND.n355 VGND.t77 17.0005
R4120 VGND.n356 VGND.t77 17.0005
R4121 VGND.n357 VGND.t77 17.0005
R4122 VGND.n358 VGND.t77 17.0005
R4123 VGND.n363 VGND.t77 17.0005
R4124 VGND.n364 VGND.t77 17.0005
R4125 VGND.n365 VGND.t77 17.0005
R4126 VGND.n367 VGND.t77 17.0005
R4127 VGND.n369 VGND.t77 17.0005
R4128 VGND.n167 VGND.t77 2.91885
R4129 VGND.n241 VGND.t77 0.649813
R4130 VGND.t77 VGND.n340 17.0005
R4131 VGND.t50 VGND.n215 12.257
R4132 VGND.t50 VGND.n325 17.0005
R4133 VGND.t50 VGND.n326 17.0005
R4134 VGND.t50 VGND.n327 17.0005
R4135 VGND.t50 VGND.n328 17.0005
R4136 VGND.t50 VGND.n329 17.0005
R4137 VGND.t50 VGND.n330 17.0005
R4138 VGND.t50 VGND.n214 8.4887
R4139 VGND.t50 VGND.n289 17.0005
R4140 VGND.t50 VGND.n286 17.0005
R4141 VGND.t50 VGND.n288 17.0005
R4142 VGND.t50 VGND.n287 17.0005
R4143 VGND.n833 VGND.t50 17.0005
R4144 VGND.t50 VGND.n834 17.0005
R4145 VGND.t50 VGND.n259 17.0005
R4146 VGND.t50 VGND.n285 17.0005
R4147 VGND.t50 VGND.n260 17.0005
R4148 VGND.t50 VGND.n284 17.0005
R4149 VGND.t50 VGND.n261 17.0005
R4150 VGND.t50 VGND.n283 17.0005
R4151 VGND.t50 VGND.n262 17.0005
R4152 VGND.t50 VGND.n282 17.0005
R4153 VGND.t50 VGND.n263 17.0005
R4154 VGND.t50 VGND.n281 17.0005
R4155 VGND.t50 VGND.n264 17.0005
R4156 VGND.t50 VGND.n280 17.0005
R4157 VGND.t50 VGND.n265 17.0005
R4158 VGND.t50 VGND.n279 17.0005
R4159 VGND.t50 VGND.n266 17.0005
R4160 VGND.t50 VGND.n278 17.0005
R4161 VGND.t50 VGND.n267 17.0005
R4162 VGND.t50 VGND.n275 17.0005
R4163 VGND.t50 VGND.n268 17.0005
R4164 VGND.t50 VGND.n274 17.0005
R4165 VGND.t50 VGND.n273 17.0005
R4166 VGND.t50 VGND.n269 17.0005
R4167 VGND.t50 VGND.n270 17.0005
R4168 VGND.t50 VGND.n272 17.0005
R4169 VGND.t50 VGND.n271 17.0005
R4170 VGND.t50 VGND.n222 0.666899
R4171 VGND.t50 VGND.n254 17.0005
R4172 VGND.t50 VGND.n258 17.0005
R4173 VGND.t50 VGND.n255 17.0005
R4174 VGND.t50 VGND.n256 17.0005
R4175 VGND.t50 VGND.n257 17.0005
R4176 VGND.n835 VGND.t50 17.0005
R4177 VGND.t50 VGND.n139 9.79177
R4178 VGND.t50 VGND.n99 3.42969
R4179 VGND.t50 VGND.n233 12.2561
R4180 VGND.t50 VGND.n245 17.0005
R4181 VGND.t50 VGND.n253 17.0005
R4182 VGND.t50 VGND.n246 17.0005
R4183 VGND.t50 VGND.n252 17.0005
R4184 VGND.t50 VGND.n247 17.0005
R4185 VGND.t50 VGND.n249 17.0005
R4186 VGND.n250 VGND.t50 17.0005
R4187 VGND.t50 VGND.n251 17.0005
R4188 VGND.t50 VGND.n248 17.0005
R4189 VGND.t50 VGND.n290 17.0005
R4190 VGND.t50 VGND.n303 17.0005
R4191 VGND.t50 VGND.n304 17.0005
R4192 VGND.t50 VGND.n305 17.0005
R4193 VGND.t50 VGND.n306 17.0005
R4194 VGND.t50 VGND.n307 17.0005
R4195 VGND.t50 VGND.n308 17.0005
R4196 VGND.t50 VGND.n309 17.0005
R4197 VGND.t50 VGND.n310 17.0005
R4198 VGND.t50 VGND.n311 17.0005
R4199 VGND.t50 VGND.n312 17.0005
R4200 VGND.t50 VGND.n313 17.0005
R4201 VGND.t50 VGND.n315 17.0005
R4202 VGND.t50 VGND.n316 17.0005
R4203 VGND.t50 VGND.n317 17.0005
R4204 VGND.t50 VGND.n318 17.0005
R4205 VGND.t50 VGND.n319 17.0005
R4206 VGND.t50 VGND.n320 17.0005
R4207 VGND.t50 VGND.n321 17.0005
R4208 VGND.t50 VGND.n322 17.0005
R4209 VGND.t50 VGND.n323 17.0005
R4210 VGND.t50 VGND.n324 17.0005
R4211 VGND.t50 VGND.n291 17.0005
R4212 VGND.t50 VGND.n298 17.0005
R4213 VGND.t50 VGND.n299 17.0005
R4214 VGND.t50 VGND.n295 17.0005
R4215 VGND.t50 VGND.n294 17.0005
R4216 VGND.t50 VGND.n293 17.0005
R4217 VGND.t50 VGND.n292 17.0005
R4218 VGND.n499 VGND.t50 17.0005
R4219 VGND.n503 VGND.t50 17.0005
R4220 VGND.n505 VGND.t50 17.0005
R4221 VGND.n506 VGND.t50 17.0005
R4222 VGND.t50 VGND.n475 17.0005
R4223 VGND.t50 VGND.n476 17.0005
R4224 VGND.t50 VGND.n477 17.0005
R4225 VGND.t50 VGND.n478 17.0005
R4226 VGND.t50 VGND.n479 17.0005
R4227 VGND.t50 VGND.n480 17.0005
R4228 VGND.t50 VGND.n481 17.0005
R4229 VGND.t50 VGND.n482 17.0005
R4230 VGND.t50 VGND.n483 17.0005
R4231 VGND.t50 VGND.n484 17.0005
R4232 VGND.t50 VGND.n485 17.0005
R4233 VGND.t50 VGND.n486 17.0005
R4234 VGND.t50 VGND.n487 17.0005
R4235 VGND.t50 VGND.n488 17.0005
R4236 VGND.t50 VGND.n489 17.0005
R4237 VGND.t50 VGND.n490 17.0005
R4238 VGND.t50 VGND.n491 17.0005
R4239 VGND.t50 VGND.n492 17.0005
R4240 VGND.t50 VGND.n493 17.0005
R4241 VGND.t50 VGND.n494 17.0005
R4242 VGND.t50 VGND.n495 17.0005
R4243 VGND.n129 VGND.t30 9.79177
R4244 VGND.n118 VGND.t30 3.42969
R4245 VGND.n743 VGND.t30 17.0005
R4246 VGND.n745 VGND.t30 17.0005
R4247 VGND.n746 VGND.t30 17.0005
R4248 VGND.n747 VGND.t30 17.0005
R4249 VGND.n748 VGND.t30 17.0005
R4250 VGND.n749 VGND.t30 17.0005
R4251 VGND.n750 VGND.t30 17.0005
R4252 VGND.n751 VGND.t30 17.0005
R4253 VGND.n752 VGND.t30 17.0005
R4254 VGND.n753 VGND.t30 17.0005
R4255 VGND.n754 VGND.t30 17.0005
R4256 VGND.n755 VGND.t30 17.0005
R4257 VGND.n756 VGND.t30 17.0005
R4258 VGND.n757 VGND.t30 17.0005
R4259 VGND.n758 VGND.t30 17.0005
R4260 VGND.n759 VGND.t30 17.0005
R4261 VGND.n761 VGND.t30 17.0005
R4262 VGND.n762 VGND.t30 17.0005
R4263 VGND.n763 VGND.t30 17.0005
R4264 VGND.n765 VGND.t30 17.0005
R4265 VGND.n766 VGND.t30 17.0005
R4266 VGND.n767 VGND.t30 17.0005
R4267 VGND.n769 VGND.t30 17.0005
R4268 VGND.n768 VGND.t30 17.0005
R4269 VGND.n741 VGND.t30 17.0005
R4270 VGND.n772 VGND.t30 17.0005
R4271 VGND.n773 VGND.t30 17.0005
R4272 VGND.n774 VGND.t30 17.0005
R4273 VGND.n776 VGND.t30 17.0005
R4274 VGND.n777 VGND.t30 17.0005
R4275 VGND.n778 VGND.t30 17.0005
R4276 VGND.n782 VGND.t30 17.0005
R4277 VGND.n151 VGND.t30 10.4539
R4278 VGND.n783 VGND.t30 17.0005
R4279 VGND.n784 VGND.t30 17.0005
R4280 VGND.n785 VGND.t30 17.0005
R4281 VGND.n786 VGND.t30 17.0005
R4282 VGND.n787 VGND.t30 17.0005
R4283 VGND.n788 VGND.t30 17.0005
R4284 VGND.n789 VGND.t30 17.0005
R4285 VGND.n790 VGND.t30 17.0005
R4286 VGND.n791 VGND.t30 17.0005
R4287 VGND.n792 VGND.t30 17.0005
R4288 VGND.n793 VGND.t30 17.0005
R4289 VGND.n794 VGND.t30 17.0005
R4290 VGND.t30 VGND.n795 17.0005
R4291 VGND.t30 VGND.n796 17.0005
R4292 VGND.t30 VGND.n807 17.0005
R4293 VGND.t30 VGND.n797 17.0005
R4294 VGND.t30 VGND.n804 17.0005
R4295 VGND.t30 VGND.n798 17.0005
R4296 VGND.t30 VGND.n803 17.0005
R4297 VGND.t30 VGND.n799 17.0005
R4298 VGND.t30 VGND.n802 17.0005
R4299 VGND.t30 VGND.n800 17.0005
R4300 VGND.t30 VGND.n801 17.0005
R4301 VGND.n142 VGND.t30 12.2558
R4302 VGND.t30 VGND.n820 17.0005
R4303 VGND.t30 VGND.n809 17.0005
R4304 VGND.t30 VGND.n819 17.0005
R4305 VGND.t30 VGND.n810 17.0005
R4306 VGND.t30 VGND.n818 17.0005
R4307 VGND.t30 VGND.n811 17.0005
R4308 VGND.t30 VGND.n817 17.0005
R4309 VGND.t30 VGND.n812 17.0005
R4310 VGND.t30 VGND.n816 17.0005
R4311 VGND.t30 VGND.n813 17.0005
R4312 VGND.t30 VGND.n242 0.689837
R4313 VGND.t25 VGND.n740 17.0005
R4314 VGND.t25 VGND.n670 17.0005
R4315 VGND.t25 VGND.n678 17.0005
R4316 VGND.t25 VGND.n671 17.0005
R4317 VGND.t25 VGND.n675 17.0005
R4318 VGND.t25 VGND.n672 17.0005
R4319 VGND.t25 VGND.n674 17.0005
R4320 VGND.t25 VGND.n673 17.0005
R4321 VGND.t25 VGND.n679 17.0005
R4322 VGND.t25 VGND.n739 17.0005
R4323 VGND.t25 VGND.n680 17.0005
R4324 VGND.t25 VGND.n707 17.0005
R4325 VGND.t25 VGND.n708 17.0005
R4326 VGND.t25 VGND.n709 17.0005
R4327 VGND.t25 VGND.n710 17.0005
R4328 VGND.t25 VGND.n713 17.0005
R4329 VGND.t25 VGND.n714 17.0005
R4330 VGND.t25 VGND.n715 17.0005
R4331 VGND.t25 VGND.n140 12.2558
R4332 VGND.t25 VGND.n716 17.0005
R4333 VGND.t25 VGND.n717 17.0005
R4334 VGND.t25 VGND.n718 17.0005
R4335 VGND.t25 VGND.n719 17.0005
R4336 VGND.t25 VGND.n720 17.0005
R4337 VGND.t25 VGND.n721 17.0005
R4338 VGND.t25 VGND.n722 17.0005
R4339 VGND.t25 VGND.n723 17.0005
R4340 VGND.t25 VGND.n724 17.0005
R4341 VGND.t25 VGND.n725 17.0005
R4342 VGND.t25 VGND.n726 17.0005
R4343 VGND.t25 VGND.n727 17.0005
R4344 VGND.t25 VGND.n728 17.0005
R4345 VGND.t25 VGND.n729 17.0005
R4346 VGND.t25 VGND.n730 17.0005
R4347 VGND.t25 VGND.n731 17.0005
R4348 VGND.t25 VGND.n732 17.0005
R4349 VGND.t25 VGND.n733 17.0005
R4350 VGND.t25 VGND.n734 17.0005
R4351 VGND.t25 VGND.n735 17.0005
R4352 VGND.t25 VGND.n738 17.0005
R4353 VGND.t25 VGND.n681 17.0005
R4354 VGND.t25 VGND.n705 17.0005
R4355 VGND.t25 VGND.n706 17.0005
R4356 VGND.n683 VGND.t25 17.0005
R4357 VGND.t25 VGND.n703 17.0005
R4358 VGND.t25 VGND.n686 17.0005
R4359 VGND.t25 VGND.n685 17.0005
R4360 VGND.t25 VGND.n684 17.0005
R4361 VGND.t25 VGND.n687 17.0005
R4362 VGND.t25 VGND.n688 17.0005
R4363 VGND.t25 VGND.n155 1.11647
R4364 VGND.t25 VGND.n690 17.0005
R4365 VGND.t25 VGND.n700 17.0005
R4366 VGND.t25 VGND.n699 17.0005
R4367 VGND.t25 VGND.n698 17.0005
R4368 VGND.t25 VGND.n697 17.0005
R4369 VGND.t25 VGND.n696 17.0005
R4370 VGND.t25 VGND.n695 17.0005
R4371 VGND.t25 VGND.n694 17.0005
R4372 VGND.t25 VGND.n693 17.0005
R4373 VGND.t25 VGND.n692 17.0005
R4374 VGND.t25 VGND.n691 17.0005
R4375 VGND.t25 VGND.n509 17.0005
R4376 VGND.t25 VGND.n510 17.0005
R4377 VGND.t25 VGND.n521 17.0005
R4378 VGND.t25 VGND.n511 17.0005
R4379 VGND.t25 VGND.n518 17.0005
R4380 VGND.t25 VGND.n512 17.0005
R4381 VGND.t25 VGND.n517 17.0005
R4382 VGND.t25 VGND.n513 17.0005
R4383 VGND.t25 VGND.n516 17.0005
R4384 VGND.t25 VGND.n514 17.0005
R4385 VGND.t25 VGND.n515 17.0005
R4386 VGND.n669 VGND.t25 17.0005
R4387 VGND.t25 VGND.n523 17.0005
R4388 VGND.t25 VGND.n668 17.0005
R4389 VGND.t25 VGND.n524 17.0005
R4390 VGND.t25 VGND.n667 17.0005
R4391 VGND.t25 VGND.n525 17.0005
R4392 VGND.t25 VGND.n666 17.0005
R4393 VGND.t25 VGND.n526 17.0005
R4394 VGND.t25 VGND.n665 17.0005
R4395 VGND.t25 VGND.n527 17.0005
R4396 VGND.t25 VGND.n209 2.91928
R4397 VGND.t25 VGND.n664 17.0005
R4398 VGND.t25 VGND.n528 17.0005
R4399 VGND.t25 VGND.n663 17.0005
R4400 VGND.t25 VGND.n529 17.0005
R4401 VGND.t25 VGND.n662 17.0005
R4402 VGND.t25 VGND.n530 17.0005
R4403 VGND.t25 VGND.n659 17.0005
R4404 VGND.t25 VGND.n531 17.0005
R4405 VGND.t25 VGND.n658 17.0005
R4406 VGND.t25 VGND.n532 17.0005
R4407 VGND.t25 VGND.n657 17.0005
R4408 VGND.t25 VGND.n533 17.0005
R4409 VGND.t25 VGND.n656 17.0005
R4410 VGND.t25 VGND.n534 17.0005
R4411 VGND.t25 VGND.n653 17.0005
R4412 VGND.t25 VGND.n535 17.0005
R4413 VGND.t25 VGND.n652 17.0005
R4414 VGND.t25 VGND.n536 17.0005
R4415 VGND.t25 VGND.n651 17.0005
R4416 VGND.t25 VGND.n538 17.0005
R4417 VGND.t25 VGND.n650 17.0005
R4418 VGND.t25 VGND.n539 17.0005
R4419 VGND.t25 VGND.n649 17.0005
R4420 VGND.t25 VGND.n540 17.0005
R4421 VGND.t25 VGND.n541 17.0005
R4422 VGND.t25 VGND.n648 17.0005
R4423 VGND.t25 VGND.n542 17.0005
R4424 VGND.t25 VGND.n543 17.0005
R4425 VGND.t25 VGND.n152 10.4539
R4426 VGND.t25 VGND.n544 17.0005
R4427 VGND.t25 VGND.n647 17.0005
R4428 VGND.t25 VGND.n166 14.5493
R4429 VGND.t25 VGND.n641 17.0005
R4430 VGND.t25 VGND.n646 17.0005
R4431 VGND.t25 VGND.n642 17.0005
R4432 VGND.t25 VGND.n645 17.0005
R4433 VGND.t25 VGND.n643 17.0005
R4434 VGND.t25 VGND.n644 17.0005
R4435 VGND.t25 VGND.n143 1.93558
R4436 VGND.t1544 VGND.t1213 16.6672
R4437 VGND.t578 VGND.t391 16.6672
R4438 VGND.t1416 VGND.t792 16.6672
R4439 VGND.t82 VGND.t710 16.6672
R4440 VGND.t422 VGND.t314 16.6672
R4441 VGND.t1201 VGND.t144 16.6672
R4442 VGND.t772 VGND.t793 16.6672
R4443 VGND.t97 VGND.t1043 16.6672
R4444 VGND.t932 VGND.t703 16.6672
R4445 VGND.t1604 VGND.t653 16.6672
R4446 VGND.t775 VGND.t700 16.6672
R4447 VGND.t887 VGND.t146 16.6672
R4448 VGND.t134 VGND.t18 16.6672
R4449 VGND.t369 VGND.n595 16.5751
R4450 VGND.n14 VGND.t369 2.05075
R4451 VGND.t35 VGND.t1434 16.2739
R4452 VGND.t466 VGND.t155 15.7607
R4453 VGND.t854 VGND.t30 2.32584
R4454 VGND.t142 VGND.t30 0.373977
R4455 VGND.n445 VGND.t677 14.7788
R4456 VGND.t813 VGND.n420 14.7788
R4457 VGND.n537 VGND.t950 14.3531
R4458 VGND.t247 VGND.t44 14.0028
R4459 VGND.t153 VGND.t466 13.9066
R4460 VGND.t693 VGND.n262 12.8945
R4461 VGND.n296 VGND.n293 12.8945
R4462 VGND.n703 VGND.n702 12.8945
R4463 VGND.t149 VGND.t382 12.8576
R4464 VGND.n365 VGND.t269 12.8576
R4465 VGND.t785 VGND.n493 12.8576
R4466 VGND.n769 VGND.t1242 12.8576
R4467 VGND.t538 VGND.t724 12.8576
R4468 VGND.t764 VGND.n734 12.8576
R4469 VGND.t1027 VGND.n733 12.8576
R4470 VGND.t338 VGND.n530 12.8576
R4471 VGND.n662 VGND.t1106 12.8576
R4472 VGND.t35 VGND.n430 12.6484
R4473 VGND.t353 VGND.t858 12.5353
R4474 VGND.t1554 VGND.n334 12.5005
R4475 VGND.n804 VGND.t1185 12.5005
R4476 VGND.n709 VGND.t333 12.5005
R4477 VGND.n518 VGND.t969 12.5005
R4478 VGND.n579 VGND.t801 12.5005
R4479 VGND.n604 VGND.t880 12.5005
R4480 VGND.t547 VGND.t394 12.0524
R4481 VGND.t1449 VGND.t433 11.0979
R4482 VGND.t1223 VGND.n497 10.4172
R4483 VGND.t1489 VGND.t1323 9.38833
R4484 VGND.n135 VGND.n105 1.0981
R4485 VGND.t676 VGND.t579 8.59649
R4486 VGND.n559 VGND.n558 8.59649
R4487 VGND.t1427 VGND.n246 8.57193
R4488 VGND.n475 VGND.t1451 8.57193
R4489 VGND.t671 VGND.n763 8.57193
R4490 VGND.t1165 VGND.t1600 8.57193
R4491 VGND.t987 VGND.t1402 8.57193
R4492 VGND.t1023 VGND.n643 8.57193
R4493 VGND.t121 VGND.t0 0.790793
R4494 VGND.n116 VGND.t15 0.708805
R4495 VGND.t25 VGND.t280 0.416317
R4496 VGND.n237 VGND.t35 1.98978
R4497 VGND.t0 VGND.t246 4.251
R4498 VGND.n102 VGND.t0 1.38502
R4499 VGND.t238 VGND.n238 0.748624
R4500 VGND.n120 VGND.t35 0.569151
R4501 VGND.n117 VGND.t35 0.316864
R4502 VGND.n832 VGND.t77 0.498022
R4503 VGND.t324 VGND.t1525 0.756962
R4504 VGND.t566 VGND.t77 1.88952
R4505 VGND.t226 VGND.t77 2.83436
R4506 VGND.n122 VGND.t77 1.12466
R4507 VGND.t50 VGND.t861 0.446906
R4508 VGND.n244 VGND.t30 2.01795
R4509 VGND.t1008 VGND.n242 7.46822
R4510 VGND.t25 VGND.t95 0.456516
R4511 VGND.t64 VGND.t25 0.564294
R4512 VGND.t278 VGND.n123 0.593198
R4513 VGND.n123 VGND.t25 0.630107
R4514 VGND.n212 VGND.t0 0.728315
R4515 VGND.n219 VGND.t0 2.72093
R4516 VGND.n208 VGND.t0 4.177
R4517 VGND.n208 VGND.t1016 0.119605
R4518 VGND.t1015 VGND.t0 8.47111
R4519 VGND.n226 VGND.t0 3.30696
R4520 VGND.t0 VGND.n227 3.30696
R4521 VGND.t0 VGND.n228 3.30696
R4522 VGND.n217 VGND.t0 1.97612
R4523 VGND.n98 VGND.t322 1.126
R4524 VGND.t0 VGND.n224 3.30696
R4525 VGND.t0 VGND.n225 3.30688
R4526 VGND.n211 VGND.t0 3.30688
R4527 VGND.t358 VGND.n239 0.897579
R4528 VGND.n100 VGND.t0 0.693206
R4529 VGND.t77 VGND.n110 0.77419
R4530 VGND.n206 VGND.t77 2.72093
R4531 VGND.t465 VGND.n206 0.235242
R4532 VGND.t396 VGND.n194 0.291546
R4533 VGND.n121 VGND.t567 0.177814
R4534 VGND.t324 VGND.t77 0.435994
R4535 VGND.t54 VGND.n6 0.0726209
R4536 VGND.t50 VGND.n6 0.274238
R4537 VGND.n218 VGND.t30 1.97616
R4538 VGND.t259 VGND.n218 0.346365
R4539 VGND.n207 VGND.t30 0.462485
R4540 VGND.t739 VGND.n243 0.549252
R4541 VGND.t664 VGND.n44 0.562817
R4542 VGND.t1490 VGND.t30 0.385336
R4543 VGND.t96 VGND.t332 1.16996
R4544 VGND.n220 VGND.t25 0.32655
R4545 VGND.t25 VGND.n125 0.400022
R4546 VGND.t155 VGND.t395 8.34413
R4547 VGND.t610 VGND.t1383 8.33383
R4548 VGND.n375 VGND.t479 8.33383
R4549 VGND.n712 VGND.t1299 8.33383
R4550 VGND.n635 VGND.t272 7.813
R4551 VGND.t1222 VGND.n500 7.38057
R4552 VGND.n451 VGND.t76 7.1604
R4553 VGND.n362 VGND.t618 7.1604
R4554 VGND.t1148 VGND.t53 7.1604
R4555 VGND.t1076 VGND.t1254 7.1604
R4556 VGND.t68 VGND.t1036 7.1604
R4557 VGND.t345 VGND.t1489 7.04138
R4558 VGND.t339 VGND.t586 5.8679
R4559 VGND.n14 VGND.t0 0.433911
R4560 VGND.t89 VGND.t0 0.627707
R4561 VGND.t6 VGND.t77 1.88906
R4562 VGND.n371 VGND.t77 2.42887
R4563 VGND.t105 VGND.t50 1.1336
R4564 VGND.t331 VGND.t30 1.88937
R4565 VGND.t654 VGND.t25 1.88866
R4566 VGND.t202 VGND.t50 0.453884
R4567 VGND.n221 VGND.t50 0.294098
R4568 VGND.t68 VGND.n556 5.66088
R4569 VGND.n557 VGND.n556 5.66088
R4570 VGND.n43 VGND.t141 0.0580684
R4571 VGND.t996 VGND.t0 5.61485
R4572 VGND.t3 VGND.n217 0.286491
R4573 VGND.n216 VGND.t0 3.30688
R4574 VGND.n192 VGND.t0 2.7209
R4575 VGND.t90 VGND.n192 0.175554
R4576 VGND.n225 VGND.t1594 0.118323
R4577 VGND.t741 VGND.n211 0.118323
R4578 VGND.t69 VGND.t0 5.61485
R4579 VGND.t77 VGND.t467 5.61485
R4580 VGND.t77 VGND.n194 2.29758
R4581 VGND.n121 VGND.t77 3.30696
R4582 VGND.t608 VGND.t77 1.12033
R4583 VGND.n113 VGND.t50 0.686133
R4584 VGND.t30 VGND.n195 2.15299
R4585 VGND.n508 VGND.t30 5.61485
R4586 VGND.t52 VGND.n44 0.357842
R4587 VGND.t145 VGND.n41 0.85327
R4588 VGND.n97 VGND.t128 0.551648
R4589 VGND.t280 VGND.t278 1.1085
R4590 VGND.n362 VGND.n361 5.54579
R4591 VGND.t105 VGND.t199 5.47495
R4592 VGND.t426 VGND.t1005 5.47495
R4593 VGND.t195 VGND.t255 5.28116
R4594 VGND.t586 VGND.t696 5.28116
R4595 VGND.n640 VGND.t117 5.16578
R4596 VGND.n826 VGND.t160 5.16578
R4597 VGND.t20 VGND.n106 5.16578
R4598 VGND.n104 VGND.t119 5.16578
R4599 VGND.n103 VGND.t40 5.16578
R4600 VGND.t276 VGND.t904 5.15293
R4601 VGND.t300 VGND.t291 5.15293
R4602 VGND.t278 VGND.n640 4.5005
R4603 VGND.t1490 VGND.n108 4.5005
R4604 VGND.n108 VGND.t861 4.5005
R4605 VGND.t150 VGND 4.5005
R4606 VGND.t32 VGND 4.5005
R4607 VGND.t65 VGND.n106 4.5005
R4608 VGND.t203 VGND.n107 4.5005
R4609 VGND.t54 VGND.n107 4.5005
R4610 VGND.t137 VGND.n826 4.5005
R4611 VGND.n103 VGND.t96 4.5005
R4612 VGND.n105 VGND.t179 4.5005
R4613 VGND.t1510 VGND.n105 4.5005
R4614 VGND.n104 VGND.t1525 4.5005
R4615 VGND.n107 VGND.n135 3.2981
R4616 VGND.n281 VGND.t1578 4.29849
R4617 VGND.t1116 VGND.n315 4.29849
R4618 VGND.t1687 VGND.n307 4.29849
R4619 VGND.n397 VGND.t541 4.28621
R4620 VGND.t1138 VGND.n752 4.28621
R4621 VGND.n749 VGND.t1393 4.28621
R4622 VGND.t530 VGND.n790 4.28621
R4623 VGND.t1084 VGND.t659 4.28621
R4624 VGND.n722 VGND.t982 4.28621
R4625 VGND.t1003 VGND.n544 4.28621
R4626 VGND.t452 VGND.t906 4.28621
R4627 VGND.t285 VGND.n616 4.28621
R4628 VGND.t891 VGND.n613 4.28621
R4629 VGND.t76 VGND.t77 4.251
R4630 VGND.t24 VGND.t25 4.251
R4631 VGND.t25 VGND.t1076 4.251
R4632 VGND.t0 VGND.t1211 4.2505
R4633 VGND.t0 VGND.t1036 4.2505
R4634 VGND.t618 VGND.t77 4.2505
R4635 VGND.t50 VGND.t1342 4.2505
R4636 VGND.t50 VGND.t1148 4.2505
R4637 VGND.t483 VGND.n387 4.16717
R4638 VGND.n806 VGND.t1421 4.16717
R4639 VGND.n520 VGND.t584 4.16717
R4640 VGND.n581 VGND.t799 4.16717
R4641 VGND.n594 VGND.t366 4.16717
R4642 VGND.n606 VGND.t1042 4.16717
R4643 VGND.t272 VGND.t0 3.95834
R4644 VGND.n302 VGND.n301 3.90675
R4645 VGND.t878 VGND.t153 3.70878
R4646 VGND.t1159 VGND.n195 0.0723845
R4647 VGND.t566 VGND.n331 3.50108
R4648 VGND.t105 VGND.t53 3.50108
R4649 VGND.t331 VGND.n808 3.50108
R4650 VGND.t1254 VGND.t426 3.50108
R4651 VGND.n704 VGND.t64 3.50108
R4652 VGND.t654 VGND.n522 3.50108
R4653 VGND.t81 VGND.t68 3.50108
R4654 VGND.n571 VGND.t89 3.50108
R4655 VGND.n14 VGND.n596 2.53375
R4656 VGND.n15 VGND.t0 1.06759
R4657 VGND.n780 VGND.t30 3.06209
R4658 VGND.t8 VGND.t399 2.89067
R4659 VGND.t0 VGND.n556 2.83383
R4660 VGND.n361 VGND.t77 2.83383
R4661 VGND.t1493 VGND.n244 0.0828453
R4662 VGND.n237 VGND.t174 0.410223
R4663 VGND.t35 VGND.n419 2.72109
R4664 VGND.n341 VGND.t77 2.42907
R4665 VGND.t30 VGND.n814 2.42907
R4666 VGND.t51 VGND.t345 2.34746
R4667 VGND.t1323 VGND.t195 2.34746
R4668 VGND.t50 VGND.n302 2.1255
R4669 VGND.t255 VGND.t339 1.76072
R4670 VGND.n102 VGND.t62 0.0814732
R4671 VGND.t205 VGND.n122 0.672253
R4672 VGND.t131 VGND.t664 1.56707
R4673 VGND.n111 VGND.t35 0.512216
R4674 VGND.t30 VGND.n243 1.20449
R4675 VGND.n114 VGND.t268 0.255363
R4676 VGND.t535 VGND.t131 1.34669
R4677 VGND.t193 VGND.t674 1.32911
R4678 VGND.t25 VGND.n537 1.32495
R4679 VGND.t25 VGND.t418 1.32228
R4680 VGND.t72 VGND.n635 1.28861
R4681 VGND.t1619 VGND.t508 1.28581
R4682 VGND.t13 VGND.t112 1.23808
R4683 VGND.t235 VGND.n111 0.848335
R4684 VGND.t45 VGND.n220 1.02729
R4685 VGND.n116 VGND.t77 0.415648
R4686 VGND.t35 VGND.n429 1.20435
R4687 VGND.t350 VGND.t30 0.42378
R4688 VGND.t608 VGND.t478 1.19611
R4689 VGND.t856 VGND.t803 1.19546
R4690 VGND.t393 VGND.n101 0.552035
R4691 VGND.t365 VGND.t411 1.18134
R4692 VGND.t453 VGND.t25 1.00647
R4693 VGND.n418 VGND.t235 1.1482
R4694 VGND.n418 VGND.t101 1.13933
R4695 VGND.t426 VGND.t25 1.13433
R4696 VGND.t399 VGND.t77 1.13383
R4697 VGND.t756 VGND.n421 1.13183
R4698 VGND.t25 VGND.n41 0.400968
R4699 VGND.t126 VGND.t128 1.11065
R4700 VGND.t45 VGND.n689 1.10601
R4701 VGND.n449 VGND.t174 1.09009
R4702 VGND.t293 VGND.n113 0.159912
R4703 VGND.t106 VGND.t50 0.339203
R4704 VGND.t1619 VGND.t38 1.07484
R4705 VGND.n239 VGND.t312 1.13968
R4706 VGND.n464 VGND.t11 1.07299
R4707 VGND.t1510 VGND.n45 0.387884
R4708 VGND.t77 VGND.t71 0.408843
R4709 VGND.t30 VGND.t824 0.382224
R4710 VGND.n16 VGND.t205 1.2145
R4711 VGND.n5 VGND.t133 0.375537
R4712 VGND.t191 VGND.n41 0.418555
R4713 VGND.t77 VGND.n16 0.212527
R4714 VGND.n450 VGND.t176 1.03069
R4715 VGND.t115 VGND.n16 0.471984
R4716 VGND.t176 VGND.n449 1.02619
R4717 VGND.t50 VGND.n114 0.536209
R4718 VGND.n421 VGND.t172 1.00486
R4719 VGND.t172 VGND.n423 1.00345
R4720 VGND.t316 VGND.t50 0.459033
R4721 VGND.t77 VGND.t17 0.292632
R4722 VGND.t93 VGND.n216 1.14207
R4723 VGND.t312 VGND.t856 0.95526
R4724 VGND.n464 VGND.t499 0.955042
R4725 VGND.n832 VGND.t147 0.92757
R4726 VGND.t202 VGND.t53 0.92757
R4727 VGND.t630 VGND.t418 0.927371
R4728 VGND.n212 VGND.t299 0.762573
R4729 VGND.t341 VGND.n28 1.13175
R4730 VGND.t179 VGND.t30 1.1834
R4731 VGND.t11 VGND.t13 0.908025
R4732 VGND.t197 VGND.n689 0.907483
R4733 VGND.t93 VGND.n238 0.0713396
R4734 VGND.n212 VGND.t273 1.12315
R4735 VGND.t143 VGND.n5 0.70295
R4736 VGND.t453 VGND.t1033 0.855798
R4737 VGND.n120 VGND.t119 0.667823
R4738 VGND.t165 VGND.t167 0.835434
R4739 VGND.n123 VGND.t1033 0.124388
R4740 VGND.t35 VGND.t167 0.800406
R4741 VGND.t0 VGND.n238 0.667697
R4742 VGND.n626 VGND.t273 0.800027
R4743 VGND.n501 VGND.t50 0.745378
R4744 VGND.n504 VGND.t50 0.745378
R4745 VGND.t50 VGND.n57 0.742871
R4746 VGND.t25 VGND.n29 0.742871
R4747 VGND.n120 VGND.t365 0.0869084
R4748 VGND.t35 VGND.n423 0.727632
R4749 VGND.t77 VGND.t13 0.727587
R4750 VGND.n498 VGND.t50 0.726955
R4751 VGND.t0 VGND.t72 0.708833
R4752 VGND.n775 VGND.t30 0.704985
R4753 VGND.t535 VGND.n243 0.372911
R4754 VGND.t50 VGND.n49 0.68391
R4755 VGND.n742 VGND.t30 0.68391
R4756 VGND.n821 VGND.t30 0.68391
R4757 VGND.t25 VGND.n40 0.68391
R4758 VGND.t25 VGND.n32 0.68391
R4759 VGND.t0 VGND.n12 0.666899
R4760 VGND.t0 VGND.n11 0.666899
R4761 VGND.t0 VGND.n8 0.666899
R4762 VGND.n389 VGND.t77 0.666899
R4763 VGND.n384 VGND.t77 0.666899
R4764 VGND.n351 VGND.t77 0.666899
R4765 VGND.n826 VGND.n107 0.66578
R4766 VGND.n105 VGND.n103 0.66578
R4767 VGND.t0 VGND.n10 0.665193
R4768 VGND.t0 VGND.n7 0.664341
R4769 VGND.t83 VGND.n207 1.09099
R4770 VGND.t77 VGND.n21 0.662634
R4771 VGND.n615 VGND.t0 0.649813
R4772 VGND.t1051 VGND.n154 77.2385
R4773 VGND.t0 VGND.n13 0.649813
R4774 VGND.n393 VGND.t77 0.649813
R4775 VGND.t77 VGND.n20 0.649813
R4776 VGND.t77 VGND.n19 0.649813
R4777 VGND.n406 VGND.t77 0.649813
R4778 VGND.n405 VGND.t77 0.649813
R4779 VGND.n398 VGND.t77 0.649813
R4780 VGND.t77 VGND.n26 0.649813
R4781 VGND.t77 VGND.n25 0.649813
R4782 VGND.t77 VGND.n24 0.649813
R4783 VGND.t77 VGND.n23 0.649813
R4784 VGND.t77 VGND.n22 0.649813
R4785 VGND.n366 VGND.t77 0.649813
R4786 VGND.n368 VGND.t77 0.649813
R4787 VGND.t77 VGND.n17 0.359408
R4788 VGND.t77 VGND.n18 0.649813
R4789 VGND.t50 VGND.n46 0.649813
R4790 VGND.t50 VGND.n47 0.649813
R4791 VGND.t50 VGND.n48 0.369516
R4792 VGND.t50 VGND.n65 0.649813
R4793 VGND.t50 VGND.n64 0.649813
R4794 VGND.t50 VGND.n63 0.649813
R4795 VGND.t50 VGND.n62 0.649813
R4796 VGND.n744 VGND.t30 0.649813
R4797 VGND.n760 VGND.t30 0.649813
R4798 VGND.n764 VGND.t30 0.649813
R4799 VGND.t30 VGND.n1 0.359547
R4800 VGND.t30 VGND.n2 0.649813
R4801 VGND.t30 VGND.n4 0.649813
R4802 VGND.t30 VGND.n3 0.649813
R4803 VGND.t25 VGND.n39 0.649813
R4804 VGND.t25 VGND.n38 0.649813
R4805 VGND.t25 VGND.n30 0.649813
R4806 VGND.t25 VGND.n34 0.649813
R4807 VGND.t25 VGND.n31 0.649813
R4808 VGND.t25 VGND.n33 0.649813
R4809 VGND.t25 VGND.n35 0.369499
R4810 VGND.t25 VGND.n37 0.649813
R4811 VGND.t25 VGND.n36 0.649813
R4812 VGND.n626 VGND.t73 0.649263
R4813 VGND.t0 VGND.n9 0.648101
R4814 VGND.t50 VGND.n56 0.648101
R4815 VGND.t50 VGND.n60 0.648101
R4816 VGND.t50 VGND.n61 0.648101
R4817 VGND.t50 VGND.n55 0.648101
R4818 VGND.t50 VGND.n54 0.648101
R4819 VGND.t50 VGND.n50 0.648101
R4820 VGND.t50 VGND.n51 0.648101
R4821 VGND.t50 VGND.n52 0.648101
R4822 VGND.t50 VGND.n53 0.648101
R4823 VGND.t50 VGND.n58 0.648101
R4824 VGND.t50 VGND.n59 0.648101
R4825 VGND.t38 VGND.n429 0.647771
R4826 VGND.t1546 VGND.n130 57.341
R4827 VGND.t112 VGND.n409 0.634035
R4828 VGND.n111 VGND.t160 0.260656
R4829 VGND.t58 VGND.n114 0.243219
R4830 VGND.t167 VGND.t508 0.605111
R4831 VGND.t0 VGND.n239 0.505421
R4832 VGND.t299 VGND.t62 0.598949
R4833 VGND.n450 VGND.t377 0.597766
R4834 VGND.t30 VGND.n0 0.482363
R4835 VGND.t696 VGND.t194 0.58724
R4836 VGND.n423 VGND.t411 0.585028
R4837 VGND.t25 VGND.n689 0.553338
R4838 VGND.t77 VGND.n409 0.552389
R4839 VGND.n125 VGND.t630 0.101123
R4840 VGND.n429 VGND.t363 0.55017
R4841 VGND.n122 VGND.t150 0.356981
R4842 VGND.t35 VGND.n450 0.513583
R4843 VGND.t286 VGND.n102 0.392048
R4844 VGND.t35 VGND.n80 0.473876
R4845 VGND.t35 VGND.n77 0.473876
R4846 VGND.t35 VGND.n95 0.473876
R4847 VGND.t35 VGND.n87 0.473876
R4848 VGND.t165 VGND.n117 1.16544
R4849 VGND.t35 VGND.t1619 0.463189
R4850 VGND.t35 VGND.n449 0.462667
R4851 VGND.t30 VGND.t131 0.462105
R4852 VGND.t0 VGND.n626 0.458855
R4853 VGND.t40 VGND.t238 0.430389
R4854 VGND.t0 VGND.t856 0.423113
R4855 VGND.n101 VGND.t478 0.213409
R4856 VGND.n100 VGND.t728 0.530604
R4857 VGND.n237 VGND.t216 0.299133
R4858 VGND.t35 VGND.n81 0.392316
R4859 VGND.t35 VGND.n79 0.392316
R4860 VGND.t35 VGND.n96 0.392316
R4861 VGND.t35 VGND.n88 0.392316
R4862 VGND.t77 VGND.n464 0.390287
R4863 VGND.t35 VGND.n82 0.389775
R4864 VGND.t35 VGND.n66 0.389775
R4865 VGND.t35 VGND.n76 0.389775
R4866 VGND.t35 VGND.n75 0.389775
R4867 VGND.t35 VGND.n67 0.389775
R4868 VGND.t35 VGND.n68 0.389775
R4869 VGND.t35 VGND.n74 0.389775
R4870 VGND.t35 VGND.n73 0.389775
R4871 VGND.t35 VGND.n69 0.389775
R4872 VGND.t35 VGND.n70 0.389775
R4873 VGND.t35 VGND.n72 0.389775
R4874 VGND.t35 VGND.n71 0.389775
R4875 VGND.t35 VGND.n94 0.389775
R4876 VGND.t35 VGND.n90 0.389775
R4877 VGND.t35 VGND.n86 0.242118
R4878 VGND.t35 VGND.n85 0.389775
R4879 VGND.t35 VGND.n83 0.389775
R4880 VGND.t35 VGND.n84 0.389775
R4881 VGND.t32 VGND.t363 1.41155
R4882 VGND.n132 VGND.t1629 253.906
R4883 VGND.t35 VGND.n78 0.333543
R4884 VGND.n149 VGND.t752 253.906
R4885 VGND VGND.n135 2.2005
R4886 VGND.t203 VGND.n28 0.761067
R4887 VGND.t65 VGND.n97 0.386142
R4888 VGND.t25 VGND.t332 1.54967
R4889 VGND.t1525 VGND.t393 1.42353
R4890 VGND.n117 VGND.t119 1.37723
R4891 VGND.n107 VGND.n106 1.33575
R4892 VGND.n105 VGND.n104 1.33575
R4893 VGND.n640 VGND.n108 1.33324
R4894 VGND.n108 VGND 1.33106
R4895 VGND.t17 VGND.t137 1.24832
R4896 VGND.t324 VGND.t553 1.24144
R4897 VGND.n100 VGND.t117 0.122165
R4898 VGND.t35 VGND.n93 0.387948
R4899 VGND.t35 VGND.n92 0.333545
R4900 VGND.t35 VGND.n91 0.387948
R4901 VGND.t35 VGND.n89 0.387948
R4902 VGND.n220 VGND.t126 0.0479337
R4903 VGND.n43 VGND.t0 0.887861
R4904 VGND.t203 VGND.t143 1.35145
R4905 VGND.t0 VGND.t20 1.33611
R4906 VGND.n42 VGND.t25 0.229075
R4907 VGND.n98 VGND.t40 1.28774
R4908 VGND.t32 VGND.t35 1.27346
R4909 VGND.t20 VGND.t286 1.26049
R4910 VGND.n44 VGND.t30 1.23924
R4911 VGND.t572 VGND.n45 0.710354
R4912 VGND.t558 VGND.n42 1.32752
R4913 VGND.n28 VGND.t30 1.20576
R4914 VGND.n192 VGND.t91 0.175554
R4915 VGND.t3 VGND.n228 0.478504
R4916 VGND.n43 VGND.t325 0.286907
R4917 VGND.t996 VGND.t325 0.360471
R4918 VGND.t741 VGND.t1594 0.360471
R4919 VGND.t35 VGND.n418 0.356606
R4920 VGND.t35 VGND.n421 0.355581
R4921 VGND.t756 VGND.n419 0.349908
R4922 VGND.n419 VGND.t101 0.346535
R4923 VGND.n244 VGND.t83 0.253835
R4924 VGND.t803 VGND.n211 0.17801
R4925 VGND.t154 VGND.n110 0.0677174
R4926 VGND.n195 VGND.t201 0.412778
R4927 VGND.n216 VGND.t88 0.478633
R4928 VGND.n508 VGND.t341 0.301114
R4929 VGND.t728 VGND.t69 0.301114
R4930 VGND.t88 VGND.n217 0.286827
R4931 VGND.t995 VGND.t996 0.301114
R4932 VGND.t842 VGND.n226 0.418807
R4933 VGND.t874 VGND.n227 0.418807
R4934 VGND.t1014 VGND.t90 0.301114
R4935 VGND.t357 VGND.n224 0.418807
R4936 VGND.n225 VGND.t357 0.17801
R4937 VGND.t467 VGND.t156 0.301114
R4938 VGND.t259 VGND.n508 0.300775
R4939 VGND.t553 VGND.n121 0.118193
R4940 VGND.t69 VGND.t358 0.300775
R4941 VGND.n226 VGND.t491 0.177814
R4942 VGND.n227 VGND.t842 0.177814
R4943 VGND.n228 VGND.t874 0.177814
R4944 VGND.t91 VGND.t322 0.300775
R4945 VGND.n224 VGND.t1014 0.177814
R4946 VGND.t359 VGND.t467 0.300775
R4947 VGND.n194 VGND.t462 0.291727
R4948 VGND.t179 VGND.t1493 0.287569
R4949 VGND.n206 VGND.t359 0.235599
R4950 VGND.t851 VGND.n6 1.17132
R4951 VGND.t96 VGND.n42 0.480382
R4952 VGND.t558 VGND.n125 1.05722
R4953 VGND.t491 VGND.t1015 0.241078
R4954 VGND.t201 VGND.n218 0.346659
R4955 VGND.t739 VGND.t86 0.241078
R4956 VGND.n207 VGND.t86 0.928408
R4957 VGND.n219 VGND.t995 0.235242
R4958 VGND.t1015 VGND.t1016 0.241078
R4959 VGND.n208 VGND.t800 0.360183
R4960 VGND.t800 VGND.n219 0.235599
R4961 VGND.t851 VGND.n113 0.595629
R4962 VGND.t156 VGND.n110 0.390777
R4963 VGND.t462 VGND.t465 0.241078
R4964 VGND.t396 VGND.t567 0.241078
R4965 VGND.t254 VGND.t50 0.533148
R4966 VGND.n97 VGND.t25 0.268428
R4967 VGND.n409 VGND.t137 1.01308
R4968 VGND.t150 VGND.n116 1.10865
R4969 VGND.n101 VGND.t77 1.10626
R4970 VGND.n108 VGND 1.09545
R4971 VGND.t0 VGND.n98 1.08635
R4972 VGND.t50 VGND.t632 1.08177
R4973 VGND.n5 VGND.t30 0.330872
R4974 VGND.t50 VGND.n45 0.354707
R4975 VGND.t449 VGND.t50 1.01786
R4976 VGND.t216 VGND.t160 1.01328
R4977 sg13cmos5l_buf_1_1.X.t2 sg13cmos5l_buf_1_1.X.t1 33.4028
R4978 sg13cmos5l_buf_1_1.X.t10 sg13cmos5l_buf_1_1.X.t9 33.4028
R4979 sg13cmos5l_buf_1_1.X.t13 sg13cmos5l_buf_1_1.X.t12 33.4028
R4980 sg13cmos5l_buf_1_1.X.t3 sg13cmos5l_buf_1_1.X.t4 33.4028
R4981 sg13cmos5l_buf_1_1.X.t8 sg13cmos5l_buf_1_1.X.t7 33.4028
R4982 sg13cmos5l_buf_1_1.X.t15 sg13cmos5l_buf_1_1.X.t14 33.4028
R4983 sg13cmos5l_buf_1_1.X.t5 sg13cmos5l_buf_1_1.X.t6 33.4028
R4984 sg13cmos5l_buf_1_1.X.n1 sg13cmos5l_buf_1_1.X 25.0242
R4985 sg13cmos5l_buf_1_1.X sg13cmos5l_buf_1_1.X.n6 23.0907
R4986 sg13cmos5l_buf_1_1.X.n3 sg13cmos5l_buf_1_1.X 20.2151
R4987 sg13cmos5l_buf_1_1.X.n0 sg13cmos5l_buf_1_1.X 20.0831
R4988 sg13cmos5l_buf_1_1.X.n1 sg13cmos5l_buf_1_1.X 19.1063
R4989 sg13cmos5l_buf_1_1.X.n2 sg13cmos5l_buf_1_1.X 18.7367
R4990 sg13cmos5l_buf_1_1.X.n6 sg13cmos5l_buf_1_1.X 18.3671
R4991 sg13cmos5l_buf_1_1.X.n0 sg13cmos5l_buf_1_1.X 18.1823
R4992 sg13cmos5l_buf_1_1.X sg13cmos5l_buf_1_1.X.t15 15.0489
R4993 sg13cmos5l_buf_1_1.X sg13cmos5l_buf_1_1.X.t8 15.0489
R4994 sg13cmos5l_buf_1_1.X sg13cmos5l_buf_1_1.X.t13 15.0489
R4995 sg13cmos5l_buf_1_1.X sg13cmos5l_buf_1_1.X.t10 15.0489
R4996 sg13cmos5l_buf_1_1.X sg13cmos5l_buf_1_1.X.t2 15.0489
R4997 sg13cmos5l_buf_1_1.X sg13cmos5l_buf_1_1.X.t11 15.0207
R4998 sg13cmos5l_buf_1_1.X sg13cmos5l_buf_1_1.X.t5 15.0005
R4999 sg13cmos5l_buf_1_1.X sg13cmos5l_buf_1_1.X.t3 15.0005
R5000 sg13cmos5l_buf_1_1.X.n4 sg13cmos5l_buf_1_1.X.n0 12.928
R5001 sg13cmos5l_buf_1_1.X.n6 sg13cmos5l_buf_1_1.X.n5 11.9543
R5002 sg13cmos5l_buf_1_1.X.n4 sg13cmos5l_buf_1_1.X.n3 9.6341
R5003 sg13cmos5l_buf_1_1.X.n5 sg13cmos5l_buf_1_1.X 9.04885
R5004 sg13cmos5l_buf_1_1.X.n2 sg13cmos5l_buf_1_1.X.n1 7.6037
R5005 sg13cmos5l_buf_1_1.X sg13cmos5l_buf_1_1.X.t0 5.69515
R5006 sg13cmos5l_buf_1_1.X.n5 sg13cmos5l_buf_1_1.X.n4 2.58466
R5007 sg13cmos5l_buf_1_1.X.n3 sg13cmos5l_buf_1_1.X.n2 1.2677
R5008 sg13cmos5l_buf_1_4.X sg13cmos5l_buf_1_4.X.n3 70.8936
R5009 sg13cmos5l_buf_1_4.X.t4 sg13cmos5l_buf_1_4.X.t3 33.4028
R5010 sg13cmos5l_buf_1_4.X.t2 sg13cmos5l_buf_1_4.X.t1 33.4028
R5011 sg13cmos5l_buf_1_4.X.t6 sg13cmos5l_buf_1_4.X.t5 33.4028
R5012 sg13cmos5l_buf_1_4.X.t10 sg13cmos5l_buf_1_4.X.t9 33.4028
R5013 sg13cmos5l_buf_1_4.X.t8 sg13cmos5l_buf_1_4.X.t7 33.4028
R5014 sg13cmos5l_buf_1_4.X.n2 sg13cmos5l_buf_1_4.X.n1 21.0007
R5015 sg13cmos5l_buf_1_4.X.n2 sg13cmos5l_buf_1_4.X 18.1823
R5016 sg13cmos5l_buf_1_4.X.n3 sg13cmos5l_buf_1_4.X.n2 16.3191
R5017 sg13cmos5l_buf_1_4.X sg13cmos5l_buf_1_4.X.t4 15.0489
R5018 sg13cmos5l_buf_1_4.X sg13cmos5l_buf_1_4.X.t2 15.0489
R5019 sg13cmos5l_buf_1_4.X sg13cmos5l_buf_1_4.X.t6 15.0489
R5020 sg13cmos5l_buf_1_4.X sg13cmos5l_buf_1_4.X.t8 15.0489
R5021 sg13cmos5l_buf_1_4.X sg13cmos5l_buf_1_4.X.t10 15.0489
R5022 sg13cmos5l_buf_1_4.X.n0 sg13cmos5l_buf_1_4.X 14.1309
R5023 sg13cmos5l_buf_1_4.X.n0 sg13cmos5l_buf_1_4.X 9.4229
R5024 sg13cmos5l_buf_1_4.X.n3 sg13cmos5l_buf_1_4.X 9.0005
R5025 sg13cmos5l_buf_1_4.X.n1 sg13cmos5l_buf_1_4.X 9.0005
R5026 sg13cmos5l_buf_1_4.X sg13cmos5l_buf_1_4.X.t0 5.69515
R5027 sg13cmos5l_buf_1_4.X.n1 sg13cmos5l_buf_1_4.X.n0 1.6021
R5028 sg13cmos5l_dfrbpq_1_13.RESET_B.t3 sg13cmos5l_dfrbpq_1_13.RESET_B.t4 33.4028
R5029 sg13cmos5l_dfrbpq_1_13.RESET_B.t2 sg13cmos5l_dfrbpq_1_13.RESET_B.t1 33.4028
R5030 sg13cmos5l_dfrbpq_1_13.RESET_B.t8 sg13cmos5l_dfrbpq_1_13.RESET_B.t7 33.4028
R5031 sg13cmos5l_dfrbpq_1_13.RESET_B.t9 sg13cmos5l_dfrbpq_1_13.RESET_B.t10 33.4028
R5032 sg13cmos5l_dfrbpq_1_13.RESET_B.t14 sg13cmos5l_dfrbpq_1_13.RESET_B.t13 33.4028
R5033 sg13cmos5l_dfrbpq_1_13.RESET_B.t5 sg13cmos5l_dfrbpq_1_13.RESET_B.t6 33.4028
R5034 sg13cmos5l_dfrbpq_1_13.RESET_B.t11 sg13cmos5l_dfrbpq_1_13.RESET_B.t12 33.4028
R5035 sg13cmos5l_dfrbpq_1_13.RESET_B sg13cmos5l_dfrbpq_1_13.RESET_B.n5 32.6437
R5036 sg13cmos5l_dfrbpq_1_13.RESET_B.n1 sg13cmos5l_dfrbpq_1_13.RESET_B 31.5319
R5037 sg13cmos5l_dfrbpq_1_13.RESET_B.n0 sg13cmos5l_dfrbpq_1_13.RESET_B 20.2151
R5038 sg13cmos5l_dfrbpq_1_13.RESET_B.n0 sg13cmos5l_dfrbpq_1_13.RESET_B 19.1546
R5039 sg13cmos5l_dfrbpq_1_13.RESET_B.n3 sg13cmos5l_dfrbpq_1_13.RESET_B 18.785
R5040 sg13cmos5l_dfrbpq_1_13.RESET_B.n1 sg13cmos5l_dfrbpq_1_13.RESET_B 18.4154
R5041 sg13cmos5l_dfrbpq_1_13.RESET_B sg13cmos5l_dfrbpq_1_13.RESET_B.t2 15.0489
R5042 sg13cmos5l_dfrbpq_1_13.RESET_B sg13cmos5l_dfrbpq_1_13.RESET_B.t8 15.0489
R5043 sg13cmos5l_dfrbpq_1_13.RESET_B sg13cmos5l_dfrbpq_1_13.RESET_B.t14 15.0489
R5044 sg13cmos5l_dfrbpq_1_13.RESET_B sg13cmos5l_dfrbpq_1_13.RESET_B.t15 15.016
R5045 sg13cmos5l_dfrbpq_1_13.RESET_B sg13cmos5l_dfrbpq_1_13.RESET_B.t11 15.0005
R5046 sg13cmos5l_dfrbpq_1_13.RESET_B sg13cmos5l_dfrbpq_1_13.RESET_B.t5 15.0005
R5047 sg13cmos5l_dfrbpq_1_13.RESET_B sg13cmos5l_dfrbpq_1_13.RESET_B.t9 15.0005
R5048 sg13cmos5l_dfrbpq_1_13.RESET_B sg13cmos5l_dfrbpq_1_13.RESET_B.t3 15.0005
R5049 sg13cmos5l_dfrbpq_1_13.RESET_B.n2 sg13cmos5l_dfrbpq_1_13.RESET_B.n1 11.8456
R5050 sg13cmos5l_dfrbpq_1_13.RESET_B.n0 sg13cmos5l_dfrbpq_1_13.RESET_B.n2 11.7461
R5051 sg13cmos5l_dfrbpq_1_13.RESET_B.n4 sg13cmos5l_dfrbpq_1_13.RESET_B 10.1063
R5052 sg13cmos5l_dfrbpq_1_13.RESET_B.n2 sg13cmos5l_dfrbpq_1_13.RESET_B 9.78501
R5053 sg13cmos5l_dfrbpq_1_13.RESET_B.n4 sg13cmos5l_dfrbpq_1_13.RESET_B 9.73666
R5054 sg13cmos5l_dfrbpq_1_13.RESET_B.n5 sg13cmos5l_dfrbpq_1_13.RESET_B.n4 9.0005
R5055 sg13cmos5l_dfrbpq_1_13.RESET_B sg13cmos5l_dfrbpq_1_13.RESET_B.t0 5.73774
R5056 sg13cmos5l_dfrbpq_1_13.RESET_B.n3 sg13cmos5l_dfrbpq_1_13.RESET_B.n0 2.9573
R5057 sg13cmos5l_dfrbpq_1_13.RESET_B.n5 sg13cmos5l_dfrbpq_1_13.RESET_B.n3 2.7461
R5058 sg13cmos5l_buf_1_4.A sg13cmos5l_buf_1_4.A.n0 75.6618
R5059 sg13cmos5l_buf_1_4.A.n0 sg13cmos5l_buf_1_4.A 36.1637
R5060 sg13cmos5l_buf_1_4.A.n0 sg13cmos5l_buf_1_4.A 18.0005
R5061 sg13cmos5l_buf_1_4.A sg13cmos5l_buf_1_4.A.t0 17.0317
R5062 sg13cmos5l_buf_1_4.A sg13cmos5l_buf_1_4.A.t2 15.0122
R5063 sg13cmos5l_buf_1_4.A sg13cmos5l_buf_1_4.A.t1 15.0122
R5064 sg13cmos5l_buf_1_4.A.t0 sg13cmos5l_buf_1_4.A 8.62605
R5065 sg13cmos5l_dfrbpq_1_53.RESET_B sg13cmos5l_dfrbpq_1_53.RESET_B.n3 67.3651
R5066 sg13cmos5l_dfrbpq_1_53.RESET_B.t8 sg13cmos5l_dfrbpq_1_53.RESET_B.t7 33.4028
R5067 sg13cmos5l_dfrbpq_1_53.RESET_B.t2 sg13cmos5l_dfrbpq_1_53.RESET_B.t1 33.4028
R5068 sg13cmos5l_dfrbpq_1_53.RESET_B.t4 sg13cmos5l_dfrbpq_1_53.RESET_B.t3 33.4028
R5069 sg13cmos5l_dfrbpq_1_53.RESET_B.t6 sg13cmos5l_dfrbpq_1_53.RESET_B.t5 33.4028
R5070 sg13cmos5l_dfrbpq_1_53.RESET_B.t10 sg13cmos5l_dfrbpq_1_53.RESET_B.t9 33.4028
R5071 sg13cmos5l_dfrbpq_1_53.RESET_B.n1 sg13cmos5l_dfrbpq_1_53.RESET_B 28.6607
R5072 sg13cmos5l_dfrbpq_1_53.RESET_B.n3 sg13cmos5l_dfrbpq_1_53.RESET_B 18.5519
R5073 sg13cmos5l_dfrbpq_1_53.RESET_B sg13cmos5l_dfrbpq_1_53.RESET_B.t0 17.0317
R5074 sg13cmos5l_dfrbpq_1_53.RESET_B sg13cmos5l_dfrbpq_1_53.RESET_B.t2 15.0489
R5075 sg13cmos5l_dfrbpq_1_53.RESET_B sg13cmos5l_dfrbpq_1_53.RESET_B.t4 15.0489
R5076 sg13cmos5l_dfrbpq_1_53.RESET_B sg13cmos5l_dfrbpq_1_53.RESET_B.t10 15.0489
R5077 sg13cmos5l_dfrbpq_1_53.RESET_B sg13cmos5l_dfrbpq_1_53.RESET_B.t6 15.0489
R5078 sg13cmos5l_dfrbpq_1_53.RESET_B sg13cmos5l_dfrbpq_1_53.RESET_B.t8 15.0489
R5079 sg13cmos5l_dfrbpq_1_53.RESET_B.n0 sg13cmos5l_dfrbpq_1_53.RESET_B 10.4789
R5080 sg13cmos5l_dfrbpq_1_53.RESET_B.n2 sg13cmos5l_dfrbpq_1_53.RESET_B 9.92146
R5081 sg13cmos5l_dfrbpq_1_53.RESET_B.n3 sg13cmos5l_dfrbpq_1_53.RESET_B.n2 9.8453
R5082 sg13cmos5l_dfrbpq_1_53.RESET_B.t0 sg13cmos5l_dfrbpq_1_53.RESET_B 9.34537
R5083 sg13cmos5l_dfrbpq_1_53.RESET_B.n0 sg13cmos5l_dfrbpq_1_53.RESET_B 9.0005
R5084 sg13cmos5l_dfrbpq_1_53.RESET_B.n1 sg13cmos5l_dfrbpq_1_53.RESET_B.n0 3.50866
R5085 sg13cmos5l_dfrbpq_1_53.RESET_B.n2 sg13cmos5l_dfrbpq_1_53.RESET_B.n1 2.21202
R5086 sg13cmos5l_buf_1_0.X sg13cmos5l_buf_1_0.X.n5 40.0391
R5087 sg13cmos5l_buf_1_0.X.n3 sg13cmos5l_buf_1_0.X 38.605
R5088 sg13cmos5l_buf_1_0.X.t10 sg13cmos5l_buf_1_0.X.t11 33.4028
R5089 sg13cmos5l_buf_1_0.X.t12 sg13cmos5l_buf_1_0.X.t13 33.4028
R5090 sg13cmos5l_buf_1_0.X.t9 sg13cmos5l_buf_1_0.X.t8 33.4028
R5091 sg13cmos5l_buf_1_0.X.t3 sg13cmos5l_buf_1_0.X.t2 33.4028
R5092 sg13cmos5l_buf_1_0.X.t7 sg13cmos5l_buf_1_0.X.t6 33.4028
R5093 sg13cmos5l_buf_1_0.X.t15 sg13cmos5l_buf_1_0.X.t14 33.4028
R5094 sg13cmos5l_buf_1_0.X.t5 sg13cmos5l_buf_1_0.X.t4 33.4028
R5095 sg13cmos5l_buf_1_0.X.n4 sg13cmos5l_buf_1_0.X 29.7167
R5096 sg13cmos5l_buf_1_0.X sg13cmos5l_buf_1_0.X.t3 15.0489
R5097 sg13cmos5l_buf_1_0.X sg13cmos5l_buf_1_0.X.t7 15.0489
R5098 sg13cmos5l_buf_1_0.X sg13cmos5l_buf_1_0.X.t15 15.0489
R5099 sg13cmos5l_buf_1_0.X sg13cmos5l_buf_1_0.X.t5 15.0489
R5100 sg13cmos5l_buf_1_0.X sg13cmos5l_buf_1_0.X.t9 15.0489
R5101 sg13cmos5l_buf_1_0.X sg13cmos5l_buf_1_0.X.t1 15.016
R5102 sg13cmos5l_buf_1_0.X sg13cmos5l_buf_1_0.X.t10 15.0005
R5103 sg13cmos5l_buf_1_0.X sg13cmos5l_buf_1_0.X.t12 15.0005
R5104 sg13cmos5l_buf_1_0.X.n0 sg13cmos5l_buf_1_0.X 12.8783
R5105 sg13cmos5l_buf_1_0.X.n2 sg13cmos5l_buf_1_0.X.n0 12.5909
R5106 sg13cmos5l_buf_1_0.X.n1 sg13cmos5l_buf_1_0.X 10.8969
R5107 sg13cmos5l_buf_1_0.X.n0 sg13cmos5l_buf_1_0.X 10.8485
R5108 sg13cmos5l_buf_1_0.X.n4 sg13cmos5l_buf_1_0.X.n3 10.1032
R5109 sg13cmos5l_buf_1_0.X.n0 sg13cmos5l_buf_1_0.X 9.92146
R5110 sg13cmos5l_buf_1_0.X.n2 sg13cmos5l_buf_1_0.X.n1 9.55186
R5111 sg13cmos5l_buf_1_0.X.n1 sg13cmos5l_buf_1_0.X 9.04885
R5112 sg13cmos5l_buf_1_0.X.n5 sg13cmos5l_buf_1_0.X 9.0005
R5113 sg13cmos5l_buf_1_0.X.n5 sg13cmos5l_buf_1_0.X.n4 8.64786
R5114 sg13cmos5l_buf_1_0.X sg13cmos5l_buf_1_0.X.t0 5.73774
R5115 sg13cmos5l_buf_1_0.X.n3 sg13cmos5l_buf_1_0.X.n2 3.1685
R5116 sg13cmos5l_dfrbpq_1_57.RESET_B.t14 sg13cmos5l_dfrbpq_1_57.RESET_B.t13 33.4028
R5117 sg13cmos5l_dfrbpq_1_57.RESET_B.t10 sg13cmos5l_dfrbpq_1_57.RESET_B.t9 33.4028
R5118 sg13cmos5l_dfrbpq_1_57.RESET_B.t0 sg13cmos5l_dfrbpq_1_57.RESET_B.t1 33.4028
R5119 sg13cmos5l_dfrbpq_1_57.RESET_B.t4 sg13cmos5l_dfrbpq_1_57.RESET_B.t5 33.4028
R5120 sg13cmos5l_dfrbpq_1_57.RESET_B.t11 sg13cmos5l_dfrbpq_1_57.RESET_B.t12 33.4028
R5121 sg13cmos5l_dfrbpq_1_57.RESET_B.t8 sg13cmos5l_dfrbpq_1_57.RESET_B.t7 33.4028
R5122 sg13cmos5l_dfrbpq_1_57.RESET_B.t3 sg13cmos5l_dfrbpq_1_57.RESET_B.t2 33.4028
R5123 sg13cmos5l_dfrbpq_1_57.RESET_B sg13cmos5l_dfrbpq_1_57.RESET_B.n5 30.5933
R5124 sg13cmos5l_dfrbpq_1_57.RESET_B.n1 sg13cmos5l_dfrbpq_1_57.RESET_B 22.4327
R5125 sg13cmos5l_dfrbpq_1_57.RESET_B.n1 sg13cmos5l_dfrbpq_1_57.RESET_B 18.3671
R5126 sg13cmos5l_dfrbpq_1_57.RESET_B sg13cmos5l_dfrbpq_1_57.RESET_B.t14 15.0489
R5127 sg13cmos5l_dfrbpq_1_57.RESET_B sg13cmos5l_dfrbpq_1_57.RESET_B.t8 15.0489
R5128 sg13cmos5l_dfrbpq_1_57.RESET_B sg13cmos5l_dfrbpq_1_57.RESET_B.t3 15.0489
R5129 sg13cmos5l_dfrbpq_1_57.RESET_B sg13cmos5l_dfrbpq_1_57.RESET_B.t10 15.0489
R5130 sg13cmos5l_dfrbpq_1_57.RESET_B sg13cmos5l_dfrbpq_1_57.RESET_B.t6 15.016
R5131 sg13cmos5l_dfrbpq_1_57.RESET_B sg13cmos5l_dfrbpq_1_57.RESET_B.t0 15.0005
R5132 sg13cmos5l_dfrbpq_1_57.RESET_B sg13cmos5l_dfrbpq_1_57.RESET_B.t4 15.0005
R5133 sg13cmos5l_dfrbpq_1_57.RESET_B sg13cmos5l_dfrbpq_1_57.RESET_B.t11 15.0005
R5134 sg13cmos5l_dfrbpq_1_57.RESET_B.n0 sg13cmos5l_dfrbpq_1_57.RESET_B.n4 12.6877
R5135 sg13cmos5l_dfrbpq_1_57.RESET_B.n2 sg13cmos5l_dfrbpq_1_57.RESET_B 12.3753
R5136 sg13cmos5l_dfrbpq_1_57.RESET_B.n0 sg13cmos5l_dfrbpq_1_57.RESET_B 11.7695
R5137 sg13cmos5l_dfrbpq_1_57.RESET_B.n3 sg13cmos5l_dfrbpq_1_57.RESET_B 10.5242
R5138 sg13cmos5l_dfrbpq_1_57.RESET_B.n2 sg13cmos5l_dfrbpq_1_57.RESET_B 9.04885
R5139 sg13cmos5l_dfrbpq_1_57.RESET_B.n4 sg13cmos5l_dfrbpq_1_57.RESET_B.n3 9.0005
R5140 sg13cmos5l_dfrbpq_1_57.RESET_B.n5 sg13cmos5l_dfrbpq_1_57.RESET_B 9.0005
R5141 sg13cmos5l_dfrbpq_1_57.RESET_B.n0 sg13cmos5l_dfrbpq_1_57.RESET_B 9.0005
R5142 sg13cmos5l_dfrbpq_1_57.RESET_B.n4 sg13cmos5l_dfrbpq_1_57.RESET_B.n1 4.0133
R5143 sg13cmos5l_dfrbpq_1_57.RESET_B.n5 sg13cmos5l_dfrbpq_1_57.RESET_B.n0 3.87522
R5144 sg13cmos5l_dfrbpq_1_57.RESET_B.n3 sg13cmos5l_dfrbpq_1_57.RESET_B.n2 1.84546
R5145 sg13cmos5l_dfrbpq_1_21.RESET_B.t5 sg13cmos5l_dfrbpq_1_21.RESET_B.t6 33.4028
R5146 sg13cmos5l_dfrbpq_1_21.RESET_B.t13 sg13cmos5l_dfrbpq_1_21.RESET_B.t14 33.4028
R5147 sg13cmos5l_dfrbpq_1_21.RESET_B.t10 sg13cmos5l_dfrbpq_1_21.RESET_B.t9 33.4028
R5148 sg13cmos5l_dfrbpq_1_21.RESET_B.t11 sg13cmos5l_dfrbpq_1_21.RESET_B.t12 33.4028
R5149 sg13cmos5l_dfrbpq_1_21.RESET_B.t1 sg13cmos5l_dfrbpq_1_21.RESET_B.t2 33.4028
R5150 sg13cmos5l_dfrbpq_1_21.RESET_B.t4 sg13cmos5l_dfrbpq_1_21.RESET_B.t3 33.4028
R5151 sg13cmos5l_dfrbpq_1_21.RESET_B.t8 sg13cmos5l_dfrbpq_1_21.RESET_B.t7 33.4028
R5152 sg13cmos5l_dfrbpq_1_21.RESET_B.t16 sg13cmos5l_dfrbpq_1_21.RESET_B.t15 33.4028
R5153 sg13cmos5l_dfrbpq_1_21.RESET_B.n5 sg13cmos5l_dfrbpq_1_21.RESET_B.n4 30.1296
R5154 sg13cmos5l_dfrbpq_1_21.RESET_B.n0 sg13cmos5l_dfrbpq_1_21.RESET_B 26.9514
R5155 sg13cmos5l_dfrbpq_1_21.RESET_B.n4 sg13cmos5l_dfrbpq_1_21.RESET_B 22.2434
R5156 sg13cmos5l_dfrbpq_1_21.RESET_B.n0 sg13cmos5l_dfrbpq_1_21.RESET_B 20.3426
R5157 sg13cmos5l_dfrbpq_1_21.RESET_B sg13cmos5l_dfrbpq_1_21.RESET_B.n6 19.9013
R5158 sg13cmos5l_dfrbpq_1_21.RESET_B.n6 sg13cmos5l_dfrbpq_1_21.RESET_B 18.3671
R5159 sg13cmos5l_dfrbpq_1_21.RESET_B.n1 sg13cmos5l_dfrbpq_1_21.RESET_B 18.1823
R5160 sg13cmos5l_dfrbpq_1_21.RESET_B.n5 sg13cmos5l_dfrbpq_1_21.RESET_B.n2 15.0695
R5161 sg13cmos5l_dfrbpq_1_21.RESET_B sg13cmos5l_dfrbpq_1_21.RESET_B.t4 15.0489
R5162 sg13cmos5l_dfrbpq_1_21.RESET_B sg13cmos5l_dfrbpq_1_21.RESET_B.t8 15.0489
R5163 sg13cmos5l_dfrbpq_1_21.RESET_B sg13cmos5l_dfrbpq_1_21.RESET_B.t16 15.0489
R5164 sg13cmos5l_dfrbpq_1_21.RESET_B sg13cmos5l_dfrbpq_1_21.RESET_B.t10 15.0489
R5165 sg13cmos5l_dfrbpq_1_21.RESET_B sg13cmos5l_dfrbpq_1_21.RESET_B.t11 15.0005
R5166 sg13cmos5l_dfrbpq_1_21.RESET_B sg13cmos5l_dfrbpq_1_21.RESET_B.t1 15.0005
R5167 sg13cmos5l_dfrbpq_1_21.RESET_B sg13cmos5l_dfrbpq_1_21.RESET_B.t13 15.0005
R5168 sg13cmos5l_dfrbpq_1_21.RESET_B sg13cmos5l_dfrbpq_1_21.RESET_B.t5 15.0005
R5169 sg13cmos5l_dfrbpq_1_21.RESET_B.n2 sg13cmos5l_dfrbpq_1_21.RESET_B.n1 11.5759
R5170 sg13cmos5l_dfrbpq_1_21.RESET_B.n3 sg13cmos5l_dfrbpq_1_21.RESET_B 10.4789
R5171 sg13cmos5l_dfrbpq_1_21.RESET_B.n4 sg13cmos5l_dfrbpq_1_21.RESET_B.n3 10.2383
R5172 sg13cmos5l_dfrbpq_1_21.RESET_B.n2 sg13cmos5l_dfrbpq_1_21.RESET_B 9.04885
R5173 sg13cmos5l_dfrbpq_1_21.RESET_B.n3 sg13cmos5l_dfrbpq_1_21.RESET_B 9.0005
R5174 sg13cmos5l_dfrbpq_1_21.RESET_B sg13cmos5l_dfrbpq_1_21.RESET_B.t0 5.70896
R5175 sg13cmos5l_dfrbpq_1_21.RESET_B.n6 sg13cmos5l_dfrbpq_1_21.RESET_B.n5 1.2677
R5176 sg13cmos5l_dfrbpq_1_21.RESET_B.n1 sg13cmos5l_dfrbpq_1_21.RESET_B.n0 1.0565
R5177 sg13cmos5l_buf_1_0.A.n0 sg13cmos5l_buf_1_0.A 134.4
R5178 sg13cmos5l_buf_1_0.A sg13cmos5l_buf_1_0.A.n0 31.3061
R5179 sg13cmos5l_buf_1_0.A sg13cmos5l_buf_1_0.A.t2 15.0122
R5180 sg13cmos5l_buf_1_0.A sg13cmos5l_buf_1_0.A.t1 15.0005
R5181 sg13cmos5l_buf_1_0.A.n0 sg13cmos5l_buf_1_0.A 9.0005
R5182 sg13cmos5l_buf_1_0.A sg13cmos5l_buf_1_0.A.t0 6.3941
C0 sg13cmos5l_dfrbpq_1_56.CLK sg13cmos5l_xnor2_1_2.B 0.70889f
C1 sg13cmos5l_nand3_1_1.B a_17015_4703# 0.02769f
C2 sg13cmos5l_dfrbpq_1_46.D a_19642_6132# 0.01049f
C3 sg13cmos5l_dlygate4sd3_1_35.A a_2166_8498# 0.01253f
C4 sg13cmos5l_dlygate4sd3_1_55.A a_25288_4742# 0.07245f
C5 a_25478_5406# a_26283_5528# 0.11742f
C6 a_25764_5724# a_26181_5385# 0.48921f
C7 a_1870_7947# a_1664_7766# 0.03208f
C8 a_20388_4212# a_20805_3873# 0.48921f
C9 a_20102_3894# a_20907_4016# 0.11742f
C10 sg13cmos5l_buf_1_1.X sg13cmos5l_dfrbpq_1_0.CLK 0.22348f
C11 sg13cmos5l_dlygate4sd3_1_0.X a_28532_2680# 0.01191f
C12 sg13cmos5l_dlygate4sd3_1_6.X sg13cmos5l_dfrbpq_1_53.RESET_B 0.13204f
C13 a_21934_1059# VPWR 0.21517f
C14 sg13cmos5l_dfrbpq_1_29.Q sg13cmos5l_dfrbpq_1_42.Q 0.14565f
C15 sg13cmos5l_dlygate4sd3_1_35.A en[4] 0.02592f
C16 sg13cmos5l_nor3_1_0.A a_20687_947# 0.017f
C17 sg13cmos5l_nor4_2_3.Y a_8576_3230# 0.05188f
C18 sg13cmos5l_dfrbpq_1_0.CLK a_25317_3155# 0.40538f
C19 sg13cmos5l_dfrbpq_1_37.D sg13cmos5l_xnor2_1_4.Y 0.91988f
C20 sg13cmos5l_buf_8_11.A en[4] 0.26071f
C21 a_10231_3108# a_10444_3582# 0.40419f
C22 sg13cmos5l_dlygate4sd3_1_22.X a_9232_2602# 0.01018f
C23 sg13cmos5l_dlygate4sd3_1_18.X a_8975_2459# 0.01176f
C24 sg13cmos5l_dfrbpq_1_53.CLK a_24612_6172# 0.09084f
C25 sg13cmos5l_buf_1_0.X a_25287_1719# 0.02113f
C26 sg13cmos5l_xnor2_1_2.B a_16260_6593# 0.02065f
C27 sg13cmos5l_nand3_1_1.Y a_16970_4936# 0.02259f
C28 a_24900_3148# a_26159_3505# 0.01741f
C29 sg13cmos5l_dfrbpq_1_11.CLK sg13cmos5l_xnor2_1_6.Y 0.01078f
C30 sg13cmos5l_nor4_2_4.D a_17231_6529# 0.02591f
C31 sg13cmos5l_dfrbpq_1_37.D sg13cmos5l_dlygate4sd3_1_11.A 0.32931f
C32 sg13cmos5l_xnor2_1_6.A a_1301_874# 0.01068f
C33 sg13cmos5l_nor3_1_0.A sg13cmos5l_nand3_1_0.B 3.92859f
C34 sg13cmos5l_dfrbpq_1_23.D a_6453_4703# 0.01404f
C35 sg13cmos5l_buf_1_0.X a_21904_8650# 0.18138f
C36 a_5990_6918# a_6564_6931# 0.36169f
C37 sg13cmos5l_dfrbpq_1_46.CLK a_20388_5724# 0.07608f
C38 a_27018_1168# sg13cmos5l_dfrbpq_1_1.Q 0.16423f
C39 sg13cmos5l_nor4_2_5.D sg13cmos5l_xnor2_1_9.A 0.01926f
C40 sg13cmos5l_xnor2_1_2.A sg13cmos5l_buf_8_0.X 0.42986f
C41 sg13cmos5l_buf_8_4.A a_7103_4164# 0.03984f
C42 sg13cmos5l_dfrbpq_1_57.RESET_B a_11567_6995# 0.2939f
C43 sg13cmos5l_dlygate4sd3_1_17.X sg13cmos5l_dlygate4sd3_1_2.A 0.06382f
C44 a_8312_4697# VPWR 0.33197f
C45 a_17614_8619# VPWR 0.21327f
C46 sg13cmos5l_xnor2_1_0.Y sg13cmos5l_buf_8_3.A 0.02286f
C47 sg13cmos5l_dfrbpq_1_55.Q a_15025_3505# 0.01317f
C48 sg13cmos5l_nand3_1_0.Y a_17472_1671# 0.14601f
C49 sg13cmos5l_buf_1_2.A a_17109_4703# 0.03527f
C50 sg13cmos5l_buf_1_4.X a_20362_4624# 0.35302f
C51 sg13cmos5l_dfrbpq_1_35.Q sg13cmos5l_xnor2_1_2.A 0.2969f
C52 a_3876_8748# a_4293_8409# 0.48921f
C53 a_3590_8430# a_4395_8552# 0.11742f
C54 sg13cmos5l_dfrbpq_1_13.RESET_B a_6391_834# 0.24135f
C55 sg13cmos5l_nor4_2_3.Y VPWR 0.14035f
C56 a_20102_8430# en[3] 0.05473f
C57 sg13cmos5l_buf_1_5.A a_10022_5406# 0.01418f
C58 sg13cmos5l_dfrbpq_1_13.CLK a_5471_1603# 0.36424f
C59 sg13cmos5l_and2_1_1.X a_24586_6136# 0.02013f
C60 sg13cmos5l_dfrbpq_1_53.RESET_B a_27023_5483# 0.19877f
C61 sg13cmos5l_dfrbpq_1_15.D sg13cmos5l_nor4_2_9.D 0.01758f
C62 sg13cmos5l_xnor2_1_4.A sg13cmos5l_dfrbpq_1_0.CLK 0.19984f
C63 sg13cmos5l_dfrbpq_1_0.CLK a_24902_3894# 0.0248f
C64 sg13cmos5l_xnor2_1_5.Y sg13cmos5l_xnor2_1_12.Y 0.01173f
C65 sg13cmos5l_dfrbpq_1_13.RESET_B a_9232_2602# 0.18834f
C66 sg13cmos5l_nor3_1_2.B sg13cmos5l_dlygate4sd3_1_33.A 1.12889f
C67 a_22049_1060# VPWR 0.24917f
C68 sg13cmos5l_nor3_1_1.C a_10791_3231# 0.0293f
C69 sg13cmos5l_dfrbpq_1_55.RESET_B a_13834_3112# 0.36482f
C70 sg13cmos5l_xnor2_1_10.Y a_21647_6529# 0.01053f
C71 a_7103_1140# a_7754_1028# 0.01562f
C72 sg13cmos5l_buf_1_11.A a_2920_7680# 0.03531f
C73 a_6972_834# a_7893_1028# 0.43042f
C74 sg13cmos5l_buf_1_0.A sg13cmos5l_nor3_1_1.C 0.02669f
C75 a_28936_8562# a_29120_8562# 0.11523f
C76 sg13cmos5l_nand3_1_3.Y a_1784_3185# 0.02539f
C77 sg13cmos5l_dfrbpq_1_53.CLK a_25871_6529# 0.01838f
C78 sg13cmos5l_dlygate4sd3_1_6.A sg13cmos5l_xnor2_1_3.A 0.02152f
C79 a_21647_8507# a_21553_8507# 0.32273f
C80 a_21857_1898# VPWR 0.24849f
C81 sg13cmos5l_xnor2_1_3.B a_18564_3148# 0.04574f
C82 sg13cmos5l_xnor2_1_2.B a_15108_7684# 0.01393f
C83 a_20311_6882# a_20524_6918# 0.40419f
C84 sg13cmos5l_dlygate4sd3_1_6.X sg13cmos5l_xnor2_1_3.A 0.01833f
C85 sg13cmos5l_dfrbpq_1_57.RESET_B sg13cmos5l_dlygate4sd3_1_18.X 0.02379f
C86 sg13cmos5l_dfrbpq_1_21.CLK sg13cmos5l_nand3_1_3.Y 0.03937f
C87 sg13cmos5l_dfrbpq_1_23.D a_8694_4680# 0.24314f
C88 sg13cmos5l_nor4_2_0.B VPWR 3.75976f
C89 a_14542_4923# a_14657_4922# 0.67711f
C90 sg13cmos5l_nand3_1_0.A a_19142_870# 0.01022f
C91 sg13cmos5l_dfrbpq_1_57.RESET_B sg13cmos5l_and2_1_3.A 0.17261f
C92 a_6951_4112# VPWR 0.20843f
C93 a_10812_5017# VPWR 0.07517f
C94 sg13cmos5l_xnor2_1_4.Y a_28289_4922# 0.01984f
C95 sg13cmos5l_dfrbpq_1_57.RESET_B sg13cmos5l_dlygate4sd3_1_28.X 0.18776f
C96 sg13cmos5l_dfrbpq_1_21.CLK a_5164_5094# 0.01631f
C97 a_5855_5676# a_5532_5017# 0.01422f
C98 sg13cmos5l_dfrbpq_1_32.CLK a_5375_7651# 0.36072f
C99 sg13cmos5l_dfrbpq_1_21.RESET_B sg13cmos5l_xnor2_1_5.Y 0.03422f
C100 a_10725_6897# VPWR 0.24242f
C101 a_5134_8118# a_5375_7651# 0.01058f
C102 sg13cmos5l_buf_1_0.X a_23835_8050# 0.05961f
C103 a_10827_1643# VPWR 0.2087f
C104 sg13cmos5l_dfrbpq_1_55.D a_16320_1671# 0.03215f
C105 sg13cmos5l_dlygate4sd3_1_11.A a_28289_4922# 0.02516f
C106 sg13cmos5l_dfrbpq_1_56.CLK a_19609_6942# 0.02131f
C107 a_3850_8653# a_3590_8430# 0.87117f
C108 sg13cmos5l_dfrbpq_1_17.Q sg13cmos5l_nor3_1_1.C 0.22063f
C109 a_18826_4620# sg13cmos5l_buf_1_4.X 0.04448f
C110 a_25605_3873# a_25707_4016# 0.66105f
C111 sg13cmos5l_buf_1_0.A a_18972_1993# 0.01879f
C112 sg13cmos5l_buf_1_0.A sg13cmos5l_dlygate4sd3_1_22.X 0.01419f
C113 sg13cmos5l_nor3_1_2.B a_5223_7767# 0.01979f
C114 sg13cmos5l_dlygate4sd3_1_55.X sg13cmos5l_nor3_1_0.C 0.84806f
C115 sg13cmos5l_buf_1_0.X a_23846_4656# 0.03561f
C116 a_10022_8430# a_10308_8748# 0.50066f
C117 sg13cmos5l_nor4_2_5.Y a_4762_6886# 0.03706f
C118 a_13574_3582# a_14277_3155# 0.02431f
C119 a_27023_5483# a_27280_5626# 0.40419f
C120 a_26181_5385# a_26929_5483# 0.01058f
C121 sg13cmos5l_dfrbpq_1_55.Q a_14379_2504# 0.02971f
C122 a_25308_1993# a_25439_1603# 0.48921f
C123 sg13cmos5l_buf_1_0.A a_15285_1679# 0.01587f
C124 a_24704_1002# VPWR 0.07578f
C125 sg13cmos5l_nor4_2_7.B sg13cmos5l_dlygate4sd3_1_9.X 0.11657f
C126 a_3799_2346# a_4380_2346# 0.01741f
C127 sg13cmos5l_xnor2_1_9.A sg13cmos5l_dfrbpq_1_15.D 0.01715f
C128 a_3680_5609# a_3488_5538# 0.02877f
C129 sg13cmos5l_dfrbpq_1_57.Q a_9446_4656# 0.01866f
C130 sg13cmos5l_nor3_1_0.C a_18852_3569# 0.02657f
C131 sg13cmos5l_dlygate4sd3_1_6.A sg13cmos5l_nor4_2_1.A 0.02011f
C132 sg13cmos5l_dfrbpq_1_21.RESET_B a_6693_6897# 0.02023f
C133 sg13cmos5l_buf_1_5.A a_9446_6168# 0.01012f
C134 sg13cmos5l_buf_8_11.A sg13cmos5l_dlygate4sd3_1_4.A 0.10056f
C135 sg13cmos5l_buf_8_10.A a_10725_6897# 0.0144f
C136 sg13cmos5l_xor2_1_2.B a_13592_4697# 0.02154f
C137 a_10022_2070# a_10725_1643# 0.02431f
C138 a_15607_4620# a_15820_5094# 0.40419f
C139 sg13cmos5l_dlygate4sd3_1_6.X sg13cmos5l_nor4_2_1.A 1.75543f
C140 sg13cmos5l_buf_1_0.X a_23846_1632# 0.0353f
C141 sg13cmos5l_dfrbpq_1_46.D sg13cmos5l_dlygate4sd3_1_55.X 1.41249f
C142 sg13cmos5l_dfrbpq_1_55.Q a_15296_4742# 0.07015f
C143 a_11786_4192# VPWR 0.30591f
C144 sg13cmos5l_xnor2_1_2.B sg13cmos5l_nand3_1_1.B 0.02074f
C145 sg13cmos5l_dlygate4sd3_1_9.A osc 0.02501f
C146 sg13cmos5l_dlygate4sd3_1_23.X a_3590_3582# 0.29985f
C147 a_17132_3108# VPWR 0.26451f
C148 a_13592_4697# a_13862_4656# 0.33585f
C149 a_11733_4703# sg13cmos5l_dfrbpq_1_17.D 0.01221f
C150 a_25764_8748# a_26052_8443# 0.4806f
C151 sg13cmos5l_dfrbpq_1_13.RESET_B a_10308_1188# 0.47982f
C152 a_8776_4026# sg13cmos5l_nand3_1_3.B 0.01335f
C153 sg13cmos5l_dlygate4sd3_1_18.X sg13cmos5l_dfrbpq_1_22.D 0.13533f
C154 a_9915_3898# sg13cmos5l_buf_8_3.A 1.05377f
C155 sg13cmos5l_dfrbpq_1_13.CLK a_10282_1600# 0.01199f
C156 a_2816_8562# VPWR 0.07156f
C157 sg13cmos5l_dfrbpq_1_23.D sg13cmos5l_xnor2_1_12.Y 0.06491f
C158 sg13cmos5l_dfrbpq_1_32.CLK a_7046_8118# 0.03777f
C159 a_6026_7960# a_6071_7727# 0.36169f
C160 a_10943_2652# a_10702_2382# 0.01058f
C161 sg13cmos5l_nor4_2_1.A osc 0.30658f
C162 sg13cmos5l_dlygate4sd3_1_18.A a_7932_1993# 0.04698f
C163 sg13cmos5l_dlygate4sd3_1_35.A VPWR 0.54588f
C164 sg13cmos5l_nor3_1_0.C a_20388_4660# 0.03686f
C165 sg13cmos5l_buf_1_0.A sg13cmos5l_dfrbpq_1_13.RESET_B 12.9208f
C166 sg13cmos5l_dfrbpq_1_12.Q a_13574_3582# 0.05202f
C167 a_20892_6882# en[4] 0.01634f
C168 sg13cmos5l_dfrbpq_1_56.RESET_B sg13cmos5l_buf_1_5.A 0.33128f
C169 sg13cmos5l_buf_8_11.A VPWR 2.28903f
C170 a_5244_8041# a_5223_7767# 0.38902f
C171 sg13cmos5l_nor4_2_1.D sg13cmos5l_dfrbpq_1_0.D 0.09808f
C172 sg13cmos5l_xnor2_1_5.Y osc 0.12643f
C173 sg13cmos5l_xnor2_1_4.A sg13cmos5l_dfrbpq_1_53.RESET_B 0.32792f
C174 sg13cmos5l_dfrbpq_1_17.D sg13cmos5l_dfrbpq_1_55.RESET_B 0.16224f
C175 sg13cmos5l_dlygate4sd3_1_58.A a_7930_4620# 0.52201f
C176 sg13cmos5l_buf_1_4.X a_25287_1719# 0.0315f
C177 sg13cmos5l_xnor2_1_3.B sg13cmos5l_nor3_1_0.B 0.01978f
C178 a_10282_1093# a_10022_870# 0.87117f
C179 a_27280_5626# a_26929_5483# 0.01017f
C180 a_3990_7704# a_4544_7967# 0.03282f
C181 a_16454_3144# osc 0.01052f
C182 sg13cmos5l_dfrbpq_1_57.CLK a_10943_7651# 0.39741f
C183 a_26351_947# VPWR 0.17272f
C184 sg13cmos5l_nor3_1_2.B a_5244_8041# 0.01352f
C185 sg13cmos5l_dfrbpq_1_21.CLK a_4359_2600# 0.0348f
C186 sg13cmos5l_dlygate4sd3_1_4.X a_28936_7766# 0.01439f
C187 sg13cmos5l_dfrbpq_1_13.RESET_B a_3905_1898# 0.04775f
C188 sg13cmos5l_dfrbpq_1_13.Q sg13cmos5l_dlygate4sd3_1_20.A 0.02096f
C189 sg13cmos5l_dfrbpq_1_53.CLK a_27022_6435# 0.01053f
C190 sg13cmos5l_buf_1_1.X sg13cmos5l_xnor2_1_3.A 0.10447f
C191 sg13cmos5l_buf_1_4.A sg13cmos5l_buf_8_2.X 0.02149f
C192 sg13cmos5l_nor3_1_0.B a_24134_2382# 0.02562f
C193 a_25478_5406# VPWR 0.92863f
C194 sg13cmos5l_dfrbpq_1_46.CLK sg13cmos5l_dlygate4sd3_1_55.X 0.01689f
C195 a_10112_7967# sg13cmos5l_dlygate4sd3_1_52.A 0.13471f
C196 a_21023_7188# a_20892_6882# 0.49014f
C197 sg13cmos5l_buf_1_0.X sg13cmos5l_nor4_2_0.C 0.02144f
C198 a_16188_5017# a_16167_4743# 0.38902f
C199 sg13cmos5l_dfrbpq_1_29.Q a_18010_8398# 0.0182f
C200 sg13cmos5l_buf_2_0.X VPWR 0.0168f
C201 a_23958_4680# a_23846_4656# 0.67711f
C202 sg13cmos5l_xnor2_1_13.A VPWR 0.30558f
C203 sg13cmos5l_dlygate4sd3_1_19.X sg13cmos5l_dfrbpq_1_13.Q 0.02108f
C204 sg13cmos5l_dfrbpq_1_21.RESET_B sg13cmos5l_dfrbpq_1_23.D 0.25182f
C205 a_8202_7216# a_8584_7050# 0.03295f
C206 sg13cmos5l_and2_1_0.X VPWR 0.41401f
C207 a_18080_1718# VPWR 0.07978f
C208 sg13cmos5l_dfrbpq_1_29.Q a_15340_8430# 0.01263f
C209 sg13cmos5l_xnor2_1_5.Y sg13cmos5l_nor3_1_4.Y 0.01775f
C210 sg13cmos5l_dfrbpq_1_23.Q a_5724_5370# 0.01889f
C211 sg13cmos5l_dlygate4sd3_1_6.X a_21435_3514# 0.10389f
C212 sg13cmos5l_nor4_2_5.Y a_4730_6168# 0.37708f
C213 a_21934_2571# VPWR 0.25677f
C214 sg13cmos5l_dfrbpq_1_32.CLK a_7851_7691# 0.01352f
C215 sg13cmos5l_dfrbpq_1_21.Q sg13cmos5l_xnor2_1_0.A 0.19773f
C216 sg13cmos5l_nor4_2_4.D sg13cmos5l_dfrbpq_1_56.D 0.51007f
C217 sg13cmos5l_dlygate4sd3_1_4.X a_27023_8507# 0.01973f
C218 sg13cmos5l_buf_1_0.A sg13cmos5l_dfrbpq_1_0.CLK 0.04968f
C219 sg13cmos5l_buf_8_0.X a_17015_4703# 0.01802f
C220 sg13cmos5l_nor3_1_0.C a_20907_4667# 0.0109f
C221 sg13cmos5l_dfrbpq_1_13.CLK a_4359_1088# 0.03934f
C222 sg13cmos5l_nand3_1_3.Y sg13cmos5l_buf_8_3.A 0.03173f
C223 sg13cmos5l_nor3_1_2.C en[4] 4.12768f
C224 a_5724_5370# a_6645_5564# 0.43042f
C225 sg13cmos5l_dlygate4sd3_1_4.A a_28524_3410# 0.0119f
C226 sg13cmos5l_xnor2_1_0.Y a_15191_1679# 0.03668f
C227 a_10112_2557# a_10231_2346# 0.13494f
C228 a_28646_874# VPWR 0.24371f
C229 sg13cmos5l_dfrbpq_1_46.D a_23861_6538# 0.0112f
C230 a_15686_6606# a_15972_6172# 0.50066f
C231 sg13cmos5l_buf_1_0.X a_20892_8041# 0.49021f
C232 a_3990_7704# sg13cmos5l_nor4_2_5.D 0.19465f
C233 sg13cmos5l_buf_8_2.X sg13cmos5l_nor3_1_0.C 0.02425f
C234 sg13cmos5l_dfrbpq_1_57.CLK sg13cmos5l_xnor2_1_2.A 0.02953f
C235 sg13cmos5l_nor4_2_5.Y sg13cmos5l_nor4_2_5.B 0.29901f
C236 sg13cmos5l_xnor2_1_13.Y sg13cmos5l_xnor2_1_12.Y 0.08338f
C237 a_11733_7727# a_11639_7727# 0.87117f
C238 sg13cmos5l_dlygate4sd3_1_53.A sg13cmos5l_dlygate4sd3_1_58.A 0.46542f
C239 a_24727_1596# a_24940_2070# 0.40419f
C240 sg13cmos5l_dfrbpq_1_2.CLK sg13cmos5l_nor3_1_0.A 0.01382f
C241 sg13cmos5l_dlygate4sd3_1_17.A sg13cmos5l_dfrbpq_1_7.Q 0.03007f
C242 sg13cmos5l_nor4_2_1.A sg13cmos5l_buf_1_1.X 0.18479f
C243 a_20892_6882# a_21813_7076# 0.43042f
C244 sg13cmos5l_nor4_2_4.D a_17518_7947# 0.01649f
C245 sg13cmos5l_dfrbpq_1_23.D a_8776_4026# 0.07047f
C246 sg13cmos5l_buf_1_1.X sg13cmos5l_dlygate4sd3_1_1.A 0.17336f
C247 sg13cmos5l_xor2_1_2.B sg13cmos5l_xnor2_1_5.Y 0.0198f
C248 a_28524_3410# VPWR 0.26117f
C249 sg13cmos5l_nor4_2_5.B sg13cmos5l_and2_1_3.A 0.02515f
C250 sg13cmos5l_and2_1_1.A sg13cmos5l_dfrbpq_1_5.Q 0.34426f
C251 a_15488_4943# VPWR 0.45157f
C252 sg13cmos5l_xnor2_1_5.Y a_16319_4627# 0.01679f
C253 sg13cmos5l_dfrbpq_1_29.Q a_17614_8619# 0.01575f
C254 sg13cmos5l_dfrbpq_1_18.D sg13cmos5l_dfrbpq_1_21.Q 0.01623f
C255 a_4511_1140# a_4380_834# 0.49014f
C256 sg13cmos5l_buf_1_0.A sg13cmos5l_xnor2_1_12.B 0.01173f
C257 sg13cmos5l_dfrbpq_1_37.D a_25094_8118# 0.05383f
C258 sg13cmos5l_dfrbpq_1_12.D a_9176_3185# 0.01077f
C259 a_3876_3148# a_5135_3505# 0.01741f
C260 sg13cmos5l_dlygate4sd3_1_19.A a_4359_2600# 0.02566f
C261 sg13cmos5l_and2_1_3.A sg13cmos5l_nand3_1_1.B 0.03061f
C262 a_7306_7648# a_7332_7684# 0.43042f
C263 sg13cmos5l_dfrbpq_1_56.CLK a_16389_6179# 0.38817f
C264 sg13cmos5l_xnor2_1_6.B a_5319_1719# 0.02126f
C265 a_10725_849# VPWR 0.23923f
C266 a_24363_7040# en[4] 0.01019f
C267 sg13cmos5l_nand3_1_1.Y a_10791_4743# 0.01834f
C268 sg13cmos5l_dlygate4sd3_1_28.X sg13cmos5l_nand3_1_1.B 0.17892f
C269 sg13cmos5l_dfrbpq_1_53.RESET_B a_16624_7922# 0.01142f
C270 sg13cmos5l_xnor2_1_4.B a_24874_3112# 0.01886f
C271 sg13cmos5l_nor3_1_2.C sg13cmos5l_dfrbpq_1_23.Q 0.05703f
C272 sg13cmos5l_dfrbpq_1_47.Q a_18363_6922# 0.18594f
C273 a_12234_1168# sg13cmos5l_dfrbpq_1_11.Q 0.13351f
C274 a_5724_5370# a_5614_5406# 0.4858f
C275 a_6551_5797# a_6506_5564# 0.36169f
C276 sg13cmos5l_buf_1_0.X sg13cmos5l_and2_1_1.X 1.08512f
C277 sg13cmos5l_dfrbpq_1_53.RESET_B a_26150_6918# 0.09853f
C278 sg13cmos5l_dfrbpq_1_21.RESET_B sg13cmos5l_nand3_1_1.Y 0.03596f
C279 a_25354_7648# a_25380_7684# 0.43042f
C280 sg13cmos5l_xnor2_1_2.B a_15782_6918# 0.04393f
C281 a_16389_6179# a_16260_6593# 0.01562f
C282 a_15972_6172# a_16491_6179# 0.38871f
C283 sg13cmos5l_dfrbpq_1_21.RESET_B a_5392_8650# 0.18244f
C284 a_13288_5538# a_13288_4742# 0.01095f
C285 sg13cmos5l_buf_1_0.X sg13cmos5l_xnor2_1_10.Y 0.45929f
C286 sg13cmos5l_nor4_2_4.D a_16587_7040# 0.0332f
C287 sg13cmos5l_and2_1_3.A a_7439_6529# 0.01695f
C288 sg13cmos5l_buf_1_4.A sg13cmos5l_xnor2_1_6.B 0.09735f
C289 sg13cmos5l_dlygate4sd3_1_35.A a_5802_8728# 0.15148f
C290 sg13cmos5l_xnor2_1_1.Y sg13cmos5l_xnor2_1_1.B 0.06986f
C291 sg13cmos5l_dfrbpq_1_56.RESET_B a_15850_3862# 0.01619f
C292 a_18789_2361# a_18660_2395# 0.01562f
C293 a_13288_2514# VPWR 0.14233f
C294 a_16138_5629# a_15878_5406# 0.87117f
C295 sg13cmos5l_nor4_2_0.C sg13cmos5l_dlygate4sd3_1_16.A 0.04049f
C296 a_5724_5370# VPWR 0.0721f
C297 sg13cmos5l_dfrbpq_1_56.CLK a_16581_5385# 0.41756f
C298 sg13cmos5l_dfrbpq_1_58.Q sg13cmos5l_xnor2_1_5.Y 0.02865f
C299 a_15686_6606# VPWR 0.92809f
C300 a_15322_6132# VPWR 0.38346f
C301 sg13cmos5l_xnor2_1_8.Y a_9640_7680# 0.04348f
C302 a_25478_5094# a_25764_4660# 0.50066f
C303 a_10812_8041# a_10791_7767# 0.38902f
C304 a_19055_3971# a_18961_3971# 0.32273f
C305 sg13cmos5l_dlygate4sd3_1_6.X a_23368_8562# 0.03384f
C306 a_20892_6882# VPWR 0.07294f
C307 sg13cmos5l_buf_1_4.X a_12234_1168# 0.026f
C308 a_16167_4743# VPWR 0.20723f
C309 sg13cmos5l_nand3_1_2.C a_28829_7216# 0.0273f
C310 sg13cmos5l_nand3_1_1.B a_14542_4923# 0.01419f
C311 sg13cmos5l_xnor2_1_6.B sg13cmos5l_dlygate4sd3_1_21.X 0.67567f
C312 sg13cmos5l_xnor2_1_6.A sg13cmos5l_nor4_2_3.Y 0.11123f
C313 sg13cmos5l_buf_1_1.X a_21435_3514# 0.03528f
C314 sg13cmos5l_dfrbpq_1_0.D a_28940_1596# 0.0596f
C315 sg13cmos5l_xnor2_1_2.B sg13cmos5l_dfrbpq_1_57.D 0.06901f
C316 sg13cmos5l_buf_8_11.A a_28362_7216# 0.01197f
C317 sg13cmos5l_dfrbpq_1_55.RESET_B a_14277_2361# 0.05162f
C318 sg13cmos5l_dfrbpq_1_21.CLK a_6951_4112# 0.03506f
C319 a_15119_2459# a_15376_2602# 0.40419f
C320 a_14379_2504# a_14148_2395# 0.15089f
C321 a_13860_2700# a_15025_2459# 0.4858f
C322 a_7332_7684# a_8591_8041# 0.01741f
C323 sg13cmos5l_xnor2_1_4.B a_25162_4117# 0.02093f
C324 a_17423_5483# sg13cmos5l_nor4_2_1.A 0.01686f
C325 a_20362_8653# a_20805_8409# 0.02241f
C326 sg13cmos5l_buf_1_0.X a_20388_8748# 0.50412f
C327 sg13cmos5l_buf_8_5.A a_10231_4620# 0.01649f
C328 a_5990_6918# a_6795_7040# 0.11742f
C329 a_6276_7236# a_6693_6897# 0.48921f
C330 a_6122_1912# a_6167_1679# 0.36169f
C331 sg13cmos5l_dfrbpq_1_53.RESET_B a_27695_6995# 0.19875f
C332 a_25380_7684# a_26639_8041# 0.01741f
C333 a_13288_5538# VPWR 0.14162f
C334 a_17488_6410# a_17231_6529# 0.40419f
C335 sg13cmos5l_and2_1_3.A a_10112_6455# 0.01194f
C336 sg13cmos5l_dfrbpq_1_12.Q a_14364_1993# 0.01593f
C337 sg13cmos5l_dlygate4sd3_1_35.A sg13cmos5l_dlygate4sd3_1_34.A 0.23062f
C338 sg13cmos5l_nand3_1_1.Y osc 0.02668f
C339 sg13cmos5l_buf_1_4.X sg13cmos5l_nor4_2_0.C 0.24193f
C340 sg13cmos5l_dlygate4sd3_1_6.X en[3] 0.53159f
C341 sg13cmos5l_nor3_1_2.C a_6795_7040# 0.01754f
C342 a_1137_3144# VPWR 0.01182f
C343 a_14254_2070# a_14495_1603# 0.01058f
C344 a_5990_6918# VPWR 0.92809f
C345 sg13cmos5l_dfrbpq_1_23.Q sg13cmos5l_xor2_1_1.B 0.024f
C346 sg13cmos5l_dfrbpq_1_21.RESET_B a_4293_3873# 0.06008f
C347 sg13cmos5l_nand3_1_1.B a_14186_6168# 0.38471f
C348 a_9176_5410# VPWR 0.32565f
C349 a_5230_7107# VPWR 0.21559f
C350 a_16491_6179# VPWR 0.20782f
C351 sg13cmos5l_xnor2_1_2.B sg13cmos5l_buf_8_0.X 0.33797f
C352 sg13cmos5l_dfrbpq_1_23.Q a_5036_6168# 0.01683f
C353 sg13cmos5l_dfrbpq_1_57.CLK sg13cmos5l_dlygate4sd3_1_38.A 0.3094f
C354 a_23818_7141# a_23844_7236# 0.43042f
C355 a_25052_8728# VPWR 0.25021f
C356 a_20907_4016# a_21647_3971# 0.3087f
C357 sg13cmos5l_and2_1_1.X a_23958_4680# 0.07437f
C358 a_15032_5410# a_15302_5410# 0.33585f
C359 a_25764_4660# a_26052_5081# 0.4806f
C360 sg13cmos5l_buf_1_1.X a_24727_1596# 0.20199f
C361 sg13cmos5l_buf_1_0.A sg13cmos5l_dfrbpq_1_18.D 0.01794f
C362 sg13cmos5l_buf_1_0.A a_2054_8434# 0.01029f
C363 sg13cmos5l_dfrbpq_1_2.D a_21742_1899# 0.21623f
C364 sg13cmos5l_dfrbpq_1_2.D a_17796_4212# 0.01887f
C365 a_26181_8409# a_25797_7691# 0.03072f
C366 sg13cmos5l_dlygate4sd3_1_22.X sg13cmos5l_dlygate4sd3_1_18.A 0.41118f
C367 sg13cmos5l_dfrbpq_1_0.CLK a_26065_3505# 0.01572f
C368 a_9558_3168# sg13cmos5l_nor3_1_1.C 0.19428f
C369 sg13cmos5l_dfrbpq_1_35.Q sg13cmos5l_xnor2_1_2.B 0.18524f
C370 a_15127_8394# a_15598_8430# 0.32273f
C371 sg13cmos5l_buf_1_0.A sg13cmos5l_nor3_1_1.Y 0.01781f
C372 sg13cmos5l_dlygate4sd3_1_6.A sg13cmos5l_dfrbpq_1_56.D 0.01604f
C373 sg13cmos5l_dfrbpq_1_37.D sg13cmos5l_buf_1_4.A 0.02542f
C374 sg13cmos5l_nor3_1_2.C VPWR 0.71147f
C375 sg13cmos5l_buf_1_2.A en[4] 0.02304f
C376 a_26159_3505# a_26826_3144# 0.13494f
C377 a_26416_3386# a_26065_3505# 0.01017f
C378 a_20805_8409# a_20676_8443# 0.01562f
C379 sg13cmos5l_dlygate4sd3_1_57.A en[4] 0.02505f
C380 a_7332_7684# a_8497_8041# 0.4858f
C381 a_8591_8041# a_9258_7680# 0.13494f
C382 sg13cmos5l_dfrbpq_1_21.RESET_B sg13cmos5l_nor4_2_9.D 1.3921f
C383 sg13cmos5l_nand3_1_1.Y sg13cmos5l_nor3_1_4.Y 0.02964f
C384 a_6795_7040# a_7792_7138# 0.06746f
C385 sg13cmos5l_dlygate4sd3_1_6.A sg13cmos5l_nand3_1_0.A 0.49305f
C386 a_26639_8041# a_27306_7680# 0.13494f
C387 a_26896_7922# a_26545_8041# 0.01017f
C388 sg13cmos5l_dlygate4sd3_1_6.X sg13cmos5l_nand3_1_0.A 0.02299f
C389 sg13cmos5l_buf_1_0.A sg13cmos5l_xnor2_1_3.A 2.10539f
C390 a_17898_6168# sg13cmos5l_dfrbpq_1_38.Q 0.13698f
C391 a_3876_4212# VPWR 0.0721f
C392 a_14822_8118# a_15525_7691# 0.02431f
C393 a_5230_7107# a_5345_7108# 0.67711f
C394 a_1985_6434# VPWR 0.24249f
C395 sg13cmos5l_dfrbpq_1_58.Q sg13cmos5l_dfrbpq_1_23.D 0.01955f
C396 sg13cmos5l_xnor2_1_13.Y a_1870_6435# 0.0135f
C397 sg13cmos5l_nand3_1_2.C sg13cmos5l_nand3_1_2.B 0.35921f
C398 a_10444_3582# VPWR 0.18785f
C399 sg13cmos5l_buf_1_4.A a_26181_4667# 0.03305f
C400 sg13cmos5l_dfrbpq_1_57.RESET_B a_10022_5406# 0.1283f
C401 sg13cmos5l_and2_1_3.A a_8768_6427# 0.34682f
C402 sg13cmos5l_buf_1_2.A a_16188_5017# 0.04266f
C403 sg13cmos5l_nor4_2_5.C a_6391_8394# 0.0179f
C404 a_17423_5483# a_17680_5626# 0.40419f
C405 a_16164_5724# a_16452_5419# 0.4806f
C406 a_26135_1679# sg13cmos5l_nor4_2_0.D 0.04588f
C407 sg13cmos5l_dlygate4sd3_1_6.X a_22314_6168# 0.01679f
C408 a_7792_7138# VPWR 0.18708f
C409 sg13cmos5l_dlygate4sd3_1_6.A a_19361_6434# 0.03179f
C410 sg13cmos5l_nor3_1_2.C a_5345_7108# 0.02173f
C411 sg13cmos5l_dfrbpq_1_38.Q VPWR 0.42791f
C412 sg13cmos5l_buf_8_3.A sg13cmos5l_nor4_2_3.Y 0.0517f
C413 sg13cmos5l_dlygate4sd3_1_15.A sg13cmos5l_nor4_2_0.C 0.01842f
C414 sg13cmos5l_dlygate4sd3_1_18.X a_9176_3185# 0.01482f
C415 sg13cmos5l_dfrbpq_1_37.D sg13cmos5l_nor3_1_0.C 0.01749f
C416 a_15525_7691# VPWR 0.23962f
C417 a_23558_6918# a_24261_6897# 0.02453f
C418 sg13cmos5l_dfrbpq_1_13.RESET_B sg13cmos5l_dlygate4sd3_1_18.A 0.41063f
C419 a_28936_5538# VPWR 0.12205f
C420 sg13cmos5l_xnor2_1_4.A a_28559_3514# 0.0107f
C421 a_18010_8398# en[2] 0.01209f
C422 a_26283_4667# a_27280_4898# 0.07014f
C423 a_10943_3115# a_11594_3424# 0.01562f
C424 sg13cmos5l_dfrbpq_1_55.RESET_B a_14379_3155# 0.57315f
C425 sg13cmos5l_buf_8_2.X a_27195_3514# 0.51395f
C426 sg13cmos5l_dfrbpq_1_23.Q sg13cmos5l_dfrbpq_1_58.D 0.11f
C427 sg13cmos5l_dlygate4sd3_1_4.A sg13cmos5l_dfrbpq_1_0.D 0.03652f
C428 sg13cmos5l_dfrbpq_1_53.CLK a_26639_8041# 0.03072f
C429 sg13cmos5l_dfrbpq_1_13.RESET_B sg13cmos5l_dlygate4sd3_1_20.A 0.06469f
C430 a_24363_7040# VPWR 0.20743f
C431 sg13cmos5l_dfrbpq_1_11.CLK a_10827_1643# 0.04014f
C432 a_20311_7644# a_20524_8118# 0.40419f
C433 sg13cmos5l_buf_1_0.X sg13cmos5l_nor4_2_0.D 0.01104f
C434 sg13cmos5l_xor2_1_2.B sg13cmos5l_nand3_1_1.Y 0.02546f
C435 sg13cmos5l_dfrbpq_1_53.RESET_B a_26128_6410# 0.011f
C436 sg13cmos5l_and2_1_1.X sg13cmos5l_buf_1_4.X 0.02304f
C437 a_10112_7967# a_10444_8118# 0.1396f
C438 sg13cmos5l_dfrbpq_1_53.CLK a_26283_4667# 0.01715f
C439 sg13cmos5l_dfrbpq_1_46.D sg13cmos5l_dfrbpq_1_37.D 0.13376f
C440 sg13cmos5l_dfrbpq_1_57.D sg13cmos5l_and2_1_3.A 0.20735f
C441 sg13cmos5l_nor3_1_0.C a_18789_2361# 0.02527f
C442 a_8853_1679# a_8759_1679# 0.87117f
C443 sg13cmos5l_dlygate4sd3_1_19.X sg13cmos5l_dfrbpq_1_13.RESET_B 0.57147f
C444 sg13cmos5l_xor2_1_1.B VPWR 1.17939f
C445 a_26853_6897# a_26724_6931# 0.01562f
C446 sg13cmos5l_buf_8_4.A a_7649_4922# 0.01308f
C447 a_5036_6168# VPWR 0.39072f
C448 sg13cmos5l_dfrbpq_1_0.D VPWR 1.3538f
C449 sg13cmos5l_xnor2_1_8.Y en[1] 0.66599f
C450 a_13860_3148# VPWR 0.07281f
C451 sg13cmos5l_dlygate4sd3_1_11.X a_28570_5374# 0.01325f
C452 a_13676_7680# a_13888_7680# 0.31789f
C453 a_14822_8118# a_15627_7691# 0.11742f
C454 a_26283_8552# sg13cmos5l_dfrbpq_1_53.CLK 0.02015f
C455 sg13cmos5l_xnor2_1_0.Y a_15756_1060# 0.22749f
C456 sg13cmos5l_nor3_1_4.C VPWR 0.59623f
C457 sg13cmos5l_dfrbpq_1_21.RESET_B a_6972_8394# 0.50612f
C458 sg13cmos5l_dfrbpq_1_57.RESET_B a_11824_5626# 0.23855f
C459 sg13cmos5l_xor2_1_1.B a_8960_4026# 0.01257f
C460 a_9166_4083# a_9281_4084# 0.67711f
C461 sg13cmos5l_buf_1_0.A sg13cmos5l_dlygate4sd3_1_1.A 0.01161f
C462 sg13cmos5l_dlygate4sd3_1_17.A sg13cmos5l_dfrbpq_1_0.CLK 0.11699f
C463 sg13cmos5l_dfrbpq_1_13.CLK a_7911_1719# 0.03442f
C464 a_17423_5483# a_17329_5483# 0.32273f
C465 a_24902_3894# a_25476_3907# 0.36169f
C466 sg13cmos5l_buf_1_0.A sg13cmos5l_xnor2_1_5.Y 0.01525f
C467 sg13cmos5l_dfrbpq_1_22.D a_11639_3191# 0.0369f
C468 a_3488_1002# VPWR 0.06719f
C469 sg13cmos5l_dfrbpq_1_57.RESET_B a_11824_8650# 0.18138f
C470 a_15627_7691# VPWR 0.20557f
C471 a_13860_3148# a_14148_3569# 0.4806f
C472 sg13cmos5l_nor3_1_4.A a_14938_4620# 0.01435f
C473 a_27990_2450# a_27992_1673# 0.01006f
C474 sg13cmos5l_dfrbpq_1_0.CLK a_26135_1679# 0.02694f
C475 a_4511_2652# a_5162_2540# 0.01562f
C476 a_20892_8041# a_21719_7727# 0.50066f
C477 a_4380_2346# a_5207_2773# 0.50066f
C478 sg13cmos5l_xnor2_1_6.Y a_15756_1060# 0.43833f
C479 a_20524_8118# a_20871_7767# 0.06746f
C480 a_20892_8041# a_20782_8118# 0.4858f
C481 sg13cmos5l_dfrbpq_1_58.Q sg13cmos5l_nand3_1_1.Y 0.02912f
C482 sg13cmos5l_buf_1_2.A a_16164_5724# 0.01854f
C483 sg13cmos5l_buf_1_4.X a_24837_2361# 0.07547f
C484 a_24881_8484# VPWR 0.24301f
C485 sg13cmos5l_dfrbpq_1_2.CLK a_18951_1719# 0.0656f
C486 sg13cmos5l_xnor2_1_4.Y a_26283_5528# 0.01733f
C487 sg13cmos5l_nor3_1_1.C a_16270_2571# 0.0144f
C488 a_21742_1899# a_21857_1898# 0.67711f
C489 sg13cmos5l_dfrbpq_1_35.Q sg13cmos5l_and2_1_3.A 0.01012f
C490 sg13cmos5l_dfrbpq_1_46.CLK sg13cmos5l_dfrbpq_1_37.D 0.16292f
C491 sg13cmos5l_nand3_1_2.Y VPWR 0.83206f
C492 sg13cmos5l_dfrbpq_1_58.D a_5614_5406# 0.01792f
C493 sg13cmos5l_buf_1_0.X sg13cmos5l_dfrbpq_1_0.CLK 0.05323f
C494 sg13cmos5l_dfrbpq_1_2.D sg13cmos5l_xnor2_1_1.B 0.02059f
C495 sg13cmos5l_dlygate4sd3_1_11.X sg13cmos5l_nand3_1_2.C 0.69164f
C496 sg13cmos5l_xnor2_1_5.A VPWR 0.66944f
C497 sg13cmos5l_and2_1_1.A a_19609_6942# 0.35423f
C498 sg13cmos5l_and2_1_1.X sg13cmos5l_dlygate4sd3_1_15.A 0.01912f
C499 sg13cmos5l_dfrbpq_1_15.D sg13cmos5l_nand3_1_3.Y 0.0157f
C500 sg13cmos5l_buf_1_4.X sg13cmos5l_nor3_1_1.C 0.01899f
C501 sg13cmos5l_and2_1_1.A sg13cmos5l_dfrbpq_1_3.D 0.01095f
C502 sg13cmos5l_buf_1_1.X sg13cmos5l_nand3_1_0.A 0.08074f
C503 a_20907_5528# VPWR 0.20735f
C504 a_27695_6995# a_27601_6995# 0.32273f
C505 sg13cmos5l_dlygate4sd3_1_23.X a_3488_3230# 0.06841f
C506 sg13cmos5l_xnor2_1_0.Y a_1870_2571# 0.05146f
C507 sg13cmos5l_xnor2_1_4.A en[3] 0.02491f
C508 a_8106_6168# VPWR 0.45265f
C509 sg13cmos5l_buf_8_0.X sg13cmos5l_dfrbpq_1_2.CLK 0.04143f
C510 a_27306_7680# a_27790_7947# 0.03282f
C511 sg13cmos5l_nand3_1_1.B a_14824_5538# 0.01185f
C512 a_15108_7684# a_16273_8041# 0.4858f
C513 a_11276_4192# a_11488_4192# 0.31789f
C514 sg13cmos5l_dlygate4sd3_1_57.A a_14822_8118# 0.05338f
C515 sg13cmos5l_dfrbpq_1_38.Q a_18778_6132# 0.5223f
C516 sg13cmos5l_dfrbpq_1_42.Q a_20102_8430# 0.01039f
C517 a_13472_1718# VPWR 0.06753f
C518 sg13cmos5l_dfrbpq_1_53.RESET_B a_27280_8650# 0.17693f
C519 a_5626_6886# sg13cmos5l_nor4_2_5.B 0.04242f
C520 sg13cmos5l_dfrbpq_1_58.D VPWR 0.56868f
C521 sg13cmos5l_nor3_1_1.A a_13860_3148# 0.04829f
C522 sg13cmos5l_dfrbpq_1_57.RESET_B sg13cmos5l_dfrbpq_1_56.RESET_B 0.02885f
C523 sg13cmos5l_dlygate4sd3_1_4.X a_25764_8748# 0.0198f
C524 sg13cmos5l_dfrbpq_1_2.CLK a_20805_4667# 0.35961f
C525 sg13cmos5l_buf_1_2.A VPWR 1.28454f
C526 sg13cmos5l_dlygate4sd3_1_6.X a_23368_6254# 0.03253f
C527 sg13cmos5l_dfrbpq_1_12.D sg13cmos5l_dfrbpq_1_13.CLK 0.02709f
C528 a_4293_3155# a_4511_2652# 0.01287f
C529 a_20388_6172# VPWR 0.07294f
C530 a_6180_6172# a_7439_6529# 0.01741f
C531 sg13cmos5l_dlygate4sd3_1_17.X a_27878_2386# 0.01063f
C532 sg13cmos5l_dlygate4sd3_1_57.A VPWR 0.4981f
C533 sg13cmos5l_dfrbpq_1_52.Q VPWR 0.40175f
C534 a_10827_5528# VPWR 0.20557f
C535 a_25103_6995# a_25770_7216# 0.13494f
C536 sg13cmos5l_dfrbpq_1_21.CLK a_5724_5370# 0.09447f
C537 sg13cmos5l_buf_8_0.X a_14542_4923# 0.04216f
C538 a_7716_2700# a_8235_2504# 0.38902f
C539 sg13cmos5l_dfrbpq_1_57.D a_14186_6168# 0.02878f
C540 sg13cmos5l_xnor2_1_0.Y a_14364_1993# 0.0601f
C541 sg13cmos5l_dlygate4sd3_1_16.A sg13cmos5l_nor4_2_0.D 0.42035f
C542 sg13cmos5l_dfrbpq_1_56.D a_17488_6410# 0.0348f
C543 a_19631_2459# a_19888_2602# 0.40419f
C544 sg13cmos5l_xnor2_1_10.Y a_21719_7727# 0.32781f
C545 sg13cmos5l_dlygate4sd3_1_9.X a_23872_5704# 0.04605f
C546 a_2632_8562# a_2632_7766# 0.01095f
C547 a_20871_7767# a_21023_7651# 0.66105f
C548 sg13cmos5l_dfrbpq_1_55.RESET_B a_14495_1603# 0.05328f
C549 a_17984_2514# sg13cmos5l_xnor2_1_1.Y 0.07148f
C550 sg13cmos5l_dlygate4sd3_1_52.X a_13676_6168# 0.11201f
C551 sg13cmos5l_dlygate4sd3_1_19.X sg13cmos5l_xnor2_1_12.B 0.04962f
C552 a_19642_6132# a_18843_5410# 0.01353f
C553 sg13cmos5l_dfrbpq_1_39.Q a_18572_5370# 0.01291f
C554 sg13cmos5l_xnor2_1_4.Y a_27690_5704# 0.01078f
C555 sg13cmos5l_and2_1_1.A sg13cmos5l_dfrbpq_1_2.CLK 0.03771f
C556 sg13cmos5l_dfrbpq_1_57.RESET_B a_11733_6215# 0.34818f
C557 sg13cmos5l_buf_1_4.X sg13cmos5l_dlygate4sd3_1_22.X 0.1728f
C558 a_17100_2572# sg13cmos5l_xnor2_1_2.Y 0.43253f
C559 a_10308_1636# a_11473_1993# 0.4858f
C560 sg13cmos5l_nor3_1_4.A a_15032_5410# 0.05409f
C561 a_6972_8394# a_7754_8588# 0.4806f
C562 a_9640_7680# sg13cmos5l_buf_1_5.A 0.2888f
C563 sg13cmos5l_dfrbpq_1_56.RESET_B sg13cmos5l_dfrbpq_1_56.CLK 0.82618f
C564 sg13cmos5l_buf_1_4.A a_19845_849# 0.0133f
C565 sg13cmos5l_dfrbpq_1_7.Q sg13cmos5l_dlygate4sd3_1_2.A 0.30597f
C566 sg13cmos5l_nor4_2_5.B a_4278_6192# 0.19383f
C567 sg13cmos5l_buf_1_2.A sg13cmos5l_buf_8_10.A 0.03285f
C568 a_23368_3230# VPWR 0.14956f
C569 sg13cmos5l_xnor2_1_4.A a_24612_6172# 0.01744f
C570 a_10231_6132# VPWR 0.17143f
C571 sg13cmos5l_dfrbpq_1_16.Q sg13cmos5l_xor2_1_1.B 0.73475f
C572 sg13cmos5l_dlygate4sd3_1_57.A sg13cmos5l_buf_8_10.A 0.04162f
C573 sg13cmos5l_nor4_2_7.B sg13cmos5l_buf_1_4.A 0.87846f
C574 sg13cmos5l_buf_1_0.A sg13cmos5l_dfrbpq_1_23.D 0.01608f
C575 sg13cmos5l_dfrbpq_1_13.RESET_B sg13cmos5l_dfrbpq_1_11.Q 0.08896f
C576 sg13cmos5l_dlygate4sd3_1_39.A sg13cmos5l_nor4_2_7.B 0.21398f
C577 sg13cmos5l_dfrbpq_1_56.D a_17423_5483# 0.03196f
C578 sg13cmos5l_and2_1_1.A a_20490_3144# 0.02076f
C579 a_16624_7922# a_16367_8041# 0.40419f
C580 a_9446_5410# a_9558_5474# 0.67711f
C581 a_14542_4923# a_14360_3898# 0.01091f
C582 sg13cmos5l_dfrbpq_1_56.RESET_B a_16260_6593# 0.01094f
C583 sg13cmos5l_dfrbpq_1_53.RESET_B sg13cmos5l_dlygate4sd3_1_17.A 0.01214f
C584 sg13cmos5l_buf_1_0.A a_24727_1596# 0.01392f
C585 a_20102_5406# a_20805_5385# 0.02453f
C586 sg13cmos5l_nor4_2_1.D a_19083_3155# 0.01367f
C587 a_18278_3582# a_18981_3155# 0.02431f
C588 a_26150_6918# a_26436_7236# 0.50066f
C589 a_8776_908# VPWR 0.32582f
C590 sg13cmos5l_buf_8_4.A en[4] 0.02957f
C591 a_21904_6410# VPWR 0.18787f
C592 a_10231_2346# a_10444_2382# 0.40419f
C593 sg13cmos5l_buf_1_4.X sg13cmos5l_nor4_2_0.D 0.16414f
C594 a_6699_6179# a_7439_6529# 0.3087f
C595 a_25770_7216# sg13cmos5l_dlygate4sd3_1_40.A 0.13181f
C596 sg13cmos5l_nor4_2_9.D sg13cmos5l_dfrbpq_1_58.Q 0.01604f
C597 a_5855_5676# a_6506_5564# 0.01562f
C598 a_10308_1188# a_10596_883# 0.4806f
C599 sg13cmos5l_buf_1_2.A sg13cmos5l_nor3_1_1.A 0.03751f
C600 sg13cmos5l_dfrbpq_1_21.RESET_B a_3876_8748# 0.50841f
C601 sg13cmos5l_buf_8_5.A a_7594_5374# 0.03913f
C602 sg13cmos5l_dlygate4sd3_1_35.A a_4293_8409# 0.01808f
C603 sg13cmos5l_dfrbpq_1_11.CLK a_10725_849# 0.37588f
C604 sg13cmos5l_dlygate4sd3_1_6.X a_21553_5017# 0.01721f
C605 sg13cmos5l_dlygate4sd3_1_9.X VPWR 0.78596f
C606 sg13cmos5l_dfrbpq_1_13.RESET_B sg13cmos5l_buf_1_4.X 0.05768f
C607 a_5511_4743# sg13cmos5l_nand3_1_3.Y 0.02086f
C608 sg13cmos5l_dlygate4sd3_1_19.X sg13cmos5l_xnor2_1_0.A 0.02059f
C609 a_3304_5538# a_3488_5538# 0.11523f
C610 sg13cmos5l_dlygate4sd3_1_55.X a_23818_7141# 0.03344f
C611 a_23846_3898# VPWR 0.23989f
C612 sg13cmos5l_dlygate4sd3_1_55.X sg13cmos5l_nand3_1_2.B 0.52353f
C613 a_5024_5581# VPWR 0.4535f
C614 sg13cmos5l_xnor2_1_12.Y sg13cmos5l_xnor2_1_0.Y 0.02377f
C615 a_1480_7766# en[4] 0.01494f
C616 a_13642_5374# a_15032_5410# 0.03987f
C617 sg13cmos5l_buf_1_0.X sg13cmos5l_dfrbpq_1_53.RESET_B 0.08747f
C618 a_1985_2572# VPWR 0.2812f
C619 sg13cmos5l_nand3_1_1.A a_16452_5419# 0.01108f
C620 a_19402_1093# a_19142_870# 0.87117f
C621 a_27608_2386# VPWR 0.36721f
C622 sg13cmos5l_nor4_2_7.D sg13cmos5l_buf_8_11.A 1.71106f
C623 a_18213_3873# a_18315_4016# 0.66105f
C624 a_10791_6255# VPWR 0.20557f
C625 sg13cmos5l_dlygate4sd3_1_52.X sg13cmos5l_xnor2_1_5.Y 0.02107f
C626 a_5164_5094# a_5511_4743# 0.06746f
C627 a_5532_5017# a_5422_5094# 0.4858f
C628 sg13cmos5l_xnor2_1_2.B sg13cmos5l_xnor2_1_2.A 2.59564f
C629 sg13cmos5l_nand3_1_1.A sg13cmos5l_nor3_1_4.C 0.0472f
C630 sg13cmos5l_dfrbpq_1_3.D a_19799_1679# 0.30208f
C631 a_20102_6606# a_20362_6136# 0.87117f
C632 sg13cmos5l_buf_1_1.X a_18278_3582# 0.11036f
C633 a_4395_3155# a_5135_3505# 0.3087f
C634 sg13cmos5l_dfrbpq_1_18.D sg13cmos5l_dlygate4sd3_1_18.A 0.06176f
C635 a_24363_7040# a_25029_6179# 0.01665f
C636 a_17034_7680# sg13cmos5l_dfrbpq_1_52.Q 0.13656f
C637 sg13cmos5l_buf_8_9.A VPWR 0.51576f
C638 sg13cmos5l_dfrbpq_1_21.CLK a_3876_4212# 0.10186f
C639 a_15756_1060# a_15791_874# 0.3658f
C640 a_10022_5406# a_10725_5385# 0.02453f
C641 a_16068_7236# VPWR 0.07247f
C642 a_13860_2700# a_14379_2504# 0.38902f
C643 sg13cmos5l_nor4_2_9.D sg13cmos5l_dlygate4sd3_1_30.A 1.30863f
C644 a_1265_5460# sg13cmos5l_nand3_1_1.Y 0.03574f
C645 sg13cmos5l_dfrbpq_1_56.RESET_B a_15108_7684# 0.03571f
C646 a_20490_3144# a_20864_3230# 0.03403f
C647 sg13cmos5l_dfrbpq_1_18.D sg13cmos5l_dlygate4sd3_1_20.A 1.09131f
C648 sg13cmos5l_nor3_1_1.Y sg13cmos5l_dlygate4sd3_1_18.A 0.02348f
C649 sg13cmos5l_dlygate4sd3_1_13.A a_20973_3492# 0.0591f
C650 a_10231_3108# a_10231_2346# 0.02404f
C651 sg13cmos5l_dfrbpq_1_58.RESET_B a_6359_4703# 0.09604f
C652 sg13cmos5l_dfrbpq_1_58.D sg13cmos5l_dfrbpq_1_16.Q 0.06891f
C653 sg13cmos5l_dfrbpq_1_46.D sg13cmos5l_nor4_2_7.B 0.73355f
C654 a_25131_6179# VPWR 0.20657f
C655 sg13cmos5l_buf_1_0.A a_4270_2382# 0.01268f
C656 sg13cmos5l_dlygate4sd3_1_5.A a_19799_1679# 0.02896f
C657 sg13cmos5l_buf_1_4.A a_11824_1090# 0.01309f
C658 a_26436_7236# a_27695_6995# 0.01741f
C659 a_5135_8507# a_5392_8650# 0.40419f
C660 a_25478_5094# sg13cmos5l_dfrbpq_1_0.CLK 0.01099f
C661 sg13cmos5l_dlygate4sd3_1_17.A a_27280_5626# 0.01483f
C662 a_23368_6254# a_23368_5538# 0.01275f
C663 sg13cmos5l_dlygate4sd3_1_52.A en[4] 0.02641f
C664 sg13cmos5l_dlygate4sd3_1_47.A sg13cmos5l_buf_8_11.A 0.01888f
C665 a_5340_1993# a_6261_1679# 0.43042f
C666 sg13cmos5l_buf_8_4.A sg13cmos5l_dfrbpq_1_23.Q 0.03577f
C667 sg13cmos5l_dfrbpq_1_55.Q a_13664_1919# 0.13238f
C668 sg13cmos5l_dlygate4sd3_1_19.X sg13cmos5l_dfrbpq_1_18.D 0.02601f
C669 sg13cmos5l_dlygate4sd3_1_39.X a_26955_7040# 0.01194f
C670 sg13cmos5l_buf_1_0.A sg13cmos5l_nand3_1_1.Y 0.02152f
C671 sg13cmos5l_dlygate4sd3_1_4.A sg13cmos5l_xnor2_1_4.Y 2.25714f
C672 sg13cmos5l_buf_8_5.A sg13cmos5l_dfrbpq_1_57.Q 0.11331f
C673 sg13cmos5l_dlygate4sd3_1_39.X sg13cmos5l_dlygate4sd3_1_40.A 0.02215f
C674 a_23872_8728# sg13cmos5l_nand3_1_2.A 0.02176f
C675 sg13cmos5l_buf_1_4.X sg13cmos5l_dfrbpq_1_0.CLK 0.77015f
C676 a_6453_4703# sg13cmos5l_nand3_1_3.Y 0.01506f
C677 a_28646_3898# VPWR 0.24407f
C678 sg13cmos5l_dlygate4sd3_1_4.A sg13cmos5l_dlygate4sd3_1_11.A 1.98938f
C679 sg13cmos5l_dlygate4sd3_1_55.X a_23844_7236# 0.04264f
C680 sg13cmos5l_buf_1_4.X a_26416_3386# 0.17013f
C681 sg13cmos5l_buf_8_10.A a_16068_7236# 0.01874f
C682 sg13cmos5l_dfrbpq_1_23.Q a_6272_4069# 0.13332f
C683 sg13cmos5l_dfrbpq_1_18.D a_2165_3898# 0.07164f
C684 a_8235_2504# VPWR 0.27363f
C685 sg13cmos5l_buf_1_11.A sg13cmos5l_dfrbpq_1_21.RESET_B 0.03856f
C686 sg13cmos5l_dfrbpq_1_2.CLK a_19799_1679# 0.06175f
C687 sg13cmos5l_nand3_1_1.A sg13cmos5l_xnor2_1_5.A 0.52899f
C688 sg13cmos5l_dfrbpq_1_2.D a_19142_870# 0.30456f
C689 sg13cmos5l_nor3_1_4.A a_15302_5410# 0.01987f
C690 sg13cmos5l_xnor2_1_8.Y a_2016_5721# 0.23026f
C691 a_7799_8821# a_8763_8434# 0.04744f
C692 sg13cmos5l_dfrbpq_1_22.Q a_9176_3185# 0.51455f
C693 sg13cmos5l_dlygate4sd3_1_18.X sg13cmos5l_dfrbpq_1_13.CLK 0.02218f
C694 sg13cmos5l_buf_1_1.X a_24614_3582# 0.01202f
C695 a_6272_1045# a_6391_834# 0.13494f
C696 a_28936_7766# VPWR 0.11957f
C697 sg13cmos5l_xnor2_1_4.Y VPWR 0.67887f
C698 a_20102_6606# a_20907_6179# 0.11742f
C699 sg13cmos5l_dfrbpq_1_21.CLK sg13cmos5l_xor2_1_1.B 0.29715f
C700 a_6951_8648# VPWR 0.20703f
C701 sg13cmos5l_xor2_1_2.A en[4] 0.01254f
C702 sg13cmos5l_buf_1_0.X sg13cmos5l_xnor2_1_3.A 0.016f
C703 sg13cmos5l_dfrbpq_1_53.RESET_B a_3608_7721# 0.03849f
C704 a_24614_3582# a_25317_3155# 0.02431f
C705 a_10827_5528# a_11567_5483# 0.3087f
C706 a_20805_8409# sg13cmos5l_dfrbpq_1_46.CLK 0.35807f
C707 sg13cmos5l_dfrbpq_1_46.CLK sg13cmos5l_nor4_2_7.B 0.0194f
C708 a_17994_7216# VPWR 0.45352f
C709 sg13cmos5l_dfrbpq_1_57.CLK sg13cmos5l_and2_1_3.A 0.04038f
C710 sg13cmos5l_xnor2_1_6.B a_7822_2070# 0.01425f
C711 sg13cmos5l_xnor2_1_6.B sg13cmos5l_dlygate4sd3_1_22.A 0.0326f
C712 a_10943_2652# a_10827_1643# 0.0167f
C713 sg13cmos5l_dlygate4sd3_1_11.A VPWR 0.61669f
C714 a_21647_5483# a_22314_5704# 0.13494f
C715 sg13cmos5l_nand3_1_1.A sg13cmos5l_buf_1_2.A 0.02528f
C716 a_27695_6995# a_27952_7138# 0.40419f
C717 a_5135_8507# a_5041_8507# 0.32273f
C718 a_18382_6435# a_18497_6434# 0.67711f
C719 sg13cmos5l_and2_1_1.A a_22330_2350# 0.01021f
C720 a_13664_7050# VPWR 0.11552f
C721 sg13cmos5l_dfrbpq_1_57.CLK sg13cmos5l_dlygate4sd3_1_28.X 0.02979f
C722 sg13cmos5l_dlygate4sd3_1_57.A sg13cmos5l_nand3_1_1.A 0.05075f
C723 sg13cmos5l_dlygate4sd3_1_17.A sg13cmos5l_dlygate4sd3_1_9.A 0.18391f
C724 sg13cmos5l_xnor2_1_8.Y a_8584_7050# 0.01045f
C725 sg13cmos5l_dfrbpq_1_56.RESET_B sg13cmos5l_nand3_1_1.B 0.0296f
C726 sg13cmos5l_buf_1_0.A a_22138_1596# 0.01196f
C727 sg13cmos5l_dfrbpq_1_57.D a_14720_7766# 0.03431f
C728 sg13cmos5l_dfrbpq_1_13.RESET_B a_11824_1874# 0.17454f
C729 sg13cmos5l_buf_1_4.X a_25092_1188# 0.47966f
C730 sg13cmos5l_dfrbpq_1_21.RESET_B a_7306_7648# 0.358f
C731 a_13288_7766# a_13472_7766# 0.11523f
C732 a_5135_3505# VPWR 0.17331f
C733 sg13cmos5l_nor4_2_5.C sg13cmos5l_dfrbpq_1_32.CLK 0.298f
C734 sg13cmos5l_dlygate4sd3_1_51.X sg13cmos5l_nand3_1_2.Y 0.075f
C735 sg13cmos5l_xnor2_1_8.Y sg13cmos5l_dfrbpq_1_53.RESET_B 0.0315f
C736 sg13cmos5l_nor4_2_5.C a_5134_8118# 0.01762f
C737 a_27023_8507# VPWR 0.17142f
C738 a_8694_4680# sg13cmos5l_nand3_1_3.Y 0.02359f
C739 a_26090_1912# a_26135_1679# 0.36169f
C740 a_4293_3873# a_5041_3971# 0.01058f
C741 a_3876_4212# sg13cmos5l_dlygate4sd3_1_19.A 0.01144f
C742 sg13cmos5l_nor3_1_1.C a_16320_1671# 0.05143f
C743 sg13cmos5l_dfrbpq_1_21.RESET_B a_6391_3858# 0.19897f
C744 sg13cmos5l_buf_1_0.A sg13cmos5l_nand3_1_0.A 0.02105f
C745 sg13cmos5l_buf_8_11.A a_25380_7684# 0.01811f
C746 sg13cmos5l_buf_8_10.A a_17994_7216# 0.05434f
C747 sg13cmos5l_dlygate4sd3_1_21.A a_800_1718# 0.07232f
C748 sg13cmos5l_buf_8_0.X a_18572_5370# 0.02677f
C749 sg13cmos5l_dlygate4sd3_1_51.X a_20907_5528# 0.01399f
C750 sg13cmos5l_dfrbpq_1_0.CLK sg13cmos5l_dlygate4sd3_1_15.A 0.03959f
C751 a_21904_4114# a_22314_4192# 0.1396f
C752 sg13cmos5l_dfrbpq_1_13.RESET_B a_7690_2605# 0.31898f
C753 sg13cmos5l_buf_8_0.X a_14824_5538# 0.04412f
C754 a_19947_992# a_20687_947# 0.3087f
C755 sg13cmos5l_dfrbpq_1_55.RESET_B a_10943_3115# 0.05424f
C756 a_10812_3505# a_10791_3231# 0.38902f
C757 sg13cmos5l_dlygate4sd3_1_15.A a_26416_3386# 0.01403f
C758 sg13cmos5l_nor4_2_0.C a_24900_3148# 0.01121f
C759 sg13cmos5l_buf_8_2.X a_23846_3144# 0.01607f
C760 sg13cmos5l_nor4_2_9.D a_1265_5460# 0.41881f
C761 sg13cmos5l_dfrbpq_1_55.RESET_B sg13cmos5l_dfrbpq_1_59.Q 0.259f
C762 a_20388_6172# a_21553_6529# 0.4858f
C763 sg13cmos5l_buf_8_4.A VPWR 2.38787f
C764 sg13cmos5l_dfrbpq_1_53.RESET_B a_3304_7766# 0.02119f
C765 a_17914_7644# sg13cmos5l_buf_1_2.A 0.10064f
C766 sg13cmos5l_xnor2_1_3.B sg13cmos5l_dfrbpq_1_3.Q 0.02948f
C767 sg13cmos5l_dlygate4sd3_1_17.A a_27601_6995# 0.01865f
C768 sg13cmos5l_dlygate4sd3_1_28.A sg13cmos5l_dlygate4sd3_1_52.X 0.0425f
C769 sg13cmos5l_dlygate4sd3_1_57.A a_14816_8562# 0.01341f
C770 sg13cmos5l_buf_1_0.X a_21719_7309# 0.12912f
C771 sg13cmos5l_dfrbpq_1_52.Q a_17914_7644# 0.51696f
C772 sg13cmos5l_dlygate4sd3_1_51.X a_20388_6172# 0.02229f
C773 sg13cmos5l_dfrbpq_1_56.RESET_B sg13cmos5l_dfrbpq_1_39.Q 0.26176f
C774 sg13cmos5l_xnor2_1_2.A sg13cmos5l_and2_1_3.A 5.15247f
C775 sg13cmos5l_buf_1_0.X a_23660_5704# 0.01766f
C776 a_22314_5704# sg13cmos5l_dlygate4sd3_1_51.A 0.13351f
C777 sg13cmos5l_dfrbpq_1_58.D sg13cmos5l_dfrbpq_1_21.CLK 0.50839f
C778 sg13cmos5l_dfrbpq_1_55.Q a_14630_3898# 0.01095f
C779 sg13cmos5l_dfrbpq_1_57.RESET_B a_13773_6964# 0.35074f
C780 sg13cmos5l_dfrbpq_1_53.RESET_B a_25478_5094# 0.09382f
C781 sg13cmos5l_buf_1_0.A sg13cmos5l_nor4_2_9.D 0.70055f
C782 sg13cmos5l_dfrbpq_1_29.Q sg13cmos5l_dlygate4sd3_1_57.A 0.19045f
C783 a_18604_2070# a_18862_2070# 0.01017f
C784 a_18391_1596# a_18951_1719# 0.3087f
C785 sg13cmos5l_xnor2_1_2.A sg13cmos5l_dlygate4sd3_1_28.X 3.16202f
C786 a_8768_6427# a_9176_6209# 0.02957f
C787 a_6272_4069# VPWR 0.45136f
C788 sg13cmos5l_dfrbpq_1_11.Q a_15322_838# 0.52226f
C789 sg13cmos5l_nor4_2_9.Y a_4202_4656# 0.37557f
C790 sg13cmos5l_dfrbpq_1_21.RESET_B a_8591_8041# 0.19971f
C791 a_10791_4743# a_9915_3898# 0.01044f
C792 a_1480_7766# VPWR 0.13994f
C793 sg13cmos5l_dlygate4sd3_1_4.A a_28532_2680# 0.01742f
C794 sg13cmos5l_dfrbpq_1_53.RESET_B sg13cmos5l_buf_1_4.X 0.01719f
C795 sg13cmos5l_dlygate4sd3_1_19.A sg13cmos5l_xor2_1_1.B 0.05473f
C796 sg13cmos5l_dfrbpq_1_13.CLK a_7351_1596# 0.02492f
C797 sg13cmos5l_dfrbpq_1_56.D a_18497_6434# 0.0142f
C798 sg13cmos5l_nor4_2_9.Y sg13cmos5l_dlygate4sd3_1_23.X 0.18156f
C799 sg13cmos5l_buf_8_5.A a_10308_5724# 0.01249f
C800 sg13cmos5l_dfrbpq_1_58.RESET_B sg13cmos5l_xnor2_1_12.B 0.01798f
C801 sg13cmos5l_buf_8_4.A sg13cmos5l_buf_8_10.A 0.01635f
C802 sg13cmos5l_dlygate4sd3_1_52.X a_9558_5474# 0.03592f
C803 a_21647_5017# VPWR 0.17266f
C804 sg13cmos5l_nor3_1_4.B a_15302_5410# 0.06647f
C805 sg13cmos5l_buf_8_3.A a_10444_3582# 0.01211f
C806 sg13cmos5l_nor4_2_0.C sg13cmos5l_nor3_1_0.B 0.59225f
C807 sg13cmos5l_buf_8_11.A a_27306_7680# 0.01381f
C808 sg13cmos5l_dfrbpq_1_0.CLK sg13cmos5l_dlygate4sd3_1_2.A 0.13279f
C809 a_24586_6136# a_24612_6172# 0.43042f
C810 sg13cmos5l_nor4_2_5.C a_4876_8118# 0.01261f
C811 sg13cmos5l_nor3_1_1.Y sg13cmos5l_dfrbpq_1_11.Q 1.41944f
C812 sg13cmos5l_dfrbpq_1_57.RESET_B a_10725_8409# 0.05801f
C813 sg13cmos5l_dlygate4sd3_1_55.X a_24170_8728# 0.11755f
C814 sg13cmos5l_dfrbpq_1_55.RESET_B a_16184_3185# 0.01141f
C815 sg13cmos5l_dfrbpq_1_11.CLK a_13860_3148# 0.07176f
C816 sg13cmos5l_nor3_1_1.C a_13472_3230# 0.07135f
C817 sg13cmos5l_buf_1_4.A a_25509_849# 0.01547f
C818 sg13cmos5l_dlygate4sd3_1_31.X en[4] 2.53038f
C819 sg13cmos5l_dfrbpq_1_57.RESET_B a_10791_7767# 0.57021f
C820 a_6951_1088# a_7754_1028# 0.15089f
C821 a_7103_1140# a_6862_870# 0.01058f
C822 a_7799_1261# a_7893_1028# 0.87117f
C823 sg13cmos5l_dfrbpq_1_53.RESET_B a_8848_7922# 0.01142f
C824 a_20388_5724# a_20388_4660# 0.01103f
C825 a_6314_4936# a_6359_4703# 0.36169f
C826 a_15340_8430# a_15687_8648# 0.07014f
C827 sg13cmos5l_buf_8_11.A a_20524_8118# 0.01012f
C828 a_27963_6538# a_28570_5374# 0.01374f
C829 a_21904_6410# a_21553_6529# 0.01017f
C830 a_21647_6529# a_22314_6168# 0.13494f
C831 a_28532_2680# VPWR 0.27268f
C832 sg13cmos5l_dfrbpq_1_53.RESET_B a_26896_7922# 0.17633f
C833 sg13cmos5l_dlygate4sd3_1_52.A VPWR 0.61537f
C834 sg13cmos5l_nor3_1_0.C sg13cmos5l_nor4_2_1.D 0.02117f
C835 sg13cmos5l_dfrbpq_1_0.CLK a_25679_2459# 0.0356f
C836 sg13cmos5l_dlygate4sd3_1_1.A a_27226_2350# 0.01045f
C837 sg13cmos5l_dlygate4sd3_1_17.X sg13cmos5l_dlygate4sd3_1_55.A 0.02386f
C838 sg13cmos5l_dlygate4sd3_1_52.X sg13cmos5l_nand3_1_1.Y 0.02418f
C839 a_18843_5410# sg13cmos5l_buf_8_2.X 0.02634f
C840 a_10812_6529# a_10943_6139# 0.48921f
C841 sg13cmos5l_dfrbpq_1_53.CLK sg13cmos5l_buf_8_11.A 0.08726f
C842 sg13cmos5l_buf_1_4.X a_17800_2514# 0.01886f
C843 a_27784_6254# VPWR 0.13195f
C844 a_20362_8653# VPWR 0.09392f
C845 a_6272_8605# a_6604_8430# 0.1396f
C846 a_9562_3862# VPWR 0.32811f
C847 sg13cmos5l_dfrbpq_1_53.RESET_B a_20192_7967# 0.01012f
C848 sg13cmos5l_buf_1_4.X sg13cmos5l_nor3_1_1.Y 3.87294f
C849 sg13cmos5l_and2_1_1.A a_20102_5406# 0.01719f
C850 sg13cmos5l_dlygate4sd3_1_23.X sg13cmos5l_dfrbpq_1_12.D 0.01368f
C851 a_15376_3386# VPWR 0.1885f
C852 sg13cmos5l_xor2_1_2.A a_14822_8118# 0.29263f
C853 sg13cmos5l_dfrbpq_1_42.Q sg13cmos5l_dlygate4sd3_1_6.X 0.1487f
C854 sg13cmos5l_nor3_1_2.B sg13cmos5l_nor3_1_2.Y 0.36267f
C855 sg13cmos5l_dfrbpq_1_53.RESET_B a_26181_8409# 0.0642f
C856 a_11567_1993# VPWR 0.1739f
C857 sg13cmos5l_buf_1_0.A sg13cmos5l_xnor2_1_9.A 0.07593f
C858 sg13cmos5l_xnor2_1_4.A a_28758_3962# 0.01414f
C859 sg13cmos5l_buf_8_3.A a_13860_3148# 0.0549f
C860 a_27114_4192# a_27598_4083# 0.03282f
C861 sg13cmos5l_dlygate4sd3_1_52.A sg13cmos5l_buf_8_10.A 0.03027f
C862 sg13cmos5l_dlygate4sd3_1_21.A sg13cmos5l_dlygate4sd3_1_22.A 2.19096f
C863 a_25029_6179# a_25131_6179# 0.6663f
C864 sg13cmos5l_xor2_1_2.A VPWR 0.99816f
C865 a_4366_7107# sg13cmos5l_nor4_2_9.D 0.19421f
C866 a_1784_3185# a_1985_2572# 0.01425f
C867 sg13cmos5l_dfrbpq_1_21.RESET_B sg13cmos5l_nand3_1_3.Y 0.04019f
C868 sg13cmos5l_nor4_2_9.D a_5143_5370# 0.01277f
C869 sg13cmos5l_xnor2_1_2.A a_14186_6168# 0.01357f
C870 sg13cmos5l_buf_1_4.X sg13cmos5l_xnor2_1_3.A 0.02299f
C871 a_25899_7691# en[4] 0.01595f
C872 sg13cmos5l_nand3_1_2.C a_27963_6538# 0.05286f
C873 sg13cmos5l_nand3_1_3.Y a_8042_3144# 0.04683f
C874 sg13cmos5l_xnor2_1_0.Y a_10596_2057# 0.01153f
C875 sg13cmos5l_and2_1_1.A a_19246_6435# 0.01204f
C876 a_20687_947# a_20593_947# 0.32273f
C877 sg13cmos5l_dfrbpq_1_56.RESET_B a_15782_6918# 0.12005f
C878 sg13cmos5l_dlygate4sd3_1_11.X a_27963_6538# 0.01792f
C879 a_18086_2382# a_18789_2361# 0.02453f
C880 sg13cmos5l_dfrbpq_1_53.RESET_B a_10812_8041# 0.0393f
C881 sg13cmos5l_dlygate4sd3_1_57.A a_15496_7050# 0.02051f
C882 a_18346_2605# a_18372_2700# 0.43042f
C883 a_15708_8394# a_16629_8588# 0.43042f
C884 sg13cmos5l_buf_8_11.A a_21023_7651# 0.01623f
C885 sg13cmos5l_dlygate4sd3_1_19.X sg13cmos5l_dfrbpq_1_23.D 0.13779f
C886 a_14277_2361# a_14495_1603# 0.03649f
C887 sg13cmos5l_xnor2_1_8.Y sg13cmos5l_xnor2_1_5.Y 0.25286f
C888 sg13cmos5l_buf_1_4.A a_26283_5528# 0.02867f
C889 sg13cmos5l_dlygate4sd3_1_9.X a_26538_6168# 0.01256f
C890 a_10282_1600# a_10725_1643# 0.02241f
C891 a_10943_6139# a_11594_6448# 0.01562f
C892 a_10812_6529# sg13cmos5l_dlygate4sd3_1_52.X 0.01207f
C893 sg13cmos5l_buf_1_1.X a_17032_908# 0.29729f
C894 a_25936_2602# VPWR 0.22456f
C895 sg13cmos5l_and2_1_1.X sg13cmos5l_nor3_1_0.B 0.05928f
C896 sg13cmos5l_xor2_1_2.A sg13cmos5l_buf_8_10.A 0.01866f
C897 a_19083_3155# VPWR 0.20935f
C898 a_25764_8748# en[4] 0.03235f
C899 a_5375_7651# VPWR 0.24655f
C900 sg13cmos5l_dfrbpq_1_53.Q sg13cmos5l_dlygate4sd3_1_40.A 1.32132f
C901 sg13cmos5l_dlygate4sd3_1_17.A a_26436_7236# 0.04019f
C902 sg13cmos5l_xor2_1_2.A a_14186_7680# 0.10226f
C903 sg13cmos5l_buf_1_1.X a_19888_2602# 0.20582f
C904 sg13cmos5l_dfrbpq_1_13.RESET_B a_10827_992# 0.55508f
C905 sg13cmos5l_dlygate4sd3_1_38.A sg13cmos5l_and2_1_3.A 0.05619f
C906 sg13cmos5l_buf_1_1.X sg13cmos5l_xnor2_1_1.Y 0.12648f
C907 sg13cmos5l_dfrbpq_1_13.CLK a_10725_1643# 0.34872f
C908 sg13cmos5l_nand3_1_0.A sg13cmos5l_nor3_1_0.Y 0.02153f
C909 a_16485_6897# a_16587_7040# 0.66105f
C910 sg13cmos5l_nand3_1_3.Y a_8776_4026# 0.01138f
C911 a_1784_8434# VPWR 0.32994f
C912 a_26128_6410# a_25871_6529# 0.40419f
C913 sg13cmos5l_dfrbpq_1_32.CLK a_6597_6179# 0.35751f
C914 a_23576_4697# VPWR 0.35207f
C915 sg13cmos5l_dfrbpq_1_0.D a_20666_2680# 0.08519f
C916 sg13cmos5l_buf_8_11.A a_28186_7644# 0.01971f
C917 sg13cmos5l_nor3_1_1.Y a_16643_1168# 0.0241f
C918 a_10022_870# a_10308_1188# 0.50066f
C919 a_10282_1093# a_10725_849# 0.02241f
C920 sg13cmos5l_dfrbpq_1_56.RESET_B a_17584_7138# 0.18178f
C921 sg13cmos5l_nor3_1_4.A a_17327_6995# 0.03531f
C922 sg13cmos5l_nor4_2_1.A sg13cmos5l_buf_1_4.X 2.73029f
C923 a_18363_6922# a_19361_6434# 0.01447f
C924 a_17614_8619# sg13cmos5l_nor4_2_4.D 0.22889f
C925 sg13cmos5l_nand3_1_0.B a_23872_1168# 0.02177f
C926 sg13cmos5l_xnor2_1_0.Y sg13cmos5l_dfrbpq_1_21.Q 0.06414f
C927 a_5375_7651# a_5345_7108# 0.01306f
C928 a_20805_3873# VPWR 0.24336f
C929 sg13cmos5l_dlygate4sd3_1_17.X sg13cmos5l_xnor2_1_4.B 0.1632f
C930 sg13cmos5l_dfrbpq_1_23.D a_7799_4285# 0.30463f
C931 sg13cmos5l_dlygate4sd3_1_17.A en[3] 0.03185f
C932 sg13cmos5l_dfrbpq_1_56.RESET_B sg13cmos5l_buf_8_0.X 0.28088f
C933 sg13cmos5l_xnor2_1_4.A a_25354_7648# 0.02341f
C934 sg13cmos5l_dlygate4sd3_1_6.X a_20907_4016# 0.02598f
C935 sg13cmos5l_nor3_1_2.C a_7332_7684# 0.03157f
C936 sg13cmos5l_dfrbpq_1_53.Q sg13cmos5l_dlygate4sd3_1_17.X 0.9719f
C937 a_23835_8050# a_24261_6897# 0.01179f
C938 a_15850_3862# a_15680_4026# 0.03811f
C939 a_7046_8118# VPWR 0.92833f
C940 sg13cmos5l_nor3_1_2.C sg13cmos5l_nor4_2_5.D 0.01237f
C941 a_3876_3148# a_4293_3155# 0.49014f
C942 sg13cmos5l_dfrbpq_1_21.RESET_B a_4359_2600# 0.5699f
C943 sg13cmos5l_dlygate4sd3_1_19.X sg13cmos5l_nand3_1_1.Y 0.01152f
C944 a_25094_8118# VPWR 0.92902f
C945 a_18660_2395# VPWR 0.01782f
C946 a_3878_7680# VPWR 0.24397f
C947 sg13cmos5l_dlygate4sd3_1_31.X VPWR 0.72367f
C948 a_16068_7236# a_16356_6931# 0.4806f
C949 a_13834_2605# a_13574_2382# 0.87117f
C950 sg13cmos5l_dlygate4sd3_1_21.X a_7716_2700# 0.02077f
C951 a_18564_3148# a_19823_3505# 0.01741f
C952 a_20907_4016# osc 0.02316f
C953 sg13cmos5l_dfrbpq_1_13.CLK a_4380_834# 0.07721f
C954 sg13cmos5l_buf_1_4.A a_9446_874# 0.01286f
C955 a_3876_8748# a_5135_8507# 0.01741f
C956 sg13cmos5l_xnor2_1_8.Y a_8842_6886# 0.04585f
C957 a_10444_2382# a_10791_2600# 0.07014f
C958 a_26538_6168# sg13cmos5l_dlygate4sd3_1_11.A 0.1336f
C959 a_24641_4922# VPWR 0.24527f
C960 sg13cmos5l_nor4_2_0.D a_25066_1093# 0.01143f
C961 a_4759_1596# a_5230_2070# 0.32273f
C962 sg13cmos5l_dfrbpq_1_58.RESET_B a_6551_5797# 0.13536f
C963 a_22049_1060# a_22330_838# 0.33585f
C964 sg13cmos5l_buf_1_0.X en[3] 0.08841f
C965 sg13cmos5l_dlygate4sd3_1_2.A sg13cmos5l_xnor2_1_3.A 0.03418f
C966 sg13cmos5l_dfrbpq_1_46.D en[4] 0.04147f
C967 a_7534_4923# a_7649_4922# 0.67711f
C968 sg13cmos5l_dfrbpq_1_53.RESET_B sg13cmos5l_buf_1_5.A 0.01034f
C969 sg13cmos5l_nor3_1_4.A sg13cmos5l_nor3_1_4.B 2.38291f
C970 sg13cmos5l_buf_1_1.X a_26229_1679# 0.32472f
C971 sg13cmos5l_dfrbpq_1_2.CLK a_19947_992# 0.07184f
C972 sg13cmos5l_dfrbpq_1_37.D a_23844_7236# 0.05103f
C973 a_25707_4016# VPWR 0.20785f
C974 sg13cmos5l_nor4_2_1.A sg13cmos5l_dlygate4sd3_1_15.A 0.08922f
C975 sg13cmos5l_buf_8_4.A sg13cmos5l_dfrbpq_1_21.CLK 0.18054f
C976 sg13cmos5l_nor4_2_5.Y sg13cmos5l_nor4_2_9.Y 0.15213f
C977 sg13cmos5l_dlygate4sd3_1_9.X a_27418_6132# 0.01755f
C978 a_4012_2382# VPWR 0.22156f
C979 sg13cmos5l_dlygate4sd3_1_6.A sg13cmos5l_dfrbpq_1_2.D 1.88056f
C980 sg13cmos5l_dfrbpq_1_58.RESET_B sg13cmos5l_xnor2_1_5.Y 0.0286f
C981 a_17796_4212# a_18084_3907# 0.4806f
C982 sg13cmos5l_dlygate4sd3_1_6.X sg13cmos5l_dfrbpq_1_2.D 0.58279f
C983 a_7103_8700# a_7893_8588# 0.02241f
C984 a_7851_7691# VPWR 0.20905f
C985 sg13cmos5l_buf_1_1.X a_20080_3386# 0.20701f
C986 a_5802_3144# a_6250_3108# 0.037f
C987 a_4511_1140# a_5301_1028# 0.02241f
C988 a_4359_1088# a_4380_834# 0.38871f
C989 sg13cmos5l_dfrbpq_1_21.CLK a_6272_4069# 0.04577f
C990 sg13cmos5l_xnor2_1_4.A a_26283_4667# 0.03109f
C991 sg13cmos5l_dfrbpq_1_3.D sg13cmos5l_nand3_1_0.B 0.11428f
C992 sg13cmos5l_dfrbpq_1_55.RESET_B a_10444_2382# 0.17023f
C993 a_25899_7691# VPWR 0.20648f
C994 a_17327_6995# a_17233_6995# 0.32273f
C995 a_23368_3230# a_23368_2514# 0.01275f
C996 a_18874_8398# VPWR 0.32837f
C997 sg13cmos5l_dlygate4sd3_1_55.X a_23861_6538# 0.01373f
C998 sg13cmos5l_nor4_2_9.Y sg13cmos5l_and2_1_3.A 0.29091f
C999 sg13cmos5l_nor3_1_1.A a_16469_2002# 0.01191f
C1000 sg13cmos5l_dfrbpq_1_2.D osc 0.02442f
C1001 sg13cmos5l_xor2_1_2.A sg13cmos5l_nand3_1_1.A 0.35019f
C1002 a_5802_8728# a_5375_7651# 0.01099f
C1003 a_4293_8409# a_4164_8443# 0.01562f
C1004 a_20362_4624# a_20805_4667# 0.02241f
C1005 sg13cmos5l_dfrbpq_1_37.D sg13cmos5l_nand3_1_2.C 0.05315f
C1006 a_18789_2361# a_19103_1603# 0.02632f
C1007 sg13cmos5l_buf_1_0.X a_24612_6172# 0.47438f
C1008 sg13cmos5l_dfrbpq_1_58.RESET_B a_6693_6897# 0.05528f
C1009 sg13cmos5l_buf_8_4.A sg13cmos5l_xnor2_1_6.A 0.05218f
C1010 sg13cmos5l_nand3_1_2.Y a_24922_4620# 0.05151f
C1011 sg13cmos5l_dfrbpq_1_46.CLK en[4] 6.21098f
C1012 sg13cmos5l_dfrbpq_1_55.Q sg13cmos5l_nor3_1_1.C 0.01816f
C1013 sg13cmos5l_dfrbpq_1_13.RESET_B a_10022_2070# 0.1358f
C1014 sg13cmos5l_buf_1_4.A sg13cmos5l_dlygate4sd3_1_4.A 0.05431f
C1015 a_9558_4680# a_9446_4656# 0.67711f
C1016 a_18789_2361# a_19537_2459# 0.01058f
C1017 a_13574_2382# VPWR 1.0033f
C1018 sg13cmos5l_buf_1_4.X a_24727_1596# 0.05052f
C1019 a_808_3230# VPWR 0.14515f
C1020 sg13cmos5l_buf_1_0.A sg13cmos5l_xnor2_1_0.Y 2.02927f
C1021 a_25764_8748# VPWR 0.0721f
C1022 sg13cmos5l_dfrbpq_1_21.RESET_B a_8312_4697# 0.01005f
C1023 sg13cmos5l_dlygate4sd3_1_2.A sg13cmos5l_dlygate4sd3_1_1.A 0.28467f
C1024 a_5319_1719# VPWR 0.20603f
C1025 sg13cmos5l_dlygate4sd3_1_22.X a_4511_1140# 0.01365f
C1026 a_10231_2346# VPWR 0.21531f
C1027 sg13cmos5l_xnor2_1_8.Y sg13cmos5l_xnor2_1_13.Y 0.17258f
C1028 sg13cmos5l_nor3_1_2.C sg13cmos5l_dfrbpq_1_15.D 0.01434f
C1029 a_2816_7050# VPWR 0.07661f
C1030 a_20102_3894# a_20805_3873# 0.02453f
C1031 sg13cmos5l_dlygate4sd3_1_18.X sg13cmos5l_dfrbpq_1_12.D 1.25843f
C1032 a_6391_3858# a_6250_3108# 0.03213f
C1033 a_10725_6897# a_10827_7040# 0.66105f
C1034 sg13cmos5l_buf_1_1.X a_20907_4016# 0.55402f
C1035 a_25936_2602# a_25439_1603# 0.01063f
C1036 sg13cmos5l_buf_1_11.A sg13cmos5l_buf_1_0.A 1.36783f
C1037 sg13cmos5l_dfrbpq_1_13.RESET_B a_3799_2346# 0.01664f
C1038 a_16167_4743# a_16970_4936# 0.15089f
C1039 a_1509_7216# VPWR 0.01355f
C1040 sg13cmos5l_buf_1_1.X a_19402_1093# 0.35265f
C1041 sg13cmos5l_nor4_2_9.D sg13cmos5l_dlygate4sd3_1_19.X 0.38536f
C1042 a_10112_3431# a_10444_3582# 0.1396f
C1043 a_10231_3108# sg13cmos5l_dfrbpq_1_55.RESET_B 0.19885f
C1044 sg13cmos5l_nor4_2_3.Y a_8042_3144# 0.38314f
C1045 sg13cmos5l_dlygate4sd3_1_22.X a_8975_2459# 0.04215f
C1046 sg13cmos5l_dlygate4sd3_1_15.A a_21435_3514# 0.05106f
C1047 sg13cmos5l_dfrbpq_1_0.CLK a_24900_3148# 0.11183f
C1048 sg13cmos5l_dlygate4sd3_1_21.X a_8576_3230# 0.03541f
C1049 sg13cmos5l_xnor2_1_6.Y a_10308_1188# 0.03487f
C1050 sg13cmos5l_buf_1_0.A a_8759_1679# 0.02326f
C1051 a_10444_8118# VPWR 0.18692f
C1052 sg13cmos5l_dfrbpq_1_46.CLK a_21023_7188# 0.39394f
C1053 sg13cmos5l_buf_1_4.A VPWR 1.54864f
C1054 a_25317_3155# a_25419_3155# 0.6663f
C1055 sg13cmos5l_xor2_1_2.A sg13cmos5l_dlygate4sd3_1_50.A 0.16531f
C1056 a_25936_2602# a_25585_2459# 0.01017f
C1057 sg13cmos5l_nand3_1_2.A a_23835_8050# 0.05006f
C1058 a_15376_2602# a_15786_2680# 0.1396f
C1059 a_15127_8394# sg13cmos5l_dfrbpq_1_56.RESET_B 0.19921f
C1060 sg13cmos5l_dlygate4sd3_1_39.A VPWR 0.44165f
C1061 sg13cmos5l_dfrbpq_1_2.CLK a_18372_2700# 0.11313f
C1062 a_27280_8650# a_27690_8728# 0.1396f
C1063 sg13cmos5l_nor4_2_7.D sg13cmos5l_dlygate4sd3_1_9.X 0.72994f
C1064 sg13cmos5l_dfrbpq_1_29.Q sg13cmos5l_xor2_1_2.A 0.01493f
C1065 a_28936_4742# VPWR 0.12281f
C1066 sg13cmos5l_buf_8_0.X a_18826_4620# 0.04111f
C1067 a_1397_5026# sg13cmos5l_xnor2_1_12.Y 0.04203f
C1068 sg13cmos5l_dlygate4sd3_1_34.A a_5375_7651# 0.01702f
C1069 a_20388_4660# a_20907_4667# 0.38871f
C1070 a_20805_4667# a_20676_5081# 0.01562f
C1071 a_7564_2070# a_7822_2070# 0.01017f
C1072 a_6261_1679# a_6167_1679# 0.87117f
C1073 a_7351_1596# a_7911_1719# 0.3087f
C1074 a_21813_7727# VPWR 0.0956f
C1075 sg13cmos5l_xnor2_1_12.B a_1248_4695# 0.43235f
C1076 sg13cmos5l_dfrbpq_1_58.RESET_B a_8842_6886# 0.02113f
C1077 sg13cmos5l_xnor2_1_2.A a_10022_5406# 0.04567f
C1078 sg13cmos5l_buf_1_0.X a_25871_6529# 0.19897f
C1079 a_25066_1093# a_25092_1188# 0.43042f
C1080 a_10308_8748# a_10596_8443# 0.4806f
C1081 sg13cmos5l_dlygate4sd3_1_21.X VPWR 0.77993f
C1082 a_10812_5017# a_10791_4743# 0.38902f
C1083 sg13cmos5l_dfrbpq_1_58.RESET_B sg13cmos5l_dfrbpq_1_23.D 0.02555f
C1084 sg13cmos5l_dfrbpq_1_13.RESET_B a_4511_1140# 0.06624f
C1085 a_4832_4943# VPWR 0.45275f
C1086 sg13cmos5l_nor4_2_5.D sg13cmos5l_dfrbpq_1_58.D 0.06784f
C1087 sg13cmos5l_dfrbpq_1_21.RESET_B a_6951_4112# 0.56098f
C1088 a_14343_1719# a_15146_1912# 0.15089f
C1089 sg13cmos5l_nor3_1_1.A a_13574_2382# 0.30122f
C1090 a_23712_6207# sg13cmos5l_xnor2_1_4.B 0.2273f
C1091 sg13cmos5l_dfrbpq_1_37.D a_24170_8728# 0.15963f
C1092 sg13cmos5l_nor3_1_0.C VPWR 0.86777f
C1093 sg13cmos5l_dfrbpq_1_13.RESET_B a_8975_2459# 0.21328f
C1094 a_10725_6897# a_10596_6931# 0.01562f
C1095 sg13cmos5l_nor3_1_1.Y a_10827_992# 0.01031f
C1096 sg13cmos5l_dfrbpq_1_2.D sg13cmos5l_buf_1_1.X 0.98652f
C1097 sg13cmos5l_buf_1_1.X a_25308_1993# 0.51292f
C1098 sg13cmos5l_dfrbpq_1_2.D a_21062_1632# 0.02794f
C1099 sg13cmos5l_buf_1_0.A sg13cmos5l_xnor2_1_2.Y 0.15982f
C1100 sg13cmos5l_and2_1_1.A a_18826_4620# 0.02435f
C1101 sg13cmos5l_dfrbpq_1_23.Q a_5663_4627# 0.01011f
C1102 a_7103_1140# a_6951_1088# 0.6663f
C1103 a_10282_7141# a_10022_6918# 0.87117f
C1104 sg13cmos5l_dfrbpq_1_58.RESET_B sg13cmos5l_dlygate4sd3_1_28.A 0.04515f
C1105 sg13cmos5l_xnor2_1_3.B a_18538_3112# 0.03115f
C1106 a_28289_8620# sg13cmos5l_dfrbpq_1_53.Q 0.01121f
C1107 sg13cmos5l_nor4_2_7.B a_23818_7141# 0.01116f
C1108 sg13cmos5l_dlygate4sd3_1_53.A a_8584_7050# 0.02427f
C1109 a_18444_1060# VPWR 0.26265f
C1110 sg13cmos5l_buf_1_5.A sg13cmos5l_xnor2_1_5.Y 0.39825f
C1111 sg13cmos5l_nor4_2_7.B sg13cmos5l_nand3_1_2.B 0.20409f
C1112 a_19893_1679# VPWR 0.09535f
C1113 sg13cmos5l_xnor2_1_2.A sg13cmos5l_dfrbpq_1_55.D 0.06973f
C1114 sg13cmos5l_dlygate4sd3_1_51.X a_23576_4697# 0.04252f
C1115 sg13cmos5l_dfrbpq_1_15.D sg13cmos5l_xor2_1_1.B 0.02156f
C1116 sg13cmos5l_buf_1_4.A sg13cmos5l_nor3_1_1.A 0.0663f
C1117 a_27690_8728# sg13cmos5l_dlygate4sd3_1_17.A 0.16313f
C1118 sg13cmos5l_and2_1_1.X a_24261_6897# 0.01245f
C1119 sg13cmos5l_buf_8_4.A sg13cmos5l_buf_8_3.A 0.12829f
C1120 sg13cmos5l_buf_1_4.A a_15041_1060# 0.01147f
C1121 sg13cmos5l_dfrbpq_1_46.D VPWR 1.33643f
C1122 a_20972_2680# VPWR 0.42812f
C1123 sg13cmos5l_buf_1_5.A a_15878_5406# 0.01187f
C1124 a_6604_3894# VPWR 0.18782f
C1125 sg13cmos5l_dfrbpq_1_32.CLK a_7103_8700# 0.36693f
C1126 sg13cmos5l_dlygate4sd3_1_34.A a_3878_7680# 0.01057f
C1127 sg13cmos5l_dlygate4sd3_1_31.X sg13cmos5l_dlygate4sd3_1_34.A 0.01954f
C1128 a_8763_8434# en[1] 0.06512f
C1129 a_7799_4285# a_7754_4052# 0.36169f
C1130 a_6972_3858# a_6862_3894# 0.4858f
C1131 a_3488_4742# VPWR 0.06946f
C1132 sg13cmos5l_dlygate4sd3_1_51.A a_23368_4742# 0.07359f
C1133 sg13cmos5l_dlygate4sd3_1_22.X a_9176_874# 0.01614f
C1134 sg13cmos5l_and2_1_4.X a_14235_6922# 0.76052f
C1135 a_9915_3898# a_10791_3231# 0.01277f
C1136 sg13cmos5l_dfrbpq_1_22.D sg13cmos5l_nor3_1_1.C 0.42663f
C1137 a_25188_4212# a_25707_4016# 0.38902f
C1138 a_2016_4209# a_2165_3898# 0.3658f
C1139 sg13cmos5l_nand3_1_2.A sg13cmos5l_nor4_2_0.C 0.05425f
C1140 sg13cmos5l_xnor2_1_8.Y sg13cmos5l_nor4_2_9.D 3.09759f
C1141 sg13cmos5l_dlygate4sd3_1_38.A a_5626_6886# 0.50714f
C1142 sg13cmos5l_xnor2_1_13.A sg13cmos5l_xnor2_1_12.Y 0.6081f
C1143 a_27994_3862# a_27195_3514# 0.01519f
C1144 sg13cmos5l_nor4_2_9.Y a_4160_7050# 0.04898f
C1145 a_13574_3582# a_13860_3148# 0.50066f
C1146 sg13cmos5l_buf_1_4.A a_26853_6897# 0.02031f
C1147 a_11824_7138# a_11473_6995# 0.01017f
C1148 sg13cmos5l_dlygate4sd3_1_35.A sg13cmos5l_dfrbpq_1_21.RESET_B 3.48126f
C1149 sg13cmos5l_dlygate4sd3_1_39.A a_26853_6897# 0.03449f
C1150 sg13cmos5l_xnor2_1_2.A a_9446_6168# 0.04088f
C1151 a_15839_8700# a_15708_8394# 0.49014f
C1152 sg13cmos5l_nor4_2_7.B a_23844_7236# 0.03032f
C1153 sg13cmos5l_dfrbpq_1_58.RESET_B sg13cmos5l_nand3_1_1.Y 0.02578f
C1154 sg13cmos5l_nor3_1_0.A a_19428_1188# 0.0277f
C1155 sg13cmos5l_dlygate4sd3_1_17.X a_25288_4742# 0.07078f
C1156 sg13cmos5l_dfrbpq_1_46.CLK VPWR 2.40261f
C1157 a_11488_4192# VPWR 0.391f
C1158 sg13cmos5l_dfrbpq_1_32.CLK a_7893_8588# 0.0128f
C1159 sg13cmos5l_dlygate4sd3_1_4.X sg13cmos5l_nand3_1_2.C 0.16415f
C1160 sg13cmos5l_dfrbpq_1_53.RESET_B a_18922_7644# 0.04204f
C1161 a_16566_3168# VPWR 0.21491f
C1162 sg13cmos5l_buf_1_0.A a_26229_1679# 0.0167f
C1163 sg13cmos5l_nor4_2_5.Y sg13cmos5l_and2_1_3.A 0.01936f
C1164 sg13cmos5l_dfrbpq_1_7.Q a_26826_3144# 0.1316f
C1165 sg13cmos5l_dlygate4sd3_1_4.X sg13cmos5l_dlygate4sd3_1_11.X 2.65168f
C1166 sg13cmos5l_dlygate4sd3_1_5.A sg13cmos5l_dfrbpq_1_3.D 0.07336f
C1167 sg13cmos5l_dfrbpq_1_56.RESET_B sg13cmos5l_xnor2_1_2.A 0.85718f
C1168 a_26351_947# a_26608_1090# 0.40419f
C1169 a_25509_849# a_25380_883# 0.01562f
C1170 a_9915_3898# sg13cmos5l_dfrbpq_1_17.Q 0.05519f
C1171 sg13cmos5l_buf_8_2.X sg13cmos5l_dlygate4sd3_1_10.A 0.02733f
C1172 a_10943_4627# a_11639_4703# 0.02453f
C1173 sg13cmos5l_dfrbpq_1_13.CLK a_8063_1603# 0.37885f
C1174 sg13cmos5l_dfrbpq_1_22.D a_15786_3144# 0.0123f
C1175 a_5663_4627# VPWR 0.24656f
C1176 sg13cmos5l_buf_1_5.A a_8842_6886# 0.05584f
C1177 sg13cmos5l_xnor2_1_4.Y a_24922_4620# 0.01005f
C1178 a_3590_3582# sg13cmos5l_dfrbpq_1_13.Q 0.01047f
C1179 a_4012_870# VPWR 0.187f
C1180 sg13cmos5l_dlygate4sd3_1_6.X sg13cmos5l_buf_8_11.A 0.02266f
C1181 sg13cmos5l_nor4_2_7.B sg13cmos5l_nand3_1_2.C 0.01158f
C1182 sg13cmos5l_buf_1_4.A a_28362_7216# 0.02194f
C1183 sg13cmos5l_buf_1_0.A sg13cmos5l_nand3_1_3.Y 0.01173f
C1184 sg13cmos5l_dfrbpq_1_53.RESET_B a_25738_5629# 0.34819f
C1185 sg13cmos5l_dlygate4sd3_1_28.X sg13cmos5l_and2_1_3.A 0.76229f
C1186 sg13cmos5l_dfrbpq_1_37.D sg13cmos5l_dlygate4sd3_1_55.X 0.21515f
C1187 a_25738_5629# a_26181_5385# 0.02241f
C1188 a_25478_5406# a_25764_5724# 0.50066f
C1189 sg13cmos5l_nor4_2_7.B a_25360_7138# 0.014f
C1190 a_20944_1090# VPWR 0.18709f
C1191 sg13cmos5l_dfrbpq_1_58.D a_5532_5017# 0.03946f
C1192 sg13cmos5l_dfrbpq_1_29.Q a_18874_8398# 0.52107f
C1193 sg13cmos5l_dlygate4sd3_1_23.X a_3850_4117# 0.03023f
C1194 sg13cmos5l_dfrbpq_1_3.D a_23958_1656# 0.20336f
C1195 a_18315_4016# VPWR 0.20707f
C1196 sg13cmos5l_dfrbpq_1_46.D a_23660_8728# 0.09448f
C1197 sg13cmos5l_buf_2_0.X sg13cmos5l_dlygate4sd3_1_6.A 0.01802f
C1198 sg13cmos5l_buf_1_5.A sg13cmos5l_dlygate4sd3_1_28.A 0.25674f
C1199 sg13cmos5l_buf_1_1.X sg13cmos5l_nor4_2_0.B 2.93811f
C1200 sg13cmos5l_dlygate4sd3_1_9.X a_27280_4898# 0.04938f
C1201 sg13cmos5l_nand3_1_2.A sg13cmos5l_and2_1_1.X 0.75392f
C1202 sg13cmos5l_nor4_2_4.D a_16491_6179# 0.02812f
C1203 a_20973_3492# VPWR 0.45064f
C1204 a_15687_8648# a_15525_7691# 0.01667f
C1205 sg13cmos5l_xnor2_1_5.Y a_15850_3862# 0.06696f
C1206 sg13cmos5l_nand3_1_2.A sg13cmos5l_xnor2_1_10.Y 0.16746f
C1207 sg13cmos5l_xnor2_1_3.B a_18372_2700# 0.0428f
C1208 sg13cmos5l_nand3_1_0.A sg13cmos5l_dfrbpq_1_2.Q 0.01081f
C1209 sg13cmos5l_dlygate4sd3_1_22.A a_5207_1261# 0.06059f
C1210 a_14054_8434# sg13cmos5l_xor2_1_2.A 0.0207f
C1211 a_17472_1671# VPWR 0.25792f
C1212 a_14360_3898# a_14630_3898# 0.33585f
C1213 sg13cmos5l_dlygate4sd3_1_6.X sg13cmos5l_and2_1_0.X 0.13488f
C1214 sg13cmos5l_xnor2_1_3.B a_18346_2605# 0.02092f
C1215 a_26608_1090# a_26257_947# 0.01017f
C1216 a_1169_3502# sg13cmos5l_xnor2_1_0.A 0.27497f
C1217 sg13cmos5l_dlygate4sd3_1_13.A a_22049_2572# 0.01189f
C1218 sg13cmos5l_dfrbpq_1_53.CLK sg13cmos5l_dlygate4sd3_1_9.X 0.25354f
C1219 a_7534_4923# VPWR 0.21396f
C1220 a_16629_8588# VPWR 0.09392f
C1221 sg13cmos5l_nor4_2_1.D a_17702_3144# 0.01445f
C1222 sg13cmos5l_buf_1_4.X a_20102_5094# 0.10593f
C1223 sg13cmos5l_xnor2_1_10.Y a_22314_5704# 0.02171f
C1224 a_21647_5017# a_21647_3971# 0.02404f
C1225 a_3590_8430# a_3876_8748# 0.50066f
C1226 a_20192_7093# en[4] 0.01012f
C1227 sg13cmos5l_dlygate4sd3_1_53.A sg13cmos5l_xnor2_1_5.Y 0.02352f
C1228 sg13cmos5l_dfrbpq_1_58.RESET_B sg13cmos5l_nor4_2_9.D 0.22909f
C1229 sg13cmos5l_and2_1_1.X a_24326_6606# 0.03547f
C1230 a_19888_2602# a_20298_2680# 0.1396f
C1231 sg13cmos5l_dfrbpq_1_58.RESET_B a_5855_5676# 0.07481f
C1232 sg13cmos5l_nor3_1_0.B sg13cmos5l_xnor2_1_3.A 0.04308f
C1233 a_27214_1899# VPWR 0.21535f
C1234 sg13cmos5l_buf_1_4.X sg13cmos5l_dfrbpq_1_12.Q 0.41307f
C1235 a_22314_4192# VPWR 0.47174f
C1236 a_10596_2057# a_10827_1643# 0.15089f
C1237 a_4951_4620# a_4293_3873# 0.01314f
C1238 a_18380_7644# a_18664_7766# 0.01225f
C1239 sg13cmos5l_dfrbpq_1_53.CLK a_25131_6179# 0.01295f
C1240 sg13cmos5l_xnor2_1_0.Y sg13cmos5l_dlygate4sd3_1_18.A 0.03862f
C1241 a_27195_3514# VPWR 1.14403f
C1242 a_7594_5374# a_7649_4922# 0.017f
C1243 sg13cmos5l_dfrbpq_1_57.Q a_9558_4680# 0.03678f
C1244 sg13cmos5l_dfrbpq_1_13.RESET_B sg13cmos5l_nor3_1_0.A 0.01964f
C1245 a_28646_874# a_28758_938# 0.67711f
C1246 sg13cmos5l_dfrbpq_1_57.RESET_B a_10943_4627# 0.058f
C1247 a_4293_3155# a_4395_3155# 0.6663f
C1248 sg13cmos5l_dfrbpq_1_12.D sg13cmos5l_dfrbpq_1_22.Q 0.64365f
C1249 a_3304_3230# a_3488_3230# 0.11523f
C1250 a_19823_3505# a_19729_3505# 0.32273f
C1251 sg13cmos5l_dlygate4sd3_1_18.A a_8759_1679# 0.02747f
C1252 sg13cmos5l_nor3_1_1.Y a_8975_2459# 0.01415f
C1253 sg13cmos5l_nor4_2_9.Y a_4278_6192# 0.01012f
C1254 sg13cmos5l_buf_1_0.A sg13cmos5l_dfrbpq_1_2.D 0.07841f
C1255 a_10231_4620# VPWR 0.17294f
C1256 sg13cmos5l_buf_1_0.A a_25308_1993# 0.0163f
C1257 sg13cmos5l_dlygate4sd3_1_51.X sg13cmos5l_nor3_1_0.C 0.46242f
C1258 sg13cmos5l_dlygate4sd3_1_19.X sg13cmos5l_xnor2_1_0.Y 0.04333f
C1259 a_10812_2346# a_11733_2540# 0.43042f
C1260 sg13cmos5l_dfrbpq_1_21.CLK a_4832_4943# 0.03926f
C1261 a_4395_8552# a_5223_7767# 0.01017f
C1262 a_10022_6918# VPWR 0.92863f
C1263 a_28374_1656# a_28262_1632# 0.67711f
C1264 a_10308_1188# a_11473_947# 0.4858f
C1265 a_10827_992# a_10596_883# 0.15089f
C1266 sg13cmos5l_xnor2_1_5.A a_17100_2572# 0.11957f
C1267 a_18144_4695# sg13cmos5l_buf_1_4.X 0.01757f
C1268 sg13cmos5l_xnor2_1_0.Y a_2165_3898# 0.01254f
C1269 sg13cmos5l_dfrbpq_1_57.RESET_B sg13cmos5l_dfrbpq_1_53.RESET_B 0.07752f
C1270 sg13cmos5l_dlygate4sd3_1_19.X a_5802_3144# 0.04491f
C1271 sg13cmos5l_dfrbpq_1_53.CLK sg13cmos5l_xnor2_1_4.Y 0.03552f
C1272 sg13cmos5l_and2_1_1.X sg13cmos5l_dlygate4sd3_1_55.A 0.01505f
C1273 a_26181_5385# a_26052_5419# 0.01562f
C1274 a_27598_4083# VPWR 0.21469f
C1275 a_24170_1168# VPWR 0.23174f
C1276 sg13cmos5l_dfrbpq_1_46.D sg13cmos5l_dlygate4sd3_1_51.X 0.43832f
C1277 sg13cmos5l_xnor2_1_10.Y sg13cmos5l_dlygate4sd3_1_55.A 0.20981f
C1278 a_2166_8498# sg13cmos5l_nor4_2_5.C 0.20159f
C1279 sg13cmos5l_buf_1_4.X a_24614_3582# 0.13055f
C1280 a_800_1718# VPWR 0.06778f
C1281 sg13cmos5l_xnor2_1_9.A sg13cmos5l_dfrbpq_1_58.RESET_B 0.01012f
C1282 a_5162_2540# VPWR 0.01782f
C1283 a_1870_7947# sg13cmos5l_nor3_1_2.B 0.2107f
C1284 sg13cmos5l_nor4_2_5.C en[4] 0.03073f
C1285 sg13cmos5l_dfrbpq_1_53.CLK sg13cmos5l_dlygate4sd3_1_11.A 0.2228f
C1286 sg13cmos5l_buf_1_5.A sg13cmos5l_dfrbpq_1_56.D 0.12204f
C1287 sg13cmos5l_nor3_1_2.Y sg13cmos5l_nor4_2_5.Y 0.24252f
C1288 a_6972_3858# sg13cmos5l_dfrbpq_1_12.D 0.01003f
C1289 a_27990_2450# VPWR 0.25365f
C1290 sg13cmos5l_buf_1_2.A a_17100_2572# 0.02348f
C1291 sg13cmos5l_dlygate4sd3_1_51.A sg13cmos5l_dfrbpq_1_5.Q 0.01908f
C1292 sg13cmos5l_buf_8_10.A a_10022_6918# 0.01222f
C1293 sg13cmos5l_dfrbpq_1_11.CLK a_13574_2382# 0.03733f
C1294 sg13cmos5l_buf_8_4.A a_9258_7680# 0.06247f
C1295 sg13cmos5l_buf_1_1.X sg13cmos5l_and2_1_0.X 0.0503f
C1296 sg13cmos5l_buf_1_4.X a_10022_870# 0.01216f
C1297 a_15488_4943# a_15607_4620# 0.13494f
C1298 sg13cmos5l_buf_1_0.A a_6167_1679# 0.02157f
C1299 sg13cmos5l_dfrbpq_1_21.CLK a_6604_3894# 0.01522f
C1300 sg13cmos5l_dfrbpq_1_55.RESET_B a_13834_2605# 0.34092f
C1301 a_24939_2504# a_25936_2602# 0.06746f
C1302 a_23958_3168# a_23846_3144# 0.67711f
C1303 sg13cmos5l_dlygate4sd3_1_53.A sg13cmos5l_dfrbpq_1_23.D 0.04092f
C1304 sg13cmos5l_dfrbpq_1_56.CLK sg13cmos5l_dfrbpq_1_53.RESET_B 0.03214f
C1305 sg13cmos5l_xnor2_1_4.A sg13cmos5l_buf_8_11.A 0.02068f
C1306 a_9446_4656# VPWR 0.24278f
C1307 a_26283_8552# a_27280_8650# 0.06746f
C1308 sg13cmos5l_nor4_2_5.C a_6862_8430# 0.02035f
C1309 sg13cmos5l_dfrbpq_1_21.RESET_B sg13cmos5l_nor3_1_2.C 0.28504f
C1310 sg13cmos5l_xnor2_1_4.Y a_28570_4620# 0.05545f
C1311 a_5223_7767# a_6071_7727# 0.11742f
C1312 sg13cmos5l_dfrbpq_1_23.D a_1248_4695# 0.12691f
C1313 a_5375_7651# a_6165_7727# 0.02241f
C1314 a_11824_7138# VPWR 0.1875f
C1315 a_7232_1919# a_7564_2070# 0.1396f
C1316 a_5319_1719# a_6122_1912# 0.15089f
C1317 sg13cmos5l_xnor2_1_10.Y a_24780_5596# 0.23004f
C1318 sg13cmos5l_dfrbpq_1_56.RESET_B a_17015_4703# 0.09183f
C1319 sg13cmos5l_buf_1_4.A sg13cmos5l_dfrbpq_1_11.CLK 0.07869f
C1320 sg13cmos5l_xnor2_1_0.A a_1190_1632# 0.01019f
C1321 a_20871_7136# en[4] 0.01646f
C1322 sg13cmos5l_dfrbpq_1_32.CLK a_4876_8118# 0.03685f
C1323 a_4876_8118# a_5134_8118# 0.01017f
C1324 a_4663_7644# a_5223_7767# 0.3087f
C1325 sg13cmos5l_nor3_1_2.B a_6071_7727# 0.31808f
C1326 a_10725_8409# sg13cmos5l_dfrbpq_1_57.CLK 0.35854f
C1327 a_4293_3155# VPWR 0.24108f
C1328 sg13cmos5l_dfrbpq_1_46.CLK sg13cmos5l_dlygate4sd3_1_51.X 0.03351f
C1329 sg13cmos5l_xnor2_1_8.Y a_10022_8430# 0.29044f
C1330 a_10725_8409# a_10943_7651# 0.03649f
C1331 sg13cmos5l_dfrbpq_1_57.CLK a_10791_7767# 0.05039f
C1332 a_3876_4212# a_5135_3971# 0.01741f
C1333 sg13cmos5l_dfrbpq_1_21.RESET_B a_3876_4212# 0.49156f
C1334 a_13783_1596# a_14254_2070# 0.32273f
C1335 a_10791_2600# VPWR 0.28202f
C1336 a_10791_7767# a_10943_7651# 0.66105f
C1337 sg13cmos5l_buf_8_3.A a_13574_2382# 0.03232f
C1338 sg13cmos5l_nor4_2_7.D a_25094_8118# 0.3091f
C1339 sg13cmos5l_dlygate4sd3_1_19.A sg13cmos5l_dlygate4sd3_1_21.X 0.0124f
C1340 a_7103_4164# sg13cmos5l_xnor2_1_6.B 0.01984f
C1341 sg13cmos5l_nor4_2_4.D sg13cmos5l_buf_1_2.A 0.0359f
C1342 sg13cmos5l_dlygate4sd3_1_22.X a_8881_2459# 0.01246f
C1343 sg13cmos5l_dfrbpq_1_2.D a_17510_3894# 0.03142f
C1344 sg13cmos5l_dlygate4sd3_1_15.A a_24614_3582# 0.02109f
C1345 a_9558_3168# a_9446_3144# 0.67711f
C1346 sg13cmos5l_dlygate4sd3_1_57.A sg13cmos5l_nor4_2_4.D 0.01763f
C1347 sg13cmos5l_nor4_2_4.D sg13cmos5l_dfrbpq_1_52.Q 0.20552f
C1348 sg13cmos5l_dfrbpq_1_21.RESET_B a_7792_7138# 0.04819f
C1349 sg13cmos5l_buf_8_10.A a_11824_7138# 0.01233f
C1350 sg13cmos5l_buf_8_2.X sg13cmos5l_dlygate4sd3_1_13.A 0.01535f
C1351 sg13cmos5l_dlygate4sd3_1_55.X sg13cmos5l_nor4_2_7.B 0.89746f
C1352 a_21023_7188# a_20871_7136# 0.6663f
C1353 a_15607_4620# a_16167_4743# 0.3087f
C1354 a_15820_5094# a_16078_5094# 0.01017f
C1355 a_26416_3386# a_26826_3144# 0.1396f
C1356 a_23958_4680# a_24526_4923# 0.03281f
C1357 a_20192_7093# VPWR 0.45334f
C1358 a_1233_5728# VPWR 0.0107f
C1359 sg13cmos5l_xnor2_1_2.A a_13773_6964# 0.01334f
C1360 sg13cmos5l_nand3_1_1.Y a_15850_3862# 0.1683f
C1361 a_11733_4703# VPWR 0.09856f
C1362 sg13cmos5l_buf_1_4.A sg13cmos5l_buf_8_3.A 0.02449f
C1363 a_13974_4680# sg13cmos5l_dfrbpq_1_17.D 0.01001f
C1364 a_2632_7766# a_2632_7050# 0.01275f
C1365 sg13cmos5l_dfrbpq_1_23.Q a_5703_5624# 0.04234f
C1366 sg13cmos5l_dfrbpq_1_21.CLK a_5663_4627# 0.41232f
C1367 sg13cmos5l_dlygate4sd3_1_39.A a_27418_6132# 0.52058f
C1368 a_3590_3894# VPWR 0.93369f
C1369 sg13cmos5l_dfrbpq_1_42.Q sg13cmos5l_buf_1_0.X 0.06728f
C1370 sg13cmos5l_buf_1_0.A a_21857_1898# 0.01037f
C1371 sg13cmos5l_nand3_1_1.Y a_10444_5094# 0.01142f
C1372 sg13cmos5l_xnor2_1_0.Y sg13cmos5l_dfrbpq_1_11.Q 0.11229f
C1373 sg13cmos5l_dfrbpq_1_53.RESET_B a_15108_7684# 0.03834f
C1374 a_5244_8041# a_6071_7727# 0.50066f
C1375 sg13cmos5l_dfrbpq_1_55.RESET_B VPWR 7.66708f
C1376 sg13cmos5l_xnor2_1_2.B sg13cmos5l_dfrbpq_1_55.D 0.30989f
C1377 sg13cmos5l_dfrbpq_1_56.Q sg13cmos5l_dfrbpq_1_55.Q 0.20459f
C1378 sg13cmos5l_buf_1_0.A sg13cmos5l_nor4_2_0.B 0.01673f
C1379 sg13cmos5l_dfrbpq_1_21.RESET_B sg13cmos5l_xor2_1_1.B 0.05996f
C1380 sg13cmos5l_xnor2_1_3.B sg13cmos5l_dfrbpq_1_2.CLK 0.35653f
C1381 sg13cmos5l_buf_1_0.X a_20311_7644# 0.27081f
C1382 a_4663_7644# a_5244_8041# 0.01741f
C1383 sg13cmos5l_dlygate4sd3_1_53.A sg13cmos5l_nand3_1_1.Y 0.02476f
C1384 a_26229_1679# a_26135_1679# 0.87117f
C1385 sg13cmos5l_dfrbpq_1_13.RESET_B a_3590_3582# 0.02246f
C1386 sg13cmos5l_and2_1_1.X sg13cmos5l_xnor2_1_4.B 0.051f
C1387 sg13cmos5l_and2_1_3.A a_6180_6172# 0.02185f
C1388 sg13cmos5l_dlygate4sd3_1_22.A VPWR 0.60367f
C1389 sg13cmos5l_xnor2_1_4.B sg13cmos5l_dfrbpq_1_7.Q 2.00434f
C1390 sg13cmos5l_dlygate4sd3_1_22.X a_9176_3185# 0.0411f
C1391 sg13cmos5l_buf_8_3.A sg13cmos5l_dlygate4sd3_1_21.X 0.01003f
C1392 sg13cmos5l_dlygate4sd3_1_18.X sg13cmos5l_dfrbpq_1_22.Q 0.08637f
C1393 a_23576_3898# a_23846_3898# 0.33585f
C1394 sg13cmos5l_dlygate4sd3_1_6.A sg13cmos5l_dfrbpq_1_38.Q 0.04031f
C1395 a_2266_1596# sg13cmos5l_dlygate4sd3_1_20.A 0.5049f
C1396 a_11594_7960# a_11639_7727# 0.36169f
C1397 a_18874_8398# en[2] 0.01113f
C1398 sg13cmos5l_nand3_1_2.A sg13cmos5l_dfrbpq_1_0.CLK 0.41475f
C1399 a_27329_1898# VPWR 0.24535f
C1400 sg13cmos5l_xnor2_1_4.A a_28524_3410# 0.12271f
C1401 sg13cmos5l_dfrbpq_1_53.Q sg13cmos5l_dfrbpq_1_7.Q 0.1053f
C1402 sg13cmos5l_xnor2_1_6.Y sg13cmos5l_dfrbpq_1_11.Q 0.01838f
C1403 a_1870_2571# a_1985_2572# 0.67711f
C1404 a_1480_2514# a_1664_2514# 0.11523f
C1405 sg13cmos5l_nor4_2_9.Y a_4088_5410# 0.056f
C1406 sg13cmos5l_buf_1_0.A a_10827_1643# 0.01627f
C1407 sg13cmos5l_dfrbpq_1_56.RESET_B a_16535_8821# 0.10366f
C1408 a_16167_4743# a_16319_4627# 0.66105f
C1409 sg13cmos5l_buf_1_0.X a_26229_1679# 0.01217f
C1410 a_24922_4620# a_24641_4922# 0.33585f
C1411 sg13cmos5l_buf_1_4.X sg13cmos5l_xnor2_1_0.Y 0.181f
C1412 sg13cmos5l_dfrbpq_1_57.RESET_B sg13cmos5l_xnor2_1_5.Y 0.08042f
C1413 sg13cmos5l_dfrbpq_1_29.Q a_16629_8588# 0.0189f
C1414 a_14938_4620# VPWR 0.33594f
C1415 a_14926_1059# VPWR 0.21298f
C1416 a_7911_1719# a_8063_1603# 0.66105f
C1417 sg13cmos5l_dlygate4sd3_1_4.X a_28570_8398# 0.0276f
C1418 a_18972_1993# a_18951_1719# 0.38902f
C1419 a_9166_4083# VPWR 0.21528f
C1420 a_7046_8118# a_7332_7684# 0.50066f
C1421 sg13cmos5l_dlygate4sd3_1_6.A sg13cmos5l_dfrbpq_1_0.D 0.05294f
C1422 a_1784_874# sg13cmos5l_dlygate4sd3_1_22.A 0.51589f
C1423 a_13834_3112# VPWR 0.09533f
C1424 a_18086_2382# VPWR 1.00949f
C1425 sg13cmos5l_nor4_2_5.C VPWR 0.7076f
C1426 sg13cmos5l_dfrbpq_1_53.RESET_B a_15396_8105# 0.01062f
C1427 sg13cmos5l_dlygate4sd3_1_19.X sg13cmos5l_nand3_1_3.Y 0.01485f
C1428 sg13cmos5l_xnor2_1_6.B sg13cmos5l_dlygate4sd3_1_21.A 0.32848f
C1429 sg13cmos5l_dlygate4sd3_1_6.X sg13cmos5l_dfrbpq_1_0.D 0.02466f
C1430 sg13cmos5l_xor2_1_1.B a_8776_4026# 0.01123f
C1431 a_9166_4083# a_8960_4026# 0.03208f
C1432 a_17274_2680# VPWR 0.01234f
C1433 a_5724_5370# a_6506_5564# 0.4806f
C1434 a_25094_8118# a_25380_7684# 0.50066f
C1435 sg13cmos5l_dfrbpq_1_13.RESET_B a_9176_3185# 0.01214f
C1436 sg13cmos5l_dfrbpq_1_13.CLK a_7932_1993# 0.09943f
C1437 a_3304_7766# a_3488_7766# 0.11523f
C1438 sg13cmos5l_dfrbpq_1_2.D a_18387_4656# 0.01298f
C1439 sg13cmos5l_buf_1_0.X a_20871_7767# 0.55805f
C1440 a_3878_7680# sg13cmos5l_nor4_2_5.D 0.01043f
C1441 sg13cmos5l_dlygate4sd3_1_31.X sg13cmos5l_nor4_2_5.D 0.01367f
C1442 sg13cmos5l_nor3_1_1.A sg13cmos5l_dfrbpq_1_55.RESET_B 0.24275f
C1443 sg13cmos5l_nor3_1_0.A sg13cmos5l_nor3_1_1.Y 0.01221f
C1444 sg13cmos5l_buf_8_3.A a_11594_3424# 0.0111f
C1445 a_25707_4016# a_26704_4114# 0.06746f
C1446 sg13cmos5l_dfrbpq_1_22.D a_11733_3191# 0.02194f
C1447 sg13cmos5l_dfrbpq_1_53.RESET_B a_25770_7216# 0.05897f
C1448 sg13cmos5l_dfrbpq_1_21.RESET_B a_8106_6168# 0.01868f
C1449 sg13cmos5l_nor4_2_4.D a_16068_7236# 0.0292f
C1450 sg13cmos5l_dfrbpq_1_53.Q a_28652_7644# 0.04255f
C1451 sg13cmos5l_dfrbpq_1_56.CLK sg13cmos5l_xnor2_1_5.Y 0.50483f
C1452 sg13cmos5l_and2_1_3.A a_6699_6179# 0.02099f
C1453 a_28174_5595# a_28289_5596# 0.67711f
C1454 sg13cmos5l_dlygate4sd3_1_35.A a_5135_8507# 0.01829f
C1455 sg13cmos5l_dfrbpq_1_55.RESET_B a_15041_1060# 0.01544f
C1456 sg13cmos5l_dlygate4sd3_1_47.A a_25764_8748# 0.01854f
C1457 sg13cmos5l_dlygate4sd3_1_17.A a_27790_7947# 0.01665f
C1458 sg13cmos5l_nand3_1_3.Y a_2165_3898# 0.01069f
C1459 a_1302_1656# a_1190_1632# 0.67711f
C1460 sg13cmos5l_dfrbpq_1_13.Q sg13cmos5l_dfrbpq_1_13.CLK 0.01124f
C1461 a_3799_2346# a_4270_2382# 0.32273f
C1462 sg13cmos5l_nor3_1_0.C a_17796_4212# 0.02406f
C1463 a_5703_5624# VPWR 0.20764f
C1464 sg13cmos5l_dfrbpq_1_56.RESET_B sg13cmos5l_xnor2_1_2.B 0.75822f
C1465 a_10725_5385# a_10943_4627# 0.03649f
C1466 a_6972_834# a_7754_1028# 0.4806f
C1467 sg13cmos5l_xnor2_1_2.B a_18380_7644# 0.04718f
C1468 a_14720_6254# VPWR 0.07495f
C1469 a_13288_5538# a_13472_5538# 0.11523f
C1470 a_20892_6882# a_20782_6918# 0.4858f
C1471 a_21719_7309# a_21674_7076# 0.36169f
C1472 sg13cmos5l_buf_1_0.A sg13cmos5l_dlygate4sd3_1_35.A 0.06052f
C1473 a_1870_6435# a_1985_6434# 0.67711f
C1474 a_10444_8118# a_10702_8118# 0.01017f
C1475 a_10231_7644# a_10791_7767# 0.3087f
C1476 a_10282_8653# VPWR 0.09391f
C1477 a_23872_5704# sg13cmos5l_nand3_1_2.B 0.02429f
C1478 sg13cmos5l_dlygate4sd3_1_1.A a_27878_2386# 0.02214f
C1479 sg13cmos5l_dlygate4sd3_1_47.A sg13cmos5l_buf_1_4.A 0.06248f
C1480 a_20871_7136# VPWR 0.20733f
C1481 sg13cmos5l_nor4_2_5.C a_5345_7108# 0.01896f
C1482 sg13cmos5l_buf_8_11.A a_27695_6995# 0.0461f
C1483 a_13916_4192# VPWR 0.25016f
C1484 sg13cmos5l_buf_1_4.X sg13cmos5l_xnor2_1_1.Y 0.20872f
C1485 a_1265_5460# sg13cmos5l_xnor2_1_13.A 0.25614f
C1486 a_7332_7684# a_7851_7691# 0.38871f
C1487 a_7749_7691# a_7620_8105# 0.01562f
C1488 sg13cmos5l_buf_1_4.X sg13cmos5l_xnor2_1_2.Y 0.15545f
C1489 a_17702_3144# VPWR 0.25341f
C1490 sg13cmos5l_dfrbpq_1_13.RESET_B a_17036_1596# 0.29665f
C1491 a_20362_8653# a_20102_8430# 0.87117f
C1492 sg13cmos5l_dfrbpq_1_53.RESET_B a_17633_7946# 0.01309f
C1493 sg13cmos5l_dlygate4sd3_1_6.X a_20907_5528# 0.02543f
C1494 sg13cmos5l_dlygate4sd3_1_22.A a_2166_938# 0.01492f
C1495 sg13cmos5l_nand3_1_1.Y a_11639_4703# 0.01721f
C1496 sg13cmos5l_buf_1_11.A sg13cmos5l_dfrbpq_1_58.RESET_B 0.01628f
C1497 sg13cmos5l_dfrbpq_1_22.D sg13cmos5l_nand3_1_3.B 0.22816f
C1498 a_5990_6918# a_6276_7236# 0.50066f
C1499 a_14926_1059# a_15041_1060# 0.67711f
C1500 sg13cmos5l_nor3_1_4.C a_15607_4620# 0.02447f
C1501 a_27994_3862# a_28376_3898# 0.09023f
C1502 a_25797_7691# a_25668_8105# 0.01562f
C1503 a_25380_7684# a_25899_7691# 0.38871f
C1504 sg13cmos5l_nor3_1_4.C sg13cmos5l_nor3_1_4.Y 0.2764f
C1505 a_5230_7107# sg13cmos5l_dfrbpq_1_58.Q 0.03066f
C1506 a_16389_6179# a_17137_6529# 0.01058f
C1507 sg13cmos5l_nand3_1_2.Y osc 0.01436f
C1508 a_20666_2680# a_20972_2680# 0.42343f
C1509 a_16491_6179# a_17488_6410# 0.07014f
C1510 a_15032_5410# VPWR 0.33602f
C1511 a_10725_6897# a_10943_6139# 0.03649f
C1512 sg13cmos5l_dfrbpq_1_21.RESET_B a_4164_8443# 0.0135f
C1513 sg13cmos5l_nand3_1_3.Y a_7799_4285# 0.0119f
C1514 a_15839_8700# VPWR 0.23735f
C1515 sg13cmos5l_and2_1_3.A sg13cmos5l_dlygate4sd3_1_58.A 0.01928f
C1516 sg13cmos5l_xnor2_1_5.A osc 0.01651f
C1517 sg13cmos5l_nand3_1_2.A sg13cmos5l_dfrbpq_1_53.RESET_B 0.03785f
C1518 a_25052_8728# sg13cmos5l_xnor2_1_4.A 0.11841f
C1519 a_7430_2382# a_8235_2504# 0.11742f
C1520 a_7716_2700# a_8133_2361# 0.48921f
C1521 a_16164_5724# a_16683_5528# 0.38902f
C1522 sg13cmos5l_dlygate4sd3_1_39.X sg13cmos5l_dfrbpq_1_53.RESET_B 0.09589f
C1523 sg13cmos5l_dfrbpq_1_46.D en[2] 0.0212f
C1524 sg13cmos5l_dlygate4sd3_1_6.X a_20388_6172# 0.01181f
C1525 sg13cmos5l_dlygate4sd3_1_4.X sg13cmos5l_dlygate4sd3_1_0.X 0.0436f
C1526 sg13cmos5l_nor3_1_2.C sg13cmos5l_dfrbpq_1_58.Q 0.14812f
C1527 sg13cmos5l_xnor2_1_0.Y a_11824_1874# 0.01061f
C1528 sg13cmos5l_dfrbpq_1_55.Q a_15119_2459# 0.02742f
C1529 sg13cmos5l_xor2_1_2.A a_13384_4026# 0.04263f
C1530 sg13cmos5l_nor3_1_1.Y a_13563_874# 0.09257f
C1531 a_25308_1993# a_26135_1679# 0.50066f
C1532 sg13cmos5l_dfrbpq_1_46.D sg13cmos5l_nor4_2_7.D 0.0167f
C1533 a_7594_5374# VPWR 1.14591f
C1534 sg13cmos5l_nand3_1_1.B a_13676_6168# 0.04872f
C1535 a_18372_2700# a_18891_2504# 0.38902f
C1536 sg13cmos5l_dfrbpq_1_11.CLK a_14254_2070# 0.01117f
C1537 a_4481_7108# VPWR 0.24394f
C1538 sg13cmos5l_buf_1_4.A a_26704_4114# 0.03135f
C1539 a_10812_8041# a_11733_7727# 0.43042f
C1540 a_25478_5094# a_26283_4667# 0.11742f
C1541 sg13cmos5l_dfrbpq_1_55.RESET_B a_13783_1596# 0.24555f
C1542 a_24416_1718# VPWR 0.07954f
C1543 a_23818_7141# VPWR 0.09655f
C1544 sg13cmos5l_buf_1_2.A osc 0.02895f
C1545 sg13cmos5l_nand3_1_2.B VPWR 0.19246f
C1546 a_26945_2572# a_27226_2350# 0.33585f
C1547 sg13cmos5l_dfrbpq_1_57.RESET_B sg13cmos5l_dlygate4sd3_1_28.A 0.0294f
C1548 sg13cmos5l_nor3_1_0.B sg13cmos5l_nand3_1_0.A 0.02352f
C1549 a_20907_8552# a_21904_8650# 0.06746f
C1550 a_20102_8430# a_20676_8443# 0.36169f
C1551 a_26830_2571# VPWR 0.24993f
C1552 sg13cmos5l_dfrbpq_1_17.D VPWR 1.42766f
C1553 a_23846_3144# VPWR 0.24444f
C1554 sg13cmos5l_dfrbpq_1_46.D sg13cmos5l_dlygate4sd3_1_47.A 0.03328f
C1555 a_8848_7922# a_8591_8041# 0.40419f
C1556 sg13cmos5l_dfrbpq_1_58.RESET_B a_6391_3858# 0.03341f
C1557 sg13cmos5l_xnor2_1_5.A sg13cmos5l_nor3_1_4.Y 1.96814f
C1558 a_14630_3898# a_14742_3962# 0.67711f
C1559 sg13cmos5l_and2_1_1.A a_19823_3505# 0.03719f
C1560 sg13cmos5l_buf_1_1.X sg13cmos5l_dfrbpq_1_0.D 0.17239f
C1561 sg13cmos5l_buf_1_4.A sg13cmos5l_xnor2_1_1.B 0.01798f
C1562 sg13cmos5l_nor3_1_0.C a_24922_4620# 0.0112f
C1563 a_1169_3502# a_1340_3144# 0.41432f
C1564 sg13cmos5l_dlygate4sd3_1_4.A a_28570_5374# 0.01472f
C1565 a_16683_5528# VPWR 0.20749f
C1566 a_26896_7922# a_26639_8041# 0.40419f
C1567 sg13cmos5l_and2_1_3.A a_9446_6168# 0.01055f
C1568 a_18278_3582# a_18564_3148# 0.50066f
C1569 sg13cmos5l_dfrbpq_1_21.CLK a_4293_3155# 0.38998f
C1570 a_14822_8118# a_15082_7648# 0.87117f
C1571 a_1480_6254# VPWR 0.14056f
C1572 a_7103_1140# VPWR 0.24122f
C1573 a_19256_8434# sg13cmos5l_dfrbpq_1_42.Q 0.53302f
C1574 a_10112_2557# a_10444_2382# 0.1396f
C1575 sg13cmos5l_dfrbpq_1_53.RESET_B a_26410_7141# 0.34027f
C1576 sg13cmos5l_dlygate4sd3_1_20.A a_6167_1679# 0.05868f
C1577 sg13cmos5l_dfrbpq_1_46.CLK en[2] 0.01317f
C1578 sg13cmos5l_dfrbpq_1_57.RESET_B a_16367_8041# 0.19897f
C1579 sg13cmos5l_nor4_2_5.C a_5802_8728# 0.0105f
C1580 sg13cmos5l_and2_1_1.X a_23744_7766# 0.0411f
C1581 sg13cmos5l_buf_1_2.A sg13cmos5l_nor3_1_4.Y 0.30651f
C1582 sg13cmos5l_dfrbpq_1_46.CLK sg13cmos5l_nor4_2_7.D 0.96874f
C1583 sg13cmos5l_dlygate4sd3_1_6.X a_21904_6410# 0.02197f
C1584 a_10022_870# a_10827_992# 0.11742f
C1585 a_10308_1188# a_10725_849# 0.48921f
C1586 sg13cmos5l_xnor2_1_4.A a_24363_7040# 0.01005f
C1587 sg13cmos5l_dfrbpq_1_57.Q VPWR 0.43389f
C1588 sg13cmos5l_dfrbpq_1_42.Q a_20192_7967# 0.13384f
C1589 a_15082_7648# VPWR 0.09572f
C1590 sg13cmos5l_dfrbpq_1_13.RESET_B a_5471_1603# 0.08441f
C1591 a_28570_5374# VPWR 0.33426f
C1592 a_25764_4660# a_26929_5017# 0.4858f
C1593 a_26052_5081# a_26283_4667# 0.15089f
C1594 a_23368_4026# VPWR 0.14951f
C1595 sg13cmos5l_nor4_2_9.D a_1436_5704# 0.02809f
C1596 sg13cmos5l_dfrbpq_1_53.CLK a_25899_7691# 0.06743f
C1597 a_23844_7236# VPWR 0.07259f
C1598 a_20192_7967# a_20311_7644# 0.13494f
C1599 a_1664_2514# VPWR 0.07543f
C1600 sg13cmos5l_xor2_1_2.B sg13cmos5l_xnor2_1_5.A 0.60092f
C1601 sg13cmos5l_nor3_1_0.C sg13cmos5l_xnor2_1_1.B 0.01002f
C1602 sg13cmos5l_nand3_1_1.B sg13cmos5l_xnor2_1_5.Y 0.03887f
C1603 sg13cmos5l_dfrbpq_1_57.RESET_B sg13cmos5l_nand3_1_1.Y 0.04024f
C1604 a_17796_4212# a_18315_4016# 0.38902f
C1605 sg13cmos5l_dlygate4sd3_1_4.A sg13cmos5l_nand3_1_2.C 0.20397f
C1606 a_6391_8394# a_6862_8430# 0.32273f
C1607 a_8848_7922# a_8497_8041# 0.01017f
C1608 a_19103_1603# VPWR 0.24562f
C1609 sg13cmos5l_xnor2_1_4.A sg13cmos5l_dfrbpq_1_0.D 0.01504f
C1610 sg13cmos5l_dlygate4sd3_1_11.X sg13cmos5l_dlygate4sd3_1_4.A 0.01582f
C1611 a_4395_3155# a_5392_3386# 0.07014f
C1612 sg13cmos5l_dlygate4sd3_1_9.X osc 0.01494f
C1613 a_7792_7138# a_8202_7216# 0.1396f
C1614 a_18972_1993# a_19799_1679# 0.50066f
C1615 sg13cmos5l_nand3_1_0.Y VPWR 0.94853f
C1616 sg13cmos5l_dlygate4sd3_1_4.A a_28376_3898# 0.0443f
C1617 sg13cmos5l_xnor2_1_1.B a_18444_1060# 0.22674f
C1618 sg13cmos5l_nor3_1_1.Y a_8881_2459# 0.01326f
C1619 a_26150_6918# a_26724_6931# 0.36169f
C1620 a_18843_5410# VPWR 1.13836f
C1621 sg13cmos5l_xnor2_1_4.B sg13cmos5l_dfrbpq_1_0.CLK 0.27489f
C1622 a_23846_3898# osc 0.0103f
C1623 a_27306_7680# sg13cmos5l_dlygate4sd3_1_39.A 0.13332f
C1624 a_13834_2605# a_14277_2361# 0.02241f
C1625 sg13cmos5l_dlygate4sd3_1_52.A a_8694_4680# 0.03617f
C1626 sg13cmos5l_nand3_1_1.B sg13cmos5l_dfrbpq_1_56.Q 0.96584f
C1627 sg13cmos5l_and2_1_3.A a_4088_5410# 0.04946f
C1628 a_6597_6179# VPWR 0.24214f
C1629 sg13cmos5l_and2_1_3.A a_11733_6215# 0.0123f
C1630 a_9176_5410# a_9446_5410# 0.33585f
C1631 a_25764_8748# sg13cmos5l_dfrbpq_1_53.CLK 0.08664f
C1632 a_26181_8409# a_26283_8552# 0.66105f
C1633 sg13cmos5l_buf_1_4.A a_10282_1093# 0.01586f
C1634 a_15302_5410# VPWR 0.24482f
C1635 sg13cmos5l_dfrbpq_1_21.RESET_B a_6951_8648# 0.55611f
C1636 a_28936_5538# a_29120_5538# 0.11523f
C1637 sg13cmos5l_nor4_2_5.C sg13cmos5l_dlygate4sd3_1_34.A 0.10238f
C1638 a_4972_2070# a_5319_1719# 0.06746f
C1639 a_5340_1993# a_5230_2070# 0.4858f
C1640 sg13cmos5l_nand3_1_2.C VPWR 0.58316f
C1641 sg13cmos5l_dlygate4sd3_1_9.X a_27023_5483# 0.02045f
C1642 sg13cmos5l_dfrbpq_1_56.CLK sg13cmos5l_nand3_1_1.Y 0.06639f
C1643 sg13cmos5l_dlygate4sd3_1_11.X VPWR 0.55506f
C1644 a_6154_6136# a_6597_6179# 0.02241f
C1645 a_24881_8484# sg13cmos5l_xnor2_1_4.A 0.25657f
C1646 sg13cmos5l_xnor2_1_5.Y a_10725_5385# 0.01021f
C1647 a_6250_7141# VPWR 0.09404f
C1648 a_28376_3898# VPWR 0.32952f
C1649 a_27023_5017# a_26929_5017# 0.32273f
C1650 sg13cmos5l_dfrbpq_1_53.CLK sg13cmos5l_buf_1_4.A 0.79835f
C1651 sg13cmos5l_buf_1_4.X a_25419_3155# 0.55145f
C1652 sg13cmos5l_dfrbpq_1_53.CLK sg13cmos5l_dlygate4sd3_1_39.A 0.54335f
C1653 a_25360_7138# VPWR 0.18753f
C1654 sg13cmos5l_xnor2_1_4.A sg13cmos5l_nand3_1_2.Y 0.01405f
C1655 a_8133_2361# VPWR 0.29093f
C1656 a_20311_7644# a_20782_8118# 0.32273f
C1657 a_5135_3971# a_5135_3505# 0.03431f
C1658 a_13472_6254# VPWR 0.07375f
C1659 sg13cmos5l_dfrbpq_1_21.RESET_B a_5135_3505# 0.22802f
C1660 sg13cmos5l_dfrbpq_1_57.D a_13592_4697# 0.01835f
C1661 a_23576_1673# VPWR 0.39781f
C1662 sg13cmos5l_xnor2_1_4.Y a_25764_5724# 0.01616f
C1663 sg13cmos5l_dfrbpq_1_57.RESET_B a_10812_6529# 0.52329f
C1664 sg13cmos5l_xnor2_1_3.B a_18391_1596# 0.02082f
C1665 a_9640_7680# sg13cmos5l_dlygate4sd3_1_38.A 0.14041f
C1666 sg13cmos5l_dfrbpq_1_37.D sg13cmos5l_nor4_2_7.B 0.02795f
C1667 sg13cmos5l_dlygate4sd3_1_22.X sg13cmos5l_dfrbpq_1_13.CLK 0.03174f
C1668 sg13cmos5l_nor3_1_4.A en[4] 0.01754f
C1669 sg13cmos5l_dfrbpq_1_58.Q sg13cmos5l_dfrbpq_1_58.D 0.25256f
C1670 a_3799_834# a_4270_870# 0.32273f
C1671 a_24614_3582# a_24900_3148# 0.50066f
C1672 sg13cmos5l_dfrbpq_1_11.CLK a_10791_2600# 0.04514f
C1673 a_20388_5724# VPWR 0.07214f
C1674 sg13cmos5l_nand3_1_1.A a_15032_5410# 0.06394f
C1675 sg13cmos5l_buf_1_2.A a_17488_6410# 0.03328f
C1676 sg13cmos5l_xnor2_1_2.A sg13cmos5l_nor3_1_1.C 0.66598f
C1677 a_7696_6410# VPWR 0.18816f
C1678 sg13cmos5l_buf_1_0.X sg13cmos5l_nor4_2_0.B 0.36482f
C1679 a_15108_7684# a_16367_8041# 0.01741f
C1680 sg13cmos5l_dfrbpq_1_21.RESET_B sg13cmos5l_buf_8_4.A 0.23215f
C1681 sg13cmos5l_dlygate4sd3_1_55.X en[4] 0.648f
C1682 a_23576_4697# a_23576_3898# 0.02287f
C1683 a_4166_6168# VPWR 0.24402f
C1684 sg13cmos5l_dfrbpq_1_58.RESET_B a_5164_5094# 0.17715f
C1685 sg13cmos5l_buf_1_0.A sg13cmos5l_nor3_1_2.C 0.0166f
C1686 sg13cmos5l_dfrbpq_1_35.Q sg13cmos5l_dfrbpq_1_53.RESET_B 0.02888f
C1687 sg13cmos5l_dfrbpq_1_56.CLK sg13cmos5l_dfrbpq_1_56.D 0.02334f
C1688 sg13cmos5l_dfrbpq_1_53.CLK sg13cmos5l_nor3_1_0.C 0.02173f
C1689 sg13cmos5l_xnor2_1_4.Y osc 0.02143f
C1690 sg13cmos5l_dfrbpq_1_2.CLK a_20362_4624# 0.01124f
C1691 sg13cmos5l_dfrbpq_1_13.RESET_B a_10282_1600# 0.35019f
C1692 a_6597_6179# a_6468_6593# 0.01562f
C1693 a_5036_6168# a_5334_6168# 0.31789f
C1694 a_6180_6172# a_6699_6179# 0.38871f
C1695 a_5392_3386# VPWR 0.18667f
C1696 a_24363_7040# a_24132_6931# 0.15089f
C1697 a_10308_5724# VPWR 0.07291f
C1698 a_23844_7236# a_25009_6995# 0.4858f
C1699 a_5143_5370# a_5724_5370# 0.01741f
C1700 sg13cmos5l_dfrbpq_1_21.CLK a_5703_5624# 0.01405f
C1701 a_14277_2361# VPWR 0.2837f
C1702 sg13cmos5l_dfrbpq_1_2.D sg13cmos5l_buf_1_4.X 0.26702f
C1703 a_19642_6132# VPWR 0.36043f
C1704 sg13cmos5l_buf_1_4.X a_25308_1993# 0.01373f
C1705 sg13cmos5l_dlygate4sd3_1_11.A osc 0.02006f
C1706 a_3590_3894# sg13cmos5l_dlygate4sd3_1_19.A 0.04265f
C1707 a_3876_4212# a_5041_3971# 0.4858f
C1708 a_4395_4016# a_4164_3907# 0.15089f
C1709 a_5392_4114# a_5802_4192# 0.1396f
C1710 a_21023_7651# a_21813_7727# 0.02241f
C1711 a_20871_7767# a_21719_7727# 0.11742f
C1712 sg13cmos5l_xnor2_1_2.Y a_16320_1671# 0.22707f
C1713 a_7232_1919# VPWR 0.45362f
C1714 sg13cmos5l_dlygate4sd3_1_22.X a_4359_1088# 0.01231f
C1715 a_21647_3971# a_22314_4192# 0.13494f
C1716 sg13cmos5l_buf_1_2.A a_17423_5483# 0.04161f
C1717 sg13cmos5l_dlygate4sd3_1_30.A sg13cmos5l_dfrbpq_1_58.D 0.21274f
C1718 a_14235_6922# en[4] 0.01043f
C1719 sg13cmos5l_buf_8_2.X a_19722_4192# 0.06198f
C1720 sg13cmos5l_dfrbpq_1_13.RESET_B sg13cmos5l_dfrbpq_1_13.CLK 0.47664f
C1721 a_24170_8728# VPWR 0.25248f
C1722 sg13cmos5l_dlygate4sd3_1_15.A a_26945_2572# 0.01189f
C1723 sg13cmos5l_nor3_1_0.B a_24614_3582# 0.03641f
C1724 sg13cmos5l_dfrbpq_1_55.RESET_B sg13cmos5l_dfrbpq_1_11.CLK 0.47644f
C1725 a_10444_3582# a_10791_3231# 0.06746f
C1726 a_10812_3505# a_10702_3582# 0.4858f
C1727 sg13cmos5l_dlygate4sd3_1_15.A a_25419_3155# 0.02462f
C1728 sg13cmos5l_xnor2_1_4.Y a_27023_5483# 0.01259f
C1729 sg13cmos5l_buf_8_2.X a_23958_3168# 0.01096f
C1730 a_7103_8700# a_6862_8430# 0.01058f
C1731 a_6951_8648# a_7754_8588# 0.15089f
C1732 sg13cmos5l_dlygate4sd3_1_17.A sg13cmos5l_buf_8_11.A 0.16258f
C1733 sg13cmos5l_xnor2_1_3.A a_18951_1719# 0.01263f
C1734 a_26346_2680# sg13cmos5l_dlygate4sd3_1_1.A 0.13182f
C1735 a_15786_2680# a_16270_2571# 0.03282f
C1736 sg13cmos5l_dfrbpq_1_53.RESET_B sg13cmos5l_xnor2_1_4.B 0.17938f
C1737 a_21904_5626# VPWR 0.18888f
C1738 a_9558_6192# VPWR 0.2131f
C1739 a_4951_4620# a_5164_5094# 0.40419f
C1740 a_6391_8394# VPWR 0.16769f
C1741 a_28186_7644# sg13cmos5l_buf_1_4.A 0.09881f
C1742 sg13cmos5l_dfrbpq_1_2.CLK a_18891_2504# 0.03371f
C1743 sg13cmos5l_dfrbpq_1_29.Q a_15839_8700# 0.02014f
C1744 sg13cmos5l_dfrbpq_1_55.Q sg13cmos5l_dfrbpq_1_12.Q 0.99963f
C1745 a_15627_7691# a_16624_7922# 0.07014f
C1746 sg13cmos5l_dfrbpq_1_56.RESET_B a_16389_6179# 0.07525f
C1747 sg13cmos5l_nor3_1_4.A a_15972_6172# 0.02177f
C1748 a_7932_1993# a_7911_1719# 0.38902f
C1749 a_18272_1919# a_18604_2070# 0.1396f
C1750 a_5802_4192# VPWR 0.45283f
C1751 a_8106_6168# a_8488_6254# 0.03295f
C1752 a_20362_5629# a_20388_5724# 0.43042f
C1753 sg13cmos5l_dfrbpq_1_23.Q sg13cmos5l_buf_8_5.A 0.02072f
C1754 sg13cmos5l_xnor2_1_1.B a_17472_1671# 0.41498f
C1755 sg13cmos5l_buf_8_0.X a_15820_5094# 0.01217f
C1756 sg13cmos5l_xnor2_1_4.A sg13cmos5l_dlygate4sd3_1_9.X 0.08007f
C1757 a_6951_4112# a_7799_4285# 0.11742f
C1758 a_25360_7138# a_25009_6995# 0.01017f
C1759 a_12234_5704# VPWR 0.46965f
C1760 sg13cmos5l_dlygate4sd3_1_51.X sg13cmos5l_nand3_1_2.B 0.12648f
C1761 sg13cmos5l_dlygate4sd3_1_50.A sg13cmos5l_dfrbpq_1_17.D 0.31846f
C1762 sg13cmos5l_dfrbpq_1_13.RESET_B a_4359_1088# 0.57655f
C1763 sg13cmos5l_dfrbpq_1_58.Q a_5024_5581# 0.01065f
C1764 sg13cmos5l_dfrbpq_1_13.CLK a_4759_1596# 0.02564f
C1765 a_18826_4620# sg13cmos5l_dfrbpq_1_2.CLK 1.09934f
C1766 sg13cmos5l_buf_8_3.A sg13cmos5l_dfrbpq_1_55.RESET_B 0.38133f
C1767 sg13cmos5l_dfrbpq_1_22.D a_10812_3505# 0.04376f
C1768 sg13cmos5l_buf_1_0.X sg13cmos5l_buf_8_11.A 0.07269f
C1769 sg13cmos5l_dfrbpq_1_58.D a_5334_6168# 0.11887f
C1770 sg13cmos5l_dfrbpq_1_56.CLK a_16587_7040# 0.02883f
C1771 sg13cmos5l_buf_1_0.A sg13cmos5l_xor2_1_1.B 0.01776f
C1772 sg13cmos5l_dlygate4sd3_1_6.X a_21647_5017# 0.04659f
C1773 sg13cmos5l_nor3_1_4.B en[4] 0.02327f
C1774 a_12234_8728# VPWR 0.46624f
C1775 sg13cmos5l_dfrbpq_1_55.RESET_B sg13cmos5l_dfrbpq_1_54.Q 0.0268f
C1776 sg13cmos5l_buf_1_0.A sg13cmos5l_dfrbpq_1_0.D 0.23548f
C1777 a_3896_6209# a_4166_6168# 0.33585f
C1778 sg13cmos5l_dfrbpq_1_56.RESET_B a_16581_5385# 0.08106f
C1779 sg13cmos5l_dlygate4sd3_1_55.X a_23872_5704# 0.02696f
C1780 a_4358_5410# VPWR 0.24361f
C1781 sg13cmos5l_dfrbpq_1_57.D sg13cmos5l_xnor2_1_5.Y 0.02478f
C1782 a_7103_1140# a_6972_834# 0.49014f
C1783 sg13cmos5l_nor4_2_0.C sg13cmos5l_nand3_1_0.B 0.15702f
C1784 sg13cmos5l_nand3_1_1.B sg13cmos5l_nand3_1_1.Y 0.21526f
C1785 sg13cmos5l_xnor2_1_4.A a_25131_6179# 0.04322f
C1786 a_4951_4620# a_5422_5094# 0.32273f
C1787 sg13cmos5l_dfrbpq_1_53.RESET_B sg13cmos5l_dlygate4sd3_1_33.A 0.02193f
C1788 sg13cmos5l_nand3_1_1.A a_15302_5410# 0.01521f
C1789 sg13cmos5l_dlygate4sd3_1_19.X sg13cmos5l_xnor2_1_13.A 0.03921f
C1790 sg13cmos5l_buf_1_4.A a_15756_1060# 0.01296f
C1791 a_22049_2572# VPWR 0.28978f
C1792 a_9281_4084# VPWR 0.244f
C1793 a_10282_5629# a_10308_5724# 0.43042f
C1794 sg13cmos5l_dlygate4sd3_1_28.A a_10112_6455# 0.14177f
C1795 sg13cmos5l_nor3_1_0.A sg13cmos5l_nand3_1_0.A 1.67418f
C1796 sg13cmos5l_dlygate4sd3_1_30.A a_5024_5581# 0.13188f
C1797 sg13cmos5l_dfrbpq_1_38.Q a_18497_6434# 0.02584f
C1798 sg13cmos5l_dfrbpq_1_46.D a_20102_8430# 0.04568f
C1799 a_20362_8653# sg13cmos5l_dlygate4sd3_1_6.X 0.01554f
C1800 a_14379_3155# VPWR 0.20867f
C1801 sg13cmos5l_nand3_1_2.C a_25188_4212# 0.03346f
C1802 sg13cmos5l_dfrbpq_1_13.RESET_B a_14343_1719# 0.02087f
C1803 a_11639_2773# a_11594_2540# 0.36169f
C1804 sg13cmos5l_dfrbpq_1_46.CLK a_21023_7651# 0.39717f
C1805 sg13cmos5l_dlygate4sd3_1_38.A en[1] 0.04643f
C1806 sg13cmos5l_xnor2_1_4.A a_28646_3898# 0.02541f
C1807 sg13cmos5l_dfrbpq_1_22.D a_14277_3155# 0.01586f
C1808 sg13cmos5l_buf_8_3.A a_13834_3112# 0.01824f
C1809 sg13cmos5l_dlygate4sd3_1_0.X a_27798_938# 0.19421f
C1810 a_10308_1636# VPWR 0.079f
C1811 sg13cmos5l_nor3_1_4.A VPWR 0.55935f
C1812 sg13cmos5l_xnor2_1_5.Y sg13cmos5l_buf_8_0.X 0.04934f
C1813 sg13cmos5l_dfrbpq_1_21.RESET_B a_5375_7651# 0.05753f
C1814 sg13cmos5l_dlygate4sd3_1_39.X a_26436_7236# 0.02058f
C1815 a_14148_3569# a_14379_3155# 0.15089f
C1816 sg13cmos5l_and2_1_3.A a_13773_6964# 0.12074f
C1817 sg13cmos5l_dfrbpq_1_56.RESET_B a_18572_5370# 0.28985f
C1818 sg13cmos5l_xnor2_1_0.Y a_10022_2070# 0.01078f
C1819 a_24608_1919# a_24416_1718# 0.03403f
C1820 sg13cmos5l_dfrbpq_1_56.D sg13cmos5l_nand3_1_1.B 0.18741f
C1821 sg13cmos5l_xnor2_1_4.A sg13cmos5l_xnor2_1_4.Y 0.02985f
C1822 sg13cmos5l_nand3_1_2.C a_25029_6179# 0.01667f
C1823 sg13cmos5l_buf_8_0.X sg13cmos5l_dfrbpq_1_56.Q 0.2394f
C1824 sg13cmos5l_buf_1_4.X sg13cmos5l_nor4_2_0.B 0.02028f
C1825 sg13cmos5l_dlygate4sd3_1_55.X VPWR 0.86417f
C1826 a_19428_1188# a_19947_992# 0.38902f
C1827 a_18444_1060# a_18479_874# 0.3658f
C1828 sg13cmos5l_buf_1_0.A sg13cmos5l_buf_1_2.A 0.02373f
C1829 sg13cmos5l_buf_8_5.A VPWR 0.68043f
C1830 a_11639_6215# VPWR 0.94493f
C1831 sg13cmos5l_nor3_1_4.B a_15972_6172# 0.01048f
C1832 a_13288_2514# a_13288_1718# 0.01095f
C1833 a_5532_5017# a_5663_4627# 0.48921f
C1834 sg13cmos5l_dfrbpq_1_57.CLK a_10943_4627# 0.35852f
C1835 sg13cmos5l_and2_1_1.A sg13cmos5l_nor4_2_1.A 0.49763f
C1836 a_20388_6172# a_20805_6179# 0.49014f
C1837 a_15333_4192# VPWR 0.01375f
C1838 a_7103_8700# VPWR 0.23603f
C1839 sg13cmos5l_nor3_1_4.A sg13cmos5l_buf_8_10.A 0.01881f
C1840 a_8759_1679# a_10022_2070# 0.01467f
C1841 a_10308_5724# a_11567_5483# 0.01741f
C1842 a_20388_8748# a_20907_8552# 0.38902f
C1843 a_17327_6995# VPWR 0.17323f
C1844 sg13cmos5l_dfrbpq_1_53.RESET_B sg13cmos5l_nor3_1_2.B 0.01241f
C1845 sg13cmos5l_dlygate4sd3_1_6.A a_19083_3155# 0.05143f
C1846 sg13cmos5l_dfrbpq_1_16.Q a_5802_4192# 0.01334f
C1847 a_20388_5724# a_21553_5483# 0.4858f
C1848 a_20907_5528# a_20676_5419# 0.15089f
C1849 sg13cmos5l_dfrbpq_1_22.D sg13cmos5l_dfrbpq_1_12.Q 0.03356f
C1850 sg13cmos5l_nand3_1_2.A en[3] 0.02077f
C1851 sg13cmos5l_dfrbpq_1_53.Q sg13cmos5l_dlygate4sd3_1_9.A 0.13161f
C1852 a_14235_6922# VPWR 1.14063f
C1853 sg13cmos5l_buf_8_9.A a_8488_6254# 0.04819f
C1854 a_8768_6427# sg13cmos5l_dlygate4sd3_1_28.A 0.06492f
C1855 sg13cmos5l_dlygate4sd3_1_39.X en[3] 0.0205f
C1856 sg13cmos5l_dlygate4sd3_1_40.A sg13cmos5l_dlygate4sd3_1_17.X 1.29163f
C1857 sg13cmos5l_nor3_1_1.A a_14379_3155# 0.01775f
C1858 a_26410_7141# a_26436_7236# 0.43042f
C1859 sg13cmos5l_dlygate4sd3_1_9.X a_26150_6918# 0.29959f
C1860 a_17132_3108# a_17432_3185# 0.0683f
C1861 sg13cmos5l_xnor2_1_6.A a_1664_2514# 0.01243f
C1862 sg13cmos5l_dfrbpq_1_57.D a_13888_7680# 0.01616f
C1863 a_13642_5374# VPWR 1.15521f
C1864 sg13cmos5l_dfrbpq_1_21.RESET_B a_7046_8118# 0.13586f
C1865 sg13cmos5l_dfrbpq_1_56.D sg13cmos5l_dfrbpq_1_39.Q 0.02795f
C1866 sg13cmos5l_dfrbpq_1_57.CLK sg13cmos5l_dfrbpq_1_53.RESET_B 0.03943f
C1867 a_8235_2504# a_9232_2602# 0.06746f
C1868 sg13cmos5l_nor4_2_0.C a_23872_1168# 0.05934f
C1869 sg13cmos5l_nor3_1_4.A sg13cmos5l_nor3_1_1.A 0.02607f
C1870 sg13cmos5l_nor4_2_5.C a_4293_8409# 0.01366f
C1871 sg13cmos5l_dfrbpq_1_21.RESET_B sg13cmos5l_dlygate4sd3_1_31.X 0.18605f
C1872 sg13cmos5l_dfrbpq_1_21.RESET_B a_3878_7680# 0.02232f
C1873 sg13cmos5l_dfrbpq_1_53.RESET_B a_10943_7651# 0.01569f
C1874 a_13784_8434# VPWR 0.36152f
C1875 a_20388_4660# VPWR 0.0721f
C1876 sg13cmos5l_dfrbpq_1_32.CLK en[4] 0.02844f
C1877 sg13cmos5l_buf_8_10.A a_17327_6995# 0.01623f
C1878 sg13cmos5l_nand3_1_2.C a_26538_6168# 0.01059f
C1879 sg13cmos5l_dlygate4sd3_1_51.X a_20388_5724# 0.01558f
C1880 sg13cmos5l_dfrbpq_1_16.Q a_4358_5410# 0.03004f
C1881 sg13cmos5l_buf_1_4.A a_22330_838# 0.01131f
C1882 sg13cmos5l_buf_8_10.A a_14235_6922# 1.10133f
C1883 a_19428_1188# a_20687_947# 0.01741f
C1884 a_20388_4212# VPWR 0.07262f
C1885 a_5511_4743# a_5663_4627# 0.66105f
C1886 a_1000_8468# en[4] 0.03447f
C1887 sg13cmos5l_dlygate4sd3_1_15.A sg13cmos5l_nor4_2_0.B 0.22531f
C1888 sg13cmos5l_dfrbpq_1_3.D a_23846_1632# 0.02058f
C1889 a_20388_6172# a_21647_6529# 0.01741f
C1890 a_7893_8588# VPWR 0.09376f
C1891 sg13cmos5l_dfrbpq_1_53.RESET_B a_5244_8041# 0.02895f
C1892 a_17518_7947# a_17633_7946# 0.67711f
C1893 a_10725_5385# a_11473_5483# 0.01058f
C1894 sg13cmos5l_nand3_1_0.B a_19428_1188# 0.03012f
C1895 a_11567_5483# a_12234_5704# 0.13494f
C1896 sg13cmos5l_dlygate4sd3_1_23.X a_3692_4656# 0.09923f
C1897 sg13cmos5l_dfrbpq_1_56.RESET_B a_16273_8041# 0.01822f
C1898 sg13cmos5l_nor3_1_4.Y a_15447_4192# 0.02966f
C1899 sg13cmos5l_buf_1_0.X a_20892_6882# 0.56028f
C1900 sg13cmos5l_nand3_1_2.A a_24612_6172# 0.05115f
C1901 a_10231_6132# a_10444_6606# 0.40419f
C1902 a_9176_6209# a_9446_6168# 0.33585f
C1903 a_21904_5626# a_21553_5483# 0.01017f
C1904 a_18272_1919# VPWR 0.45304f
C1905 a_19642_6132# sg13cmos5l_dlygate4sd3_1_51.X 0.01104f
C1906 sg13cmos5l_dfrbpq_1_58.D a_5143_5370# 0.05406f
C1907 sg13cmos5l_dfrbpq_1_17.D sg13cmos5l_buf_8_3.A 0.02276f
C1908 sg13cmos5l_nor3_1_4.B VPWR 0.5431f
C1909 sg13cmos5l_dfrbpq_1_18.D sg13cmos5l_dfrbpq_1_13.CLK 5.65328f
C1910 a_18213_3873# sg13cmos5l_nor4_2_1.D 0.01338f
C1911 a_3850_3112# a_4293_3155# 0.02241f
C1912 sg13cmos5l_dfrbpq_1_21.RESET_B a_4012_2382# 0.17651f
C1913 sg13cmos5l_dlygate4sd3_1_4.A a_27992_1673# 0.01453f
C1914 a_14495_1603# VPWR 0.24491f
C1915 sg13cmos5l_dlygate4sd3_1_21.X a_7430_2382# 0.05051f
C1916 sg13cmos5l_xnor2_1_6.B a_7716_2700# 0.05386f
C1917 a_18981_3155# a_19083_3155# 0.6663f
C1918 sg13cmos5l_nor3_1_1.Y sg13cmos5l_dfrbpq_1_13.CLK 0.1855f
C1919 sg13cmos5l_nor4_2_1.D sg13cmos5l_dlygate4sd3_1_13.A 0.11818f
C1920 a_20805_3873# osc 0.01076f
C1921 sg13cmos5l_dfrbpq_1_55.Q sg13cmos5l_xnor2_1_0.Y 0.35463f
C1922 sg13cmos5l_dlygate4sd3_1_21.X a_1870_1899# 0.01391f
C1923 sg13cmos5l_nor4_2_9.Y a_3692_4656# 0.04919f
C1924 sg13cmos5l_buf_1_4.X a_26351_947# 0.19875f
C1925 sg13cmos5l_dfrbpq_1_21.RESET_B a_7851_7691# 0.60963f
C1926 sg13cmos5l_xor2_1_2.A sg13cmos5l_xor2_1_2.B 0.37667f
C1927 a_10943_2652# a_10791_2600# 0.6663f
C1928 a_11567_8507# a_12234_8728# 0.13494f
C1929 sg13cmos5l_buf_1_4.A a_7799_1261# 0.01452f
C1930 a_28570_8398# VPWR 0.33229f
C1931 sg13cmos5l_buf_1_2.A a_17510_3894# 0.02071f
C1932 sg13cmos5l_dfrbpq_1_12.Q a_14148_2395# 0.01884f
C1933 a_20907_4667# VPWR 0.20733f
C1934 a_17729_8620# a_18010_8398# 0.33585f
C1935 sg13cmos5l_buf_8_11.A a_26896_7922# 0.01153f
C1936 a_24326_6606# a_24612_6172# 0.50066f
C1937 sg13cmos5l_dlygate4sd3_1_4.A a_27963_6538# 0.05211f
C1938 sg13cmos5l_dfrbpq_1_42.Q a_18922_7644# 0.20431f
C1939 a_10282_8653# a_10308_8748# 0.43042f
C1940 sg13cmos5l_dfrbpq_1_57.RESET_B a_10022_8430# 0.09404f
C1941 sg13cmos5l_dfrbpq_1_55.RESET_B a_15191_1679# 0.09207f
C1942 a_16535_8821# a_16490_8588# 0.36169f
C1943 a_27992_1673# VPWR 0.33413f
C1944 sg13cmos5l_buf_1_4.A a_24806_870# 0.01778f
C1945 sg13cmos5l_buf_8_10.A sg13cmos5l_nor3_1_4.B 0.24454f
C1946 a_25605_3873# VPWR 0.24232f
C1947 a_19947_992# a_19716_883# 0.15089f
C1948 a_19428_1188# a_20593_947# 0.4858f
C1949 sg13cmos5l_nor4_2_1.A a_21553_3971# 0.01271f
C1950 sg13cmos5l_buf_8_2.X VPWR 2.20452f
C1951 sg13cmos5l_dfrbpq_1_37.D a_26283_5528# 0.01571f
C1952 sg13cmos5l_buf_8_5.A sg13cmos5l_dfrbpq_1_16.Q 0.02245f
C1953 sg13cmos5l_dfrbpq_1_53.RESET_B a_7620_8105# 0.01133f
C1954 a_23958_1656# a_23846_1632# 0.67711f
C1955 a_5663_4627# a_6453_4703# 0.02241f
C1956 a_10827_1643# a_11824_1874# 0.07014f
C1957 sg13cmos5l_nor4_2_0.C sg13cmos5l_dfrbpq_1_3.D 0.17806f
C1958 sg13cmos5l_dfrbpq_1_57.D sg13cmos5l_nand3_1_1.Y 2.19352f
C1959 a_4511_2652# VPWR 0.28653f
C1960 sg13cmos5l_buf_8_11.A a_20192_7967# 0.05141f
C1961 a_21904_6410# a_21647_6529# 0.40419f
C1962 sg13cmos5l_dfrbpq_1_53.RESET_B a_25668_8105# 0.02532f
C1963 sg13cmos5l_buf_1_1.X a_25936_2602# 0.18481f
C1964 a_18315_4016# a_19312_4114# 0.06746f
C1965 a_17510_3894# a_18084_3907# 0.36169f
C1966 a_12234_5704# sg13cmos5l_dlygate4sd3_1_50.A 0.13324f
C1967 sg13cmos5l_dfrbpq_1_12.D sg13cmos5l_nor3_1_1.C 0.25085f
C1968 sg13cmos5l_buf_1_1.X a_19083_3155# 0.57512f
C1969 a_10444_6606# a_10791_6255# 0.06746f
C1970 a_10812_6529# a_10702_6606# 0.4858f
C1971 sg13cmos5l_dfrbpq_1_21.CLK a_5802_4192# 0.01727f
C1972 sg13cmos5l_nor4_2_1.A a_21270_2680# 0.11685f
C1973 a_27963_6538# VPWR 1.15229f
C1974 a_3304_1002# a_3488_1002# 0.11523f
C1975 a_3799_834# a_4012_870# 0.40419f
C1976 a_9446_3144# a_8975_2459# 0.01425f
C1977 sg13cmos5l_dfrbpq_1_55.RESET_B a_10943_2652# 0.05574f
C1978 a_25707_4016# osc 0.02175f
C1979 sg13cmos5l_nand3_1_1.A sg13cmos5l_nor3_1_4.A 0.65092f
C1980 a_2816_7766# VPWR 0.07233f
C1981 a_12234_8728# sg13cmos5l_dfrbpq_1_29.Q 0.14178f
C1982 sg13cmos5l_dfrbpq_1_37.D en[4] 0.03617f
C1983 sg13cmos5l_nor4_2_7.D a_23818_7141# 0.02131f
C1984 a_25738_8653# a_25764_8748# 0.43042f
C1985 sg13cmos5l_dlygate4sd3_1_4.A sg13cmos5l_dlygate4sd3_1_0.X 0.97232f
C1986 sg13cmos5l_dfrbpq_1_53.RESET_B a_25478_8430# 0.09499f
C1987 a_20311_7644# a_20311_6882# 0.02404f
C1988 sg13cmos5l_nor4_2_7.D sg13cmos5l_nand3_1_2.B 0.29328f
C1989 a_11567_947# a_12234_1168# 0.13494f
C1990 sg13cmos5l_dlygate4sd3_1_19.X a_3876_4212# 0.02268f
C1991 sg13cmos5l_buf_8_4.A a_6250_3108# 0.54081f
C1992 sg13cmos5l_dlygate4sd3_1_10.A VPWR 0.7526f
C1993 sg13cmos5l_nand3_1_1.Y sg13cmos5l_buf_8_0.X 1.14518f
C1994 a_24612_6172# a_24900_6593# 0.4806f
C1995 sg13cmos5l_dfrbpq_1_13.RESET_B sg13cmos5l_dlygate4sd3_1_23.X 0.74416f
C1996 sg13cmos5l_dfrbpq_1_13.RESET_B a_7911_1719# 0.57557f
C1997 a_15008_8605# VPWR 0.45056f
C1998 sg13cmos5l_nor4_2_5.C sg13cmos5l_nor4_2_5.D 0.1139f
C1999 sg13cmos5l_nor4_2_9.D a_4470_5474# 0.01153f
C2000 a_2166_3168# VPWR 0.22811f
C2001 sg13cmos5l_nand3_1_2.C a_27418_6132# 0.01259f
C2002 sg13cmos5l_xnor2_1_2.B sg13cmos5l_nor3_1_1.C 0.03318f
C2003 a_5024_5581# a_5143_5370# 0.13494f
C2004 a_17614_8619# a_17729_8620# 0.67711f
C2005 sg13cmos5l_buf_1_4.A a_26608_1090# 0.02619f
C2006 sg13cmos5l_dfrbpq_1_57.D sg13cmos5l_dfrbpq_1_56.D 0.24755f
C2007 sg13cmos5l_dlygate4sd3_1_31.X a_1870_6435# 0.19376f
C2008 sg13cmos5l_dfrbpq_1_57.RESET_B a_11733_7727# 0.34666f
C2009 sg13cmos5l_dfrbpq_1_37.D a_27690_5704# 0.01064f
C2010 sg13cmos5l_nor4_2_0.C a_23958_1656# 0.04512f
C2011 a_10112_2557# VPWR 0.48938f
C2012 sg13cmos5l_dfrbpq_1_53.RESET_B a_10231_7644# 0.01435f
C2013 sg13cmos5l_buf_8_11.A a_21719_7727# 0.02393f
C2014 a_3790_1899# VPWR 0.23504f
C2015 sg13cmos5l_xnor2_1_2.A a_15820_5094# 0.02056f
C2016 sg13cmos5l_nor4_2_0.D sg13cmos5l_nand3_1_0.B 0.31557f
C2017 sg13cmos5l_dfrbpq_1_32.CLK a_6795_7040# 0.04507f
C2018 a_20102_3894# a_20388_4212# 0.50066f
C2019 sg13cmos5l_dlygate4sd3_1_22.X sg13cmos5l_dfrbpq_1_12.D 0.02437f
C2020 sg13cmos5l_dfrbpq_1_5.Q sg13cmos5l_dfrbpq_1_0.CLK 2.62684f
C2021 sg13cmos5l_buf_1_1.X a_20805_3873# 0.06311f
C2022 sg13cmos5l_dfrbpq_1_21.RESET_B sg13cmos5l_dlygate4sd3_1_21.X 0.03337f
C2023 a_22314_6168# sg13cmos5l_dlygate4sd3_1_55.A 0.13188f
C2024 sg13cmos5l_nor3_1_4.B a_18778_6132# 0.10374f
C2025 sg13cmos5l_dfrbpq_1_57.CLK sg13cmos5l_xnor2_1_5.Y 0.03159f
C2026 sg13cmos5l_dfrbpq_1_13.RESET_B a_3680_2557# 0.04118f
C2027 sg13cmos5l_nor4_2_9.Y sg13cmos5l_dfrbpq_1_13.RESET_B 0.13112f
C2028 sg13cmos5l_dlygate4sd3_1_0.X VPWR 0.51034f
C2029 sg13cmos5l_nor4_2_3.Y a_7744_3144# 0.02176f
C2030 sg13cmos5l_dlygate4sd3_1_21.X a_8042_3144# 0.15359f
C2031 sg13cmos5l_buf_1_4.A a_25764_5724# 0.0351f
C2032 sg13cmos5l_dlygate4sd3_1_9.X a_26128_6410# 0.03856f
C2033 a_22314_8728# VPWR 0.47188f
C2034 sg13cmos5l_buf_1_0.X a_24363_7040# 0.55373f
C2035 sg13cmos5l_dfrbpq_1_11.CLK a_14277_2361# 0.40041f
C2036 sg13cmos5l_nand3_1_1.A a_14235_6922# 0.07269f
C2037 a_10791_6255# a_10943_6139# 0.66105f
C2038 sg13cmos5l_xnor2_1_6.Y a_9176_874# 0.01011f
C2039 sg13cmos5l_dfrbpq_1_2.D a_18564_3148# 0.01742f
C2040 a_24900_3148# a_25419_3155# 0.38871f
C2041 a_25317_3155# a_25188_3569# 0.01562f
C2042 sg13cmos5l_dfrbpq_1_0.D a_26135_1679# 0.30864f
C2043 a_24420_2700# a_24708_2395# 0.4806f
C2044 a_13860_2700# a_15119_2459# 0.01741f
C2045 sg13cmos5l_dfrbpq_1_32.CLK VPWR 1.9848f
C2046 sg13cmos5l_dfrbpq_1_15.D a_3590_3894# 0.3024f
C2047 sg13cmos5l_and2_1_4.X VPWR 0.4092f
C2048 sg13cmos5l_dlygate4sd3_1_19.X sg13cmos5l_xor2_1_1.B 0.30278f
C2049 a_16068_7236# a_16485_6897# 0.48921f
C2050 a_15782_6918# a_16587_7040# 0.11742f
C2051 sg13cmos5l_nor4_2_7.D a_23844_7236# 0.03866f
C2052 sg13cmos5l_dfrbpq_1_56.D sg13cmos5l_buf_8_0.X 0.05371f
C2053 a_7351_1596# a_7932_1993# 0.01741f
C2054 sg13cmos5l_dfrbpq_1_55.Q a_15119_3505# 0.02882f
C2055 a_2266_7644# VPWR 0.36124f
C2056 sg13cmos5l_buf_1_0.X sg13cmos5l_dfrbpq_1_0.D 2.69551f
C2057 sg13cmos5l_dlygate4sd3_1_55.X sg13cmos5l_dlygate4sd3_1_51.X 0.21942f
C2058 sg13cmos5l_buf_1_4.A osc 0.02296f
C2059 a_1000_8468# VPWR 0.26367f
C2060 sg13cmos5l_dfrbpq_1_12.Q a_12234_1632# 0.13192f
C2061 a_25131_6179# a_26128_6410# 0.07014f
C2062 sg13cmos5l_xnor2_1_6.B VPWR 1.53299f
C2063 sg13cmos5l_dlygate4sd3_1_52.A a_9446_5410# 0.01842f
C2064 sg13cmos5l_dfrbpq_1_47.Q sg13cmos5l_xnor2_1_2.B 0.35346f
C2065 sg13cmos5l_xnor2_1_2.A a_15946_6136# 0.0365f
C2066 a_5802_4192# sg13cmos5l_dlygate4sd3_1_19.A 0.13777f
C2067 sg13cmos5l_dfrbpq_1_21.RESET_B a_6604_3894# 0.17013f
C2068 a_21934_1059# a_21728_1002# 0.03208f
C2069 sg13cmos5l_dfrbpq_1_13.RESET_B sg13cmos5l_dfrbpq_1_12.D 2.37652f
C2070 sg13cmos5l_xnor2_1_3.A a_27610_1596# 0.01207f
C2071 a_13288_1718# a_13472_1718# 0.11523f
C2072 a_14364_1993# a_14254_2070# 0.4858f
C2073 a_13996_2070# a_14343_1719# 0.06746f
C2074 sg13cmos5l_dfrbpq_1_53.RESET_B sg13cmos5l_dlygate4sd3_1_38.A 0.01224f
C2075 a_7930_4620# a_8312_4697# 0.09023f
C2076 sg13cmos5l_buf_8_5.A sg13cmos5l_dfrbpq_1_21.CLK 0.02024f
C2077 sg13cmos5l_dlygate4sd3_1_6.A sg13cmos5l_nor3_1_0.C 2.4339f
C2078 sg13cmos5l_nor3_1_2.C sg13cmos5l_xnor2_1_8.Y 0.04267f
C2079 a_10827_8552# VPWR 0.20634f
C2080 sg13cmos5l_dfrbpq_1_55.RESET_B a_13574_3582# 0.12359f
C2081 sg13cmos5l_buf_8_10.A sg13cmos5l_and2_1_4.X 0.05187f
C2082 sg13cmos5l_dlygate4sd3_1_6.X sg13cmos5l_nor3_1_0.C 0.0341f
C2083 sg13cmos5l_xnor2_1_2.A sg13cmos5l_xnor2_1_5.Y 0.02506f
C2084 sg13cmos5l_buf_1_4.A a_27023_5483# 0.02773f
C2085 sg13cmos5l_dfrbpq_1_53.Q en[3] 0.55731f
C2086 sg13cmos5l_nand3_1_1.A sg13cmos5l_nor3_1_4.B 0.09973f
C2087 a_10791_6255# sg13cmos5l_dlygate4sd3_1_52.X 0.02149f
C2088 sg13cmos5l_xnor2_1_4.A a_25094_8118# 0.01803f
C2089 sg13cmos5l_xnor2_1_2.A a_16454_3144# 0.02044f
C2090 sg13cmos5l_dlygate4sd3_1_39.X a_27022_6435# 0.19346f
C2091 sg13cmos5l_xnor2_1_2.A a_15878_5406# 0.01874f
C2092 sg13cmos5l_buf_1_0.X sg13cmos5l_nand3_1_2.Y 0.02508f
C2093 sg13cmos5l_nor3_1_0.C osc 0.02355f
C2094 sg13cmos5l_dfrbpq_1_46.D sg13cmos5l_dlygate4sd3_1_6.A 0.2142f
C2095 sg13cmos5l_dfrbpq_1_18.D a_1985_1898# 0.01248f
C2096 sg13cmos5l_and2_1_1.A a_23552_2514# 0.04573f
C2097 a_7103_4164# VPWR 0.24594f
C2098 sg13cmos5l_dfrbpq_1_46.D sg13cmos5l_dlygate4sd3_1_6.X 0.91654f
C2099 a_3304_8562# VPWR 0.12416f
C2100 sg13cmos5l_and2_1_1.A sg13cmos5l_nand3_1_0.A 0.07641f
C2101 sg13cmos5l_xnor2_1_12.B sg13cmos5l_dlygate4sd3_1_23.X 0.01335f
C2102 a_4876_8118# VPWR 0.18791f
C2103 a_16587_7040# a_17584_7138# 0.06746f
C2104 sg13cmos5l_buf_1_0.X a_20907_5528# 0.55515f
C2105 sg13cmos5l_dfrbpq_1_29.Q a_13784_8434# 0.01845f
C2106 sg13cmos5l_dlygate4sd3_1_6.X a_20972_2680# 0.01385f
C2107 sg13cmos5l_dfrbpq_1_57.CLK a_8842_6886# 1.06175f
C2108 a_10943_3115# VPWR 0.24731f
C2109 a_16042_7141# a_16068_7236# 0.43042f
C2110 a_7799_4285# sg13cmos5l_xor2_1_1.B 0.02616f
C2111 sg13cmos5l_dfrbpq_1_59.Q VPWR 1.61663f
C2112 a_25188_4212# a_25605_3873# 0.48921f
C2113 a_24902_3894# a_25707_4016# 0.11742f
C2114 sg13cmos5l_dlygate4sd3_1_18.X sg13cmos5l_nor3_1_1.C 0.07372f
C2115 sg13cmos5l_dfrbpq_1_58.RESET_B a_5724_5370# 0.54576f
C2116 sg13cmos5l_dlygate4sd3_1_22.X a_6604_870# 0.01333f
C2117 sg13cmos5l_nand3_1_2.A a_23958_3962# 0.03694f
C2118 sg13cmos5l_and2_1_1.A a_19361_6434# 0.04556f
C2119 sg13cmos5l_xnor2_1_4.B a_24612_6172# 0.02177f
C2120 sg13cmos5l_dfrbpq_1_2.D sg13cmos5l_nor3_1_0.B 0.0215f
C2121 a_27713_4084# a_27195_3514# 0.01681f
C2122 sg13cmos5l_dfrbpq_1_11.CLK a_14379_3155# 0.03414f
C2123 sg13cmos5l_buf_1_0.X a_20388_6172# 0.53468f
C2124 a_13574_3582# a_13834_3112# 0.87117f
C2125 sg13cmos5l_dfrbpq_1_2.CLK a_19428_1188# 0.08175f
C2126 a_5663_4627# a_5135_3971# 0.01314f
C2127 sg13cmos5l_dfrbpq_1_13.Q a_4380_2346# 0.04726f
C2128 a_3799_2346# a_4359_2600# 0.3087f
C2129 a_2016_7233# a_2632_7050# 0.03457f
C2130 sg13cmos5l_buf_1_4.A a_26929_5483# 0.01902f
C2131 sg13cmos5l_dlygate4sd3_1_53.A a_8312_4697# 0.51805f
C2132 a_28506_2578# sg13cmos5l_xnor2_1_3.A 0.24985f
C2133 sg13cmos5l_buf_1_0.A a_11567_1993# 0.0117f
C2134 sg13cmos5l_dfrbpq_1_11.CLK a_10308_1636# 0.02787f
C2135 sg13cmos5l_dfrbpq_1_37.D VPWR 1.11507f
C2136 sg13cmos5l_buf_1_4.A sg13cmos5l_buf_1_1.X 3.72074f
C2137 sg13cmos5l_nand3_1_2.C a_24922_4620# 0.03601f
C2138 a_8763_8434# a_8591_8041# 0.02392f
C2139 a_28936_7766# a_29120_7766# 0.11523f
C2140 sg13cmos5l_dlygate4sd3_1_18.A a_8776_908# 0.03115f
C2141 sg13cmos5l_xnor2_1_8.Y a_5036_6168# 0.03061f
C2142 sg13cmos5l_nor3_1_0.A a_17032_908# 0.04301f
C2143 a_11276_4192# VPWR 0.41177f
C2144 a_13288_1002# VPWR 0.13817f
C2145 sg13cmos5l_dlygate4sd3_1_6.X sg13cmos5l_dfrbpq_1_46.CLK 0.19133f
C2146 sg13cmos5l_dlygate4sd3_1_17.A sg13cmos5l_dlygate4sd3_1_9.X 1.84499f
C2147 a_16184_3185# VPWR 0.32786f
C2148 sg13cmos5l_dlygate4sd3_1_22.X sg13cmos5l_dlygate4sd3_1_18.X 2.25301f
C2149 a_9562_3862# sg13cmos5l_dfrbpq_1_17.Q 0.499f
C2150 a_3590_8430# a_4164_8443# 0.36169f
C2151 a_5135_8507# a_5375_7651# 0.01269f
C2152 a_18789_2361# VPWR 0.27955f
C2153 a_20102_5094# a_20805_4667# 0.02431f
C2154 sg13cmos5l_dlygate4sd3_1_5.A a_18972_1993# 0.01336f
C2155 sg13cmos5l_nor3_1_0.A sg13cmos5l_xnor2_1_1.Y 0.04498f
C2156 sg13cmos5l_nand3_1_0.Y sg13cmos5l_xnor2_1_1.B 0.80758f
C2157 a_26181_4667# VPWR 0.2407f
C2158 sg13cmos5l_nor4_2_0.D a_25611_992# 0.01363f
C2159 sg13cmos5l_dfrbpq_1_13.RESET_B a_6604_870# 0.18541f
C2160 a_14360_3898# a_14277_3155# 0.02322f
C2161 sg13cmos5l_dfrbpq_1_22.D a_15119_3505# 0.01582f
C2162 a_27598_4083# a_27713_4084# 0.67711f
C2163 sg13cmos5l_dlygate4sd3_1_4.X a_28940_1596# 0.02386f
C2164 sg13cmos5l_dfrbpq_1_58.RESET_B a_5990_6918# 0.10207f
C2165 sg13cmos5l_nor3_1_0.A sg13cmos5l_xnor2_1_2.Y 0.05475f
C2166 sg13cmos5l_dlygate4sd3_1_17.A a_27608_2386# 0.50719f
C2167 a_14235_6922# a_15496_7050# 0.03673f
C2168 sg13cmos5l_nor3_1_1.A sg13cmos5l_dfrbpq_1_59.Q 0.01543f
C2169 sg13cmos5l_nor4_2_7.B en[4] 0.3944f
C2170 sg13cmos5l_buf_1_0.X a_21904_6410# 0.17886f
C2171 sg13cmos5l_nor3_1_0.C sg13cmos5l_buf_1_1.X 0.09958f
C2172 sg13cmos5l_dfrbpq_1_21.CLK a_4511_2652# 0.36027f
C2173 sg13cmos5l_dfrbpq_1_21.RESET_B a_7534_4923# 0.0157f
C2174 sg13cmos5l_xnor2_1_8.Y a_2165_5410# 0.04203f
C2175 sg13cmos5l_and2_1_1.A a_20102_5094# 0.01582f
C2176 a_6972_834# a_6862_870# 0.4858f
C2177 a_7799_1261# a_7754_1028# 0.36169f
C2178 sg13cmos5l_nor3_1_2.C sg13cmos5l_dfrbpq_1_58.RESET_B 2.45227f
C2179 sg13cmos5l_dlygate4sd3_1_4.A a_28289_4922# 0.05001f
C2180 sg13cmos5l_xnor2_1_4.A sg13cmos5l_buf_1_4.A 1.69737f
C2181 sg13cmos5l_buf_1_0.X sg13cmos5l_dlygate4sd3_1_9.X 0.02776f
C2182 a_10022_6918# a_10827_7040# 0.11742f
C2183 a_10308_7236# a_10725_6897# 0.48921f
C2184 sg13cmos5l_dlygate4sd3_1_21.A VPWR 0.81531f
C2185 sg13cmos5l_dfrbpq_1_57.CLK sg13cmos5l_nand3_1_1.Y 0.02813f
C2186 a_1784_8434# sg13cmos5l_buf_1_0.A 0.10476f
C2187 a_16188_5017# a_17109_4703# 0.43042f
C2188 sg13cmos5l_dfrbpq_1_2.CLK a_18972_1993# 0.11505f
C2189 sg13cmos5l_xnor2_1_2.A sg13cmos5l_dlygate4sd3_1_28.A 0.02395f
C2190 sg13cmos5l_nor4_2_0.C a_24134_2382# 0.05745f
C2191 sg13cmos5l_buf_1_1.X a_19893_1679# 0.3433f
C2192 sg13cmos5l_buf_1_0.X a_23846_3898# 0.03423f
C2193 sg13cmos5l_dlygate4sd3_1_23.X sg13cmos5l_dfrbpq_1_18.D 0.07838f
C2194 a_18213_3873# VPWR 0.24485f
C2195 a_10112_7967# VPWR 0.4541f
C2196 sg13cmos5l_buf_1_4.X sg13cmos5l_dfrbpq_1_0.D 0.02434f
C2197 sg13cmos5l_buf_8_5.A sg13cmos5l_buf_8_3.A 0.02976f
C2198 sg13cmos5l_dlygate4sd3_1_13.A VPWR 3.08408f
C2199 a_15008_8605# a_14816_8562# 0.03403f
C2200 sg13cmos5l_dlygate4sd3_1_51.X sg13cmos5l_dlygate4sd3_1_10.A 0.02133f
C2201 sg13cmos5l_dfrbpq_1_13.RESET_B sg13cmos5l_dlygate4sd3_1_18.X 0.20985f
C2202 a_27023_8507# a_27280_8650# 0.40419f
C2203 sg13cmos5l_xnor2_1_8.Y sg13cmos5l_dfrbpq_1_58.D 0.48902f
C2204 a_14360_3898# sg13cmos5l_dfrbpq_1_12.Q 0.51763f
C2205 sg13cmos5l_dlygate4sd3_1_22.A a_3799_834# 0.01228f
C2206 sg13cmos5l_and2_1_1.X a_24170_5704# 0.03835f
C2207 sg13cmos5l_dfrbpq_1_29.Q a_15008_8605# 0.01364f
C2208 sg13cmos5l_dfrbpq_1_58.Q a_4832_4943# 0.14699f
C2209 a_28289_4922# VPWR 0.24407f
C2210 a_1248_4695# a_1397_5026# 0.3658f
C2211 sg13cmos5l_buf_8_0.X a_18144_4695# 0.0187f
C2212 sg13cmos5l_dfrbpq_1_32.CLK sg13cmos5l_dlygate4sd3_1_34.A 1.63599f
C2213 sg13cmos5l_nor3_1_1.A a_16184_3185# 0.01387f
C2214 sg13cmos5l_dfrbpq_1_12.D sg13cmos5l_xnor2_1_0.A 0.03621f
C2215 sg13cmos5l_nand3_1_2.A a_24526_4923# 0.02643f
C2216 sg13cmos5l_xnor2_1_10.Y a_24170_5704# 0.04137f
C2217 sg13cmos5l_and2_1_3.A sg13cmos5l_dfrbpq_1_13.RESET_B 0.24469f
C2218 a_27690_4656# VPWR 0.45321f
C2219 a_17814_3168# a_17702_3144# 0.67711f
C2220 sg13cmos5l_dfrbpq_1_58.RESET_B a_7792_7138# 0.18182f
C2221 sg13cmos5l_xnor2_1_2.A a_9558_5474# 0.20081f
C2222 sg13cmos5l_buf_1_0.X a_25131_6179# 0.55147f
C2223 sg13cmos5l_nand3_1_0.A a_21270_2680# 0.04872f
C2224 a_18315_4016# osc 0.02008f
C2225 sg13cmos5l_dlygate4sd3_1_18.X a_9558_938# 0.23518f
C2226 sg13cmos5l_dlygate4sd3_1_34.A a_2266_7644# 0.50954f
C2227 a_9642_2680# a_10112_2557# 0.03469f
C2228 sg13cmos5l_xnor2_1_4.A sg13cmos5l_nor3_1_0.C 0.10599f
C2229 a_10827_8552# a_11567_8507# 0.3087f
C2230 a_10444_5094# a_10702_5094# 0.01017f
C2231 a_10231_4620# a_10791_4743# 0.3087f
C2232 sg13cmos5l_dlygate4sd3_1_17.A sg13cmos5l_xnor2_1_4.Y 0.01879f
C2233 sg13cmos5l_dlygate4sd3_1_21.A a_1784_874# 0.01151f
C2234 sg13cmos5l_dlygate4sd3_1_38.A a_6693_6897# 0.01639f
C2235 sg13cmos5l_dfrbpq_1_0.CLK a_25611_992# 0.04212f
C2236 sg13cmos5l_dfrbpq_1_2.CLK a_19716_883# 0.01332f
C2237 sg13cmos5l_nor4_2_5.D a_4166_6168# 0.01181f
C2238 sg13cmos5l_xnor2_1_3.A a_28262_1632# 0.01195f
C2239 sg13cmos5l_dfrbpq_1_37.D a_25009_6995# 0.01735f
C2240 sg13cmos5l_dfrbpq_1_11.CLK a_14495_1603# 0.39352f
C2241 sg13cmos5l_dfrbpq_1_12.Q a_13860_2700# 0.015f
C2242 sg13cmos5l_buf_1_0.A sg13cmos5l_dlygate4sd3_1_31.X 0.22466f
C2243 sg13cmos5l_buf_1_2.A a_17432_3185# 0.03839f
C2244 a_16184_3185# a_16385_2572# 0.01425f
C2245 sg13cmos5l_dlygate4sd3_1_17.A sg13cmos5l_dlygate4sd3_1_11.A 0.07681f
C2246 sg13cmos5l_nand3_1_2.Y sg13cmos5l_buf_1_4.X 0.75373f
C2247 a_808_5538# a_808_4742# 0.01095f
C2248 a_10827_7040# a_11824_7138# 0.06746f
C2249 a_10022_6918# a_10596_6931# 0.36169f
C2250 sg13cmos5l_dfrbpq_1_55.RESET_B a_14364_1993# 0.50001f
C2251 sg13cmos5l_dfrbpq_1_3.D a_23368_1002# 0.03297f
C2252 sg13cmos5l_dfrbpq_1_57.CLK a_10812_6529# 0.10413f
C2253 sg13cmos5l_dlygate4sd3_1_52.A sg13cmos5l_dlygate4sd3_1_52.X 0.46599f
C2254 a_21904_4114# VPWR 0.19003f
C2255 sg13cmos5l_nor4_2_1.A sg13cmos5l_dfrbpq_1_5.Q 2.40734f
C2256 sg13cmos5l_xnor2_1_2.A sg13cmos5l_nand3_1_1.Y 0.03555f
C2257 sg13cmos5l_nor3_1_0.B sg13cmos5l_nor4_2_0.B 0.18295f
C2258 a_27226_2350# a_27608_2386# 0.09023f
C2259 a_10022_2070# a_10827_1643# 0.11742f
C2260 sg13cmos5l_xnor2_1_2.B sg13cmos5l_dfrbpq_1_53.RESET_B 0.49489f
C2261 a_17541_1168# VPWR 0.0138f
C2262 a_24708_2395# VPWR 0.01746f
C2263 sg13cmos5l_nor4_2_7.B a_23872_5704# 0.04931f
C2264 sg13cmos5l_dfrbpq_1_58.RESET_B sg13cmos5l_xor2_1_1.B 0.02239f
C2265 a_28570_5374# a_28570_4620# 0.02325f
C2266 sg13cmos5l_dfrbpq_1_18.D sg13cmos5l_dfrbpq_1_12.D 0.04572f
C2267 a_27280_8650# a_26929_8507# 0.01017f
C2268 sg13cmos5l_and2_1_1.X a_23558_6918# 0.01736f
C2269 a_4293_3155# a_4164_3569# 0.01562f
C2270 a_18315_4016# a_18981_3155# 0.01665f
C2271 sg13cmos5l_dfrbpq_1_12.D sg13cmos5l_nor3_1_1.Y 1.66253f
C2272 a_3876_3148# a_4395_3155# 0.38871f
C2273 sg13cmos5l_dfrbpq_1_53.CLK sg13cmos5l_nand3_1_2.C 0.95058f
C2274 sg13cmos5l_buf_1_0.X sg13cmos5l_xnor2_1_4.Y 0.02643f
C2275 a_19526_8434# VPWR 0.23952f
C2276 sg13cmos5l_buf_1_2.A sg13cmos5l_buf_1_4.X 0.1611f
C2277 sg13cmos5l_dfrbpq_1_53.CLK sg13cmos5l_dlygate4sd3_1_11.X 0.07191f
C2278 sg13cmos5l_dfrbpq_1_13.RESET_B a_11567_947# 0.19883f
C2279 a_20805_4667# a_21553_5017# 0.01058f
C2280 sg13cmos5l_dlygate4sd3_1_4.X sg13cmos5l_dlygate4sd3_1_4.A 0.06962f
C2281 sg13cmos5l_dfrbpq_1_35.Q a_13664_8562# 0.07116f
C2282 a_13784_8434# a_14054_8434# 0.33585f
C2283 a_20080_3386# a_19729_3505# 0.01017f
C2284 a_19823_3505# a_20490_3144# 0.13494f
C2285 sg13cmos5l_buf_1_0.A a_4012_2382# 0.02033f
C2286 a_10812_2346# a_11639_2773# 0.50066f
C2287 sg13cmos5l_xnor2_1_4.B a_24614_3582# 0.04598f
C2288 a_25092_1188# a_25611_992# 0.38902f
C2289 sg13cmos5l_and2_1_1.X a_24134_2382# 0.04548f
C2290 sg13cmos5l_dlygate4sd3_1_55.X sg13cmos5l_nor4_2_7.D 0.81279f
C2291 a_6951_1088# VPWR 0.2079f
C2292 a_10812_5017# a_11639_4703# 0.50066f
C2293 sg13cmos5l_dlygate4sd3_1_38.A a_8842_6886# 0.07549f
C2294 sg13cmos5l_xor2_1_2.A sg13cmos5l_dlygate4sd3_1_52.X 0.05069f
C2295 sg13cmos5l_xnor2_1_2.A a_13472_7766# 0.03262f
C2296 a_10725_849# a_10827_992# 0.66105f
C2297 sg13cmos5l_xnor2_1_13.A a_1248_4695# 0.035f
C2298 sg13cmos5l_dlygate4sd3_1_19.X a_5135_3505# 0.02264f
C2299 sg13cmos5l_dfrbpq_1_13.RESET_B a_7351_1596# 0.25034f
C2300 sg13cmos5l_dfrbpq_1_2.CLK sg13cmos5l_dfrbpq_1_0.CLK 0.01745f
C2301 sg13cmos5l_xnor2_1_8.Y a_5024_5581# 0.01873f
C2302 a_2632_8562# a_2816_8562# 0.11523f
C2303 sg13cmos5l_dlygate4sd3_1_4.X VPWR 0.94263f
C2304 sg13cmos5l_xnor2_1_2.A sg13cmos5l_dfrbpq_1_56.D 0.06526f
C2305 sg13cmos5l_xnor2_1_2.B a_16666_2350# 0.02534f
C2306 a_27114_4192# VPWR 0.45321f
C2307 a_1480_7766# a_1664_7766# 0.11523f
C2308 sg13cmos5l_buf_1_1.X a_20944_1090# 0.17713f
C2309 sg13cmos5l_dlygate4sd3_1_47.A sg13cmos5l_dlygate4sd3_1_55.X 0.02702f
C2310 a_6250_2350# VPWR 1.35911f
C2311 sg13cmos5l_xnor2_1_2.A a_10812_6529# 0.02305f
C2312 a_17109_4703# VPWR 0.09646f
C2313 a_15839_8700# a_15687_8648# 0.6663f
C2314 a_18922_7644# sg13cmos5l_buf_8_11.A 0.54513f
C2315 sg13cmos5l_nor4_2_7.B a_23368_7050# 0.07067f
C2316 sg13cmos5l_dfrbpq_1_21.RESET_B a_4293_3155# 0.08424f
C2317 a_19845_849# VPWR 0.2414f
C2318 a_28570_4620# a_28376_3898# 0.01738f
C2319 sg13cmos5l_nor4_2_9.Y sg13cmos5l_xnor2_1_5.Y 0.03029f
C2320 sg13cmos5l_dlygate4sd3_1_2.A sg13cmos5l_dfrbpq_1_0.D 0.02729f
C2321 sg13cmos5l_dlygate4sd3_1_17.X a_25764_4660# 0.01512f
C2322 sg13cmos5l_buf_1_1.X a_20973_3492# 0.35235f
C2323 sg13cmos5l_dlygate4sd3_1_39.X a_26639_8041# 0.02252f
C2324 sg13cmos5l_xnor2_1_6.A sg13cmos5l_xnor2_1_6.B 1.39652f
C2325 a_20805_8409# VPWR 0.23968f
C2326 sg13cmos5l_nor4_2_7.B VPWR 0.59506f
C2327 sg13cmos5l_dfrbpq_1_21.CLK a_7103_4164# 0.36479f
C2328 sg13cmos5l_buf_1_4.X a_8776_908# 0.29729f
C2329 a_23576_3185# a_23846_3144# 0.33585f
C2330 sg13cmos5l_buf_1_0.A a_5319_1719# 0.01089f
C2331 a_21647_5017# a_22314_4656# 0.13494f
C2332 sg13cmos5l_nor4_2_4.D a_14720_6254# 0.03537f
C2333 a_21904_4898# a_21553_5017# 0.01017f
C2334 sg13cmos5l_dfrbpq_1_58.RESET_B sg13cmos5l_dfrbpq_1_58.D 0.22369f
C2335 a_24134_2382# a_24837_2361# 0.02453f
C2336 a_13288_2514# a_13472_2514# 0.11523f
C2337 a_27418_6132# a_27963_6538# 0.03987f
C2338 sg13cmos5l_buf_1_4.A a_10308_1188# 0.02303f
C2339 a_24806_870# a_25380_883# 0.36169f
C2340 a_3904_4656# VPWR 0.391f
C2341 a_5340_1993# a_5471_1603# 0.48921f
C2342 sg13cmos5l_buf_1_0.A sg13cmos5l_buf_1_4.A 0.04168f
C2343 sg13cmos5l_dlygate4sd3_1_39.X a_26283_8552# 0.02111f
C2344 sg13cmos5l_buf_1_5.A sg13cmos5l_dfrbpq_1_38.Q 0.13405f
C2345 a_3876_3148# VPWR 0.07259f
C2346 sg13cmos5l_buf_1_4.A a_27695_6995# 0.01765f
C2347 sg13cmos5l_dlygate4sd3_1_17.A a_27784_6254# 0.01102f
C2348 sg13cmos5l_dfrbpq_1_13.Q a_4186_1596# 0.10073f
C2349 sg13cmos5l_dfrbpq_1_21.RESET_B a_3590_3894# 0.10296f
C2350 a_10444_2382# VPWR 0.22454f
C2351 sg13cmos5l_dlygate4sd3_1_21.A a_920_1673# 0.52937f
C2352 a_7103_4164# sg13cmos5l_xnor2_1_6.A 0.01441f
C2353 a_20388_4212# a_21647_3971# 0.01741f
C2354 a_25738_5629# a_25478_5406# 0.87117f
C2355 sg13cmos5l_nor4_2_7.D a_23861_6538# 0.01256f
C2356 sg13cmos5l_dfrbpq_1_22.Q sg13cmos5l_nor3_1_1.C 0.1814f
C2357 a_9176_3185# a_9446_3144# 0.33585f
C2358 sg13cmos5l_dfrbpq_1_0.CLK a_26159_3505# 0.0165f
C2359 sg13cmos5l_dfrbpq_1_58.D a_4951_4620# 0.0173f
C2360 sg13cmos5l_dfrbpq_1_53.Q a_28936_8562# 0.07461f
C2361 sg13cmos5l_buf_1_0.A sg13cmos5l_dlygate4sd3_1_21.X 0.01414f
C2362 sg13cmos5l_dlygate4sd3_1_17.X a_27023_5017# 0.01409f
C2363 a_26416_3386# a_26159_3505# 0.40419f
C2364 sg13cmos5l_dlygate4sd3_1_40.A sg13cmos5l_dfrbpq_1_7.Q 0.01352f
C2365 sg13cmos5l_xnor2_1_2.B a_15946_6136# 0.01479f
C2366 a_16167_4743# a_15850_3862# 0.01076f
C2367 a_20192_7093# sg13cmos5l_dlygate4sd3_1_6.A 0.13378f
C2368 a_4511_1140# a_5162_1028# 0.01562f
C2369 a_4380_834# a_5301_1028# 0.43042f
C2370 a_1436_5704# sg13cmos5l_xnor2_1_13.A 0.11841f
C2371 a_7103_8700# a_7332_7684# 0.01465f
C2372 sg13cmos5l_dfrbpq_1_57.RESET_B a_10812_5017# 0.5089f
C2373 sg13cmos5l_buf_1_0.A sg13cmos5l_nor3_1_0.C 0.02405f
C2374 a_11824_1090# VPWR 0.18926f
C2375 sg13cmos5l_dfrbpq_1_57.RESET_B a_10725_6897# 0.08045f
C2376 sg13cmos5l_dfrbpq_1_23.D sg13cmos5l_dlygate4sd3_1_23.X 0.07561f
C2377 a_20362_8653# sg13cmos5l_buf_1_0.X 0.31898f
C2378 sg13cmos5l_xnor2_1_2.B sg13cmos5l_xnor2_1_5.Y 0.28638f
C2379 a_3488_4026# VPWR 0.0687f
C2380 a_15708_8394# VPWR 0.07227f
C2381 sg13cmos5l_buf_1_0.A a_19893_1679# 0.01641f
C2382 a_10231_3108# VPWR 0.17441f
C2383 sg13cmos5l_dfrbpq_1_13.RESET_B a_10725_1643# 0.06333f
C2384 sg13cmos5l_xnor2_1_2.B a_16454_3144# 0.0351f
C2385 sg13cmos5l_dfrbpq_1_18.D sg13cmos5l_dlygate4sd3_1_18.X 0.02688f
C2386 a_19631_2459# a_19537_2459# 0.32273f
C2387 sg13cmos5l_xnor2_1_2.B a_15878_5406# 0.03838f
C2388 sg13cmos5l_nor4_2_9.Y sg13cmos5l_dfrbpq_1_23.D 0.128f
C2389 sg13cmos5l_dlygate4sd3_1_22.X sg13cmos5l_dfrbpq_1_22.Q 0.16487f
C2390 sg13cmos5l_dlygate4sd3_1_18.X sg13cmos5l_nor3_1_1.Y 0.0311f
C2391 a_7564_2070# VPWR 0.18658f
C2392 a_25198_2070# a_25439_1603# 0.01058f
C2393 sg13cmos5l_dlygate4sd3_1_22.X a_4380_834# 0.03356f
C2394 sg13cmos5l_nor4_2_5.C sg13cmos5l_dfrbpq_1_21.RESET_B 0.44006f
C2395 sg13cmos5l_nor4_2_7.B a_26853_6897# 0.01399f
C2396 sg13cmos5l_xnor2_1_4.A a_27195_3514# 0.01405f
C2397 sg13cmos5l_nor3_1_1.C a_11639_3191# 0.02119f
C2398 a_10791_3231# a_11594_3424# 0.15089f
C2399 sg13cmos5l_dfrbpq_1_11.CLK a_10943_3115# 0.36554f
C2400 sg13cmos5l_nor3_1_2.B a_1985_7946# 0.03085f
C2401 a_2266_7644# a_2920_7680# 0.02088f
C2402 sg13cmos5l_buf_8_4.A sg13cmos5l_xnor2_1_8.Y 0.07871f
C2403 sg13cmos5l_nor3_1_0.A a_21934_1059# 0.20159f
C2404 a_1870_2571# a_1664_2514# 0.03208f
C2405 sg13cmos5l_dlygate4sd3_1_17.X sg13cmos5l_dfrbpq_1_7.Q 0.08889f
C2406 a_21647_8507# a_22314_8728# 0.13494f
C2407 sg13cmos5l_dfrbpq_1_58.RESET_B sg13cmos5l_buf_8_9.A 0.01246f
C2408 sg13cmos5l_xnor2_1_3.A sg13cmos5l_dfrbpq_1_3.D 0.74191f
C2409 sg13cmos5l_nand3_1_1.Y a_17015_4703# 0.01458f
C2410 sg13cmos5l_dfrbpq_1_55.RESET_B a_15376_2602# 0.23041f
C2411 a_15119_2459# a_15025_2459# 0.32273f
C2412 a_6795_7040# a_6564_6931# 0.15089f
C2413 a_6276_7236# a_7441_6995# 0.4858f
C2414 sg13cmos5l_dlygate4sd3_1_5.A sg13cmos5l_xnor2_1_3.A 0.87121f
C2415 sg13cmos5l_and2_1_3.A a_13676_6168# 0.03057f
C2416 a_7932_1993# a_8063_1603# 0.48921f
C2417 sg13cmos5l_dlygate4sd3_1_28.X a_13676_6168# 0.08493f
C2418 a_18391_1596# a_18972_1993# 0.01741f
C2419 sg13cmos5l_dlygate4sd3_1_4.X a_28362_7216# 0.03859f
C2420 a_9558_4680# VPWR 0.21431f
C2421 sg13cmos5l_xnor2_1_1.B a_18272_1919# 0.05121f
C2422 sg13cmos5l_dfrbpq_1_13.RESET_B a_3850_4117# 0.02909f
C2423 sg13cmos5l_xnor2_1_6.A sg13cmos5l_dlygate4sd3_1_21.A 0.15533f
C2424 sg13cmos5l_xnor2_1_10.Y sg13cmos5l_dlygate4sd3_1_51.A 0.03217f
C2425 sg13cmos5l_dlygate4sd3_1_9.X sg13cmos5l_dlygate4sd3_1_2.A 0.2344f
C2426 sg13cmos5l_buf_1_5.A sg13cmos5l_buf_1_2.A 0.03003f
C2427 a_4293_8409# sg13cmos5l_dfrbpq_1_32.CLK 0.35736f
C2428 sg13cmos5l_nor3_1_2.C sg13cmos5l_dlygate4sd3_1_53.A 0.01213f
C2429 a_20907_8552# en[3] 0.01894f
C2430 sg13cmos5l_buf_1_5.A a_10827_5528# 0.0142f
C2431 sg13cmos5l_buf_8_3.A a_10943_3115# 0.01662f
C2432 sg13cmos5l_dfrbpq_1_13.RESET_B a_4380_834# 0.48887f
C2433 a_25707_4016# a_26447_3971# 0.3087f
C2434 sg13cmos5l_dfrbpq_1_46.CLK a_20805_6179# 0.3804f
C2435 a_14495_1603# a_15191_1679# 0.02453f
C2436 sg13cmos5l_dfrbpq_1_13.CLK a_5340_1993# 0.10414f
C2437 sg13cmos5l_dfrbpq_1_3.Q sg13cmos5l_xnor2_1_1.Y 0.16461f
C2438 a_13574_3582# a_14379_3155# 0.11742f
C2439 sg13cmos5l_nor3_1_1.C sg13cmos5l_dfrbpq_1_55.D 0.55114f
C2440 sg13cmos5l_nand3_1_1.A a_17109_4703# 0.02178f
C2441 sg13cmos5l_dlygate4sd3_1_33.A a_3990_7704# 0.01523f
C2442 a_808_4742# VPWR 0.11588f
C2443 sg13cmos5l_dfrbpq_1_3.Q sg13cmos5l_xnor2_1_2.Y 0.15255f
C2444 sg13cmos5l_dlygate4sd3_1_2.A a_27608_2386# 0.07002f
C2445 sg13cmos5l_buf_1_0.X a_23576_4697# 0.05575f
C2446 sg13cmos5l_dfrbpq_1_2.CLK sg13cmos5l_xnor2_1_3.A 0.05037f
C2447 a_25478_5406# a_26052_5419# 0.36169f
C2448 a_4359_2600# a_5207_2773# 0.11742f
C2449 sg13cmos5l_dfrbpq_1_54.Q sg13cmos5l_dfrbpq_1_59.Q 0.01432f
C2450 sg13cmos5l_xnor2_1_8.Y sg13cmos5l_dlygate4sd3_1_52.A 0.01565f
C2451 a_23660_1168# VPWR 0.4126f
C2452 sg13cmos5l_nor3_1_0.A a_22049_1060# 0.01157f
C2453 sg13cmos5l_dfrbpq_1_56.D a_17015_4703# 0.29958f
C2454 a_6951_1088# a_6972_834# 0.38871f
C2455 a_7103_1140# a_7799_1261# 0.02431f
C2456 a_22314_8728# sg13cmos5l_dlygate4sd3_1_47.A 0.13378f
C2457 sg13cmos5l_xnor2_1_2.B a_13888_7680# 0.07412f
C2458 a_20311_6882# a_20892_6882# 0.01741f
C2459 a_20792_1673# VPWR 0.38301f
C2460 sg13cmos5l_nor4_2_9.Y sg13cmos5l_nand3_1_1.Y 0.03901f
C2461 sg13cmos5l_buf_8_4.A a_8848_7922# 0.02072f
C2462 sg13cmos5l_dfrbpq_1_21.RESET_B a_7594_5374# 0.05317f
C2463 sg13cmos5l_dfrbpq_1_21.RESET_B a_4481_7108# 0.04713f
C2464 sg13cmos5l_dfrbpq_1_18.D a_7351_1596# 0.01253f
C2465 a_13713_4216# VPWR 0.01072f
C2466 sg13cmos5l_buf_1_4.A sg13cmos5l_nor3_1_0.Y 0.03647f
C2467 sg13cmos5l_nand3_1_0.A a_19947_992# 0.0342f
C2468 a_23661_2428# VPWR 0.51063f
C2469 sg13cmos5l_nor4_2_1.D VPWR 1.45041f
C2470 a_7649_4922# VPWR 0.24092f
C2471 sg13cmos5l_dlygate4sd3_1_18.X sg13cmos5l_nand3_1_3.B 2.5808f
C2472 sg13cmos5l_dfrbpq_1_22.D a_11786_4192# 0.08473f
C2473 sg13cmos5l_buf_1_4.X a_21647_5017# 0.20971f
C2474 sg13cmos5l_xor2_1_2.B sg13cmos5l_dfrbpq_1_55.RESET_B 0.01284f
C2475 sg13cmos5l_dfrbpq_1_23.D a_992_4742# 0.03287f
C2476 a_5375_7651# a_6026_7960# 0.01562f
C2477 sg13cmos5l_and2_1_3.A sg13cmos5l_xnor2_1_5.Y 0.02523f
C2478 sg13cmos5l_nor3_1_4.C a_15850_3862# 0.02141f
C2479 a_21023_7188# en[4] 0.01216f
C2480 sg13cmos5l_dfrbpq_1_54.Q a_16184_3185# 0.59803f
C2481 sg13cmos5l_dlygate4sd3_1_31.X a_3590_8430# 0.29745f
C2482 sg13cmos5l_dlygate4sd3_1_33.A a_3488_7766# 0.0703f
C2483 a_7430_2382# a_8133_2361# 0.02453f
C2484 a_10308_8748# a_10827_8552# 0.38902f
C2485 sg13cmos5l_nor4_2_7.B sg13cmos5l_dlygate4sd3_1_51.X 0.05952f
C2486 a_25509_849# VPWR 0.2372f
C2487 a_10725_8409# a_10791_7767# 0.0167f
C2488 sg13cmos5l_nor4_2_1.A sg13cmos5l_dfrbpq_1_2.CLK 0.06775f
C2489 sg13cmos5l_buf_1_4.A a_26447_3971# 0.02823f
C2490 sg13cmos5l_buf_8_4.A sg13cmos5l_dfrbpq_1_58.RESET_B 0.08021f
C2491 sg13cmos5l_nor3_1_0.C sg13cmos5l_nor3_1_0.Y 0.23495f
C2492 sg13cmos5l_dfrbpq_1_56.RESET_B a_16490_8588# 0.02084f
C2493 sg13cmos5l_buf_1_11.A sg13cmos5l_nor3_1_2.B 0.02085f
C2494 sg13cmos5l_xnor2_1_2.B a_16367_8041# 0.01191f
C2495 a_1384_8468# sg13cmos5l_buf_1_11.A 0.1357f
C2496 a_19722_4192# VPWR 0.45469f
C2497 sg13cmos5l_dfrbpq_1_23.D a_8582_4656# 0.07165f
C2498 a_808_5538# VPWR 0.11679f
C2499 sg13cmos5l_xnor2_1_0.Y sg13cmos5l_dfrbpq_1_13.CLK 1.09053f
C2500 a_23958_3168# VPWR 0.21374f
C2501 sg13cmos5l_buf_1_5.A sg13cmos5l_buf_8_9.A 0.13538f
C2502 sg13cmos5l_nand3_1_0.A a_20687_947# 0.01529f
C2503 a_24420_2700# VPWR 0.12745f
C2504 sg13cmos5l_dfrbpq_1_58.RESET_B a_6272_4069# 0.01113f
C2505 sg13cmos5l_buf_1_4.X a_11567_1993# 0.01642f
C2506 sg13cmos5l_and2_1_1.A a_20080_3386# 0.01868f
C2507 sg13cmos5l_buf_1_0.A a_27214_1899# 0.01262f
C2508 a_26181_8409# a_26929_8507# 0.01058f
C2509 sg13cmos5l_dfrbpq_1_13.RESET_B sg13cmos5l_dfrbpq_1_55.D 0.10701f
C2510 sg13cmos5l_nor4_2_9.D a_4202_4656# 0.11833f
C2511 sg13cmos5l_dfrbpq_1_12.D a_1340_3144# 0.01088f
C2512 sg13cmos5l_buf_1_1.X a_18086_2382# 0.10184f
C2513 sg13cmos5l_nand3_1_0.A sg13cmos5l_nand3_1_0.B 0.11231f
C2514 sg13cmos5l_dfrbpq_1_32.CLK a_7332_7684# 0.15944f
C2515 a_18278_3582# a_18538_3112# 0.87117f
C2516 sg13cmos5l_xnor2_1_2.B sg13cmos5l_nand3_1_1.Y 0.01236f
C2517 sg13cmos5l_xnor2_1_6.A a_6250_2350# 0.02473f
C2518 sg13cmos5l_nand3_1_2.B osc 0.02164f
C2519 sg13cmos5l_dfrbpq_1_13.CLK a_8759_1679# 0.02098f
C2520 sg13cmos5l_dfrbpq_1_21.CLK a_3876_3148# 0.10076f
C2521 sg13cmos5l_dfrbpq_1_37.D sg13cmos5l_nor4_2_7.D 1.12912f
C2522 a_10282_7141# VPWR 0.09589f
C2523 a_5207_1261# VPWR 0.92698f
C2524 sg13cmos5l_dlygate4sd3_1_20.A a_5319_1719# 0.01234f
C2525 a_27798_938# VPWR 0.2127f
C2526 sg13cmos5l_dlygate4sd3_1_17.A sg13cmos5l_buf_1_4.A 0.02914f
C2527 sg13cmos5l_dlygate4sd3_1_31.X a_3608_7721# 0.03273f
C2528 a_4544_7967# a_4876_8118# 0.1396f
C2529 a_3608_7721# a_3878_7680# 0.33585f
C2530 a_27416_874# VPWR 0.32634f
C2531 sg13cmos5l_dlygate4sd3_1_17.A sg13cmos5l_dlygate4sd3_1_39.A 1.23527f
C2532 a_4511_2652# a_4972_2070# 0.01059f
C2533 sg13cmos5l_xor2_1_2.B a_14720_6254# 0.01427f
C2534 a_15322_6132# a_15041_6434# 0.33585f
C2535 a_10943_7651# a_11733_7727# 0.02241f
C2536 sg13cmos5l_nor4_2_9.Y sg13cmos5l_nor4_2_9.D 1.20599f
C2537 sg13cmos5l_dlygate4sd3_1_53.A a_8106_6168# 0.01392f
C2538 sg13cmos5l_buf_1_4.A sg13cmos5l_dlygate4sd3_1_18.A 0.02985f
C2539 sg13cmos5l_dfrbpq_1_13.RESET_B a_4186_1596# 0.01495f
C2540 sg13cmos5l_dfrbpq_1_53.CLK a_27963_6538# 1.05817f
C2541 sg13cmos5l_buf_1_4.A a_26135_1679# 0.05615f
C2542 sg13cmos5l_dlygate4sd3_1_47.A sg13cmos5l_dfrbpq_1_37.D 0.0481f
C2543 a_9446_5410# a_9446_4656# 0.01869f
C2544 a_8842_6886# sg13cmos5l_and2_1_3.A 0.0103f
C2545 a_26283_5528# VPWR 0.20648f
C2546 a_21023_7188# a_21813_7076# 0.02241f
C2547 a_1480_2514# VPWR 0.15071f
C2548 sg13cmos5l_xor2_1_2.B a_13916_4192# 0.03145f
C2549 sg13cmos5l_dfrbpq_1_2.D a_18951_1719# 0.02023f
C2550 sg13cmos5l_dfrbpq_1_21.RESET_B a_6250_7141# 0.01254f
C2551 sg13cmos5l_dfrbpq_1_18.D a_2054_3144# 0.03203f
C2552 sg13cmos5l_buf_8_10.A a_10282_7141# 0.01612f
C2553 a_8842_6886# sg13cmos5l_dlygate4sd3_1_28.X 0.03035f
C2554 a_17510_3894# a_18315_4016# 0.11742f
C2555 a_17796_4212# a_18213_3873# 0.48921f
C2556 sg13cmos5l_dfrbpq_1_29.Q a_15708_8394# 0.02381f
C2557 sg13cmos5l_nor3_1_0.B sg13cmos5l_dfrbpq_1_0.D 0.02035f
C2558 a_13974_4680# VPWR 0.21405f
C2559 a_18604_2070# VPWR 0.18786f
C2560 sg13cmos5l_buf_1_0.X sg13cmos5l_buf_1_4.A 0.28835f
C2561 sg13cmos5l_xnor2_1_2.B sg13cmos5l_dfrbpq_1_56.D 0.02127f
C2562 sg13cmos5l_dlygate4sd3_1_6.A a_18843_5410# 0.07083f
C2563 sg13cmos5l_dlygate4sd3_1_17.A sg13cmos5l_nor3_1_0.C 0.02055f
C2564 sg13cmos5l_dlygate4sd3_1_4.X a_28174_8619# 0.01481f
C2565 sg13cmos5l_nor3_1_0.C a_22314_4656# 0.01205f
C2566 sg13cmos5l_dlygate4sd3_1_21.X sg13cmos5l_dlygate4sd3_1_20.A 0.09196f
C2567 sg13cmos5l_xnor2_1_4.B a_25419_3155# 0.02922f
C2568 sg13cmos5l_dfrbpq_1_56.Q a_15296_4742# 0.01538f
C2569 a_2166_8498# VPWR 0.21924f
C2570 sg13cmos5l_and2_1_3.A sg13cmos5l_dlygate4sd3_1_28.A 1.12994f
C2571 sg13cmos5l_dfrbpq_1_56.CLK a_16167_4743# 0.0148f
C2572 a_5703_5624# a_6506_5564# 0.15089f
C2573 sg13cmos5l_buf_1_0.X a_21813_7727# 0.34671f
C2574 VPWR en[4] 2.12121f
C2575 sg13cmos5l_dlygate4sd3_1_11.X a_25764_5724# 0.03175f
C2576 sg13cmos5l_dlygate4sd3_1_17.X sg13cmos5l_dfrbpq_1_0.CLK 0.08248f
C2577 a_15946_6136# a_16389_6179# 0.02241f
C2578 a_15686_6606# a_16260_6593# 0.36169f
C2579 sg13cmos5l_dfrbpq_1_53.RESET_B a_25103_6995# 0.04201f
C2580 sg13cmos5l_xnor2_1_0.Y a_14343_1719# 0.01433f
C2581 sg13cmos5l_dfrbpq_1_21.RESET_B a_7696_6410# 0.05049f
C2582 sg13cmos5l_dlygate4sd3_1_28.X sg13cmos5l_dlygate4sd3_1_28.A 0.21765f
C2583 sg13cmos5l_dfrbpq_1_57.RESET_B a_9176_5410# 0.09531f
C2584 sg13cmos5l_dlygate4sd3_1_19.X sg13cmos5l_dlygate4sd3_1_21.X 0.01742f
C2585 a_27994_3862# VPWR 0.33272f
C2586 sg13cmos5l_xnor2_1_3.B sg13cmos5l_xnor2_1_3.A 1.498f
C2587 a_28940_1596# VPWR 0.25194f
C2588 sg13cmos5l_buf_1_4.X a_25188_3569# 0.0159f
C2589 a_7716_2700# VPWR 0.13289f
C2590 a_13888_6168# VPWR 0.39085f
C2591 a_27690_5704# VPWR 0.45268f
C2592 a_20892_6882# a_21674_7076# 0.4806f
C2593 a_11824_1874# a_11567_1993# 0.40419f
C2594 sg13cmos5l_nor4_2_4.D sg13cmos5l_nor3_1_4.A 3.71278f
C2595 sg13cmos5l_xor2_1_1.B a_1169_3502# 0.39475f
C2596 sg13cmos5l_dfrbpq_1_21.RESET_B a_5392_3386# 0.20186f
C2597 sg13cmos5l_buf_1_0.X sg13cmos5l_nor3_1_0.C 0.02254f
C2598 sg13cmos5l_buf_8_4.A sg13cmos5l_buf_1_5.A 0.33077f
C2599 sg13cmos5l_xor2_1_2.B sg13cmos5l_dfrbpq_1_17.D 0.10157f
C2600 sg13cmos5l_nand3_1_2.C osc 0.04794f
C2601 sg13cmos5l_xnor2_1_9.A sg13cmos5l_nor4_2_9.Y 0.2421f
C2602 a_2016_7233# sg13cmos5l_nor3_1_2.Y 0.02665f
C2603 sg13cmos5l_and2_1_1.A sg13cmos5l_dfrbpq_1_2.D 0.18424f
C2604 a_3680_5609# sg13cmos5l_buf_8_5.A 0.13194f
C2605 sg13cmos5l_buf_1_1.X a_26830_2571# 0.01154f
C2606 a_21023_7188# VPWR 0.24164f
C2607 sg13cmos5l_buf_8_3.A a_6250_2350# 0.54673f
C2608 sg13cmos5l_dlygate4sd3_1_11.X osc 0.02232f
C2609 sg13cmos5l_nor3_1_1.Y sg13cmos5l_dfrbpq_1_22.Q 0.06787f
C2610 a_16188_5017# VPWR 0.07236f
C2611 sg13cmos5l_buf_1_4.A a_27226_2350# 0.01056f
C2612 sg13cmos5l_buf_8_10.A en[4] 0.67863f
C2613 sg13cmos5l_dfrbpq_1_2.D sg13cmos5l_dfrbpq_1_3.Q 0.03896f
C2614 a_24614_3582# a_24874_3112# 0.87117f
C2615 a_23958_3168# a_24424_3230# 0.0311f
C2616 a_10943_3115# a_10943_2652# 0.03069f
C2617 sg13cmos5l_dfrbpq_1_37.D a_25380_7684# 0.01348f
C2618 a_13862_4656# sg13cmos5l_dfrbpq_1_17.D 0.01508f
C2619 sg13cmos5l_dfrbpq_1_56.CLK a_16491_6179# 0.04432f
C2620 sg13cmos5l_nand3_1_1.Y sg13cmos5l_dlygate4sd3_1_18.X 0.02529f
C2621 sg13cmos5l_nand3_1_2.A sg13cmos5l_buf_8_11.A 0.14749f
C2622 sg13cmos5l_dlygate4sd3_1_6.X a_20388_5724# 0.02528f
C2623 a_9446_874# VPWR 0.24466f
C2624 sg13cmos5l_dfrbpq_1_46.D sg13cmos5l_buf_1_0.X 0.49789f
C2625 sg13cmos5l_dlygate4sd3_1_39.X sg13cmos5l_buf_8_11.A 0.02386f
C2626 sg13cmos5l_dfrbpq_1_53.RESET_B a_26955_7040# 0.55132f
C2627 sg13cmos5l_dlygate4sd3_1_11.X a_27023_5483# 0.01317f
C2628 sg13cmos5l_xnor2_1_2.B a_16587_7040# 0.01387f
C2629 sg13cmos5l_dfrbpq_1_55.Q a_13860_3148# 0.0207f
C2630 sg13cmos5l_dfrbpq_1_23.Q VPWR 0.96602f
C2631 a_16260_6593# a_16491_6179# 0.15089f
C2632 sg13cmos5l_dfrbpq_1_21.RESET_B a_6391_8394# 0.25684f
C2633 sg13cmos5l_dfrbpq_1_53.RESET_B sg13cmos5l_dlygate4sd3_1_40.A 0.17966f
C2634 sg13cmos5l_nor4_2_4.D a_17327_6995# 0.01458f
C2635 sg13cmos5l_buf_1_4.X a_25707_4016# 0.55658f
C2636 sg13cmos5l_xnor2_1_1.Y a_17621_2002# 0.05944f
C2637 a_4395_3155# VPWR 0.20954f
C2638 sg13cmos5l_dfrbpq_1_57.RESET_B a_15525_7691# 0.05306f
C2639 sg13cmos5l_dfrbpq_1_13.RESET_B a_8063_1603# 0.08694f
C2640 a_15878_5406# a_16581_5385# 0.02453f
C2641 a_4293_3873# a_4164_3907# 0.01562f
C2642 a_5135_3971# a_5802_4192# 0.13494f
C2643 sg13cmos5l_dlygate4sd3_1_53.A sg13cmos5l_buf_8_9.A 0.54679f
C2644 a_13834_2605# VPWR 0.13688f
C2645 sg13cmos5l_nor3_1_2.C a_4762_6886# 0.11588f
C2646 a_6645_5564# VPWR 0.09513f
C2647 sg13cmos5l_nor4_2_0.C a_23846_1632# 0.01467f
C2648 sg13cmos5l_xnor2_1_6.Y a_15930_1168# 0.01004f
C2649 sg13cmos5l_nor4_2_1.A sg13cmos5l_xnor2_1_3.B 0.03322f
C2650 a_21647_3971# a_21904_4114# 0.40419f
C2651 a_15972_6172# VPWR 0.07225f
C2652 a_4640_1919# VPWR 0.45352f
C2653 sg13cmos5l_dlygate4sd3_1_22.X a_2054_874# 0.01157f
C2654 sg13cmos5l_buf_1_0.A a_3590_3894# 0.03106f
C2655 sg13cmos5l_buf_1_5.A sg13cmos5l_dlygate4sd3_1_52.A 1.11493f
C2656 a_25738_4624# a_26181_4667# 0.02241f
C2657 a_10812_8041# a_11594_7960# 0.4806f
C2658 sg13cmos5l_xnor2_1_0.A sg13cmos5l_dfrbpq_1_55.D 0.03117f
C2659 sg13cmos5l_dfrbpq_1_55.RESET_B a_10791_3231# 0.55539f
C2660 a_10444_3582# a_10702_3582# 0.01017f
C2661 sg13cmos5l_buf_8_2.X a_23576_3185# 0.01159f
C2662 sg13cmos5l_buf_1_0.A sg13cmos5l_dfrbpq_1_55.RESET_B 0.01227f
C2663 a_8763_8434# sg13cmos5l_nor3_1_2.C 0.0349f
C2664 sg13cmos5l_buf_1_4.A sg13cmos5l_dlygate4sd3_1_16.A 0.89466f
C2665 a_21813_7076# VPWR 0.09474f
C2666 a_2920_6956# VPWR 0.32908f
C2667 a_23872_5704# VPWR 0.39111f
C2668 sg13cmos5l_buf_1_1.X a_19103_1603# 0.065f
C2669 a_13288_4742# VPWR 0.13985f
C2670 sg13cmos5l_xnor2_1_3.A a_18391_1596# 0.03394f
C2671 a_25679_2459# a_25936_2602# 0.40419f
C2672 a_24939_2504# a_24708_2395# 0.15089f
C2673 a_24420_2700# a_25585_2459# 0.4858f
C2674 a_7851_7691# a_8848_7922# 0.07014f
C2675 a_14657_4922# sg13cmos5l_xnor2_1_5.A 0.01132f
C2676 a_14379_2504# a_15119_2459# 0.3087f
C2677 sg13cmos5l_buf_1_1.X sg13cmos5l_nand3_1_0.Y 0.01205f
C2678 sg13cmos5l_buf_1_0.A a_27329_1898# 0.01147f
C2679 sg13cmos5l_dfrbpq_1_56.CLK a_15525_7691# 0.37802f
C2680 sg13cmos5l_buf_1_0.X sg13cmos5l_dfrbpq_1_46.CLK 0.49941f
C2681 sg13cmos5l_dfrbpq_1_21.RESET_B a_4358_5410# 0.02406f
C2682 sg13cmos5l_dfrbpq_1_55.Q sg13cmos5l_xnor2_1_5.A 0.04641f
C2683 sg13cmos5l_dlygate4sd3_1_6.X a_21904_5626# 0.0111f
C2684 sg13cmos5l_dlygate4sd3_1_5.A a_22138_1596# 0.51025f
C2685 sg13cmos5l_dlygate4sd3_1_4.X sg13cmos5l_nor4_2_7.D 0.01067f
C2686 sg13cmos5l_buf_1_4.A sg13cmos5l_dfrbpq_1_11.Q 3.65098f
C2687 a_21435_3514# a_22330_2350# 0.01342f
C2688 sg13cmos5l_nand3_1_0.A sg13cmos5l_dfrbpq_1_3.D 0.54773f
C2689 a_16164_5724# VPWR 0.07239f
C2690 a_5392_4114# VPWR 0.18764f
C2691 a_25899_7691# a_26896_7922# 0.07014f
C2692 sg13cmos5l_dfrbpq_1_53.RESET_B sg13cmos5l_dlygate4sd3_1_17.X 0.16602f
C2693 a_25797_7691# a_26545_8041# 0.01058f
C2694 a_5471_1603# a_6167_1679# 0.02453f
C2695 sg13cmos5l_dlygate4sd3_1_28.X sg13cmos5l_dfrbpq_1_56.D 0.21116f
C2696 sg13cmos5l_and2_1_3.A a_10812_6529# 0.01501f
C2697 a_17231_6529# a_17137_6529# 0.32273f
C2698 sg13cmos5l_xnor2_1_2.B a_16563_1632# 0.01001f
C2699 a_8576_3230# VPWR 0.07263f
C2700 sg13cmos5l_nor4_2_4.D a_17233_6995# 0.01329f
C2701 sg13cmos5l_dfrbpq_1_55.Q a_13472_1718# 0.01341f
C2702 sg13cmos5l_dlygate4sd3_1_5.A sg13cmos5l_nand3_1_0.A 0.25125f
C2703 a_18874_8398# a_19256_8434# 0.09023f
C2704 sg13cmos5l_dfrbpq_1_57.RESET_B a_15627_7691# 0.55134f
C2705 sg13cmos5l_xor2_1_2.A sg13cmos5l_buf_1_5.A 0.02421f
C2706 a_7103_4164# a_7893_4052# 0.02241f
C2707 a_6391_3858# a_6862_3894# 0.32273f
C2708 sg13cmos5l_dlygate4sd3_1_4.A VPWR 0.8661f
C2709 sg13cmos5l_dlygate4sd3_1_28.X a_10812_6529# 0.02683f
C2710 sg13cmos5l_nor4_2_5.C a_5135_8507# 0.01636f
C2711 sg13cmos5l_and2_1_1.X a_23835_8050# 0.60214f
C2712 sg13cmos5l_dfrbpq_1_37.D sg13cmos5l_dfrbpq_1_53.CLK 0.02859f
C2713 a_16683_5528# a_17423_5483# 0.3087f
C2714 sg13cmos5l_nor4_2_7.D sg13cmos5l_nor4_2_7.B 0.02157f
C2715 sg13cmos5l_nor4_2_4.D sg13cmos5l_nor3_1_4.B 0.02962f
C2716 sg13cmos5l_dlygate4sd3_1_10.A a_23576_3185# 0.52174f
C2717 sg13cmos5l_buf_8_3.A a_10231_3108# 0.01477f
C2718 a_6795_7040# VPWR 0.20633f
C2719 sg13cmos5l_dlygate4sd3_1_47.A sg13cmos5l_dlygate4sd3_1_4.X 3.39975f
C2720 sg13cmos5l_xnor2_1_3.A a_28374_1656# 0.01253f
C2721 a_14364_1993# a_14495_1603# 0.48921f
C2722 sg13cmos5l_dfrbpq_1_55.D a_16666_2350# 0.05672f
C2723 a_17898_6168# VPWR 0.4536f
C2724 a_14822_8118# VPWR 0.92814f
C2725 sg13cmos5l_nor3_1_1.Y sg13cmos5l_dfrbpq_1_55.D 0.21258f
C2726 a_11733_3191# a_11639_3191# 0.87117f
C2727 sg13cmos5l_and2_1_1.X a_23846_4656# 0.06344f
C2728 sg13cmos5l_buf_1_4.A sg13cmos5l_buf_1_4.X 3.94006f
C2729 sg13cmos5l_dfrbpq_1_56.Q a_14824_5538# 0.07245f
C2730 a_25764_4660# a_27023_5017# 0.01741f
C2731 sg13cmos5l_buf_1_0.A sg13cmos5l_nor4_2_5.C 0.64541f
C2732 sg13cmos5l_dfrbpq_1_23.Q a_3896_6209# 0.01041f
C2733 sg13cmos5l_nand3_1_1.B a_16167_4743# 0.01427f
C2734 a_23368_7050# VPWR 0.15675f
C2735 a_6272_1045# a_6604_870# 0.1396f
C2736 sg13cmos5l_dfrbpq_1_2.CLK sg13cmos5l_nand3_1_0.A 0.06929f
C2737 a_15127_8394# a_15340_8430# 0.40419f
C2738 sg13cmos5l_dfrbpq_1_2.D a_21270_2680# 0.08599f
C2739 sg13cmos5l_dfrbpq_1_53.CLK a_26181_4667# 0.35462f
C2740 sg13cmos5l_dfrbpq_1_56.CLK a_15627_7691# 0.04087f
C2741 sg13cmos5l_nor4_2_9.D sg13cmos5l_and2_1_3.A 0.12999f
C2742 a_7535_6995# a_7792_7138# 0.40419f
C2743 sg13cmos5l_xnor2_1_6.B a_1395_1168# 0.01343f
C2744 a_8960_4026# VPWR 0.06791f
C2745 sg13cmos5l_nor3_1_0.C a_25478_5094# 0.01163f
C2746 sg13cmos5l_nand3_1_1.A en[4] 0.05136f
C2747 a_18090_5704# VPWR 0.45336f
C2748 sg13cmos5l_dfrbpq_1_56.RESET_B sg13cmos5l_dfrbpq_1_53.RESET_B 0.11722f
C2749 sg13cmos5l_xnor2_1_4.A sg13cmos5l_nand3_1_2.C 1.45201f
C2750 sg13cmos5l_dfrbpq_1_21.RESET_B sg13cmos5l_buf_8_5.A 0.04025f
C2751 sg13cmos5l_nand3_1_2.C a_24902_3894# 0.04531f
C2752 a_6250_7141# a_6276_7236# 0.43042f
C2753 a_6154_6136# VPWR 0.09511f
C2754 sg13cmos5l_nor4_2_5.B a_5990_6918# 0.29664f
C2755 sg13cmos5l_dfrbpq_1_23.Q sg13cmos5l_dfrbpq_1_16.Q 0.32491f
C2756 a_25764_8748# a_26181_8409# 0.48921f
C2757 a_25478_8430# a_26283_8552# 0.11742f
C2758 a_15108_7684# a_15525_7691# 0.49014f
C2759 a_5230_7107# sg13cmos5l_nor4_2_5.B 0.02528f
C2760 sg13cmos5l_dlygate4sd3_1_10.A a_23576_3898# 0.04518f
C2761 sg13cmos5l_dfrbpq_1_21.RESET_B a_7103_8700# 0.08095f
C2762 sg13cmos5l_dfrbpq_1_57.RESET_B sg13cmos5l_dlygate4sd3_1_57.A 0.18548f
C2763 sg13cmos5l_dfrbpq_1_57.RESET_B a_10827_5528# 0.57151f
C2764 sg13cmos5l_nor3_1_0.C sg13cmos5l_buf_1_4.X 0.72643f
C2765 sg13cmos5l_xnor2_1_4.B sg13cmos5l_nor4_2_0.B 0.0618f
C2766 a_26704_4114# a_27114_4192# 0.1396f
C2767 sg13cmos5l_dfrbpq_1_22.D a_13860_3148# 0.02542f
C2768 sg13cmos5l_buf_8_4.A sg13cmos5l_dlygate4sd3_1_53.A 0.12755f
C2769 a_20871_7136# a_20805_6179# 0.0167f
C2770 sg13cmos5l_dlygate4sd3_1_17.A a_27195_3514# 0.05582f
C2771 sg13cmos5l_dlygate4sd3_1_17.X sg13cmos5l_xnor2_1_3.A 0.21937f
C2772 a_16581_5385# a_17329_5483# 0.01058f
C2773 sg13cmos5l_buf_8_10.A VPWR 2.00531f
C2774 sg13cmos5l_xnor2_1_4.A a_25360_7138# 0.02031f
C2775 a_14277_3155# a_15025_3505# 0.01058f
C2776 sg13cmos5l_nor3_1_2.C sg13cmos5l_nor4_2_5.B 0.11775f
C2777 a_5894_6606# a_6597_6179# 0.02431f
C2778 a_14186_7680# VPWR 0.23173f
C2779 a_24261_6897# a_24363_7040# 0.66105f
C2780 a_1784_874# VPWR 0.35502f
C2781 a_5345_7108# VPWR 0.2431f
C2782 a_4380_2346# a_4270_2382# 0.4858f
C2783 sg13cmos5l_nor3_1_0.C a_19055_3971# 0.03861f
C2784 a_27280_4898# a_27690_4656# 0.1396f
C2785 sg13cmos5l_dfrbpq_1_15.D a_2165_6922# 0.05686f
C2786 sg13cmos5l_dfrbpq_1_56.D a_14186_6168# 0.08479f
C2787 sg13cmos5l_nand3_1_1.A a_16188_5017# 0.01751f
C2788 sg13cmos5l_buf_1_4.A sg13cmos5l_dlygate4sd3_1_15.A 0.15877f
C2789 sg13cmos5l_xnor2_1_13.Y sg13cmos5l_nor3_1_2.Y 0.01407f
C2790 sg13cmos5l_xnor2_1_9.A sg13cmos5l_nor4_2_5.Y 0.22468f
C2791 sg13cmos5l_xnor2_1_4.Y a_25738_5629# 0.01392f
C2792 sg13cmos5l_dfrbpq_1_56.CLK sg13cmos5l_buf_1_2.A 0.13765f
C2793 sg13cmos5l_dfrbpq_1_57.RESET_B a_10231_6132# 0.28622f
C2794 sg13cmos5l_dfrbpq_1_53.RESET_B a_25777_6529# 0.01768f
C2795 sg13cmos5l_buf_1_4.A sg13cmos5l_dfrbpq_1_2.Q 2.4128f
C2796 sg13cmos5l_dlygate4sd3_1_6.X sg13cmos5l_dlygate4sd3_1_55.X 0.17243f
C2797 sg13cmos5l_dlygate4sd3_1_57.A sg13cmos5l_dfrbpq_1_56.CLK 0.15426f
C2798 sg13cmos5l_dlygate4sd3_1_51.X en[4] 0.01469f
C2799 sg13cmos5l_nor3_1_1.A VPWR 1.50382f
C2800 sg13cmos5l_and2_1_1.X sg13cmos5l_nor4_2_0.C 0.13505f
C2801 a_15041_1060# VPWR 0.24092f
C2802 a_7911_1719# a_8759_1679# 0.11742f
C2803 a_20362_5629# VPWR 0.09469f
C2804 sg13cmos5l_dlygate4sd3_1_17.A a_27598_4083# 0.04601f
C2805 sg13cmos5l_dfrbpq_1_57.Q a_9446_5410# 0.05712f
C2806 sg13cmos5l_dlygate4sd3_1_58.A sg13cmos5l_xnor2_1_5.Y 0.01913f
C2807 sg13cmos5l_xnor2_1_5.Y sg13cmos5l_dfrbpq_1_55.D 0.1746f
C2808 a_15525_7691# a_15396_8105# 0.01562f
C2809 a_15108_7684# a_15627_7691# 0.38871f
C2810 sg13cmos5l_xnor2_1_0.A a_1152_1185# 0.02927f
C2811 sg13cmos5l_dfrbpq_1_21.RESET_B a_7893_8588# 0.3206f
C2812 sg13cmos5l_dlygate4sd3_1_52.A a_10308_7236# 0.02152f
C2813 sg13cmos5l_dlygate4sd3_1_17.X sg13cmos5l_dlygate4sd3_1_9.A 0.79372f
C2814 a_3896_6209# VPWR 0.35842f
C2815 sg13cmos5l_dfrbpq_1_42.Q a_19638_8498# 0.04425f
C2816 sg13cmos5l_dlygate4sd3_1_52.A sg13cmos5l_dlygate4sd3_1_53.A 0.03586f
C2817 sg13cmos5l_dlygate4sd3_1_39.X a_26724_6931# 0.0146f
C2818 sg13cmos5l_xnor2_1_6.A a_1480_2514# 0.01225f
C2819 a_17132_3108# sg13cmos5l_dfrbpq_1_3.Q 0.03289f
C2820 sg13cmos5l_dfrbpq_1_13.CLK a_6167_1679# 0.03386f
C2821 a_16385_2572# VPWR 0.26715f
C2822 a_16320_1671# a_16469_2002# 0.3658f
C2823 a_28936_4742# a_29120_4742# 0.11523f
C2824 sg13cmos5l_dfrbpq_1_56.RESET_B a_15820_5094# 0.18782f
C2825 a_4730_6168# a_5036_6168# 0.42343f
C2826 sg13cmos5l_nor4_2_9.D a_5356_5406# 0.01001f
C2827 a_8235_2504# a_8975_2459# 0.3087f
C2828 sg13cmos5l_nor3_1_4.A sg13cmos5l_nor3_1_4.Y 0.0628f
C2829 a_28570_4620# a_28289_4922# 0.33585f
C2830 a_17034_7680# VPWR 0.45286f
C2831 a_10282_5629# VPWR 0.09605f
C2832 a_23844_7236# a_24132_6931# 0.4806f
C2833 a_5143_5370# a_5703_5624# 0.3087f
C2834 a_2166_938# VPWR 0.22927f
C2835 sg13cmos5l_dfrbpq_1_46.D a_20192_7967# 0.01586f
C2836 a_21813_7727# a_21719_7727# 0.87117f
C2837 a_18778_6132# VPWR 0.33093f
C2838 a_2266_1596# a_1985_1898# 0.33585f
C2839 sg13cmos5l_dlygate4sd3_1_39.X a_25052_8728# 0.01534f
C2840 sg13cmos5l_nor4_2_4.D sg13cmos5l_and2_1_4.X 0.01297f
C2841 a_26853_6897# VPWR 0.24937f
C2842 a_21023_7651# a_21674_7960# 0.01562f
C2843 a_15414_5474# sg13cmos5l_nor3_1_4.C 0.2294f
C2844 sg13cmos5l_dfrbpq_1_0.CLK a_25287_1719# 0.08657f
C2845 sg13cmos5l_buf_1_4.A sg13cmos5l_dlygate4sd3_1_2.A 0.02549f
C2846 a_27226_2350# a_27214_1899# 0.01006f
C2847 a_20892_8041# sg13cmos5l_xnor2_1_10.Y 0.01623f
C2848 sg13cmos5l_dlygate4sd3_1_6.X a_20388_4660# 0.02582f
C2849 a_23660_8728# VPWR 0.4126f
C2850 sg13cmos5l_dfrbpq_1_16.Q VPWR 0.71124f
C2851 sg13cmos5l_dfrbpq_1_57.RESET_B a_10791_6255# 0.57168f
C2852 sg13cmos5l_xnor2_1_0.Y sg13cmos5l_dfrbpq_1_12.D 0.06279f
C2853 a_20102_3894# VPWR 0.92534f
C2854 sg13cmos5l_dfrbpq_1_53.Q sg13cmos5l_buf_8_11.A 0.04176f
C2855 sg13cmos5l_dfrbpq_1_59.Q a_17100_2572# 0.03517f
C2856 sg13cmos5l_nor4_2_5.B a_5036_6168# 0.02974f
C2857 sg13cmos5l_dfrbpq_1_18.D a_8063_1603# 0.01052f
C2858 a_7103_8700# a_7754_8588# 0.01562f
C2859 sg13cmos5l_dlygate4sd3_1_6.X a_20388_4212# 0.02584f
C2860 a_24424_3230# VPWR 0.14357f
C2861 sg13cmos5l_dfrbpq_1_57.RESET_B sg13cmos5l_buf_8_9.A 0.01081f
C2862 sg13cmos5l_nand3_1_1.A a_16164_5724# 0.03349f
C2863 sg13cmos5l_and2_1_1.A sg13cmos5l_buf_2_0.X 0.01034f
C2864 sg13cmos5l_nor3_1_4.Y a_15333_4192# 0.02475f
C2865 a_28362_7216# sg13cmos5l_dlygate4sd3_1_4.A 0.1416f
C2866 a_4832_4943# a_4951_4620# 0.13494f
C2867 a_5802_8728# VPWR 0.45132f
C2868 a_27790_7947# a_27905_7946# 0.67711f
C2869 sg13cmos5l_and2_1_1.A sg13cmos5l_and2_1_0.X 0.02445f
C2870 a_3850_3112# a_3876_3148# 0.43042f
C2871 sg13cmos5l_dfrbpq_1_21.RESET_B a_4511_2652# 0.06716f
C2872 sg13cmos5l_nor3_1_4.B sg13cmos5l_dlygate4sd3_1_6.A 0.31826f
C2873 sg13cmos5l_nand3_1_1.B sg13cmos5l_nor3_1_4.C 0.02293f
C2874 sg13cmos5l_dlygate4sd3_1_57.A a_15108_7684# 0.03074f
C2875 a_15396_8105# a_15627_7691# 0.15089f
C2876 sg13cmos5l_xnor2_1_4.B a_25478_5406# 0.01578f
C2877 sg13cmos5l_dfrbpq_1_23.Q sg13cmos5l_dfrbpq_1_21.CLK 0.80883f
C2878 sg13cmos5l_dfrbpq_1_38.Q sg13cmos5l_dfrbpq_1_39.Q 0.03888f
C2879 sg13cmos5l_dfrbpq_1_56.RESET_B a_15946_6136# 0.34972f
C2880 a_18564_3148# a_19083_3155# 0.38871f
C2881 sg13cmos5l_xnor2_1_6.B a_7430_2382# 0.03492f
C2882 sg13cmos5l_dlygate4sd3_1_21.X a_7690_2605# 0.01986f
C2883 sg13cmos5l_xnor2_1_6.A a_7716_2700# 0.01626f
C2884 a_18981_3155# a_18852_3569# 0.01562f
C2885 sg13cmos5l_dfrbpq_1_3.Q a_18080_1718# 0.01371f
C2886 a_20388_4212# osc 0.01125f
C2887 sg13cmos5l_xnor2_1_6.B a_1870_1899# 0.20991f
C2888 sg13cmos5l_dlygate4sd3_1_4.X sg13cmos5l_dfrbpq_1_53.CLK 0.02236f
C2889 a_13783_1596# VPWR 0.1719f
C2890 sg13cmos5l_dfrbpq_1_21.CLK a_4395_3155# 0.04967f
C2891 sg13cmos5l_nor4_2_1.D a_20666_2680# 0.14904f
C2892 sg13cmos5l_dlygate4sd3_1_6.X a_23861_6538# 0.01384f
C2893 sg13cmos5l_nand3_1_1.A a_14822_8118# 0.01185f
C2894 sg13cmos5l_dlygate4sd3_1_18.X a_10022_870# 0.34096f
C2895 sg13cmos5l_dfrbpq_1_46.D a_21719_7727# 0.01203f
C2896 sg13cmos5l_buf_8_0.X a_15488_4943# 0.0132f
C2897 a_9640_7680# en[1] 0.32178f
C2898 a_6597_6179# a_7345_6529# 0.01058f
C2899 a_20000_6254# VPWR 0.07933f
C2900 sg13cmos5l_buf_1_0.A a_19103_1603# 0.01786f
C2901 sg13cmos5l_buf_1_2.A sg13cmos5l_nor3_1_0.A 0.57434f
C2902 a_4366_7107# a_4481_7108# 0.67711f
C2903 sg13cmos5l_nor3_1_1.A a_16385_2572# 0.03067f
C2904 sg13cmos5l_nor4_2_9.D a_4160_7050# 0.01243f
C2905 a_11567_5483# VPWR 0.17376f
C2906 a_28362_7216# VPWR 0.45233f
C2907 sg13cmos5l_dfrbpq_1_56.RESET_B sg13cmos5l_xnor2_1_5.Y 0.01889f
C2908 sg13cmos5l_nand3_1_2.A a_24363_7040# 0.02663f
C2909 sg13cmos5l_xnor2_1_10.Y sg13cmos5l_and2_1_1.X 0.08042f
C2910 sg13cmos5l_buf_1_0.A sg13cmos5l_nand3_1_0.Y 0.03871f
C2911 sg13cmos5l_dfrbpq_1_12.Q a_14379_2504# 0.02262f
C2912 sg13cmos5l_dfrbpq_1_56.CLK a_16068_7236# 0.15536f
C2913 a_8842_6886# a_9176_6209# 0.01537f
C2914 sg13cmos5l_dlygate4sd3_1_6.X a_20907_4667# 0.02774f
C2915 a_11567_8507# VPWR 0.17167f
C2916 sg13cmos5l_buf_1_4.X a_18315_4016# 0.55275f
C2917 sg13cmos5l_dfrbpq_1_53.CLK sg13cmos5l_nor4_2_7.B 0.08737f
C2918 sg13cmos5l_nor3_1_2.Y sg13cmos5l_nor4_2_9.D 0.01262f
C2919 sg13cmos5l_nand3_1_1.A VPWR 0.48647f
C2920 a_25188_4212# VPWR 0.0721f
C2921 sg13cmos5l_dfrbpq_1_57.Q sg13cmos5l_dfrbpq_1_17.Q 0.02186f
C2922 a_25439_1603# VPWR 0.24266f
C2923 sg13cmos5l_dfrbpq_1_56.RESET_B a_15878_5406# 0.1235f
C2924 sg13cmos5l_dlygate4sd3_1_22.X a_7932_1993# 0.03697f
C2925 a_920_1673# VPWR 0.35669f
C2926 sg13cmos5l_buf_8_9.A a_8776_5444# 0.02037f
C2927 a_3488_2514# VPWR 0.0764f
C2928 sg13cmos5l_dlygate4sd3_1_58.A sg13cmos5l_dfrbpq_1_23.D 0.02565f
C2929 sg13cmos5l_dlygate4sd3_1_6.X sg13cmos5l_buf_8_2.X 0.03569f
C2930 a_27608_2386# a_27878_2386# 0.33585f
C2931 sg13cmos5l_xnor2_1_6.B a_7799_1261# 0.30334f
C2932 a_10308_1636# a_10596_2057# 0.4806f
C2933 sg13cmos5l_nand3_1_1.B sg13cmos5l_xnor2_1_5.A 3.13495f
C2934 a_18315_4016# a_19055_3971# 0.3087f
C2935 sg13cmos5l_xnor2_1_3.B sg13cmos5l_nand3_1_0.A 0.03296f
C2936 sg13cmos5l_nor4_2_5.B sg13cmos5l_dfrbpq_1_58.D 0.07844f
C2937 sg13cmos5l_dlygate4sd3_1_34.A VPWR 0.52691f
C2938 a_4395_3155# sg13cmos5l_xnor2_1_6.A 0.02018f
C2939 sg13cmos5l_dfrbpq_1_57.CLK a_10812_5017# 0.09924f
C2940 sg13cmos5l_dlygate4sd3_1_57.A a_15396_8105# 0.01849f
C2941 sg13cmos5l_buf_1_0.X a_20192_7093# 0.02305f
C2942 a_16367_8041# a_16273_8041# 0.32273f
C2943 a_25605_3873# osc 0.01072f
C2944 sg13cmos5l_dfrbpq_1_57.CLK a_10725_6897# 0.41277f
C2945 sg13cmos5l_dfrbpq_1_56.RESET_B a_17231_6529# 0.20999f
C2946 sg13cmos5l_dlygate4sd3_1_28.A a_9176_6209# 0.5076f
C2947 sg13cmos5l_buf_8_2.X osc 0.02453f
C2948 sg13cmos5l_dfrbpq_1_58.RESET_B a_5663_4627# 0.05483f
C2949 sg13cmos5l_dfrbpq_1_13.CLK a_10827_1643# 0.01927f
C2950 sg13cmos5l_nor3_1_4.B sg13cmos5l_nor3_1_4.Y 0.33156f
C2951 sg13cmos5l_nand3_1_1.A sg13cmos5l_buf_8_10.A 0.1893f
C2952 a_10943_7651# a_10725_6897# 0.01287f
C2953 a_25029_6179# VPWR 0.24509f
C2954 sg13cmos5l_xor2_1_2.B a_13642_5374# 0.06793f
C2955 a_20805_5385# a_20907_5528# 0.66105f
C2956 sg13cmos5l_xnor2_1_4.B a_28524_3410# 0.42466f
C2957 a_26436_7236# a_26955_7040# 0.38902f
C2958 sg13cmos5l_buf_1_2.A sg13cmos5l_nand3_1_1.B 0.04728f
C2959 sg13cmos5l_nand3_1_1.A a_14186_7680# 0.41202f
C2960 sg13cmos5l_dlygate4sd3_1_40.A a_26436_7236# 0.02679f
C2961 a_6972_834# VPWR 0.0721f
C2962 a_20805_8409# a_21023_7651# 0.03649f
C2963 sg13cmos5l_buf_8_0.X a_16167_4743# 0.04426f
C2964 a_7439_6529# a_8106_6168# 0.13494f
C2965 a_7696_6410# a_7345_6529# 0.01017f
C2966 sg13cmos5l_dlygate4sd3_1_50.A VPWR 1.01039f
C2967 sg13cmos5l_dlygate4sd3_1_19.X a_3590_3894# 0.03117f
C2968 a_14816_8562# VPWR 0.06625f
C2969 a_17914_7644# VPWR 0.33299f
C2970 sg13cmos5l_nor4_2_0.C sg13cmos5l_nor4_2_0.D 0.12896f
C2971 sg13cmos5l_dfrbpq_1_21.RESET_B sg13cmos5l_dfrbpq_1_32.CLK 1.46922f
C2972 a_13642_5374# a_13862_4656# 0.0168f
C2973 sg13cmos5l_dlygate4sd3_1_51.X VPWR 0.92354f
C2974 sg13cmos5l_dlygate4sd3_1_16.A a_24170_1168# 0.03475f
C2975 sg13cmos5l_dfrbpq_1_58.Q sg13cmos5l_buf_8_5.A 0.02441f
C2976 a_1784_3185# VPWR 0.32637f
C2977 sg13cmos5l_dfrbpq_1_29.Q VPWR 0.99061f
C2978 sg13cmos5l_dfrbpq_1_13.RESET_B a_7932_1993# 0.47034f
C2979 a_24881_8484# sg13cmos5l_nand3_1_2.A 0.01286f
C2980 a_4202_4656# sg13cmos5l_nand3_1_3.Y 0.01001f
C2981 sg13cmos5l_xnor2_1_2.B sg13cmos5l_xnor2_1_2.Y 0.06303f
C2982 sg13cmos5l_dfrbpq_1_23.Q sg13cmos5l_dlygate4sd3_1_19.A 0.22322f
C2983 sg13cmos5l_dlygate4sd3_1_39.X a_24881_8484# 0.40048f
C2984 a_3304_4026# a_3488_4026# 0.11523f
C2985 a_3850_4117# a_4293_3873# 0.02241f
C2986 a_9642_2680# VPWR 0.47822f
C2987 sg13cmos5l_dfrbpq_1_56.RESET_B a_17680_5626# 0.20001f
C2988 sg13cmos5l_nand3_1_2.A sg13cmos5l_nand3_1_2.Y 0.82823f
C2989 sg13cmos5l_dfrbpq_1_21.CLK VPWR 2.39473f
C2990 sg13cmos5l_dlygate4sd3_1_23.X sg13cmos5l_nand3_1_3.Y 0.01351f
C2991 a_20362_4117# a_20805_3873# 0.02241f
C2992 sg13cmos5l_dlygate4sd3_1_19.A a_4395_3155# 0.01121f
C2993 sg13cmos5l_buf_1_1.X a_20388_4212# 0.50067f
C2994 sg13cmos5l_buf_8_4.A sg13cmos5l_dfrbpq_1_57.RESET_B 0.0355f
C2995 a_13642_5374# a_13472_5538# 0.03811f
C2996 a_1384_8468# sg13cmos5l_dlygate4sd3_1_35.A 0.03445f
C2997 sg13cmos5l_dfrbpq_1_13.RESET_B sg13cmos5l_dfrbpq_1_13.Q 0.02186f
C2998 sg13cmos5l_buf_1_4.A a_21354_1168# 0.01069f
C2999 a_19142_870# a_19845_849# 0.02453f
C3000 sg13cmos5l_nor4_2_3.Y a_7532_3144# 0.04872f
C3001 a_10112_3431# a_10231_3108# 0.13494f
C3002 sg13cmos5l_dlygate4sd3_1_21.X a_7744_3144# 0.01199f
C3003 sg13cmos5l_xnor2_1_9.A sg13cmos5l_nor3_1_2.Y 1.87628f
C3004 sg13cmos5l_dlygate4sd3_1_10.A osc 0.01626f
C3005 a_17633_7946# sg13cmos5l_buf_1_2.A 0.01277f
C3006 sg13cmos5l_dfrbpq_1_52.Q a_17633_7946# 0.01996f
C3007 sg13cmos5l_dfrbpq_1_11.CLK a_13834_2605# 0.02763f
C3008 a_24900_3148# a_25188_3569# 0.4806f
C3009 sg13cmos5l_dlygate4sd3_1_19.A a_4640_1919# 0.03529f
C3010 a_20362_6136# a_20388_6172# 0.43042f
C3011 sg13cmos5l_dlygate4sd3_1_6.X a_22314_8728# 0.01515f
C3012 sg13cmos5l_buf_1_1.X a_18272_1919# 0.01305f
C3013 a_18951_1719# a_19754_1912# 0.15089f
C3014 a_10725_5385# a_10827_5528# 0.66105f
C3015 a_20102_8430# a_20805_8409# 0.02453f
C3016 sg13cmos5l_dlygate4sd3_1_40.A en[3] 0.01001f
C3017 a_24420_2700# a_24939_2504# 0.38902f
C3018 a_26538_6168# VPWR 0.45354f
C3019 a_20388_5724# a_20676_5419# 0.4806f
C3020 sg13cmos5l_dfrbpq_1_15.D a_3488_4026# 0.07047f
C3021 a_26955_7040# a_27952_7138# 0.06746f
C3022 sg13cmos5l_dlygate4sd3_1_58.A sg13cmos5l_nand3_1_1.Y 0.02189f
C3023 sg13cmos5l_buf_1_4.A a_10827_992# 0.01885f
C3024 sg13cmos5l_xnor2_1_0.Y sg13cmos5l_dlygate4sd3_1_18.X 0.02464f
C3025 sg13cmos5l_dlygate4sd3_1_0.X a_28758_938# 0.01442f
C3026 a_25770_7216# sg13cmos5l_dlygate4sd3_1_9.X 0.0358f
C3027 sg13cmos5l_xnor2_1_5.Y a_17135_2386# 0.04203f
C3028 sg13cmos5l_xnor2_1_6.A VPWR 2.45149f
C3029 sg13cmos5l_dlygate4sd3_1_52.X sg13cmos5l_dfrbpq_1_57.Q 0.73808f
C3030 sg13cmos5l_dfrbpq_1_21.RESET_B a_7103_4164# 0.06111f
C3031 sg13cmos5l_dfrbpq_1_21.RESET_B a_4876_8118# 0.18254f
C3032 sg13cmos5l_dfrbpq_1_21.RESET_B a_3304_8562# 0.02129f
C3033 sg13cmos5l_nor4_2_5.C a_3590_8430# 0.01375f
C3034 sg13cmos5l_dfrbpq_1_53.RESET_B a_10791_7767# 0.0181f
C3035 sg13cmos5l_buf_8_4.A a_8776_5444# 0.01003f
C3036 a_22314_4192# sg13cmos5l_dlygate4sd3_1_15.A 0.15461f
C3037 sg13cmos5l_dfrbpq_1_56.RESET_B a_17329_5483# 0.02105f
C3038 sg13cmos5l_buf_8_2.X sg13cmos5l_buf_1_1.X 0.27197f
C3039 a_13664_1919# a_13996_2070# 0.1396f
C3040 sg13cmos5l_nand3_1_2.C a_26128_6410# 0.01102f
C3041 sg13cmos5l_nor4_2_1.A a_18826_4620# 0.02f
C3042 sg13cmos5l_dfrbpq_1_57.RESET_B sg13cmos5l_dlygate4sd3_1_52.A 1.57671f
C3043 a_25605_3873# a_25317_3155# 0.04082f
C3044 sg13cmos5l_buf_8_3.A a_13834_2605# 0.01765f
C3045 a_10812_3505# a_11639_3191# 0.50066f
C3046 sg13cmos5l_dlygate4sd3_1_18.X sg13cmos5l_xnor2_1_6.Y 0.0121f
C3047 sg13cmos5l_buf_8_2.X a_25317_3155# 0.01264f
C3048 a_24608_1919# VPWR 0.45216f
C3049 sg13cmos5l_nand3_1_3.Y sg13cmos5l_dfrbpq_1_12.D 0.01569f
C3050 sg13cmos5l_buf_8_4.A a_8763_8434# 0.58372f
C3051 sg13cmos5l_nor4_2_7.D en[4] 0.16734f
C3052 sg13cmos5l_xnor2_1_3.B a_18278_3582# 0.02092f
C3053 a_20388_6172# a_20907_6179# 0.38871f
C3054 a_20805_6179# a_20676_6593# 0.01562f
C3055 sg13cmos5l_dfrbpq_1_53.RESET_B a_23835_8050# 0.02729f
C3056 a_4359_1088# a_5162_1028# 0.15089f
C3057 a_4511_1140# a_4270_870# 0.01058f
C3058 a_10725_5385# a_10596_5419# 0.01562f
C3059 sg13cmos5l_dfrbpq_1_38.Q sg13cmos5l_buf_8_0.X 0.01027f
C3060 sg13cmos5l_buf_1_0.X a_20871_7136# 0.57411f
C3061 sg13cmos5l_dfrbpq_1_56.RESET_B a_16367_8041# 0.0632f
C3062 sg13cmos5l_dfrbpq_1_32.CLK a_7754_8588# 0.01476f
C3063 sg13cmos5l_nor4_2_9.D a_4278_6192# 0.05089f
C3064 a_10112_6455# a_10231_6132# 0.13494f
C3065 a_2259_4192# VPWR 0.01044f
C3066 sg13cmos5l_dfrbpq_1_58.D a_4470_5474# 0.21829f
C3067 a_19246_6435# a_19361_6434# 0.67711f
C3068 a_15496_7050# VPWR 0.13113f
C3069 sg13cmos5l_dlygate4sd3_1_19.A VPWR 0.55484f
C3070 sg13cmos5l_nand3_1_0.Y sg13cmos5l_nor3_1_0.Y 0.05831f
C3071 sg13cmos5l_dfrbpq_1_11.CLK VPWR 6.32765f
C3072 sg13cmos5l_dlygate4sd3_1_55.A sg13cmos5l_nand3_1_2.Y 0.70329f
C3073 sg13cmos5l_dfrbpq_1_57.RESET_B sg13cmos5l_xor2_1_2.A 0.1663f
C3074 a_6972_3858# a_7754_4052# 0.4806f
C3075 sg13cmos5l_nand3_1_2.A sg13cmos5l_dlygate4sd3_1_9.X 0.02025f
C3076 a_28174_8619# VPWR 0.21247f
C3077 a_24902_3894# a_25605_3873# 0.02453f
C3078 sg13cmos5l_dlygate4sd3_1_18.X a_9446_3144# 0.04391f
C3079 sg13cmos5l_xnor2_1_4.A sg13cmos5l_buf_8_2.X 0.05077f
C3080 sg13cmos5l_dfrbpq_1_56.RESET_B sg13cmos5l_nand3_1_1.Y 0.01406f
C3081 a_18144_4695# sg13cmos5l_xnor2_1_3.B 0.22677f
C3082 sg13cmos5l_dfrbpq_1_55.RESET_B sg13cmos5l_dfrbpq_1_11.Q 0.01076f
C3083 a_25287_1719# a_26090_1912# 0.15089f
C3084 sg13cmos5l_dlygate4sd3_1_2.A a_27195_3514# 0.06941f
C3085 sg13cmos5l_dfrbpq_1_16.Q sg13cmos5l_dfrbpq_1_21.CLK 0.5914f
C3086 a_15340_8430# a_15598_8430# 0.01017f
C3087 sg13cmos5l_buf_1_4.A a_25066_1093# 0.016f
C3088 a_3799_2346# a_4012_2382# 0.40419f
C3089 sg13cmos5l_buf_8_10.A a_15496_7050# 0.01253f
C3090 a_19428_1188# a_19716_883# 0.4806f
C3091 sg13cmos5l_buf_8_0.X sg13cmos5l_nor3_1_4.C 0.05945f
C3092 sg13cmos5l_dlygate4sd3_1_52.X a_13472_6254# 0.03302f
C3093 sg13cmos5l_buf_8_5.A a_3304_5538# 0.0111f
C3094 sg13cmos5l_buf_1_11.A a_2920_8468# 0.34444f
C3095 sg13cmos5l_dfrbpq_1_53.RESET_B a_7749_7691# 0.01264f
C3096 a_5663_4627# a_6314_4936# 0.01562f
C3097 sg13cmos5l_xnor2_1_6.Y a_11567_947# 0.01059f
C3098 sg13cmos5l_nor3_1_0.C a_18564_3148# 0.01667f
C3099 sg13cmos5l_buf_1_0.A a_10308_1636# 0.01467f
C3100 a_20907_6179# a_21904_6410# 0.07014f
C3101 sg13cmos5l_dfrbpq_1_53.RESET_B a_25797_7691# 0.136f
C3102 a_11824_5626# a_11473_5483# 0.01017f
C3103 sg13cmos5l_dlygate4sd3_1_9.X a_24326_6606# 0.01838f
C3104 a_24780_5596# sg13cmos5l_nand3_1_2.Y 0.12665f
C3105 sg13cmos5l_buf_1_0.X a_23818_7141# 0.34536f
C3106 sg13cmos5l_dlygate4sd3_1_51.X a_20000_6254# 0.06909f
C3107 sg13cmos5l_buf_1_0.X sg13cmos5l_nand3_1_2.B 0.09856f
C3108 a_10231_6132# a_10702_6606# 0.32273f
C3109 sg13cmos5l_buf_8_3.A VPWR 2.56994f
C3110 a_27418_6132# VPWR 0.33169f
C3111 sg13cmos5l_dfrbpq_1_53.RESET_B a_25764_4660# 0.5015f
C3112 sg13cmos5l_and2_1_1.X sg13cmos5l_dfrbpq_1_0.CLK 0.02516f
C3113 sg13cmos5l_buf_1_4.X sg13cmos5l_dfrbpq_1_55.RESET_B 0.04135f
C3114 sg13cmos5l_dfrbpq_1_7.Q sg13cmos5l_dfrbpq_1_0.CLK 0.08433f
C3115 sg13cmos5l_buf_1_0.X a_23846_3144# 0.03423f
C3116 sg13cmos5l_nor4_2_5.C sg13cmos5l_xnor2_1_8.Y 0.23667f
C3117 sg13cmos5l_dfrbpq_1_2.D a_18372_2700# 0.05472f
C3118 sg13cmos5l_dfrbpq_1_54.Q VPWR 0.40506f
C3119 sg13cmos5l_dfrbpq_1_2.D a_18346_2605# 0.02545f
C3120 a_11639_7727# en[4] 0.01283f
C3121 a_9915_3898# sg13cmos5l_dlygate4sd3_1_18.X 0.02312f
C3122 sg13cmos5l_dlygate4sd3_1_6.A a_18789_2361# 0.04717f
C3123 sg13cmos5l_and2_1_1.A sg13cmos5l_dfrbpq_1_0.D 0.93709f
C3124 sg13cmos5l_dfrbpq_1_11.Q a_14926_1059# 0.01018f
C3125 a_2920_7680# VPWR 0.2907f
C3126 sg13cmos5l_buf_1_0.A sg13cmos5l_buf_8_5.A 0.41439f
C3127 a_11824_8650# a_11473_8507# 0.01017f
C3128 sg13cmos5l_dfrbpq_1_13.RESET_B sg13cmos5l_nor3_1_1.C 0.02452f
C3129 sg13cmos5l_dfrbpq_1_56.RESET_B sg13cmos5l_dfrbpq_1_56.D 0.23483f
C3130 sg13cmos5l_dfrbpq_1_22.D a_15376_3386# 0.01211f
C3131 sg13cmos5l_nor3_1_1.A sg13cmos5l_dfrbpq_1_11.CLK 0.91163f
C3132 sg13cmos5l_dfrbpq_1_13.RESET_B a_3692_4656# 0.02282f
C3133 sg13cmos5l_nor4_2_7.D a_23872_5704# 0.02181f
C3134 sg13cmos5l_buf_8_11.A a_27905_7946# 0.06382f
C3135 a_8582_4656# sg13cmos5l_nand3_1_3.Y 0.01274f
C3136 sg13cmos5l_dfrbpq_1_13.RESET_B a_5301_1028# 0.35399f
C3137 sg13cmos5l_dlygate4sd3_1_52.X a_10308_5724# 0.01205f
C3138 sg13cmos5l_buf_8_0.X sg13cmos5l_xnor2_1_5.A 0.07543f
C3139 a_2054_3144# a_2266_2350# 0.01425f
C3140 a_15119_3505# a_15025_3505# 0.32273f
C3141 a_24326_6606# a_25131_6179# 0.11742f
C3142 a_14054_8434# VPWR 0.23925f
C3143 sg13cmos5l_buf_1_2.A a_17584_7138# 0.02036f
C3144 a_6250_2350# a_7430_2382# 0.04744f
C3145 a_25380_7684# en[4] 0.01015f
C3146 sg13cmos5l_buf_1_2.A a_17036_1596# 0.33094f
C3147 a_4470_5474# a_5024_5581# 0.03282f
C3148 sg13cmos5l_nor4_2_5.D en[4] 0.02799f
C3149 a_20944_1090# a_21354_1168# 0.1396f
C3150 sg13cmos5l_nand3_1_2.A sg13cmos5l_xnor2_1_4.Y 0.14548f
C3151 sg13cmos5l_buf_1_4.A sg13cmos5l_nor3_1_0.B 0.98791f
C3152 a_6951_1088# a_7799_1261# 0.11742f
C3153 a_6391_834# a_6862_870# 0.32273f
C3154 a_15687_8648# a_15708_8394# 0.38871f
C3155 sg13cmos5l_dfrbpq_1_32.CLK a_6276_7236# 0.11639f
C3156 sg13cmos5l_buf_1_2.A sg13cmos5l_buf_8_0.X 0.0254f
C3157 a_21742_1899# VPWR 0.21765f
C3158 sg13cmos5l_buf_1_0.X a_23844_7236# 0.50416f
C3159 a_21647_8507# VPWR 0.17307f
C3160 sg13cmos5l_dfrbpq_1_0.CLK a_24837_2361# 0.37154f
C3161 a_17796_4212# VPWR 0.07291f
C3162 sg13cmos5l_dlygate4sd3_1_17.A sg13cmos5l_nand3_1_2.C 0.03238f
C3163 a_10812_6529# a_11733_6215# 0.43042f
C3164 sg13cmos5l_dfrbpq_1_18.D a_7932_1993# 0.02082f
C3165 sg13cmos5l_dlygate4sd3_1_39.X sg13cmos5l_dlygate4sd3_1_11.A 0.20677f
C3166 a_19754_1912# a_19799_1679# 0.36169f
C3167 sg13cmos5l_buf_8_5.A sg13cmos5l_dfrbpq_1_17.Q 0.10016f
C3168 sg13cmos5l_dlygate4sd3_1_17.A sg13cmos5l_dlygate4sd3_1_11.X 0.02065f
C3169 sg13cmos5l_xnor2_1_0.Y a_4380_2346# 0.01536f
C3170 sg13cmos5l_dfrbpq_1_53.RESET_B a_27023_5017# 0.19899f
C3171 sg13cmos5l_dlygate4sd3_1_9.X sg13cmos5l_dlygate4sd3_1_55.A 1.19164f
C3172 a_23368_2514# VPWR 0.15049f
C3173 sg13cmos5l_dfrbpq_1_13.RESET_B sg13cmos5l_dlygate4sd3_1_22.X 0.91878f
C3174 sg13cmos5l_dfrbpq_1_16.Q sg13cmos5l_dlygate4sd3_1_19.A 1.90662f
C3175 sg13cmos5l_dfrbpq_1_53.RESET_B a_20892_8041# 0.03656f
C3176 sg13cmos5l_nor3_1_1.Y a_7932_1993# 0.02698f
C3177 a_14360_3898# sg13cmos5l_xnor2_1_5.A 0.10207f
C3178 a_13745_3948# sg13cmos5l_dfrbpq_1_12.Q 0.03511f
C3179 sg13cmos5l_buf_8_3.A sg13cmos5l_nor3_1_1.A 0.22743f
C3180 sg13cmos5l_dlygate4sd3_1_6.X sg13cmos5l_dlygate4sd3_1_13.A 0.02073f
C3181 sg13cmos5l_xnor2_1_12.B a_1491_4656# 0.01371f
C3182 a_20666_2680# VPWR 0.21849f
C3183 a_4293_8409# VPWR 0.24352f
C3184 sg13cmos5l_dfrbpq_1_13.RESET_B a_15285_1679# 0.01168f
C3185 sg13cmos5l_xnor2_1_5.A sg13cmos5l_dfrbpq_1_3.Q 0.62112f
C3186 sg13cmos5l_nor3_1_1.A sg13cmos5l_dfrbpq_1_54.Q 0.01061f
C3187 sg13cmos5l_dfrbpq_1_18.D sg13cmos5l_dfrbpq_1_13.Q 0.52705f
C3188 a_8768_6427# sg13cmos5l_buf_8_9.A 0.13117f
C3189 sg13cmos5l_nor3_1_2.C sg13cmos5l_nor3_1_2.B 0.23132f
C3190 sg13cmos5l_xnor2_1_6.A a_920_1673# 0.03065f
C3191 a_15782_6918# a_16068_7236# 0.50066f
C3192 sg13cmos5l_buf_1_11.A sg13cmos5l_nor3_1_2.Y 0.02048f
C3193 a_17814_3168# sg13cmos5l_nor4_2_1.D 0.23124f
C3194 a_17432_3185# a_17702_3144# 0.33585f
C3195 a_18213_3873# osc 0.0107f
C3196 VPWR en[2] 0.45261f
C3197 a_29120_8562# VPWR 0.05508f
C3198 sg13cmos5l_dlygate4sd3_1_39.X a_27023_8507# 0.01096f
C3199 a_9920_1718# VPWR 0.06942f
C3200 a_9176_4697# sg13cmos5l_dlygate4sd3_1_22.X 0.01015f
C3201 sg13cmos5l_nor4_2_7.D VPWR 0.68702f
C3202 a_24612_6172# a_25777_6529# 0.4858f
C3203 a_24900_6593# a_25131_6179# 0.15089f
C3204 sg13cmos5l_nor3_1_0.C sg13cmos5l_nor3_1_0.B 0.24562f
C3205 sg13cmos5l_dfrbpq_1_53.CLK a_26283_5528# 0.03924f
C3206 a_18010_8398# sg13cmos5l_xnor2_1_2.B 0.0931f
C3207 sg13cmos5l_xnor2_1_2.A a_15686_6606# 0.02837f
C3208 sg13cmos5l_dfrbpq_1_46.D a_18922_7644# 0.06276f
C3209 sg13cmos5l_buf_1_0.X sg13cmos5l_nand3_1_2.C 0.01708f
C3210 sg13cmos5l_dfrbpq_1_56.RESET_B a_16587_7040# 0.55136f
C3211 sg13cmos5l_buf_1_2.A sg13cmos5l_dfrbpq_1_3.Q 0.25484f
C3212 sg13cmos5l_xnor2_1_0.Y a_10725_1643# 0.01164f
C3213 sg13cmos5l_nor4_2_9.D a_4088_5410# 0.02394f
C3214 sg13cmos5l_nor4_2_0.C sg13cmos5l_xnor2_1_3.A 0.01615f
C3215 sg13cmos5l_dlygate4sd3_1_16.A a_24416_1718# 0.01341f
C3216 sg13cmos5l_buf_1_0.A a_14495_1603# 0.01392f
C3217 a_24727_1596# a_25287_1719# 0.3087f
C3218 a_24940_2070# a_25198_2070# 0.01017f
C3219 sg13cmos5l_dfrbpq_1_11.CLK a_13783_1596# 0.04079f
C3220 sg13cmos5l_buf_8_5.A a_5143_5370# 0.01155f
C3221 a_10308_8748# VPWR 0.07371f
C3222 sg13cmos5l_xnor2_1_0.Y a_2054_3144# 0.06319f
C3223 a_21647_3971# VPWR 0.17598f
C3224 sg13cmos5l_nand3_1_0.B a_22049_1060# 0.01309f
C3225 sg13cmos5l_buf_1_4.X a_17702_3144# 0.08147f
C3226 sg13cmos5l_buf_1_0.X a_25360_7138# 0.17709f
C3227 sg13cmos5l_dlygate4sd3_1_47.A VPWR 0.69902f
C3228 a_10943_6139# a_11639_6215# 0.02453f
C3229 sg13cmos5l_dfrbpq_1_53.RESET_B sg13cmos5l_and2_1_1.X 0.01543f
C3230 a_24939_2504# VPWR 0.27263f
C3231 sg13cmos5l_buf_1_0.X a_23576_1673# 0.05946f
C3232 sg13cmos5l_dfrbpq_1_53.CLK en[4] 0.75922f
C3233 a_6165_7727# VPWR 0.09421f
C3234 a_18213_3873# a_18981_3155# 0.01209f
C3235 sg13cmos5l_dfrbpq_1_12.D sg13cmos5l_nor4_2_3.Y 0.18359f
C3236 a_3876_3148# a_4164_3569# 0.4806f
C3237 a_1784_3185# sg13cmos5l_xnor2_1_6.A 0.02327f
C3238 sg13cmos5l_buf_1_0.A a_27992_1673# 0.01198f
C3239 sg13cmos5l_nor4_2_5.C sg13cmos5l_dfrbpq_1_58.RESET_B 0.0166f
C3240 sg13cmos5l_nor4_2_0.B sg13cmos5l_nand3_1_0.B 0.17411f
C3241 sg13cmos5l_buf_1_1.X a_18789_2361# 0.07114f
C3242 a_20080_3386# a_20490_3144# 0.1396f
C3243 a_4544_7967# VPWR 0.4521f
C3244 sg13cmos5l_buf_1_0.X a_20388_5724# 0.47981f
C3245 sg13cmos5l_dfrbpq_1_21.CLK sg13cmos5l_xnor2_1_6.A 0.05594f
C3246 sg13cmos5l_dlygate4sd3_1_39.X a_26929_8507# 0.01812f
C3247 sg13cmos5l_dlygate4sd3_1_2.A a_27329_1898# 0.01226f
C3248 sg13cmos5l_dlygate4sd3_1_55.A sg13cmos5l_xnor2_1_4.Y 0.0495f
C3249 a_25871_6529# a_25777_6529# 0.32273f
C3250 a_24922_4620# VPWR 0.35414f
C3251 sg13cmos5l_dfrbpq_1_46.CLK a_18922_7644# 1.0519f
C3252 sg13cmos5l_buf_8_3.A a_13783_1596# 0.01929f
C3253 sg13cmos5l_dlygate4sd3_1_20.A a_7232_1919# 0.13292f
C3254 sg13cmos5l_dfrbpq_1_58.RESET_B a_5703_5624# 0.56018f
C3255 sg13cmos5l_dfrbpq_1_0.CLK sg13cmos5l_nor4_2_0.D 0.02696f
C3256 sg13cmos5l_nand3_1_2.B sg13cmos5l_buf_1_4.X 0.0179f
C3257 sg13cmos5l_dfrbpq_1_37.D sg13cmos5l_xnor2_1_4.A 1.10541f
C3258 sg13cmos5l_dlygate4sd3_1_31.X a_1664_6254# 0.01245f
C3259 a_26704_4114# VPWR 0.18772f
C3260 sg13cmos5l_dfrbpq_1_13.RESET_B a_4759_1596# 0.20033f
C3261 sg13cmos5l_dfrbpq_1_2.CLK a_19402_1093# 0.01773f
C3262 a_27695_6995# a_27963_6538# 0.0159f
C3263 sg13cmos5l_buf_1_0.A a_2816_7766# 0.05866f
C3264 a_11639_7727# VPWR 0.94287f
C3265 sg13cmos5l_dfrbpq_1_18.D a_9736_1718# 0.07407f
C3266 sg13cmos5l_dlygate4sd3_1_52.X sg13cmos5l_buf_8_5.A 0.10563f
C3267 sg13cmos5l_dfrbpq_1_57.RESET_B a_10444_8118# 0.23852f
C3268 a_11639_6215# sg13cmos5l_dlygate4sd3_1_52.X 0.0248f
C3269 a_18213_3873# sg13cmos5l_buf_1_1.X 0.0631f
C3270 a_19312_4114# a_19722_4192# 0.1396f
C3271 a_13288_3230# a_13288_2514# 0.01275f
C3272 sg13cmos5l_dfrbpq_1_21.RESET_B a_3876_3148# 0.5068f
C3273 sg13cmos5l_dlygate4sd3_1_52.A a_10112_6455# 0.01532f
C3274 sg13cmos5l_buf_1_1.X sg13cmos5l_dlygate4sd3_1_13.A 2.2638f
C3275 sg13cmos5l_xnor2_1_0.A sg13cmos5l_nor3_1_1.C 0.05226f
C3276 sg13cmos5l_dlygate4sd3_1_9.X sg13cmos5l_xnor2_1_4.B 0.02927f
C3277 a_24780_5596# sg13cmos5l_xnor2_1_4.Y 0.43698f
C3278 a_6604_8430# a_6951_8648# 0.07014f
C3279 sg13cmos5l_xnor2_1_12.B a_6359_4703# 0.04964f
C3280 sg13cmos5l_dfrbpq_1_21.CLK sg13cmos5l_dlygate4sd3_1_19.A 0.40243f
C3281 a_7332_7684# VPWR 0.0721f
C3282 sg13cmos5l_dfrbpq_1_2.D sg13cmos5l_dlygate4sd3_1_5.A 0.06724f
C3283 a_15127_8394# sg13cmos5l_dlygate4sd3_1_57.A 0.01279f
C3284 sg13cmos5l_dlygate4sd3_1_4.X osc 0.09651f
C3285 sg13cmos5l_dfrbpq_1_55.RESET_B a_11733_2540# 0.34672f
C3286 sg13cmos5l_dlygate4sd3_1_6.X a_20805_8409# 0.01707f
C3287 sg13cmos5l_dlygate4sd3_1_6.X sg13cmos5l_nor4_2_7.B 0.05835f
C3288 sg13cmos5l_xnor2_1_4.A a_26181_4667# 0.02002f
C3289 sg13cmos5l_xnor2_1_6.Y a_4380_834# 0.02699f
C3290 sg13cmos5l_xnor2_1_1.B VPWR 0.68083f
C3291 a_25380_7684# VPWR 0.0721f
C3292 sg13cmos5l_dfrbpq_1_53.RESET_B en[1] 0.04426f
C3293 sg13cmos5l_dlygate4sd3_1_4.X a_28758_938# 0.19612f
C3294 sg13cmos5l_nor4_2_5.D VPWR 0.53164f
C3295 a_17584_7138# a_17994_7216# 0.1396f
C3296 sg13cmos5l_buf_1_0.X a_21904_5626# 0.17711f
C3297 a_16485_6897# a_17233_6995# 0.01058f
C3298 a_15191_1679# VPWR 0.92863f
C3299 sg13cmos5l_dfrbpq_1_15.D sg13cmos5l_dfrbpq_1_23.Q 0.26761f
C3300 a_21023_7651# a_21023_7188# 0.03069f
C3301 sg13cmos5l_dfrbpq_1_32.CLK a_5135_8507# 0.01107f
C3302 a_4395_8552# a_5392_8650# 0.06746f
C3303 sg13cmos5l_buf_1_0.A sg13cmos5l_dlygate4sd3_1_0.X 0.02706f
C3304 a_20102_5094# a_20362_4624# 0.87117f
C3305 sg13cmos5l_dlygate4sd3_1_52.X a_13642_5374# 0.01561f
C3306 sg13cmos5l_buf_1_4.A a_9176_874# 0.01328f
C3307 a_25738_4624# VPWR 0.09429f
C3308 sg13cmos5l_nor4_2_0.D a_25092_1188# 0.03517f
C3309 sg13cmos5l_dlygate4sd3_1_34.A a_2920_7680# 0.01813f
C3310 a_3790_1899# a_3905_1898# 0.67711f
C3311 a_4640_1919# a_4972_2070# 0.1396f
C3312 sg13cmos5l_xnor2_1_4.B a_25131_6179# 0.04913f
C3313 a_3850_3112# VPWR 0.09677f
C3314 a_8312_4697# a_8582_4656# 0.33585f
C3315 a_10231_4620# a_10444_5094# 0.40419f
C3316 sg13cmos5l_buf_1_0.X a_20676_6593# 0.01056f
C3317 sg13cmos5l_dfrbpq_1_2.D sg13cmos5l_dfrbpq_1_2.CLK 0.2291f
C3318 sg13cmos5l_dfrbpq_1_13.RESET_B sg13cmos5l_xnor2_1_12.B 0.01339f
C3319 a_4293_3873# a_4395_4016# 0.66105f
C3320 a_10943_2652# VPWR 0.28563f
C3321 sg13cmos5l_buf_1_1.X a_21904_4114# 0.17693f
C3322 sg13cmos5l_dlygate4sd3_1_19.A sg13cmos5l_xnor2_1_6.A 0.01611f
C3323 a_2920_6956# sg13cmos5l_dfrbpq_1_15.D 0.02331f
C3324 a_11824_1874# a_11473_1993# 0.01017f
C3325 a_11567_1993# a_12234_1632# 0.13494f
C3326 sg13cmos5l_buf_1_0.A a_2266_7644# 0.0128f
C3327 a_10022_6918# a_10308_7236# 0.50066f
C3328 sg13cmos5l_nor4_2_0.B a_23872_1168# 0.05749f
C3329 sg13cmos5l_dfrbpq_1_2.D a_17770_4117# 0.01076f
C3330 sg13cmos5l_dfrbpq_1_22.Q a_9446_3144# 0.01793f
C3331 sg13cmos5l_dlygate4sd3_1_15.A a_23846_3144# 0.01093f
C3332 sg13cmos5l_nor3_1_1.Y sg13cmos5l_nor3_1_1.C 0.13823f
C3333 a_16188_5017# a_16970_4936# 0.4806f
C3334 sg13cmos5l_buf_1_0.A sg13cmos5l_xnor2_1_6.B 4.30898f
C3335 sg13cmos5l_dfrbpq_1_21.CLK sg13cmos5l_buf_8_3.A 0.01237f
C3336 sg13cmos5l_dfrbpq_1_23.Q a_5532_5017# 0.01741f
C3337 a_25419_3155# a_26159_3505# 0.3087f
C3338 a_6972_8394# a_7799_8821# 0.50066f
C3339 sg13cmos5l_dfrbpq_1_47.Q sg13cmos5l_dfrbpq_1_53.RESET_B 0.03054f
C3340 a_9258_7680# VPWR 0.45264f
C3341 a_14166_8498# a_14632_8562# 0.0311f
C3342 a_27306_7680# VPWR 0.4535f
C3343 sg13cmos5l_xnor2_1_2.A sg13cmos5l_nor3_1_4.C 0.21999f
C3344 sg13cmos5l_dfrbpq_1_53.CLK sg13cmos5l_dlygate4sd3_1_4.A 0.21083f
C3345 sg13cmos5l_nand3_1_2.C sg13cmos5l_buf_1_4.X 0.27984f
C3346 sg13cmos5l_dfrbpq_1_29.Q a_14054_8434# 0.01763f
C3347 sg13cmos5l_xnor2_1_10.Y a_21719_7309# 0.05241f
C3348 a_20102_5094# a_20676_5081# 0.36169f
C3349 a_10282_1093# VPWR 0.0947f
C3350 sg13cmos5l_nor3_1_4.B a_18363_6922# 0.01342f
C3351 sg13cmos5l_dfrbpq_1_57.CLK a_10827_5528# 0.05047f
C3352 sg13cmos5l_nor4_2_0.D a_27018_1168# 0.04103f
C3353 a_27280_4898# VPWR 0.18751f
C3354 sg13cmos5l_xnor2_1_4.B sg13cmos5l_xnor2_1_4.Y 0.31639f
C3355 a_3304_4026# VPWR 0.14147f
C3356 a_20524_8118# VPWR 0.18787f
C3357 a_11567_947# a_11473_947# 0.32273f
C3358 sg13cmos5l_xnor2_1_0.Y sg13cmos5l_dfrbpq_1_55.D 0.19614f
C3359 a_10112_3431# VPWR 0.45421f
C3360 sg13cmos5l_dfrbpq_1_53.Q sg13cmos5l_xnor2_1_4.Y 0.76455f
C3361 a_18826_4620# a_20102_5094# 0.0259f
C3362 a_10308_8748# a_11567_8507# 0.01741f
C3363 sg13cmos5l_dfrbpq_1_18.D sg13cmos5l_dlygate4sd3_1_22.X 0.01444f
C3364 a_6391_3858# a_6972_3858# 0.01741f
C3365 sg13cmos5l_dlygate4sd3_1_38.A a_5990_6918# 0.02493f
C3366 sg13cmos5l_dfrbpq_1_0.CLK a_25092_1188# 0.07644f
C3367 sg13cmos5l_dfrbpq_1_53.CLK VPWR 2.0049f
C3368 sg13cmos5l_dlygate4sd3_1_22.X sg13cmos5l_nor3_1_1.Y 1.91918f
C3369 sg13cmos5l_buf_8_3.A sg13cmos5l_xnor2_1_6.A 0.45832f
C3370 sg13cmos5l_dfrbpq_1_53.Q sg13cmos5l_dlygate4sd3_1_11.A 0.01946f
C3371 a_4972_2070# VPWR 0.18658f
C3372 sg13cmos5l_nor3_1_1.C a_11733_3191# 0.0129f
C3373 a_10791_3231# a_10943_3115# 0.66105f
C3374 sg13cmos5l_dlygate4sd3_1_22.X a_3680_1045# 0.01052f
C3375 a_16167_4743# a_17015_4703# 0.11742f
C3376 a_16319_4627# a_17109_4703# 0.02241f
C3377 sg13cmos5l_dfrbpq_1_15.D VPWR 2.38355f
C3378 sg13cmos5l_nand3_1_3.Y a_2054_3144# 0.01209f
C3379 sg13cmos5l_buf_1_1.X a_19845_849# 0.06907f
C3380 sg13cmos5l_xnor2_1_2.A sg13cmos5l_xnor2_1_5.A 0.01703f
C3381 sg13cmos5l_nor3_1_2.C sg13cmos5l_dlygate4sd3_1_38.A 0.80098f
C3382 sg13cmos5l_dfrbpq_1_23.Q a_5511_4743# 0.05306f
C3383 sg13cmos5l_buf_1_11.A en[0] 0.07616f
C3384 sg13cmos5l_xnor2_1_12.B a_7328_4742# 0.0126f
C3385 sg13cmos5l_buf_1_0.X sg13cmos5l_dlygate4sd3_1_55.X 0.56404f
C3386 sg13cmos5l_xnor2_1_3.A a_18972_1993# 0.03345f
C3387 sg13cmos5l_buf_1_4.A sg13cmos5l_nor3_1_0.A 0.62137f
C3388 a_25936_2602# a_26346_2680# 0.1396f
C3389 sg13cmos5l_dfrbpq_1_29.Q en[2] 0.63997f
C3390 sg13cmos5l_dfrbpq_1_58.RESET_B a_6597_6179# 0.11761f
C3391 a_13574_2382# a_14148_2395# 0.36169f
C3392 sg13cmos5l_dlygate4sd3_1_5.A a_21857_1898# 0.01647f
C3393 sg13cmos5l_nor4_2_0.B sg13cmos5l_dfrbpq_1_3.D 0.23403f
C3394 a_7893_4052# VPWR 0.09681f
C3395 sg13cmos5l_nand3_1_2.A a_24641_4922# 0.06145f
C3396 a_28570_4620# VPWR 0.33174f
C3397 a_13574_3582# VPWR 0.93369f
C3398 sg13cmos5l_xor2_1_2.A sg13cmos5l_dfrbpq_1_57.D 0.33295f
C3399 a_21023_7651# VPWR 0.24199f
C3400 sg13cmos5l_dfrbpq_1_13.RESET_B sg13cmos5l_dfrbpq_1_18.D 0.17005f
C3401 a_24806_870# a_25509_849# 0.02453f
C3402 a_10725_8409# a_11473_8507# 0.01058f
C3403 sg13cmos5l_xnor2_1_4.A sg13cmos5l_dlygate4sd3_1_4.X 0.15344f
C3404 sg13cmos5l_dfrbpq_1_13.RESET_B sg13cmos5l_nor3_1_1.Y 0.38621f
C3405 sg13cmos5l_dfrbpq_1_58.RESET_B a_6250_7141# 0.32854f
C3406 sg13cmos5l_xnor2_1_4.A a_27114_4192# 0.02124f
C3407 sg13cmos5l_buf_8_3.A sg13cmos5l_dfrbpq_1_11.CLK 0.26068f
C3408 sg13cmos5l_dfrbpq_1_22.D a_11594_3424# 0.01965f
C3409 sg13cmos5l_dlygate4sd3_1_38.A a_7792_7138# 0.01264f
C3410 sg13cmos5l_nor3_1_0.B a_24170_1168# 0.02259f
C3411 a_5532_5017# VPWR 0.0721f
C3412 sg13cmos5l_dfrbpq_1_13.RESET_B a_3680_1045# 0.01485f
C3413 sg13cmos5l_dfrbpq_1_21.RESET_B a_7649_4922# 0.06064f
C3414 a_13574_3582# a_14148_3569# 0.36169f
C3415 sg13cmos5l_dfrbpq_1_53.RESET_B sg13cmos5l_dfrbpq_1_0.CLK 0.01614f
C3416 sg13cmos5l_buf_1_5.A a_7594_5374# 0.02248f
C3417 a_18144_4695# a_18826_4620# 0.03979f
C3418 sg13cmos5l_dfrbpq_1_55.D sg13cmos5l_xnor2_1_2.Y 0.04873f
C3419 a_11824_7138# a_12234_7216# 0.1396f
C3420 sg13cmos5l_dfrbpq_1_13.Q a_4270_2382# 0.01553f
C3421 a_4359_2600# a_4380_2346# 0.38871f
C3422 a_4511_2652# a_5301_2540# 0.02241f
C3423 sg13cmos5l_nor3_1_0.C sg13cmos5l_nor3_1_0.A 0.669f
C3424 sg13cmos5l_dfrbpq_1_57.CLK a_10791_6255# 0.05332f
C3425 sg13cmos5l_xnor2_1_4.A sg13cmos5l_nor4_2_7.B 0.02851f
C3426 sg13cmos5l_nor4_2_4.D en[4] 0.02242f
C3427 sg13cmos5l_xnor2_1_2.A a_10231_6132# 0.01374f
C3428 sg13cmos5l_dfrbpq_1_2.Q a_23576_1673# 0.50723f
C3429 a_6391_834# a_6951_1088# 0.3087f
C3430 a_19142_870# VPWR 0.92863f
C3431 sg13cmos5l_dlygate4sd3_1_6.A a_20792_1673# 0.51771f
C3432 sg13cmos5l_buf_1_4.A a_26826_3144# 0.05383f
C3433 sg13cmos5l_nor4_2_0.B a_23958_1656# 0.05409f
C3434 sg13cmos5l_dfrbpq_1_58.RESET_B a_7696_6410# 0.1759f
C3435 a_20102_8430# VPWR 0.92718f
C3436 a_28186_7644# VPWR 0.333f
C3437 a_13384_4026# VPWR 0.18934f
C3438 sg13cmos5l_dfrbpq_1_18.D a_4759_1596# 0.01427f
C3439 a_21904_4898# a_21647_5017# 0.40419f
C3440 sg13cmos5l_dlygate4sd3_1_6.A sg13cmos5l_nor4_2_1.D 0.02782f
C3441 sg13cmos5l_dfrbpq_1_35.Q sg13cmos5l_xor2_1_2.A 0.07737f
C3442 a_17814_3168# VPWR 0.22099f
C3443 sg13cmos5l_buf_1_4.A a_13563_874# 0.03714f
C3444 sg13cmos5l_dfrbpq_1_37.D a_24586_6136# 0.03331f
C3445 sg13cmos5l_buf_1_5.A a_16683_5528# 0.01022f
C3446 sg13cmos5l_dfrbpq_1_0.D a_28506_2578# 0.1013f
C3447 sg13cmos5l_dfrbpq_1_22.D a_11488_4192# 0.0295f
C3448 sg13cmos5l_dlygate4sd3_1_22.X sg13cmos5l_nand3_1_3.B 0.67096f
C3449 sg13cmos5l_dfrbpq_1_53.CLK a_26853_6897# 0.35971f
C3450 a_27022_6435# a_27137_6434# 0.67711f
C3451 a_25611_992# a_26351_947# 0.3087f
C3452 a_27713_4084# a_27994_3862# 0.33585f
C3453 a_10791_4743# a_11594_4936# 0.15089f
C3454 a_5511_4743# VPWR 0.208f
C3455 sg13cmos5l_buf_8_11.A a_19609_6942# 0.01774f
C3456 a_8853_1679# VPWR 0.09508f
C3457 sg13cmos5l_dlygate4sd3_1_39.X a_25764_8748# 0.04088f
C3458 a_7430_2382# a_7716_2700# 0.50066f
C3459 sg13cmos5l_dfrbpq_1_13.CLK a_8235_2504# 0.01691f
C3460 a_7690_2605# a_8133_2361# 0.02241f
C3461 sg13cmos5l_dfrbpq_1_2.D sg13cmos5l_xnor2_1_3.B 0.78494f
C3462 sg13cmos5l_dlygate4sd3_1_17.A a_27963_6538# 0.01299f
C3463 sg13cmos5l_xnor2_1_8.Y sg13cmos5l_buf_8_5.A 0.12515f
C3464 sg13cmos5l_dfrbpq_1_0.CLK sg13cmos5l_xnor2_1_3.A 0.03934f
C3465 sg13cmos5l_nor3_1_2.C sg13cmos5l_nor4_2_9.Y 0.0221f
C3466 sg13cmos5l_dfrbpq_1_46.CLK a_24261_6897# 0.35319f
C3467 sg13cmos5l_dlygate4sd3_1_39.X sg13cmos5l_buf_1_4.A 0.62694f
C3468 sg13cmos5l_dlygate4sd3_1_23.X a_3876_4212# 0.03561f
C3469 sg13cmos5l_buf_1_0.X sg13cmos5l_buf_8_2.X 0.02106f
C3470 a_19312_4114# VPWR 0.18729f
C3471 sg13cmos5l_dlygate4sd3_1_17.X a_26283_4667# 0.0117f
C3472 sg13cmos5l_dlygate4sd3_1_39.X sg13cmos5l_dlygate4sd3_1_39.A 0.05684f
C3473 a_24837_2361# a_24727_1596# 0.02731f
C3474 a_19609_6942# sg13cmos5l_buf_2_0.X 0.57889f
C3475 sg13cmos5l_xnor2_1_2.B a_15686_6606# 0.04504f
C3476 a_20192_7093# a_20311_6882# 0.13494f
C3477 a_23576_3185# VPWR 0.35401f
C3478 a_7594_5374# a_7930_4620# 0.01536f
C3479 sg13cmos5l_xnor2_1_5.Y sg13cmos5l_dfrbpq_1_13.RESET_B 0.02585f
C3480 a_28174_8619# sg13cmos5l_nor4_2_7.D 0.19355f
C3481 a_22314_4656# sg13cmos5l_dlygate4sd3_1_10.A 0.13536f
C3482 a_15756_1060# VPWR 0.25727f
C3483 sg13cmos5l_nor4_2_4.D a_15972_6172# 0.03046f
C3484 a_8063_1603# a_8759_1679# 0.02453f
C3485 sg13cmos5l_buf_1_5.A a_18843_5410# 0.02718f
C3486 sg13cmos5l_dfrbpq_1_23.D a_3692_4656# 0.10324f
C3487 sg13cmos5l_dfrbpq_1_57.RESET_B a_10231_4620# 0.24562f
C3488 sg13cmos5l_xnor2_1_2.B a_16167_4743# 0.01973f
C3489 a_18478_8619# VPWR 0.21284f
C3490 a_19631_2459# VPWR 0.21495f
C3491 sg13cmos5l_dfrbpq_1_23.D a_2016_4695# 0.01371f
C3492 sg13cmos5l_dfrbpq_1_57.RESET_B a_10022_6918# 0.13318f
C3493 a_1152_1185# sg13cmos5l_xnor2_1_6.Y 0.2259f
C3494 sg13cmos5l_dfrbpq_1_39.Q sg13cmos5l_nor3_1_0.C 0.05618f
C3495 a_11733_4703# a_11639_4703# 0.87117f
C3496 a_6250_3108# a_6250_2350# 0.08349f
C3497 a_17984_2514# VPWR 0.07405f
C3498 a_6453_4703# VPWR 0.09598f
C3499 a_15687_8648# VPWR 0.20568f
C3500 a_17100_2572# VPWR 0.297f
C3501 sg13cmos5l_dlygate4sd3_1_47.A a_28174_8619# 0.01252f
C3502 sg13cmos5l_nand3_1_2.A sg13cmos5l_nor3_1_0.C 0.02357f
C3503 a_20805_4667# a_20805_3873# 0.03069f
C3504 a_3799_834# VPWR 0.17066f
C3505 sg13cmos5l_dfrbpq_1_53.RESET_B a_26181_5385# 0.05624f
C3506 sg13cmos5l_buf_1_0.X sg13cmos5l_dlygate4sd3_1_10.A 1.20508f
C3507 sg13cmos5l_dfrbpq_1_0.CLK a_26090_1912# 0.01508f
C3508 sg13cmos5l_nor4_2_5.C a_2632_8562# 0.02357f
C3509 sg13cmos5l_nor4_2_7.B a_26150_6918# 0.01381f
C3510 sg13cmos5l_buf_8_4.A sg13cmos5l_dfrbpq_1_57.CLK 0.12963f
C3511 sg13cmos5l_buf_8_2.X a_27226_2350# 0.01034f
C3512 sg13cmos5l_dfrbpq_1_46.D sg13cmos5l_dfrbpq_1_39.Q 0.2422f
C3513 a_25764_5724# a_26283_5528# 0.38902f
C3514 sg13cmos5l_dlygate4sd3_1_23.X sg13cmos5l_xor2_1_1.B 0.01992f
C3515 a_1870_7947# a_1985_7946# 0.67711f
C3516 sg13cmos5l_nor3_1_2.B a_1480_7766# 0.01203f
C3517 sg13cmos5l_dfrbpq_1_21.RESET_B en[4] 0.40628f
C3518 a_23576_3898# VPWR 0.3499f
C3519 sg13cmos5l_nor4_2_1.A sg13cmos5l_dfrbpq_1_0.CLK 0.04006f
C3520 sg13cmos5l_dlygate4sd3_1_17.X a_28174_4923# 0.04514f
C3521 sg13cmos5l_dlygate4sd3_1_19.X a_3790_1899# 0.19353f
C3522 a_27195_3514# a_27878_2386# 0.01621f
C3523 a_1870_2571# VPWR 0.24848f
C3524 sg13cmos5l_dfrbpq_1_53.CLK a_25029_6179# 0.35654f
C3525 a_20792_1673# a_21062_1632# 0.33585f
C3526 sg13cmos5l_and2_1_1.A a_20805_3873# 0.02736f
C3527 sg13cmos5l_dfrbpq_1_46.D sg13cmos5l_nand3_1_2.A 0.18466f
C3528 a_3680_5609# VPWR 0.45249f
C3529 sg13cmos5l_xnor2_1_2.B a_16491_6179# 0.0226f
C3530 sg13cmos5l_dfrbpq_1_0.D a_28262_1632# 0.0131f
C3531 a_17510_3894# a_18213_3873# 0.02453f
C3532 sg13cmos5l_buf_1_0.X sg13cmos5l_dlygate4sd3_1_0.X 0.04456f
C3533 a_28376_874# a_28646_874# 0.33585f
C3534 a_6972_8394# a_7749_7691# 0.01465f
C3535 sg13cmos5l_buf_1_1.X sg13cmos5l_nor4_2_1.D 1.90467f
C3536 a_3850_3112# sg13cmos5l_xnor2_1_6.A 0.01164f
C3537 a_4164_3569# a_4395_3155# 0.15089f
C3538 sg13cmos5l_xnor2_1_0.A sg13cmos5l_nor3_1_1.Y 0.08619f
C3539 sg13cmos5l_buf_1_0.A sg13cmos5l_dlygate4sd3_1_4.X 0.15081f
C3540 a_6276_7236# a_6564_6931# 0.4806f
C3541 sg13cmos5l_nor3_1_0.A a_17472_1671# 0.06611f
C3542 sg13cmos5l_dfrbpq_1_46.CLK a_20805_5385# 0.36467f
C3543 sg13cmos5l_dlygate4sd3_1_53.A a_7594_5374# 0.08657f
C3544 a_27416_874# sg13cmos5l_dfrbpq_1_1.Q 0.60428f
C3545 sg13cmos5l_dlygate4sd3_1_22.A a_4511_1140# 0.01395f
C3546 sg13cmos5l_dfrbpq_1_57.RESET_B a_11824_7138# 0.24559f
C3547 sg13cmos5l_xnor2_1_6.Y a_2054_874# 0.01077f
C3548 a_1152_1185# a_1301_874# 0.3658f
C3549 sg13cmos5l_xnor2_1_6.B sg13cmos5l_dlygate4sd3_1_20.A 5.50144f
C3550 a_8694_4680# VPWR 0.21456f
C3551 a_14364_1993# VPWR 0.07323f
C3552 sg13cmos5l_nor4_2_4.D VPWR 0.62366f
C3553 sg13cmos5l_xnor2_1_4.B a_25188_3569# 0.01898f
C3554 sg13cmos5l_buf_1_2.A a_17015_4703# 0.02866f
C3555 sg13cmos5l_buf_1_4.X a_20388_4660# 0.48733f
C3556 a_3876_8748# a_4395_8552# 0.38902f
C3557 sg13cmos5l_dlygate4sd3_1_6.A en[4] 0.12879f
C3558 a_20388_8748# en[3] 0.04922f
C3559 a_28652_7644# en[3] 0.32639f
C3560 sg13cmos5l_buf_1_5.A a_10308_5724# 0.01365f
C3561 sg13cmos5l_dfrbpq_1_55.Q sg13cmos5l_dfrbpq_1_55.RESET_B 0.2038f
C3562 sg13cmos5l_dlygate4sd3_1_6.X en[4] 0.01699f
C3563 sg13cmos5l_and2_1_1.X a_24612_6172# 0.05144f
C3564 sg13cmos5l_dfrbpq_1_53.RESET_B a_27280_5626# 0.17696f
C3565 sg13cmos5l_xnor2_1_13.Y a_2016_4695# 0.2456f
C3566 sg13cmos5l_buf_1_1.X a_25509_849# 0.02578f
C3567 sg13cmos5l_nor3_1_1.Y a_15322_838# 0.01233f
C3568 a_18891_2504# a_19888_2602# 0.06746f
C3569 sg13cmos5l_nand3_1_1.A a_16970_4936# 0.01462f
C3570 sg13cmos5l_nor4_2_7.B a_27695_6995# 0.01465f
C3571 a_27713_4084# VPWR 0.2435f
C3572 sg13cmos5l_dfrbpq_1_13.RESET_B sg13cmos5l_dfrbpq_1_23.D 0.08083f
C3573 sg13cmos5l_dfrbpq_1_57.CLK sg13cmos5l_dlygate4sd3_1_52.A 0.02665f
C3574 a_1985_2572# a_1985_1898# 0.01869f
C3575 a_26283_5528# a_27023_5483# 0.3087f
C3576 sg13cmos5l_dfrbpq_1_58.RESET_B sg13cmos5l_buf_8_5.A 0.03381f
C3577 sg13cmos5l_buf_8_4.A sg13cmos5l_xnor2_1_2.A 0.15872f
C3578 a_22330_838# VPWR 0.41246f
C3579 sg13cmos5l_dfrbpq_1_21.RESET_B sg13cmos5l_dfrbpq_1_23.Q 0.02311f
C3580 sg13cmos5l_xnor2_1_10.Y a_22314_6168# 0.04386f
C3581 a_7430_2382# VPWR 0.99764f
C3582 a_1870_1899# VPWR 0.21644f
C3583 sg13cmos5l_dfrbpq_1_46.CLK sg13cmos5l_nand3_1_2.A 0.46108f
C3584 sg13cmos5l_xnor2_1_2.Y a_17135_2386# 0.01799f
C3585 sg13cmos5l_dlygate4sd3_1_57.A a_15598_8430# 0.01108f
C3586 sg13cmos5l_xor2_1_1.B sg13cmos5l_dfrbpq_1_12.D 0.30696f
C3587 sg13cmos5l_dlygate4sd3_1_19.A a_3850_3112# 0.01377f
C3588 sg13cmos5l_buf_1_0.A a_3904_4656# 0.0188f
C3589 sg13cmos5l_dfrbpq_1_18.D sg13cmos5l_nor3_1_1.Y 0.01559f
C3590 sg13cmos5l_dfrbpq_1_53.CLK a_26538_6168# 0.02554f
C3591 sg13cmos5l_dfrbpq_1_21.RESET_B a_4395_3155# 0.60225f
C3592 a_27878_2386# a_27990_2450# 0.67711f
C3593 a_21904_8650# a_21553_8507# 0.01017f
C3594 sg13cmos5l_nor4_2_4.D sg13cmos5l_buf_8_10.A 0.02091f
C3595 a_10725_1643# a_10827_1643# 0.6663f
C3596 sg13cmos5l_xnor2_1_2.B a_15525_7691# 0.01011f
C3597 a_20311_6882# a_20871_7136# 0.3087f
C3598 sg13cmos5l_buf_1_1.X a_24420_2700# 0.46771f
C3599 sg13cmos5l_buf_1_5.A a_9558_6192# 0.04212f
C3600 sg13cmos5l_buf_1_0.A a_3876_3148# 0.01387f
C3601 sg13cmos5l_dfrbpq_1_23.D a_9176_4697# 0.09454f
C3602 sg13cmos5l_dfrbpq_1_57.RESET_B a_11733_4703# 0.3206f
C3603 sg13cmos5l_dfrbpq_1_11.CLK a_10943_2652# 0.3797f
C3604 a_7535_6995# a_7441_6995# 0.32273f
C3605 a_27994_3862# osc 0.01036f
C3606 sg13cmos5l_xnor2_1_5.Y a_2016_5721# 0.43869f
C3607 sg13cmos5l_dlygate4sd3_1_55.A sg13cmos5l_nor3_1_0.C 0.02245f
C3608 a_26181_4667# a_26447_3971# 0.01286f
C3609 a_14938_4620# a_14657_4922# 0.33585f
C3610 sg13cmos5l_nand3_1_0.A a_19428_1188# 0.02498f
C3611 a_14938_4620# sg13cmos5l_dfrbpq_1_55.Q 0.51254f
C3612 a_24394_2605# a_24420_2700# 0.43042f
C3613 sg13cmos5l_nor4_2_0.B a_24134_2382# 0.31196f
C3614 sg13cmos5l_nand3_1_1.Y sg13cmos5l_dlygate4sd3_1_22.X 0.21044f
C3615 sg13cmos5l_buf_1_4.X a_20907_4667# 0.58015f
C3616 sg13cmos5l_dfrbpq_1_21.CLK a_5532_5017# 0.0988f
C3617 a_7799_1261# VPWR 0.9273f
C3618 a_5223_7767# a_5375_7651# 0.66105f
C3619 a_10827_7040# VPWR 0.20557f
C3620 sg13cmos5l_dlygate4sd3_1_47.A sg13cmos5l_nor4_2_7.D 0.10917f
C3621 sg13cmos5l_dfrbpq_1_37.D sg13cmos5l_dlygate4sd3_1_17.A 0.04449f
C3622 sg13cmos5l_xnor2_1_2.B a_16452_5419# 0.01726f
C3623 sg13cmos5l_xnor2_1_0.A a_1302_1656# 0.039f
C3624 a_13288_1718# a_13288_1002# 0.01275f
C3625 sg13cmos5l_buf_1_4.X a_25605_3873# 0.05118f
C3626 sg13cmos5l_dfrbpq_1_46.CLK a_20907_6179# 0.04455f
C3627 a_4293_8409# a_4544_7967# 0.01099f
C3628 a_3850_8653# a_3876_8748# 0.43042f
C3629 sg13cmos5l_buf_8_2.X sg13cmos5l_buf_1_4.X 0.06677f
C3630 sg13cmos5l_dlygate4sd3_1_31.X sg13cmos5l_dlygate4sd3_1_33.A 0.15829f
C3631 sg13cmos5l_dlygate4sd3_1_33.A a_3878_7680# 0.01803f
C3632 sg13cmos5l_nor3_1_2.B a_5375_7651# 0.01501f
C3633 sg13cmos5l_xnor2_1_12.Y VPWR 0.59815f
C3634 a_10022_8430# a_10725_8409# 0.02453f
C3635 a_3876_4212# a_4164_3907# 0.4806f
C3636 a_5135_3971# a_5392_4114# 0.40419f
C3637 sg13cmos5l_dfrbpq_1_21.RESET_B a_5392_4114# 0.17736f
C3638 a_27023_5483# a_27690_5704# 0.13494f
C3639 a_24806_870# VPWR 0.92814f
C3640 sg13cmos5l_dlygate4sd3_1_52.A sg13cmos5l_xnor2_1_2.A 0.19714f
C3641 a_20805_3873# a_21553_3971# 0.01058f
C3642 sg13cmos5l_buf_8_2.X a_19055_3971# 0.02563f
C3643 sg13cmos5l_nor3_1_0.C a_18951_1719# 0.0262f
C3644 a_10812_3505# sg13cmos5l_nor3_1_1.C 0.0141f
C3645 a_10231_3108# a_10791_3231# 0.3087f
C3646 sg13cmos5l_nor3_1_0.B a_23846_3144# 0.01235f
C3647 sg13cmos5l_nor4_2_0.C a_24614_3582# 0.31177f
C3648 a_3680_5609# sg13cmos5l_dfrbpq_1_16.Q 0.05818f
C3649 sg13cmos5l_xnor2_1_2.B a_15627_7691# 0.0148f
C3650 sg13cmos5l_nor3_1_2.C sg13cmos5l_nor4_2_5.Y 1.20173f
C3651 a_1000_8468# a_808_8562# 0.01225f
C3652 sg13cmos5l_nor4_2_4.D a_17034_7680# 0.01214f
C3653 sg13cmos5l_dfrbpq_1_21.RESET_B a_6795_7040# 0.01657f
C3654 sg13cmos5l_buf_8_10.A a_10827_7040# 0.02059f
C3655 sg13cmos5l_xor2_1_2.B a_13974_4680# 0.04574f
C3656 a_15488_4943# a_15296_4742# 0.03403f
C3657 a_15607_4620# a_16188_5017# 0.01741f
C3658 sg13cmos5l_dfrbpq_1_32.CLK sg13cmos5l_xnor2_1_8.Y 0.11349f
C3659 sg13cmos5l_buf_1_0.X sg13cmos5l_dfrbpq_1_37.D 0.18503f
C3660 sg13cmos5l_buf_1_1.X a_18604_2070# 0.1773f
C3661 sg13cmos5l_nand3_1_1.Y sg13cmos5l_dfrbpq_1_13.RESET_B 0.02851f
C3662 sg13cmos5l_nor3_1_0.Y a_17541_1168# 0.02331f
C3663 sg13cmos5l_buf_8_4.A a_6862_3894# 0.01845f
C3664 sg13cmos5l_buf_8_0.X sg13cmos5l_nor3_1_0.C 0.03896f
C3665 a_13574_2382# a_13860_2700# 0.50066f
C3666 a_10791_4743# VPWR 0.20806f
C3667 a_11639_4703# sg13cmos5l_dfrbpq_1_17.D 0.04277f
C3668 a_13974_4680# a_13862_4656# 0.67711f
C3669 a_26181_8409# a_26052_8443# 0.01562f
C3670 sg13cmos5l_buf_1_4.X sg13cmos5l_dlygate4sd3_1_10.A 1.41585f
C3671 sg13cmos5l_dfrbpq_1_21.CLK a_5511_4743# 0.06239f
C3672 a_5135_3971# VPWR 0.17205f
C3673 sg13cmos5l_dfrbpq_1_21.RESET_B VPWR 12.0597f
C3674 sg13cmos5l_xnor2_1_2.B sg13cmos5l_xnor2_1_5.A 0.01574f
C3675 sg13cmos5l_xor2_1_2.A sg13cmos5l_xnor2_1_2.A 1.54216f
C3676 sg13cmos5l_buf_1_4.A sg13cmos5l_xnor2_1_4.B 0.02743f
C3677 sg13cmos5l_dfrbpq_1_23.D sg13cmos5l_xnor2_1_12.B 0.98077f
C3678 sg13cmos5l_nor3_1_0.C a_20805_4667# 0.01358f
C3679 a_8042_3144# VPWR 0.18626f
C3680 a_5319_1719# a_5471_1603# 0.66105f
C3681 sg13cmos5l_nand3_1_1.Y a_9176_4697# 0.01815f
C3682 sg13cmos5l_buf_1_5.A sg13cmos5l_nor3_1_4.A 0.03657f
C3683 a_2266_1596# a_2054_874# 0.01425f
C3684 a_5244_8041# a_5375_7651# 0.48921f
C3685 a_7103_4164# a_7799_4285# 0.02431f
C3686 sg13cmos5l_dfrbpq_1_53.Q sg13cmos5l_buf_1_4.A 0.53946f
C3687 a_6951_4112# a_6972_3858# 0.38871f
C3688 sg13cmos5l_xnor2_1_5.Y a_16666_2350# 0.06732f
C3689 sg13cmos5l_buf_8_3.A a_10112_3431# 0.0113f
C3690 sg13cmos5l_dfrbpq_1_22.D sg13cmos5l_dfrbpq_1_55.RESET_B 3.67735f
C3691 sg13cmos5l_nand3_1_3.B sg13cmos5l_nor3_1_1.Y 0.24069f
C3692 sg13cmos5l_dfrbpq_1_0.CLK a_25476_3907# 0.01345f
C3693 a_23958_3962# sg13cmos5l_nor4_2_0.C 0.19355f
C3694 a_26608_1090# VPWR 0.18782f
C3695 sg13cmos5l_buf_8_2.X sg13cmos5l_dlygate4sd3_1_15.A 1.39773f
C3696 a_14926_6435# a_14720_6254# 0.03208f
C3697 sg13cmos5l_dlygate4sd3_1_31.X sg13cmos5l_nor3_1_2.B 0.28622f
C3698 a_16454_3144# a_16666_2350# 0.01425f
C3699 sg13cmos5l_nor4_2_7.D a_25380_7684# 0.02776f
C3700 a_10943_7651# a_11594_7960# 0.01562f
C3701 sg13cmos5l_xnor2_1_3.A a_26090_1912# 0.01101f
C3702 a_13783_1596# a_14364_1993# 0.01741f
C3703 sg13cmos5l_xnor2_1_2.B sg13cmos5l_buf_1_2.A 1.13476f
C3704 a_25738_8653# VPWR 0.09374f
C3705 a_10282_8653# sg13cmos5l_dfrbpq_1_57.RESET_B 0.32061f
C3706 sg13cmos5l_and2_1_1.A sg13cmos5l_nor3_1_0.C 0.17606f
C3707 sg13cmos5l_dlygate4sd3_1_57.A sg13cmos5l_xnor2_1_2.B 0.02607f
C3708 sg13cmos5l_xnor2_1_2.B sg13cmos5l_dfrbpq_1_52.Q 0.08835f
C3709 sg13cmos5l_dfrbpq_1_53.CLK a_27418_6132# 0.03476f
C3710 a_2266_2350# sg13cmos5l_dfrbpq_1_13.Q 0.52477f
C3711 sg13cmos5l_dfrbpq_1_2.CLK a_19754_1912# 0.02064f
C3712 sg13cmos5l_dlygate4sd3_1_17.A a_27690_4656# 0.04685f
C3713 a_24940_2070# VPWR 0.18782f
C3714 a_25764_5724# VPWR 0.0721f
C3715 sg13cmos5l_dlygate4sd3_1_1.A sg13cmos5l_xnor2_1_3.A 0.24484f
C3716 sg13cmos5l_buf_8_4.A sg13cmos5l_dlygate4sd3_1_38.A 0.24997f
C3717 sg13cmos5l_dlygate4sd3_1_4.A osc 0.01825f
C3718 a_16188_5017# a_16319_4627# 0.48921f
C3719 sg13cmos5l_dfrbpq_1_56.RESET_B a_15340_8430# 0.1703f
C3720 sg13cmos5l_dfrbpq_1_29.Q a_18478_8619# 0.01469f
C3721 sg13cmos5l_dlygate4sd3_1_6.A VPWR 1.32753f
C3722 sg13cmos5l_nor3_1_0.B sg13cmos5l_nand3_1_0.Y 0.04995f
C3723 a_4380_834# a_5162_1028# 0.4806f
C3724 a_8842_6886# a_8584_7050# 0.03673f
C3725 sg13cmos5l_dfrbpq_1_29.Q a_15687_8648# 0.0232f
C3726 sg13cmos5l_dfrbpq_1_17.D a_14657_4922# 0.01129f
C3727 sg13cmos5l_nor4_2_4.D sg13cmos5l_nand3_1_1.A 0.01592f
C3728 sg13cmos5l_xnor2_1_4.B sg13cmos5l_nor3_1_0.C 0.02288f
C3729 sg13cmos5l_dlygate4sd3_1_6.X VPWR 2.2471f
C3730 a_8776_4026# VPWR 0.12921f
C3731 sg13cmos5l_nor4_2_5.Y a_5036_6168# 0.02176f
C3732 sg13cmos5l_dfrbpq_1_53.Q sg13cmos5l_nor3_1_0.C 0.21697f
C3733 sg13cmos5l_buf_1_4.X sg13cmos5l_xnor2_1_6.B 0.01587f
C3734 sg13cmos5l_dfrbpq_1_46.D sg13cmos5l_and2_1_1.A 0.2417f
C3735 sg13cmos5l_xnor2_1_4.A en[4] 0.02567f
C3736 sg13cmos5l_and2_1_1.A a_20972_2680# 0.03074f
C3737 sg13cmos5l_dlygate4sd3_1_4.X a_27280_8650# 0.0108f
C3738 sg13cmos5l_nand3_1_2.C sg13cmos5l_nor3_1_0.B 0.10757f
C3739 sg13cmos5l_nor3_1_0.C a_21904_4898# 0.01197f
C3740 a_10812_2346# a_11594_2540# 0.4806f
C3741 a_8776_4026# a_8960_4026# 0.11523f
C3742 sg13cmos5l_buf_1_5.A a_13642_5374# 0.02775f
C3743 VPWR osc 0.81677f
C3744 sg13cmos5l_buf_1_0.A a_20792_1673# 0.01185f
C3745 sg13cmos5l_buf_8_3.A a_13574_3582# 0.03838f
C3746 sg13cmos5l_dfrbpq_1_22.D a_13834_3112# 0.01029f
C3747 a_26447_3971# a_27114_4192# 0.13494f
C3748 sg13cmos5l_dfrbpq_1_12.Q sg13cmos5l_nor3_1_1.C 0.01776f
C3749 a_28758_938# VPWR 0.21268f
C3750 sg13cmos5l_buf_8_2.X sg13cmos5l_dlygate4sd3_1_2.A 0.07473f
C3751 sg13cmos5l_dfrbpq_1_46.D sg13cmos5l_xnor2_1_4.B 0.06201f
C3752 a_2266_6132# sg13cmos5l_xnor2_1_5.Y 0.01137f
C3753 a_15686_6606# a_16389_6179# 0.02431f
C3754 a_3488_8562# sg13cmos5l_dlygate4sd3_1_31.X 0.06854f
C3755 a_15376_2602# VPWR 0.21999f
C3756 a_3304_8562# a_3304_7766# 0.01095f
C3757 sg13cmos5l_dfrbpq_1_1.Q VPWR 0.40187f
C3758 a_13860_3148# a_15025_3505# 0.4858f
C3759 a_6261_1679# VPWR 0.0956f
C3760 a_28174_8619# a_28186_7644# 0.01006f
C3761 sg13cmos5l_dlygate4sd3_1_22.X a_6272_1045# 0.04944f
C3762 a_5207_2773# a_5162_2540# 0.36169f
C3763 a_10725_1643# a_10725_849# 0.03069f
C3764 a_27023_5483# VPWR 0.17248f
C3765 a_28506_2578# a_28532_2680# 0.41432f
C3766 a_20871_7136# a_21674_7076# 0.15089f
C3767 a_21023_7188# a_20782_6918# 0.01058f
C3768 sg13cmos5l_xnor2_1_0.Y a_7932_1993# 0.01957f
C3769 sg13cmos5l_dfrbpq_1_57.RESET_B sg13cmos5l_dfrbpq_1_17.D 0.0296f
C3770 a_15839_8700# sg13cmos5l_dfrbpq_1_56.CLK 0.35414f
C3771 a_15607_4620# VPWR 0.17548f
C3772 sg13cmos5l_dfrbpq_1_32.CLK sg13cmos5l_dfrbpq_1_58.RESET_B 0.16429f
C3773 sg13cmos5l_xnor2_1_2.A a_16469_2002# 0.02119f
C3774 sg13cmos5l_dfrbpq_1_29.Q sg13cmos5l_nor4_2_4.D 0.0245f
C3775 sg13cmos5l_xnor2_1_13.Y a_2016_5721# 0.02303f
C3776 sg13cmos5l_nor3_1_4.Y VPWR 0.57103f
C3777 sg13cmos5l_and2_1_1.X a_23958_3962# 0.05202f
C3778 sg13cmos5l_buf_1_5.A sg13cmos5l_nor3_1_4.B 0.02623f
C3779 sg13cmos5l_xnor2_1_0.Y sg13cmos5l_dfrbpq_1_13.Q 0.02489f
C3780 sg13cmos5l_dfrbpq_1_58.Q sg13cmos5l_dfrbpq_1_23.Q 0.02494f
C3781 a_18981_3155# VPWR 0.24686f
C3782 sg13cmos5l_nand3_1_1.Y a_2016_5721# 0.12921f
C3783 sg13cmos5l_dfrbpq_1_53.CLK sg13cmos5l_nor4_2_7.D 0.02896f
C3784 sg13cmos5l_buf_8_11.A sg13cmos5l_dlygate4sd3_1_40.A 0.02761f
C3785 sg13cmos5l_dfrbpq_1_21.RESET_B sg13cmos5l_dfrbpq_1_16.Q 1.47446f
C3786 a_7046_8118# a_7620_8105# 0.36169f
C3787 a_7306_7648# a_7749_7691# 0.02241f
C3788 a_7932_1993# a_8759_1679# 0.50066f
C3789 sg13cmos5l_dlygate4sd3_1_4.X sg13cmos5l_dlygate4sd3_1_17.A 0.01911f
C3790 sg13cmos5l_nor4_2_5.Y sg13cmos5l_dfrbpq_1_58.D 0.1144f
C3791 sg13cmos5l_nand3_1_1.Y a_10943_4627# 0.01608f
C3792 sg13cmos5l_dfrbpq_1_53.RESET_B a_16367_8041# 0.01381f
C3793 a_17036_1596# a_17472_1671# 0.01653f
C3794 a_7594_5374# a_8776_5444# 0.1225f
C3795 sg13cmos5l_dfrbpq_1_53.RESET_B a_26436_7236# 0.4762f
C3796 a_25354_7648# a_25797_7691# 0.02241f
C3797 a_25094_8118# a_25668_8105# 0.36169f
C3798 a_4481_7108# a_4762_6886# 0.33585f
C3799 a_1870_6435# VPWR 0.21795f
C3800 sg13cmos5l_xnor2_1_2.B a_16068_7236# 0.02291f
C3801 sg13cmos5l_xnor2_1_6.A a_1870_2571# 0.19979f
C3802 sg13cmos5l_xnor2_1_5.Y sg13cmos5l_dfrbpq_1_56.Q 0.02031f
C3803 a_16389_6179# a_16491_6179# 0.6663f
C3804 sg13cmos5l_dfrbpq_1_13.RESET_B a_6272_1045# 0.02913f
C3805 sg13cmos5l_dfrbpq_1_57.RESET_B sg13cmos5l_dfrbpq_1_57.Q 0.10929f
C3806 sg13cmos5l_dfrbpq_1_13.CLK a_5319_1719# 0.02926f
C3807 sg13cmos5l_and2_1_3.A a_8106_6168# 0.01306f
C3808 sg13cmos5l_dlygate4sd3_1_47.A sg13cmos5l_dfrbpq_1_53.CLK 0.01595f
C3809 sg13cmos5l_dfrbpq_1_57.RESET_B a_15082_7648# 0.34275f
C3810 sg13cmos5l_dlygate4sd3_1_17.A sg13cmos5l_nor4_2_7.B 0.65331f
C3811 a_16138_5629# a_16164_5724# 0.43042f
C3812 sg13cmos5l_nor4_2_5.C a_4730_6168# 0.0848f
C3813 sg13cmos5l_and2_1_3.A sg13cmos5l_dfrbpq_1_58.D 0.02513f
C3814 sg13cmos5l_dfrbpq_1_56.CLK a_16683_5528# 0.06266f
C3815 sg13cmos5l_dfrbpq_1_23.Q a_5894_6606# 0.02801f
C3816 a_6972_834# a_7799_1261# 0.50066f
C3817 sg13cmos5l_xnor2_1_3.A a_24727_1596# 0.01066f
C3818 sg13cmos5l_dfrbpq_1_23.Q sg13cmos5l_dlygate4sd3_1_30.A 0.14511f
C3819 sg13cmos5l_xor2_1_2.B VPWR 0.6152f
C3820 a_25478_5094# a_26181_4667# 0.02431f
C3821 sg13cmos5l_dlygate4sd3_1_35.A en[0] 0.13598f
C3822 sg13cmos5l_nor3_1_2.C sg13cmos5l_nor3_1_2.Y 1.10211f
C3823 sg13cmos5l_buf_1_1.X VPWR 11.8173f
C3824 sg13cmos5l_dlygate4sd3_1_6.X a_23660_8728# 0.0954f
C3825 a_16319_4627# VPWR 0.24324f
C3826 sg13cmos5l_dlygate4sd3_1_19.X a_6250_2350# 0.05106f
C3827 a_21062_1632# VPWR 0.24633f
C3828 sg13cmos5l_dfrbpq_1_7.Q a_28758_3962# 0.05746f
C3829 sg13cmos5l_nand3_1_2.C a_28931_7216# 0.02521f
C3830 a_23368_5538# VPWR 0.15697f
C3831 sg13cmos5l_nand3_1_1.B a_14938_4620# 0.06102f
C3832 a_25317_3155# VPWR 0.24281f
C3833 sg13cmos5l_nor4_2_5.C sg13cmos5l_nor4_2_5.B 0.71852f
C3834 sg13cmos5l_nor4_2_1.A a_21435_3514# 0.05188f
C3835 a_19893_1679# a_19799_1679# 0.87117f
C3836 a_13862_4656# VPWR 0.2431f
C3837 sg13cmos5l_nor3_1_4.Y sg13cmos5l_nor3_1_1.A 0.0228f
C3838 a_24394_2605# VPWR 0.13713f
C3839 a_7620_8105# a_7851_7691# 0.15089f
C3840 a_26150_6918# en[4] 0.01049f
C3841 sg13cmos5l_dlygate4sd3_1_31.X a_1192_7050# 0.04599f
C3842 sg13cmos5l_and2_1_1.A a_20973_3492# 0.1563f
C3843 sg13cmos5l_dfrbpq_1_53.RESET_B en[3] 2.34753f
C3844 sg13cmos5l_buf_1_0.X a_20805_8409# 0.05147f
C3845 sg13cmos5l_dfrbpq_1_17.D sg13cmos5l_dfrbpq_1_22.D 0.20954f
C3846 a_3590_3582# a_4293_3155# 0.02431f
C3847 sg13cmos5l_dfrbpq_1_12.D a_5135_3505# 0.01053f
C3848 sg13cmos5l_nor3_1_0.A a_17702_3144# 0.01621f
C3849 sg13cmos5l_buf_1_0.X sg13cmos5l_nor4_2_7.B 1.70781f
C3850 sg13cmos5l_xnor2_1_0.A a_1340_3144# 0.14136f
C3851 sg13cmos5l_buf_8_5.A a_10444_5094# 0.01277f
C3852 a_6276_7236# a_6795_7040# 0.38902f
C3853 sg13cmos5l_dlygate4sd3_1_52.X a_9558_4680# 0.19346f
C3854 sg13cmos5l_xnor2_1_4.A sg13cmos5l_dlygate4sd3_1_4.A 0.03721f
C3855 a_18564_3148# a_18852_3569# 0.4806f
C3856 a_16138_5629# VPWR 0.09469f
C3857 sg13cmos5l_xnor2_1_6.B a_7690_2605# 0.03139f
C3858 sg13cmos5l_dlygate4sd3_1_21.X sg13cmos5l_dfrbpq_1_13.CLK 0.20923f
C3859 sg13cmos5l_xnor2_1_6.A a_7430_2382# 0.32968f
C3860 a_13563_874# a_14926_1059# 0.03691f
C3861 a_8776_5444# sg13cmos5l_dfrbpq_1_57.Q 0.03115f
C3862 a_20102_3894# osc 0.02046f
C3863 a_25668_8105# a_25899_7691# 0.15089f
C3864 sg13cmos5l_dfrbpq_1_53.RESET_B a_27952_7138# 0.17693f
C3865 a_20972_2680# a_21270_2680# 0.31789f
C3866 a_13472_5538# VPWR 0.06896f
C3867 sg13cmos5l_and2_1_3.A a_10231_6132# 0.01371f
C3868 a_17488_6410# a_17898_6168# 0.1396f
C3869 sg13cmos5l_dfrbpq_1_21.RESET_B sg13cmos5l_dlygate4sd3_1_34.A 0.14983f
C3870 sg13cmos5l_dlygate4sd3_1_53.A sg13cmos5l_buf_8_5.A 0.02802f
C3871 sg13cmos5l_nor4_2_9.D sg13cmos5l_xnor2_1_12.B 0.01157f
C3872 a_18593_8620# a_18874_8398# 0.33585f
C3873 sg13cmos5l_buf_1_0.A a_18604_2070# 0.0103f
C3874 sg13cmos5l_dlygate4sd3_1_19.X a_3904_4656# 0.05262f
C3875 a_16164_5724# a_17423_5483# 0.01741f
C3876 a_6276_7236# VPWR 0.07247f
C3877 sg13cmos5l_buf_8_4.A sg13cmos5l_dfrbpq_1_12.D 0.03086f
C3878 sg13cmos5l_nand3_1_2.A a_24815_5410# 0.01424f
C3879 sg13cmos5l_dfrbpq_1_55.Q a_14277_2361# 0.01306f
C3880 sg13cmos5l_dfrbpq_1_58.Q VPWR 0.46041f
C3881 a_17488_6410# VPWR 0.18822f
C3882 a_25308_1993# a_25287_1719# 0.38902f
C3883 sg13cmos5l_dlygate4sd3_1_19.X a_3876_3148# 0.06202f
C3884 sg13cmos5l_buf_1_4.X a_18213_3873# 0.05347f
C3885 sg13cmos5l_dfrbpq_1_11.CLK a_14364_1993# 0.11887f
C3886 a_23818_7141# a_24261_6897# 0.02241f
C3887 sg13cmos5l_xnor2_1_4.A VPWR 1.38789f
C3888 a_24902_3894# VPWR 0.9292f
C3889 a_25764_4660# a_26283_4667# 0.38871f
C3890 a_26181_4667# a_26052_5081# 0.01562f
C3891 sg13cmos5l_nor4_2_9.D a_2016_5721# 0.01455f
C3892 a_1480_6254# a_1664_6254# 0.11523f
C3893 sg13cmos5l_dfrbpq_1_53.CLK a_25380_7684# 0.11831f
C3894 a_3304_2514# VPWR 0.14797f
C3895 sg13cmos5l_buf_1_0.A en[4] 0.93534f
C3896 sg13cmos5l_nor3_1_1.A sg13cmos5l_buf_1_1.X 0.01035f
C3897 sg13cmos5l_dlygate4sd3_1_47.A a_28186_7644# 0.51775f
C3898 a_20388_8748# a_21553_8507# 0.4858f
C3899 a_20907_8552# a_20676_8443# 0.15089f
C3900 a_10022_2070# a_10308_1636# 0.50066f
C3901 sg13cmos5l_dfrbpq_1_53.RESET_B a_24612_6172# 0.03288f
C3902 a_7749_7691# a_8497_8041# 0.01058f
C3903 sg13cmos5l_dfrbpq_1_58.D a_5356_5406# 0.03548f
C3904 sg13cmos5l_dfrbpq_1_21.CLK a_5135_3971# 0.01153f
C3905 sg13cmos5l_nand3_1_1.A osc 0.07718f
C3906 sg13cmos5l_dfrbpq_1_21.RESET_B sg13cmos5l_dfrbpq_1_21.CLK 0.39021f
C3907 sg13cmos5l_dlygate4sd3_1_6.X a_21553_5483# 0.01721f
C3908 sg13cmos5l_buf_1_0.A a_28940_1596# 0.32052f
C3909 a_17423_5483# VPWR 0.17486f
C3910 a_26639_8041# a_26545_8041# 0.32273f
C3911 sg13cmos5l_dfrbpq_1_13.RESET_B a_10022_870# 0.1167f
C3912 sg13cmos5l_nand3_1_1.B a_15032_5410# 0.01073f
C3913 a_13288_6254# a_13288_5538# 0.01275f
C3914 sg13cmos5l_xnor2_1_4.B a_27195_3514# 0.01328f
C3915 a_5626_6886# a_5990_6918# 0.02797f
C3916 a_5894_6606# VPWR 0.93114f
C3917 sg13cmos5l_and2_1_3.A a_10791_6255# 0.01831f
C3918 a_25478_8430# a_25764_8748# 0.50066f
C3919 a_15082_7648# a_15108_7684# 0.43042f
C3920 sg13cmos5l_dlygate4sd3_1_30.A VPWR 0.50508f
C3921 sg13cmos5l_xnor2_1_13.Y a_2266_6132# 0.08259f
C3922 sg13cmos5l_dfrbpq_1_57.RESET_B a_10308_5724# 0.51637f
C3923 sg13cmos5l_and2_1_3.A sg13cmos5l_buf_8_9.A 0.03291f
C3924 a_6391_834# VPWR 0.1688f
C3925 sg13cmos5l_nor4_2_1.D a_20298_2680# 0.03426f
C3926 a_21023_7188# a_20805_6179# 0.03649f
C3927 a_16581_5385# a_16452_5419# 0.01562f
C3928 a_17423_5483# a_18090_5704# 0.13494f
C3929 a_8202_7216# VPWR 0.45366f
C3930 sg13cmos5l_buf_1_4.X a_25198_2070# 0.0178f
C3931 sg13cmos5l_dlygate4sd3_1_6.A sg13cmos5l_dlygate4sd3_1_51.X 0.01645f
C3932 sg13cmos5l_nor3_1_2.C a_5626_6886# 0.01189f
C3933 a_5894_6606# a_6154_6136# 0.87117f
C3934 sg13cmos5l_dfrbpq_1_21.Q VPWR 2.67738f
C3935 sg13cmos5l_dlygate4sd3_1_6.X sg13cmos5l_dlygate4sd3_1_51.X 0.16038f
C3936 a_13676_7680# VPWR 0.41253f
C3937 a_2632_7050# a_2816_7050# 0.11523f
C3938 a_23844_7236# a_24261_6897# 0.48921f
C3939 a_23558_6918# a_24363_7040# 0.11742f
C3940 a_29120_5538# VPWR 0.05642f
C3941 a_26283_4667# a_27023_5017# 0.3087f
C3942 a_3850_4117# a_3876_4212# 0.43042f
C3943 a_18478_8619# en[2] 0.05403f
C3944 sg13cmos5l_dfrbpq_1_13.RESET_B a_5340_1993# 0.4809f
C3945 a_9232_2602# VPWR 0.22357f
C3946 sg13cmos5l_nand3_1_1.A sg13cmos5l_nor3_1_4.Y 0.01456f
C3947 sg13cmos5l_buf_1_1.X a_20102_3894# 0.09527f
C3948 a_20362_4117# a_20388_4212# 0.43042f
C3949 a_20311_7644# a_20892_8041# 0.01741f
C3950 sg13cmos5l_dlygate4sd3_1_19.A a_4164_3569# 0.01038f
C3951 sg13cmos5l_dfrbpq_1_21.RESET_B sg13cmos5l_xnor2_1_6.A 1.9871f
C3952 sg13cmos5l_buf_1_0.A sg13cmos5l_dfrbpq_1_23.Q 0.02764f
C3953 sg13cmos5l_xnor2_1_3.A a_22138_1596# 0.01058f
C3954 sg13cmos5l_nand3_1_1.B sg13cmos5l_dfrbpq_1_17.D 0.01574f
C3955 a_7439_6529# a_7594_5374# 0.02333f
C3956 sg13cmos5l_xnor2_1_13.Y a_2016_7233# 0.44429f
C3957 sg13cmos5l_xnor2_1_6.B a_7744_3144# 0.065f
C3958 sg13cmos5l_buf_8_2.X a_18564_3148# 0.02631f
C3959 sg13cmos5l_dfrbpq_1_53.RESET_B a_25871_6529# 0.08677f
C3960 a_10231_7644# a_10444_8118# 0.40419f
C3961 sg13cmos5l_xnor2_1_13.Y sg13cmos5l_xnor2_1_5.Y 0.39911f
C3962 a_8488_6254# VPWR 0.13801f
C3963 sg13cmos5l_nand3_1_0.A sg13cmos5l_xnor2_1_3.A 0.03215f
C3964 a_25871_6529# a_26181_5385# 0.01206f
C3965 sg13cmos5l_nand3_1_1.Y sg13cmos5l_xnor2_1_5.Y 10.2385f
C3966 a_26955_7040# a_26724_6931# 0.15089f
C3967 a_26436_7236# a_27601_6995# 0.4858f
C3968 sg13cmos5l_nor3_1_0.A sg13cmos5l_nand3_1_0.Y 0.06683f
C3969 a_5334_6168# VPWR 0.41177f
C3970 sg13cmos5l_buf_1_4.A a_26929_5017# 0.02392f
C3971 sg13cmos5l_dfrbpq_1_55.Q a_14379_3155# 0.0261f
C3972 sg13cmos5l_dfrbpq_1_57.RESET_B a_12234_5704# 0.02304f
C3973 sg13cmos5l_xnor2_1_0.Y sg13cmos5l_dlygate4sd3_1_22.X 0.01998f
C3974 a_19256_8434# a_19526_8434# 0.33585f
C3975 a_17680_5626# a_17329_5483# 0.01017f
C3976 sg13cmos5l_nand3_1_1.Y sg13cmos5l_dfrbpq_1_56.Q 0.01845f
C3977 sg13cmos5l_xnor2_1_4.A a_25009_6995# 0.01608f
C3978 sg13cmos5l_xnor2_1_0.Y a_15285_1679# 0.03631f
C3979 a_4759_1596# a_5340_1993# 0.01741f
C3980 a_6250_3108# VPWR 1.24294f
C3981 sg13cmos5l_and2_1_3.A a_13664_7050# 0.04549f
C3982 sg13cmos5l_dfrbpq_1_58.Q sg13cmos5l_dfrbpq_1_16.Q 0.30833f
C3983 a_5894_6606# a_6468_6593# 0.36169f
C3984 a_16624_7922# VPWR 0.18658f
C3985 a_5392_4114# a_5041_3971# 0.01017f
C3986 a_24363_7040# a_25103_6995# 0.3087f
C3987 sg13cmos5l_dfrbpq_1_21.RESET_B sg13cmos5l_dlygate4sd3_1_19.A 1.04487f
C3988 a_9446_5410# VPWR 0.23989f
C3989 sg13cmos5l_nor3_1_4.A sg13cmos5l_dfrbpq_1_55.Q 0.83349f
C3990 a_5024_5581# a_5356_5406# 0.1396f
C3991 a_21674_7960# a_21719_7727# 0.36169f
C3992 a_26150_6918# VPWR 0.92698f
C3993 sg13cmos5l_dlygate4sd3_1_22.X a_8759_1679# 0.01679f
C3994 a_15302_5410# a_15414_5474# 0.67711f
C3995 sg13cmos5l_buf_1_1.X a_25439_1603# 0.06158f
C3996 sg13cmos5l_nand3_1_2.A sg13cmos5l_nand3_1_2.B 1.16038f
C3997 a_6972_8394# sg13cmos5l_dfrbpq_1_53.RESET_B 0.01114f
C3998 a_20892_8041# a_20871_7767# 0.38902f
C3999 a_9176_6209# a_9176_5410# 0.02287f
C4000 sg13cmos5l_dlygate4sd3_1_30.A a_3896_6209# 0.50757f
C4001 a_24608_1919# a_24940_2070# 0.1396f
C4002 a_10812_3505# a_11733_3191# 0.43042f
C4003 a_25188_4212# a_25317_3155# 0.01407f
C4004 sg13cmos5l_dlygate4sd3_1_22.X sg13cmos5l_xnor2_1_6.Y 3.0282f
C4005 sg13cmos5l_xor2_1_2.A sg13cmos5l_xnor2_1_2.B 0.49855f
C4006 sg13cmos5l_buf_8_2.X a_24900_3148# 0.02255f
C4007 sg13cmos5l_dfrbpq_1_56.D sg13cmos5l_nor4_2_1.A 0.03951f
C4008 a_3304_5538# VPWR 0.13874f
C4009 a_24780_5596# a_24815_5410# 0.3658f
C4010 sg13cmos5l_buf_1_0.A sg13cmos5l_dlygate4sd3_1_4.A 0.01924f
C4011 sg13cmos5l_nand3_1_1.Y a_17148_3902# 0.01467f
C4012 a_1265_5460# VPWR 0.24681f
C4013 a_4012_870# a_4359_1088# 0.07014f
C4014 sg13cmos5l_xnor2_1_1.B a_18479_874# 0.04203f
C4015 a_27952_7138# a_27601_6995# 0.01017f
C4016 a_5135_8507# VPWR 0.16997f
C4017 sg13cmos5l_nor4_2_1.A sg13cmos5l_nand3_1_0.A 0.11764f
C4018 sg13cmos5l_dfrbpq_1_13.RESET_B sg13cmos5l_xnor2_1_0.Y 0.08852f
C4019 a_15525_7691# a_16273_8041# 0.01058f
C4020 sg13cmos5l_dlygate4sd3_1_30.A sg13cmos5l_dfrbpq_1_16.Q 0.6437f
C4021 sg13cmos5l_dfrbpq_1_38.Q a_19246_6435# 0.03284f
C4022 sg13cmos5l_buf_8_4.A sg13cmos5l_and2_1_3.A 0.09391f
C4023 a_10308_1188# VPWR 0.07298f
C4024 sg13cmos5l_nor3_1_4.A a_15041_6434# 0.05349f
C4025 sg13cmos5l_dfrbpq_1_56.RESET_B a_15686_6606# 0.12627f
C4026 sg13cmos5l_dlygate4sd3_1_21.X a_1985_1898# 0.01662f
C4027 sg13cmos5l_buf_1_0.X a_23661_2428# 0.35426f
C4028 sg13cmos5l_nor3_1_4.A a_14926_6435# 0.01717f
C4029 a_10791_3231# VPWR 0.20981f
C4030 sg13cmos5l_nor4_2_5.C a_6604_8430# 0.01271f
C4031 sg13cmos5l_buf_1_0.A VPWR 2.41425f
C4032 sg13cmos5l_dlygate4sd3_1_40.A a_28936_5538# 0.0725f
C4033 a_6604_3894# a_6862_3894# 0.01017f
C4034 sg13cmos5l_dfrbpq_1_56.RESET_B a_16167_4743# 0.56968f
C4035 a_20805_6179# VPWR 0.24164f
C4036 sg13cmos5l_nor4_2_9.D a_6551_5797# 0.31021f
C4037 sg13cmos5l_dfrbpq_1_13.RESET_B a_8759_1679# 0.10951f
C4038 a_25360_7138# a_25770_7216# 0.1396f
C4039 a_5855_5676# a_6551_5797# 0.02431f
C4040 sg13cmos5l_dlygate4sd3_1_51.X a_23368_5538# 0.03352f
C4041 sg13cmos5l_buf_8_0.X a_14938_4620# 0.01153f
C4042 a_24902_3894# a_25188_4212# 0.50066f
C4043 a_18363_6922# en[4] 0.03283f
C4044 sg13cmos5l_buf_8_2.X sg13cmos5l_nor3_1_0.B 0.35895f
C4045 a_2016_4209# sg13cmos5l_dfrbpq_1_18.D 0.23524f
C4046 a_27695_6995# VPWR 0.17214f
C4047 a_18372_2700# a_18660_2395# 0.4806f
C4048 sg13cmos5l_dfrbpq_1_56.D a_17231_6529# 0.02341f
C4049 sg13cmos5l_nand3_1_2.A a_23844_7236# 0.01974f
C4050 sg13cmos5l_dfrbpq_1_13.RESET_B sg13cmos5l_xnor2_1_6.Y 0.02386f
C4051 sg13cmos5l_dlygate4sd3_1_9.X a_24170_5704# 0.1016f
C4052 sg13cmos5l_xnor2_1_13.Y sg13cmos5l_dfrbpq_1_23.D 0.02838f
C4053 a_3905_1898# VPWR 0.24487f
C4054 a_13288_7766# VPWR 0.15071f
C4055 a_3304_2514# a_3488_2514# 0.11523f
C4056 sg13cmos5l_dfrbpq_1_13.Q a_4359_2600# 0.02609f
C4057 a_3680_2557# a_4012_2382# 0.1396f
C4058 sg13cmos5l_nand3_1_1.Y sg13cmos5l_dfrbpq_1_23.D 1.27741f
C4059 sg13cmos5l_dfrbpq_1_57.RESET_B sg13cmos5l_buf_8_5.A 0.62152f
C4060 sg13cmos5l_dfrbpq_1_39.Q a_18843_5410# 0.05083f
C4061 sg13cmos5l_dfrbpq_1_57.RESET_B a_11639_6215# 0.12202f
C4062 sg13cmos5l_nor4_2_9.D sg13cmos5l_xnor2_1_5.Y 0.05623f
C4063 sg13cmos5l_nor3_1_0.C a_18538_3112# 0.01159f
C4064 sg13cmos5l_buf_1_4.A a_19947_992# 0.01533f
C4065 sg13cmos5l_dfrbpq_1_56.CLK sg13cmos5l_nor3_1_4.A 0.03133f
C4066 sg13cmos5l_dlygate4sd3_1_11.A a_28174_5595# 0.05514f
C4067 a_5626_6886# sg13cmos5l_dfrbpq_1_58.D 0.01583f
C4068 sg13cmos5l_dfrbpq_1_0.D a_28374_1656# 0.19775f
C4069 sg13cmos5l_dfrbpq_1_55.RESET_B a_13860_2700# 0.48259f
C4070 a_10444_6606# VPWR 0.18692f
C4071 a_26346_2680# a_26830_2571# 0.03282f
C4072 a_14235_6922# a_15041_6434# 0.01684f
C4073 a_14277_2361# a_14148_2395# 0.01562f
C4074 sg13cmos5l_dfrbpq_1_17.Q VPWR 0.38983f
C4075 sg13cmos5l_dfrbpq_1_57.RESET_B a_14235_6922# 0.05525f
C4076 sg13cmos5l_dfrbpq_1_56.D a_17680_5626# 0.04005f
C4077 a_16624_7922# a_17034_7680# 0.1396f
C4078 sg13cmos5l_dfrbpq_1_57.CLK a_10022_6918# 0.02156f
C4079 sg13cmos5l_dfrbpq_1_56.RESET_B a_16491_6179# 0.55306f
C4080 sg13cmos5l_dlygate4sd3_1_52.A sg13cmos5l_and2_1_3.A 0.01321f
C4081 sg13cmos5l_nand3_1_2.A sg13cmos5l_nand3_1_2.C 0.06303f
C4082 a_24586_6136# VPWR 0.09622f
C4083 sg13cmos5l_dlygate4sd3_1_17.X a_28936_5538# 0.0132f
C4084 a_20102_5406# a_20907_5528# 0.11742f
C4085 a_20388_5724# a_20805_5385# 0.48921f
C4086 a_9915_3898# sg13cmos5l_dlygate4sd3_1_22.X 0.04521f
C4087 a_9562_3862# sg13cmos5l_dlygate4sd3_1_18.X 0.06467f
C4088 a_17472_1671# a_17621_2002# 0.3658f
C4089 a_26150_6918# a_26853_6897# 0.02453f
C4090 a_19638_8498# sg13cmos5l_dfrbpq_1_46.D 0.19375f
C4091 sg13cmos5l_dlygate4sd3_1_52.A sg13cmos5l_dlygate4sd3_1_28.X 0.45382f
C4092 sg13cmos5l_nand3_1_1.A a_13676_7680# 0.04872f
C4093 sg13cmos5l_dfrbpq_1_13.RESET_B sg13cmos5l_xnor2_1_2.Y 0.14815f
C4094 a_27114_4192# sg13cmos5l_dlygate4sd3_1_2.A 0.13303f
C4095 sg13cmos5l_dfrbpq_1_22.D a_14379_3155# 0.01492f
C4096 a_21647_6529# VPWR 0.17146f
C4097 a_7696_6410# a_7439_6529# 0.40419f
C4098 sg13cmos5l_buf_1_0.A sg13cmos5l_nor3_1_1.A 0.02288f
C4099 sg13cmos5l_xnor2_1_2.B a_16469_2002# 0.01479f
C4100 a_5143_5370# a_5614_5406# 0.32273f
C4101 sg13cmos5l_dfrbpq_1_58.Q sg13cmos5l_dfrbpq_1_21.CLK 0.16029f
C4102 sg13cmos5l_dfrbpq_1_21.Q a_3488_2514# 0.01341f
C4103 a_15119_3505# a_15786_3144# 0.13494f
C4104 a_15376_3386# a_15025_3505# 0.01017f
C4105 sg13cmos5l_dfrbpq_1_21.RESET_B a_4293_8409# 0.08229f
C4106 a_18497_6434# VPWR 0.24283f
C4107 a_14364_1993# a_15191_1679# 0.50066f
C4108 sg13cmos5l_dlygate4sd3_1_35.A a_4395_8552# 0.01341f
C4109 sg13cmos5l_nor4_2_1.A a_20102_5094# 0.04554f
C4110 a_4366_7107# VPWR 0.2129f
C4111 sg13cmos5l_nor3_1_1.Y a_10022_870# 0.0218f
C4112 a_5143_5370# VPWR 0.17297f
C4113 sg13cmos5l_nand3_1_2.C a_24326_6606# 0.01335f
C4114 sg13cmos5l_dfrbpq_1_57.D sg13cmos5l_dfrbpq_1_17.D 0.37098f
C4115 sg13cmos5l_dfrbpq_1_2.D a_21174_1656# 0.03512f
C4116 sg13cmos5l_xor2_1_2.A sg13cmos5l_and2_1_3.A 0.11479f
C4117 a_6391_834# a_6972_834# 0.01741f
C4118 sg13cmos5l_buf_1_4.A a_20687_947# 0.01293f
C4119 a_19402_1093# a_19428_1188# 0.43042f
C4120 sg13cmos5l_xnor2_1_9.A a_2016_7233# 0.1283f
C4121 a_10943_6139# VPWR 0.24242f
C4122 sg13cmos5l_nor3_1_4.B a_15041_6434# 0.02279f
C4123 a_17510_3894# VPWR 0.9292f
C4124 a_3304_4742# a_3488_4742# 0.11523f
C4125 a_5532_5017# a_5511_4743# 0.38902f
C4126 sg13cmos5l_xor2_1_2.A sg13cmos5l_dlygate4sd3_1_28.X 0.01822f
C4127 sg13cmos5l_nor4_2_0.B a_23846_1632# 0.06551f
C4128 sg13cmos5l_xnor2_1_13.Y sg13cmos5l_nand3_1_1.Y 0.06808f
C4129 a_20102_6606# a_20388_6172# 0.50066f
C4130 sg13cmos5l_dlygate4sd3_1_6.X a_21647_8507# 0.0189f
C4131 sg13cmos5l_buf_1_4.A sg13cmos5l_nand3_1_0.B 0.1878f
C4132 sg13cmos5l_buf_8_10.A a_18497_6434# 0.01792f
C4133 sg13cmos5l_dfrbpq_1_18.D a_5340_1993# 0.01651f
C4134 a_10022_5406# a_10827_5528# 0.11742f
C4135 a_10308_5724# a_10725_5385# 0.48921f
C4136 a_16485_6897# VPWR 0.24454f
C4137 a_13745_3948# sg13cmos5l_xnor2_1_5.A 0.2737f
C4138 sg13cmos5l_dfrbpq_1_56.RESET_B a_15525_7691# 0.04369f
C4139 a_19642_6132# sg13cmos5l_dfrbpq_1_39.Q 0.52159f
C4140 sg13cmos5l_dlygate4sd3_1_17.A a_27994_3862# 0.01056f
C4141 a_26128_6410# VPWR 0.18701f
C4142 a_20907_5528# a_21647_5483# 0.3087f
C4143 a_5135_8507# a_5802_8728# 0.13494f
C4144 sg13cmos5l_dfrbpq_1_18.D a_2266_2350# 0.0564f
C4145 sg13cmos5l_dfrbpq_1_21.Q a_1784_3185# 0.51852f
C4146 sg13cmos5l_buf_1_0.A sg13cmos5l_dfrbpq_1_16.Q 0.01394f
C4147 a_15850_3862# a_16184_3185# 0.01537f
C4148 sg13cmos5l_dfrbpq_1_12.D a_808_3230# 0.04469f
C4149 sg13cmos5l_dlygate4sd3_1_17.A a_27690_5704# 0.04892f
C4150 a_8106_6168# sg13cmos5l_dlygate4sd3_1_58.A 0.15916f
C4151 a_17796_4212# osc 0.01125f
C4152 sg13cmos5l_dlygate4sd3_1_0.X a_28256_1002# 0.0152f
C4153 sg13cmos5l_nor4_2_9.D sg13cmos5l_dfrbpq_1_23.D 0.05763f
C4154 sg13cmos5l_buf_8_0.X sg13cmos5l_dfrbpq_1_17.D 0.01606f
C4155 sg13cmos5l_dfrbpq_1_21.RESET_B a_6165_7727# 0.34883f
C4156 a_8133_2361# a_8881_2459# 0.01058f
C4157 a_9232_2602# a_9642_2680# 0.1396f
C4158 sg13cmos5l_dlygate4sd3_1_22.X a_7893_1028# 0.01103f
C4159 sg13cmos5l_dfrbpq_1_56.D a_18382_6435# 0.20067f
C4160 a_24170_8728# sg13cmos5l_nand3_1_2.A 0.37631f
C4161 sg13cmos5l_buf_1_0.X en[4] 0.39312f
C4162 sg13cmos5l_dfrbpq_1_21.RESET_B a_4544_7967# 0.04776f
C4163 a_6359_4703# sg13cmos5l_nand3_1_3.Y 0.01348f
C4164 a_11567_1993# a_11567_947# 0.02404f
C4165 sg13cmos5l_dfrbpq_1_56.CLK sg13cmos5l_nor3_1_4.B 3.49732f
C4166 sg13cmos5l_buf_1_2.A sg13cmos5l_dfrbpq_1_55.D 0.05753f
C4167 sg13cmos5l_dlygate4sd3_1_35.A a_3850_8653# 0.01543f
C4168 sg13cmos5l_buf_8_11.A a_23835_8050# 1.07073f
C4169 sg13cmos5l_buf_8_10.A a_16485_6897# 0.01486f
C4170 sg13cmos5l_xnor2_1_4.Y a_28289_5596# 0.01977f
C4171 sg13cmos5l_nor4_2_1.A a_18144_4695# 0.12916f
C4172 sg13cmos5l_buf_1_0.A a_13783_1596# 0.01087f
C4173 sg13cmos5l_nor3_1_0.C sg13cmos5l_nand3_1_0.B 0.05135f
C4174 sg13cmos5l_xnor2_1_0.Y sg13cmos5l_xnor2_1_0.A 0.08908f
C4175 sg13cmos5l_dfrbpq_1_56.RESET_B sg13cmos5l_nor3_1_4.C 0.14927f
C4176 sg13cmos5l_buf_1_0.X a_28940_1596# 0.28945f
C4177 sg13cmos5l_nand3_1_2.C sg13cmos5l_dlygate4sd3_1_55.A 1.31579f
C4178 sg13cmos5l_buf_1_4.X sg13cmos5l_nor4_2_1.D 0.07649f
C4179 sg13cmos5l_dfrbpq_1_2.CLK a_19083_3155# 0.04644f
C4180 sg13cmos5l_dlygate4sd3_1_52.X VPWR 0.74115f
C4181 sg13cmos5l_nor4_2_0.C sg13cmos5l_nor4_2_0.B 0.6356f
C4182 sg13cmos5l_dlygate4sd3_1_11.A a_28289_5596# 0.03423f
C4183 a_7799_8821# sg13cmos5l_nor3_1_2.C 0.29958f
C4184 a_5532_5017# a_6453_4703# 0.43042f
C4185 sg13cmos5l_dlygate4sd3_1_6.X a_21647_3971# 0.03944f
C4186 a_29120_7766# VPWR 0.05607f
C4187 sg13cmos5l_dlygate4sd3_1_6.X sg13cmos5l_dlygate4sd3_1_47.A 0.58014f
C4188 sg13cmos5l_dlygate4sd3_1_18.A a_9446_874# 0.01919f
C4189 a_10827_5528# a_11824_5626# 0.06746f
C4190 a_10022_5406# a_10596_5419# 0.36169f
C4191 a_20907_8552# sg13cmos5l_dfrbpq_1_46.CLK 0.01965f
C4192 sg13cmos5l_nor3_1_0.Y VPWR 0.43694f
C4193 sg13cmos5l_nor3_1_0.C a_18372_2700# 0.01936f
C4194 a_18363_6922# VPWR 1.14122f
C4195 sg13cmos5l_dfrbpq_1_56.RESET_B a_15627_7691# 0.04509f
C4196 sg13cmos5l_buf_1_0.X a_21023_7188# 0.07176f
C4197 a_18951_1719# a_19103_1603# 0.66105f
C4198 sg13cmos5l_dfrbpq_1_21.Q sg13cmos5l_xnor2_1_6.A 0.51042f
C4199 sg13cmos5l_dfrbpq_1_12.D sg13cmos5l_dlygate4sd3_1_21.X 0.24985f
C4200 a_9558_6192# a_10112_6455# 0.03282f
C4201 sg13cmos5l_buf_1_11.A sg13cmos5l_dfrbpq_1_53.RESET_B 0.15463f
C4202 a_21904_5626# a_22314_5704# 0.1396f
C4203 a_27695_6995# a_28362_7216# 0.13494f
C4204 a_18778_6132# a_18497_6434# 0.33585f
C4205 sg13cmos5l_dfrbpq_1_13.RESET_B sg13cmos5l_nand3_1_3.Y 0.01375f
C4206 a_5392_8650# a_5041_8507# 0.01017f
C4207 a_16042_7141# VPWR 0.0964f
C4208 sg13cmos5l_buf_1_0.A a_25439_1603# 0.01668f
C4209 sg13cmos5l_xnor2_1_0.A sg13cmos5l_xnor2_1_6.Y 17.506f
C4210 a_20080_3386# a_19823_3505# 0.40419f
C4211 a_20298_2680# VPWR 0.48729f
C4212 sg13cmos5l_dfrbpq_1_21.CLK a_6250_3108# 1.04282f
C4213 sg13cmos5l_xnor2_1_0.Y a_15322_838# 0.06731f
C4214 sg13cmos5l_dfrbpq_1_13.RESET_B a_7893_1028# 0.355f
C4215 sg13cmos5l_nor3_1_4.A sg13cmos5l_nand3_1_1.B 0.01358f
C4216 a_10791_2600# a_11639_2773# 0.11742f
C4217 sg13cmos5l_dlygate4sd3_1_40.A sg13cmos5l_dlygate4sd3_1_9.X 0.15457f
C4218 sg13cmos5l_buf_1_4.X a_25509_849# 0.05383f
C4219 sg13cmos5l_dfrbpq_1_21.RESET_B a_7332_7684# 0.50772f
C4220 sg13cmos5l_dfrbpq_1_13.CLK sg13cmos5l_dlygate4sd3_1_22.A 0.0308f
C4221 sg13cmos5l_dfrbpq_1_57.RESET_B a_15008_8605# 0.01249f
C4222 sg13cmos5l_buf_1_0.A sg13cmos5l_dlygate4sd3_1_34.A 0.11326f
C4223 sg13cmos5l_nand3_1_2.C a_24780_5596# 0.04915f
C4224 sg13cmos5l_nor4_2_5.C a_5223_7767# 0.02805f
C4225 a_3304_1002# VPWR 0.13859f
C4226 sg13cmos5l_dfrbpq_1_21.RESET_B sg13cmos5l_nor4_2_5.D 1.09769f
C4227 a_27280_8650# VPWR 0.18665f
C4228 sg13cmos5l_dfrbpq_1_56.RESET_B sg13cmos5l_xnor2_1_5.A 0.01908f
C4229 sg13cmos5l_dlygate4sd3_1_11.X a_24780_5596# 0.02089f
C4230 sg13cmos5l_xnor2_1_0.Y sg13cmos5l_dfrbpq_1_18.D 1.36344f
C4231 sg13cmos5l_buf_8_11.A a_25797_7691# 0.01678f
C4232 sg13cmos5l_buf_8_10.A a_18363_6922# 0.5282f
C4233 sg13cmos5l_buf_8_0.X a_18843_5410# 0.5335f
C4234 sg13cmos5l_dfrbpq_1_0.CLK a_26229_1679# 0.0119f
C4235 sg13cmos5l_xnor2_1_0.Y sg13cmos5l_nor3_1_1.Y 0.02701f
C4236 a_26447_3971# VPWR 0.17588f
C4237 sg13cmos5l_xnor2_1_13.Y sg13cmos5l_nor4_2_9.D 0.03704f
C4238 sg13cmos5l_nor4_2_5.C sg13cmos5l_nor3_1_2.B 0.17123f
C4239 sg13cmos5l_buf_8_10.A a_16042_7141# 0.01253f
C4240 a_19947_992# a_20944_1090# 0.06746f
C4241 sg13cmos5l_buf_1_4.X a_24420_2700# 0.02287f
C4242 sg13cmos5l_dfrbpq_1_37.D a_25738_5629# 0.01091f
C4243 sg13cmos5l_buf_1_11.A a_2054_8434# 0.01134f
C4244 a_5301_2540# VPWR 0.14287f
C4245 sg13cmos5l_nor4_2_9.D sg13cmos5l_nand3_1_1.Y 0.07303f
C4246 a_19055_3971# a_19722_4192# 0.13494f
C4247 sg13cmos5l_dfrbpq_1_18.D a_8759_1679# 0.29921f
C4248 sg13cmos5l_dfrbpq_1_21.RESET_B a_3850_3112# 0.33348f
C4249 a_20676_6593# a_20907_6179# 0.15089f
C4250 a_20805_6179# a_21553_6529# 0.01058f
C4251 sg13cmos5l_dfrbpq_1_53.RESET_B a_25354_7648# 0.34364f
C4252 sg13cmos5l_dfrbpq_1_56.RESET_B sg13cmos5l_buf_1_2.A 0.62436f
C4253 a_18380_7644# sg13cmos5l_buf_1_2.A 0.28897f
C4254 sg13cmos5l_dfrbpq_1_2.D a_18972_1993# 0.05172f
C4255 sg13cmos5l_dlygate4sd3_1_17.A sg13cmos5l_dlygate4sd3_1_4.A 0.01507f
C4256 sg13cmos5l_nor3_1_1.Y a_8759_1679# 0.03844f
C4257 a_6250_3108# sg13cmos5l_xnor2_1_6.A 0.02871f
C4258 sg13cmos5l_dfrbpq_1_56.RESET_B sg13cmos5l_dfrbpq_1_52.Q 0.01318f
C4259 sg13cmos5l_dlygate4sd3_1_57.A sg13cmos5l_dfrbpq_1_56.RESET_B 0.03201f
C4260 sg13cmos5l_dfrbpq_1_52.Q a_18380_7644# 0.03131f
C4261 sg13cmos5l_buf_1_0.X a_21813_7076# 0.3573f
C4262 sg13cmos5l_nor3_1_1.Y sg13cmos5l_xnor2_1_6.Y 2.74428f
C4263 sg13cmos5l_dfrbpq_1_55.RESET_B a_11639_2773# 0.11639f
C4264 sg13cmos5l_dfrbpq_1_57.RESET_B sg13cmos5l_and2_1_4.X 0.04351f
C4265 sg13cmos5l_dlygate4sd3_1_22.A a_4359_1088# 0.01557f
C4266 sg13cmos5l_dfrbpq_1_53.Q a_28570_5374# 0.05121f
C4267 sg13cmos5l_xnor2_1_0.A a_1301_874# 0.01829f
C4268 sg13cmos5l_xnor2_1_2.A sg13cmos5l_dfrbpq_1_55.RESET_B 0.02218f
C4269 sg13cmos5l_dlygate4sd3_1_9.X sg13cmos5l_dlygate4sd3_1_17.X 0.02157f
C4270 sg13cmos5l_and2_1_1.A a_18843_5410# 1.05679f
C4271 sg13cmos5l_xnor2_1_8.Y en[4] 1.19434f
C4272 sg13cmos5l_nand3_1_1.B a_13642_5374# 0.01348f
C4273 sg13cmos5l_dlygate4sd3_1_58.A sg13cmos5l_buf_8_9.A 0.08089f
C4274 a_13288_1718# VPWR 0.13817f
C4275 a_1664_7766# VPWR 0.06878f
C4276 sg13cmos5l_and2_1_1.X sg13cmos5l_nor4_2_0.B 0.24476f
C4277 sg13cmos5l_dfrbpq_1_3.Q sg13cmos5l_nand3_1_0.Y 0.02068f
C4278 sg13cmos5l_dlygate4sd3_1_17.A VPWR 0.87618f
C4279 a_22314_4656# VPWR 0.46312f
C4280 sg13cmos5l_nor3_1_4.B a_15414_5474# 0.02685f
C4281 a_18010_8398# sg13cmos5l_dfrbpq_1_47.Q 0.51763f
C4282 sg13cmos5l_nor3_1_1.Y a_17032_908# 0.01029f
C4283 a_24586_6136# a_25029_6179# 0.02241f
C4284 sg13cmos5l_nor4_2_5.C a_5244_8041# 0.03585f
C4285 sg13cmos5l_buf_1_0.X sg13cmos5l_dlygate4sd3_1_4.A 0.01506f
C4286 sg13cmos5l_dfrbpq_1_57.RESET_B a_10827_8552# 0.55322f
C4287 sg13cmos5l_dlygate4sd3_1_55.X sg13cmos5l_nand3_1_2.A 0.52093f
C4288 a_3876_4212# a_4395_4016# 0.38902f
C4289 a_4358_5410# a_4470_5474# 0.67711f
C4290 sg13cmos5l_dlygate4sd3_1_18.A VPWR 0.57474f
C4291 sg13cmos5l_buf_1_4.A a_25611_992# 0.02061f
C4292 a_18363_6922# a_18778_6132# 0.01538f
C4293 a_20687_947# a_20944_1090# 0.40419f
C4294 sg13cmos5l_dfrbpq_1_55.RESET_B a_14343_1719# 0.55322f
C4295 a_26135_1679# VPWR 0.92718f
C4296 sg13cmos5l_dfrbpq_1_53.RESET_B a_8591_8041# 0.01342f
C4297 a_20907_4016# sg13cmos5l_dfrbpq_1_0.CLK 0.04146f
C4298 sg13cmos5l_buf_1_1.X a_21647_3971# 0.19903f
C4299 sg13cmos5l_dlygate4sd3_1_20.A VPWR 0.68947f
C4300 sg13cmos5l_nand3_1_2.C sg13cmos5l_xnor2_1_4.B 0.12665f
C4301 sg13cmos5l_buf_8_11.A a_20892_8041# 0.02486f
C4302 a_27990_2450# a_28506_2578# 0.03406f
C4303 a_21647_6529# a_21553_6529# 0.32273f
C4304 sg13cmos5l_dfrbpq_1_53.RESET_B a_26639_8041# 0.20509f
C4305 a_23576_3898# a_23576_3185# 0.02325f
C4306 sg13cmos5l_dfrbpq_1_0.CLK a_25419_3155# 0.0665f
C4307 sg13cmos5l_dlygate4sd3_1_11.X sg13cmos5l_xnor2_1_4.B 0.1473f
C4308 sg13cmos5l_xnor2_1_12.B sg13cmos5l_nand3_1_3.Y 6.18581f
C4309 sg13cmos5l_buf_8_2.X a_19729_3505# 0.01978f
C4310 sg13cmos5l_buf_1_0.A sg13cmos5l_xnor2_1_6.A 0.01622f
C4311 sg13cmos5l_dfrbpq_1_42.Q sg13cmos5l_dfrbpq_1_53.RESET_B 0.04447f
C4312 sg13cmos5l_dfrbpq_1_53.Q sg13cmos5l_nand3_1_2.C 0.05171f
C4313 sg13cmos5l_xnor2_1_9.A sg13cmos5l_xnor2_1_13.Y 0.57667f
C4314 sg13cmos5l_buf_1_1.X a_24939_2504# 0.5521f
C4315 a_25419_3155# a_26416_3386# 0.07014f
C4316 sg13cmos5l_dfrbpq_1_53.Q sg13cmos5l_dlygate4sd3_1_11.X 0.0309f
C4317 a_10812_6529# a_11594_6448# 0.4806f
C4318 sg13cmos5l_nor3_1_4.B sg13cmos5l_nand3_1_1.B 0.01631f
C4319 sg13cmos5l_buf_1_4.A sg13cmos5l_dfrbpq_1_3.D 0.02466f
C4320 sg13cmos5l_dlygate4sd3_1_19.X VPWR 1.58999f
C4321 sg13cmos5l_dfrbpq_1_53.RESET_B a_26283_4667# 0.55328f
C4322 sg13cmos5l_buf_1_0.X VPWR 10.4966f
C4323 a_6391_8394# a_6604_8430# 0.40419f
C4324 sg13cmos5l_dfrbpq_1_32.CLK a_8763_8434# 1.06698f
C4325 sg13cmos5l_dfrbpq_1_53.RESET_B a_20311_7644# 0.01247f
C4326 sg13cmos5l_buf_1_4.A sg13cmos5l_dlygate4sd3_1_18.X 0.04156f
C4327 sg13cmos5l_dfrbpq_1_21.RESET_B sg13cmos5l_dfrbpq_1_15.D 0.12688f
C4328 sg13cmos5l_buf_8_4.A a_6972_3858# 0.05115f
C4329 a_3590_8430# VPWR 0.92874f
C4330 sg13cmos5l_xnor2_1_4.A sg13cmos5l_nor4_2_7.D 0.01548f
C4331 sg13cmos5l_xnor2_1_8.Y sg13cmos5l_dfrbpq_1_23.Q 0.03101f
C4332 sg13cmos5l_xnor2_1_2.B sg13cmos5l_dfrbpq_1_46.CLK 0.01043f
C4333 sg13cmos5l_xnor2_1_6.B a_1190_1632# 0.02464f
C4334 sg13cmos5l_buf_1_0.A a_24608_1919# 0.01056f
C4335 sg13cmos5l_dfrbpq_1_53.RESET_B a_26283_8552# 0.55329f
C4336 a_14495_1603# a_13563_874# 0.01615f
C4337 a_9558_3168# VPWR 0.21505f
C4338 a_27610_1596# a_27329_1898# 0.33585f
C4339 sg13cmos5l_xnor2_1_5.A a_17135_2386# 0.01069f
C4340 sg13cmos5l_xnor2_1_2.B a_16566_3168# 0.05119f
C4341 a_10022_870# a_10596_883# 0.36169f
C4342 a_10827_992# a_11824_1090# 0.06746f
C4343 a_24612_6172# a_25871_6529# 0.01741f
C4344 sg13cmos5l_dfrbpq_1_53.CLK a_25764_5724# 0.11329f
C4345 sg13cmos5l_dfrbpq_1_21.RESET_B a_7893_4052# 0.36424f
C4346 sg13cmos5l_nor4_2_9.D a_5855_5676# 0.02341f
C4347 sg13cmos5l_dlygate4sd3_1_17.X sg13cmos5l_xnor2_1_4.Y 0.026f
C4348 sg13cmos5l_dfrbpq_1_13.RESET_B a_6167_1679# 0.12312f
C4349 a_26896_7922# en[4] 0.0111f
C4350 a_9281_4084# a_9176_3185# 0.01201f
C4351 sg13cmos5l_buf_8_3.A a_6250_3108# 0.04377f
C4352 sg13cmos5l_xnor2_1_0.A a_15791_874# 0.02066f
C4353 sg13cmos5l_and2_1_1.A a_19642_6132# 0.06901f
C4354 sg13cmos5l_dfrbpq_1_11.CLK a_10308_1188# 0.07591f
C4355 a_20944_1090# a_20593_947# 0.01017f
C4356 sg13cmos5l_dlygate4sd3_1_47.A sg13cmos5l_xnor2_1_4.A 0.02567f
C4357 sg13cmos5l_dfrbpq_1_56.RESET_B a_16068_7236# 0.51821f
C4358 sg13cmos5l_buf_1_0.A sg13cmos5l_dlygate4sd3_1_19.A 2.29809f
C4359 sg13cmos5l_buf_8_11.A sg13cmos5l_and2_1_1.X 0.13505f
C4360 a_10791_3231# sg13cmos5l_dfrbpq_1_11.CLK 0.04229f
C4361 a_10702_3582# a_10943_3115# 0.01058f
C4362 sg13cmos5l_dfrbpq_1_0.CLK a_25308_1993# 0.10977f
C4363 sg13cmos5l_dlygate4sd3_1_17.X sg13cmos5l_dlygate4sd3_1_11.A 0.92775f
C4364 a_16535_8821# a_16629_8588# 0.87117f
C4365 sg13cmos5l_buf_8_11.A sg13cmos5l_xnor2_1_10.Y 0.029f
C4366 sg13cmos5l_buf_8_2.X a_26826_3144# 0.0472f
C4367 sg13cmos5l_nor3_1_4.B sg13cmos5l_dfrbpq_1_39.Q 0.01699f
C4368 sg13cmos5l_buf_1_0.A sg13cmos5l_dfrbpq_1_11.CLK 0.06494f
C4369 sg13cmos5l_buf_1_4.A sg13cmos5l_dfrbpq_1_2.CLK 0.03093f
C4370 sg13cmos5l_buf_1_2.A a_17135_2386# 0.01201f
C4371 a_27226_2350# VPWR 0.37122f
C4372 sg13cmos5l_buf_8_4.A a_9176_6209# 0.06205f
C4373 a_19103_1603# a_19799_1679# 0.02453f
C4374 sg13cmos5l_dfrbpq_1_53.RESET_B a_20871_7767# 0.01088f
C4375 sg13cmos5l_buf_1_1.X sg13cmos5l_xnor2_1_1.B 0.0229f
C4376 a_26181_8409# en[4] 0.03094f
C4377 sg13cmos5l_buf_8_4.A sg13cmos5l_dlygate4sd3_1_58.A 0.12318f
C4378 a_24420_2700# a_25679_2459# 0.01741f
C4379 sg13cmos5l_dlygate4sd3_1_17.A a_26853_6897# 0.01011f
C4380 a_13574_2382# a_14379_2504# 0.11742f
C4381 a_13860_2700# a_14277_2361# 0.48921f
C4382 sg13cmos5l_xor2_1_2.A a_14720_7766# 0.07191f
C4383 sg13cmos5l_dlygate4sd3_1_31.X sg13cmos5l_nor3_1_2.Y 0.56698f
C4384 sg13cmos5l_dfrbpq_1_46.D a_19609_6942# 0.0305f
C4385 sg13cmos5l_dfrbpq_1_18.D a_2266_1596# 0.04051f
C4386 a_7799_4285# VPWR 0.92847f
C4387 sg13cmos5l_dfrbpq_1_13.CLK a_7103_1140# 0.36139f
C4388 sg13cmos5l_buf_1_4.A a_11567_947# 0.0156f
C4389 sg13cmos5l_dfrbpq_1_58.RESET_B en[4] 0.02361f
C4390 sg13cmos5l_dlygate4sd3_1_55.X sg13cmos5l_dlygate4sd3_1_55.A 0.03035f
C4391 a_3608_7721# VPWR 0.33536f
C4392 sg13cmos5l_buf_1_0.X a_20362_5629# 0.3467f
C4393 a_808_8562# VPWR 0.12807f
C4394 a_26128_6410# a_26538_6168# 0.1396f
C4395 a_23958_4680# VPWR 0.21304f
C4396 sg13cmos5l_xnor2_1_4.A a_26704_4114# 0.04089f
C4397 sg13cmos5l_dfrbpq_1_2.CLK sg13cmos5l_nor3_1_0.C 2.50027f
C4398 sg13cmos5l_xnor2_1_5.Y sg13cmos5l_xnor2_1_2.Y 0.0636f
C4399 a_25188_4212# a_26447_3971# 0.01741f
C4400 sg13cmos5l_dfrbpq_1_22.D a_10943_3115# 0.0204f
C4401 sg13cmos5l_buf_8_3.A a_10791_3231# 0.01501f
C4402 sg13cmos5l_buf_1_0.A sg13cmos5l_buf_8_3.A 0.02007f
C4403 sg13cmos5l_dfrbpq_1_22.D sg13cmos5l_dfrbpq_1_59.Q 0.21923f
C4404 sg13cmos5l_nand3_1_3.Y sg13cmos5l_dfrbpq_1_18.D 0.01679f
C4405 a_21647_5483# a_21647_5017# 0.03431f
C4406 a_13664_1919# a_13472_1718# 0.03403f
C4407 sg13cmos5l_nand3_1_3.Y sg13cmos5l_nor3_1_1.Y 0.02811f
C4408 a_4511_2652# a_5207_2773# 0.02431f
C4409 sg13cmos5l_dfrbpq_1_56.D a_18144_4695# 0.02398f
C4410 sg13cmos5l_xnor2_1_9.A sg13cmos5l_nor4_2_9.D 0.07974f
C4411 a_26955_7040# a_27784_6254# 0.01056f
C4412 sg13cmos5l_buf_1_0.A a_2920_7680# 0.34143f
C4413 sg13cmos5l_dfrbpq_1_2.CLK a_19893_1679# 0.0488f
C4414 sg13cmos5l_nand3_1_0.B a_24170_1168# 0.37552f
C4415 sg13cmos5l_xnor2_1_8.Y VPWR 0.84652f
C4416 sg13cmos5l_dlygate4sd3_1_16.A VPWR 0.66647f
C4417 sg13cmos5l_dfrbpq_1_57.RESET_B a_10112_7967# 0.02304f
C4418 sg13cmos5l_nor4_2_5.D sg13cmos5l_dfrbpq_1_58.Q 0.17073f
C4419 sg13cmos5l_nor3_1_4.A sg13cmos5l_buf_8_0.X 0.01707f
C4420 sg13cmos5l_xnor2_1_4.A a_25380_7684# 0.05168f
C4421 a_4380_834# a_4270_870# 0.4858f
C4422 sg13cmos5l_dlygate4sd3_1_19.X sg13cmos5l_dfrbpq_1_16.Q 0.03684f
C4423 sg13cmos5l_buf_8_4.A a_9446_6168# 0.04132f
C4424 sg13cmos5l_buf_1_4.A a_26159_3505# 0.01495f
C4425 sg13cmos5l_nor3_1_2.C a_7749_7691# 0.01763f
C4426 sg13cmos5l_dfrbpq_1_57.D a_14235_6922# 0.12766f
C4427 sg13cmos5l_dlygate4sd3_1_6.X a_20102_8430# 0.31115f
C4428 sg13cmos5l_dfrbpq_1_11.Q VPWR 0.71171f
C4429 a_14938_4620# a_14742_3962# 0.01091f
C4430 sg13cmos5l_xnor2_1_4.A a_25738_4624# 0.01791f
C4431 a_17432_3185# VPWR 0.34135f
C4432 sg13cmos5l_dfrbpq_1_57.D a_13642_5374# 0.04925f
C4433 a_3304_7766# VPWR 0.12322f
C4434 sg13cmos5l_dfrbpq_1_7.Q a_28524_3410# 0.04473f
C4435 a_17327_6995# a_17584_7138# 0.40419f
C4436 a_16485_6897# a_16356_6931# 0.01562f
C4437 sg13cmos5l_dfrbpq_1_58.RESET_B sg13cmos5l_dfrbpq_1_23.Q 0.24997f
C4438 a_23368_4742# a_23368_4026# 0.01275f
C4439 sg13cmos5l_dfrbpq_1_17.Q sg13cmos5l_buf_8_3.A 0.06409f
C4440 sg13cmos5l_dlygate4sd3_1_18.X a_11488_4192# 0.05806f
C4441 a_9915_3898# sg13cmos5l_nand3_1_3.B 0.01935f
C4442 sg13cmos5l_nor4_2_5.C sg13cmos5l_dlygate4sd3_1_38.A 0.01076f
C4443 a_10812_2346# a_10702_2382# 0.4858f
C4444 sg13cmos5l_xnor2_1_8.Y sg13cmos5l_buf_8_10.A 0.01825f
C4445 sg13cmos5l_dfrbpq_1_12.Q a_14277_3155# 0.02169f
C4446 sg13cmos5l_dfrbpq_1_22.D a_16184_3185# 0.03439f
C4447 sg13cmos5l_nor3_1_4.B a_15782_6918# 0.30401f
C4448 sg13cmos5l_buf_1_0.A a_21742_1899# 0.01059f
C4449 sg13cmos5l_dfrbpq_1_13.RESET_B a_10827_1643# 0.57916f
C4450 a_25478_5094# VPWR 0.92845f
C4451 sg13cmos5l_xnor2_1_2.A sg13cmos5l_dfrbpq_1_57.Q 0.03999f
C4452 sg13cmos5l_nor4_2_0.D a_24704_1002# 0.10467f
C4453 a_16270_2571# VPWR 0.24281f
C4454 sg13cmos5l_dfrbpq_1_58.RESET_B a_6645_5564# 0.3576f
C4455 sg13cmos5l_nor4_2_5.D a_5894_6606# 0.29144f
C4456 sg13cmos5l_dfrbpq_1_13.CLK a_8133_2361# 0.36693f
C4457 a_7690_2605# a_7716_2700# 0.43042f
C4458 a_25439_1603# a_26135_1679# 0.02453f
C4459 sg13cmos5l_xnor2_1_13.A a_2016_4695# 0.14062f
C4460 a_10112_4943# a_10231_4620# 0.13494f
C4461 a_7930_4620# a_7649_4922# 0.33585f
C4462 sg13cmos5l_dlygate4sd3_1_21.A a_1190_1632# 0.01185f
C4463 sg13cmos5l_xor2_1_2.A a_13745_3948# 0.09262f
C4464 sg13cmos5l_buf_1_4.X VPWR 9.99053f
C4465 sg13cmos5l_dfrbpq_1_37.D a_24261_6897# 0.04059f
C4466 a_2920_6956# sg13cmos5l_dfrbpq_1_58.RESET_B 0.28943f
C4467 sg13cmos5l_dfrbpq_1_46.CLK sg13cmos5l_dfrbpq_1_2.CLK 0.01239f
C4468 sg13cmos5l_nor3_1_2.Y a_1509_7216# 0.0292f
C4469 sg13cmos5l_dlygate4sd3_1_9.X a_27137_6434# 0.01556f
C4470 a_13642_5374# sg13cmos5l_buf_8_0.X 0.5252f
C4471 sg13cmos5l_dlygate4sd3_1_23.X a_3590_3894# 0.0259f
C4472 a_19055_3971# VPWR 0.17461f
C4473 sg13cmos5l_dlygate4sd3_1_6.A a_19312_4114# 0.01321f
C4474 sg13cmos5l_dfrbpq_1_0.CLK sg13cmos5l_nor4_2_0.B 0.02095f
C4475 a_6951_8648# a_7799_8821# 0.11742f
C4476 a_8848_7922# VPWR 0.18756f
C4477 sg13cmos5l_dlygate4sd3_1_9.A a_28174_4923# 0.02938f
C4478 a_26896_7922# VPWR 0.18664f
C4479 a_17584_7138# a_17233_6995# 0.01017f
C4480 a_19256_8434# VPWR 0.32689f
C4481 sg13cmos5l_dlygate4sd3_1_55.X sg13cmos5l_xnor2_1_4.B 0.03267f
C4482 a_18391_1596# a_18862_2070# 0.32273f
C4483 a_13784_8434# sg13cmos5l_dfrbpq_1_35.Q 0.51764f
C4484 sg13cmos5l_xnor2_1_10.Y a_20892_6882# 0.02642f
C4485 sg13cmos5l_dfrbpq_1_11.Q a_15041_1060# 0.01779f
C4486 a_4395_8552# a_4164_8443# 0.15089f
C4487 a_3876_8748# a_5041_8507# 0.4858f
C4488 a_20388_4660# a_20805_4667# 0.49014f
C4489 sg13cmos5l_nand3_1_3.Y sg13cmos5l_nand3_1_3.B 0.44191f
C4490 sg13cmos5l_dfrbpq_1_57.CLK a_10308_5724# 0.10135f
C4491 sg13cmos5l_nand3_1_0.Y a_17621_2002# 0.01677f
C4492 sg13cmos5l_nor4_2_0.D a_26351_947# 0.01978f
C4493 sg13cmos5l_buf_1_5.A en[4] 0.02537f
C4494 sg13cmos5l_dfrbpq_1_58.RESET_B a_6795_7040# 0.55458f
C4495 a_20192_7967# VPWR 0.45201f
C4496 sg13cmos5l_buf_1_0.X a_25029_6179# 0.05318f
C4497 a_9642_2680# sg13cmos5l_dlygate4sd3_1_18.A 0.15529f
C4498 a_23872_1168# a_24170_1168# 0.42343f
C4499 sg13cmos5l_dfrbpq_1_13.CLK a_7232_1919# 0.05401f
C4500 sg13cmos5l_nor3_1_1.A a_16270_2571# 0.03937f
C4501 a_8591_8041# a_8842_6886# 0.02335f
C4502 sg13cmos5l_nor3_1_4.B sg13cmos5l_buf_8_0.X 0.01925f
C4503 a_26181_8409# VPWR 0.24048f
C4504 sg13cmos5l_buf_1_0.X sg13cmos5l_dlygate4sd3_1_51.X 1.53977f
C4505 sg13cmos5l_xnor2_1_8.Y sg13cmos5l_dfrbpq_1_16.Q 0.02946f
C4506 sg13cmos5l_buf_1_4.X sg13cmos5l_nor3_1_1.A 0.30198f
C4507 sg13cmos5l_dlygate4sd3_1_19.X a_1784_3185# 0.01123f
C4508 sg13cmos5l_dfrbpq_1_2.CLK a_18315_4016# 0.02958f
C4509 sg13cmos5l_dfrbpq_1_2.D sg13cmos5l_xnor2_1_3.A 1.16522f
C4510 sg13cmos5l_xnor2_1_3.A a_25308_1993# 0.02705f
C4511 sg13cmos5l_dfrbpq_1_58.RESET_B VPWR 5.74572f
C4512 sg13cmos5l_buf_1_4.A sg13cmos5l_xnor2_1_3.B 0.01782f
C4513 sg13cmos5l_dlygate4sd3_1_15.A VPWR 1.87972f
C4514 a_16319_4627# a_16970_4936# 0.01562f
C4515 sg13cmos5l_buf_1_1.X a_19142_870# 0.10865f
C4516 sg13cmos5l_xnor2_1_0.Y a_10812_2346# 0.01126f
C4517 sg13cmos5l_dlygate4sd3_1_19.X sg13cmos5l_dfrbpq_1_21.CLK 0.05981f
C4518 sg13cmos5l_dfrbpq_1_2.Q VPWR 0.62756f
C4519 a_10812_8041# VPWR 0.0761f
C4520 a_16270_2571# a_16385_2572# 0.67711f
C4521 a_17510_3894# a_17796_4212# 0.50066f
C4522 a_16643_1168# VPWR 0.01379f
C4523 sg13cmos5l_nor4_2_0.C sg13cmos5l_dfrbpq_1_0.D 0.34866f
C4524 sg13cmos5l_dfrbpq_1_58.RESET_B a_6154_6136# 0.32699f
C4525 sg13cmos5l_dlygate4sd3_1_4.A sg13cmos5l_dlygate4sd3_1_2.A 0.02945f
C4526 a_29120_4742# VPWR 0.05605f
C4527 sg13cmos5l_dlygate4sd3_1_34.A a_6026_7960# 0.0193f
C4528 a_20805_4667# a_20907_4667# 0.6663f
C4529 a_21719_7727# VPWR 0.95033f
C4530 sg13cmos5l_dfrbpq_1_3.Q a_18272_1919# 0.13351f
C4531 sg13cmos5l_dlygate4sd3_1_34.A a_3608_7721# 0.0107f
C4532 a_11824_1874# VPWR 0.18951f
C4533 a_25066_1093# a_25509_849# 0.02241f
C4534 a_10725_8409# a_10596_8443# 0.01562f
C4535 a_10812_5017# a_10943_4627# 0.48921f
C4536 sg13cmos5l_xnor2_1_3.B sg13cmos5l_nor3_1_0.C 0.21208f
C4537 a_4951_4620# VPWR 0.17447f
C4538 sg13cmos5l_dlygate4sd3_1_51.A a_23576_4697# 0.49655f
C4539 sg13cmos5l_buf_1_0.A sg13cmos5l_xnor2_1_1.B 1.10519f
C4540 sg13cmos5l_dlygate4sd3_1_19.X sg13cmos5l_xnor2_1_6.A 0.04778f
C4541 sg13cmos5l_buf_1_0.A sg13cmos5l_nor4_2_5.D 0.01546f
C4542 sg13cmos5l_buf_1_0.A a_15191_1679# 0.01183f
C4543 a_23861_6538# sg13cmos5l_xnor2_1_4.B 0.05503f
C4544 sg13cmos5l_dlygate4sd3_1_2.A VPWR 0.61834f
C4545 a_25308_1993# a_26090_1912# 0.4806f
C4546 sg13cmos5l_dfrbpq_1_37.D sg13cmos5l_nand3_1_2.A 0.84128f
C4547 a_18086_2382# a_18372_2700# 0.50066f
C4548 sg13cmos5l_xnor2_1_2.B sg13cmos5l_dfrbpq_1_55.RESET_B 0.02391f
C4549 a_10827_7040# a_10596_6931# 0.15089f
C4550 a_10308_7236# a_11473_6995# 0.4858f
C4551 a_11567_6995# a_11824_7138# 0.40419f
C4552 sg13cmos5l_dfrbpq_1_37.D sg13cmos5l_dlygate4sd3_1_39.X 0.32129f
C4553 sg13cmos5l_xnor2_1_3.B a_18444_1060# 0.42795f
C4554 a_18346_2605# a_18086_2382# 0.87117f
C4555 a_7690_2605# VPWR 0.14423f
C4556 a_15839_8700# a_15598_8430# 0.01058f
C4557 sg13cmos5l_nor4_2_1.A sg13cmos5l_dfrbpq_1_2.D 0.90004f
C4558 sg13cmos5l_nand3_1_2.Y sg13cmos5l_nor4_2_0.C 0.13825f
C4559 a_15119_3505# a_15119_2459# 0.02404f
C4560 sg13cmos5l_dfrbpq_1_12.D a_14926_1059# 0.19666f
C4561 sg13cmos5l_and2_1_1.A sg13cmos5l_buf_8_2.X 0.767f
C4562 sg13cmos5l_dfrbpq_1_23.Q a_6314_4936# 0.01198f
C4563 sg13cmos5l_xnor2_1_2.A a_9558_6192# 0.04649f
C4564 sg13cmos5l_dlygate4sd3_1_28.X a_10022_6918# 0.29917f
C4565 a_10282_7141# a_10308_7236# 0.43042f
C4566 sg13cmos5l_dfrbpq_1_21.RESET_B a_4164_3569# 0.02073f
C4567 a_14277_2361# a_14343_1719# 0.0167f
C4568 sg13cmos5l_dfrbpq_1_23.D sg13cmos5l_nand3_1_3.Y 6.40295f
C4569 a_28570_8398# sg13cmos5l_dfrbpq_1_53.Q 0.5286f
C4570 a_10282_1600# a_10308_1636# 0.43042f
C4571 sg13cmos5l_dfrbpq_1_46.D a_23558_6918# 0.02088f
C4572 sg13cmos5l_buf_1_0.A a_3850_3112# 0.03588f
C4573 a_25679_2459# VPWR 0.21404f
C4574 sg13cmos5l_dfrbpq_1_57.D sg13cmos5l_and2_1_4.X 0.30052f
C4575 sg13cmos5l_dfrbpq_1_58.RESET_B a_6468_6593# 0.02411f
C4576 sg13cmos5l_dlygate4sd3_1_51.X a_23958_4680# 0.20747f
C4577 sg13cmos5l_and2_1_1.X a_24363_7040# 0.05536f
C4578 a_27713_4084# osc 0.0106f
C4579 sg13cmos5l_xnor2_1_4.B sg13cmos5l_buf_8_2.X 0.11707f
C4580 a_20907_4667# a_21904_4898# 0.07014f
C4581 sg13cmos5l_buf_1_1.X a_19631_2459# 0.25712f
C4582 sg13cmos5l_dfrbpq_1_37.D a_24326_6606# 0.34686f
C4583 sg13cmos5l_dfrbpq_1_23.D a_5164_5094# 0.01017f
C4584 sg13cmos5l_dfrbpq_1_13.RESET_B a_10725_849# 0.0541f
C4585 a_23846_4656# a_23846_3898# 0.02196f
C4586 sg13cmos5l_dfrbpq_1_13.CLK a_10308_1636# 0.09195f
C4587 sg13cmos5l_dfrbpq_1_53.CLK a_26150_6918# 0.03789f
C4588 a_25092_1188# a_26351_947# 0.01741f
C4589 sg13cmos5l_dlygate4sd3_1_19.X sg13cmos5l_dlygate4sd3_1_19.A 0.01481f
C4590 a_10702_5094# a_10943_4627# 0.01058f
C4591 sg13cmos5l_buf_1_4.X a_25188_4212# 0.50397f
C4592 sg13cmos5l_buf_1_4.X a_25439_1603# 0.03642f
C4593 a_10282_1093# a_10308_1188# 0.43042f
C4594 sg13cmos5l_dlygate4sd3_1_38.A a_6250_7141# 0.01514f
C4595 sg13cmos5l_dfrbpq_1_53.Q a_27963_6538# 0.03038f
C4596 a_3590_3894# a_4164_3907# 0.36169f
C4597 sg13cmos5l_dfrbpq_1_21.RESET_B a_5135_3971# 0.19907f
C4598 a_11733_2540# VPWR 0.14226f
C4599 sg13cmos5l_buf_1_4.A a_26955_7040# 0.0394f
C4600 sg13cmos5l_dlygate4sd3_1_17.A a_27418_6132# 0.04085f
C4601 sg13cmos5l_dfrbpq_1_57.CLK sg13cmos5l_buf_8_5.A 0.03574f
C4602 sg13cmos5l_dlygate4sd3_1_39.A a_26955_7040# 0.01845f
C4603 a_20907_4016# a_20676_3907# 0.15089f
C4604 a_20388_4212# a_21553_3971# 0.4858f
C4605 sg13cmos5l_buf_1_4.A sg13cmos5l_dlygate4sd3_1_40.A 0.2637f
C4606 sg13cmos5l_dfrbpq_1_5.Q a_23368_4026# 0.07333f
C4607 sg13cmos5l_dlygate4sd3_1_39.A sg13cmos5l_dlygate4sd3_1_40.A 0.01789f
C4608 sg13cmos5l_nor3_1_0.B a_23958_3168# 0.19454f
C4609 sg13cmos5l_xnor2_1_13.Y a_2259_7216# 0.01001f
C4610 a_10231_3108# a_10702_3582# 0.32273f
C4611 a_10444_3582# sg13cmos5l_nor3_1_1.C 0.01016f
C4612 sg13cmos5l_dfrbpq_1_56.CLK a_15708_8394# 0.0963f
C4613 a_15839_8700# a_16535_8821# 0.02431f
C4614 sg13cmos5l_nor3_1_0.B a_24420_2700# 0.0483f
C4615 sg13cmos5l_nor4_2_7.B a_24261_6897# 0.01598f
C4616 sg13cmos5l_nor3_1_0.C a_18391_1596# 0.02619f
C4617 sg13cmos5l_buf_1_5.A VPWR 1.42403f
C4618 sg13cmos5l_nor3_1_0.A a_19845_849# 0.01081f
C4619 sg13cmos5l_nor4_2_5.D a_4366_7107# 0.03556f
C4620 sg13cmos5l_nor4_2_0.B sg13cmos5l_xnor2_1_3.A 0.01445f
C4621 a_19609_6942# a_20192_7093# 0.03694f
C4622 a_2016_5721# sg13cmos5l_xnor2_1_13.A 0.06971f
C4623 sg13cmos5l_xnor2_1_5.Y a_2259_5704# 0.01027f
C4624 sg13cmos5l_dfrbpq_1_37.D a_24900_6593# 0.01887f
C4625 a_18972_1993# a_19754_1912# 0.4806f
C4626 sg13cmos5l_dfrbpq_1_53.RESET_B sg13cmos5l_buf_8_11.A 0.90836f
C4627 sg13cmos5l_nor4_2_4.D sg13cmos5l_xor2_1_2.B 0.03259f
C4628 sg13cmos5l_xnor2_1_13.Y sg13cmos5l_nand3_1_3.Y 0.04476f
C4629 a_16320_1671# VPWR 0.26289f
C4630 sg13cmos5l_buf_1_4.A sg13cmos5l_dfrbpq_1_55.D 0.74646f
C4631 sg13cmos5l_dlygate4sd3_1_19.X sg13cmos5l_buf_8_3.A 0.02581f
C4632 sg13cmos5l_xnor2_1_4.B sg13cmos5l_dlygate4sd3_1_0.X 0.01438f
C4633 sg13cmos5l_and2_1_1.X sg13cmos5l_nand3_1_2.Y 0.05755f
C4634 sg13cmos5l_dlygate4sd3_1_51.X sg13cmos5l_buf_1_4.X 0.75214f
C4635 a_26351_947# a_27018_1168# 0.13494f
C4636 a_25092_1188# a_26257_947# 0.4858f
C4637 a_25611_992# a_25380_883# 0.15089f
C4638 sg13cmos5l_xnor2_1_2.A sg13cmos5l_nor3_1_4.A 0.02135f
C4639 sg13cmos5l_xnor2_1_0.Y sg13cmos5l_dfrbpq_1_12.Q 2.29659f
C4640 a_17729_8620# VPWR 0.24004f
C4641 sg13cmos5l_dfrbpq_1_37.D sg13cmos5l_dlygate4sd3_1_55.A 0.48797f
C4642 sg13cmos5l_dfrbpq_1_46.D a_20102_5406# 0.32656f
C4643 a_11594_4936# a_11639_4703# 0.36169f
C4644 a_7744_3144# VPWR 0.39618f
C4645 sg13cmos5l_xnor2_1_0.Y a_2016_4209# 0.43246f
C4646 sg13cmos5l_buf_1_11.A sg13cmos5l_xnor2_1_9.A 0.01811f
C4647 sg13cmos5l_buf_1_5.A sg13cmos5l_buf_8_10.A 0.11723f
C4648 sg13cmos5l_nand3_1_3.B sg13cmos5l_nor4_2_3.Y 0.11127f
C4649 sg13cmos5l_buf_1_4.A sg13cmos5l_dlygate4sd3_1_17.X 0.02138f
C4650 sg13cmos5l_dfrbpq_1_17.Q a_10112_3431# 0.13324f
C4651 sg13cmos5l_dfrbpq_1_53.RESET_B a_25478_5406# 0.12147f
C4652 a_11594_3424# a_11639_3191# 0.36169f
C4653 sg13cmos5l_dfrbpq_1_46.D a_20102_6606# 0.01189f
C4654 sg13cmos5l_nor3_1_1.C a_13860_3148# 0.01081f
C4655 a_2166_8498# a_2632_8562# 0.0311f
C4656 sg13cmos5l_xnor2_1_2.A a_11639_6215# 0.30583f
C4657 a_24608_1919# sg13cmos5l_dlygate4sd3_1_16.A 0.13332f
C4658 a_24727_1596# a_25308_1993# 0.01741f
C4659 sg13cmos5l_xnor2_1_3.B a_18315_4016# 0.05599f
C4660 sg13cmos5l_dlygate4sd3_1_35.A a_2054_8434# 0.01624f
C4661 a_25478_5406# a_26181_5385# 0.02453f
C4662 sg13cmos5l_nor4_2_7.B a_25770_7216# 0.01321f
C4663 a_21354_1168# VPWR 0.45254f
C4664 sg13cmos5l_dlygate4sd3_1_17.X a_28936_4742# 0.01231f
C4665 a_18922_7644# en[4] 0.01241f
C4666 sg13cmos5l_dfrbpq_1_46.D a_23872_8728# 0.03358f
C4667 a_9176_5410# a_9176_4697# 0.02325f
C4668 sg13cmos5l_dlygate4sd3_1_17.A sg13cmos5l_nor4_2_7.D 0.29583f
C4669 sg13cmos5l_dlygate4sd3_1_9.X a_27023_5017# 0.02202f
C4670 a_4511_1140# a_5207_1261# 0.02431f
C4671 a_27798_938# a_28256_1002# 0.03208f
C4672 sg13cmos5l_nor4_2_0.B sg13cmos5l_dlygate4sd3_1_1.A 0.21428f
C4673 sg13cmos5l_buf_1_0.X a_21647_8507# 0.24554f
C4674 a_15008_8605# a_15127_8394# 0.13494f
C4675 a_14166_8498# sg13cmos5l_xor2_1_2.A 0.19463f
C4676 a_10827_992# VPWR 0.20784f
C4677 sg13cmos5l_nor3_1_1.A a_16320_1671# 0.02928f
C4678 a_13472_3230# VPWR 0.06894f
C4679 sg13cmos5l_nand3_1_0.Y sg13cmos5l_nand3_1_0.B 0.18772f
C4680 sg13cmos5l_xnor2_1_1.B sg13cmos5l_nor3_1_0.Y 0.01364f
C4681 sg13cmos5l_nor4_2_5.C sg13cmos5l_nor4_2_5.Y 0.17547f
C4682 sg13cmos5l_nand3_1_2.C a_25162_4117# 0.01459f
C4683 sg13cmos5l_dlygate4sd3_1_17.X sg13cmos5l_nor3_1_0.C 3.10652f
C4684 sg13cmos5l_dfrbpq_1_13.RESET_B a_3876_4212# 0.04203f
C4685 a_7930_4620# VPWR 0.32651f
C4686 sg13cmos5l_xnor2_1_5.Y a_10812_5017# 0.01134f
C4687 sg13cmos5l_xor2_1_1.B sg13cmos5l_dlygate4sd3_1_22.X 0.17148f
C4688 sg13cmos5l_dlygate4sd3_1_6.A osc 0.01958f
C4689 a_18789_2361# a_18951_1719# 0.01667f
C4690 sg13cmos5l_dlygate4sd3_1_47.A sg13cmos5l_dlygate4sd3_1_17.A 0.04639f
C4691 a_3590_8430# a_4293_8409# 0.02453f
C4692 a_25605_3873# a_26353_3971# 0.01058f
C4693 a_26447_3971# a_26704_4114# 0.40419f
C4694 a_20311_6882# en[4] 0.01071f
C4695 sg13cmos5l_dlygate4sd3_1_6.X osc 0.01991f
C4696 sg13cmos5l_dfrbpq_1_11.CLK sg13cmos5l_dfrbpq_1_11.Q 0.06948f
C4697 sg13cmos5l_dlygate4sd3_1_39.X sg13cmos5l_dlygate4sd3_1_4.X 1.75844f
C4698 a_18372_2700# a_19537_2459# 0.4858f
C4699 a_18891_2504# a_18660_2395# 0.15089f
C4700 a_13472_2514# VPWR 0.07294f
C4701 sg13cmos5l_dfrbpq_1_58.RESET_B sg13cmos5l_dfrbpq_1_21.CLK 0.03983f
C4702 sg13cmos5l_buf_1_0.X sg13cmos5l_nor4_2_7.D 0.57865f
C4703 sg13cmos5l_nor4_2_5.C sg13cmos5l_and2_1_3.A 0.01881f
C4704 a_4380_2346# a_5162_2540# 0.4806f
C4705 a_28186_7644# a_27695_6995# 0.01133f
C4706 a_25764_5724# a_27023_5483# 0.01741f
C4707 a_21728_1002# VPWR 0.07964f
C4708 sg13cmos5l_dlygate4sd3_1_51.A sg13cmos5l_nor3_1_0.C 1.31144f
C4709 sg13cmos5l_nand3_1_2.A sg13cmos5l_nor4_2_7.B 0.02337f
C4710 a_25679_2459# a_25439_1603# 0.02731f
C4711 sg13cmos5l_dfrbpq_1_53.CLK a_26128_6410# 0.02142f
C4712 sg13cmos5l_dlygate4sd3_1_39.X sg13cmos5l_nor4_2_7.B 0.02301f
C4713 sg13cmos5l_dfrbpq_1_57.Q a_10112_4943# 0.13769f
C4714 sg13cmos5l_xnor2_1_0.Y a_5340_1993# 0.0234f
C4715 sg13cmos5l_and2_1_1.X sg13cmos5l_dlygate4sd3_1_9.X 0.03346f
C4716 sg13cmos5l_xnor2_1_2.A sg13cmos5l_nor3_1_4.B 0.02173f
C4717 a_20192_7093# a_20524_6918# 0.1396f
C4718 sg13cmos5l_dfrbpq_1_0.D sg13cmos5l_nor4_2_0.D 0.15921f
C4719 a_25679_2459# a_25585_2459# 0.32273f
C4720 sg13cmos5l_dfrbpq_1_55.RESET_B a_14379_2504# 0.55308f
C4721 sg13cmos5l_xnor2_1_10.Y sg13cmos5l_dlygate4sd3_1_9.X 0.04742f
C4722 a_15850_3862# VPWR 1.14257f
C4723 sg13cmos5l_dfrbpq_1_23.D a_8312_4697# 0.02965f
C4724 a_15119_2459# a_15786_2680# 0.13494f
C4725 a_14277_2361# a_15025_2459# 0.01058f
C4726 sg13cmos5l_and2_1_1.X a_23846_3898# 0.05434f
C4727 sg13cmos5l_buf_1_4.X sg13cmos5l_dfrbpq_1_11.CLK 0.12669f
C4728 a_18564_3148# VPWR 0.07323f
C4729 sg13cmos5l_dlygate4sd3_1_6.A a_18981_3155# 0.01124f
C4730 sg13cmos5l_dfrbpq_1_13.RESET_B sg13cmos5l_xor2_1_1.B 0.01923f
C4731 a_11786_4192# sg13cmos5l_nand3_1_3.B 0.37647f
C4732 sg13cmos5l_dfrbpq_1_37.D sg13cmos5l_xnor2_1_4.B 0.13182f
C4733 sg13cmos5l_nor4_2_9.Y a_4166_6168# 0.05307f
C4734 a_7351_1596# a_7822_2070# 0.32273f
C4735 a_10444_5094# VPWR 0.18791f
C4736 sg13cmos5l_buf_8_3.A sg13cmos5l_dfrbpq_1_11.Q 0.02274f
C4737 sg13cmos5l_dfrbpq_1_57.RESET_B a_10282_7141# 0.35152f
C4738 sg13cmos5l_dfrbpq_1_21.CLK a_4951_4620# 0.02312f
C4739 sg13cmos5l_nor3_1_4.C a_15680_4026# 0.0485f
C4740 sg13cmos5l_dfrbpq_1_32.CLK a_5223_7767# 0.02566f
C4741 a_10308_7236# VPWR 0.07275f
C4742 a_16566_3168# sg13cmos5l_dfrbpq_1_55.D 0.19988f
C4743 sg13cmos5l_nor3_1_4.Y osc 0.22427f
C4744 sg13cmos5l_dlygate4sd3_1_53.A VPWR 0.50916f
C4745 a_7716_2700# a_8975_2459# 0.01741f
C4746 sg13cmos5l_nor3_1_4.A a_14742_3962# 0.0347f
C4747 a_14343_1719# a_14495_1603# 0.66105f
C4748 sg13cmos5l_dfrbpq_1_32.CLK sg13cmos5l_nor3_1_2.B 2.34307f
C4749 a_2920_7680# a_3304_7766# 0.03269f
C4750 a_1248_4695# VPWR 0.25964f
C4751 sg13cmos5l_buf_1_5.A sg13cmos5l_nand3_1_1.A 0.15371f
C4752 sg13cmos5l_nor4_2_5.Y a_4481_7108# 0.03294f
C4753 sg13cmos5l_nor3_1_1.A a_13472_2514# 0.07047f
C4754 a_25764_5724# a_26929_5483# 0.4858f
C4755 a_26283_5528# a_26052_5419# 0.15089f
C4756 a_25066_1093# VPWR 0.09489f
C4757 a_2920_8468# sg13cmos5l_nor4_2_5.C 0.04493f
C4758 sg13cmos5l_dfrbpq_1_58.D a_6359_4703# 0.29772f
C4759 sg13cmos5l_dfrbpq_1_47.Q sg13cmos5l_buf_1_2.A 0.22342f
C4760 sg13cmos5l_nor4_2_7.B a_26410_7141# 0.0114f
C4761 sg13cmos5l_buf_1_1.X a_24940_2070# 0.17693f
C4762 a_2266_7644# sg13cmos5l_nor3_1_2.B 0.02099f
C4763 sg13cmos5l_dfrbpq_1_47.Q sg13cmos5l_dfrbpq_1_52.Q 0.14476f
C4764 sg13cmos5l_buf_1_4.X sg13cmos5l_buf_8_3.A 0.02365f
C4765 a_20362_4117# VPWR 0.09469f
C4766 sg13cmos5l_dfrbpq_1_3.D a_24416_1718# 0.01376f
C4767 sg13cmos5l_dlygate4sd3_1_6.A sg13cmos5l_buf_1_1.X 0.06988f
C4768 sg13cmos5l_dfrbpq_1_7.Q a_28646_3898# 0.04558f
C4769 sg13cmos5l_buf_8_10.A a_10308_7236# 0.03103f
C4770 a_24900_3148# VPWR 0.0721f
C4771 sg13cmos5l_dlygate4sd3_1_6.X sg13cmos5l_buf_1_1.X 0.11837f
C4772 a_15488_4943# a_15820_5094# 0.1396f
C4773 sg13cmos5l_dfrbpq_1_21.RESET_B sg13cmos5l_dfrbpq_1_58.Q 0.07624f
C4774 sg13cmos5l_nor4_2_1.A sg13cmos5l_and2_1_0.X 0.01522f
C4775 sg13cmos5l_dfrbpq_1_2.D sg13cmos5l_nand3_1_0.A 0.20823f
C4776 sg13cmos5l_xnor2_1_5.Y sg13cmos5l_xnor2_1_13.A 0.20801f
C4777 sg13cmos5l_and2_1_1.A sg13cmos5l_dlygate4sd3_1_13.A 0.05556f
C4778 a_10791_2600# a_10725_1643# 0.0167f
C4779 sg13cmos5l_dfrbpq_1_0.CLK sg13cmos5l_dfrbpq_1_0.D 0.02953f
C4780 sg13cmos5l_nor4_2_1.A a_21934_2571# 0.2272f
C4781 a_3590_3582# a_3876_3148# 0.50066f
C4782 sg13cmos5l_dfrbpq_1_17.D sg13cmos5l_dlygate4sd3_1_18.X 0.04395f
C4783 a_25478_8430# a_26052_8443# 0.36169f
C4784 sg13cmos5l_xnor2_1_4.Y sg13cmos5l_dfrbpq_1_7.Q 0.33472f
C4785 sg13cmos5l_xnor2_1_6.B sg13cmos5l_dfrbpq_1_13.CLK 0.84271f
C4786 a_3905_1898# a_3799_834# 0.01203f
C4787 sg13cmos5l_buf_1_1.X osc 0.01743f
C4788 a_2632_8562# VPWR 0.14446f
C4789 sg13cmos5l_dfrbpq_1_23.D a_1397_5026# 0.01461f
C4790 sg13cmos5l_dfrbpq_1_57.RESET_B en[4] 2.84525f
C4791 a_5375_7651# a_6071_7727# 0.02453f
C4792 a_12234_7216# VPWR 0.46908f
C4793 sg13cmos5l_xnor2_1_10.Y sg13cmos5l_xnor2_1_4.Y 0.0652f
C4794 a_16319_4627# osc 0.01208f
C4795 sg13cmos5l_buf_1_0.A a_3680_5609# 0.02794f
C4796 sg13cmos5l_nand3_1_3.Y a_2016_4209# 0.13198f
C4797 a_18922_7644# VPWR 1.1417f
C4798 sg13cmos5l_nor4_2_7.B sg13cmos5l_dlygate4sd3_1_55.A 0.03502f
C4799 sg13cmos5l_buf_1_2.A sg13cmos5l_dfrbpq_1_13.RESET_B 0.01099f
C4800 sg13cmos5l_dfrbpq_1_32.CLK a_5244_8041# 0.0914f
C4801 a_4876_8118# a_5223_7767# 0.06746f
C4802 a_5244_8041# a_5134_8118# 0.4858f
C4803 a_27610_1596# a_27992_1673# 0.09023f
C4804 a_10022_2070# VPWR 0.92912f
C4805 sg13cmos5l_dlygate4sd3_1_22.X a_8776_908# 0.01825f
C4806 a_5356_5406# a_5703_5624# 0.07014f
C4807 sg13cmos5l_dfrbpq_1_46.CLK a_18380_7644# 0.01479f
C4808 a_10827_8552# sg13cmos5l_dfrbpq_1_57.CLK 0.01965f
C4809 a_27023_5483# a_26929_5483# 0.32273f
C4810 a_10827_8552# a_10943_7651# 0.0167f
C4811 sg13cmos5l_dlygate4sd3_1_17.A a_27306_7680# 0.01326f
C4812 sg13cmos5l_nor3_1_2.B a_4876_8118# 0.01167f
C4813 sg13cmos5l_nor3_1_2.C sg13cmos5l_dfrbpq_1_53.RESET_B 0.02935f
C4814 sg13cmos5l_buf_1_4.X a_17796_4212# 0.51556f
C4815 a_10791_7767# a_11594_7960# 0.15089f
C4816 a_23958_1656# a_24416_1718# 0.03208f
C4817 sg13cmos5l_nor3_1_0.B VPWR 0.98498f
C4818 sg13cmos5l_buf_1_0.A a_14364_1993# 0.01234f
C4819 sg13cmos5l_dfrbpq_1_53.Q a_27690_4656# 0.13653f
C4820 sg13cmos5l_xnor2_1_0.Y sg13cmos5l_xnor2_1_6.Y 0.07369f
C4821 sg13cmos5l_dlygate4sd3_1_17.A a_27280_4898# 0.01483f
C4822 a_3799_2346# VPWR 0.20801f
C4823 sg13cmos5l_dfrbpq_1_21.RESET_B a_8202_7216# 0.01543f
C4824 sg13cmos5l_nand3_1_2.Y sg13cmos5l_dfrbpq_1_0.CLK 0.02383f
C4825 sg13cmos5l_xnor2_1_12.B sg13cmos5l_xor2_1_1.B 6.94009f
C4826 sg13cmos5l_buf_8_10.A a_12234_7216# 0.01255f
C4827 a_25738_5629# VPWR 0.09623f
C4828 sg13cmos5l_dfrbpq_1_56.CLK en[4] 0.11755f
C4829 a_20524_6918# a_20871_7136# 0.07014f
C4830 a_16188_5017# a_16078_5094# 0.4858f
C4831 sg13cmos5l_dfrbpq_1_29.Q a_17729_8620# 0.01763f
C4832 a_15820_5094# a_16167_4743# 0.06746f
C4833 a_17796_4212# a_19055_3971# 0.01741f
C4834 a_20311_6882# VPWR 0.17146f
C4835 a_23576_4697# a_23846_4656# 0.33585f
C4836 a_1436_5704# VPWR 0.2502f
C4837 sg13cmos5l_dlygate4sd3_1_4.A a_28256_1002# 0.07188f
C4838 sg13cmos5l_xnor2_1_2.A sg13cmos5l_and2_1_4.X 0.01235f
C4839 sg13cmos5l_nor3_1_0.C a_18891_2504# 0.07523f
C4840 sg13cmos5l_buf_1_1.X a_18981_3155# 0.07506f
C4841 a_5135_3505# a_5041_3505# 0.32273f
C4842 a_28652_7644# a_28936_7766# 0.01225f
C4843 a_11639_4703# VPWR 0.9409f
C4844 a_14542_4923# sg13cmos5l_dfrbpq_1_17.D 0.19497f
C4845 sg13cmos5l_dfrbpq_1_53.CLK sg13cmos5l_dlygate4sd3_1_17.A 0.03075f
C4846 sg13cmos5l_xnor2_1_4.A osc 0.10848f
C4847 sg13cmos5l_buf_1_4.A a_27137_6434# 0.0235f
C4848 sg13cmos5l_dlygate4sd3_1_13.A a_20864_3230# 0.01341f
C4849 sg13cmos5l_and2_1_0.X a_21435_3514# 0.76157f
C4850 a_24902_3894# osc 0.01851f
C4851 a_6071_7727# a_7046_8118# 0.0441f
C4852 sg13cmos5l_buf_8_0.X a_17109_4703# 0.01127f
C4853 sg13cmos5l_dfrbpq_1_13.RESET_B a_8776_908# 0.01529f
C4854 sg13cmos5l_nand3_1_1.Y a_10812_5017# 0.0385f
C4855 sg13cmos5l_dfrbpq_1_53.RESET_B a_15525_7691# 0.01382f
C4856 sg13cmos5l_dfrbpq_1_56.Q a_15488_4943# 0.13654f
C4857 sg13cmos5l_dfrbpq_1_56.CLK a_16188_5017# 0.08486f
C4858 a_5724_5370# a_6551_5797# 0.50066f
C4859 a_28256_1002# VPWR 0.07781f
C4860 sg13cmos5l_dfrbpq_1_46.D a_23712_6207# 0.42235f
C4861 a_15686_6606# a_15946_6136# 0.87117f
C4862 a_3304_8562# a_3488_8562# 0.11523f
C4863 a_4511_1140# VPWR 0.24126f
C4864 sg13cmos5l_buf_1_0.X a_20524_8118# 0.23038f
C4865 a_18826_4620# sg13cmos5l_nor3_1_0.C 0.07081f
C4866 sg13cmos5l_dlygate4sd3_1_17.X a_27195_3514# 0.02612f
C4867 sg13cmos5l_and2_1_3.A a_6597_6179# 0.01698f
C4868 sg13cmos5l_dfrbpq_1_58.D a_7328_4742# 0.06924f
C4869 a_1169_3502# VPWR 0.25847f
C4870 a_9176_874# a_9446_874# 0.33585f
C4871 sg13cmos5l_xnor2_1_13.A sg13cmos5l_dfrbpq_1_23.D 0.0168f
C4872 a_3850_4117# a_3590_3894# 0.87117f
C4873 a_2266_2350# a_2266_1596# 0.02325f
C4874 a_8975_2459# VPWR 0.20948f
C4875 sg13cmos5l_nand3_1_2.Y a_24540_3902# 0.01437f
C4876 sg13cmos5l_buf_1_4.X a_24939_2504# 0.06626f
C4877 sg13cmos5l_xnor2_1_5.Y a_5724_5370# 0.01063f
C4878 sg13cmos5l_dfrbpq_1_2.CLK a_19103_1603# 0.39064f
C4879 a_20362_4117# a_20102_3894# 0.87117f
C4880 sg13cmos5l_xor2_1_1.B sg13cmos5l_xnor2_1_0.A 0.19596f
C4881 sg13cmos5l_nor4_2_9.Y sg13cmos5l_buf_8_5.A 0.01946f
C4882 a_21023_7188# a_21674_7076# 0.01562f
C4883 a_20892_6882# a_21719_7309# 0.50066f
C4884 sg13cmos5l_dfrbpq_1_56.RESET_B a_16629_8588# 0.3259f
C4885 a_22138_1596# a_21857_1898# 0.33585f
C4886 sg13cmos5l_xor2_1_2.B a_13862_4656# 0.03795f
C4887 a_24922_4620# a_25478_5094# 0.01249f
C4888 sg13cmos5l_dlygate4sd3_1_22.X a_8235_2504# 0.01461f
C4889 a_9558_3168# a_10112_3431# 0.03282f
C4890 sg13cmos5l_xnor2_1_6.B a_7532_3144# 0.09803f
C4891 sg13cmos5l_xnor2_1_3.A a_19754_1912# 0.01083f
C4892 a_2016_5721# a_2165_5410# 0.3658f
C4893 sg13cmos5l_dfrbpq_1_3.D a_23576_1673# 0.04639f
C4894 a_14657_4922# VPWR 0.24577f
C4895 sg13cmos5l_xnor2_1_5.Y a_16167_4743# 0.05356f
C4896 sg13cmos5l_dfrbpq_1_58.D sg13cmos5l_xnor2_1_12.B 0.03675f
C4897 sg13cmos5l_dfrbpq_1_2.D a_18278_3582# 0.04851f
C4898 sg13cmos5l_buf_1_1.X a_24394_2605# 0.33215f
C4899 a_24614_3582# a_25419_3155# 0.11742f
C4900 sg13cmos5l_xnor2_1_8.Y sg13cmos5l_nor4_2_5.D 0.26838f
C4901 sg13cmos5l_dfrbpq_1_55.Q VPWR 0.73487f
C4902 sg13cmos5l_xnor2_1_3.B a_18086_2382# 0.03268f
C4903 sg13cmos5l_dfrbpq_1_12.D a_10308_1636# 0.01612f
C4904 sg13cmos5l_dlygate4sd3_1_22.A a_4380_834# 0.01252f
C4905 sg13cmos5l_dlygate4sd3_1_4.X sg13cmos5l_dfrbpq_1_53.Q 0.49492f
C4906 sg13cmos5l_buf_1_4.X a_24922_4620# 0.01243f
C4907 a_7046_8118# a_7749_7691# 0.02431f
C4908 sg13cmos5l_dfrbpq_1_56.CLK a_15972_6172# 0.1023f
C4909 sg13cmos5l_xnor2_1_6.Y a_1301_874# 0.05541f
C4910 sg13cmos5l_xnor2_1_2.A sg13cmos5l_dfrbpq_1_59.Q 0.01433f
C4911 sg13cmos5l_nand3_1_1.Y a_10702_5094# 0.01022f
C4912 sg13cmos5l_dfrbpq_1_53.RESET_B a_15627_7691# 0.0165f
C4913 sg13cmos5l_dfrbpq_1_47.Q a_17994_7216# 0.13576f
C4914 sg13cmos5l_nor4_2_7.B sg13cmos5l_xnor2_1_4.B 0.17082f
C4915 sg13cmos5l_buf_8_4.A en[1] 0.12001f
C4916 a_25094_8118# a_25797_7691# 0.02431f
C4917 sg13cmos5l_buf_1_4.X a_26704_4114# 0.17693f
C4918 a_28931_7216# VPWR 0.01368f
C4919 a_15972_6172# a_16260_6593# 0.4806f
C4920 sg13cmos5l_dfrbpq_1_21.RESET_B a_5135_8507# 0.20797f
C4921 sg13cmos5l_buf_1_0.X a_21023_7651# 0.05707f
C4922 sg13cmos5l_dlygate4sd3_1_17.X a_27990_2450# 0.19471f
C4923 sg13cmos5l_nor4_2_4.D a_16485_6897# 0.01829f
C4924 sg13cmos5l_and2_1_3.A a_7696_6410# 0.01134f
C4925 a_6250_2350# a_5471_1603# 0.01715f
C4926 sg13cmos5l_dlygate4sd3_1_35.A a_5392_8650# 0.01387f
C4927 sg13cmos5l_dfrbpq_1_57.RESET_B a_14822_8118# 0.11341f
C4928 a_24881_8484# sg13cmos5l_dfrbpq_1_53.RESET_B 0.01183f
C4929 a_5135_3971# a_5041_3971# 0.32273f
C4930 a_19631_2459# a_20298_2680# 0.13494f
C4931 sg13cmos5l_and2_1_3.A a_4166_6168# 0.0161f
C4932 sg13cmos5l_dfrbpq_1_2.D a_18144_4695# 0.42795f
C4933 a_21904_4114# a_21553_3971# 0.01017f
C4934 sg13cmos5l_buf_8_2.X sg13cmos5l_dfrbpq_1_5.Q 0.13028f
C4935 a_10827_5528# a_10943_4627# 0.0167f
C4936 sg13cmos5l_buf_1_0.A sg13cmos5l_dfrbpq_1_21.RESET_B 0.27604f
C4937 sg13cmos5l_xnor2_1_2.B sg13cmos5l_nor3_1_4.A 0.03452f
C4938 sg13cmos5l_dfrbpq_1_13.RESET_B a_8235_2504# 0.55685f
C4939 sg13cmos5l_dfrbpq_1_56.CLK a_16164_5724# 0.11442f
C4940 a_15041_6434# VPWR 0.24336f
C4941 sg13cmos5l_dfrbpq_1_55.RESET_B a_11639_3191# 0.12135f
C4942 sg13cmos5l_nor3_1_0.B a_24424_3230# 0.03421f
C4943 sg13cmos5l_buf_8_2.X a_24874_3112# 0.01232f
C4944 a_14926_6435# VPWR 0.21261f
C4945 a_28506_2578# sg13cmos5l_dlygate4sd3_1_0.X 0.39561f
C4946 a_2266_6132# a_1985_6434# 0.33585f
C4947 a_25478_5094# a_25738_4624# 0.87117f
C4948 a_10812_8041# a_10702_8118# 0.4858f
C4949 a_10444_8118# a_10791_7767# 0.06746f
C4950 sg13cmos5l_dfrbpq_1_57.RESET_B VPWR 10.4798f
C4951 a_10725_1643# a_11473_1993# 0.01058f
C4952 a_24170_5704# sg13cmos5l_nand3_1_2.B 0.37559f
C4953 sg13cmos5l_nor3_1_2.C a_2016_7233# 0.03033f
C4954 a_28524_3410# a_28559_3514# 0.3658f
C4955 sg13cmos5l_xnor2_1_13.Y sg13cmos5l_xnor2_1_13.A 0.1315f
C4956 sg13cmos5l_xnor2_1_2.A a_16184_3185# 0.06148f
C4957 sg13cmos5l_buf_8_11.A a_27952_7138# 0.04116f
C4958 sg13cmos5l_nand3_1_1.Y sg13cmos5l_xnor2_1_13.A 0.17025f
C4959 sg13cmos5l_buf_1_4.X a_25738_4624# 0.01316f
C4960 a_7749_7691# a_7851_7691# 0.6663f
C4961 sg13cmos5l_dfrbpq_1_32.CLK sg13cmos5l_dlygate4sd3_1_38.A 0.03785f
C4962 sg13cmos5l_dfrbpq_1_55.Q sg13cmos5l_nor3_1_1.A 0.88936f
C4963 a_3680_1045# a_3488_1002# 0.03403f
C4964 sg13cmos5l_dfrbpq_1_0.D sg13cmos5l_xnor2_1_3.A 6.83966f
C4965 a_20362_8653# a_20388_8748# 0.43042f
C4966 sg13cmos5l_dfrbpq_1_53.RESET_B sg13cmos5l_buf_1_2.A 0.03891f
C4967 sg13cmos5l_buf_1_0.X a_20102_8430# 0.09266f
C4968 sg13cmos5l_buf_8_5.A a_10112_4943# 0.06625f
C4969 a_5990_6918# a_6693_6897# 0.02453f
C4970 sg13cmos5l_xnor2_1_0.Y a_15791_874# 0.04203f
C4971 sg13cmos5l_dlygate4sd3_1_18.A a_8853_1679# 0.02729f
C4972 sg13cmos5l_dlygate4sd3_1_57.A sg13cmos5l_dfrbpq_1_53.RESET_B 0.16159f
C4973 sg13cmos5l_dfrbpq_1_53.RESET_B sg13cmos5l_dfrbpq_1_52.Q 0.27225f
C4974 sg13cmos5l_xnor2_1_6.B a_1985_1898# 0.02905f
C4975 sg13cmos5l_buf_1_0.A a_24940_2070# 0.01146f
C4976 a_9176_874# VPWR 0.32941f
C4977 sg13cmos5l_nor3_1_4.C a_15820_5094# 0.03143f
C4978 a_25797_7691# a_25899_7691# 0.6663f
C4979 sg13cmos5l_buf_8_4.A a_6359_4703# 0.01887f
C4980 a_10827_7040# a_10943_6139# 0.0167f
C4981 a_16491_6179# a_17231_6529# 0.3087f
C4982 sg13cmos5l_dfrbpq_1_57.RESET_B sg13cmos5l_buf_8_10.A 1.80461f
C4983 a_27992_1673# a_28262_1632# 0.33585f
C4984 sg13cmos5l_dfrbpq_1_56.CLK VPWR 1.98734f
C4985 sg13cmos5l_nand3_1_3.Y sg13cmos5l_xnor2_1_0.Y 0.55836f
C4986 sg13cmos5l_dlygate4sd3_1_10.A sg13cmos5l_dfrbpq_1_5.Q 1.8349f
C4987 a_6951_4112# a_7754_4052# 0.15089f
C4988 a_7799_4285# a_7893_4052# 0.87117f
C4989 a_7103_4164# a_6862_3894# 0.01058f
C4990 sg13cmos5l_xnor2_1_5.A a_17800_2514# 0.03166f
C4991 a_10725_849# a_10596_883# 0.01562f
C4992 sg13cmos5l_dlygate4sd3_1_28.X a_9558_6192# 0.19408f
C4993 a_25162_4117# a_25605_3873# 0.02241f
C4994 a_16581_5385# a_16683_5528# 0.66105f
C4995 sg13cmos5l_dfrbpq_1_11.CLK a_10827_992# 0.04502f
C4996 sg13cmos5l_dfrbpq_1_55.RESET_B sg13cmos5l_dfrbpq_1_55.D 0.37188f
C4997 a_8776_5444# VPWR 0.24922f
C4998 sg13cmos5l_nand3_1_1.B a_13888_6168# 0.02196f
C4999 sg13cmos5l_xnor2_1_6.Y a_15791_874# 0.01914f
C5000 sg13cmos5l_xnor2_1_8.Y sg13cmos5l_dfrbpq_1_15.D 0.16695f
C5001 a_4762_6886# VPWR 0.33261f
C5002 sg13cmos5l_dfrbpq_1_23.Q a_4730_6168# 0.01673f
C5003 a_23818_7141# a_23558_6918# 0.87117f
C5004 a_24849_8752# VPWR 0.0107f
C5005 a_1190_1632# VPWR 0.25366f
C5006 a_10812_8041# a_11639_7727# 0.50066f
C5007 a_18826_4620# a_18315_4016# 0.01117f
C5008 a_25764_8748# a_25797_7691# 0.01382f
C5009 a_13784_8434# sg13cmos5l_xnor2_1_2.B 0.01576f
C5010 sg13cmos5l_xnor2_1_4.Y sg13cmos5l_dfrbpq_1_0.CLK 0.05355f
C5011 a_27878_2386# VPWR 0.28815f
C5012 a_8763_8434# VPWR 1.23331f
C5013 a_20388_8748# a_20676_8443# 0.4806f
C5014 sg13cmos5l_dfrbpq_1_56.CLK sg13cmos5l_buf_8_10.A 1.17261f
C5015 sg13cmos5l_nor4_2_5.D sg13cmos5l_dfrbpq_1_58.RESET_B 0.19845f
C5016 sg13cmos5l_dlygate4sd3_1_52.A sg13cmos5l_dlygate4sd3_1_22.X 0.01094f
C5017 a_8848_7922# a_9258_7680# 0.1396f
C5018 sg13cmos5l_nor4_2_5.B sg13cmos5l_dfrbpq_1_23.Q 0.01096f
C5019 sg13cmos5l_dfrbpq_1_58.Q sg13cmos5l_dlygate4sd3_1_30.A 0.18717f
C5020 sg13cmos5l_dfrbpq_1_21.RESET_B a_4366_7107# 0.04946f
C5021 sg13cmos5l_dfrbpq_1_22.D VPWR 1.61352f
C5022 a_24939_2504# a_25679_2459# 0.3087f
C5023 a_14277_2361# a_14379_2504# 0.66105f
C5024 a_6795_7040# a_7535_6995# 0.3087f
C5025 sg13cmos5l_buf_1_0.X a_23576_3185# 0.06297f
C5026 sg13cmos5l_dlygate4sd3_1_23.X a_2166_3168# 0.19724f
C5027 sg13cmos5l_dfrbpq_1_13.CLK a_6951_1088# 0.03936f
C5028 sg13cmos5l_nand3_1_2.A en[4] 0.01716f
C5029 sg13cmos5l_buf_1_4.A a_12234_1168# 0.01202f
C5030 sg13cmos5l_dfrbpq_1_0.D sg13cmos5l_dlygate4sd3_1_1.A 0.12918f
C5031 a_26896_7922# a_27306_7680# 0.1396f
C5032 sg13cmos5l_dlygate4sd3_1_39.X en[4] 1.06974f
C5033 sg13cmos5l_xor2_1_1.B sg13cmos5l_nand3_1_3.B 0.08325f
C5034 a_9281_4084# sg13cmos5l_dlygate4sd3_1_18.X 0.02447f
C5035 a_9562_3862# sg13cmos5l_dlygate4sd3_1_22.X 0.01317f
C5036 a_7232_1919# a_7351_1596# 0.13494f
C5037 a_5340_1993# a_6167_1679# 0.50066f
C5038 a_14822_8118# a_15108_7684# 0.50066f
C5039 a_1664_6254# VPWR 0.06866f
C5040 sg13cmos5l_xnor2_1_5.Y sg13cmos5l_nor3_1_4.C 0.02435f
C5041 sg13cmos5l_dfrbpq_1_46.D a_23835_8050# 0.02596f
C5042 sg13cmos5l_dfrbpq_1_53.RESET_B sg13cmos5l_dlygate4sd3_1_9.X 0.34039f
C5043 sg13cmos5l_buf_1_4.A a_25764_4660# 0.05367f
C5044 sg13cmos5l_xnor2_1_2.B sg13cmos5l_nor3_1_4.B 0.02146f
C5045 sg13cmos5l_dfrbpq_1_57.RESET_B a_10282_5629# 0.35499f
C5046 a_28289_5596# a_28570_5374# 0.33585f
C5047 sg13cmos5l_nor4_2_5.C a_6272_8605# 0.01071f
C5048 a_15878_5406# a_16452_5419# 0.36169f
C5049 a_15376_3386# a_15786_3144# 0.1396f
C5050 sg13cmos5l_dlygate4sd3_1_6.X a_21647_6529# 0.04372f
C5051 a_7535_6995# VPWR 0.17266f
C5052 sg13cmos5l_dlygate4sd3_1_50.A a_11639_4703# 0.01098f
C5053 a_6250_2350# sg13cmos5l_dfrbpq_1_13.CLK 1.09575f
C5054 sg13cmos5l_nor3_1_4.C a_15878_5406# 0.34585f
C5055 a_15108_7684# VPWR 0.07227f
C5056 sg13cmos5l_nor3_1_0.C a_18961_3971# 0.01359f
C5057 a_23558_6918# a_23844_7236# 0.50066f
C5058 sg13cmos5l_dfrbpq_1_56.Q sg13cmos5l_nor3_1_4.C 0.04086f
C5059 a_26181_4667# a_26929_5017# 0.01058f
C5060 sg13cmos5l_nor4_2_9.D sg13cmos5l_xnor2_1_13.A 0.04887f
C5061 a_26283_8552# a_26639_8041# 0.01275f
C5062 a_24261_6897# VPWR 0.24645f
C5063 sg13cmos5l_buf_1_4.A sg13cmos5l_nor4_2_0.C 0.0241f
C5064 a_20192_7967# a_20524_8118# 0.1396f
C5065 sg13cmos5l_buf_1_0.X a_23576_3898# 0.05008f
C5066 a_15127_8394# a_15708_8394# 0.01741f
C5067 sg13cmos5l_xnor2_1_5.Y a_2165_5410# 0.01749f
C5068 sg13cmos5l_dfrbpq_1_53.RESET_B a_25131_6179# 0.0491f
C5069 sg13cmos5l_nor3_1_0.A VPWR 0.76541f
C5070 a_8591_8041# a_8497_8041# 0.32273f
C5071 a_10112_7967# a_10231_7644# 0.13494f
C5072 sg13cmos5l_nand3_1_1.Y a_16167_4743# 0.01544f
C5073 sg13cmos5l_buf_8_5.A sg13cmos5l_dlygate4sd3_1_18.X 0.05249f
C5074 sg13cmos5l_xnor2_1_6.B a_7911_1719# 0.08006f
C5075 sg13cmos5l_nor3_1_0.C a_25764_4660# 0.02588f
C5076 sg13cmos5l_xnor2_1_5.Y sg13cmos5l_xnor2_1_5.A 0.19152f
C5077 sg13cmos5l_dlygate4sd3_1_21.X a_7932_1993# 0.02774f
C5078 sg13cmos5l_dfrbpq_1_22.D sg13cmos5l_nor3_1_1.A 0.60928f
C5079 a_13745_3948# a_13916_4192# 0.41432f
C5080 sg13cmos5l_dlygate4sd3_1_17.A a_27713_4084# 0.0235f
C5081 a_26436_7236# a_26724_6931# 0.4806f
C5082 sg13cmos5l_and2_1_1.A a_23661_2428# 0.12146f
C5083 sg13cmos5l_and2_1_3.A sg13cmos5l_buf_8_5.A 0.07648f
C5084 sg13cmos5l_dlygate4sd3_1_52.A a_9176_4697# 0.5135f
C5085 sg13cmos5l_and2_1_1.A sg13cmos5l_nor4_2_1.D 0.78702f
C5086 a_4730_6168# VPWR 0.1789f
C5087 a_15850_3862# sg13cmos5l_dfrbpq_1_54.Q 0.01259f
C5088 sg13cmos5l_dfrbpq_1_18.D a_1985_2572# 0.03423f
C5089 a_26181_8409# sg13cmos5l_dfrbpq_1_53.CLK 0.36556f
C5090 a_14822_8118# a_15396_8105# 0.36169f
C5091 a_15414_5474# VPWR 0.21519f
C5092 sg13cmos5l_buf_1_0.A sg13cmos5l_buf_1_1.X 0.10856f
C5093 sg13cmos5l_buf_1_0.A a_21062_1632# 0.01037f
C5094 sg13cmos5l_dfrbpq_1_13.RESET_B a_11567_1993# 0.20568f
C5095 sg13cmos5l_dfrbpq_1_17.D a_11639_3191# 0.29982f
C5096 sg13cmos5l_dfrbpq_1_12.D a_10112_2557# 0.02137f
C5097 sg13cmos5l_dlygate4sd3_1_21.X sg13cmos5l_dfrbpq_1_13.Q 0.01939f
C5098 sg13cmos5l_dfrbpq_1_57.RESET_B a_11567_5483# 0.28622f
C5099 sg13cmos5l_dfrbpq_1_58.D sg13cmos5l_xnor2_1_5.Y 0.02514f
C5100 a_17510_3894# osc 0.01981f
C5101 a_21023_7188# a_20907_6179# 0.0167f
C5102 a_18572_5370# a_18843_5410# 0.1225f
C5103 a_14148_2395# VPWR 0.01652f
C5104 a_8975_2459# a_9642_2680# 0.13494f
C5105 a_8235_2504# a_8004_2395# 0.15089f
C5106 a_7716_2700# a_8881_2459# 0.4858f
C5107 sg13cmos5l_nand3_1_1.A a_15041_6434# 0.03698f
C5108 sg13cmos5l_dlygate4sd3_1_9.X a_27280_5626# 0.04942f
C5109 sg13cmos5l_buf_1_2.A sg13cmos5l_xnor2_1_5.Y 0.21866f
C5110 sg13cmos5l_nand3_1_1.A a_14926_6435# 0.05248f
C5111 a_6180_6172# a_6597_6179# 0.49014f
C5112 sg13cmos5l_dfrbpq_1_57.RESET_B a_11567_8507# 0.24555f
C5113 sg13cmos5l_dfrbpq_1_57.RESET_B sg13cmos5l_nand3_1_1.A 0.14328f
C5114 a_23844_7236# a_25103_6995# 0.01741f
C5115 sg13cmos5l_xnor2_1_5.Y a_10827_5528# 0.0124f
C5116 a_15782_6918# en[4] 0.01543f
C5117 sg13cmos5l_nor4_2_5.B VPWR 0.39555f
C5118 sg13cmos5l_buf_8_4.A sg13cmos5l_xnor2_1_12.B 0.13055f
C5119 sg13cmos5l_nor3_1_0.B a_24608_1919# 0.01326f
C5120 a_20892_8041# a_21813_7727# 0.43042f
C5121 sg13cmos5l_dfrbpq_1_53.RESET_B sg13cmos5l_xnor2_1_4.Y 0.03096f
C5122 a_25770_7216# VPWR 0.45261f
C5123 sg13cmos5l_and2_1_3.A a_13642_5374# 1.04477f
C5124 a_20311_7644# a_20871_7767# 0.3087f
C5125 a_20524_8118# a_20782_8118# 0.01017f
C5126 sg13cmos5l_nand3_1_1.B VPWR 0.32249f
C5127 sg13cmos5l_dlygate4sd3_1_58.A a_7594_5374# 0.05388f
C5128 sg13cmos5l_dlygate4sd3_1_28.X a_13642_5374# 0.01531f
C5129 sg13cmos5l_dfrbpq_1_57.D a_13974_4680# 0.21977f
C5130 sg13cmos5l_xnor2_1_4.Y a_26181_5385# 0.01241f
C5131 sg13cmos5l_dfrbpq_1_23.D sg13cmos5l_xor2_1_1.B 0.15013f
C5132 sg13cmos5l_buf_1_4.X a_17814_3168# 0.05393f
C5133 sg13cmos5l_nor3_1_2.C sg13cmos5l_xnor2_1_13.Y 0.03279f
C5134 sg13cmos5l_dfrbpq_1_53.RESET_B sg13cmos5l_dlygate4sd3_1_11.A 0.01532f
C5135 a_26826_3144# VPWR 0.451f
C5136 sg13cmos5l_buf_1_4.A a_16928_1002# 0.06188f
C5137 sg13cmos5l_nor3_1_1.A sg13cmos5l_nor3_1_0.A 0.03279f
C5138 sg13cmos5l_nor3_1_0.C a_27023_5017# 0.01436f
C5139 a_18363_6922# sg13cmos5l_dlygate4sd3_1_6.A 0.01218f
C5140 a_20805_5385# VPWR 0.23877f
C5141 a_13563_874# VPWR 1.17418f
C5142 sg13cmos5l_dlygate4sd3_1_19.A a_3799_2346# 0.0387f
C5143 sg13cmos5l_buf_1_2.A a_17231_6529# 0.02872f
C5144 sg13cmos5l_dfrbpq_1_12.D sg13cmos5l_xnor2_1_6.B 0.42308f
C5145 a_3590_3582# a_4395_3155# 0.11742f
C5146 a_1169_3502# sg13cmos5l_xnor2_1_6.A 0.02007f
C5147 a_7822_2070# a_8063_1603# 0.01058f
C5148 sg13cmos5l_dfrbpq_1_21.RESET_B a_5301_2540# 0.34662f
C5149 sg13cmos5l_dfrbpq_1_56.CLK sg13cmos5l_nand3_1_1.A 0.80404f
C5150 a_7439_6529# VPWR 0.17377f
C5151 a_18604_2070# a_18951_1719# 0.06746f
C5152 a_18972_1993# a_18862_2070# 0.4858f
C5153 sg13cmos5l_dfrbpq_1_57.D en[4] 0.02386f
C5154 sg13cmos5l_dfrbpq_1_2.D sg13cmos5l_xnor2_1_1.Y 0.04227f
C5155 a_19083_3155# a_19823_3505# 0.3087f
C5156 sg13cmos5l_nor3_1_1.Y a_8235_2504# 0.03219f
C5157 sg13cmos5l_dfrbpq_1_38.Q a_18382_6435# 0.02145f
C5158 sg13cmos5l_dfrbpq_1_11.Q a_15756_1060# 0.03542f
C5159 a_1152_1185# sg13cmos5l_dlygate4sd3_1_22.A 0.0355f
C5160 sg13cmos5l_dfrbpq_1_53.RESET_B a_27023_8507# 0.19889f
C5161 a_3688_6254# VPWR 0.18099f
C5162 a_5345_7108# sg13cmos5l_nor4_2_5.B 0.0408f
C5163 sg13cmos5l_dfrbpq_1_57.RESET_B sg13cmos5l_dlygate4sd3_1_50.A 0.06523f
C5164 sg13cmos5l_dfrbpq_1_58.RESET_B a_5532_5017# 0.50133f
C5165 sg13cmos5l_xnor2_1_13.Y a_1985_6434# 0.04096f
C5166 a_10943_2652# a_11733_2540# 0.02241f
C5167 sg13cmos5l_dlygate4sd3_1_4.X a_25478_8430# 0.3042f
C5168 sg13cmos5l_dfrbpq_1_2.CLK a_20388_4660# 0.08215f
C5169 sg13cmos5l_dlygate4sd3_1_40.A a_28570_5374# 0.5072f
C5170 a_17633_7946# VPWR 0.24356f
C5171 sg13cmos5l_dfrbpq_1_13.CLK a_7564_2070# 0.01777f
C5172 a_20362_6136# VPWR 0.0951f
C5173 a_6597_6179# a_6699_6179# 0.6663f
C5174 sg13cmos5l_nor4_2_9.D a_5724_5370# 0.03088f
C5175 sg13cmos5l_dfrbpq_1_7.Q a_28936_4742# 0.08124f
C5176 a_25103_6995# a_25360_7138# 0.40419f
C5177 a_24261_6897# a_25009_6995# 0.01058f
C5178 a_10725_5385# VPWR 0.24286f
C5179 a_5855_5676# a_5724_5370# 0.49014f
C5180 sg13cmos5l_dfrbpq_1_57.D a_13888_6168# 0.02949f
C5181 sg13cmos5l_dfrbpq_1_39.Q VPWR 0.57263f
C5182 a_21023_7651# a_21719_7727# 0.02453f
C5183 a_920_1673# a_1190_1632# 0.33585f
C5184 sg13cmos5l_dlygate4sd3_1_19.X a_4164_3569# 0.01395f
C5185 sg13cmos5l_buf_1_4.X a_19312_4114# 0.17695f
C5186 sg13cmos5l_buf_8_4.A sg13cmos5l_dfrbpq_1_53.RESET_B 0.03151f
C5187 a_20782_8118# a_21023_7651# 0.01058f
C5188 a_13288_6254# a_13472_6254# 0.11523f
C5189 a_6604_870# a_6862_870# 0.01017f
C5190 sg13cmos5l_nand3_1_2.A VPWR 0.38601f
C5191 sg13cmos5l_buf_1_0.A sg13cmos5l_dlygate4sd3_1_30.A 0.15201f
C5192 sg13cmos5l_dfrbpq_1_39.Q a_18090_5704# 0.13536f
C5193 sg13cmos5l_xnor2_1_4.Y a_27280_5626# 0.01012f
C5194 a_5207_2773# VPWR 1.00533f
C5195 sg13cmos5l_dlygate4sd3_1_39.X VPWR 0.48405f
C5196 a_28958_2704# VPWR 0.01388f
C5197 a_19055_3971# a_19312_4114# 0.40419f
C5198 sg13cmos5l_dlygate4sd3_1_1.A a_27608_2386# 0.01282f
C5199 a_6604_8430# a_6862_8430# 0.01017f
C5200 sg13cmos5l_dfrbpq_1_56.RESET_B a_15839_8700# 0.07318f
C5201 sg13cmos5l_and2_1_1.X sg13cmos5l_nor3_1_0.C 0.03607f
C5202 a_19799_1679# a_20792_1673# 0.02797f
C5203 sg13cmos5l_dfrbpq_1_58.D sg13cmos5l_dfrbpq_1_23.D 1.42389f
C5204 a_22314_5704# VPWR 0.46829f
C5205 a_10112_6455# VPWR 0.45418f
C5206 sg13cmos5l_xnor2_1_10.Y sg13cmos5l_nor3_1_0.C 0.1321f
C5207 a_4951_4620# a_5532_5017# 0.01741f
C5208 a_28652_7644# sg13cmos5l_buf_1_4.A 0.28823f
C5209 sg13cmos5l_dfrbpq_1_35.Q en[4] 1.63603f
C5210 sg13cmos5l_dfrbpq_1_29.Q sg13cmos5l_dfrbpq_1_56.CLK 0.01041f
C5211 a_15627_7691# a_16367_8041# 0.3087f
C5212 sg13cmos5l_dlygate4sd3_1_40.A sg13cmos5l_nand3_1_2.C 0.0645f
C5213 sg13cmos5l_dlygate4sd3_1_22.A a_2054_874# 0.01873f
C5214 sg13cmos5l_dlygate4sd3_1_40.A sg13cmos5l_dlygate4sd3_1_11.X 0.01526f
C5215 sg13cmos5l_dfrbpq_1_58.RESET_B a_5511_4743# 0.55192f
C5216 sg13cmos5l_nand3_1_1.Y sg13cmos5l_xor2_1_1.B 0.01283f
C5217 a_24326_6606# VPWR 0.92706f
C5218 sg13cmos5l_dlygate4sd3_1_17.X a_28570_5374# 0.01667f
C5219 a_20362_5629# a_20805_5385# 0.02241f
C5220 a_20102_5406# a_20388_5724# 0.50066f
C5221 a_22049_2572# a_22330_2350# 0.33585f
C5222 a_19526_8434# a_19638_8498# 0.67711f
C5223 sg13cmos5l_dfrbpq_1_2.CLK a_20907_4667# 0.02688f
C5224 a_12234_1632# VPWR 0.46518f
C5225 sg13cmos5l_nand3_1_1.Y sg13cmos5l_nor3_1_4.C 0.02184f
C5226 sg13cmos5l_buf_8_0.X a_16188_5017# 0.04145f
C5227 sg13cmos5l_buf_1_4.A sg13cmos5l_nor3_1_1.C 0.0263f
C5228 sg13cmos5l_dfrbpq_1_46.D sg13cmos5l_and2_1_1.X 0.01671f
C5229 sg13cmos5l_dfrbpq_1_46.CLK a_20892_8041# 0.10182f
C5230 sg13cmos5l_dfrbpq_1_21.RESET_B sg13cmos5l_dlygate4sd3_1_19.X 0.41407f
C5231 a_20907_6179# VPWR 0.20733f
C5232 a_6699_6179# a_7696_6410# 0.07014f
C5233 sg13cmos5l_dfrbpq_1_55.Q sg13cmos5l_dfrbpq_1_11.CLK 0.2284f
C5234 sg13cmos5l_dfrbpq_1_46.D sg13cmos5l_xnor2_1_10.Y 0.01918f
C5235 sg13cmos5l_dfrbpq_1_56.D sg13cmos5l_dfrbpq_1_38.Q 0.34774f
C5236 sg13cmos5l_dfrbpq_1_21.RESET_B a_3590_8430# 0.14083f
C5237 sg13cmos5l_buf_8_2.X sg13cmos5l_dfrbpq_1_2.CLK 0.35185f
C5238 a_3590_3582# VPWR 0.93369f
C5239 sg13cmos5l_dlygate4sd3_1_35.A a_3876_8748# 0.01308f
C5240 sg13cmos5l_dlygate4sd3_1_16.A a_22330_838# 0.50849f
C5241 sg13cmos5l_dfrbpq_1_53.RESET_B sg13cmos5l_dlygate4sd3_1_52.A 0.01123f
C5242 sg13cmos5l_xnor2_1_0.Y a_10827_1643# 0.01198f
C5243 sg13cmos5l_buf_1_2.A a_17329_5483# 0.01417f
C5244 a_25308_1993# a_26229_1679# 0.43042f
C5245 a_3590_3894# a_4395_4016# 0.11742f
C5246 a_3876_4212# a_4293_3873# 0.48921f
C5247 a_18086_2382# a_18891_2504# 0.11742f
C5248 a_26410_7141# VPWR 0.09602f
C5249 a_18372_2700# a_18789_2361# 0.48921f
C5250 sg13cmos5l_nor3_1_2.C sg13cmos5l_nor4_2_9.D 0.04381f
C5251 a_4278_6192# a_4166_6168# 0.67711f
C5252 sg13cmos5l_xnor2_1_2.B sg13cmos5l_dfrbpq_1_59.Q 0.01617f
C5253 a_18346_2605# a_18789_2361# 0.02241f
C5254 sg13cmos5l_xor2_1_1.B a_1340_3144# 0.01187f
C5255 a_20805_3873# sg13cmos5l_dfrbpq_1_0.CLK 0.3656f
C5256 sg13cmos5l_dfrbpq_1_56.RESET_B a_16683_5528# 0.59536f
C5257 a_4470_5474# VPWR 0.21555f
C5258 sg13cmos5l_dfrbpq_1_13.RESET_B a_4012_2382# 0.02837f
C5259 sg13cmos5l_xnor2_1_13.Y a_2165_5410# 0.0118f
C5260 a_14379_2504# a_14495_1603# 0.0167f
C5261 a_18922_7644# en[2] 0.0119f
C5262 sg13cmos5l_dlygate4sd3_1_17.A osc 0.02744f
C5263 sg13cmos5l_dlygate4sd3_1_11.A sg13cmos5l_dlygate4sd3_1_9.A 0.17805f
C5264 a_10308_1636# a_10725_1643# 0.49014f
C5265 sg13cmos5l_nand3_1_1.Y a_2165_5410# 0.01319f
C5266 a_25317_3155# a_26065_3505# 0.01058f
C5267 sg13cmos5l_buf_1_1.X sg13cmos5l_nor3_1_0.Y 0.05472f
C5268 a_26346_2680# VPWR 0.48786f
C5269 a_4951_4620# a_5511_4743# 0.3087f
C5270 a_5164_5094# a_5422_5094# 0.01017f
C5271 sg13cmos5l_dlygate4sd3_1_17.X sg13cmos5l_nand3_1_2.C 0.81927f
C5272 sg13cmos5l_nand3_1_1.A a_15414_5474# 0.01213f
C5273 sg13cmos5l_dfrbpq_1_57.RESET_B a_15496_7050# 0.01876f
C5274 a_24261_6897# a_25029_6179# 0.01209f
C5275 sg13cmos5l_buf_1_0.X sg13cmos5l_dlygate4sd3_1_6.A 0.02995f
C5276 sg13cmos5l_dlygate4sd3_1_17.X sg13cmos5l_dlygate4sd3_1_11.X 0.82478f
C5277 a_8768_6427# VPWR 0.45199f
C5278 a_10282_5629# a_10725_5385# 0.02241f
C5279 a_19642_6132# a_20102_6606# 0.01714f
C5280 a_10022_5406# a_10308_5724# 0.50066f
C5281 sg13cmos5l_nand3_1_1.Y sg13cmos5l_xnor2_1_5.A 0.14445f
C5282 a_15782_6918# VPWR 0.92936f
C5283 sg13cmos5l_nor3_1_4.A a_17137_6529# 0.01588f
C5284 sg13cmos5l_buf_1_4.A sg13cmos5l_dlygate4sd3_1_22.X 0.19623f
C5285 sg13cmos5l_buf_1_1.X a_20298_2680# 0.05941f
C5286 sg13cmos5l_dfrbpq_1_58.RESET_B a_6453_4703# 0.32195f
C5287 sg13cmos5l_buf_1_0.X sg13cmos5l_dlygate4sd3_1_6.X 1.11475f
C5288 sg13cmos5l_dfrbpq_1_55.Q sg13cmos5l_buf_8_3.A 0.08672f
C5289 sg13cmos5l_dlygate4sd3_1_17.X a_28376_3898# 0.01436f
C5290 a_20388_5724# a_21647_5483# 0.01741f
C5291 sg13cmos5l_xor2_1_2.A sg13cmos5l_dfrbpq_1_53.RESET_B 0.6691f
C5292 sg13cmos5l_dfrbpq_1_46.CLK sg13cmos5l_and2_1_1.X 0.01811f
C5293 sg13cmos5l_xnor2_1_6.A a_1190_1632# 0.05726f
C5294 sg13cmos5l_dlygate4sd3_1_17.A a_27023_5483# 0.01025f
C5295 sg13cmos5l_dfrbpq_1_46.CLK sg13cmos5l_xnor2_1_10.Y 0.03661f
C5296 sg13cmos5l_dlygate4sd3_1_55.A VPWR 0.7937f
C5297 sg13cmos5l_dfrbpq_1_58.D sg13cmos5l_nand3_1_1.Y 1.85967f
C5298 a_9176_3185# VPWR 0.37452f
C5299 sg13cmos5l_dlygate4sd3_1_0.X a_28376_874# 0.13689f
C5300 sg13cmos5l_dlygate4sd3_1_20.A a_6261_1679# 0.01482f
C5301 sg13cmos5l_dfrbpq_1_0.D sg13cmos5l_nand3_1_0.A 0.17665f
C5302 sg13cmos5l_dfrbpq_1_32.CLK sg13cmos5l_and2_1_3.A 0.0274f
C5303 a_13783_1596# a_13563_874# 0.01393f
C5304 sg13cmos5l_buf_1_0.X osc 0.01808f
C5305 sg13cmos5l_dfrbpq_1_56.CLK a_16356_6931# 0.01373f
C5306 a_6391_3858# a_6951_4112# 0.3087f
C5307 sg13cmos5l_dfrbpq_1_21.RESET_B a_7799_4285# 0.13895f
C5308 a_10022_870# a_10725_849# 0.02453f
C5309 sg13cmos5l_nand3_1_1.A sg13cmos5l_nand3_1_1.B 0.851f
C5310 a_23872_8728# a_24170_8728# 0.42343f
C5311 a_23660_8728# sg13cmos5l_nand3_1_2.A 0.04872f
C5312 sg13cmos5l_dfrbpq_1_21.RESET_B a_3608_7721# 0.02823f
C5313 sg13cmos5l_dfrbpq_1_0.CLK a_25707_4016# 0.0954f
C5314 sg13cmos5l_buf_8_4.A a_6551_5797# 0.02032f
C5315 sg13cmos5l_dfrbpq_1_13.RESET_B a_5319_1719# 0.56836f
C5316 sg13cmos5l_xor2_1_2.A a_13592_4697# 0.03201f
C5317 sg13cmos5l_dlygate4sd3_1_55.X a_23558_6918# 0.02343f
C5318 sg13cmos5l_dfrbpq_1_13.RESET_B a_10231_2346# 0.0468f
C5319 sg13cmos5l_buf_8_10.A a_15782_6918# 0.02583f
C5320 sg13cmos5l_buf_1_4.A sg13cmos5l_nor4_2_0.D 3.06597f
C5321 sg13cmos5l_dfrbpq_1_57.D VPWR 0.67684f
C5322 sg13cmos5l_buf_1_11.A a_2816_8562# 0.05863f
C5323 a_17109_4703# a_17015_4703# 0.87117f
C5324 sg13cmos5l_buf_8_2.X a_26159_3505# 0.01597f
C5325 sg13cmos5l_xnor2_1_3.A a_28532_2680# 0.11687f
C5326 sg13cmos5l_buf_1_11.A sg13cmos5l_dlygate4sd3_1_35.A 1.43739f
C5327 sg13cmos5l_nor3_1_0.C a_18972_1993# 0.02168f
C5328 a_19845_849# a_19947_992# 0.66105f
C5329 sg13cmos5l_nor3_1_2.C sg13cmos5l_xnor2_1_9.A 0.06604f
C5330 a_5532_5017# a_6314_4936# 0.4806f
C5331 sg13cmos5l_buf_1_4.A sg13cmos5l_dfrbpq_1_13.RESET_B 0.16198f
C5332 a_24780_5596# VPWR 0.26179f
C5333 a_20102_6606# a_20676_6593# 0.36169f
C5334 a_6604_8430# VPWR 0.18732f
C5335 sg13cmos5l_buf_8_4.A sg13cmos5l_xnor2_1_5.Y 0.02686f
C5336 a_18951_1719# VPWR 0.20799f
C5337 sg13cmos5l_dfrbpq_1_39.Q a_20000_6254# 0.07232f
C5338 a_20388_8748# sg13cmos5l_dfrbpq_1_46.CLK 0.09799f
C5339 a_20805_8409# a_20907_8552# 0.66105f
C5340 a_17584_7138# VPWR 0.18843f
C5341 sg13cmos5l_dfrbpq_1_21.RESET_B sg13cmos5l_xnor2_1_8.Y 0.06698f
C5342 a_18972_1993# a_19893_1679# 0.43042f
C5343 sg13cmos5l_buf_1_0.A a_3905_1898# 0.02104f
C5344 a_17036_1596# VPWR 0.31363f
C5345 a_20805_5385# a_21553_5483# 0.01058f
C5346 a_21647_5483# a_21904_5626# 0.40419f
C5347 a_6272_8605# a_6391_8394# 0.13494f
C5348 sg13cmos5l_dfrbpq_1_57.CLK a_10282_7141# 0.01661f
C5349 a_13834_2605# a_13860_2700# 0.43042f
C5350 sg13cmos5l_dfrbpq_1_57.D sg13cmos5l_buf_8_10.A 0.15985f
C5351 sg13cmos5l_buf_1_4.A a_9558_938# 0.01296f
C5352 a_26410_7141# a_26853_6897# 0.02241f
C5353 sg13cmos5l_buf_1_2.A sg13cmos5l_dfrbpq_1_56.D 0.40681f
C5354 sg13cmos5l_xnor2_1_9.A a_1985_6434# 0.02767f
C5355 sg13cmos5l_dfrbpq_1_57.D a_14186_7680# 0.15222f
C5356 sg13cmos5l_buf_1_4.X a_24806_870# 0.11647f
C5357 sg13cmos5l_buf_8_0.X VPWR 1.91234f
C5358 sg13cmos5l_dlygate4sd3_1_57.A sg13cmos5l_dfrbpq_1_56.D 0.02131f
C5359 a_4759_1596# a_5319_1719# 0.3087f
C5360 a_4972_2070# a_5230_2070# 0.01017f
C5361 sg13cmos5l_dfrbpq_1_13.RESET_B sg13cmos5l_dlygate4sd3_1_21.X 0.20573f
C5362 sg13cmos5l_xnor2_1_4.A a_26447_3971# 0.01749f
C5363 sg13cmos5l_dlygate4sd3_1_18.X a_10943_3115# 0.01956f
C5364 sg13cmos5l_dfrbpq_1_22.D sg13cmos5l_dfrbpq_1_11.CLK 0.04749f
C5365 sg13cmos5l_buf_8_3.A a_10702_3582# 0.02284f
C5366 sg13cmos5l_nor4_2_0.C a_24170_1168# 0.10626f
C5367 sg13cmos5l_nor4_2_5.C a_4395_8552# 0.01227f
C5368 a_8312_4697# sg13cmos5l_nand3_1_3.Y 0.01258f
C5369 sg13cmos5l_dfrbpq_1_53.RESET_B a_11594_7960# 0.01141f
C5370 sg13cmos5l_dfrbpq_1_35.Q VPWR 0.75519f
C5371 a_13860_3148# a_14277_3155# 0.49014f
C5372 a_20805_4667# VPWR 0.23817f
C5373 sg13cmos5l_buf_8_11.A a_25354_7648# 0.01539f
C5374 sg13cmos5l_buf_8_10.A a_17584_7138# 0.01281f
C5375 sg13cmos5l_buf_1_1.X a_26135_1679# 0.09596f
C5376 sg13cmos5l_dlygate4sd3_1_51.X a_20805_5385# 0.01016f
C5377 sg13cmos5l_dfrbpq_1_16.Q a_4470_5474# 0.04507f
C5378 sg13cmos5l_nand3_1_3.Y sg13cmos5l_nor4_2_3.Y 0.26455f
C5379 a_4511_2652# a_4380_2346# 0.49014f
C5380 a_13642_5374# a_14824_5538# 0.01093f
C5381 sg13cmos5l_dlygate4sd3_1_4.A sg13cmos5l_xnor2_1_4.B 0.04566f
C5382 a_1784_8434# a_2054_8434# 0.33585f
C5383 sg13cmos5l_nor3_1_2.B en[4] 0.87405f
C5384 a_3904_4656# a_4202_4656# 0.42343f
C5385 a_5511_4743# a_6314_4936# 0.15089f
C5386 sg13cmos5l_buf_1_4.A sg13cmos5l_dfrbpq_1_0.CLK 0.19931f
C5387 a_1384_8468# en[4] 0.33177f
C5388 sg13cmos5l_xnor2_1_3.B a_18272_1919# 0.01373f
C5389 sg13cmos5l_xnor2_1_4.Y a_28559_3514# 0.05833f
C5390 sg13cmos5l_dfrbpq_1_53.RESET_B a_25094_8118# 0.14512f
C5391 sg13cmos5l_dfrbpq_1_53.Q sg13cmos5l_dlygate4sd3_1_4.A 0.51955f
C5392 sg13cmos5l_dlygate4sd3_1_52.A sg13cmos5l_xnor2_1_5.Y 0.0252f
C5393 sg13cmos5l_nor3_1_0.B sg13cmos5l_xnor2_1_1.B 0.02899f
C5394 sg13cmos5l_dlygate4sd3_1_31.X sg13cmos5l_dfrbpq_1_53.RESET_B 0.02371f
C5395 a_17518_7947# sg13cmos5l_buf_1_2.A 0.01156f
C5396 a_17914_7644# a_17633_7946# 0.33585f
C5397 a_11824_5626# a_12234_5704# 0.1396f
C5398 sg13cmos5l_buf_1_4.A a_26416_3386# 0.01179f
C5399 sg13cmos5l_dlygate4sd3_1_23.X a_3904_4656# 0.05274f
C5400 sg13cmos5l_and2_1_1.A VPWR 3.69962f
C5401 sg13cmos5l_buf_1_0.X sg13cmos5l_buf_1_1.X 0.03612f
C5402 a_4359_1088# a_5207_1261# 0.11742f
C5403 sg13cmos5l_dfrbpq_1_52.Q a_17518_7947# 0.01737f
C5404 a_14360_3898# VPWR 0.32823f
C5405 sg13cmos5l_dlygate4sd3_1_51.X a_20362_6136# 0.01304f
C5406 a_10231_6132# a_10812_6529# 0.01741f
C5407 sg13cmos5l_nor4_2_9.D sg13cmos5l_dfrbpq_1_58.D 0.3017f
C5408 a_9558_6192# a_9446_6168# 0.67711f
C5409 sg13cmos5l_dfrbpq_1_39.Q sg13cmos5l_dlygate4sd3_1_51.X 0.03742f
C5410 sg13cmos5l_dfrbpq_1_35.Q sg13cmos5l_buf_8_10.A 0.01017f
C5411 sg13cmos5l_dlygate4sd3_1_23.X a_3876_3148# 0.02181f
C5412 sg13cmos5l_xnor2_1_6.B a_7351_1596# 0.04269f
C5413 sg13cmos5l_dfrbpq_1_3.Q VPWR 0.6091f
C5414 sg13cmos5l_dfrbpq_1_57.CLK en[4] 0.31021f
C5415 sg13cmos5l_dfrbpq_1_7.Q a_27195_3514# 0.21721f
C5416 sg13cmos5l_xnor2_1_4.A sg13cmos5l_dlygate4sd3_1_17.A 0.06004f
C5417 a_9562_3862# sg13cmos5l_nand3_1_3.B 0.01082f
C5418 sg13cmos5l_dfrbpq_1_22.D sg13cmos5l_buf_8_3.A 1.00317f
C5419 sg13cmos5l_dlygate4sd3_1_18.X a_11276_4192# 0.10528f
C5420 sg13cmos5l_xnor2_1_4.B VPWR 0.85144f
C5421 sg13cmos5l_buf_1_4.X a_26608_1090# 0.17693f
C5422 a_8133_2361# a_8063_1603# 0.04143f
C5423 sg13cmos5l_nor4_2_9.Y a_3904_4656# 0.02358f
C5424 sg13cmos5l_dfrbpq_1_21.RESET_B a_8848_7922# 0.17065f
C5425 sg13cmos5l_dfrbpq_1_22.D sg13cmos5l_dfrbpq_1_54.Q 0.18628f
C5426 sg13cmos5l_dfrbpq_1_12.Q a_13860_3148# 0.0249f
C5427 a_18891_2504# a_19103_1603# 0.01667f
C5428 a_11824_8650# a_12234_8728# 0.1396f
C5429 sg13cmos5l_dfrbpq_1_53.Q VPWR 0.56603f
C5430 sg13cmos5l_xnor2_1_1.Y a_18080_1718# 0.01073f
C5431 sg13cmos5l_buf_8_5.A a_10022_5406# 0.01275f
C5432 sg13cmos5l_buf_8_4.A a_8842_6886# 0.06419f
C5433 a_13860_2700# VPWR 0.12678f
C5434 a_21904_4898# VPWR 0.18875f
C5435 sg13cmos5l_buf_8_11.A a_26639_8041# 0.0156f
C5436 a_7690_2605# a_7430_2382# 0.87117f
C5437 sg13cmos5l_dfrbpq_1_13.CLK a_7716_2700# 0.09597f
C5438 sg13cmos5l_buf_1_4.X a_24940_2070# 0.0239f
C5439 a_24326_6606# a_25029_6179# 0.02431f
C5440 sg13cmos5l_xor2_1_2.A sg13cmos5l_xnor2_1_5.Y 0.02365f
C5441 a_2920_8468# a_3304_8562# 0.03269f
C5442 sg13cmos5l_dfrbpq_1_42.Q sg13cmos5l_buf_8_11.A 0.04246f
C5443 sg13cmos5l_nor4_2_5.C a_4663_7644# 0.0462f
C5444 sg13cmos5l_buf_8_4.A sg13cmos5l_dfrbpq_1_23.D 0.03232f
C5445 a_5471_1603# VPWR 0.24411f
C5446 sg13cmos5l_dfrbpq_1_57.RESET_B a_10308_8748# 0.5089f
C5447 a_10282_8653# a_10725_8409# 0.02241f
C5448 sg13cmos5l_dlygate4sd3_1_22.X a_4012_870# 0.01009f
C5449 sg13cmos5l_dlygate4sd3_1_6.A sg13cmos5l_buf_1_4.X 0.03621f
C5450 sg13cmos5l_buf_1_4.A a_25092_1188# 0.0133f
C5451 a_15708_8394# a_15598_8430# 0.4858f
C5452 a_19845_849# a_20593_947# 0.01058f
C5453 sg13cmos5l_dfrbpq_1_53.RESET_B a_7851_7691# 0.01112f
C5454 sg13cmos5l_dlygate4sd3_1_6.X sg13cmos5l_buf_1_4.X 0.04333f
C5455 a_5663_4627# a_6359_4703# 0.02453f
C5456 sg13cmos5l_buf_8_11.A a_20311_7644# 0.01478f
C5457 sg13cmos5l_dfrbpq_1_11.CLK a_14148_2395# 0.01652f
C5458 a_21904_6410# a_22314_6168# 0.1396f
C5459 a_27963_6538# a_28289_5596# 0.0135f
C5460 sg13cmos5l_dfrbpq_1_53.RESET_B a_25899_7691# 0.5889f
C5461 sg13cmos5l_buf_1_0.X sg13cmos5l_xnor2_1_4.A 0.0349f
C5462 sg13cmos5l_dlygate4sd3_1_6.A a_19055_3971# 0.02891f
C5463 sg13cmos5l_xnor2_1_3.A a_18862_2070# 0.01115f
C5464 sg13cmos5l_dlygate4sd3_1_51.X a_20907_6179# 0.01389f
C5465 a_18843_5410# a_18826_4620# 0.04432f
C5466 a_10812_6529# a_10791_6255# 0.38902f
C5467 a_20864_3230# VPWR 0.07832f
C5468 sg13cmos5l_buf_8_4.A sg13cmos5l_dlygate4sd3_1_28.A 0.08089f
C5469 sg13cmos5l_dlygate4sd3_1_58.A sg13cmos5l_buf_8_5.A 0.0231f
C5470 sg13cmos5l_dfrbpq_1_2.CLK a_18789_2361# 0.38448f
C5471 sg13cmos5l_buf_1_4.X osc 0.1203f
C5472 sg13cmos5l_dfrbpq_1_21.RESET_B sg13cmos5l_dfrbpq_1_58.RESET_B 0.21256f
C5473 sg13cmos5l_xnor2_1_5.A sg13cmos5l_dfrbpq_1_12.Q 0.11926f
C5474 sg13cmos5l_xnor2_1_2.A en[4] 0.01488f
C5475 a_2166_3168# a_2054_3144# 0.67711f
C5476 sg13cmos5l_dfrbpq_1_12.D a_3876_3148# 0.01208f
C5477 a_7932_1993# a_7822_2070# 0.4858f
C5478 a_7564_2070# a_7911_1719# 0.06746f
C5479 sg13cmos5l_nor4_2_4.D sg13cmos5l_buf_1_5.A 0.1546f
C5480 a_18272_1919# a_18391_1596# 0.13494f
C5481 sg13cmos5l_dlygate4sd3_1_33.A VPWR 0.38379f
C5482 a_27610_1596# a_27416_874# 0.01738f
C5483 a_25738_8653# a_26181_8409# 0.02241f
C5484 sg13cmos5l_dfrbpq_1_53.RESET_B a_25764_8748# 0.50029f
C5485 a_28936_7766# en[3] 0.05868f
C5486 a_9232_2602# sg13cmos5l_dlygate4sd3_1_18.A 0.02555f
C5487 sg13cmos5l_dfrbpq_1_57.D sg13cmos5l_nand3_1_1.A 0.5329f
C5488 sg13cmos5l_dfrbpq_1_13.RESET_B a_4012_870# 0.17584f
C5489 sg13cmos5l_dfrbpq_1_11.CLK a_13563_874# 1.06287f
C5490 a_25029_6179# a_24900_6593# 0.01562f
C5491 a_24612_6172# a_25131_6179# 0.38871f
C5492 a_15127_8394# VPWR 0.16769f
C5493 sg13cmos5l_dfrbpq_1_13.CLK a_4640_1919# 0.04734f
C5494 a_14495_1603# a_15146_1912# 0.01562f
C5495 sg13cmos5l_dlygate4sd3_1_52.A sg13cmos5l_dfrbpq_1_23.D 0.12917f
C5496 sg13cmos5l_nand3_1_2.C a_27137_6434# 0.01146f
C5497 sg13cmos5l_nor4_2_4.D a_17729_8620# 0.01084f
C5498 sg13cmos5l_dfrbpq_1_57.RESET_B a_11639_7727# 0.11652f
C5499 sg13cmos5l_dfrbpq_1_37.D a_28174_5595# 0.19414f
C5500 sg13cmos5l_dfrbpq_1_2.CLK a_18213_3873# 0.36335f
C5501 sg13cmos5l_dfrbpq_1_53.RESET_B sg13cmos5l_buf_1_4.A 0.05236f
C5502 sg13cmos5l_dlygate4sd3_1_19.X sg13cmos5l_dfrbpq_1_21.Q 0.24353f
C5503 sg13cmos5l_xnor2_1_2.A a_16188_5017# 0.02847f
C5504 a_4088_5410# a_4358_5410# 0.33585f
C5505 a_15708_8394# a_16535_8821# 0.50066f
C5506 sg13cmos5l_dfrbpq_1_2.D a_21857_1898# 0.01338f
C5507 sg13cmos5l_buf_8_11.A a_20871_7767# 0.02988f
C5508 sg13cmos5l_nor3_1_4.B a_19246_6435# 0.19346f
C5509 sg13cmos5l_dfrbpq_1_53.RESET_B sg13cmos5l_dlygate4sd3_1_39.A 0.0148f
C5510 a_6604_870# a_6951_1088# 0.07014f
C5511 sg13cmos5l_dlygate4sd3_1_9.X a_25871_6529# 0.03927f
C5512 sg13cmos5l_dlygate4sd3_1_51.X sg13cmos5l_dlygate4sd3_1_55.A 0.34389f
C5513 sg13cmos5l_and2_1_1.A a_20102_3894# 0.01178f
C5514 a_10791_6255# a_11594_6448# 0.15089f
C5515 sg13cmos5l_dfrbpq_1_56.RESET_B sg13cmos5l_nor3_1_4.A 0.18718f
C5516 a_19799_1679# VPWR 0.92809f
C5517 a_17770_4117# a_18213_3873# 0.02241f
C5518 sg13cmos5l_dlygate4sd3_1_52.A sg13cmos5l_dlygate4sd3_1_28.A 0.21588f
C5519 sg13cmos5l_buf_8_4.A sg13cmos5l_nand3_1_1.Y 0.02593f
C5520 a_19055_3971# a_18981_3155# 0.013f
C5521 a_3590_3582# sg13cmos5l_xnor2_1_6.A 0.01498f
C5522 sg13cmos5l_xnor2_1_0.A sg13cmos5l_dlygate4sd3_1_21.X 0.16322f
C5523 a_4293_3155# a_5041_3505# 0.01058f
C5524 sg13cmos5l_buf_1_4.A a_15322_838# 0.01193f
C5525 sg13cmos5l_nand3_1_1.A sg13cmos5l_buf_8_0.X 0.02438f
C5526 a_21270_2680# VPWR 0.43877f
C5527 a_5223_7767# VPWR 0.20763f
C5528 sg13cmos5l_xor2_1_2.A a_13888_7680# 0.04122f
C5529 sg13cmos5l_dlygate4sd3_1_31.X a_2016_7233# 0.02077f
C5530 a_20490_3144# sg13cmos5l_dlygate4sd3_1_13.A 0.13104f
C5531 sg13cmos5l_dlygate4sd3_1_21.X a_8004_2395# 0.02066f
C5532 sg13cmos5l_dfrbpq_1_22.Q a_10112_2557# 0.13332f
C5533 sg13cmos5l_dfrbpq_1_57.D sg13cmos5l_dlygate4sd3_1_50.A 1.457f
C5534 sg13cmos5l_xnor2_1_13.A sg13cmos5l_nand3_1_3.Y 0.04258f
C5535 sg13cmos5l_buf_8_3.A a_13563_874# 0.56881f
C5536 a_16068_7236# a_16587_7040# 0.38902f
C5537 sg13cmos5l_dfrbpq_1_35.Q sg13cmos5l_nand3_1_1.A 0.02895f
C5538 sg13cmos5l_nor3_1_2.B VPWR 0.83309f
C5539 sg13cmos5l_xnor2_1_8.Y a_6276_7236# 0.0278f
C5540 a_1384_8468# VPWR 0.24888f
C5541 sg13cmos5l_dfrbpq_1_53.RESET_B sg13cmos5l_nor3_1_0.C 0.03148f
C5542 a_10282_1600# VPWR 0.09536f
C5543 a_27214_1899# sg13cmos5l_nor4_2_0.D 0.19471f
C5544 a_25131_6179# a_25871_6529# 0.3087f
C5545 sg13cmos5l_dfrbpq_1_32.CLK a_6180_6172# 0.10754f
C5546 sg13cmos5l_dlygate4sd3_1_52.A a_9558_5474# 0.01721f
C5547 sg13cmos5l_buf_1_4.A sg13cmos5l_nor3_1_1.Y 0.97421f
C5548 sg13cmos5l_xnor2_1_8.Y sg13cmos5l_dfrbpq_1_58.Q 0.36232f
C5549 sg13cmos5l_buf_8_11.A a_27790_7947# 0.03163f
C5550 sg13cmos5l_nor3_1_1.Y a_16541_1168# 0.02677f
C5551 a_21934_1059# a_22049_1060# 0.67711f
C5552 sg13cmos5l_buf_1_4.X sg13cmos5l_buf_1_1.X 0.30037f
C5553 sg13cmos5l_dlygate4sd3_1_19.X a_6250_3108# 0.01104f
C5554 sg13cmos5l_dfrbpq_1_56.RESET_B a_17327_6995# 0.19877f
C5555 sg13cmos5l_buf_1_4.X a_25317_3155# 0.0872f
C5556 sg13cmos5l_nor3_1_0.B a_19142_870# 0.02186f
C5557 sg13cmos5l_dfrbpq_1_57.CLK VPWR 2.11055f
C5558 sg13cmos5l_dfrbpq_1_13.CLK VPWR 2.41076f
C5559 sg13cmos5l_nand3_1_0.B a_23660_1168# 0.0488f
C5560 a_10943_7651# VPWR 0.24262f
C5561 sg13cmos5l_dfrbpq_1_37.D a_24170_5704# 0.02518f
C5562 sg13cmos5l_dlygate4sd3_1_40.A a_27963_6538# 0.03599f
C5563 sg13cmos5l_buf_1_0.X a_24132_6931# 0.01917f
C5564 sg13cmos5l_dfrbpq_1_18.D sg13cmos5l_dlygate4sd3_1_21.X 6.9695f
C5565 sg13cmos5l_dlygate4sd3_1_19.A a_3590_3582# 0.0403f
C5566 a_19722_4192# sg13cmos5l_dfrbpq_1_5.Q 0.13104f
C5567 sg13cmos5l_dfrbpq_1_46.D sg13cmos5l_dfrbpq_1_53.RESET_B 0.06265f
C5568 a_10943_6139# sg13cmos5l_dlygate4sd3_1_52.X 0.01061f
C5569 a_11733_6215# a_11639_6215# 0.87117f
C5570 sg13cmos5l_buf_1_4.A sg13cmos5l_xnor2_1_3.A 0.03246f
C5571 sg13cmos5l_nor4_2_5.D a_4762_6886# 0.01089f
C5572 sg13cmos5l_dlygate4sd3_1_21.X sg13cmos5l_nor3_1_1.Y 0.06402f
C5573 sg13cmos5l_dlygate4sd3_1_52.A sg13cmos5l_nand3_1_1.Y 0.03405f
C5574 sg13cmos5l_xnor2_1_2.A a_16164_5724# 0.04669f
C5575 sg13cmos5l_xnor2_1_4.B a_25188_4212# 0.04274f
C5576 sg13cmos5l_buf_1_0.A sg13cmos5l_dlygate4sd3_1_18.A 0.0194f
C5577 sg13cmos5l_xnor2_1_4.A a_25478_5094# 0.01905f
C5578 sg13cmos5l_xnor2_1_10.Y a_24815_5410# 0.04203f
C5579 sg13cmos5l_dlygate4sd3_1_19.X a_1265_5460# 0.09446f
C5580 a_23744_7766# VPWR 0.11254f
C5581 sg13cmos5l_xnor2_1_8.Y sg13cmos5l_dlygate4sd3_1_30.A 0.14991f
C5582 sg13cmos5l_buf_1_0.A sg13cmos5l_dlygate4sd3_1_20.A 0.02624f
C5583 a_5244_8041# VPWR 0.07284f
C5584 a_3488_8562# VPWR 0.06722f
C5585 a_15782_6918# a_16356_6931# 0.36169f
C5586 sg13cmos5l_dfrbpq_1_29.Q sg13cmos5l_dfrbpq_1_35.Q 0.01483f
C5587 sg13cmos5l_dfrbpq_1_57.CLK sg13cmos5l_buf_8_10.A 0.76893f
C5588 sg13cmos5l_dfrbpq_1_13.CLK a_8714_1912# 0.02417f
C5589 sg13cmos5l_dlygate4sd3_1_38.A en[4] 0.05293f
C5590 a_16042_7141# a_16485_6897# 0.02241f
C5591 sg13cmos5l_dfrbpq_1_32.CLK a_6699_6179# 0.01548f
C5592 sg13cmos5l_xnor2_1_0.Y sg13cmos5l_xor2_1_1.B 0.05841f
C5593 a_23368_4742# VPWR 0.14951f
C5594 sg13cmos5l_nor4_2_0.D a_24170_1168# 0.11893f
C5595 sg13cmos5l_xnor2_1_4.A sg13cmos5l_buf_1_4.X 0.05167f
C5596 sg13cmos5l_buf_1_4.X a_24902_3894# 0.11046f
C5597 a_4359_1088# VPWR 0.20718f
C5598 sg13cmos5l_buf_1_0.A sg13cmos5l_dlygate4sd3_1_19.X 1.38168f
C5599 sg13cmos5l_buf_1_0.A sg13cmos5l_buf_1_0.X 5.9507f
C5600 a_3488_3230# VPWR 0.06882f
C5601 a_20362_8653# en[3] 0.03854f
C5602 sg13cmos5l_xnor2_1_4.B a_25029_6179# 0.03818f
C5603 a_9558_4680# a_10112_4943# 0.03282f
C5604 a_7534_4923# a_7328_4742# 0.03208f
C5605 sg13cmos5l_xor2_1_2.A sg13cmos5l_nand3_1_1.Y 0.01704f
C5606 sg13cmos5l_buf_1_0.X a_20805_6179# 0.06638f
C5607 sg13cmos5l_dfrbpq_1_37.D a_28289_5596# 0.01169f
C5608 sg13cmos5l_nor3_1_0.C sg13cmos5l_xnor2_1_3.A 0.20524f
C5609 sg13cmos5l_dlygate4sd3_1_0.X a_28374_1656# 0.0398f
C5610 a_11639_2773# VPWR 1.02588f
C5611 sg13cmos5l_dfrbpq_1_56.RESET_B sg13cmos5l_nor3_1_4.B 0.23691f
C5612 sg13cmos5l_dfrbpq_1_2.CLK a_19845_849# 0.37229f
C5613 sg13cmos5l_dlygate4sd3_1_17.X a_27963_6538# 0.02963f
C5614 sg13cmos5l_nand3_1_2.B sg13cmos5l_nor4_2_0.C 0.01198f
C5615 sg13cmos5l_buf_8_4.A sg13cmos5l_nor4_2_9.D 0.1863f
C5616 a_20805_3873# a_20676_3907# 0.01562f
C5617 sg13cmos5l_buf_1_1.X sg13cmos5l_dlygate4sd3_1_15.A 3.54895f
C5618 sg13cmos5l_xnor2_1_2.A VPWR 1.51429f
C5619 sg13cmos5l_dfrbpq_1_46.CLK sg13cmos5l_dfrbpq_1_53.RESET_B 0.10291f
C5620 a_7744_3144# a_8042_3144# 0.42343f
C5621 sg13cmos5l_dfrbpq_1_0.CLK a_27195_3514# 1.06119f
C5622 sg13cmos5l_dfrbpq_1_55.RESET_B sg13cmos5l_nor3_1_1.C 4.81066f
C5623 sg13cmos5l_dlygate4sd3_1_15.A a_25317_3155# 0.01296f
C5624 sg13cmos5l_xnor2_1_3.A a_18444_1060# 0.12761f
C5625 sg13cmos5l_buf_1_5.A sg13cmos5l_dlygate4sd3_1_6.A 0.0426f
C5626 sg13cmos5l_dfrbpq_1_2.D sg13cmos5l_and2_1_0.X 0.01227f
C5627 sg13cmos5l_nor3_1_2.C a_8591_8041# 0.02837f
C5628 sg13cmos5l_buf_1_4.A sg13cmos5l_dlygate4sd3_1_1.A 0.06385f
C5629 sg13cmos5l_xnor2_1_12.B a_7534_4923# 0.19497f
C5630 a_7103_8700# a_7799_8821# 0.02431f
C5631 a_6951_8648# a_6972_8394# 0.38871f
C5632 sg13cmos5l_dlygate4sd3_1_22.A a_5301_1028# 0.01678f
C5633 sg13cmos5l_nor3_1_0.A sg13cmos5l_xnor2_1_1.B 0.17292f
C5634 a_18593_8620# VPWR 0.23974f
C5635 sg13cmos5l_dlygate4sd3_1_55.X a_23712_6207# 0.01387f
C5636 sg13cmos5l_dlygate4sd3_1_13.A a_22330_2350# 0.52182f
C5637 a_14343_1719# VPWR 0.20678f
C5638 sg13cmos5l_nand3_1_2.A sg13cmos5l_nor4_2_7.D 0.09637f
C5639 a_808_4742# a_992_4742# 0.11523f
C5640 a_3876_8748# a_4164_8443# 0.4806f
C5641 a_20362_4624# a_20388_4660# 0.43042f
C5642 sg13cmos5l_dlygate4sd3_1_21.X a_1302_1656# 0.19382f
C5643 sg13cmos5l_xnor2_1_2.A sg13cmos5l_buf_8_10.A 0.0475f
C5644 sg13cmos5l_dlygate4sd3_1_39.X sg13cmos5l_nor4_2_7.D 0.0216f
C5645 a_20676_8443# en[3] 0.02209f
C5646 a_25288_4742# VPWR 0.14143f
C5647 sg13cmos5l_dlygate4sd3_1_34.A sg13cmos5l_dlygate4sd3_1_33.A 0.43083f
C5648 a_7532_3144# VPWR 0.41596f
C5649 sg13cmos5l_buf_1_0.X a_24586_6136# 0.33446f
C5650 sg13cmos5l_dfrbpq_1_58.RESET_B a_6276_7236# 0.51559f
C5651 sg13cmos5l_dfrbpq_1_58.RESET_B a_6506_5564# 0.01916f
C5652 a_23660_1168# a_23872_1168# 0.31789f
C5653 sg13cmos5l_nand3_1_2.Y a_24526_4923# 0.01339f
C5654 sg13cmos5l_dlygate4sd3_1_9.A sg13cmos5l_nor3_1_0.C 0.23062f
C5655 a_7103_4164# a_6972_3858# 0.49014f
C5656 sg13cmos5l_dfrbpq_1_58.RESET_B sg13cmos5l_dfrbpq_1_58.Q 0.02156f
C5657 sg13cmos5l_nor4_2_5.D a_4730_6168# 0.11844f
C5658 a_9176_4697# a_9446_4656# 0.33585f
C5659 sg13cmos5l_dlygate4sd3_1_51.A sg13cmos5l_dlygate4sd3_1_10.A 0.05883f
C5660 sg13cmos5l_buf_1_0.X a_21647_6529# 0.25271f
C5661 sg13cmos5l_xnor2_1_4.A sg13cmos5l_dlygate4sd3_1_15.A 0.667f
C5662 a_23846_3898# a_23958_3962# 0.67711f
C5663 sg13cmos5l_nor4_2_1.A sg13cmos5l_nor3_1_0.C 0.03825f
C5664 sg13cmos5l_dfrbpq_1_37.D a_25103_6995# 0.01771f
C5665 a_25478_8430# VPWR 0.92643f
C5666 sg13cmos5l_dfrbpq_1_21.RESET_B a_7930_4620# 0.08288f
C5667 sg13cmos5l_dlygate4sd3_1_47.A sg13cmos5l_nand3_1_2.A 0.04392f
C5668 sg13cmos5l_dfrbpq_1_55.RESET_B a_15285_1679# 0.31876f
C5669 a_10943_3115# a_11639_3191# 0.02453f
C5670 sg13cmos5l_dfrbpq_1_55.RESET_B a_15786_3144# 0.01287f
C5671 a_27610_1596# VPWR 0.32993f
C5672 sg13cmos5l_dlygate4sd3_1_47.A sg13cmos5l_dlygate4sd3_1_39.X 0.19796f
C5673 sg13cmos5l_xnor2_1_3.B a_18213_3873# 0.03431f
C5674 sg13cmos5l_dlygate4sd3_1_22.X sg13cmos5l_dlygate4sd3_1_22.A 1.82098f
C5675 a_2632_7050# VPWR 0.15649f
C5676 a_1985_2572# a_2266_2350# 0.33585f
C5677 a_10308_7236# a_10827_7040# 0.38902f
C5678 a_23576_1673# a_23846_1632# 0.33585f
C5679 sg13cmos5l_xnor2_1_2.A sg13cmos5l_nor3_1_1.A 1.12161f
C5680 a_1192_7050# VPWR 0.20009f
C5681 sg13cmos5l_nor4_2_5.D sg13cmos5l_nor4_2_5.B 0.99577f
C5682 a_16188_5017# a_17015_4703# 0.50066f
C5683 sg13cmos5l_nor3_1_2.C a_8497_8041# 0.01771f
C5684 a_1000_8468# en[0] 0.33141f
C5685 sg13cmos5l_buf_1_1.X a_25679_2459# 0.21312f
C5686 a_7799_8821# a_7893_8588# 0.87117f
C5687 a_10231_7644# VPWR 0.17143f
C5688 a_27905_7946# VPWR 0.24547f
C5689 a_28289_5596# a_28289_4922# 0.01869f
C5690 sg13cmos5l_xor2_1_2.A a_14632_8562# 0.02255f
C5691 sg13cmos5l_dfrbpq_1_58.RESET_B a_5894_6606# 0.10715f
C5692 a_3680_1045# a_4012_870# 0.1396f
C5693 a_27023_8507# a_27690_8728# 0.13494f
C5694 sg13cmos5l_and2_1_1.X sg13cmos5l_nand3_1_2.B 0.2265f
C5695 sg13cmos5l_dfrbpq_1_29.Q a_15127_8394# 0.01704f
C5696 sg13cmos5l_dlygate4sd3_1_31.X sg13cmos5l_xnor2_1_13.Y 0.07742f
C5697 a_1248_4695# sg13cmos5l_xnor2_1_12.Y 0.23006f
C5698 sg13cmos5l_dlygate4sd3_1_34.A a_5223_7767# 0.01117f
C5699 sg13cmos5l_xnor2_1_2.A a_16385_2572# 0.05786f
C5700 sg13cmos5l_buf_1_0.A sg13cmos5l_xnor2_1_8.Y 0.85788f
C5701 a_20388_4660# a_20676_5081# 0.4806f
C5702 a_13288_3230# VPWR 0.14295f
C5703 sg13cmos5l_nand3_1_2.A a_24922_4620# 0.02755f
C5704 sg13cmos5l_xnor2_1_10.Y sg13cmos5l_nand3_1_2.B 0.40374f
C5705 sg13cmos5l_dfrbpq_1_13.RESET_B a_3590_3894# 0.02348f
C5706 sg13cmos5l_and2_1_1.X a_23846_3144# 0.05346f
C5707 a_10791_2600# a_11594_2540# 0.15089f
C5708 a_18664_7766# VPWR 0.13951f
C5709 a_9166_4083# sg13cmos5l_dlygate4sd3_1_22.X 0.05009f
C5710 sg13cmos5l_buf_1_0.X a_26128_6410# 0.17013f
C5711 a_15680_7050# sg13cmos5l_nor3_1_4.B 0.06872f
C5712 sg13cmos5l_nor4_2_0.D a_27329_1898# 0.01063f
C5713 a_25066_1093# a_24806_870# 0.87117f
C5714 sg13cmos5l_dlygate4sd3_1_4.A a_28506_2578# 0.02898f
C5715 sg13cmos5l_dfrbpq_1_13.RESET_B sg13cmos5l_dfrbpq_1_55.RESET_B 0.01902f
C5716 sg13cmos5l_xnor2_1_4.A sg13cmos5l_dlygate4sd3_1_2.A 0.08083f
C5717 sg13cmos5l_dlygate4sd3_1_34.A sg13cmos5l_nor3_1_2.B 0.47109f
C5718 a_10725_849# a_11473_947# 0.01058f
C5719 a_11567_947# a_11824_1090# 0.40419f
C5720 a_25707_4016# a_25476_3907# 0.15089f
C5721 a_25188_4212# a_26353_3971# 0.4858f
C5722 a_10022_8430# a_10596_8443# 0.36169f
C5723 a_10444_5094# a_10791_4743# 0.06746f
C5724 a_10812_5017# a_10702_5094# 0.4858f
C5725 a_10827_8552# a_11824_8650# 0.06746f
C5726 sg13cmos5l_xnor2_1_5.A sg13cmos5l_xnor2_1_2.Y 0.57301f
C5727 sg13cmos5l_dlygate4sd3_1_38.A a_6795_7040# 0.02341f
C5728 sg13cmos5l_dfrbpq_1_13.RESET_B a_7822_2070# 0.0141f
C5729 a_13860_3148# a_15119_3505# 0.01741f
C5730 sg13cmos5l_dfrbpq_1_13.RESET_B sg13cmos5l_dlygate4sd3_1_22.A 2.7794f
C5731 sg13cmos5l_dfrbpq_1_55.D sg13cmos5l_dfrbpq_1_59.Q 0.50866f
C5732 a_4012_2382# a_4270_2382# 0.01017f
C5733 a_23712_6207# a_23861_6538# 0.3658f
C5734 sg13cmos5l_dfrbpq_1_37.D a_23872_8728# 0.05091f
C5735 sg13cmos5l_buf_1_5.A sg13cmos5l_xor2_1_2.B 0.04574f
C5736 a_10308_7236# a_10596_6931# 0.4806f
C5737 a_1985_1898# VPWR 0.24418f
C5738 a_15839_8700# a_16490_8588# 0.01562f
C5739 sg13cmos5l_dfrbpq_1_3.D a_23660_1168# 0.11726f
C5740 sg13cmos5l_dfrbpq_1_21.RESET_B sg13cmos5l_dlygate4sd3_1_53.A 0.10429f
C5741 sg13cmos5l_nor4_2_7.D sg13cmos5l_dlygate4sd3_1_55.A 0.0159f
C5742 a_28506_2578# VPWR 0.29385f
C5743 sg13cmos5l_buf_1_2.A sg13cmos5l_xnor2_1_2.Y 0.5847f
C5744 sg13cmos5l_dlygate4sd3_1_38.A VPWR 0.50941f
C5745 a_28289_8620# a_28570_8398# 0.33585f
C5746 sg13cmos5l_dfrbpq_1_11.CLK a_13860_2700# 0.1339f
C5747 sg13cmos5l_dfrbpq_1_3.D a_20792_1673# 0.02374f
C5748 a_14742_3962# VPWR 0.21284f
C5749 sg13cmos5l_and2_1_1.X a_23844_7236# 0.01673f
C5750 a_24134_2382# a_24708_2395# 0.36169f
C5751 sg13cmos5l_xnor2_1_0.Y a_1985_2572# 0.05357f
C5752 sg13cmos5l_buf_1_0.A sg13cmos5l_buf_1_4.X 0.0927f
C5753 a_18538_3112# VPWR 0.0948f
C5754 sg13cmos5l_dlygate4sd3_1_6.A a_18564_3148# 0.01126f
C5755 a_19638_8498# VPWR 0.21297f
C5756 a_20676_5081# a_20907_4667# 0.15089f
C5757 sg13cmos5l_dfrbpq_1_13.CLK a_6972_834# 0.07693f
C5758 a_11488_4192# sg13cmos5l_nand3_1_3.B 0.03386f
C5759 sg13cmos5l_xnor2_1_5.Y a_16566_3168# 0.01827f
C5760 sg13cmos5l_dlygate4sd3_1_34.A a_5244_8041# 0.02856f
C5761 a_28646_3898# a_28758_3962# 0.67711f
C5762 sg13cmos5l_nor4_2_9.Y sg13cmos5l_dfrbpq_1_23.Q 0.02255f
C5763 a_7351_1596# a_7564_2070# 0.40419f
C5764 a_5471_1603# a_6122_1912# 0.01562f
C5765 a_25509_849# a_25611_992# 0.66105f
C5766 sg13cmos5l_nand3_1_3.Y sg13cmos5l_xor2_1_1.B 0.70653f
C5767 a_28936_8562# a_28936_7766# 0.01095f
C5768 a_16566_3168# a_16454_3144# 0.67711f
C5769 sg13cmos5l_dfrbpq_1_55.Q a_14364_1993# 0.02785f
C5770 a_1985_1898# a_1784_874# 0.01425f
C5771 a_15850_3862# osc 0.55596f
C5772 sg13cmos5l_dlygate4sd3_1_38.A sg13cmos5l_buf_8_10.A 0.04967f
C5773 a_3304_4742# VPWR 0.14144f
C5774 sg13cmos5l_xnor2_1_2.A sg13cmos5l_nand3_1_1.A 0.15197f
C5775 sg13cmos5l_nor4_2_7.D a_24780_5596# 0.03289f
C5776 a_18826_4620# sg13cmos5l_buf_8_2.X 0.54004f
C5777 a_13996_2070# a_14254_2070# 0.01017f
C5778 a_13783_1596# a_14343_1719# 0.3087f
C5779 a_11567_6995# a_11473_6995# 0.32273f
C5780 sg13cmos5l_buf_1_4.A a_26436_7236# 0.01619f
C5781 sg13cmos5l_xnor2_1_2.B en[4] 2.73356f
C5782 sg13cmos5l_buf_8_3.A a_13860_2700# 0.05429f
C5783 sg13cmos5l_dlygate4sd3_1_39.A a_26436_7236# 0.02712f
C5784 sg13cmos5l_dlygate4sd3_1_11.X sg13cmos5l_dfrbpq_1_7.Q 0.25352f
C5785 a_17015_4703# VPWR 0.92863f
C5786 sg13cmos5l_dfrbpq_1_56.CLK a_15687_8648# 0.01712f
C5787 sg13cmos5l_dlygate4sd3_1_55.A a_24922_4620# 0.50353f
C5788 sg13cmos5l_nor4_2_7.B a_23558_6918# 0.3343f
C5789 sg13cmos5l_dfrbpq_1_5.Q VPWR 0.75624f
C5790 a_19947_992# VPWR 0.20718f
C5791 sg13cmos5l_dfrbpq_1_2.CLK sg13cmos5l_nor4_2_1.D 0.02568f
C5792 sg13cmos5l_nor3_1_0.A a_19142_870# 0.01451f
C5793 sg13cmos5l_dfrbpq_1_58.RESET_B a_7345_6529# 0.01066f
C5794 a_24874_3112# VPWR 0.09417f
C5795 a_20907_8552# VPWR 0.20677f
C5796 sg13cmos5l_xnor2_1_6.B a_8063_1603# 0.03205f
C5797 a_808_5538# a_992_5538# 0.11523f
C5798 a_14742_3962# sg13cmos5l_nor3_1_1.A 0.19376f
C5799 a_25764_8748# en[3] 0.02115f
C5800 a_15850_3862# sg13cmos5l_nor3_1_4.Y 0.01163f
C5801 sg13cmos5l_dlygate4sd3_1_55.X a_23835_8050# 0.12297f
C5802 a_21647_5017# a_21553_5017# 0.32273f
C5803 sg13cmos5l_xnor2_1_6.B a_1152_1185# 0.42339f
C5804 sg13cmos5l_dfrbpq_1_32.CLK a_7799_8821# 0.02164f
C5805 sg13cmos5l_dfrbpq_1_23.D a_3488_4742# 0.03361f
C5806 a_3590_3582# a_3850_3112# 0.87117f
C5807 sg13cmos5l_nor4_2_4.D a_14926_6435# 0.01215f
C5808 sg13cmos5l_dlygate4sd3_1_4.A a_28262_1632# 0.05356f
C5809 sg13cmos5l_dfrbpq_1_21.RESET_B a_3799_2346# 0.21504f
C5810 sg13cmos5l_buf_1_0.A sg13cmos5l_dfrbpq_1_58.RESET_B 0.02313f
C5811 sg13cmos5l_dfrbpq_1_0.D a_26945_2572# 0.01317f
C5812 sg13cmos5l_xnor2_1_2.B a_16188_5017# 0.03692f
C5813 sg13cmos5l_and2_1_1.A a_20666_2680# 0.02136f
C5814 a_25092_1188# a_25380_883# 0.4806f
C5815 a_18564_3148# a_18981_3155# 0.49014f
C5816 a_18278_3582# a_19083_3155# 0.11742f
C5817 a_20362_4117# osc 0.01525f
C5818 sg13cmos5l_buf_1_0.A sg13cmos5l_dfrbpq_1_2.Q 0.02395f
C5819 a_10943_4627# a_11733_4703# 0.02241f
C5820 a_10791_4743# a_11639_4703# 0.11742f
C5821 a_10231_2346# a_10812_2346# 0.01741f
C5822 a_4202_4656# VPWR 0.17835f
C5823 sg13cmos5l_buf_1_4.A en[3] 0.03284f
C5824 sg13cmos5l_dlygate4sd3_1_39.X sg13cmos5l_dfrbpq_1_53.CLK 0.20531f
C5825 sg13cmos5l_dlygate4sd3_1_23.X VPWR 0.67438f
C5826 a_7911_1719# VPWR 0.20578f
C5827 sg13cmos5l_dlygate4sd3_1_22.X a_7103_1140# 0.01981f
C5828 sg13cmos5l_buf_1_4.A a_27952_7138# 0.01158f
C5829 a_2632_7766# a_2816_7766# 0.11523f
C5830 a_28262_1632# VPWR 0.24664f
C5831 sg13cmos5l_buf_1_4.X a_17510_3894# 0.12443f
C5832 a_25162_4117# VPWR 0.09608f
C5833 a_25738_5629# a_25764_5724# 0.43042f
C5834 sg13cmos5l_dfrbpq_1_56.CLK sg13cmos5l_nor4_2_4.D 0.17066f
C5835 sg13cmos5l_nor4_2_7.D sg13cmos5l_xnor2_1_4.B 0.18494f
C5836 sg13cmos5l_nor4_2_7.B a_25103_6995# 0.01821f
C5837 sg13cmos5l_buf_1_0.A a_11824_1874# 0.0107f
C5838 sg13cmos5l_dlygate4sd3_1_17.X a_28289_4922# 0.03557f
C5839 a_20687_947# VPWR 0.17088f
C5840 a_3680_2557# VPWR 0.48695f
C5841 sg13cmos5l_dfrbpq_1_29.Q a_18593_8620# 0.02349f
C5842 sg13cmos5l_nor4_2_9.Y VPWR 0.19877f
C5843 sg13cmos5l_dlygate4sd3_1_17.X a_27690_4656# 0.01267f
C5844 sg13cmos5l_buf_1_0.X a_26135_1679# 0.0171f
C5845 a_16319_4627# a_15850_3862# 0.01659f
C5846 sg13cmos5l_xnor2_1_2.B a_15972_6172# 0.01768f
C5847 sg13cmos5l_nand3_1_0.B VPWR 0.162f
C5848 sg13cmos5l_buf_1_1.X a_18564_3148# 0.51899f
C5849 sg13cmos5l_dlygate4sd3_1_19.A sg13cmos5l_dfrbpq_1_13.CLK 0.01219f
C5850 a_5135_3505# a_5802_3144# 0.13494f
C5851 a_5392_3386# a_5041_3505# 0.01017f
C5852 sg13cmos5l_buf_1_0.A sg13cmos5l_dlygate4sd3_1_2.A 0.01729f
C5853 sg13cmos5l_dfrbpq_1_23.D a_5663_4627# 0.01412f
C5854 a_7103_8700# a_7749_7691# 0.05236f
C5855 sg13cmos5l_dfrbpq_1_2.D sg13cmos5l_dfrbpq_1_0.D 0.60371f
C5856 sg13cmos5l_dfrbpq_1_0.D a_25308_1993# 0.02224f
C5857 a_7911_1719# a_8714_1912# 0.15089f
C5858 sg13cmos5l_dfrbpq_1_11.CLK sg13cmos5l_dfrbpq_1_13.CLK 0.16451f
C5859 a_18972_1993# a_19103_1603# 0.48921f
C5860 sg13cmos5l_buf_1_4.A sg13cmos5l_nand3_1_0.A 2.97799f
C5861 sg13cmos5l_dlygate4sd3_1_31.X sg13cmos5l_xnor2_1_9.A 1.66473f
C5862 a_26351_947# a_26257_947# 0.32273f
C5863 sg13cmos5l_xnor2_1_0.A sg13cmos5l_dlygate4sd3_1_22.A 0.03612f
C5864 sg13cmos5l_dfrbpq_1_57.RESET_B a_10827_7040# 0.58526f
C5865 a_18372_2700# VPWR 0.12696f
C5866 sg13cmos5l_dfrbpq_1_53.CLK a_26410_7141# 0.02636f
C5867 sg13cmos5l_dlygate4sd3_1_47.A sg13cmos5l_dfrbpq_1_53.Q 0.13129f
C5868 a_16535_8821# VPWR 0.92718f
C5869 sg13cmos5l_nor4_2_5.Y en[4] 0.19692f
C5870 a_18346_2605# VPWR 0.13787f
C5871 sg13cmos5l_dlygate4sd3_1_4.X sg13cmos5l_dlygate4sd3_1_40.A 0.03037f
C5872 sg13cmos5l_dfrbpq_1_13.RESET_B a_7103_1140# 0.067f
C5873 sg13cmos5l_nor3_1_0.A a_17100_2572# 0.04932f
C5874 a_19609_6942# en[4] 0.01582f
C5875 sg13cmos5l_xnor2_1_2.B a_16164_5724# 0.02383f
C5876 sg13cmos5l_dfrbpq_1_55.RESET_B a_15322_838# 0.02525f
C5877 sg13cmos5l_dfrbpq_1_46.D en[3] 0.0236f
C5878 sg13cmos5l_dfrbpq_1_58.RESET_B a_5143_5370# 0.20421f
C5879 sg13cmos5l_dfrbpq_1_12.D VPWR 2.36869f
C5880 sg13cmos5l_nor4_2_7.B a_26955_7040# 0.03314f
C5881 sg13cmos5l_nor4_2_7.B sg13cmos5l_dlygate4sd3_1_40.A 0.8117f
C5882 sg13cmos5l_dfrbpq_1_58.D a_5422_5094# 0.02035f
C5883 a_1784_8434# a_1985_7946# 0.01258f
C5884 sg13cmos5l_nand3_1_2.B sg13cmos5l_dfrbpq_1_0.CLK 0.01894f
C5885 sg13cmos5l_dfrbpq_1_5.Q a_20102_3894# 0.05151f
C5886 a_20362_4117# sg13cmos5l_buf_1_1.X 0.3206f
C5887 sg13cmos5l_dlygate4sd3_1_1.A a_27990_2450# 0.0108f
C5888 a_21904_8650# a_22314_8728# 0.1396f
C5889 sg13cmos5l_nor3_1_0.C sg13cmos5l_nand3_1_0.A 1.08482f
C5890 sg13cmos5l_xnor2_1_6.A a_7532_3144# 0.12514f
C5891 sg13cmos5l_buf_8_3.A sg13cmos5l_dfrbpq_1_13.CLK 0.05181f
C5892 sg13cmos5l_xnor2_1_2.B a_14822_8118# 0.01956f
C5893 sg13cmos5l_dfrbpq_1_57.Q a_9176_4697# 0.01142f
C5894 a_24900_3148# a_25317_3155# 0.49014f
C5895 a_24614_3582# a_25188_3569# 0.36169f
C5896 sg13cmos5l_dfrbpq_1_23.D a_7534_4923# 0.01129f
C5897 sg13cmos5l_dfrbpq_1_57.RESET_B a_10791_4743# 0.55322f
C5898 sg13cmos5l_nor4_2_5.C sg13cmos5l_dfrbpq_1_53.RESET_B 0.79403f
C5899 a_6693_6897# a_7441_6995# 0.01058f
C5900 sg13cmos5l_and2_1_3.A a_13888_6168# 0.02688f
C5901 sg13cmos5l_nand3_1_0.A a_18444_1060# 0.04499f
C5902 sg13cmos5l_dlygate4sd3_1_22.A a_3680_1045# 0.01206f
C5903 a_13974_4680# a_14542_4923# 0.03281f
C5904 sg13cmos5l_xnor2_1_2.B VPWR 1.71688f
C5905 sg13cmos5l_dfrbpq_1_37.D a_23712_6207# 0.03828f
C5906 sg13cmos5l_buf_8_4.A a_6391_3858# 0.01685f
C5907 sg13cmos5l_dlygate4sd3_1_28.X a_13888_6168# 0.0295f
C5908 a_13288_1002# a_13472_1002# 0.11523f
C5909 sg13cmos5l_dlygate4sd3_1_4.X sg13cmos5l_dlygate4sd3_1_17.X 0.24804f
C5910 a_10112_4943# VPWR 0.45413f
C5911 sg13cmos5l_nor4_2_9.Y a_3896_6209# 0.03458f
C5912 sg13cmos5l_dfrbpq_1_16.Q a_4202_4656# 0.0278f
C5913 sg13cmos5l_nor4_2_9.D a_4832_4943# 0.03069f
C5914 a_5143_5370# a_4951_4620# 0.0121f
C5915 sg13cmos5l_dfrbpq_1_3.Q sg13cmos5l_xnor2_1_1.B 0.17003f
C5916 sg13cmos5l_nand3_1_0.A a_20972_2680# 0.02176f
C5917 a_4395_8552# sg13cmos5l_dfrbpq_1_32.CLK 0.01714f
C5918 sg13cmos5l_buf_1_4.X a_26447_3971# 0.19883f
C5919 sg13cmos5l_dfrbpq_1_46.CLK en[3] 0.06102f
C5920 sg13cmos5l_dlygate4sd3_1_18.X a_9446_874# 0.01703f
C5921 sg13cmos5l_dlygate4sd3_1_21.A a_1152_1185# 0.01793f
C5922 a_13773_6964# sg13cmos5l_and2_1_4.X 0.16292f
C5923 a_6272_4069# a_6391_3858# 0.13494f
C5924 sg13cmos5l_nand3_1_1.A a_17015_4703# 0.05f
C5925 sg13cmos5l_xnor2_1_3.A a_27329_1898# 0.01299f
C5926 sg13cmos5l_dlygate4sd3_1_33.A a_4544_7967# 0.13282f
C5927 sg13cmos5l_xnor2_1_0.Y a_11567_1993# 0.017f
C5928 a_992_4742# VPWR 0.06962f
C5929 sg13cmos5l_buf_1_0.A a_16320_1671# 0.01098f
C5930 sg13cmos5l_dfrbpq_1_12.Q a_13574_2382# 0.04751f
C5931 sg13cmos5l_dfrbpq_1_11.CLK a_14343_1719# 0.05115f
C5932 a_18789_2361# a_18891_2504# 0.66105f
C5933 a_25764_5724# a_26052_5419# 0.4806f
C5934 sg13cmos5l_buf_1_1.X sg13cmos5l_nor3_1_0.B 3.66542f
C5935 a_21647_3971# a_21553_3971# 0.32273f
C5936 a_23872_1168# VPWR 0.39108f
C5937 sg13cmos5l_and2_1_3.A sg13cmos5l_dfrbpq_1_23.Q 0.65689f
C5938 a_2054_8434# sg13cmos5l_nor4_2_5.C 0.01157f
C5939 sg13cmos5l_dfrbpq_1_13.RESET_B a_8133_2361# 0.05852f
C5940 sg13cmos5l_dfrbpq_1_12.D a_15041_1060# 0.01351f
C5941 sg13cmos5l_nor4_2_9.Y sg13cmos5l_dfrbpq_1_16.Q 0.44905f
C5942 a_10812_3505# a_11594_3424# 0.4806f
C5943 sg13cmos5l_dfrbpq_1_55.RESET_B a_11733_3191# 0.35285f
C5944 sg13cmos5l_xnor2_1_2.B sg13cmos5l_buf_8_10.A 0.02381f
C5945 sg13cmos5l_dfrbpq_1_2.D a_18084_3907# 0.02632f
C5946 sg13cmos5l_dfrbpq_1_55.RESET_B a_13996_2070# 0.18138f
C5947 sg13cmos5l_xnor2_1_2.B a_14186_7680# 0.01508f
C5948 sg13cmos5l_nor3_1_0.B a_24394_2605# 0.02533f
C5949 a_10022_2070# a_10596_2057# 0.36169f
C5950 sg13cmos5l_dlygate4sd3_1_57.A a_15340_8430# 0.01324f
C5951 sg13cmos5l_xnor2_1_3.B sg13cmos5l_nor4_2_1.D 0.02102f
C5952 a_8842_6886# a_10022_6918# 0.04744f
C5953 sg13cmos5l_buf_1_0.X sg13cmos5l_dlygate4sd3_1_16.A 0.01395f
C5954 sg13cmos5l_buf_8_4.A a_8591_8041# 0.02256f
C5955 sg13cmos5l_xnor2_1_2.A sg13cmos5l_dfrbpq_1_54.Q 0.01737f
C5956 a_8202_7216# sg13cmos5l_dlygate4sd3_1_53.A 0.13387f
C5957 sg13cmos5l_dlygate4sd3_1_55.X sg13cmos5l_and2_1_1.X 0.31767f
C5958 sg13cmos5l_dlygate4sd3_1_55.X sg13cmos5l_xnor2_1_10.Y 0.63226f
C5959 sg13cmos5l_nor4_2_4.D sg13cmos5l_nand3_1_1.B 0.35391f
C5960 a_8582_4656# VPWR 0.24367f
C5961 a_26283_8552# a_27023_8507# 0.3087f
C5962 sg13cmos5l_buf_1_4.X a_22314_4656# 0.01131f
C5963 sg13cmos5l_xnor2_1_2.B sg13cmos5l_nor3_1_1.A 1.68588f
C5964 sg13cmos5l_dfrbpq_1_32.CLK a_6071_7727# 0.01158f
C5965 a_11567_6995# VPWR 0.17366f
C5966 sg13cmos5l_nand3_1_2.C sg13cmos5l_dfrbpq_1_0.CLK 0.02803f
C5967 sg13cmos5l_dfrbpq_1_56.RESET_B a_17109_4703# 0.3184f
C5968 sg13cmos5l_dfrbpq_1_0.D sg13cmos5l_nor4_2_0.B 0.02196f
C5969 sg13cmos5l_nor3_1_0.C a_20102_5094# 0.30106f
C5970 a_6604_870# VPWR 0.18767f
C5971 sg13cmos5l_buf_1_4.X sg13cmos5l_dlygate4sd3_1_18.A 0.07122f
C5972 sg13cmos5l_dfrbpq_1_56.CLK sg13cmos5l_dlygate4sd3_1_6.A 0.05455f
C5973 sg13cmos5l_dlygate4sd3_1_11.A a_28174_4923# 0.03957f
C5974 a_4663_7644# a_5134_8118# 0.32273f
C5975 sg13cmos5l_dfrbpq_1_32.CLK a_4663_7644# 0.03218f
C5976 sg13cmos5l_dfrbpq_1_16.Q sg13cmos5l_dfrbpq_1_12.D 0.01459f
C5977 sg13cmos5l_xnor2_1_5.Y sg13cmos5l_dfrbpq_1_55.RESET_B 0.18773f
C5978 a_10308_1188# a_10827_992# 0.38902f
C5979 sg13cmos5l_nor3_1_2.B a_6165_7727# 0.01956f
C5980 sg13cmos5l_dlygate4sd3_1_33.A sg13cmos5l_nor4_2_5.D 0.22183f
C5981 a_9562_3862# a_9446_3144# 0.01201f
C5982 a_25162_4117# a_25188_4212# 0.43042f
C5983 sg13cmos5l_nor3_1_0.B a_24902_3894# 0.29959f
C5984 a_10725_8409# a_10827_8552# 0.66105f
C5985 a_10308_8748# sg13cmos5l_dfrbpq_1_57.CLK 0.09924f
C5986 sg13cmos5l_buf_8_2.X sg13cmos5l_nor4_2_0.C 0.05369f
C5987 sg13cmos5l_dlygate4sd3_1_53.A a_8488_6254# 0.01115f
C5988 a_13888_6168# a_14186_6168# 0.42343f
C5989 a_27690_5704# a_28174_5595# 0.03282f
C5990 a_25611_992# VPWR 0.20561f
C5991 sg13cmos5l_dfrbpq_1_55.RESET_B a_16454_3144# 0.01263f
C5992 sg13cmos5l_nor3_1_2.B a_4544_7967# 0.01261f
C5993 sg13cmos5l_xnor2_1_2.B a_16385_2572# 0.05063f
C5994 a_10702_8118# a_10943_7651# 0.01058f
C5995 a_3680_2557# a_3488_2514# 0.03403f
C5996 sg13cmos5l_dfrbpq_1_13.Q a_4511_2652# 0.02156f
C5997 a_18826_4620# a_18213_3873# 0.01637f
C5998 sg13cmos5l_nor4_2_4.D a_17633_7946# 0.01024f
C5999 sg13cmos5l_buf_1_0.X sg13cmos5l_buf_1_4.X 0.17353f
C6000 a_20311_6882# a_20782_6918# 0.32273f
C6001 sg13cmos5l_dfrbpq_1_21.RESET_B a_7535_6995# 0.04267f
C6002 sg13cmos5l_nor4_2_5.Y VPWR 0.11003f
C6003 sg13cmos5l_nor3_1_0.C a_18278_3582# 0.03247f
C6004 sg13cmos5l_buf_8_10.A a_11567_6995# 0.01708f
C6005 a_15607_4620# a_16078_5094# 0.32273f
C6006 sg13cmos5l_dfrbpq_1_53.CLK sg13cmos5l_xnor2_1_4.B 0.10331f
C6007 a_19609_6942# VPWR 0.62432f
C6008 a_992_5538# VPWR 0.06957f
C6009 sg13cmos5l_dfrbpq_1_3.D VPWR 0.87498f
C6010 sg13cmos5l_dlygate4sd3_1_4.A a_28376_874# 0.5234f
C6011 sg13cmos5l_dfrbpq_1_53.CLK sg13cmos5l_dfrbpq_1_53.Q 0.16663f
C6012 sg13cmos5l_dlygate4sd3_1_18.X VPWR 1.09931f
C6013 a_13592_4697# sg13cmos5l_dfrbpq_1_17.D 0.01221f
C6014 a_24134_2382# a_24420_2700# 0.50066f
C6015 sg13cmos5l_buf_8_4.A sg13cmos5l_nand3_1_3.Y 0.058f
C6016 sg13cmos5l_buf_1_4.A a_27022_6435# 0.04599f
C6017 sg13cmos5l_dlygate4sd3_1_5.A VPWR 0.47067f
C6018 a_5855_5676# a_5663_4627# 0.05836f
C6019 sg13cmos5l_dfrbpq_1_32.CLK a_7749_7691# 0.34802f
C6020 sg13cmos5l_and2_1_3.A VPWR 2.09278f
C6021 sg13cmos5l_buf_1_4.A a_10022_870# 0.01392f
C6022 a_9166_4083# sg13cmos5l_nand3_1_3.B 0.01138f
C6023 a_9281_4084# sg13cmos5l_dlygate4sd3_1_22.X 0.0278f
C6024 a_9562_3862# a_9915_3898# 0.11303f
C6025 sg13cmos5l_dlygate4sd3_1_17.A sg13cmos5l_dlygate4sd3_1_15.A 0.29774f
C6026 sg13cmos5l_nor3_1_0.C a_20000_4742# 0.06873f
C6027 a_10231_2346# a_10702_2382# 0.32273f
C6028 sg13cmos5l_nand3_1_1.Y a_10231_4620# 0.01447f
C6029 a_5244_8041# a_6165_7727# 0.43042f
C6030 a_26704_4114# a_26353_3971# 0.01017f
C6031 sg13cmos5l_dlygate4sd3_1_28.X VPWR 0.48725f
C6032 a_5340_1993# a_5319_1719# 0.38902f
C6033 a_5703_5624# a_6551_5797# 0.11742f
C6034 sg13cmos5l_dfrbpq_1_56.Q a_14938_4620# 0.09381f
C6035 a_28376_874# VPWR 0.33444f
C6036 a_15376_3386# a_15119_3505# 0.40419f
C6037 sg13cmos5l_buf_1_0.X a_20192_7967# 0.02297f
C6038 a_3990_7704# a_3878_7680# 0.67711f
C6039 a_4663_7644# a_4876_8118# 0.40419f
C6040 sg13cmos5l_and2_1_3.A a_6154_6136# 0.01593f
C6041 a_15322_6132# a_15686_6606# 0.02797f
C6042 sg13cmos5l_nor3_1_2.B sg13cmos5l_nor4_2_5.D 0.01962f
C6043 sg13cmos5l_nor4_2_7.D a_25668_8105# 0.0101f
C6044 a_10943_7651# a_11639_7727# 0.02453f
C6045 a_18593_8620# en[2] 0.0235f
C6046 a_14926_6435# sg13cmos5l_xor2_1_2.B 0.19302f
C6047 sg13cmos5l_buf_1_11.A sg13cmos5l_dlygate4sd3_1_31.X 0.0172f
C6048 sg13cmos5l_dfrbpq_1_2.CLK VPWR 2.40516f
C6049 sg13cmos5l_dfrbpq_1_53.Q a_28570_4620# 0.04085f
C6050 sg13cmos5l_buf_1_5.A sg13cmos5l_dlygate4sd3_1_52.X 2.32117f
C6051 a_20871_7136# a_21719_7309# 0.11742f
C6052 a_23958_1656# VPWR 0.21323f
C6053 sg13cmos5l_dfrbpq_1_56.RESET_B a_15708_8394# 0.51674f
C6054 a_16078_5094# a_16319_4627# 0.01058f
C6055 sg13cmos5l_xnor2_1_3.B a_18604_2070# 0.04568f
C6056 a_24526_4923# a_24641_4922# 0.67711f
C6057 sg13cmos5l_buf_1_0.X sg13cmos5l_dlygate4sd3_1_15.A 0.01968f
C6058 sg13cmos5l_dfrbpq_1_21.RESET_B sg13cmos5l_nor4_2_5.B 0.17629f
C6059 sg13cmos5l_xnor2_1_2.B sg13cmos5l_nand3_1_1.A 0.21583f
C6060 sg13cmos5l_buf_8_10.A sg13cmos5l_dlygate4sd3_1_28.X 0.64406f
C6061 a_17770_4117# VPWR 0.096f
C6062 sg13cmos5l_dfrbpq_1_29.Q a_16535_8821# 0.02034f
C6063 a_4380_834# a_5207_1261# 0.50066f
C6064 sg13cmos5l_and2_1_1.X sg13cmos5l_buf_8_2.X 0.0257f
C6065 sg13cmos5l_dlygate4sd3_1_23.X sg13cmos5l_xnor2_1_6.A 0.01048f
C6066 sg13cmos5l_buf_8_5.A sg13cmos5l_dlygate4sd3_1_22.X 0.05297f
C6067 sg13cmos5l_buf_8_2.X sg13cmos5l_dfrbpq_1_7.Q 0.20266f
C6068 a_14542_4923# VPWR 0.21237f
C6069 a_20490_3144# VPWR 0.45248f
C6070 sg13cmos5l_dfrbpq_1_37.D a_23835_8050# 0.03861f
C6071 sg13cmos5l_xnor2_1_6.B a_7932_1993# 0.0366f
C6072 sg13cmos5l_dlygate4sd3_1_4.X a_28289_8620# 0.01731f
C6073 sg13cmos5l_dlygate4sd3_1_17.A sg13cmos5l_dlygate4sd3_1_2.A 1.36621f
C6074 a_7046_8118# a_7306_7648# 0.87117f
C6075 a_11567_947# VPWR 0.17516f
C6076 sg13cmos5l_dlygate4sd3_1_21.X a_5340_1993# 0.02093f
C6077 sg13cmos5l_dfrbpq_1_53.RESET_B sg13cmos5l_nand3_1_2.C 0.02436f
C6078 a_1169_3502# sg13cmos5l_dfrbpq_1_21.Q 0.03685f
C6079 a_23558_6918# en[4] 0.01423f
C6080 sg13cmos5l_xnor2_1_5.A a_17132_3108# 0.06236f
C6081 sg13cmos5l_dfrbpq_1_53.RESET_B sg13cmos5l_dlygate4sd3_1_11.X 0.18349f
C6082 sg13cmos5l_nor3_1_1.A a_15025_3505# 0.02197f
C6083 sg13cmos5l_nand3_1_1.Y a_9446_4656# 0.01807f
C6084 a_2920_8468# VPWR 0.29452f
C6085 sg13cmos5l_nor4_2_7.B a_23712_6207# 0.05026f
C6086 sg13cmos5l_dfrbpq_1_56.CLK a_16319_4627# 0.36755f
C6087 a_5356_5406# a_5614_5406# 0.01017f
C6088 sg13cmos5l_buf_1_0.X a_21719_7727# 0.11334f
C6089 a_25094_8118# a_25354_7648# 0.87117f
C6090 sg13cmos5l_dfrbpq_1_21.CLK sg13cmos5l_dfrbpq_1_12.D 0.05911f
C6091 sg13cmos5l_dfrbpq_1_13.RESET_B a_10308_1636# 0.48434f
C6092 a_15686_6606# a_16491_6179# 0.11742f
C6093 a_15972_6172# a_16389_6179# 0.49014f
C6094 sg13cmos5l_buf_8_9.A a_8312_4697# 0.01704f
C6095 a_9176_4697# a_9281_4084# 0.01206f
C6096 a_8975_2459# a_9232_2602# 0.40419f
C6097 a_8133_2361# a_8004_2395# 0.01562f
C6098 sg13cmos5l_nor4_2_7.D a_27905_7946# 0.01862f
C6099 sg13cmos5l_dfrbpq_1_21.RESET_B a_7439_6529# 0.02726f
C6100 a_14379_2504# VPWR 0.27343f
C6101 sg13cmos5l_buf_1_4.X sg13cmos5l_dlygate4sd3_1_16.A 0.05676f
C6102 sg13cmos5l_xnor2_1_2.Y a_16469_2002# 0.05474f
C6103 a_7351_1596# VPWR 0.17489f
C6104 sg13cmos5l_and2_1_3.A a_3896_6209# 0.04589f
C6105 sg13cmos5l_buf_1_2.A a_17132_3108# 0.32591f
C6106 a_5356_5406# VPWR 0.18794f
C6107 a_10725_5385# a_10791_4743# 0.0167f
C6108 sg13cmos5l_dlygate4sd3_1_15.A a_27226_2350# 0.52182f
C6109 a_14186_6168# VPWR 0.18456f
C6110 a_28174_5595# VPWR 0.21408f
C6111 sg13cmos5l_dfrbpq_1_0.D a_28646_874# 0.01918f
C6112 a_15032_5410# sg13cmos5l_dfrbpq_1_56.Q 0.50425f
C6113 a_18664_7766# en[2] 0.06451f
C6114 a_1870_6435# a_1664_6254# 0.03208f
C6115 a_10231_7644# a_10702_8118# 0.32273f
C6116 sg13cmos5l_buf_1_4.X sg13cmos5l_dfrbpq_1_11.Q 0.04381f
C6117 a_23872_5704# a_24170_5704# 0.42343f
C6118 sg13cmos5l_xnor2_1_13.A a_2165_5410# 0.01134f
C6119 sg13cmos5l_dfrbpq_1_29.Q sg13cmos5l_xnor2_1_2.B 0.02014f
C6120 sg13cmos5l_dfrbpq_1_13.RESET_B sg13cmos5l_buf_8_5.A 0.0868f
C6121 a_23660_5704# sg13cmos5l_nand3_1_2.B 0.05098f
C6122 sg13cmos5l_buf_1_4.X a_17432_3185# 0.0283f
C6123 sg13cmos5l_buf_1_0.A a_10022_2070# 0.0248f
C6124 a_20524_6918# VPWR 0.18787f
C6125 a_15296_4742# VPWR 0.07744f
C6126 a_26159_3505# VPWR 0.17652f
C6127 sg13cmos5l_dfrbpq_1_55.RESET_B a_15119_2459# 0.26991f
C6128 sg13cmos5l_nor3_1_4.Y sg13cmos5l_nor3_1_0.A 0.07159f
C6129 a_1265_5460# a_1436_5704# 0.41432f
C6130 a_13288_4742# a_13472_4742# 0.11523f
C6131 sg13cmos5l_nor4_2_4.D sg13cmos5l_dfrbpq_1_57.D 0.15167f
C6132 sg13cmos5l_dfrbpq_1_17.D sg13cmos5l_nand3_1_3.B 0.29072f
C6133 a_7332_7684# a_7620_8105# 0.4806f
C6134 sg13cmos5l_dfrbpq_1_12.D sg13cmos5l_xnor2_1_6.A 2.1065f
C6135 a_3590_3582# a_4164_3569# 0.36169f
C6136 sg13cmos5l_and2_1_3.A sg13cmos5l_dfrbpq_1_16.Q 0.41501f
C6137 sg13cmos5l_dfrbpq_1_21.RESET_B a_5207_2773# 0.11285f
C6138 sg13cmos5l_buf_1_0.A sg13cmos5l_nor3_1_0.B 0.41757f
C6139 sg13cmos5l_buf_1_4.A sg13cmos5l_xnor2_1_0.Y 0.03168f
C6140 sg13cmos5l_nand3_1_1.Y a_11733_4703# 0.01012f
C6141 sg13cmos5l_buf_1_11.A a_2816_7050# 0.05831f
C6142 a_18981_3155# a_19729_3505# 0.01058f
C6143 a_19083_3155# a_20080_3386# 0.07014f
C6144 sg13cmos5l_nor3_1_1.Y a_8133_2361# 0.02044f
C6145 sg13cmos5l_nand3_1_1.B osc 0.01769f
C6146 a_18391_1596# a_18604_2070# 0.40419f
C6147 sg13cmos5l_buf_1_0.A a_3799_2346# 0.03338f
C6148 sg13cmos5l_xnor2_1_1.B a_17621_2002# 0.01034f
C6149 sg13cmos5l_nor3_1_4.C a_15488_4943# 0.05154f
C6150 a_10943_2652# a_11639_2773# 0.02431f
C6151 sg13cmos5l_dfrbpq_1_12.Q a_14254_2070# 0.01983f
C6152 a_10791_2600# a_10812_2346# 0.38871f
C6153 a_25380_7684# a_25668_8105# 0.4806f
C6154 a_10725_6897# a_10791_6255# 0.0167f
C6155 a_4762_6886# sg13cmos5l_dfrbpq_1_58.Q 0.52171f
C6156 a_15972_6172# a_17137_6529# 0.4858f
C6157 sg13cmos5l_dfrbpq_1_13.CLK a_4972_2070# 0.0171f
C6158 a_14343_1719# a_15191_1679# 0.11742f
C6159 a_14495_1603# a_15285_1679# 0.02241f
C6160 sg13cmos5l_nor3_1_2.C a_5990_6918# 0.02676f
C6161 sg13cmos5l_dlygate4sd3_1_6.A sg13cmos5l_dfrbpq_1_39.Q 0.07273f
C6162 a_16164_5724# a_16581_5385# 0.48921f
C6163 a_15878_5406# a_16683_5528# 0.11742f
C6164 sg13cmos5l_dlygate4sd3_1_39.X a_25738_8653# 0.01601f
C6165 a_3799_2346# a_3905_1898# 0.01461f
C6166 sg13cmos5l_nor3_1_2.C a_5230_7107# 0.20916f
C6167 sg13cmos5l_xnor2_1_8.Y sg13cmos5l_dfrbpq_1_58.RESET_B 2.25625f
C6168 sg13cmos5l_dfrbpq_1_3.Q a_17100_2572# 0.0303f
C6169 sg13cmos5l_buf_1_4.X a_19055_3971# 0.19886f
C6170 sg13cmos5l_buf_1_4.A sg13cmos5l_xnor2_1_6.Y 0.92319f
C6171 sg13cmos5l_xnor2_1_5.Y sg13cmos5l_dfrbpq_1_57.Q 0.02534f
C6172 sg13cmos5l_xnor2_1_0.Y sg13cmos5l_dlygate4sd3_1_21.X 7.16176f
C6173 a_4160_7050# VPWR 0.07812f
C6174 a_16389_6179# VPWR 0.23948f
C6175 sg13cmos5l_dfrbpq_1_23.Q a_6180_6172# 0.01097f
C6176 sg13cmos5l_nor4_2_4.D sg13cmos5l_buf_8_0.X 0.01623f
C6177 a_25764_4660# a_26181_4667# 0.49014f
C6178 a_25478_5094# a_26052_5081# 0.36169f
C6179 a_4380_2346# VPWR 0.13367f
C6180 sg13cmos5l_dlygate4sd3_1_6.X sg13cmos5l_nand3_1_2.A 0.12047f
C6181 sg13cmos5l_nand3_1_1.B sg13cmos5l_nor3_1_4.Y 0.68363f
C6182 a_4293_3873# a_4293_3155# 0.11208f
C6183 sg13cmos5l_nor3_1_2.Y VPWR 0.55231f
C6184 sg13cmos5l_nor3_1_0.A sg13cmos5l_buf_1_1.X 0.11923f
C6185 a_18213_3873# a_18961_3971# 0.01058f
C6186 sg13cmos5l_dfrbpq_1_21.RESET_B a_3590_3582# 0.09533f
C6187 a_24170_5704# VPWR 0.23015f
C6188 a_20907_8552# a_21647_8507# 0.3087f
C6189 sg13cmos5l_dfrbpq_1_12.D sg13cmos5l_dfrbpq_1_11.CLK 0.30266f
C6190 a_13472_4742# VPWR 0.06596f
C6191 a_7851_7691# a_8591_8041# 0.3087f
C6192 sg13cmos5l_buf_1_4.A a_17032_908# 0.3281f
C6193 sg13cmos5l_dfrbpq_1_55.RESET_B a_10812_2346# 0.48123f
C6194 a_22330_2350# VPWR 0.44431f
C6195 sg13cmos5l_dfrbpq_1_21.RESET_B a_4470_5474# 0.03746f
C6196 sg13cmos5l_nand3_1_2.A osc 0.02371f
C6197 a_6276_7236# a_7535_6995# 0.01741f
C6198 sg13cmos5l_dlygate4sd3_1_4.A a_28289_5596# 0.05031f
C6199 a_16581_5385# VPWR 0.2441f
C6200 a_25899_7691# a_26639_8041# 0.3087f
C6201 sg13cmos5l_dlygate4sd3_1_11.X sg13cmos5l_dlygate4sd3_1_9.A 0.01979f
C6202 sg13cmos5l_xnor2_1_2.B a_16356_6931# 0.01831f
C6203 a_28374_1656# a_28940_1596# 0.03283f
C6204 sg13cmos5l_dfrbpq_1_57.RESET_B a_16624_7922# 0.17013f
C6205 a_10725_1643# VPWR 0.24419f
C6206 sg13cmos5l_nor4_2_5.C a_5392_8650# 0.01159f
C6207 a_16683_5528# a_17680_5626# 0.06746f
C6208 sg13cmos5l_buf_1_4.X sg13cmos5l_dlygate4sd3_1_15.A 0.04186f
C6209 sg13cmos5l_dlygate4sd3_1_6.X a_20907_6179# 0.02363f
C6210 a_2054_3144# VPWR 0.24239f
C6211 sg13cmos5l_dfrbpq_1_32.CLK en[1] 0.16132f
C6212 a_3590_3894# a_4293_3873# 0.02453f
C6213 sg13cmos5l_nand3_1_1.B sg13cmos5l_xor2_1_2.B 0.31605f
C6214 a_28289_5596# VPWR 0.2434f
C6215 sg13cmos5l_xnor2_1_3.B VPWR 0.90417f
C6216 a_20388_4212# sg13cmos5l_dfrbpq_1_0.CLK 0.07719f
C6217 sg13cmos5l_buf_8_3.A sg13cmos5l_dfrbpq_1_12.D 0.55415f
C6218 a_20805_3873# a_20907_4016# 0.66105f
C6219 sg13cmos5l_nand3_1_1.B a_16319_4627# 0.01141f
C6220 a_23558_6918# VPWR 0.9339f
C6221 sg13cmos5l_dfrbpq_1_13.RESET_B a_4511_2652# 0.01576f
C6222 sg13cmos5l_dfrbpq_1_55.RESET_B a_10812_3505# 0.48601f
C6223 a_6693_6897# a_6597_6179# 0.08475f
C6224 sg13cmos5l_dlygate4sd3_1_18.X a_9642_2680# 0.05778f
C6225 sg13cmos5l_buf_8_2.X a_19823_3505# 0.01043f
C6226 en[0] en[4] 0.01243f
C6227 sg13cmos5l_dfrbpq_1_58.Q a_4730_6168# 0.03659f
C6228 a_15127_8394# a_15687_8648# 0.3087f
C6229 a_24900_3148# a_26065_3505# 0.4858f
C6230 a_25188_3569# a_25419_3155# 0.15089f
C6231 a_9640_7680# a_10112_7967# 0.03469f
C6232 sg13cmos5l_dfrbpq_1_58.D a_5724_5370# 0.01424f
C6233 a_24134_2382# VPWR 1.00301f
C6234 sg13cmos5l_buf_1_4.X a_11824_1874# 0.0128f
C6235 a_7535_6995# a_8202_7216# 0.13494f
C6236 sg13cmos5l_dfrbpq_1_37.D sg13cmos5l_and2_1_1.X 0.2767f
C6237 a_18572_5370# VPWR 0.24804f
C6238 sg13cmos5l_buf_8_4.A a_6951_4112# 0.03214f
C6239 sg13cmos5l_dfrbpq_1_37.D sg13cmos5l_xnor2_1_10.Y 0.20689f
C6240 sg13cmos5l_dlygate4sd3_1_17.X a_27994_3862# 0.02057f
C6241 a_6180_6172# VPWR 0.07225f
C6242 a_6250_7141# a_6693_6897# 0.02241f
C6243 sg13cmos5l_dlygate4sd3_1_57.A a_15686_6606# 0.01281f
C6244 a_25764_8748# a_26283_8552# 0.38902f
C6245 sg13cmos5l_dfrbpq_1_58.Q sg13cmos5l_nor4_2_5.B 0.02271f
C6246 sg13cmos5l_dfrbpq_1_13.CLK a_8853_1679# 0.01447f
C6247 a_14824_5538# VPWR 0.13308f
C6248 sg13cmos5l_dfrbpq_1_21.RESET_B a_6604_8430# 0.20017f
C6249 a_3850_4117# VPWR 0.09684f
C6250 sg13cmos5l_dlygate4sd3_1_57.A a_15322_6132# 0.51243f
C6251 sg13cmos5l_buf_1_4.A a_26283_4667# 0.0254f
C6252 sg13cmos5l_nor4_2_5.C a_5041_8507# 0.02485f
C6253 sg13cmos5l_dfrbpq_1_22.Q VPWR 0.55241f
C6254 a_18090_5704# a_18572_5370# 0.03469f
C6255 sg13cmos5l_dlygate4sd3_1_6.X sg13cmos5l_dlygate4sd3_1_55.A 0.48758f
C6256 a_4380_834# VPWR 0.0721f
C6257 a_4164_3907# sg13cmos5l_dlygate4sd3_1_19.A 0.01042f
C6258 a_6391_3858# a_6604_3894# 0.40419f
C6259 a_18922_7644# a_18363_6922# 0.05096f
C6260 a_6154_6136# a_6180_6172# 0.43042f
C6261 a_24881_8484# a_25052_8728# 0.41432f
C6262 sg13cmos5l_dlygate4sd3_1_55.X sg13cmos5l_dfrbpq_1_53.RESET_B 0.05455f
C6263 a_14720_7766# VPWR 0.07546f
C6264 a_4511_2652# a_4759_1596# 0.01914f
C6265 sg13cmos5l_xnor2_1_5.Y a_10308_5724# 0.02137f
C6266 sg13cmos5l_dlygate4sd3_1_22.X sg13cmos5l_xnor2_1_6.B 0.02981f
C6267 sg13cmos5l_dfrbpq_1_0.CLK a_25605_3873# 0.39094f
C6268 a_5626_6886# VPWR 0.38035f
C6269 a_27023_5017# a_27690_4656# 0.13494f
C6270 sg13cmos5l_dfrbpq_1_15.D a_2632_7050# 0.01639f
C6271 a_27280_4898# a_26929_5017# 0.01017f
C6272 sg13cmos5l_buf_8_2.X sg13cmos5l_dfrbpq_1_0.CLK 0.72182f
C6273 a_20892_8041# a_21674_7960# 0.4806f
C6274 sg13cmos5l_xnor2_1_4.A a_26826_3144# 0.02227f
C6275 sg13cmos5l_dlygate4sd3_1_28.A sg13cmos5l_dfrbpq_1_57.Q 0.01192f
C6276 sg13cmos5l_xnor2_1_8.Y sg13cmos5l_buf_1_5.A 0.21754f
C6277 sg13cmos5l_dfrbpq_1_13.RESET_B a_3790_1899# 0.05724f
C6278 sg13cmos5l_nor3_1_1.C a_10943_3115# 0.01554f
C6279 sg13cmos5l_dfrbpq_1_55.RESET_B a_14277_3155# 0.06544f
C6280 a_25103_6995# VPWR 0.16932f
C6281 sg13cmos5l_buf_8_2.X a_26416_3386# 0.01198f
C6282 sg13cmos5l_nor4_2_0.C a_24708_2395# 0.02544f
C6283 sg13cmos5l_buf_1_4.A a_26229_1679# 0.01348f
C6284 a_16535_8821# en[2] 0.01051f
C6285 a_13288_6254# VPWR 0.15037f
C6286 sg13cmos5l_nor3_1_0.B sg13cmos5l_nor3_1_0.Y 0.29813f
C6287 sg13cmos5l_nor3_1_1.C sg13cmos5l_dfrbpq_1_59.Q 0.32061f
C6288 sg13cmos5l_xnor2_1_4.Y a_25478_5406# 0.01354f
C6289 sg13cmos5l_dfrbpq_1_57.RESET_B a_10444_6606# 0.23854f
C6290 sg13cmos5l_dfrbpq_1_2.D a_18862_2070# 0.01391f
C6291 a_9258_7680# sg13cmos5l_dlygate4sd3_1_38.A 0.13098f
C6292 sg13cmos5l_dfrbpq_1_56.RESET_B en[4] 0.04541f
C6293 sg13cmos5l_dfrbpq_1_12.D a_9920_1718# 0.06831f
C6294 sg13cmos5l_dlygate4sd3_1_22.A a_6272_1045# 0.14178f
C6295 sg13cmos5l_nand3_1_1.Y sg13cmos5l_dfrbpq_1_17.D 0.11361f
C6296 a_18391_1596# VPWR 0.17255f
C6297 a_20102_5406# VPWR 0.92687f
C6298 sg13cmos5l_dlygate4sd3_1_40.A sg13cmos5l_dlygate4sd3_1_4.A 0.0293f
C6299 a_6699_6179# VPWR 0.20801f
C6300 a_6972_3858# VPWR 0.07222f
C6301 sg13cmos5l_dfrbpq_1_57.Q a_9558_5474# 0.05128f
C6302 sg13cmos5l_dlygate4sd3_1_4.A a_28374_1656# 0.0538f
C6303 a_15525_7691# a_15627_7691# 0.6663f
C6304 a_11639_3191# VPWR 0.94091f
C6305 a_5345_7108# a_5626_6886# 0.33585f
C6306 a_4278_6192# VPWR 0.2124f
C6307 sg13cmos5l_dfrbpq_1_58.RESET_B a_4951_4620# 0.19889f
C6308 sg13cmos5l_dfrbpq_1_42.Q sg13cmos5l_dfrbpq_1_46.D 0.51031f
C6309 sg13cmos5l_dlygate4sd3_1_10.A sg13cmos5l_dfrbpq_1_0.CLK 0.06059f
C6310 sg13cmos5l_dlygate4sd3_1_6.A sg13cmos5l_buf_8_0.X 0.14382f
C6311 sg13cmos5l_dfrbpq_1_13.RESET_B sg13cmos5l_xnor2_1_6.B 1.25468f
C6312 sg13cmos5l_dfrbpq_1_56.RESET_B a_16188_5017# 0.49489f
C6313 sg13cmos5l_dfrbpq_1_12.Q sg13cmos5l_dfrbpq_1_55.RESET_B 0.11179f
C6314 a_6180_6172# a_6468_6593# 0.4806f
C6315 a_20102_6606# VPWR 0.92668f
C6316 sg13cmos5l_nor4_2_9.D a_5703_5624# 0.03194f
C6317 a_24261_6897# a_24132_6931# 0.01562f
C6318 a_10022_5406# VPWR 0.92718f
C6319 a_5855_5676# a_5703_5624# 0.6663f
C6320 a_13642_5374# a_13592_4697# 0.01501f
C6321 a_19246_6435# VPWR 0.21456f
C6322 sg13cmos5l_dlygate4sd3_1_39.X sg13cmos5l_xnor2_1_4.A 0.04478f
C6323 a_26955_7040# VPWR 0.20796f
C6324 a_13834_3112# a_14277_3155# 0.02241f
C6325 sg13cmos5l_dlygate4sd3_1_40.A VPWR 0.49959f
C6326 sg13cmos5l_xnor2_1_2.B en[2] 0.63022f
C6327 sg13cmos5l_nand3_1_1.Y sg13cmos5l_dfrbpq_1_57.Q 0.04295f
C6328 a_28374_1656# VPWR 0.21343f
C6329 sg13cmos5l_dlygate4sd3_1_30.A a_3688_6254# 0.07949f
C6330 a_4012_2382# a_4359_2600# 0.07014f
C6331 sg13cmos5l_dlygate4sd3_1_6.X a_20805_4667# 0.01081f
C6332 sg13cmos5l_dlygate4sd3_1_19.X a_1248_4695# 0.02795f
C6333 a_23872_8728# VPWR 0.3911f
C6334 a_10827_1643# a_11567_1993# 0.3087f
C6335 sg13cmos5l_buf_8_0.X osc 0.04857f
C6336 a_3304_4742# a_3304_4026# 0.01275f
C6337 sg13cmos5l_dfrbpq_1_57.RESET_B a_10943_6139# 0.0741f
C6338 sg13cmos5l_nor4_2_5.B a_5334_6168# 0.08493f
C6339 sg13cmos5l_buf_1_1.X a_26346_2680# 0.05447f
C6340 sg13cmos5l_xnor2_1_4.Y a_28524_3410# 0.24549f
C6341 sg13cmos5l_buf_1_4.A a_26945_2572# 0.0235f
C6342 sg13cmos5l_buf_1_4.A a_19402_1093# 0.01366f
C6343 sg13cmos5l_dfrbpq_1_21.RESET_B a_5471_1603# 0.01911f
C6344 sg13cmos5l_nor3_1_0.C a_28174_4923# 0.19882f
C6345 sg13cmos5l_and2_1_1.A sg13cmos5l_dlygate4sd3_1_6.A 0.34037f
C6346 a_21647_5483# VPWR 0.17403f
C6347 sg13cmos5l_dlygate4sd3_1_17.X sg13cmos5l_dlygate4sd3_1_4.A 0.49627f
C6348 a_9176_6209# VPWR 0.35298f
C6349 a_13745_3948# VPWR 0.25465f
C6350 a_6272_8605# VPWR 0.45186f
C6351 a_4832_4943# a_5164_5094# 0.1396f
C6352 a_28186_7644# a_27905_7946# 0.33585f
C6353 sg13cmos5l_nor4_2_1.A a_22049_2572# 0.01495f
C6354 a_3799_834# a_4359_1088# 0.3087f
C6355 sg13cmos5l_nor4_2_5.D sg13cmos5l_nor4_2_9.Y 0.06161f
C6356 sg13cmos5l_dlygate4sd3_1_6.X sg13cmos5l_and2_1_1.A 0.08582f
C6357 sg13cmos5l_dlygate4sd3_1_58.A VPWR 0.50897f
C6358 sg13cmos5l_xnor2_1_6.A a_7351_1596# 0.01116f
C6359 sg13cmos5l_dfrbpq_1_55.D VPWR 0.68523f
C6360 sg13cmos5l_dlygate4sd3_1_57.A a_15525_7691# 0.0108f
C6361 sg13cmos5l_dfrbpq_1_56.RESET_B a_15972_6172# 0.54519f
C6362 sg13cmos5l_dlygate4sd3_1_22.X a_11276_4192# 0.11533f
C6363 sg13cmos5l_dlygate4sd3_1_18.X sg13cmos5l_buf_8_3.A 0.03807f
C6364 a_9281_4084# sg13cmos5l_nand3_1_3.B 0.01049f
C6365 a_20362_5629# a_20102_5406# 0.87117f
C6366 sg13cmos5l_nor4_2_5.C a_6972_8394# 0.01965f
C6367 sg13cmos5l_dfrbpq_1_12.Q a_13834_3112# 0.02108f
C6368 sg13cmos5l_nor3_1_4.C sg13cmos5l_xnor2_1_5.A 0.01785f
C6369 sg13cmos5l_buf_1_0.A sg13cmos5l_nor3_1_0.A 0.02602f
C6370 a_11824_1090# a_12234_1168# 0.1396f
C6371 sg13cmos5l_buf_8_0.X a_15607_4620# 0.04066f
C6372 VPWR en[0] 0.31202f
C6373 sg13cmos5l_and2_1_1.A osc 0.0202f
C6374 a_6468_6593# a_6699_6179# 0.15089f
C6375 sg13cmos5l_nor4_2_9.D a_7594_5374# 0.04146f
C6376 sg13cmos5l_buf_8_0.X sg13cmos5l_nor3_1_4.Y 0.05424f
C6377 a_11824_5626# VPWR 0.18742f
C6378 a_25103_6995# a_25009_6995# 0.32273f
C6379 sg13cmos5l_dfrbpq_1_53.RESET_B a_25605_3873# 0.03604f
C6380 a_18478_8619# a_18593_8620# 0.67711f
C6381 sg13cmos5l_dlygate4sd3_1_50.A a_13472_4742# 0.07178f
C6382 sg13cmos5l_xnor2_1_1.Y a_17472_1671# 0.22443f
C6383 sg13cmos5l_dlygate4sd3_1_17.X VPWR 0.71674f
C6384 sg13cmos5l_buf_8_11.A a_27784_6254# 0.04406f
C6385 sg13cmos5l_nor3_1_4.A sg13cmos5l_xnor2_1_5.Y 0.01441f
C6386 sg13cmos5l_dfrbpq_1_57.D sg13cmos5l_xor2_1_2.B 1.28671f
C6387 sg13cmos5l_dfrbpq_1_56.CLK a_16485_6897# 0.3799f
C6388 sg13cmos5l_dfrbpq_1_21.CLK a_4380_2346# 0.07142f
C6389 sg13cmos5l_dfrbpq_1_21.RESET_B sg13cmos5l_dlygate4sd3_1_33.A 0.19296f
C6390 sg13cmos5l_dlygate4sd3_1_6.X a_21904_4898# 0.0111f
C6391 a_11824_8650# VPWR 0.1886f
C6392 sg13cmos5l_xnor2_1_4.B osc 0.02024f
C6393 a_4186_1596# VPWR 0.33111f
C6394 sg13cmos5l_dfrbpq_1_57.RESET_B sg13cmos5l_dlygate4sd3_1_52.X 0.35825f
C6395 sg13cmos5l_dlygate4sd3_1_55.X a_21719_7309# 0.29266f
C6396 sg13cmos5l_dfrbpq_1_56.RESET_B a_16164_5724# 0.51175f
C6397 sg13cmos5l_dfrbpq_1_57.D a_13862_4656# 0.02976f
C6398 sg13cmos5l_dfrbpq_1_53.Q osc 0.09467f
C6399 sg13cmos5l_nor3_1_4.A sg13cmos5l_dfrbpq_1_56.Q 0.18589f
C6400 sg13cmos5l_buf_1_4.A sg13cmos5l_dfrbpq_1_2.D 0.0149f
C6401 sg13cmos5l_buf_1_4.A a_25308_1993# 0.02971f
C6402 sg13cmos5l_buf_1_0.X sg13cmos5l_nor3_1_0.B 0.14009f
C6403 sg13cmos5l_dfrbpq_1_11.CLK a_14379_2504# 0.04616f
C6404 sg13cmos5l_buf_1_1.X a_18951_1719# 0.55501f
C6405 sg13cmos5l_buf_1_4.X a_10827_992# 0.02108f
C6406 sg13cmos5l_dlygate4sd3_1_4.X sg13cmos5l_dfrbpq_1_7.Q 0.25033f
C6407 sg13cmos5l_xnor2_1_5.Y sg13cmos5l_buf_8_5.A 3.04102f
C6408 sg13cmos5l_xnor2_1_4.A a_24900_6593# 0.01036f
C6409 a_9446_6168# VPWR 0.24106f
C6410 sg13cmos5l_dlygate4sd3_1_22.X sg13cmos5l_dlygate4sd3_1_21.A 0.01609f
C6411 sg13cmos5l_dlygate4sd3_1_51.A VPWR 0.93771f
C6412 sg13cmos5l_buf_8_5.A sg13cmos5l_nand3_1_3.B 0.02561f
C6413 sg13cmos5l_xnor2_1_2.B a_11639_7727# 0.30316f
C6414 a_24837_2361# a_24708_2395# 0.01562f
C6415 sg13cmos5l_dlygate4sd3_1_19.X a_1436_5704# 0.01007f
C6416 sg13cmos5l_dlygate4sd3_1_57.A a_15627_7691# 0.0133f
C6417 sg13cmos5l_nor4_2_4.D sg13cmos5l_xnor2_1_2.A 2.40634f
C6418 sg13cmos5l_buf_1_0.X a_20311_6882# 0.28203f
C6419 a_10282_5629# a_10022_5406# 0.87117f
C6420 sg13cmos5l_dfrbpq_1_57.CLK a_10827_7040# 0.07241f
C6421 sg13cmos5l_nor3_1_4.A a_17231_6529# 0.01524f
C6422 sg13cmos5l_nor3_1_1.A sg13cmos5l_dfrbpq_1_55.D 0.51166f
C6423 a_1784_3185# a_2054_3144# 0.33585f
C6424 a_21435_3514# a_22049_2572# 0.01602f
C6425 sg13cmos5l_xor2_1_2.B sg13cmos5l_buf_8_0.X 0.2603f
C6426 a_26853_6897# a_26955_7040# 0.66105f
C6427 sg13cmos5l_xnor2_1_8.Y sg13cmos5l_dlygate4sd3_1_53.A 0.05562f
C6428 sg13cmos5l_and2_1_1.X sg13cmos5l_nor4_2_7.B 0.02916f
C6429 a_5319_1719# a_6167_1679# 0.11742f
C6430 a_5471_1603# a_6261_1679# 0.02241f
C6431 sg13cmos5l_buf_8_0.X a_16319_4627# 0.02399f
C6432 sg13cmos5l_dfrbpq_1_46.CLK a_20871_7767# 0.05027f
C6433 a_20907_8552# a_21023_7651# 0.0167f
C6434 sg13cmos5l_xnor2_1_10.Y sg13cmos5l_nor4_2_7.B 0.0222f
C6435 a_7439_6529# a_7345_6529# 0.32273f
C6436 sg13cmos5l_nand3_1_0.A sg13cmos5l_nand3_1_0.Y 0.24213f
C6437 sg13cmos5l_dlygate4sd3_1_5.A a_20666_2680# 0.11708f
C6438 sg13cmos5l_dfrbpq_1_15.D sg13cmos5l_dlygate4sd3_1_23.X 0.01759f
C6439 a_9232_2602# a_8881_2459# 0.01017f
C6440 a_8975_2459# sg13cmos5l_dlygate4sd3_1_18.A 0.01794f
C6441 sg13cmos5l_dlygate4sd3_1_0.X a_27686_874# 0.01021f
C6442 sg13cmos5l_dfrbpq_1_56.RESET_B VPWR 6.89306f
C6443 a_18380_7644# VPWR 0.28389f
C6444 sg13cmos5l_xnor2_1_5.Y a_13642_5374# 0.02828f
C6445 sg13cmos5l_dfrbpq_1_21.RESET_B a_5223_7767# 0.55528f
C6446 sg13cmos5l_dlygate4sd3_1_39.X a_26150_6918# 0.05255f
C6447 sg13cmos5l_buf_1_2.A sg13cmos5l_xnor2_1_5.A 0.6926f
C6448 sg13cmos5l_dfrbpq_1_56.CLK a_18363_6922# 1.06624f
C6449 sg13cmos5l_dfrbpq_1_2.D sg13cmos5l_nor3_1_0.C 1.17404f
C6450 a_23660_8728# a_23872_8728# 0.31789f
C6451 a_20805_6179# a_20805_5385# 0.03069f
C6452 sg13cmos5l_xnor2_1_3.A a_27992_1673# 0.01099f
C6453 a_14364_1993# a_14343_1719# 0.38902f
C6454 sg13cmos5l_dfrbpq_1_56.CLK a_16042_7141# 0.03513f
C6455 sg13cmos5l_dfrbpq_1_21.RESET_B sg13cmos5l_nor3_1_2.B 0.6359f
C6456 sg13cmos5l_dfrbpq_1_56.RESET_B a_18090_5704# 0.01699f
C6457 sg13cmos5l_dlygate4sd3_1_19.X a_1169_3502# 0.01869f
C6458 sg13cmos5l_dfrbpq_1_2.CLK a_17796_4212# 0.07539f
C6459 sg13cmos5l_buf_1_0.A a_3688_6254# 0.0111f
C6460 sg13cmos5l_dlygate4sd3_1_4.X a_28652_7644# 0.0236f
C6461 a_19361_6434# a_18843_5410# 0.01607f
C6462 sg13cmos5l_dfrbpq_1_2.Q a_21354_1168# 0.1355f
C6463 a_16970_4936# a_17015_4703# 0.36169f
C6464 a_17327_6995# a_17231_6529# 0.02016f
C6465 sg13cmos5l_dfrbpq_1_13.RESET_B sg13cmos5l_dlygate4sd3_1_21.A 0.02693f
C6466 sg13cmos5l_dfrbpq_1_2.D a_18444_1060# 0.02023f
C6467 a_1784_8434# sg13cmos5l_dlygate4sd3_1_35.A 0.51364f
C6468 sg13cmos5l_buf_1_4.A a_21934_1059# 0.0126f
C6469 a_19142_870# a_19947_992# 0.11742f
C6470 a_19428_1188# a_19845_849# 0.48921f
C6471 a_4088_5410# VPWR 0.35887f
C6472 sg13cmos5l_dlygate4sd3_1_6.X a_21553_3971# 0.01381f
C6473 sg13cmos5l_dfrbpq_1_32.CLK sg13cmos5l_dfrbpq_1_53.RESET_B 1.02263f
C6474 a_11733_6215# VPWR 0.09718f
C6475 sg13cmos5l_and2_1_1.A sg13cmos5l_buf_1_1.X 0.98818f
C6476 sg13cmos5l_dfrbpq_1_57.CLK a_10791_4743# 0.01965f
C6477 sg13cmos5l_dfrbpq_1_18.D a_2166_3168# 0.05955f
C6478 sg13cmos5l_dfrbpq_1_52.Q sg13cmos5l_buf_1_2.A 0.34335f
C6479 a_17770_4117# a_17796_4212# 0.43042f
C6480 sg13cmos5l_nor3_1_0.A a_17510_3894# 0.29958f
C6481 a_20362_6136# a_20805_6179# 0.02241f
C6482 sg13cmos5l_dfrbpq_1_56.RESET_B sg13cmos5l_buf_8_10.A 0.04698f
C6483 sg13cmos5l_dfrbpq_1_2.D a_20972_2680# 0.03066f
C6484 a_25103_6995# a_25029_6179# 0.013f
C6485 a_20388_8748# a_20805_8409# 0.48921f
C6486 a_20102_8430# a_20907_8552# 0.11742f
C6487 sg13cmos5l_dlygate4sd3_1_19.A a_4380_2346# 0.0173f
C6488 a_3876_3148# a_5041_3505# 0.4858f
C6489 sg13cmos5l_xnor2_1_0.A sg13cmos5l_xnor2_1_6.B 0.73737f
C6490 a_2054_3144# sg13cmos5l_xnor2_1_6.A 0.01009f
C6491 sg13cmos5l_dlygate4sd3_1_21.X a_6167_1679# 0.29703f
C6492 sg13cmos5l_dfrbpq_1_21.RESET_B sg13cmos5l_dfrbpq_1_13.CLK 0.01159f
C6493 a_20805_5385# a_20676_5419# 0.01562f
C6494 sg13cmos5l_xnor2_1_6.B a_8004_2395# 0.01027f
C6495 a_5802_8728# a_6272_8605# 0.03469f
C6496 sg13cmos5l_xnor2_1_4.B sg13cmos5l_buf_1_1.X 1.2863f
C6497 sg13cmos5l_nor3_1_4.B sg13cmos5l_xnor2_1_5.Y 0.01615f
C6498 a_8768_6427# a_8488_6254# 0.02783f
C6499 sg13cmos5l_dlygate4sd3_1_6.X a_21270_2680# 0.022f
C6500 a_26410_7141# a_26150_6918# 0.87117f
C6501 sg13cmos5l_buf_1_4.X a_25066_1093# 0.3466f
C6502 a_10231_4620# a_9915_3898# 0.02012f
C6503 sg13cmos5l_nor4_2_5.B a_5143_5370# 0.01052f
C6504 sg13cmos5l_nor4_2_1.A a_20907_4667# 0.01115f
C6505 a_8063_1603# VPWR 0.24342f
C6506 a_10943_4627# a_10943_3115# 0.01028f
C6507 sg13cmos5l_nor3_1_4.B sg13cmos5l_dfrbpq_1_56.Q 0.19091f
C6508 sg13cmos5l_dlygate4sd3_1_22.X a_6951_1088# 0.022f
C6509 sg13cmos5l_nor4_2_5.C a_3876_8748# 0.05019f
C6510 sg13cmos5l_dfrbpq_1_21.RESET_B a_5244_8041# 0.51234f
C6511 sg13cmos5l_buf_8_4.A a_9176_5410# 0.01916f
C6512 a_20362_4624# VPWR 0.09481f
C6513 sg13cmos5l_nor3_1_0.B sg13cmos5l_dlygate4sd3_1_16.A 0.4044f
C6514 a_1152_1185# VPWR 0.25795f
C6515 sg13cmos5l_buf_8_11.A a_25094_8118# 0.02601f
C6516 sg13cmos5l_xnor2_1_0.Y sg13cmos5l_dfrbpq_1_55.RESET_B 0.17401f
C6517 sg13cmos5l_dlygate4sd3_1_1.A a_27992_1673# 0.51802f
C6518 sg13cmos5l_nand3_1_2.C a_25871_6529# 0.01437f
C6519 sg13cmos5l_dlygate4sd3_1_51.X a_20102_5406# 0.01582f
C6520 sg13cmos5l_dfrbpq_1_2.Q a_21728_1002# 0.01581f
C6521 sg13cmos5l_nor4_2_1.A sg13cmos5l_buf_8_2.X 0.15895f
C6522 sg13cmos5l_buf_1_4.X a_24900_3148# 0.53641f
C6523 a_2054_8434# a_2266_7644# 0.01258f
C6524 sg13cmos5l_buf_1_4.A a_22049_1060# 0.01147f
C6525 sg13cmos5l_dlygate4sd3_1_0.X sg13cmos5l_xnor2_1_3.A 0.40784f
C6526 sg13cmos5l_dfrbpq_1_11.CLK a_10725_1643# 0.05115f
C6527 a_4395_4016# a_4395_3155# 0.01307f
C6528 sg13cmos5l_dfrbpq_1_18.D sg13cmos5l_xnor2_1_6.B 0.08754f
C6529 sg13cmos5l_buf_8_4.A sg13cmos5l_nor3_1_2.C 0.17216f
C6530 a_5422_5094# a_5663_4627# 0.01058f
C6531 a_3692_4656# a_3904_4656# 0.31789f
C6532 a_20805_6179# a_20907_6179# 0.6663f
C6533 a_7799_8821# VPWR 0.92863f
C6534 a_20805_3873# sg13cmos5l_and2_1_0.X 0.01825f
C6535 sg13cmos5l_dlygate4sd3_1_21.X sg13cmos5l_nor4_2_3.Y 0.31253f
C6536 sg13cmos5l_xnor2_1_6.B sg13cmos5l_nor3_1_1.Y 0.08525f
C6537 sg13cmos5l_buf_1_0.A a_3590_3582# 0.03748f
C6538 a_11567_5483# a_11824_5626# 0.40419f
C6539 a_10308_5724# a_11473_5483# 0.4858f
C6540 a_10827_5528# a_10596_5419# 0.15089f
C6541 sg13cmos5l_dfrbpq_1_21.CLK a_6972_3858# 0.07464f
C6542 sg13cmos5l_dlygate4sd3_1_18.A a_9176_874# 0.53479f
C6543 sg13cmos5l_dfrbpq_1_56.RESET_B a_17034_7680# 0.01585f
C6544 sg13cmos5l_xnor2_1_4.A sg13cmos5l_xnor2_1_4.B 4.5724f
C6545 sg13cmos5l_nand3_1_2.A a_24586_6136# 0.02177f
C6546 sg13cmos5l_nor3_1_0.A sg13cmos5l_nor3_1_0.Y 0.09228f
C6547 sg13cmos5l_dlygate4sd3_1_51.X a_20102_6606# 0.34771f
C6548 sg13cmos5l_xnor2_1_4.B a_24902_3894# 0.03268f
C6549 a_13472_1002# VPWR 0.06312f
C6550 sg13cmos5l_nor4_2_9.D a_4166_6168# 0.04273f
C6551 a_8063_1603# a_8714_1912# 0.01562f
C6552 a_10112_6455# a_10444_6606# 0.1396f
C6553 a_21647_5483# a_21553_5483# 0.32273f
C6554 sg13cmos5l_buf_1_4.A sg13cmos5l_nor4_2_0.B 0.26375f
C6555 sg13cmos5l_nor4_2_5.D sg13cmos5l_nor4_2_5.Y 0.3353f
C6556 sg13cmos5l_dfrbpq_1_58.D a_5024_5581# 0.0168f
C6557 a_19642_6132# a_19361_6434# 0.33585f
C6558 a_6272_8605# sg13cmos5l_dlygate4sd3_1_34.A 0.13351f
C6559 a_2016_4695# a_2165_5026# 0.3658f
C6560 a_15680_7050# VPWR 0.0681f
C6561 sg13cmos5l_xnor2_1_6.Y sg13cmos5l_dlygate4sd3_1_22.A 0.20637f
C6562 sg13cmos5l_dfrbpq_1_35.Q a_13676_7680# 0.02595f
C6563 sg13cmos5l_dfrbpq_1_58.RESET_B sg13cmos5l_dlygate4sd3_1_53.A 0.04191f
C6564 a_18891_2504# VPWR 0.27265f
C6565 a_23712_6207# VPWR 0.26944f
C6566 a_10791_7767# en[4] 0.01177f
C6567 sg13cmos5l_dfrbpq_1_21.RESET_B a_7620_8105# 0.01614f
C6568 sg13cmos5l_dfrbpq_1_13.RESET_B a_6951_1088# 0.56941f
C6569 a_11567_8507# a_11824_8650# 0.40419f
C6570 sg13cmos5l_dfrbpq_1_13.CLK a_6261_1679# 0.01097f
C6571 a_28289_8620# VPWR 0.23982f
C6572 sg13cmos5l_buf_1_4.X sg13cmos5l_nor3_1_0.B 0.43667f
C6573 sg13cmos5l_nor4_2_5.D sg13cmos5l_and2_1_3.A 1.86882f
C6574 a_10943_6139# a_10725_5385# 0.01287f
C6575 a_3304_3230# VPWR 0.14147f
C6576 sg13cmos5l_dlygate4sd3_1_52.A a_9176_5410# 0.03074f
C6577 sg13cmos5l_nor3_1_4.A sg13cmos5l_nand3_1_1.Y 0.01452f
C6578 a_18293_5026# sg13cmos5l_xnor2_1_3.B 0.04203f
C6579 a_2054_874# VPWR 0.24819f
C6580 sg13cmos5l_buf_8_11.A a_25899_7691# 0.01878f
C6581 a_1870_1899# a_1985_1898# 0.67711f
C6582 a_24326_6606# a_24586_6136# 0.87117f
C6583 a_4395_4016# a_5392_4114# 0.06746f
C6584 a_3850_4117# sg13cmos5l_dlygate4sd3_1_19.A 0.01421f
C6585 sg13cmos5l_dfrbpq_1_37.D sg13cmos5l_dfrbpq_1_53.RESET_B 0.10779f
C6586 a_19256_8434# a_18922_7644# 0.01537f
C6587 a_10282_8653# a_10022_8430# 0.87117f
C6588 a_15708_8394# a_16490_8588# 0.4806f
C6589 a_20388_4212# a_20676_3907# 0.4806f
C6590 sg13cmos5l_dfrbpq_1_5.Q a_23576_3898# 0.50726f
C6591 a_19845_849# a_19716_883# 0.01562f
C6592 a_18826_4620# VPWR 1.18995f
C6593 sg13cmos5l_dlygate4sd3_1_52.X sg13cmos5l_nand3_1_1.B 0.11105f
C6594 sg13cmos5l_buf_8_5.A a_3488_5538# 0.01709f
C6595 a_4088_5410# sg13cmos5l_dfrbpq_1_16.Q 0.50957f
C6596 sg13cmos5l_buf_1_11.A sg13cmos5l_nor4_2_5.C 0.66049f
C6597 sg13cmos5l_dfrbpq_1_13.RESET_B a_6250_2350# 0.06697f
C6598 sg13cmos5l_dfrbpq_1_2.D a_18315_4016# 0.03281f
C6599 sg13cmos5l_nor4_2_0.C a_23958_3168# 0.01093f
C6600 a_10231_3108# sg13cmos5l_nor3_1_1.C 0.01483f
C6601 sg13cmos5l_dfrbpq_1_22.Q sg13cmos5l_dfrbpq_1_11.CLK 0.03431f
C6602 a_14277_3155# a_14277_2361# 0.03069f
C6603 sg13cmos5l_nor4_2_0.C a_24420_2700# 0.06654f
C6604 sg13cmos5l_buf_8_2.X a_21435_3514# 1.0749f
C6605 a_20907_6179# a_21647_6529# 0.3087f
C6606 sg13cmos5l_dfrbpq_1_59.Q a_16666_2350# 0.50728f
C6607 sg13cmos5l_buf_1_1.X a_19799_1679# 0.11299f
C6608 sg13cmos5l_xnor2_1_4.Y sg13cmos5l_nand3_1_2.Y 0.656f
C6609 sg13cmos5l_nand3_1_1.Y sg13cmos5l_buf_8_5.A 0.0304f
C6610 sg13cmos5l_buf_1_0.X a_21674_7076# 0.0118f
C6611 a_10444_6606# a_10702_6606# 0.01017f
C6612 a_10231_6132# a_10791_6255# 0.3087f
C6613 a_27137_6434# VPWR 0.24321f
C6614 sg13cmos5l_dfrbpq_1_53.RESET_B a_26181_4667# 0.0547f
C6615 sg13cmos5l_buf_8_4.A sg13cmos5l_xor2_1_1.B 0.0264f
C6616 sg13cmos5l_dfrbpq_1_56.RESET_B sg13cmos5l_nand3_1_1.A 0.50994f
C6617 a_1784_874# a_2054_874# 0.33585f
C6618 a_26181_5385# a_26181_4667# 0.11208f
C6619 sg13cmos5l_dlygate4sd3_1_55.X en[3] 0.02358f
C6620 a_4395_4016# VPWR 0.20693f
C6621 a_2632_7766# VPWR 0.14502f
C6622 sg13cmos5l_xnor2_1_6.B a_1302_1656# 0.01589f
C6623 a_13664_1919# VPWR 0.45643f
C6624 sg13cmos5l_nor3_1_4.A sg13cmos5l_dfrbpq_1_56.D 2.6276f
C6625 sg13cmos5l_and2_1_1.X a_23661_2428# 0.12912f
C6626 sg13cmos5l_dfrbpq_1_13.RESET_B a_3904_4656# 0.0173f
C6627 a_25738_8653# a_25478_8430# 0.87117f
C6628 sg13cmos5l_nor4_2_7.D a_24170_5704# 0.14282f
C6629 sg13cmos5l_buf_8_11.A sg13cmos5l_buf_1_4.A 0.19905f
C6630 sg13cmos5l_xnor2_1_0.A sg13cmos5l_dlygate4sd3_1_21.A 0.03973f
C6631 sg13cmos5l_buf_1_0.A a_18951_1719# 0.02149f
C6632 a_6604_3894# a_6951_4112# 0.07014f
C6633 sg13cmos5l_buf_8_11.A sg13cmos5l_dlygate4sd3_1_39.A 0.02565f
C6634 sg13cmos5l_dfrbpq_1_13.RESET_B a_3876_3148# 0.04186f
C6635 a_14166_8498# VPWR 0.21195f
C6636 sg13cmos5l_dlygate4sd3_1_51.X sg13cmos5l_dlygate4sd3_1_51.A 0.16502f
C6637 sg13cmos5l_dlygate4sd3_1_15.A sg13cmos5l_nor3_1_0.B 0.88093f
C6638 sg13cmos5l_buf_8_3.A sg13cmos5l_dfrbpq_1_22.Q 0.4181f
C6639 sg13cmos5l_buf_1_0.A a_17036_1596# 0.01115f
C6640 sg13cmos5l_nor4_2_9.D a_4358_5410# 0.07019f
C6641 a_25797_7691# en[4] 0.01001f
C6642 sg13cmos5l_nand3_1_2.C a_27022_6435# 0.01059f
C6643 a_18372_2700# a_19631_2459# 0.01741f
C6644 sg13cmos5l_buf_1_4.A a_26351_947# 0.01519f
C6645 sg13cmos5l_dlygate4sd3_1_55.A a_24586_6136# 0.01635f
C6646 sg13cmos5l_dfrbpq_1_57.RESET_B sg13cmos5l_xnor2_1_8.Y 0.21343f
C6647 sg13cmos5l_dfrbpq_1_55.RESET_B a_15119_3505# 0.21134f
C6648 a_10943_3115# a_11733_3191# 0.02241f
C6649 sg13cmos5l_dfrbpq_1_11.CLK a_11639_3191# 0.01164f
C6650 sg13cmos5l_nor3_1_0.B sg13cmos5l_dfrbpq_1_2.Q 2.40632f
C6651 sg13cmos5l_xnor2_1_1.Y a_18086_2382# 0.29318f
C6652 sg13cmos5l_buf_8_11.A a_21813_7727# 0.01587f
C6653 sg13cmos5l_dfrbpq_1_53.RESET_B a_10112_7967# 0.01296f
C6654 sg13cmos5l_xnor2_1_3.B a_17796_4212# 0.0183f
C6655 sg13cmos5l_xnor2_1_2.A a_15607_4620# 0.05095f
C6656 a_25287_1719# VPWR 0.20742f
C6657 a_15687_8648# a_16535_8821# 0.11742f
C6658 sg13cmos5l_dfrbpq_1_32.CLK a_6693_6897# 0.39063f
C6659 sg13cmos5l_dfrbpq_1_55.Q sg13cmos5l_buf_1_4.X 0.74339f
C6660 sg13cmos5l_xnor2_1_2.A sg13cmos5l_nor3_1_4.Y 0.02613f
C6661 sg13cmos5l_xnor2_1_2.Y a_17274_2680# 0.01003f
C6662 sg13cmos5l_dlygate4sd3_1_9.X a_25131_6179# 0.01594f
C6663 a_21904_8650# VPWR 0.18949f
C6664 sg13cmos5l_buf_1_0.X a_24261_6897# 0.11455f
C6665 a_10702_6606# a_10943_6139# 0.01058f
C6666 a_10812_6529# a_11639_6215# 0.50066f
C6667 a_17518_7947# sg13cmos5l_nor3_1_4.A 0.19336f
C6668 a_6391_8394# a_6972_8394# 0.01741f
C6669 sg13cmos5l_dfrbpq_1_29.Q sg13cmos5l_dfrbpq_1_56.RESET_B 0.75234f
C6670 sg13cmos5l_dfrbpq_1_0.D a_28532_2680# 0.01007f
C6671 a_4395_8552# VPWR 0.20584f
C6672 sg13cmos5l_dfrbpq_1_13.RESET_B a_11824_1090# 0.17706f
C6673 a_2054_874# a_2166_938# 0.67711f
C6674 sg13cmos5l_dfrbpq_1_21.RESET_B sg13cmos5l_dlygate4sd3_1_38.A 0.02807f
C6675 a_13773_6964# VPWR 0.49057f
C6676 sg13cmos5l_nor3_1_4.B sg13cmos5l_nand3_1_1.Y 0.01626f
C6677 sg13cmos5l_buf_8_4.A sg13cmos5l_dfrbpq_1_58.D 0.05975f
C6678 sg13cmos5l_and2_1_1.X a_23958_3168# 0.05096f
C6679 a_15782_6918# a_16485_6897# 0.02453f
C6680 sg13cmos5l_nor4_2_7.D a_23558_6918# 0.02815f
C6681 sg13cmos5l_dfrbpq_1_56.D a_13642_5374# 0.0153f
C6682 a_1870_7947# VPWR 0.21931f
C6683 a_23368_5538# a_23368_4742# 0.01095f
C6684 sg13cmos5l_nand3_1_2.B a_24526_4923# 0.06749f
C6685 sg13cmos5l_dlygate4sd3_1_21.A a_3680_1045# 0.1355f
C6686 a_25605_3873# a_25476_3907# 0.01562f
C6687 a_25029_6179# a_25777_6529# 0.01058f
C6688 a_18478_8619# sg13cmos5l_xnor2_1_2.B 0.19346f
C6689 sg13cmos5l_xnor2_1_5.Y sg13cmos5l_dfrbpq_1_59.Q 0.41602f
C6690 a_26545_8041# en[4] 0.01268f
C6691 a_14277_3155# a_14379_3155# 0.6663f
C6692 sg13cmos5l_dfrbpq_1_46.D sg13cmos5l_buf_8_11.A 1.86075f
C6693 sg13cmos5l_xnor2_1_2.A sg13cmos5l_xor2_1_2.B 0.02788f
C6694 sg13cmos5l_buf_1_0.A sg13cmos5l_dfrbpq_1_3.Q 0.02394f
C6695 a_21354_1168# a_21728_1002# 0.03403f
C6696 sg13cmos5l_dfrbpq_1_13.RESET_B a_7564_2070# 0.21702f
C6697 sg13cmos5l_dfrbpq_1_37.D sg13cmos5l_dlygate4sd3_1_9.A 0.22397f
C6698 sg13cmos5l_nor3_1_4.A a_16587_7040# 0.01469f
C6699 a_4511_2652# a_4270_2382# 0.01058f
C6700 a_4359_2600# a_5162_2540# 0.15089f
C6701 a_5207_2773# a_5301_2540# 0.87117f
C6702 sg13cmos5l_nor4_2_9.D sg13cmos5l_buf_8_5.A 0.72413f
C6703 sg13cmos5l_dlygate4sd3_1_9.X sg13cmos5l_xnor2_1_4.Y 0.01875f
C6704 a_16535_8821# sg13cmos5l_nor4_2_4.D 0.35003f
C6705 a_8763_8434# sg13cmos5l_xnor2_1_8.Y 0.04745f
C6706 a_10725_8409# VPWR 0.23875f
C6707 a_26853_6897# a_27137_6434# 0.02293f
C6708 sg13cmos5l_buf_8_10.A a_13773_6964# 0.01206f
C6709 sg13cmos5l_nand3_1_0.B a_22330_838# 0.01222f
C6710 a_10791_7767# VPWR 0.20601f
C6711 sg13cmos5l_dlygate4sd3_1_9.X sg13cmos5l_dlygate4sd3_1_11.A 0.98405f
C6712 a_28570_8398# en[3] 0.01154f
C6713 a_11594_6448# a_11639_6215# 0.36169f
C6714 sg13cmos5l_dlygate4sd3_1_19.A a_4186_1596# 0.50537f
C6715 a_14630_3898# VPWR 0.24537f
C6716 sg13cmos5l_buf_1_4.X a_9176_874# 0.09783f
C6717 sg13cmos5l_xnor2_1_2.A a_16138_5629# 0.01592f
C6718 sg13cmos5l_nor3_1_4.B sg13cmos5l_dfrbpq_1_56.D 0.87638f
C6719 sg13cmos5l_xnor2_1_12.B a_3904_4656# 0.01033f
C6720 a_6071_7727# VPWR 0.92833f
C6721 sg13cmos5l_dfrbpq_1_46.D sg13cmos5l_buf_2_0.X 0.0129f
C6722 a_24420_2700# a_24837_2361# 0.48921f
C6723 a_24134_2382# a_24939_2504# 0.11742f
C6724 sg13cmos5l_dlygate4sd3_1_31.X sg13cmos5l_nor3_1_2.C 0.17056f
C6725 sg13cmos5l_dlygate4sd3_1_11.X a_28758_3962# 0.19359f
C6726 a_11276_4192# sg13cmos5l_nand3_1_3.B 0.0717f
C6727 a_11488_4192# a_11786_4192# 0.42343f
C6728 a_23835_8050# VPWR 1.19894f
C6729 a_19638_8498# sg13cmos5l_dlygate4sd3_1_6.X 0.0331f
C6730 a_3850_8653# VPWR 0.0944f
C6731 a_4663_7644# VPWR 0.1739f
C6732 sg13cmos5l_buf_1_0.X a_20805_5385# 0.05414f
C6733 a_16587_7040# a_17327_6995# 0.3087f
C6734 sg13cmos5l_buf_1_4.A a_10725_849# 0.01782f
C6735 sg13cmos5l_dfrbpq_1_12.Q a_14379_3155# 0.02259f
C6736 sg13cmos5l_dlygate4sd3_1_39.X sg13cmos5l_dlygate4sd3_1_17.A 0.0691f
C6737 sg13cmos5l_xnor2_1_8.Y a_7535_6995# 0.01066f
C6738 a_16042_7141# a_15782_6918# 0.87117f
C6739 sg13cmos5l_dfrbpq_1_53.RESET_B sg13cmos5l_dlygate4sd3_1_4.X 0.20309f
C6740 a_16184_3185# a_16454_3144# 0.33585f
C6741 a_16566_3168# a_17132_3108# 0.03283f
C6742 a_23846_4656# VPWR 0.24107f
C6743 sg13cmos5l_dfrbpq_1_46.CLK sg13cmos5l_buf_8_11.A 0.17026f
C6744 sg13cmos5l_nor4_2_4.D sg13cmos5l_xnor2_1_2.B 0.07852f
C6745 sg13cmos5l_buf_1_0.X a_20362_6136# 0.35247f
C6746 sg13cmos5l_dfrbpq_1_13.Q a_4640_1919# 0.13351f
C6747 sg13cmos5l_dfrbpq_1_22.D a_16270_2571# 0.19953f
C6748 sg13cmos5l_xnor2_1_4.Y a_28646_3898# 0.04068f
C6749 sg13cmos5l_dfrbpq_1_2.CLK a_19142_870# 0.0295f
C6750 sg13cmos5l_and2_1_1.X en[4] 0.02221f
C6751 a_13664_1919# a_13783_1596# 0.13494f
C6752 sg13cmos5l_dfrbpq_1_21.RESET_B a_4202_4656# 0.02915f
C6753 sg13cmos5l_dfrbpq_1_53.RESET_B sg13cmos5l_nor4_2_7.B 0.90175f
C6754 a_2016_7233# a_2165_6922# 0.3658f
C6755 sg13cmos5l_xnor2_1_10.Y en[4] 0.02202f
C6756 sg13cmos5l_dfrbpq_1_57.RESET_B a_10812_8041# 0.49019f
C6757 sg13cmos5l_nor3_1_0.A sg13cmos5l_dlygate4sd3_1_16.A 0.01029f
C6758 a_23846_1632# VPWR 0.24535f
C6759 sg13cmos5l_dfrbpq_1_21.RESET_B sg13cmos5l_dlygate4sd3_1_23.X 0.70815f
C6760 sg13cmos5l_buf_1_0.X sg13cmos5l_nand3_1_2.A 0.18538f
C6761 sg13cmos5l_dlygate4sd3_1_19.X a_5207_2773# 0.32782f
C6762 sg13cmos5l_xnor2_1_3.B sg13cmos5l_xnor2_1_1.B 0.3823f
C6763 sg13cmos5l_nor3_1_2.C a_7851_7691# 0.03468f
C6764 a_5207_1261# a_5301_1028# 0.87117f
C6765 sg13cmos5l_dlygate4sd3_1_6.X sg13cmos5l_dfrbpq_1_5.Q 0.01497f
C6766 sg13cmos5l_nor4_2_1.A sg13cmos5l_dlygate4sd3_1_13.A 0.06161f
C6767 a_7103_8700# a_6972_8394# 0.49014f
C6768 a_7749_7691# VPWR 0.2421f
C6769 sg13cmos5l_dlygate4sd3_1_9.A a_27690_4656# 0.01103f
C6770 sg13cmos5l_xor2_1_2.A sg13cmos5l_dlygate4sd3_1_57.A 0.09643f
C6771 sg13cmos5l_xnor2_1_8.Y a_4730_6168# 0.03083f
C6772 sg13cmos5l_buf_8_4.A sg13cmos5l_buf_8_9.A 0.05101f
C6773 sg13cmos5l_dlygate4sd3_1_6.X a_20907_8552# 0.02428f
C6774 sg13cmos5l_xnor2_1_4.A a_25288_4742# 0.01594f
C6775 a_25797_7691# VPWR 0.23996f
C6776 a_10943_2652# a_10725_1643# 0.03649f
C6777 sg13cmos5l_xnor2_1_6.A a_1152_1185# 0.12761f
C6778 a_12234_1168# VPWR 0.46586f
C6779 sg13cmos5l_dlygate4sd3_1_11.A sg13cmos5l_xnor2_1_4.Y 0.05324f
C6780 sg13cmos5l_nor3_1_0.A a_17432_3185# 0.0565f
C6781 sg13cmos5l_dfrbpq_1_21.RESET_B sg13cmos5l_nor4_2_9.Y 0.05375f
C6782 a_18278_3582# a_18852_3569# 0.36169f
C6783 a_18538_3112# a_18981_3155# 0.02241f
C6784 sg13cmos5l_dfrbpq_1_5.Q osc 0.3253f
C6785 a_20102_5094# a_20388_4660# 0.50066f
C6786 a_2266_7644# sg13cmos5l_xnor2_1_13.Y 0.01241f
C6787 a_25764_4660# VPWR 0.0721f
C6788 sg13cmos5l_dlygate4sd3_1_34.A a_2632_7766# 0.07525f
C6789 sg13cmos5l_nor4_2_0.D a_25509_849# 0.01179f
C6790 sg13cmos5l_buf_1_0.A a_19799_1679# 0.0194f
C6791 sg13cmos5l_xnor2_1_4.A a_25478_8430# 0.02317f
C6792 sg13cmos5l_xnor2_1_2.A a_13676_7680# 0.10778f
C6793 sg13cmos5l_buf_1_0.X a_24326_6606# 0.09175f
C6794 sg13cmos5l_xnor2_1_8.Y sg13cmos5l_nor4_2_5.B 0.13983f
C6795 a_19888_2602# a_19537_2459# 0.01017f
C6796 sg13cmos5l_buf_1_4.A a_26724_6931# 0.01995f
C6797 sg13cmos5l_xnor2_1_1.Y sg13cmos5l_nand3_1_0.Y 0.07497f
C6798 a_8694_4680# a_8582_4656# 0.67711f
C6799 a_10231_4620# a_10812_5017# 0.01741f
C6800 sg13cmos5l_buf_1_0.X a_20907_6179# 0.56692f
C6801 a_25287_1719# a_25439_1603# 0.66105f
C6802 a_7932_1993# VPWR 0.07256f
C6803 sg13cmos5l_dlygate4sd3_1_22.X a_5207_1261# 0.30923f
C6804 sg13cmos5l_dlygate4sd3_1_19.X a_3590_3582# 0.05243f
C6805 sg13cmos5l_dfrbpq_1_2.CLK a_19312_4114# 0.04136f
C6806 sg13cmos5l_buf_1_4.X sg13cmos5l_nor3_1_0.A 0.5436f
C6807 sg13cmos5l_nor4_2_0.C VPWR 0.98808f
C6808 sg13cmos5l_nor4_2_1.A a_21904_4114# 0.02036f
C6809 sg13cmos5l_buf_1_0.A sg13cmos5l_nor3_1_2.B 0.29999f
C6810 a_10022_6918# a_10725_6897# 0.02453f
C6811 sg13cmos5l_dfrbpq_1_13.Q VPWR 1.4927f
C6812 a_1384_8468# sg13cmos5l_buf_1_0.A 0.28859f
C6813 sg13cmos5l_buf_1_0.A a_10282_1600# 0.01864f
C6814 sg13cmos5l_dfrbpq_1_55.RESET_B a_15786_2680# 0.02297f
C6815 sg13cmos5l_dfrbpq_1_21.RESET_B sg13cmos5l_dfrbpq_1_12.D 1.98798f
C6816 a_6972_8394# a_7893_8588# 0.43042f
C6817 a_9640_7680# VPWR 0.25066f
C6818 a_15376_2602# a_15025_2459# 0.01017f
C6819 sg13cmos5l_dfrbpq_1_12.D a_8042_3144# 0.12015f
C6820 a_5392_3386# a_5802_3144# 0.1396f
C6821 sg13cmos5l_dfrbpq_1_2.CLK a_19631_2459# 0.01177f
C6822 sg13cmos5l_buf_1_1.X a_18538_3112# 0.36289f
C6823 sg13cmos5l_dfrbpq_1_21.CLK a_4395_4016# 0.04455f
C6824 a_15708_8394# sg13cmos5l_dfrbpq_1_53.RESET_B 0.01508f
C6825 a_18363_6922# sg13cmos5l_and2_1_1.A 0.05147f
C6826 a_20973_3492# sg13cmos5l_and2_1_0.X 0.1616f
C6827 sg13cmos5l_and2_1_4.X sg13cmos5l_dfrbpq_1_56.D 0.0125f
C6828 a_25162_4117# osc 0.01228f
C6829 sg13cmos5l_dfrbpq_1_2.D a_18086_2382# 0.02525f
C6830 sg13cmos5l_buf_1_0.A sg13cmos5l_dfrbpq_1_13.CLK 1.58227f
C6831 a_7932_1993# a_8714_1912# 0.4806f
C6832 sg13cmos5l_dfrbpq_1_29.Q a_14166_8498# 0.01572f
C6833 a_17472_1671# a_18080_1718# 0.0358f
C6834 a_20102_5094# a_20907_4667# 0.11742f
C6835 sg13cmos5l_and2_1_3.A a_3680_5609# 0.1492f
C6836 a_27023_5017# VPWR 0.1712f
C6837 sg13cmos5l_dfrbpq_1_11.Q a_13563_874# 0.0179f
C6838 sg13cmos5l_dlygate4sd3_1_6.A a_18372_2700# 0.0252f
C6839 a_20892_8041# VPWR 0.07716f
C6840 sg13cmos5l_dfrbpq_1_58.RESET_B a_7535_6995# 0.19894f
C6841 sg13cmos5l_xnor2_1_2.A a_9446_5410# 0.01452f
C6842 a_15496_7050# a_15680_7050# 0.11523f
C6843 sg13cmos5l_nand3_1_2.Y a_24641_4922# 0.01215f
C6844 sg13cmos5l_dfrbpq_1_13.RESET_B a_5207_1261# 0.11661f
C6845 a_10231_4620# a_10702_5094# 0.32273f
C6846 sg13cmos5l_buf_1_0.X sg13cmos5l_dlygate4sd3_1_55.A 1.42957f
C6847 a_15146_1912# a_15191_1679# 0.36169f
C6848 sg13cmos5l_dlygate4sd3_1_38.A a_6276_7236# 0.02758f
C6849 sg13cmos5l_dfrbpq_1_0.CLK a_25509_849# 0.36621f
C6850 sg13cmos5l_nor4_2_5.D a_4278_6192# 0.04963f
C6851 sg13cmos5l_dlygate4sd3_1_2.A a_27878_2386# 0.0235f
C6852 sg13cmos5l_dfrbpq_1_47.Q en[4] 0.02873f
C6853 a_10827_7040# a_11567_6995# 0.3087f
C6854 sg13cmos5l_dlygate4sd3_1_4.A sg13cmos5l_dfrbpq_1_7.Q 0.01782f
C6855 sg13cmos5l_dfrbpq_1_57.RESET_B sg13cmos5l_buf_1_5.A 0.16368f
C6856 a_7103_1140# a_7893_1028# 0.02241f
C6857 a_16319_4627# a_17015_4703# 0.02453f
C6858 sg13cmos5l_buf_1_1.X a_19947_992# 0.58141f
C6859 sg13cmos5l_xnor2_1_12.B a_7649_4922# 0.01129f
C6860 sg13cmos5l_buf_1_1.X a_24874_3112# 0.01365f
C6861 sg13cmos5l_dfrbpq_1_56.RESET_B en[2] 0.01315f
C6862 sg13cmos5l_dlygate4sd3_1_22.X a_7716_2700# 0.01046f
C6863 a_18380_7644# en[2] 0.3218f
C6864 sg13cmos5l_dfrbpq_1_22.Q a_10112_3431# 0.01819f
C6865 sg13cmos5l_nor3_1_0.A sg13cmos5l_dfrbpq_1_2.Q 0.12696f
C6866 a_28936_5538# a_28936_4742# 0.01095f
C6867 a_21174_1656# VPWR 0.21509f
C6868 sg13cmos5l_dfrbpq_1_46.CLK a_20892_6882# 0.10117f
C6869 a_26830_2571# a_26945_2572# 0.67711f
C6870 sg13cmos5l_dfrbpq_1_0.CLK a_24420_2700# 0.12514f
C6871 a_16928_1002# VPWR 0.0777f
C6872 sg13cmos5l_nor4_2_7.B a_23660_5704# 0.10239f
C6873 a_28174_8619# a_28289_8620# 0.67711f
C6874 a_24874_3112# a_25317_3155# 0.02241f
C6875 a_27023_8507# a_26929_8507# 0.32273f
C6876 sg13cmos5l_buf_1_0.X a_24780_5596# 0.01076f
C6877 sg13cmos5l_buf_1_0.A sg13cmos5l_xnor2_1_2.A 0.01177f
C6878 sg13cmos5l_dlygate4sd3_1_34.A a_6071_7727# 0.01557f
C6879 a_20388_4660# a_21553_5017# 0.4858f
C6880 sg13cmos5l_and2_1_1.X VPWR 0.97744f
C6881 sg13cmos5l_buf_8_3.A a_13472_1002# 0.0411f
C6882 sg13cmos5l_dfrbpq_1_7.Q VPWR 0.54864f
C6883 sg13cmos5l_buf_1_4.A sg13cmos5l_dfrbpq_1_0.D 0.53626f
C6884 sg13cmos5l_dfrbpq_1_37.D en[3] 0.05561f
C6885 sg13cmos5l_xnor2_1_10.Y VPWR 1.50678f
C6886 sg13cmos5l_dlygate4sd3_1_34.A a_4663_7644# 0.01367f
C6887 a_24806_870# a_25611_992# 0.11742f
C6888 sg13cmos5l_dfrbpq_1_56.CLK sg13cmos5l_buf_1_5.A 0.03209f
C6889 a_25092_1188# a_25509_849# 0.48921f
C6890 sg13cmos5l_buf_8_2.X a_20000_4742# 0.04292f
C6891 a_10812_5017# a_11733_4703# 0.43042f
C6892 a_9736_1718# VPWR 0.13426f
C6893 sg13cmos5l_dfrbpq_1_58.RESET_B sg13cmos5l_nor4_2_5.B 1.16818f
C6894 sg13cmos5l_dfrbpq_1_55.D a_15191_1679# 0.32103f
C6895 sg13cmos5l_dlygate4sd3_1_38.A a_8202_7216# 0.01394f
C6896 sg13cmos5l_nand3_1_2.A sg13cmos5l_buf_1_4.X 0.17541f
C6897 a_4395_4016# sg13cmos5l_dlygate4sd3_1_19.A 0.02183f
C6898 sg13cmos5l_buf_1_5.A a_8776_5444# 0.32752f
C6899 sg13cmos5l_dfrbpq_1_21.RESET_B a_4164_3907# 0.02182f
C6900 sg13cmos5l_xnor2_1_2.B osc 0.08911f
C6901 sg13cmos5l_xnor2_1_0.Y a_10308_1636# 0.03865f
C6902 a_24727_1596# a_25198_2070# 0.32273f
C6903 sg13cmos5l_buf_1_0.A a_14343_1719# 0.01557f
C6904 sg13cmos5l_dfrbpq_1_13.RESET_B a_7716_2700# 0.48864f
C6905 sg13cmos5l_dfrbpq_1_57.CLK a_10943_6139# 0.3927f
C6906 sg13cmos5l_buf_1_1.X a_20687_947# 0.19921f
C6907 sg13cmos5l_nor3_1_0.B a_24900_3148# 0.0508f
C6908 sg13cmos5l_xnor2_1_13.Y a_2165_6922# 0.02187f
C6909 sg13cmos5l_nor4_2_0.C a_24424_3230# 0.08705f
C6910 a_10812_3505# a_10943_3115# 0.48921f
C6911 sg13cmos5l_dfrbpq_1_23.Q a_6359_4703# 0.01689f
C6912 a_21062_1632# a_20687_947# 0.01203f
C6913 sg13cmos5l_buf_8_2.X a_24614_3582# 0.01303f
C6914 sg13cmos5l_dlygate4sd3_1_17.A sg13cmos5l_xnor2_1_4.B 0.01411f
C6915 sg13cmos5l_buf_8_4.A sg13cmos5l_dlygate4sd3_1_52.A 0.15827f
C6916 a_27195_3514# a_28524_3410# 0.03979f
C6917 a_19428_1188# VPWR 0.0721f
C6918 sg13cmos5l_dlygate4sd3_1_17.A sg13cmos5l_dfrbpq_1_53.Q 0.04133f
C6919 sg13cmos5l_dlygate4sd3_1_17.X a_25738_4624# 0.01069f
C6920 sg13cmos5l_dlygate4sd3_1_39.X a_26896_7922# 0.03325f
C6921 sg13cmos5l_dfrbpq_1_58.RESET_B a_7439_6529# 0.21566f
C6922 a_20388_8748# VPWR 0.07372f
C6923 sg13cmos5l_dlygate4sd3_1_51.X a_23846_4656# 0.01952f
C6924 a_28652_7644# VPWR 0.2594f
C6925 sg13cmos5l_nor3_1_1.A a_16928_1002# 0.0399f
C6926 a_24837_2361# VPWR 0.28521f
C6927 sg13cmos5l_buf_1_4.X a_12234_1632# 0.06314f
C6928 sg13cmos5l_dfrbpq_1_58.Q a_4202_4656# 0.11835f
C6929 a_21904_4898# a_22314_4656# 0.1396f
C6930 sg13cmos5l_nor4_2_4.D a_14186_6168# 0.12362f
C6931 sg13cmos5l_buf_1_0.A a_27610_1596# 0.0121f
C6932 sg13cmos5l_dfrbpq_1_37.D a_24612_6172# 0.02596f
C6933 sg13cmos5l_buf_1_0.X sg13cmos5l_and2_1_1.A 0.26056f
C6934 sg13cmos5l_dfrbpq_1_32.CLK a_6972_8394# 0.13421f
C6935 sg13cmos5l_dfrbpq_1_21.RESET_B sg13cmos5l_nor4_2_5.Y 0.15581f
C6936 sg13cmos5l_buf_1_1.X a_18372_2700# 0.47242f
C6937 sg13cmos5l_dfrbpq_1_53.CLK a_26955_7040# 0.01714f
C6938 sg13cmos5l_xnor2_1_2.B sg13cmos5l_nor3_1_4.Y 0.02123f
C6939 a_27418_6132# a_27137_6434# 0.33585f
C6940 a_25611_992# a_26608_1090# 0.06746f
C6941 sg13cmos5l_buf_1_1.X a_18346_2605# 0.33227f
C6942 sg13cmos5l_dfrbpq_1_53.CLK sg13cmos5l_dlygate4sd3_1_40.A 0.63969f
C6943 sg13cmos5l_dlygate4sd3_1_55.X a_24526_4923# 0.19682f
C6944 sg13cmos5l_nor3_1_1.C VPWR 1.52454f
C6945 a_10943_4627# a_11594_4936# 0.01562f
C6946 a_8582_4656# a_8776_4026# 0.01235f
C6947 VPWR en[1] 0.28841f
C6948 a_3692_4656# VPWR 0.41253f
C6949 sg13cmos5l_buf_1_0.X sg13cmos5l_xnor2_1_4.B 0.23473f
C6950 a_7103_4164# a_7754_4052# 0.01562f
C6951 a_6972_3858# a_7893_4052# 0.43042f
C6952 sg13cmos5l_dfrbpq_1_0.D a_20972_2680# 0.02956f
C6953 a_5301_1028# VPWR 0.09583f
C6954 sg13cmos5l_buf_8_3.A a_13664_1919# 0.06673f
C6955 sg13cmos5l_dlygate4sd3_1_20.A a_5471_1603# 0.01202f
C6956 sg13cmos5l_dlygate4sd3_1_39.X a_26181_8409# 0.0154f
C6957 a_25162_4117# a_24902_3894# 0.87117f
C6958 a_2016_4695# VPWR 0.26852f
C6959 sg13cmos5l_nor4_2_9.Y sg13cmos5l_dfrbpq_1_58.Q 0.04818f
C6960 a_9446_874# a_9558_938# 0.67711f
C6961 sg13cmos5l_dfrbpq_1_21.RESET_B sg13cmos5l_and2_1_3.A 0.04912f
C6962 sg13cmos5l_dfrbpq_1_55.RESET_B a_17132_3108# 0.28982f
C6963 sg13cmos5l_dfrbpq_1_57.CLK sg13cmos5l_dlygate4sd3_1_52.X 0.04258f
C6964 sg13cmos5l_nand3_1_2.Y sg13cmos5l_nor3_1_0.C 0.30862f
C6965 sg13cmos5l_dlygate4sd3_1_19.X a_5471_1603# 0.01352f
C6966 sg13cmos5l_dfrbpq_1_46.CLK a_24363_7040# 0.02271f
C6967 sg13cmos5l_nor4_2_7.D a_23712_6207# 0.02767f
C6968 sg13cmos5l_dfrbpq_1_2.D a_19103_1603# 0.02761f
C6969 sg13cmos5l_dlygate4sd3_1_17.X a_27280_4898# 0.01025f
C6970 a_19609_6942# sg13cmos5l_dlygate4sd3_1_6.A 0.10352f
C6971 sg13cmos5l_dlygate4sd3_1_6.A sg13cmos5l_dfrbpq_1_3.D 0.09543f
C6972 sg13cmos5l_nor4_2_4.D a_16389_6179# 0.01512f
C6973 sg13cmos5l_nand3_1_0.Y a_18104_878# 0.01437f
C6974 sg13cmos5l_dlygate4sd3_1_55.A sg13cmos5l_buf_1_4.X 0.0107f
C6975 a_18972_1993# VPWR 0.07235f
C6976 a_27686_874# a_27798_938# 0.67711f
C6977 sg13cmos5l_dlygate4sd3_1_22.X VPWR 1.32716f
C6978 sg13cmos5l_dfrbpq_1_57.RESET_B a_10444_5094# 0.18156f
C6979 a_14054_8434# a_14166_8498# 0.67711f
C6980 a_27416_874# a_27686_874# 0.33585f
C6981 sg13cmos5l_xnor2_1_2.B a_16319_4627# 0.03051f
C6982 sg13cmos5l_dlygate4sd3_1_6.A sg13cmos5l_dlygate4sd3_1_5.A 0.04023f
C6983 sg13cmos5l_dlygate4sd3_1_4.A sg13cmos5l_nor4_2_0.D 0.02293f
C6984 sg13cmos5l_dfrbpq_1_53.CLK sg13cmos5l_dlygate4sd3_1_17.X 0.05585f
C6985 a_15285_1679# VPWR 0.09591f
C6986 a_15786_3144# VPWR 0.45296f
C6987 sg13cmos5l_dfrbpq_1_47.Q VPWR 0.48996f
C6988 sg13cmos5l_dfrbpq_1_57.RESET_B a_10308_7236# 0.52742f
C6989 sg13cmos5l_nor4_2_9.Y sg13cmos5l_dlygate4sd3_1_30.A 0.02122f
C6990 sg13cmos5l_dfrbpq_1_57.RESET_B sg13cmos5l_dlygate4sd3_1_53.A 0.01586f
C6991 a_6359_4703# VPWR 0.92812f
C6992 a_3304_5538# a_3304_4742# 0.01095f
C6993 sg13cmos5l_buf_1_4.A a_8776_908# 0.32403f
C6994 sg13cmos5l_dlygate4sd3_1_47.A a_28289_8620# 0.02014f
C6995 sg13cmos5l_nor3_1_1.A sg13cmos5l_nor3_1_1.C 1.90263f
C6996 a_26447_3971# a_26353_3971# 0.32273f
C6997 sg13cmos5l_xnor2_1_0.Y a_14495_1603# 0.01368f
C6998 a_4640_1919# a_4759_1596# 0.13494f
C6999 sg13cmos5l_dfrbpq_1_21.Q a_3680_2557# 0.13104f
C7000 a_14379_3155# a_15119_3505# 0.3087f
C7001 sg13cmos5l_xnor2_1_0.A a_1480_2514# 0.01622f
C7002 sg13cmos5l_xnor2_1_2.B a_16138_5629# 0.02447f
C7003 sg13cmos5l_dfrbpq_1_53.RESET_B a_26283_5528# 0.55678f
C7004 sg13cmos5l_nand3_1_3.Y a_8796_3510# 0.01582f
C7005 a_2920_8468# sg13cmos5l_dfrbpq_1_21.RESET_B 0.2977f
C7006 sg13cmos5l_dfrbpq_1_21.CLK sg13cmos5l_dfrbpq_1_13.Q 0.20906f
C7007 sg13cmos5l_nor4_2_0.D VPWR 0.6558f
C7008 sg13cmos5l_buf_1_4.A sg13cmos5l_dlygate4sd3_1_9.X 0.1942f
C7009 sg13cmos5l_xnor2_1_2.A sg13cmos5l_dlygate4sd3_1_52.X 1.7788f
C7010 sg13cmos5l_nor4_2_7.B a_26436_7236# 0.02297f
C7011 a_26181_5385# a_26283_5528# 0.66105f
C7012 sg13cmos5l_dlygate4sd3_1_35.A sg13cmos5l_nor4_2_5.C 1.173f
C7013 sg13cmos5l_dlygate4sd3_1_6.A sg13cmos5l_dfrbpq_1_2.CLK 1.22599f
C7014 a_2266_7644# a_1985_7946# 0.33585f
C7015 sg13cmos5l_nor3_1_2.B a_1664_7766# 0.01678f
C7016 sg13cmos5l_buf_1_5.A sg13cmos5l_nand3_1_1.B 0.02807f
C7017 sg13cmos5l_dlygate4sd3_1_39.A sg13cmos5l_dlygate4sd3_1_9.X 0.02089f
C7018 sg13cmos5l_dfrbpq_1_47.Q sg13cmos5l_buf_8_10.A 0.03975f
C7019 a_11824_1874# a_12234_1632# 0.1396f
C7020 sg13cmos5l_nor3_1_0.A a_21354_1168# 0.01064f
C7021 sg13cmos5l_dlygate4sd3_1_6.X sg13cmos5l_dfrbpq_1_2.CLK 0.02566f
C7022 sg13cmos5l_dlygate4sd3_1_17.X a_28570_4620# 0.02189f
C7023 a_21647_8507# a_21904_8650# 0.40419f
C7024 sg13cmos5l_dfrbpq_1_13.RESET_B VPWR 11.1409f
C7025 sg13cmos5l_dfrbpq_1_58.RESET_B a_8768_6427# 0.12961f
C7026 a_15680_4026# VPWR 0.0762f
C7027 sg13cmos5l_nor4_2_4.D a_17137_6529# 0.01365f
C7028 sg13cmos5l_buf_8_5.A a_9915_3898# 0.57976f
C7029 a_3799_834# a_4380_834# 0.01741f
C7030 a_19823_3505# VPWR 0.17342f
C7031 sg13cmos5l_dfrbpq_1_23.Q sg13cmos5l_xnor2_1_12.B 0.01778f
C7032 sg13cmos5l_dlygate4sd3_1_4.X en[3] 0.70774f
C7033 a_6693_6897# a_6564_6931# 0.01562f
C7034 sg13cmos5l_nor4_2_0.B a_26830_2571# 0.19338f
C7035 sg13cmos5l_buf_8_0.X sg13cmos5l_buf_1_4.X 0.50544f
C7036 sg13cmos5l_dfrbpq_1_46.CLK a_20907_5528# 0.03875f
C7037 sg13cmos5l_dfrbpq_1_2.CLK osc 0.04739f
C7038 sg13cmos5l_dfrbpq_1_53.RESET_B en[4] 0.78201f
C7039 sg13cmos5l_dfrbpq_1_57.RESET_B a_12234_7216# 0.03235f
C7040 a_9558_938# VPWR 0.21419f
C7041 sg13cmos5l_dfrbpq_1_12.D sg13cmos5l_dfrbpq_1_21.Q 0.02436f
C7042 a_9176_4697# VPWR 0.32908f
C7043 a_10812_5017# sg13cmos5l_dfrbpq_1_17.D 0.01381f
C7044 sg13cmos5l_buf_1_4.X a_20805_4667# 0.0668f
C7045 sg13cmos5l_xnor2_1_6.A sg13cmos5l_dfrbpq_1_13.Q 1.02326f
C7046 sg13cmos5l_dfrbpq_1_3.Q a_17432_3185# 0.50598f
C7047 sg13cmos5l_dlygate4sd3_1_9.X sg13cmos5l_nor3_1_0.C 0.02042f
C7048 a_3876_8748# sg13cmos5l_dfrbpq_1_32.CLK 0.09528f
C7049 a_17770_4117# osc 0.01332f
C7050 a_4293_8409# a_4395_8552# 0.66105f
C7051 a_20805_8409# en[3] 0.01767f
C7052 a_7716_2700# a_8004_2395# 0.4806f
C7053 sg13cmos5l_buf_1_5.A sg13cmos5l_dfrbpq_1_39.Q 0.254f
C7054 sg13cmos5l_dfrbpq_1_13.CLK sg13cmos5l_dlygate4sd3_1_18.A 0.01858f
C7055 sg13cmos5l_dfrbpq_1_46.CLK a_20388_6172# 0.10374f
C7056 sg13cmos5l_xnor2_1_13.Y a_2165_5026# 0.05622f
C7057 sg13cmos5l_buf_1_1.X a_25611_992# 0.01341f
C7058 sg13cmos5l_dfrbpq_1_13.CLK sg13cmos5l_dlygate4sd3_1_20.A 2.93622f
C7059 a_11594_2540# VPWR 0.01861f
C7060 sg13cmos5l_dlygate4sd3_1_33.A a_3608_7721# 0.51179f
C7061 a_26283_5528# a_27280_5626# 0.06746f
C7062 a_4759_1596# VPWR 0.17438f
C7063 a_23368_1002# VPWR 0.15785f
C7064 sg13cmos5l_dlygate4sd3_1_22.X a_2166_938# 0.2016f
C7065 sg13cmos5l_and2_1_1.A sg13cmos5l_buf_1_4.X 0.03632f
C7066 a_2054_8434# a_2166_8498# 0.67711f
C7067 sg13cmos5l_xnor2_1_4.B a_25478_5094# 0.01932f
C7068 sg13cmos5l_dfrbpq_1_58.D a_5663_4627# 0.01645f
C7069 sg13cmos5l_nor3_1_0.A a_21728_1002# 0.01393f
C7070 sg13cmos5l_xnor2_1_9.A a_2165_6922# 0.01072f
C7071 sg13cmos5l_and2_1_1.X sg13cmos5l_dlygate4sd3_1_51.X 0.0858f
C7072 sg13cmos5l_xnor2_1_0.Y a_2166_3168# 0.01886f
C7073 sg13cmos5l_buf_1_0.A a_4202_4656# 0.02647f
C7074 sg13cmos5l_dfrbpq_1_53.CLK a_25777_6529# 0.01287f
C7075 sg13cmos5l_dfrbpq_1_0.CLK VPWR 2.7986f
C7076 sg13cmos5l_nor4_2_1.A a_19722_4192# 0.03653f
C7077 sg13cmos5l_xnor2_1_10.Y sg13cmos5l_dlygate4sd3_1_51.X 0.32339f
C7078 sg13cmos5l_dlygate4sd3_1_19.X sg13cmos5l_dfrbpq_1_13.CLK 0.06595f
C7079 sg13cmos5l_xnor2_1_2.B a_13676_7680# 0.11128f
C7080 sg13cmos5l_buf_1_4.X sg13cmos5l_dfrbpq_1_3.Q 0.52608f
C7081 sg13cmos5l_dfrbpq_1_2.CLK a_18981_3155# 0.39719f
C7082 sg13cmos5l_buf_1_1.X sg13cmos5l_dfrbpq_1_3.D 0.22621f
C7083 a_26416_3386# VPWR 0.1881f
C7084 sg13cmos5l_buf_1_0.A a_7911_1719# 0.01649f
C7085 sg13cmos5l_dfrbpq_1_32.CLK a_10022_8430# 0.01006f
C7086 sg13cmos5l_dfrbpq_1_13.RESET_B sg13cmos5l_nor3_1_1.A 0.05982f
C7087 sg13cmos5l_dfrbpq_1_57.RESET_B a_11639_4703# 0.09404f
C7088 sg13cmos5l_dfrbpq_1_0.D a_27214_1899# 0.04617f
C7089 sg13cmos5l_xnor2_1_3.A a_18604_2070# 0.03379f
C7090 sg13cmos5l_buf_1_4.A sg13cmos5l_xnor2_1_4.Y 0.02052f
C7091 sg13cmos5l_xnor2_1_4.B sg13cmos5l_buf_1_4.X 0.96593f
C7092 a_7792_7138# a_7441_6995# 0.01017f
C7093 a_25679_2459# a_26346_2680# 0.13494f
C7094 a_24837_2361# a_25585_2459# 0.01058f
C7095 a_14379_2504# a_15376_2602# 0.06746f
C7096 sg13cmos5l_buf_1_1.X sg13cmos5l_dlygate4sd3_1_5.A 0.15384f
C7097 sg13cmos5l_nand3_1_0.A a_19845_849# 0.01543f
C7098 sg13cmos5l_and2_1_3.A sg13cmos5l_xor2_1_2.B 0.01358f
C7099 sg13cmos5l_dfrbpq_1_17.D a_11786_4192# 0.16882f
C7100 sg13cmos5l_dlygate4sd3_1_19.A sg13cmos5l_dfrbpq_1_13.Q 0.47251f
C7101 sg13cmos5l_dfrbpq_1_12.D a_6250_3108# 0.04222f
C7102 sg13cmos5l_dlygate4sd3_1_5.A a_21062_1632# 0.01161f
C7103 sg13cmos5l_dfrbpq_1_21.RESET_B a_4380_2346# 0.48122f
C7104 sg13cmos5l_buf_1_4.A sg13cmos5l_dlygate4sd3_1_11.A 0.02115f
C7105 a_7328_4742# VPWR 0.08126f
C7106 a_25764_8748# a_27023_8507# 0.01741f
C7107 sg13cmos5l_nor3_1_1.Y a_7716_2700# 0.02842f
C7108 sg13cmos5l_dlygate4sd3_1_21.X a_8235_2504# 0.02359f
C7109 a_18564_3148# a_19729_3505# 0.4858f
C7110 sg13cmos5l_buf_1_4.X a_21904_4898# 0.17945f
C7111 sg13cmos5l_buf_1_4.X a_13860_2700# 0.02782f
C7112 sg13cmos5l_dfrbpq_1_55.D a_15756_1060# 0.01276f
C7113 sg13cmos5l_buf_1_0.A sg13cmos5l_nor4_2_9.Y 0.48905f
C7114 a_5223_7767# a_6026_7960# 0.15089f
C7115 a_4293_8409# a_4663_7644# 0.01269f
C7116 a_3850_8653# a_4293_8409# 0.02241f
C7117 a_10022_8430# a_10827_8552# 0.11742f
C7118 a_10308_8748# a_10725_8409# 0.48921f
C7119 sg13cmos5l_nor4_2_5.Y sg13cmos5l_dfrbpq_1_58.Q 0.71563f
C7120 a_13676_6168# a_13888_6168# 0.31789f
C7121 a_14364_1993# a_15146_1912# 0.4806f
C7122 sg13cmos5l_buf_1_2.A a_17472_1671# 0.01501f
C7123 a_27280_5626# a_27690_5704# 0.1396f
C7124 sg13cmos5l_xnor2_1_12.B VPWR 0.65784f
C7125 a_25092_1188# VPWR 0.0721f
C7126 sg13cmos5l_dfrbpq_1_2.CLK sg13cmos5l_buf_1_1.X 0.58559f
C7127 sg13cmos5l_nor3_1_2.B a_3608_7721# 0.01154f
C7128 sg13cmos5l_xnor2_1_0.Y sg13cmos5l_xnor2_1_6.B 0.86986f
C7129 sg13cmos5l_nor4_2_7.D a_23835_8050# 0.06722f
C7130 sg13cmos5l_xnor2_1_4.Y sg13cmos5l_nor3_1_0.C 0.06581f
C7131 sg13cmos5l_dlygate4sd3_1_11.A sg13cmos5l_nor3_1_0.C 0.02085f
C7132 a_6391_834# a_6604_870# 0.40419f
C7133 a_1000_8468# sg13cmos5l_buf_1_11.A 0.30034f
C7134 a_3304_4026# a_3304_3230# 0.01095f
C7135 a_18315_4016# a_18084_3907# 0.15089f
C7136 a_17796_4212# a_18961_3971# 0.4858f
C7137 sg13cmos5l_xor2_1_2.B a_14542_4923# 0.01037f
C7138 sg13cmos5l_dfrbpq_1_23.D a_7649_4922# 0.01325f
C7139 sg13cmos5l_and2_1_1.A sg13cmos5l_dfrbpq_1_2.Q 0.01124f
C7140 sg13cmos5l_dfrbpq_1_58.Q sg13cmos5l_and2_1_3.A 0.01401f
C7141 sg13cmos5l_xnor2_1_6.B a_8759_1679# 0.01013f
C7142 a_2016_5721# VPWR 0.26448f
C7143 sg13cmos5l_buf_1_1.X a_20490_3144# 0.06751f
C7144 sg13cmos5l_buf_1_0.A sg13cmos5l_dfrbpq_1_12.D 0.03203f
C7145 sg13cmos5l_nor3_1_0.Y a_17655_1168# 0.02791f
C7146 sg13cmos5l_xnor2_1_6.B sg13cmos5l_xnor2_1_6.Y 0.07469f
C7147 sg13cmos5l_xnor2_1_4.B sg13cmos5l_dlygate4sd3_1_15.A 1.88487f
C7148 a_10943_4627# VPWR 0.246f
C7149 a_25764_8748# a_26929_8507# 0.4858f
C7150 a_26283_8552# a_26052_8443# 0.15089f
C7151 sg13cmos5l_dlygate4sd3_1_17.A a_27610_1596# 0.01027f
C7152 sg13cmos5l_xnor2_1_4.B a_28698_3144# 0.01331f
C7153 sg13cmos5l_dfrbpq_1_32.CLK a_7306_7648# 0.03939f
C7154 a_6165_7727# a_6071_7727# 0.87117f
C7155 a_21719_7309# en[4] 0.01825f
C7156 sg13cmos5l_nand3_1_1.Y a_9558_4680# 0.01072f
C7157 sg13cmos5l_dfrbpq_1_53.RESET_B a_14822_8118# 0.01928f
C7158 a_5244_8041# a_6026_7960# 0.4806f
C7159 sg13cmos5l_dlygate4sd3_1_9.A a_27994_3862# 0.52653f
C7160 a_8584_7050# VPWR 0.14362f
C7161 a_5703_5624# a_5724_5370# 0.38871f
C7162 a_27686_874# VPWR 0.24411f
C7163 sg13cmos5l_dlygate4sd3_1_17.A a_27905_7946# 0.01193f
C7164 sg13cmos5l_dlygate4sd3_1_22.X a_6972_834# 0.0346f
C7165 sg13cmos5l_dfrbpq_1_55.D a_14364_1993# 0.01122f
C7166 a_27690_5704# sg13cmos5l_dlygate4sd3_1_9.A 0.13324f
C7167 a_4544_7967# a_4663_7644# 0.13494f
C7168 sg13cmos5l_xnor2_1_0.A VPWR 0.68089f
C7169 sg13cmos5l_xnor2_1_8.Y sg13cmos5l_dfrbpq_1_57.CLK 0.9543f
C7170 a_27018_1168# VPWR 0.45348f
C7171 sg13cmos5l_and2_1_3.A a_5894_6606# 0.02035f
C7172 sg13cmos5l_xor2_1_2.B a_14186_6168# 0.101f
C7173 a_14926_6435# a_15041_6434# 0.67711f
C7174 a_808_1002# VPWR 0.13641f
C7175 sg13cmos5l_buf_1_0.A sg13cmos5l_xnor2_1_2.B 0.01616f
C7176 a_3590_3894# a_3876_4212# 0.50066f
C7177 a_10791_7767# a_11639_7727# 0.11742f
C7178 sg13cmos5l_buf_1_5.A sg13cmos5l_dfrbpq_1_57.D 0.0254f
C7179 sg13cmos5l_and2_1_3.A sg13cmos5l_dlygate4sd3_1_30.A 0.63505f
C7180 sg13cmos5l_dfrbpq_1_21.RESET_B a_3850_4117# 0.31497f
C7181 a_8004_2395# VPWR 0.01746f
C7182 sg13cmos5l_dfrbpq_1_53.RESET_B VPWR 7.53159f
C7183 sg13cmos5l_nor3_1_0.A sg13cmos5l_nor3_1_0.B 0.20841f
C7184 sg13cmos5l_dfrbpq_1_17.Q sg13cmos5l_dfrbpq_1_12.D 0.01526f
C7185 sg13cmos5l_dfrbpq_1_47.Q a_17914_7644# 0.03146f
C7186 a_20388_4212# a_20907_4016# 0.38902f
C7187 sg13cmos5l_dfrbpq_1_53.CLK a_27137_6434# 0.01873f
C7188 a_2266_6132# sg13cmos5l_dfrbpq_1_23.Q 0.51293f
C7189 a_26181_5385# VPWR 0.24021f
C7190 a_20871_7136# a_20892_6882# 0.38871f
C7191 a_21023_7188# a_21719_7309# 0.02431f
C7192 sg13cmos5l_dfrbpq_1_55.RESET_B a_10444_3582# 0.17713f
C7193 a_10231_3108# a_10812_3505# 0.01741f
C7194 sg13cmos5l_dfrbpq_1_29.Q sg13cmos5l_dfrbpq_1_47.Q 0.01466f
C7195 sg13cmos5l_dfrbpq_1_56.RESET_B a_15687_8648# 0.58453f
C7196 sg13cmos5l_buf_8_11.A sg13cmos5l_nand3_1_2.C 0.01401f
C7197 sg13cmos5l_xnor2_1_4.B sg13cmos5l_dlygate4sd3_1_2.A 0.01526f
C7198 sg13cmos5l_xnor2_1_5.Y a_16188_5017# 0.01251f
C7199 sg13cmos5l_nor4_2_5.C a_5230_7107# 0.04269f
C7200 a_15322_838# VPWR 0.34781f
C7201 a_8063_1603# a_8853_1679# 0.02241f
C7202 a_13592_4697# VPWR 0.3507f
C7203 sg13cmos5l_nor4_2_5.Y a_5334_6168# 0.04872f
C7204 sg13cmos5l_xnor2_1_3.B osc 0.02198f
C7205 sg13cmos5l_dlygate4sd3_1_39.A a_27784_6254# 0.07234f
C7206 sg13cmos5l_dfrbpq_1_55.Q sg13cmos5l_dfrbpq_1_22.D 0.02136f
C7207 sg13cmos5l_dlygate4sd3_1_4.X a_27690_8728# 0.013f
C7208 sg13cmos5l_nor4_2_5.C sg13cmos5l_nor3_1_2.C 0.48491f
C7209 sg13cmos5l_nor3_1_0.C a_21647_5017# 0.01778f
C7210 sg13cmos5l_dfrbpq_1_57.RESET_B sg13cmos5l_dfrbpq_1_56.CLK 0.02382f
C7211 sg13cmos5l_buf_1_5.A sg13cmos5l_buf_8_0.X 0.05312f
C7212 sg13cmos5l_dfrbpq_1_18.D VPWR 0.93779f
C7213 a_2054_8434# VPWR 0.24696f
C7214 a_17800_2514# VPWR 0.14345f
C7215 sg13cmos5l_dfrbpq_1_13.RESET_B a_6972_834# 0.48964f
C7216 sg13cmos5l_dlygate4sd3_1_4.A sg13cmos5l_xnor2_1_3.A 0.43109f
C7217 a_16320_1671# a_17036_1596# 0.03511f
C7218 a_6551_5797# a_6645_5564# 0.87117f
C7219 a_16666_2350# VPWR 0.38755f
C7220 sg13cmos5l_nor3_1_1.Y VPWR 0.90984f
C7221 sg13cmos5l_dlygate4sd3_1_11.X a_25478_5406# 0.3064f
C7222 a_15946_6136# a_15972_6172# 0.43042f
C7223 sg13cmos5l_dfrbpq_1_23.Q sg13cmos5l_xnor2_1_5.Y 0.01941f
C7224 sg13cmos5l_dfrbpq_1_16.Q sg13cmos5l_xnor2_1_12.B 0.0133f
C7225 a_6272_4069# a_6604_3894# 0.1396f
C7226 sg13cmos5l_dfrbpq_1_21.RESET_B a_6972_3858# 0.49751f
C7227 sg13cmos5l_dfrbpq_1_57.RESET_B a_8776_5444# 0.30026f
C7228 a_3680_1045# VPWR 0.4534f
C7229 sg13cmos5l_dfrbpq_1_0.CLK a_25188_4212# 0.09983f
C7230 sg13cmos5l_dfrbpq_1_21.RESET_B a_4278_6192# 0.03654f
C7231 sg13cmos5l_dfrbpq_1_0.CLK a_25439_1603# 0.39911f
C7232 sg13cmos5l_nor3_1_1.C sg13cmos5l_dfrbpq_1_11.CLK 0.71854f
C7233 sg13cmos5l_dfrbpq_1_55.RESET_B a_13860_3148# 0.48697f
C7234 sg13cmos5l_buf_8_2.X a_25419_3155# 0.01596f
C7235 a_13676_6168# VPWR 0.41253f
C7236 a_27280_5626# VPWR 0.18795f
C7237 a_20524_6918# a_20782_6918# 0.01017f
C7238 a_21719_7309# a_21813_7076# 0.87117f
C7239 sg13cmos5l_dfrbpq_1_56.RESET_B sg13cmos5l_nor4_2_4.D 0.24019f
C7240 sg13cmos5l_dfrbpq_1_0.CLK a_25585_2459# 0.02401f
C7241 sg13cmos5l_xnor2_1_3.A VPWR 0.47806f
C7242 a_27195_3514# a_27608_2386# 0.0135f
C7243 a_3680_5609# a_4088_5410# 0.02957f
C7244 a_23660_5704# a_23872_5704# 0.31789f
C7245 a_21174_1656# a_21742_1899# 0.03281f
C7246 sg13cmos5l_dfrbpq_1_0.D a_27329_1898# 0.0144f
C7247 a_15820_5094# VPWR 0.18719f
C7248 sg13cmos5l_dfrbpq_1_57.RESET_B sg13cmos5l_dfrbpq_1_22.D 0.02094f
C7249 sg13cmos5l_nor3_1_1.Y a_8714_1912# 0.01536f
C7250 sg13cmos5l_nor3_1_0.Y sg13cmos5l_nand3_1_0.B 0.24379f
C7251 a_7046_8118# a_7851_7691# 0.11742f
C7252 a_7332_7684# a_7749_7691# 0.49014f
C7253 sg13cmos5l_nand3_1_0.A a_20792_1673# 0.02288f
C7254 sg13cmos5l_nor3_1_2.B sg13cmos5l_dfrbpq_1_58.RESET_B 0.01136f
C7255 a_15041_1060# a_15322_838# 0.33585f
C7256 a_16581_5385# a_16319_4627# 0.05804f
C7257 sg13cmos5l_nand3_1_1.Y a_11594_4936# 0.01143f
C7258 sg13cmos5l_xnor2_1_2.A a_16270_2571# 0.07094f
C7259 sg13cmos5l_dfrbpq_1_53.RESET_B a_17034_7680# 0.01291f
C7260 sg13cmos5l_xnor2_1_6.B a_2266_1596# 0.01671f
C7261 a_11733_3191# VPWR 0.09495f
C7262 a_13996_2070# VPWR 0.18794f
C7263 sg13cmos5l_buf_1_0.A sg13cmos5l_nor4_2_5.Y 0.03238f
C7264 sg13cmos5l_dfrbpq_1_53.RESET_B a_26853_6897# 0.05193f
C7265 a_25094_8118# a_25899_7691# 0.11742f
C7266 a_25380_7684# a_25797_7691# 0.49014f
C7267 sg13cmos5l_nor4_2_1.D sg13cmos5l_nand3_1_0.A 0.28892f
C7268 sg13cmos5l_dlygate4sd3_1_9.X a_27598_4083# 0.19338f
C7269 a_9166_4083# sg13cmos5l_xor2_1_1.B 0.19337f
C7270 sg13cmos5l_xnor2_1_2.B a_16485_6897# 0.01209f
C7271 a_2266_6132# VPWR 0.38749f
C7272 sg13cmos5l_dfrbpq_1_21.RESET_B a_6272_8605# 0.05428f
C7273 a_15972_6172# a_17231_6529# 0.01741f
C7274 sg13cmos5l_buf_1_0.A sg13cmos5l_dfrbpq_1_3.D 0.83225f
C7275 sg13cmos5l_dlygate4sd3_1_4.A sg13cmos5l_dlygate4sd3_1_1.A 0.07616f
C7276 sg13cmos5l_dfrbpq_1_13.RESET_B sg13cmos5l_xnor2_1_6.A 0.17282f
C7277 sg13cmos5l_dfrbpq_1_21.RESET_B sg13cmos5l_dlygate4sd3_1_58.A 1.22208f
C7278 sg13cmos5l_nor3_1_1.A a_16666_2350# 0.01888f
C7279 sg13cmos5l_dlygate4sd3_1_21.A sg13cmos5l_xnor2_1_6.Y 0.04506f
C7280 sg13cmos5l_xnor2_1_2.A sg13cmos5l_buf_1_4.X 0.02559f
C7281 sg13cmos5l_xnor2_1_5.A sg13cmos5l_dfrbpq_1_55.RESET_B 0.15631f
C7282 sg13cmos5l_nor3_1_1.A sg13cmos5l_nor3_1_1.Y 0.10989f
C7283 sg13cmos5l_buf_8_3.A sg13cmos5l_nor3_1_1.C 0.45571f
C7284 sg13cmos5l_dfrbpq_1_57.RESET_B a_15108_7684# 0.48108f
C7285 sg13cmos5l_buf_1_0.A sg13cmos5l_dlygate4sd3_1_18.X 0.01932f
C7286 sg13cmos5l_dlygate4sd3_1_6.A a_19246_6435# 0.05114f
C7287 sg13cmos5l_nor3_1_1.Y a_15041_1060# 0.01347f
C7288 a_16138_5629# a_16581_5385# 0.02241f
C7289 a_15878_5406# a_16164_5724# 0.50066f
C7290 sg13cmos5l_nor4_2_5.C a_5036_6168# 0.03714f
C7291 a_13834_3112# a_13860_3148# 0.43042f
C7292 a_18891_2504# a_19631_2459# 0.3087f
C7293 sg13cmos5l_nor3_1_1.C sg13cmos5l_dfrbpq_1_54.Q 0.03826f
C7294 sg13cmos5l_buf_1_0.A sg13cmos5l_dlygate4sd3_1_5.A 2.18967f
C7295 sg13cmos5l_xnor2_1_3.B sg13cmos5l_buf_1_1.X 0.93995f
C7296 a_6551_5797# VPWR 0.92902f
C7297 sg13cmos5l_buf_1_0.A sg13cmos5l_and2_1_3.A 0.05181f
C7298 a_4511_2652# a_4359_2600# 0.6663f
C7299 sg13cmos5l_dlygate4sd3_1_9.A VPWR 0.48821f
C7300 a_15946_6136# VPWR 0.0958f
C7301 sg13cmos5l_dfrbpq_1_57.CLK a_10812_8041# 0.10184f
C7302 sg13cmos5l_nor4_2_7.D sg13cmos5l_and2_1_1.X 0.23836f
C7303 a_1302_1656# VPWR 0.21644f
C7304 sg13cmos5l_nor4_2_7.D sg13cmos5l_xnor2_1_10.Y 0.03332f
C7305 a_10812_8041# a_10943_7651# 0.48921f
C7306 a_25738_4624# a_25764_4660# 0.43042f
C7307 a_17100_2572# a_17135_2386# 0.3658f
C7308 sg13cmos5l_nand3_1_2.Y a_24815_5410# 0.02283f
C7309 sg13cmos5l_nor3_1_0.C a_19083_3155# 0.016f
C7310 sg13cmos5l_nand3_1_1.B a_14657_4922# 0.04503f
C7311 a_21719_7309# VPWR 0.94679f
C7312 a_16385_2572# a_16666_2350# 0.33585f
C7313 a_9736_1718# a_9920_1718# 0.11523f
C7314 sg13cmos5l_nor4_2_1.A VPWR 1.51409f
C7315 a_10308_1636# a_10827_1643# 0.38871f
C7316 a_10725_1643# a_10596_2057# 0.01562f
C7317 sg13cmos5l_buf_1_2.A sg13cmos5l_dfrbpq_1_55.RESET_B 0.01348f
C7318 a_2016_7233# VPWR 0.26295f
C7319 a_23660_5704# VPWR 0.4126f
C7320 sg13cmos5l_nand3_1_1.B sg13cmos5l_dfrbpq_1_55.Q 0.07775f
C7321 sg13cmos5l_dlygate4sd3_1_1.A VPWR 1.24575f
C7322 sg13cmos5l_buf_1_1.X a_24134_2382# 0.1011f
C7323 a_20388_8748# a_21647_8507# 0.01741f
C7324 sg13cmos5l_xnor2_1_5.Y VPWR 1.09894f
C7325 sg13cmos5l_nand3_1_3.B VPWR 0.19015f
C7326 sg13cmos5l_buf_1_4.X a_25288_4742# 0.01605f
C7327 sg13cmos5l_dfrbpq_1_23.Q sg13cmos5l_dfrbpq_1_23.D 0.02002f
C7328 a_15839_8700# a_15525_7691# 0.03343f
C7329 sg13cmos5l_dfrbpq_1_56.CLK a_15108_7684# 0.09959f
C7330 a_18090_5704# sg13cmos5l_nor4_2_1.A 0.01234f
C7331 sg13cmos5l_buf_1_0.X a_20907_8552# 0.55128f
C7332 sg13cmos5l_dlygate4sd3_1_6.X a_21647_5483# 0.04676f
C7333 sg13cmos5l_buf_1_0.A sg13cmos5l_dfrbpq_1_2.CLK 0.07162f
C7334 a_16454_3144# VPWR 0.24195f
C7335 a_6693_6897# a_6795_7040# 0.66105f
C7336 a_24394_2605# a_24134_2382# 0.87117f
C7337 sg13cmos5l_dlygate4sd3_1_18.X sg13cmos5l_dfrbpq_1_17.Q 0.19898f
C7338 sg13cmos5l_dlygate4sd3_1_22.X sg13cmos5l_buf_8_3.A 0.07624f
C7339 a_15878_5406# VPWR 0.92718f
C7340 a_9176_5410# sg13cmos5l_dfrbpq_1_57.Q 0.53537f
C7341 a_25380_7684# a_26545_8041# 0.4858f
C7342 sg13cmos5l_buf_8_4.A a_7534_4923# 0.02181f
C7343 a_10444_2382# a_10702_2382# 0.01017f
C7344 sg13cmos5l_dfrbpq_1_13.RESET_B sg13cmos5l_dfrbpq_1_11.CLK 0.1943f
C7345 sg13cmos5l_and2_1_3.A a_10444_6606# 0.01033f
C7346 sg13cmos5l_dfrbpq_1_56.Q VPWR 0.40172f
C7347 a_17231_6529# a_17898_6168# 0.13494f
C7348 a_17488_6410# a_17137_6529# 0.01017f
C7349 sg13cmos5l_dfrbpq_1_53.RESET_B sg13cmos5l_nand3_1_1.A 0.02355f
C7350 sg13cmos5l_buf_8_0.X a_15850_3862# 1.03593f
C7351 sg13cmos5l_dfrbpq_1_21.CLK sg13cmos5l_xnor2_1_12.B 0.0381f
C7352 sg13cmos5l_xnor2_1_2.B a_16042_7141# 0.03055f
C7353 a_15786_3144# sg13cmos5l_dfrbpq_1_54.Q 0.16746f
C7354 a_10308_1188# a_11567_947# 0.01741f
C7355 sg13cmos5l_dlygate4sd3_1_19.X a_4202_4656# 0.09805f
C7356 a_6693_6897# VPWR 0.24202f
C7357 a_17231_6529# VPWR 0.17358f
C7358 sg13cmos5l_dlygate4sd3_1_19.X sg13cmos5l_dlygate4sd3_1_23.X 3.0635f
C7359 sg13cmos5l_nor4_2_5.Y a_4366_7107# 0.01061f
C7360 sg13cmos5l_nand3_1_1.B a_14926_6435# 0.02808f
C7361 sg13cmos5l_xnor2_1_8.Y sg13cmos5l_dlygate4sd3_1_38.A 0.96839f
C7362 a_26181_4667# a_26283_4667# 0.6663f
C7363 sg13cmos5l_dlygate4sd3_1_34.A sg13cmos5l_dfrbpq_1_53.RESET_B 3.64154f
C7364 sg13cmos5l_nor3_1_0.C a_18862_2070# 0.01341f
C7365 sg13cmos5l_dfrbpq_1_53.CLK a_25797_7691# 0.37892f
C7366 en[4] en[3] 0.01396f
C7367 a_20805_8409# a_21553_8507# 0.01058f
C7368 sg13cmos5l_dlygate4sd3_1_47.A a_28652_7644# 0.0336f
C7369 sg13cmos5l_nor3_1_0.C a_18660_2395# 0.01066f
C7370 sg13cmos5l_dlygate4sd3_1_17.X osc 0.13291f
C7371 a_15008_8605# a_15340_8430# 0.1396f
C7372 sg13cmos5l_dlygate4sd3_1_19.X a_3680_2557# 0.04421f
C7373 sg13cmos5l_nor4_2_9.Y sg13cmos5l_dlygate4sd3_1_19.X 0.16436f
C7374 sg13cmos5l_dfrbpq_1_53.RESET_B a_25029_6179# 0.02733f
C7375 sg13cmos5l_xnor2_1_0.Y a_6250_2350# 0.01077f
C7376 sg13cmos5l_dfrbpq_1_53.CLK a_25764_4660# 0.08985f
C7377 sg13cmos5l_buf_1_1.X a_18391_1596# 0.23141f
C7378 a_21435_3514# VPWR 1.15526f
C7379 a_15839_8700# a_15627_7691# 0.01667f
C7380 sg13cmos5l_nand3_1_1.Y a_16188_5017# 0.01904f
C7381 a_19103_1603# a_19754_1912# 0.01562f
C7382 sg13cmos5l_dfrbpq_1_58.D a_5703_5624# 0.01705f
C7383 sg13cmos5l_dfrbpq_1_13.RESET_B sg13cmos5l_buf_8_3.A 0.02365f
C7384 sg13cmos5l_dlygate4sd3_1_6.X sg13cmos5l_dlygate4sd3_1_51.A 0.0453f
C7385 a_13916_4192# sg13cmos5l_xnor2_1_5.A 0.13903f
C7386 a_24837_2361# a_24939_2504# 0.66105f
C7387 a_17680_5626# VPWR 0.18764f
C7388 sg13cmos5l_dfrbpq_1_53.RESET_B a_17914_7644# 0.01267f
C7389 sg13cmos5l_nor3_1_1.A a_16454_3144# 0.05553f
C7390 a_1784_3185# sg13cmos5l_xnor2_1_0.A 0.09191f
C7391 a_6250_7141# a_5990_6918# 0.87117f
C7392 sg13cmos5l_and2_1_3.A a_10943_6139# 0.01333f
C7393 sg13cmos5l_dlygate4sd3_1_55.X sg13cmos5l_buf_8_11.A 0.08016f
C7394 a_25478_8430# a_26181_8409# 0.02453f
C7395 a_15082_7648# a_15525_7691# 0.02241f
C7396 sg13cmos5l_nor4_2_1.D a_18278_3582# 0.36197f
C7397 sg13cmos5l_dfrbpq_1_12.D sg13cmos5l_dlygate4sd3_1_18.A 0.02423f
C7398 sg13cmos5l_dfrbpq_1_29.Q sg13cmos5l_dfrbpq_1_53.RESET_B 0.6093f
C7399 a_5230_2070# a_5471_1603# 0.01058f
C7400 sg13cmos5l_xnor2_1_13.Y sg13cmos5l_dfrbpq_1_23.Q 0.13137f
C7401 sg13cmos5l_dfrbpq_1_57.RESET_B a_10725_5385# 0.06889f
C7402 a_21934_2571# a_22049_2572# 0.67711f
C7403 sg13cmos5l_nor4_2_5.C a_4164_8443# 0.01107f
C7404 a_8975_2459# a_8881_2459# 0.32273f
C7405 a_17680_5626# a_18090_5704# 0.1396f
C7406 a_16164_5724# a_17329_5483# 0.4858f
C7407 a_16683_5528# a_16452_5419# 0.15089f
C7408 sg13cmos5l_dfrbpq_1_23.Q sg13cmos5l_nand3_1_1.Y 0.01676f
C7409 a_8842_6886# VPWR 1.25101f
C7410 sg13cmos5l_xnor2_1_4.A a_25103_6995# 0.0447f
C7411 sg13cmos5l_dlygate4sd3_1_50.A a_13592_4697# 0.50425f
C7412 sg13cmos5l_nor3_1_2.C a_6250_7141# 0.01258f
C7413 a_5894_6606# a_6180_6172# 0.50066f
C7414 a_13888_7680# VPWR 0.39106f
C7415 a_23844_7236# a_24363_7040# 0.38902f
C7416 sg13cmos5l_dfrbpq_1_23.D VPWR 0.85237f
C7417 sg13cmos5l_dfrbpq_1_57.CLK sg13cmos5l_buf_1_5.A 0.04963f
C7418 sg13cmos5l_dfrbpq_1_47.Q en[2] 0.04184f
C7419 a_27280_4898# a_27023_5017# 0.40419f
C7420 sg13cmos5l_dfrbpq_1_56.D a_13888_6168# 0.0295f
C7421 a_13783_1596# a_13996_2070# 0.40419f
C7422 sg13cmos5l_dlygate4sd3_1_19.X sg13cmos5l_dfrbpq_1_12.D 5.64685f
C7423 sg13cmos5l_dfrbpq_1_53.CLK a_26545_8041# 0.02048f
C7424 sg13cmos5l_nor4_2_1.A a_20102_3894# 0.33975f
C7425 a_24727_1596# VPWR 0.17296f
C7426 sg13cmos5l_dfrbpq_1_57.D a_11639_4703# 0.28981f
C7427 sg13cmos5l_xnor2_1_5.Y sg13cmos5l_dfrbpq_1_16.Q 0.0173f
C7428 sg13cmos5l_nand3_1_2.Y sg13cmos5l_nand3_1_2.B 0.29569f
C7429 sg13cmos5l_xnor2_1_4.Y a_24954_5704# 0.01103f
C7430 sg13cmos5l_xor2_1_2.B a_13745_3948# 0.41006f
C7431 sg13cmos5l_dfrbpq_1_57.RESET_B a_10112_6455# 0.02292f
C7432 a_10231_7644# a_10812_8041# 0.01741f
C7433 sg13cmos5l_dfrbpq_1_35.Q a_12234_7216# 0.13536f
C7434 a_4012_870# a_4270_870# 0.01017f
C7435 a_17770_4117# a_17510_3894# 0.87117f
C7436 a_8842_6886# sg13cmos5l_buf_8_10.A 0.5167f
C7437 sg13cmos5l_dlygate4sd3_1_28.A VPWR 0.39151f
C7438 sg13cmos5l_dfrbpq_1_17.D sg13cmos5l_xnor2_1_5.A 0.5388f
C7439 sg13cmos5l_xnor2_1_0.A sg13cmos5l_xnor2_1_6.A 0.62823f
C7440 sg13cmos5l_dlygate4sd3_1_39.A sg13cmos5l_buf_1_4.A 0.05554f
C7441 sg13cmos5l_xnor2_1_6.B a_6167_1679# 0.01216f
C7442 sg13cmos5l_xnor2_1_6.A a_808_1002# 0.0341f
C7443 a_26853_6897# a_27601_6995# 0.01058f
C7444 sg13cmos5l_and2_1_3.A sg13cmos5l_dlygate4sd3_1_52.X 0.88246f
C7445 sg13cmos5l_dlygate4sd3_1_11.X a_28936_5538# 0.01686f
C7446 a_13888_7680# a_14186_7680# 0.42343f
C7447 a_15108_7684# a_15396_8105# 0.4806f
C7448 a_17898_6168# a_18382_6435# 0.03282f
C7449 sg13cmos5l_dfrbpq_1_21.RESET_B a_7799_8821# 0.09221f
C7450 sg13cmos5l_dlygate4sd3_1_52.A a_10022_6918# 0.05514f
C7451 a_11639_2773# a_11733_2540# 0.87117f
C7452 sg13cmos5l_xnor2_1_4.B a_24900_3148# 0.0165f
C7453 sg13cmos5l_buf_1_0.A sg13cmos5l_nor3_1_2.Y 0.15391f
C7454 sg13cmos5l_dlygate4sd3_1_28.X sg13cmos5l_dlygate4sd3_1_52.X 0.06557f
C7455 sg13cmos5l_dfrbpq_1_42.Q a_19526_8434# 0.05244f
C7456 sg13cmos5l_dlygate4sd3_1_2.A a_27610_1596# 0.52861f
C7457 sg13cmos5l_dfrbpq_1_56.RESET_B a_15607_4620# 0.20146f
C7458 a_20298_2680# sg13cmos5l_dlygate4sd3_1_5.A 0.13351f
C7459 a_15119_2459# VPWR 0.21128f
C7460 a_5894_6606# a_6699_6179# 0.11742f
C7461 sg13cmos5l_dfrbpq_1_56.RESET_B sg13cmos5l_nor3_1_4.Y 0.01304f
C7462 a_28174_4923# a_28289_4922# 0.67711f
C7463 a_16367_8041# VPWR 0.17237f
C7464 a_9558_5474# VPWR 0.21384f
C7465 a_24363_7040# a_25360_7138# 0.06746f
C7466 a_23558_6918# a_24132_6931# 0.36169f
C7467 sg13cmos5l_xnor2_1_5.Y a_11567_5483# 0.01024f
C7468 a_5143_5370# a_5356_5406# 0.40419f
C7469 a_16587_7040# en[4] 0.01092f
C7470 a_18382_6435# VPWR 0.21531f
C7471 a_25439_1603# a_26090_1912# 0.01562f
C7472 a_27690_4656# a_28174_4923# 0.03282f
C7473 a_26436_7236# VPWR 0.07254f
C7474 sg13cmos5l_buf_1_4.X sg13cmos5l_dfrbpq_1_5.Q 0.30037f
C7475 sg13cmos5l_dfrbpq_1_56.D a_15972_6172# 0.02239f
C7476 a_20871_7767# a_21674_7960# 0.15089f
C7477 a_15302_5410# sg13cmos5l_nor3_1_4.C 0.01107f
C7478 sg13cmos5l_buf_1_5.A sg13cmos5l_xnor2_1_2.A 1.07636f
C7479 sg13cmos5l_xnor2_1_8.Y sg13cmos5l_nor4_2_9.Y 0.01227f
C7480 sg13cmos5l_buf_1_4.X a_24874_3112# 0.35313f
C7481 sg13cmos5l_dlygate4sd3_1_38.A sg13cmos5l_dfrbpq_1_58.RESET_B 0.20549f
C7482 a_20892_8041# a_21023_7651# 0.48921f
C7483 sg13cmos5l_buf_1_2.A a_16683_5528# 0.02497f
C7484 sg13cmos5l_buf_1_4.A sg13cmos5l_nor3_1_0.C 0.30575f
C7485 sg13cmos5l_nand3_1_1.A sg13cmos5l_xnor2_1_5.Y 0.68484f
C7486 a_7535_6995# a_7439_6529# 0.02016f
C7487 a_23368_8562# VPWR 0.16412f
C7488 a_3488_5538# VPWR 0.06649f
C7489 a_19312_4114# a_18961_3971# 0.01017f
C7490 sg13cmos5l_dfrbpq_1_18.D sg13cmos5l_xnor2_1_6.A 0.02301f
C7491 sg13cmos5l_buf_1_0.A a_10725_1643# 0.01328f
C7492 sg13cmos5l_nor4_2_5.B a_4730_6168# 0.1048f
C7493 sg13cmos5l_dlygate4sd3_1_16.A sg13cmos5l_nand3_1_0.B 1.79003f
C7494 sg13cmos5l_xnor2_1_13.Y VPWR 0.8208f
C7495 sg13cmos5l_xnor2_1_6.B sg13cmos5l_nor4_2_3.Y 0.16123f
C7496 a_15786_2680# sg13cmos5l_dfrbpq_1_59.Q 0.13332f
C7497 sg13cmos5l_xnor2_1_2.A a_16320_1671# 0.12717f
C7498 sg13cmos5l_nand3_1_1.A a_15878_5406# 0.01104f
C7499 sg13cmos5l_nand3_1_1.Y VPWR 1.0276f
C7500 sg13cmos5l_nand3_1_1.A sg13cmos5l_dfrbpq_1_56.Q 0.25555f
C7501 a_5392_8650# VPWR 0.18667f
C7502 sg13cmos5l_nor4_2_9.D sg13cmos5l_dfrbpq_1_23.Q 0.4798f
C7503 a_7932_1993# a_8853_1679# 0.43042f
C7504 sg13cmos5l_buf_1_0.A sg13cmos5l_xnor2_1_3.B 0.02379f
C7505 sg13cmos5l_dlygate4sd3_1_57.A a_15082_7648# 0.03481f
C7506 sg13cmos5l_dfrbpq_1_23.Q a_5855_5676# 0.05304f
C7507 a_18272_1919# a_18080_1718# 0.03403f
C7508 sg13cmos5l_nor3_1_4.A a_15686_6606# 0.29666f
C7509 sg13cmos5l_xnor2_1_5.A sg13cmos5l_nand3_1_0.Y 0.06205f
C7510 sg13cmos5l_dlygate4sd3_1_6.A a_18891_2504# 0.01761f
C7511 sg13cmos5l_nor3_1_4.A a_15322_6132# 0.02716f
C7512 sg13cmos5l_xnor2_1_4.A sg13cmos5l_dlygate4sd3_1_17.X 1.76379f
C7513 sg13cmos5l_dlygate4sd3_1_4.X a_26283_8552# 0.01119f
C7514 a_9446_4656# a_9562_3862# 0.01206f
C7515 sg13cmos5l_dlygate4sd3_1_19.X a_4164_3907# 0.01087f
C7516 VPWR en[3] 0.27783f
C7517 sg13cmos5l_dlygate4sd3_1_6.X a_23712_6207# 0.1324f
C7518 sg13cmos5l_xnor2_1_9.A en[4] 0.14282f
C7519 sg13cmos5l_dfrbpq_1_56.RESET_B a_16319_4627# 0.06143f
C7520 sg13cmos5l_buf_8_0.X a_14657_4922# 0.02816f
C7521 a_9258_7680# en[1] 0.03665f
C7522 a_6180_6172# a_7345_6529# 0.4858f
C7523 sg13cmos5l_nor4_2_9.D a_6645_5564# 0.01704f
C7524 sg13cmos5l_nand3_1_2.C sg13cmos5l_nand3_1_2.Y 0.05658f
C7525 a_4366_7107# a_4160_7050# 0.03208f
C7526 sg13cmos5l_buf_1_4.X a_25162_4117# 0.34783f
C7527 a_15285_1679# a_15191_1679# 0.87117f
C7528 a_5855_5676# a_6645_5564# 0.02241f
C7529 sg13cmos5l_dlygate4sd3_1_51.X a_23660_5704# 0.11562f
C7530 sg13cmos5l_xnor2_1_5.Y sg13cmos5l_dlygate4sd3_1_50.A 0.03078f
C7531 a_1340_3144# VPWR 0.25259f
C7532 sg13cmos5l_dlygate4sd3_1_11.X sg13cmos5l_nand3_1_2.Y 0.03546f
C7533 sg13cmos5l_dfrbpq_1_16.Q sg13cmos5l_dfrbpq_1_23.D 0.016f
C7534 a_28570_4620# sg13cmos5l_dfrbpq_1_7.Q 0.50792f
C7535 a_27952_7138# VPWR 0.18809f
C7536 sg13cmos5l_buf_8_11.A a_27963_6538# 0.53352f
C7537 sg13cmos5l_dfrbpq_1_56.D a_17898_6168# 0.06029f
C7538 sg13cmos5l_nand3_1_2.A a_24261_6897# 0.04601f
C7539 sg13cmos5l_dlygate4sd3_1_9.X sg13cmos5l_nand3_1_2.B 0.16175f
C7540 sg13cmos5l_dfrbpq_1_57.RESET_B sg13cmos5l_dfrbpq_1_57.D 0.20084f
C7541 sg13cmos5l_dfrbpq_1_56.CLK a_15782_6918# 0.03174f
C7542 a_4395_4016# a_5135_3971# 0.3087f
C7543 sg13cmos5l_dfrbpq_1_18.D sg13cmos5l_dlygate4sd3_1_19.A 0.02036f
C7544 sg13cmos5l_dfrbpq_1_21.RESET_B a_4395_4016# 0.58827f
C7545 sg13cmos5l_buf_8_5.A a_5724_5370# 0.03218f
C7546 a_10812_2346# VPWR 0.14244f
C7547 sg13cmos5l_buf_1_2.A sg13cmos5l_nand3_1_0.Y 0.03788f
C7548 a_13472_7766# VPWR 0.07341f
C7549 sg13cmos5l_nor3_1_0.C a_18444_1060# 0.02875f
C7550 a_20907_4016# a_21904_4114# 0.06746f
C7551 a_20102_3894# a_20676_3907# 0.36169f
C7552 sg13cmos5l_buf_1_0.A a_3850_4117# 0.03043f
C7553 sg13cmos5l_dlygate4sd3_1_6.A a_18826_4620# 0.03872f
C7554 sg13cmos5l_dfrbpq_1_56.RESET_B a_16138_5629# 0.3609f
C7555 sg13cmos5l_dfrbpq_1_12.D sg13cmos5l_dfrbpq_1_11.Q 0.38059f
C7556 sg13cmos5l_buf_8_9.A a_7594_5374# 0.53253f
C7557 sg13cmos5l_dlygate4sd3_1_15.A a_24874_3112# 0.01303f
C7558 a_7532_3144# a_7744_3144# 0.31789f
C7559 sg13cmos5l_dlygate4sd3_1_18.X sg13cmos5l_dlygate4sd3_1_18.A 0.31953f
C7560 sg13cmos5l_nor3_1_1.Y sg13cmos5l_dfrbpq_1_11.CLK 0.05583f
C7561 a_10112_3431# sg13cmos5l_nor3_1_1.C 0.01322f
C7562 a_23846_3898# a_23846_3144# 0.01869f
C7563 a_23368_4026# a_23368_3230# 0.01095f
C7564 sg13cmos5l_xnor2_1_5.Y sg13cmos5l_dfrbpq_1_21.CLK 0.02045f
C7565 sg13cmos5l_dfrbpq_1_53.RESET_B a_27418_6132# 0.01271f
C7566 sg13cmos5l_dfrbpq_1_56.D VPWR 0.56357f
C7567 sg13cmos5l_buf_8_2.X sg13cmos5l_and2_1_0.X 0.04307f
C7568 sg13cmos5l_dfrbpq_1_46.D sg13cmos5l_nor3_1_0.C 0.02043f
C7569 a_16485_6897# a_16389_6179# 0.08475f
C7570 a_6972_8394# a_6862_8430# 0.4858f
C7571 a_7799_8821# a_7754_8588# 0.36169f
C7572 a_22138_1596# VPWR 0.39762f
C7573 a_26159_3505# a_26065_3505# 0.32273f
C7574 sg13cmos5l_dfrbpq_1_0.CLK a_24939_2504# 0.04817f
C7575 a_10812_6529# VPWR 0.07518f
C7576 sg13cmos5l_dfrbpq_1_53.RESET_B a_2920_7680# 0.28893f
C7577 a_23552_2514# VPWR 0.07247f
C7578 sg13cmos5l_dfrbpq_1_56.D a_18090_5704# 0.01247f
C7579 sg13cmos5l_dlygate4sd3_1_19.X a_992_5538# 0.03994f
C7580 a_16624_7922# a_16273_8041# 0.01017f
C7581 a_16367_8041# a_17034_7680# 0.13494f
C7582 sg13cmos5l_nand3_1_0.A VPWR 0.32246f
C7583 sg13cmos5l_buf_1_0.X sg13cmos5l_dfrbpq_1_3.D 0.30807f
C7584 sg13cmos5l_dfrbpq_1_57.CLK a_10308_7236# 0.11037f
C7585 sg13cmos5l_dfrbpq_1_56.RESET_B a_17488_6410# 0.17118f
C7586 sg13cmos5l_nor3_1_4.B a_15488_4943# 0.01214f
C7587 sg13cmos5l_dfrbpq_1_13.RESET_B a_15191_1679# 0.01889f
C7588 sg13cmos5l_dfrbpq_1_57.CLK sg13cmos5l_dlygate4sd3_1_53.A 0.02477f
C7589 a_24612_6172# VPWR 0.07305f
C7590 sg13cmos5l_dlygate4sd3_1_58.A a_8488_6254# 0.02427f
C7591 a_20388_5724# a_20907_5528# 0.38902f
C7592 a_4293_3873# VPWR 0.24249f
C7593 sg13cmos5l_dfrbpq_1_15.D a_3692_4656# 0.01407f
C7594 a_26150_6918# a_26955_7040# 0.11742f
C7595 a_26436_7236# a_26853_6897# 0.48921f
C7596 sg13cmos5l_xnor2_1_6.A a_1302_1656# 0.04461f
C7597 sg13cmos5l_nand3_1_1.A a_13888_7680# 0.02179f
C7598 sg13cmos5l_buf_1_4.X sg13cmos5l_dfrbpq_1_12.D 0.02591f
C7599 sg13cmos5l_dlygate4sd3_1_40.A a_26150_6918# 0.05891f
C7600 a_20805_8409# a_20871_7767# 0.0167f
C7601 a_22314_6168# VPWR 0.46554f
C7602 a_7696_6410# a_8106_6168# 0.1396f
C7603 a_10812_3505# VPWR 0.07416f
C7604 sg13cmos5l_buf_8_10.A sg13cmos5l_dfrbpq_1_56.D 0.1604f
C7605 a_5855_5676# a_5614_5406# 0.01058f
C7606 sg13cmos5l_dfrbpq_1_57.RESET_B sg13cmos5l_dfrbpq_1_35.Q 1.67313f
C7607 a_14632_8562# VPWR 0.12288f
C7608 a_17518_7947# VPWR 0.21523f
C7609 a_7103_4164# a_6951_4112# 0.6663f
C7610 sg13cmos5l_dfrbpq_1_21.RESET_B a_4395_8552# 0.62427f
C7611 a_19361_6434# VPWR 0.24414f
C7612 sg13cmos5l_buf_1_0.A a_18391_1596# 0.01434f
C7613 sg13cmos5l_dfrbpq_1_13.RESET_B a_3850_3112# 0.03031f
C7614 sg13cmos5l_dlygate4sd3_1_35.A sg13cmos5l_dfrbpq_1_32.CLK 0.01108f
C7615 sg13cmos5l_buf_8_5.A a_9176_5410# 0.01086f
C7616 sg13cmos5l_buf_8_3.A sg13cmos5l_nor3_1_1.Y 0.15227f
C7617 a_9915_3898# a_10231_3108# 0.02788f
C7618 sg13cmos5l_dfrbpq_1_17.Q sg13cmos5l_dfrbpq_1_22.Q 0.06877f
C7619 sg13cmos5l_dlygate4sd3_1_18.X a_9558_3168# 0.05795f
C7620 sg13cmos5l_dfrbpq_1_55.Q a_13860_2700# 0.03207f
C7621 a_24940_2070# a_25287_1719# 0.06746f
C7622 a_25308_1993# a_25198_2070# 0.4858f
C7623 sg13cmos5l_dfrbpq_1_55.RESET_B a_15376_3386# 0.18477f
C7624 sg13cmos5l_xnor2_1_9.A a_3896_6926# 0.01437f
C7625 sg13cmos5l_dfrbpq_1_12.Q a_13834_2605# 0.01861f
C7626 a_10791_3231# a_11639_3191# 0.11742f
C7627 sg13cmos5l_nor4_2_9.Y sg13cmos5l_dfrbpq_1_58.RESET_B 0.02406f
C7628 sg13cmos5l_nor3_1_1.C a_13574_3582# 0.31683f
C7629 sg13cmos5l_dfrbpq_1_11.CLK a_13996_2070# 0.03473f
C7630 sg13cmos5l_dfrbpq_1_56.RESET_B a_17423_5483# 0.22117f
C7631 sg13cmos5l_nor4_2_9.D VPWR 1.01003f
C7632 a_5855_5676# VPWR 0.24304f
C7633 sg13cmos5l_xnor2_1_2.A a_15850_3862# 0.07974f
C7634 sg13cmos5l_dlygate4sd3_1_38.A sg13cmos5l_buf_1_5.A 0.03223f
C7635 sg13cmos5l_dfrbpq_1_55.RESET_B a_11567_1993# 0.0468f
C7636 sg13cmos5l_buf_1_4.A a_20944_1090# 0.01121f
C7637 sg13cmos5l_dfrbpq_1_56.CLK sg13cmos5l_buf_8_0.X 0.05914f
C7638 a_19142_870# a_19428_1188# 0.50066f
C7639 a_19402_1093# a_19845_849# 0.02241f
C7640 sg13cmos5l_nand3_1_1.Y sg13cmos5l_dfrbpq_1_16.Q 0.01863f
C7641 sg13cmos5l_xnor2_1_2.B sg13cmos5l_buf_1_4.X 0.01293f
C7642 a_10022_2070# a_10282_1600# 0.87117f
C7643 sg13cmos5l_xor2_1_2.A sg13cmos5l_dfrbpq_1_55.RESET_B 0.08036f
C7644 sg13cmos5l_nor3_1_4.B a_15322_6132# 0.05993f
C7645 a_20102_6606# a_20805_6179# 0.02431f
C7646 sg13cmos5l_dlygate4sd3_1_6.X a_21904_8650# 0.01415f
C7647 a_20102_8430# a_20388_8748# 0.50066f
C7648 a_10308_5724# a_10827_5528# 0.38902f
C7649 a_27790_7947# sg13cmos5l_nor4_2_7.B 0.19471f
C7650 a_16587_7040# VPWR 0.20834f
C7651 sg13cmos5l_buf_1_0.A a_28374_1656# 0.01018f
C7652 sg13cmos5l_dfrbpq_1_53.RESET_B en[2] 0.02807f
C7653 sg13cmos5l_dlygate4sd3_1_9.X sg13cmos5l_nand3_1_2.C 2.08779f
C7654 sg13cmos5l_dfrbpq_1_46.D sg13cmos5l_dfrbpq_1_46.CLK 4.46788f
C7655 a_25871_6529# VPWR 0.16954f
C7656 a_20907_5528# a_21904_5626# 0.06746f
C7657 a_20102_5406# a_20676_5419# 0.36169f
C7658 sg13cmos5l_dfrbpq_1_53.RESET_B sg13cmos5l_nor4_2_7.D 1.19018f
C7659 sg13cmos5l_buf_1_1.X a_18891_2504# 0.55491f
C7660 a_26955_7040# a_27695_6995# 0.3087f
C7661 sg13cmos5l_dlygate4sd3_1_9.X sg13cmos5l_dlygate4sd3_1_11.X 0.02016f
C7662 a_5392_8650# a_5802_8728# 0.1396f
C7663 sg13cmos5l_dfrbpq_1_13.RESET_B a_10282_1093# 0.34682f
C7664 a_14277_3155# VPWR 0.24789f
C7665 sg13cmos5l_dfrbpq_1_13.CLK a_10022_2070# 0.01451f
C7666 sg13cmos5l_dlygate4sd3_1_40.A a_27695_6995# 0.01065f
C7667 a_10943_2652# a_11594_2540# 0.01562f
C7668 sg13cmos5l_dlygate4sd3_1_0.X a_28646_874# 0.04641f
C7669 a_6272_1045# VPWR 0.4519f
C7670 sg13cmos5l_dfrbpq_1_21.RESET_B a_6071_7727# 0.10906f
C7671 sg13cmos5l_buf_8_3.A a_13996_2070# 0.0106f
C7672 a_25188_4212# a_25476_3907# 0.4806f
C7673 sg13cmos5l_dfrbpq_1_21.CLK sg13cmos5l_dfrbpq_1_23.D 1.38091f
C7674 sg13cmos5l_dfrbpq_1_56.CLK sg13cmos5l_and2_1_1.A 0.03627f
C7675 a_10308_8748# sg13cmos5l_dfrbpq_1_53.RESET_B 0.01859f
C7676 a_13860_3148# a_14379_3155# 0.38871f
C7677 a_13288_3230# a_13472_3230# 0.11523f
C7678 a_14277_3155# a_14148_3569# 0.01562f
C7679 sg13cmos5l_dfrbpq_1_21.RESET_B a_4663_7644# 0.20584f
C7680 sg13cmos5l_dfrbpq_1_21.RESET_B a_3850_8653# 0.35914f
C7681 sg13cmos5l_dfrbpq_1_53.RESET_B a_10702_8118# 0.0102f
C7682 sg13cmos5l_buf_1_0.A sg13cmos5l_dfrbpq_1_55.D 0.14749f
C7683 a_9446_6168# a_9446_5410# 0.02196f
C7684 sg13cmos5l_dlygate4sd3_1_47.A sg13cmos5l_dfrbpq_1_53.RESET_B 0.02175f
C7685 sg13cmos5l_buf_8_4.A a_7594_5374# 1.06905f
C7686 a_20102_5094# VPWR 0.92915f
C7687 sg13cmos5l_buf_8_10.A a_16587_7040# 0.02019f
C7688 a_4380_2346# a_5301_2540# 0.43042f
C7689 sg13cmos5l_nor3_1_0.C a_18315_4016# 0.02385f
C7690 sg13cmos5l_dfrbpq_1_13.RESET_B a_4972_2070# 0.18502f
C7691 sg13cmos5l_nand3_1_2.C a_25131_6179# 0.02482f
C7692 sg13cmos5l_xnor2_1_4.Y a_28570_5374# 0.03652f
C7693 sg13cmos5l_xnor2_1_8.Y sg13cmos5l_nor4_2_5.Y 0.02452f
C7694 sg13cmos5l_nor4_2_1.A a_18293_5026# 0.01071f
C7695 sg13cmos5l_nand3_1_1.A sg13cmos5l_nand3_1_1.Y 1.32955f
C7696 sg13cmos5l_dfrbpq_1_15.D sg13cmos5l_dfrbpq_1_13.RESET_B 0.2032f
C7697 sg13cmos5l_dfrbpq_1_3.D sg13cmos5l_dlygate4sd3_1_16.A 0.11604f
C7698 a_5532_5017# a_6359_4703# 0.50066f
C7699 sg13cmos5l_xnor2_1_9.A VPWR 0.90192f
C7700 a_20388_6172# a_20676_6593# 0.4806f
C7701 a_6972_8394# VPWR 0.0721f
C7702 sg13cmos5l_dfrbpq_1_12.Q VPWR 0.81146f
C7703 a_10308_5724# a_10596_5419# 0.4806f
C7704 sg13cmos5l_buf_1_0.X a_20524_6918# 0.23141f
C7705 a_17034_7680# a_17518_7947# 0.03282f
C7706 sg13cmos5l_dfrbpq_1_56.RESET_B a_16624_7922# 0.01408f
C7707 sg13cmos5l_nand3_1_2.A a_24326_6606# 0.03036f
C7708 sg13cmos5l_xnor2_1_8.Y sg13cmos5l_and2_1_3.A 0.08121f
C7709 a_18278_3582# VPWR 0.93112f
C7710 a_27952_7138# a_28362_7216# 0.1396f
C7711 a_2016_4209# VPWR 0.3041f
C7712 sg13cmos5l_buf_1_0.A a_4186_1596# 0.05971f
C7713 a_23368_7050# a_23368_6254# 0.01095f
C7714 sg13cmos5l_buf_8_3.A sg13cmos5l_nand3_1_3.B 0.08378f
C7715 sg13cmos5l_dfrbpq_1_37.D sg13cmos5l_buf_8_11.A 0.04725f
C7716 sg13cmos5l_dfrbpq_1_12.Q a_14148_3569# 0.02065f
C7717 a_28376_3898# a_28646_3898# 0.33585f
C7718 a_23368_6254# VPWR 0.15703f
C7719 sg13cmos5l_nor3_1_1.A a_14277_3155# 0.0221f
C7720 sg13cmos5l_dfrbpq_1_13.CLK a_4511_1140# 0.36133f
C7721 sg13cmos5l_buf_1_4.X a_25611_992# 0.55499f
C7722 sg13cmos5l_dfrbpq_1_21.RESET_B a_7749_7691# 0.13396f
C7723 sg13cmos5l_dfrbpq_1_57.RESET_B a_15127_8394# 0.03259f
C7724 a_3304_3230# a_3304_2514# 0.01275f
C7725 sg13cmos5l_nor3_1_1.C a_15756_1060# 0.02349f
C7726 sg13cmos5l_nand3_1_2.C sg13cmos5l_xnor2_1_4.Y 0.04507f
C7727 a_4186_1596# a_3905_1898# 0.33585f
C7728 a_4759_1596# a_4972_2070# 0.40419f
C7729 sg13cmos5l_nor4_2_5.C a_5375_7651# 0.01105f
C7730 a_21647_6529# a_21647_5483# 0.02404f
C7731 sg13cmos5l_nand3_1_1.Y sg13cmos5l_dlygate4sd3_1_50.A 0.01911f
C7732 sg13cmos5l_dlygate4sd3_1_39.X a_26410_7141# 0.02256f
C7733 a_27690_8728# VPWR 0.45241f
C7734 sg13cmos5l_dfrbpq_1_53.RESET_B a_11639_7727# 0.0194f
C7735 a_8133_2361# a_8235_2504# 0.66105f
C7736 sg13cmos5l_nor3_1_4.A sg13cmos5l_xnor2_1_5.A 0.01675f
C7737 sg13cmos5l_dlygate4sd3_1_11.X sg13cmos5l_xnor2_1_4.Y 3.62687f
C7738 sg13cmos5l_buf_8_4.A sg13cmos5l_dfrbpq_1_57.Q 0.01498f
C7739 a_20000_4742# VPWR 0.0766f
C7740 sg13cmos5l_nand3_1_1.A sg13cmos5l_dfrbpq_1_56.D 0.02687f
C7741 sg13cmos5l_dfrbpq_1_57.D sg13cmos5l_nand3_1_1.B 0.04091f
C7742 sg13cmos5l_nor4_2_9.D sg13cmos5l_dfrbpq_1_16.Q 0.0479f
C7743 sg13cmos5l_xor2_1_2.A a_13916_4192# 0.01192f
C7744 sg13cmos5l_nand3_1_2.C sg13cmos5l_dlygate4sd3_1_11.A 0.39787f
C7745 sg13cmos5l_xnor2_1_4.Y a_28376_3898# 0.05083f
C7746 sg13cmos5l_dlygate4sd3_1_22.X a_8853_1679# 0.0122f
C7747 sg13cmos5l_buf_1_1.X a_25287_1719# 0.55357f
C7748 sg13cmos5l_dlygate4sd3_1_11.X sg13cmos5l_dlygate4sd3_1_11.A 0.02064f
C7749 a_15687_8648# a_16490_8588# 0.15089f
C7750 sg13cmos5l_buf_1_4.A a_24170_1168# 0.01177f
C7751 a_24608_1919# a_24727_1596# 0.13494f
C7752 a_19142_870# a_19716_883# 0.36169f
C7753 sg13cmos5l_dfrbpq_1_37.D a_25478_5406# 0.02594f
C7754 a_18144_4695# VPWR 0.26376f
C7755 a_11567_1993# a_11473_1993# 0.32273f
C7756 sg13cmos5l_buf_1_11.A a_2166_8498# 0.01147f
C7757 sg13cmos5l_dfrbpq_1_53.RESET_B a_7332_7684# 0.03256f
C7758 sg13cmos5l_nor3_1_4.B sg13cmos5l_dfrbpq_1_38.Q 0.15216f
C7759 a_5511_4743# a_6359_4703# 0.11742f
C7760 sg13cmos5l_dlygate4sd3_1_11.A a_28376_3898# 0.50719f
C7761 sg13cmos5l_buf_1_4.X sg13cmos5l_dlygate4sd3_1_18.X 0.03128f
C7762 sg13cmos5l_dlygate4sd3_1_55.X sg13cmos5l_nand3_1_2.Y 0.05557f
C7763 sg13cmos5l_nand3_1_1.Y sg13cmos5l_dfrbpq_1_21.CLK 0.36725f
C7764 sg13cmos5l_buf_1_11.A en[4] 0.17153f
C7765 sg13cmos5l_dlygate4sd3_1_6.A a_18961_3971# 0.01267f
C7766 sg13cmos5l_dfrbpq_1_53.RESET_B a_25380_7684# 0.54851f
C7767 sg13cmos5l_nor3_1_4.A sg13cmos5l_buf_1_2.A 1.13345f
C7768 sg13cmos5l_dlygate4sd3_1_19.X a_4380_2346# 0.01623f
C7769 a_11567_5483# a_11473_5483# 0.32273f
C7770 a_24614_3582# VPWR 0.92797f
C7771 sg13cmos5l_dlygate4sd3_1_57.A sg13cmos5l_nor3_1_4.A 0.16536f
C7772 sg13cmos5l_dfrbpq_1_52.Q sg13cmos5l_nor3_1_4.A 0.21349f
C7773 a_4511_1140# a_4359_1088# 0.6663f
C7774 sg13cmos5l_dfrbpq_1_12.Q sg13cmos5l_nor3_1_1.A 0.06744f
C7775 a_27022_6435# VPWR 0.21355f
C7776 sg13cmos5l_dfrbpq_1_53.RESET_B a_25738_4624# 0.32062f
C7777 sg13cmos5l_and2_1_1.A a_19729_3505# 0.01739f
C7778 sg13cmos5l_nand3_1_2.A sg13cmos5l_dlygate4sd3_1_55.A 0.06547f
C7779 sg13cmos5l_nor3_1_0.A sg13cmos5l_dfrbpq_1_3.Q 1.19098f
C7780 sg13cmos5l_dfrbpq_1_21.RESET_B sg13cmos5l_dfrbpq_1_13.Q 0.02849f
C7781 sg13cmos5l_dfrbpq_1_58.D sg13cmos5l_buf_8_5.A 0.44893f
C7782 a_10022_870# VPWR 0.92718f
C7783 sg13cmos5l_nand3_1_1.B sg13cmos5l_buf_8_0.X 0.5444f
C7784 a_25764_5724# a_25764_4660# 0.01103f
C7785 a_18538_3112# a_18564_3148# 0.43042f
C7786 sg13cmos5l_buf_1_0.A a_4088_5410# 0.03816f
C7787 a_1985_7946# VPWR 0.24887f
C7788 a_11567_8507# a_11473_8507# 0.32273f
C7789 a_11824_1090# a_11473_947# 0.01017f
C7790 sg13cmos5l_dlygate4sd3_1_38.A sg13cmos5l_dlygate4sd3_1_53.A 0.01264f
C7791 a_10231_2346# a_10791_2600# 0.3087f
C7792 sg13cmos5l_nor4_2_5.C a_7046_8118# 0.30025f
C7793 a_7649_4922# sg13cmos5l_nand3_1_3.Y 0.01127f
C7794 sg13cmos5l_dfrbpq_1_2.CLK sg13cmos5l_buf_1_4.X 1.81972f
C7795 sg13cmos5l_dlygate4sd3_1_52.X a_10022_5406# 0.31227f
C7796 sg13cmos5l_dfrbpq_1_13.RESET_B a_8853_1679# 0.33276f
C7797 sg13cmos5l_dlygate4sd3_1_52.A sg13cmos5l_dfrbpq_1_57.Q 0.1657f
C7798 sg13cmos5l_nor3_1_4.B sg13cmos5l_nor3_1_4.C 0.38673f
C7799 sg13cmos5l_dfrbpq_1_15.D sg13cmos5l_xnor2_1_12.B 0.01531f
C7800 a_18478_8619# sg13cmos5l_dfrbpq_1_47.Q 0.03188f
C7801 a_24612_6172# a_25029_6179# 0.49014f
C7802 a_24326_6606# a_24900_6593# 0.36169f
C7803 a_13664_8562# VPWR 0.11434f
C7804 sg13cmos5l_buf_1_2.A a_17327_6995# 0.03558f
C7805 sg13cmos5l_xor2_1_2.A sg13cmos5l_dfrbpq_1_17.D 0.02565f
C7806 a_18086_2382# a_18660_2395# 0.36169f
C7807 sg13cmos5l_nor4_2_5.C sg13cmos5l_dlygate4sd3_1_31.X 0.03f
C7808 sg13cmos5l_dfrbpq_1_57.RESET_B sg13cmos5l_dfrbpq_1_57.CLK 1.71336f
C7809 sg13cmos5l_dlygate4sd3_1_55.A a_24326_6606# 0.03537f
C7810 sg13cmos5l_dfrbpq_1_57.RESET_B a_10943_7651# 0.06831f
C7811 a_20687_947# a_21354_1168# 0.13494f
C7812 a_5340_1993# VPWR 0.07212f
C7813 sg13cmos5l_dfrbpq_1_2.CLK a_19055_3971# 0.03005f
C7814 sg13cmos5l_buf_1_4.X a_17770_4117# 0.35612f
C7815 sg13cmos5l_nor4_2_5.Y sg13cmos5l_dfrbpq_1_58.RESET_B 0.02175f
C7816 sg13cmos5l_dlygate4sd3_1_22.X a_3799_834# 0.01672f
C7817 a_23958_3962# VPWR 0.21244f
C7818 a_20805_5385# a_20805_4667# 0.11208f
C7819 a_6453_4703# a_6359_4703# 0.87117f
C7820 sg13cmos5l_nor4_2_1.A a_21647_3971# 0.03532f
C7821 sg13cmos5l_nand3_1_2.A a_24780_5596# 0.02147f
C7822 a_18922_7644# a_18664_7766# 0.03673f
C7823 a_27963_6538# a_28936_5538# 0.0111f
C7824 a_2266_2350# VPWR 0.42728f
C7825 sg13cmos5l_xnor2_1_2.A sg13cmos5l_dfrbpq_1_55.Q 0.02977f
C7826 sg13cmos5l_buf_1_0.X a_23558_6918# 0.11769f
C7827 sg13cmos5l_dfrbpq_1_3.D sg13cmos5l_dfrbpq_1_2.Q 0.71593f
C7828 sg13cmos5l_buf_1_0.A a_8063_1603# 0.01005f
C7829 sg13cmos5l_dfrbpq_1_39.Q sg13cmos5l_buf_8_0.X 0.04942f
C7830 a_14632_8562# a_14816_8562# 0.11523f
C7831 sg13cmos5l_dfrbpq_1_55.RESET_B a_13574_2382# 0.1057f
C7832 a_1340_3144# sg13cmos5l_xnor2_1_6.A 0.02471f
C7833 sg13cmos5l_dfrbpq_1_12.D a_7744_3144# 0.05765f
C7834 a_13860_2700# a_14148_2395# 0.4806f
C7835 sg13cmos5l_dlygate4sd3_1_19.A a_4270_2382# 0.01115f
C7836 a_5392_3386# a_5135_3505# 0.40419f
C7837 sg13cmos5l_dfrbpq_1_53.RESET_B a_27280_4898# 0.17016f
C7838 sg13cmos5l_dfrbpq_1_58.RESET_B sg13cmos5l_and2_1_3.A 1.4759f
C7839 a_6391_8394# a_6951_8648# 0.3087f
C7840 sg13cmos5l_dfrbpq_1_32.CLK sg13cmos5l_nor3_1_2.C 0.18527f
C7841 sg13cmos5l_dfrbpq_1_21.CLK a_4293_3873# 0.38306f
C7842 sg13cmos5l_xnor2_1_2.B sg13cmos5l_buf_1_5.A 0.02528f
C7843 sg13cmos5l_dfrbpq_1_55.RESET_B a_10231_2346# 0.19897f
C7844 sg13cmos5l_dfrbpq_1_22.Q sg13cmos5l_dlygate4sd3_1_18.A 0.22229f
C7845 a_3876_8748# VPWR 0.07271f
C7846 a_26283_5528# a_26283_4667# 0.01307f
C7847 sg13cmos5l_nor3_1_4.B sg13cmos5l_xnor2_1_5.A 0.02061f
C7848 sg13cmos5l_buf_1_11.A a_2920_6956# 0.33665f
C7849 sg13cmos5l_dfrbpq_1_53.RESET_B sg13cmos5l_dfrbpq_1_53.CLK 0.50289f
C7850 a_28936_8562# VPWR 0.11965f
C7851 sg13cmos5l_xnor2_1_2.B a_16320_1671# 0.43031f
C7852 sg13cmos5l_dlygate4sd3_1_19.X a_3850_4117# 0.01382f
C7853 sg13cmos5l_buf_1_2.A a_17233_6995# 0.01268f
C7854 sg13cmos5l_dfrbpq_1_53.CLK a_26181_5385# 0.38899f
C7855 sg13cmos5l_dlygate4sd3_1_55.X sg13cmos5l_dlygate4sd3_1_9.X 0.60293f
C7856 sg13cmos5l_dfrbpq_1_13.RESET_B a_3799_834# 0.20877f
C7857 sg13cmos5l_nor4_2_9.D sg13cmos5l_dfrbpq_1_21.CLK 0.02027f
C7858 a_26639_8041# en[4] 0.03391f
C7859 a_14364_1993# a_15285_1679# 0.43042f
C7860 a_5855_5676# sg13cmos5l_dfrbpq_1_21.CLK 0.35272f
C7861 sg13cmos5l_nor4_2_4.D sg13cmos5l_dfrbpq_1_47.Q 0.0516f
C7862 sg13cmos5l_and2_1_1.A sg13cmos5l_dfrbpq_1_39.Q 0.30927f
C7863 a_28758_3962# VPWR 0.21115f
C7864 sg13cmos5l_dfrbpq_1_57.RESET_B sg13cmos5l_xnor2_1_2.A 0.2854f
C7865 sg13cmos5l_nor3_1_4.A a_16068_7236# 0.01044f
C7866 sg13cmos5l_buf_1_2.A sg13cmos5l_nor3_1_4.B 0.02619f
C7867 sg13cmos5l_dfrbpq_1_56.RESET_B a_16485_6897# 0.05466f
C7868 sg13cmos5l_buf_1_4.X a_26159_3505# 0.2043f
C7869 a_20907_5528# a_20907_4667# 0.01307f
C7870 sg13cmos5l_dlygate4sd3_1_57.A sg13cmos5l_nor3_1_4.B 0.26423f
C7871 sg13cmos5l_xnor2_1_2.A a_16078_5094# 0.0272f
C7872 a_10022_8430# VPWR 0.92902f
C7873 a_26853_6897# a_27022_6435# 0.01217f
C7874 sg13cmos5l_buf_1_0.X a_25103_6995# 0.19895f
C7875 a_21647_3971# a_21435_3514# 0.03213f
C7876 sg13cmos5l_dfrbpq_1_22.Q a_9558_3168# 0.01559f
C7877 a_10943_6139# a_11733_6215# 0.02241f
C7878 a_3680_5609# sg13cmos5l_dfrbpq_1_13.RESET_B 0.32233f
C7879 a_10791_6255# a_11639_6215# 0.11742f
C7880 sg13cmos5l_dfrbpq_1_2.D sg13cmos5l_nor4_2_1.D 0.33489f
C7881 a_24874_3112# a_24900_3148# 0.43042f
C7882 sg13cmos5l_dfrbpq_1_11.CLK a_10812_2346# 0.10373f
C7883 sg13cmos5l_buf_8_9.A sg13cmos5l_buf_8_5.A 0.0116f
C7884 sg13cmos5l_dlygate4sd3_1_6.X a_21174_1656# 0.19346f
C7885 sg13cmos5l_dfrbpq_1_53.RESET_B a_21023_7651# 0.01078f
C7886 sg13cmos5l_dlygate4sd3_1_21.X a_7822_2070# 0.01161f
C7887 a_26283_8552# en[4] 0.02451f
C7888 sg13cmos5l_nand3_1_2.A sg13cmos5l_xnor2_1_4.B 0.03164f
C7889 sg13cmos5l_xnor2_1_12.B a_5511_4743# 0.0101f
C7890 sg13cmos5l_dlygate4sd3_1_17.A a_26955_7040# 0.01313f
C7891 sg13cmos5l_buf_1_4.A a_14926_1059# 0.01262f
C7892 a_27023_5483# a_27023_5017# 0.03431f
C7893 sg13cmos5l_dfrbpq_1_46.D a_20192_7093# 0.01319f
C7894 sg13cmos5l_dfrbpq_1_0.D sg13cmos5l_dlygate4sd3_1_0.X 0.69188f
C7895 sg13cmos5l_xnor2_1_0.Y VPWR 2.57055f
C7896 sg13cmos5l_xnor2_1_12.Y a_2016_4695# 0.47075f
C7897 sg13cmos5l_dlygate4sd3_1_17.A sg13cmos5l_dlygate4sd3_1_40.A 0.02225f
C7898 a_3990_7704# VPWR 0.21474f
C7899 a_16068_7236# a_17327_6995# 0.01741f
C7900 sg13cmos5l_buf_1_0.X a_20102_5406# 0.11667f
C7901 sg13cmos5l_nand3_1_2.B a_24641_4922# 0.04463f
C7902 sg13cmos5l_dlygate4sd3_1_55.A a_24780_5596# 0.02779f
C7903 sg13cmos5l_buf_1_11.A VPWR 0.73111f
C7904 sg13cmos5l_dlygate4sd3_1_6.X sg13cmos5l_xnor2_1_10.Y 0.10321f
C7905 a_26128_6410# a_25777_6529# 0.01017f
C7906 a_25871_6529# a_26538_6168# 0.13494f
C7907 a_24526_4923# VPWR 0.21473f
C7908 sg13cmos5l_buf_8_11.A sg13cmos5l_nor4_2_7.B 0.13312f
C7909 a_5802_3144# VPWR 0.45528f
C7910 a_8759_1679# VPWR 0.92889f
C7911 sg13cmos5l_dlygate4sd3_1_22.X a_7799_1261# 0.02331f
C7912 sg13cmos5l_dfrbpq_1_58.RESET_B a_5356_5406# 0.17014f
C7913 a_5802_4192# a_6272_4069# 0.03469f
C7914 sg13cmos5l_xnor2_1_6.Y VPWR 0.70122f
C7915 sg13cmos5l_xnor2_1_4.B a_24326_6606# 0.0625f
C7916 sg13cmos5l_dfrbpq_1_37.D a_25052_8728# 0.01342f
C7917 sg13cmos5l_dlygate4sd3_1_31.X a_1480_6254# 0.01329f
C7918 sg13cmos5l_and2_1_1.X osc 0.02292f
C7919 sg13cmos5l_buf_1_0.X a_20102_6606# 0.12754f
C7920 sg13cmos5l_dfrbpq_1_7.Q osc 0.02737f
C7921 sg13cmos5l_buf_1_1.X sg13cmos5l_nor4_2_0.C 0.56892f
C7922 sg13cmos5l_dfrbpq_1_56.RESET_B a_16042_7141# 0.34084f
C7923 sg13cmos5l_dfrbpq_1_13.RESET_B a_7430_2382# 0.08963f
C7924 sg13cmos5l_nor3_1_0.B a_24874_3112# 0.03134f
C7925 a_10812_3505# sg13cmos5l_dfrbpq_1_11.CLK 0.07763f
C7926 a_11733_7727# VPWR 0.09675f
C7927 sg13cmos5l_dfrbpq_1_22.D a_11639_2773# 0.29544f
C7928 sg13cmos5l_dlygate4sd3_1_15.A a_26159_3505# 0.01023f
C7929 sg13cmos5l_dfrbpq_1_57.RESET_B a_10231_7644# 0.28621f
C7930 a_11733_6215# sg13cmos5l_dlygate4sd3_1_52.X 0.01484f
C7931 sg13cmos5l_nor4_2_0.C a_24394_2605# 0.0279f
C7932 sg13cmos5l_xnor2_1_2.A sg13cmos5l_dfrbpq_1_22.D 0.61333f
C7933 a_24837_2361# a_24940_2070# 0.01063f
C7934 a_7103_8700# a_6951_8648# 0.6663f
C7935 a_17032_908# VPWR 0.28987f
C7936 a_7306_7648# VPWR 0.09646f
C7937 sg13cmos5l_dlygate4sd3_1_17.A sg13cmos5l_dlygate4sd3_1_17.X 0.07081f
C7938 a_8714_1912# a_8759_1679# 0.36169f
C7939 a_15008_8605# sg13cmos5l_dlygate4sd3_1_57.A 0.14388f
C7940 sg13cmos5l_xnor2_1_8.Y a_6180_6172# 0.01285f
C7941 a_18862_2070# a_19103_1603# 0.01058f
C7942 sg13cmos5l_dlygate4sd3_1_6.X a_20388_8748# 0.03573f
C7943 sg13cmos5l_dfrbpq_1_55.Q a_14742_3962# 0.01351f
C7944 sg13cmos5l_xnor2_1_4.A a_25764_4660# 0.02284f
C7945 a_25354_7648# VPWR 0.09576f
C7946 sg13cmos5l_dfrbpq_1_57.D sg13cmos5l_buf_8_0.X 0.01042f
C7947 sg13cmos5l_dlygate4sd3_1_4.X a_28646_874# 0.01267f
C7948 a_3488_7766# VPWR 0.06454f
C7949 sg13cmos5l_buf_1_5.A sg13cmos5l_and2_1_3.A 0.13926f
C7950 sg13cmos5l_buf_1_0.X a_21647_5483# 0.19888f
C7951 a_16068_7236# a_17233_6995# 0.4858f
C7952 a_16587_7040# a_16356_6931# 0.15089f
C7953 a_17327_6995# a_17994_7216# 0.13494f
C7954 sg13cmos5l_buf_1_0.A a_25287_1719# 0.01688f
C7955 a_19888_2602# VPWR 0.22366f
C7956 a_6391_3858# VPWR 0.16725f
C7957 sg13cmos5l_xnor2_1_2.B a_15850_3862# 0.05106f
C7958 sg13cmos5l_dfrbpq_1_15.D a_2266_6132# 0.02882f
C7959 a_1784_874# sg13cmos5l_xnor2_1_6.Y 0.07809f
C7960 sg13cmos5l_xnor2_1_1.Y VPWR 0.48664f
C7961 a_4395_8552# a_5135_8507# 0.3087f
C7962 sg13cmos5l_buf_1_5.A sg13cmos5l_dlygate4sd3_1_28.X 0.38099f
C7963 sg13cmos5l_dfrbpq_1_13.RESET_B a_7799_1261# 0.13058f
C7964 sg13cmos5l_nor3_1_4.B a_16068_7236# 0.02499f
C7965 a_9446_3144# VPWR 0.24507f
C7966 sg13cmos5l_dfrbpq_1_35.Q sg13cmos5l_dfrbpq_1_57.D 0.02733f
C7967 a_21647_8507# en[3] 0.01026f
C7968 sg13cmos5l_xnor2_1_2.Y VPWR 0.59247f
C7969 sg13cmos5l_nor4_2_0.D a_24806_870# 0.3022f
C7970 a_6972_3858# a_7799_4285# 0.50066f
C7971 sg13cmos5l_xnor2_1_3.B sg13cmos5l_buf_1_4.X 0.03786f
C7972 sg13cmos5l_buf_8_3.A a_10812_3505# 0.05595f
C7973 sg13cmos5l_dlygate4sd3_1_10.A a_23368_3230# 0.0727f
C7974 sg13cmos5l_xnor2_1_13.A a_2165_5026# 0.02331f
C7975 sg13cmos5l_xnor2_1_4.B a_24900_6593# 0.01013f
C7976 a_10112_4943# a_10444_5094# 0.1396f
C7977 sg13cmos5l_dlygate4sd3_1_51.A a_22314_4656# 0.01765f
C7978 sg13cmos5l_dlygate4sd3_1_4.X a_28524_3410# 0.01345f
C7979 sg13cmos5l_dfrbpq_1_23.Q sg13cmos5l_nand3_1_3.Y 0.02042f
C7980 sg13cmos5l_dfrbpq_1_55.RESET_B a_16566_3168# 0.01206f
C7981 sg13cmos5l_dfrbpq_1_11.CLK a_14277_3155# 0.35972f
C7982 sg13cmos5l_dfrbpq_1_37.D a_24363_7040# 0.03166f
C7983 sg13cmos5l_xnor2_1_0.A a_15756_1060# 0.13515f
C7984 sg13cmos5l_dlygate4sd3_1_55.A sg13cmos5l_xnor2_1_4.B 0.0838f
C7985 a_3680_2557# a_3799_2346# 0.13494f
C7986 sg13cmos5l_nor3_1_2.Y a_1623_7216# 0.0277f
C7987 a_2016_7233# sg13cmos5l_dfrbpq_1_15.D 0.22441f
C7988 sg13cmos5l_nor4_2_0.B a_23660_1168# 0.10324f
C7989 sg13cmos5l_buf_8_4.A sg13cmos5l_buf_8_5.A 0.18393f
C7990 sg13cmos5l_nor4_2_7.D en[3] 0.64043f
C7991 sg13cmos5l_dfrbpq_1_15.D sg13cmos5l_xnor2_1_5.Y 0.02055f
C7992 a_21174_1656# a_21062_1632# 0.67711f
C7993 sg13cmos5l_nand3_1_2.C a_24641_4922# 0.01129f
C7994 a_8591_8041# VPWR 0.17284f
C7995 sg13cmos5l_nor3_1_1.Y a_8853_1679# 0.02449f
C7996 sg13cmos5l_buf_1_4.A a_26830_2571# 0.04565f
C7997 a_26639_8041# VPWR 0.1735f
C7998 sg13cmos5l_nor3_1_1.A a_17032_908# 0.01571f
C7999 a_9915_3898# VPWR 1.15585f
C8000 sg13cmos5l_dfrbpq_1_12.D a_10022_2070# 0.32186f
C8001 sg13cmos5l_dlygate4sd3_1_22.A a_4012_870# 0.01054f
C8002 sg13cmos5l_and2_1_1.X sg13cmos5l_buf_1_1.X 0.01866f
C8003 sg13cmos5l_dfrbpq_1_42.Q VPWR 0.41428f
C8004 a_15119_3505# VPWR 0.17644f
C8005 a_23368_2514# a_23552_2514# 0.11523f
C8006 a_23661_2428# sg13cmos5l_nor4_2_0.B 0.03366f
C8007 a_4293_8409# a_5041_8507# 0.01058f
C8008 sg13cmos5l_dfrbpq_1_21.RESET_B sg13cmos5l_dfrbpq_1_13.RESET_B 0.7966f
C8009 sg13cmos5l_dfrbpq_1_57.CLK a_10725_5385# 0.39741f
C8010 a_9281_4084# a_9562_3862# 0.33585f
C8011 sg13cmos5l_dlygate4sd3_1_47.A en[3] 6.85016f
C8012 sg13cmos5l_nor4_2_0.D a_26608_1090# 0.01369f
C8013 a_26283_4667# VPWR 0.20731f
C8014 a_26538_6168# a_27022_6435# 0.03282f
C8015 sg13cmos5l_dfrbpq_1_16.Q a_5802_3144# 0.13324f
C8016 a_20311_7644# VPWR 0.17139f
C8017 a_20666_2680# sg13cmos5l_nand3_1_0.A 0.37716f
C8018 sg13cmos5l_dfrbpq_1_12.Q sg13cmos5l_dfrbpq_1_11.CLK 0.57957f
C8019 sg13cmos5l_nor3_1_1.A sg13cmos5l_xnor2_1_2.Y 0.17237f
C8020 sg13cmos5l_dfrbpq_1_21.Q sg13cmos5l_dfrbpq_1_13.Q 1.51894f
C8021 a_14379_3155# a_15376_3386# 0.07014f
C8022 sg13cmos5l_dfrbpq_1_55.Q a_15025_2459# 0.01757f
C8023 sg13cmos5l_nor3_1_1.Y a_15756_1060# 0.02809f
C8024 sg13cmos5l_xnor2_1_0.Y a_13783_1596# 0.01494f
C8025 sg13cmos5l_xnor2_1_5.Y a_5532_5017# 0.01063f
C8026 a_26283_8552# VPWR 0.20568f
C8027 sg13cmos5l_xnor2_1_2.A sg13cmos5l_nand3_1_1.B 0.0754f
C8028 a_5207_2773# sg13cmos5l_dfrbpq_1_13.CLK 0.01046f
C8029 sg13cmos5l_nand3_1_2.B sg13cmos5l_nor3_1_0.C 0.06921f
C8030 sg13cmos5l_dfrbpq_1_37.D a_24881_8484# 0.11059f
C8031 a_17800_2514# a_17984_2514# 0.11523f
C8032 a_26229_1679# VPWR 0.09479f
C8033 a_10308_7236# a_11567_6995# 0.01741f
C8034 a_2266_1596# VPWR 0.40007f
C8035 sg13cmos5l_xnor2_1_3.A a_18479_874# 0.01068f
C8036 sg13cmos5l_dlygate4sd3_1_52.A sg13cmos5l_buf_8_5.A 0.02015f
C8037 a_2259_7216# VPWR 0.01044f
C8038 sg13cmos5l_buf_1_1.X a_19428_1188# 0.48428f
C8039 sg13cmos5l_xnor2_1_6.B a_8776_908# 0.06688f
C8040 a_10308_1636# a_11567_1993# 0.01741f
C8041 sg13cmos5l_dfrbpq_1_37.D sg13cmos5l_nand3_1_2.Y 0.01551f
C8042 a_808_8562# en[0] 0.06311f
C8043 sg13cmos5l_buf_1_2.A sg13cmos5l_dfrbpq_1_59.Q 0.03148f
C8044 sg13cmos5l_buf_1_1.X a_24837_2361# 0.05959f
C8045 sg13cmos5l_dfrbpq_1_46.CLK a_20871_7136# 0.05027f
C8046 sg13cmos5l_xnor2_1_4.A sg13cmos5l_dfrbpq_1_7.Q 0.44337f
C8047 sg13cmos5l_dfrbpq_1_46.D a_23818_7141# 0.01452f
C8048 sg13cmos5l_nor4_2_4.D sg13cmos5l_dfrbpq_1_53.RESET_B 0.03637f
C8049 sg13cmos5l_dfrbpq_1_58.RESET_B a_6180_6172# 0.54775f
C8050 a_20080_3386# VPWR 0.18836f
C8051 a_27690_8728# a_28174_8619# 0.03282f
C8052 a_5703_5624# a_5663_4627# 0.01029f
C8053 a_3680_1045# a_3799_834# 0.13494f
C8054 sg13cmos5l_buf_8_3.A sg13cmos5l_dfrbpq_1_12.Q 0.03369f
C8055 sg13cmos5l_nor4_2_0.B a_24420_2700# 0.01009f
C8056 a_24394_2605# a_24837_2361# 0.02241f
C8057 sg13cmos5l_nand3_1_3.Y VPWR 1.24798f
C8058 a_20388_4660# a_21647_5017# 0.01741f
C8059 a_28174_4923# VPWR 0.21369f
C8060 sg13cmos5l_nor4_2_0.D sg13cmos5l_dfrbpq_1_1.Q 0.09403f
C8061 sg13cmos5l_xnor2_1_12.B sg13cmos5l_xnor2_1_12.Y 0.1459f
C8062 sg13cmos5l_nor3_1_1.A a_15119_3505# 0.01066f
C8063 sg13cmos5l_dfrbpq_1_12.D a_1169_3502# 0.10356f
C8064 sg13cmos5l_dlygate4sd3_1_11.A a_27963_6538# 0.02137f
C8065 a_20871_7767# VPWR 0.20783f
C8066 a_7893_1028# VPWR 0.09572f
C8067 a_24806_870# a_25092_1188# 0.50066f
C8068 sg13cmos5l_dlygate4sd3_1_21.A a_3488_1002# 0.0157f
C8069 a_10827_8552# a_10596_8443# 0.15089f
C8070 a_27214_1899# a_27329_1898# 0.67711f
C8071 a_14343_1719# a_13563_874# 0.01094f
C8072 a_10308_8748# a_11473_8507# 0.4858f
C8073 a_10812_5017# a_11594_4936# 0.4806f
C8074 sg13cmos5l_buf_1_11.A sg13cmos5l_dlygate4sd3_1_34.A 0.02039f
C8075 a_10827_992# a_11567_947# 0.3087f
C8076 sg13cmos5l_dlygate4sd3_1_38.A a_7535_6995# 0.01749f
C8077 sg13cmos5l_buf_1_4.A sg13cmos5l_nand3_1_2.C 0.02103f
C8078 a_5164_5094# VPWR 0.1877f
C8079 a_7430_2382# a_8004_2395# 0.36169f
C8080 sg13cmos5l_nor3_1_0.B a_23872_1168# 0.01946f
C8081 sg13cmos5l_dfrbpq_1_15.D sg13cmos5l_dfrbpq_1_23.D 0.6641f
C8082 sg13cmos5l_dlygate4sd3_1_39.A sg13cmos5l_nand3_1_2.C 0.01797f
C8083 sg13cmos5l_buf_1_4.A sg13cmos5l_dlygate4sd3_1_11.X 0.02494f
C8084 sg13cmos5l_dfrbpq_1_13.RESET_B a_6261_1679# 0.35059f
C8085 a_18144_4695# a_18293_5026# 0.3658f
C8086 a_10725_6897# a_11473_6995# 0.01058f
C8087 a_11567_6995# a_12234_7216# 0.13494f
C8088 sg13cmos5l_xnor2_1_3.B a_18618_1168# 0.01298f
C8089 sg13cmos5l_dlygate4sd3_1_53.A sg13cmos5l_and2_1_3.A 0.04733f
C8090 sg13cmos5l_dlygate4sd3_1_11.X a_28936_4742# 0.01101f
C8091 sg13cmos5l_xnor2_1_0.Y a_1784_3185# 0.02909f
C8092 sg13cmos5l_dlygate4sd3_1_28.X a_10308_7236# 0.01723f
C8093 a_10282_7141# a_10725_6897# 0.02241f
C8094 a_20907_4016# VPWR 0.20865f
C8095 sg13cmos5l_dfrbpq_1_2.CLK a_18564_3148# 0.0978f
C8096 sg13cmos5l_buf_1_4.X sg13cmos5l_dfrbpq_1_55.D 0.97034f
C8097 sg13cmos5l_nor3_1_0.C sg13cmos5l_nand3_1_0.Y 0.01097f
C8098 a_26945_2572# VPWR 0.28756f
C8099 a_19402_1093# VPWR 0.09579f
C8100 a_18843_5410# sg13cmos5l_nor3_1_0.C 0.01355f
C8101 sg13cmos5l_dlygate4sd3_1_6.X sg13cmos5l_dfrbpq_1_0.CLK 0.0981f
C8102 a_25419_3155# VPWR 0.20957f
C8103 sg13cmos5l_dfrbpq_1_46.D a_23844_7236# 0.0435f
C8104 sg13cmos5l_dfrbpq_1_21.RESET_B sg13cmos5l_xnor2_1_12.B 0.03363f
C8105 sg13cmos5l_xor2_1_2.A a_13642_5374# 0.02215f
C8106 sg13cmos5l_dlygate4sd3_1_17.X a_25478_5094# 0.29706f
C8107 sg13cmos5l_dfrbpq_1_58.RESET_B a_6699_6179# 0.62262f
C8108 sg13cmos5l_buf_1_1.X a_18972_1993# 0.51061f
C8109 sg13cmos5l_xnor2_1_6.Y a_6972_834# 0.02699f
C8110 a_27790_7947# VPWR 0.21534f
C8111 a_18951_1719# a_19799_1679# 0.11742f
C8112 a_19103_1603# a_19893_1679# 0.02241f
C8113 sg13cmos5l_and2_1_1.A a_20864_3230# 0.05058f
C8114 sg13cmos5l_dfrbpq_1_17.D a_11488_4192# 0.01709f
C8115 a_20907_4667# a_21647_5017# 0.3087f
C8116 a_13574_2382# a_14277_2361# 0.02453f
C8117 sg13cmos5l_buf_1_0.A sg13cmos5l_nor4_2_0.C 0.01798f
C8118 sg13cmos5l_dfrbpq_1_32.CLK a_6951_8648# 0.03279f
C8119 sg13cmos5l_nand3_1_2.C sg13cmos5l_nor3_1_0.C 0.02111f
C8120 sg13cmos5l_dfrbpq_1_23.D a_5532_5017# 0.01253f
C8121 sg13cmos5l_dlygate4sd3_1_21.X a_8133_2361# 0.01362f
C8122 a_18852_3569# a_19083_3155# 0.15089f
C8123 sg13cmos5l_dlygate4sd3_1_17.X sg13cmos5l_buf_1_4.X 0.01077f
C8124 sg13cmos5l_dfrbpq_1_0.CLK osc 1.4337f
C8125 sg13cmos5l_dlygate4sd3_1_11.X sg13cmos5l_nor3_1_0.C 0.35033f
C8126 sg13cmos5l_dfrbpq_1_53.CLK a_26436_7236# 0.15115f
C8127 sg13cmos5l_buf_1_0.A sg13cmos5l_dfrbpq_1_13.Q 0.03003f
C8128 a_10943_2652# a_10812_2346# 0.49014f
C8129 sg13cmos5l_dfrbpq_1_46.D a_18843_5410# 0.04569f
C8130 sg13cmos5l_nand3_1_0.A sg13cmos5l_xnor2_1_1.B 0.065f
C8131 a_5340_1993# a_6122_1912# 0.4806f
C8132 a_10791_4743# a_10943_4627# 0.66105f
C8133 sg13cmos5l_buf_1_0.X a_23712_6207# 0.03035f
C8134 sg13cmos5l_xnor2_1_5.Y a_17100_2572# 0.22668f
C8135 sg13cmos5l_dlygate4sd3_1_39.X a_25478_8430# 0.01887f
C8136 sg13cmos5l_dfrbpq_1_37.D sg13cmos5l_dlygate4sd3_1_9.X 0.52303f
C8137 sg13cmos5l_dlygate4sd3_1_38.A sg13cmos5l_nor4_2_5.B 0.44052f
C8138 sg13cmos5l_xnor2_1_0.Y sg13cmos5l_xnor2_1_6.A 0.20437f
C8139 sg13cmos5l_dlygate4sd3_1_51.A sg13cmos5l_buf_1_4.X 0.50991f
C8140 sg13cmos5l_xnor2_1_13.Y sg13cmos5l_dfrbpq_1_15.D 0.65486f
C8141 sg13cmos5l_nor3_1_0.B sg13cmos5l_dfrbpq_1_3.D 3.70156f
C8142 sg13cmos5l_dfrbpq_1_2.D VPWR 1.29729f
C8143 a_4359_2600# VPWR 0.27622f
C8144 a_15839_8700# a_16629_8588# 0.02241f
C8145 a_25308_1993# VPWR 0.07322f
C8146 sg13cmos5l_dfrbpq_1_46.CLK a_23844_7236# 0.07066f
C8147 sg13cmos5l_nor4_2_7.B a_24363_7040# 0.01952f
C8148 a_20388_5724# sg13cmos5l_nor3_1_0.C 0.01542f
C8149 sg13cmos5l_dfrbpq_1_58.RESET_B a_9176_6209# 0.04239f
C8150 a_3876_4212# a_3876_3148# 0.01103f
C8151 a_18213_3873# a_18084_3907# 0.01562f
C8152 sg13cmos5l_dfrbpq_1_15.D sg13cmos5l_nand3_1_1.Y 1.30161f
C8153 a_5207_1261# a_5162_1028# 0.36169f
C8154 sg13cmos5l_dlygate4sd3_1_4.X sg13cmos5l_dfrbpq_1_0.D 0.39859f
C8155 sg13cmos5l_nor4_2_5.D sg13cmos5l_nor4_2_9.D 0.49202f
C8156 sg13cmos5l_and2_1_1.X a_24132_6931# 0.01183f
C8157 sg13cmos5l_buf_1_1.X a_19823_3505# 0.27948f
C8158 sg13cmos5l_dfrbpq_1_21.RESET_B sg13cmos5l_dfrbpq_1_53.RESET_B 0.34175f
C8159 sg13cmos5l_dfrbpq_1_53.CLK en[3] 0.02045f
C8160 sg13cmos5l_dfrbpq_1_16.Q sg13cmos5l_nand3_1_3.Y 0.01314f
C8161 sg13cmos5l_dfrbpq_1_21.CLK a_6391_3858# 0.01825f
C8162 sg13cmos5l_dfrbpq_1_57.RESET_B sg13cmos5l_xnor2_1_2.B 0.25457f
C8163 sg13cmos5l_dfrbpq_1_55.RESET_B a_10791_2600# 0.55521f
C8164 sg13cmos5l_buf_1_5.A a_18572_5370# 0.32747f
C8165 sg13cmos5l_dfrbpq_1_23.D a_5511_4743# 0.01104f
C8166 sg13cmos5l_dfrbpq_1_32.CLK sg13cmos5l_buf_8_4.A 0.21163f
C8167 sg13cmos5l_dlygate4sd3_1_21.X a_7232_1919# 0.04234f
C8168 a_27963_6538# a_27784_6254# 0.01093f
C8169 a_25509_849# a_26257_947# 0.01058f
C8170 a_26608_1090# a_27018_1168# 0.1396f
C8171 a_18010_8398# VPWR 0.32639f
C8172 sg13cmos5l_buf_1_0.A a_21174_1656# 0.01059f
C8173 a_15340_8430# VPWR 0.18665f
C8174 sg13cmos5l_dlygate4sd3_1_9.A a_27713_4084# 0.01218f
C8175 sg13cmos5l_xnor2_1_0.Y sg13cmos5l_dlygate4sd3_1_19.A 0.01786f
C8176 a_25738_8653# sg13cmos5l_dfrbpq_1_53.RESET_B 0.32061f
C8177 a_15786_2680# VPWR 0.48971f
C8178 a_24881_8484# sg13cmos5l_dlygate4sd3_1_4.X 0.03594f
C8179 sg13cmos5l_dfrbpq_1_2.CLK sg13cmos5l_nor3_1_0.B 0.02852f
C8180 sg13cmos5l_xnor2_1_2.A sg13cmos5l_dfrbpq_1_57.D 0.03034f
C8181 sg13cmos5l_xnor2_1_0.Y sg13cmos5l_dfrbpq_1_11.CLK 0.10117f
C8182 a_25439_1603# a_26229_1679# 0.02241f
C8183 a_25287_1719# a_26135_1679# 0.11742f
C8184 sg13cmos5l_nand3_1_1.Y a_5532_5017# 0.02457f
C8185 a_6167_1679# VPWR 0.92698f
C8186 sg13cmos5l_dfrbpq_1_53.RESET_B a_25764_5724# 0.51004f
C8187 sg13cmos5l_dlygate4sd3_1_22.X a_6391_834# 0.02141f
C8188 a_1302_1656# a_1870_1899# 0.03281f
C8189 en[4] VGND 21.65525f
C8190 VPWR VGND 78.90397f
C8191 a_28646_874# VGND 0.20407f
C8192 a_28256_1002# VGND 0.04521f ; **FLOATING
C8193 a_26770_870# VGND 0.67187f
C8194 a_27798_938# VGND 0.14379f
C8195 a_26257_947# VGND 0.20752f
C8196 a_25318_883# VGND 0.86946f
C8197 a_25380_883# VGND 0.90612f
C8198 a_26553_1185# VGND 0.07696f
C8199 a_25449_1261# VGND 0.23109f
C8200 a_25092_1188# VGND 0.7541f
C8201 a_24806_870# VGND 0.32072f
C8202 a_24704_1002# VGND 0.04053f ; **FLOATING
C8203 a_24170_1168# VGND 0.62979f
C8204 a_23872_1168# VGND 0.545f
C8205 a_23660_1168# VGND 0.34805f
C8206 a_23368_1002# VGND 0.16588f ; **FLOATING
C8207 a_21728_1002# VGND 0.04572f ; **FLOATING
C8208 a_20593_947# VGND 0.11471f
C8209 a_19654_883# VGND 0.86946f
C8210 a_19716_883# VGND 1.02205f
C8211 a_20889_1185# VGND 0.37598f
C8212 a_21934_1059# VGND 0.28504f
C8213 a_18900_916# VGND 0.11297f
C8214 a_18479_874# VGND 0.93298f
C8215 a_18104_878# VGND 0.91967f
C8216 a_18002_878# VGND 0.03854f
C8217 a_19428_1188# VGND 0.15196f
C8218 a_19142_870# VGND 1.53598f
C8219 a_16928_1002# VGND 0.04325f ; **FLOATING
C8220 a_16212_916# VGND 1.82859f
C8221 a_15791_874# VGND 0.22191f
C8222 a_16643_1168# VGND 0.14517f
C8223 a_16541_1168# VGND 0.05477f
C8224 a_15930_1168# VGND 0.84226f
C8225 sg13cmos5l_nand3_1_0.B VGND 0.07686f
C8226 a_15322_838# VGND 0.13102f
C8227 a_13472_1002# VGND 0.04235f ; **FLOATING
C8228 a_13288_1002# VGND 0.15123f ; **FLOATING
C8229 a_11986_870# VGND 0.51972f
C8230 a_14926_1059# VGND 0.23539f
C8231 a_11473_947# VGND 0.11471f
C8232 a_10534_883# VGND 0.19556f
C8233 a_10596_883# VGND 0.23222f
C8234 a_11769_1185# VGND 0.09258f
C8235 a_10665_1261# VGND 1.61903f
C8236 a_10022_870# VGND 1.29983f
C8237 a_9446_874# VGND 0.17716f
C8238 a_8150_883# VGND 1.96974f
C8239 a_6862_870# VGND 0.20662f
C8240 a_6698_870# VGND 0.51972f
C8241 a_7754_1028# VGND 1.12038f
C8242 a_8776_908# VGND 0.26662f
C8243 a_7995_1261# VGND 0.08237f
C8244 a_7799_1261# VGND 0.296f
C8245 a_5954_870# VGND 0.56845f
C8246 a_4270_870# VGND 0.20779f
C8247 a_4106_870# VGND 0.70496f
C8248 a_5162_1028# VGND 0.03666f
C8249 a_6272_1045# VGND 0.15305f
C8250 a_5403_1261# VGND 0.98594f
C8251 a_5207_1261# VGND 1.86717f
C8252 a_4380_834# VGND 0.0412f
C8253 a_4270_1185# VGND 0.46272f
C8254 a_3488_1002# VGND 0.04866f ; **FLOATING
C8255 a_3304_1002# VGND 0.16095f ; **FLOATING
C8256 a_1301_874# VGND 0.32133f
C8257 a_2054_874# VGND 0.1375f
C8258 a_808_1002# VGND 0.12491f ; **FLOATING
C8259 a_26331_1679# VGND 0.02413f
C8260 a_28262_1632# VGND 0.3554f
C8261 a_27329_1898# VGND 0.16259f
C8262 a_27610_1596# VGND 0.50929f
C8263 a_26135_1679# VGND 0.5151f
C8264 a_26486_2057# VGND 2.15083f
C8265 a_26090_1912# VGND 0.98064f
C8266 a_25198_2070# VGND 0.2799f
C8267 a_25034_2070# VGND 0.71794f
C8268 a_24416_1718# VGND 0.04372f ; **FLOATING
C8269 a_23846_1632# VGND 0.36321f
C8270 a_19995_1679# VGND 0.26796f
C8271 sg13cmos5l_dfrbpq_1_2.Q VGND 0.22334f
C8272 a_21857_1898# VGND 0.18813f
C8273 a_21062_1632# VGND 0.43299f
C8274 a_22138_1596# VGND 0.37576f
C8275 a_20546_2070# VGND 1.20723f
C8276 a_18862_1755# VGND 0.09086f
C8277 a_19799_1679# VGND 0.22747f
C8278 a_20150_2057# VGND 0.8679f
C8279 a_19754_1912# VGND 0.90456f
C8280 a_18862_2070# VGND 0.36166f
C8281 a_18698_2070# VGND 0.76531f
C8282 a_18080_1718# VGND 0.04326f ; **FLOATING
C8283 a_17715_1632# VGND 0.95152f
C8284 a_15387_1679# VGND 0.02051f
C8285 a_18972_1993# VGND 0.15141f
C8286 a_17621_2002# VGND 0.76811f
C8287 a_17472_1671# VGND 0.3833f
C8288 a_17435_1980# VGND 0.38445f
C8289 a_16469_2002# VGND 0.31209f
C8290 a_16283_1980# VGND 0.05347f
C8291 a_15938_2070# VGND 0.2496f
C8292 a_14254_1755# VGND 0.09532f
C8293 a_15191_1679# VGND 0.47928f
C8294 a_15542_2057# VGND 0.9777f
C8295 a_15146_1912# VGND 1.01436f
C8296 a_14254_2070# VGND 0.35808f
C8297 a_13472_1718# VGND 0.0432f ; **FLOATING
C8298 a_13288_1718# VGND 0.14861f ; **FLOATING
C8299 a_10665_1679# VGND 0.86812f
C8300 a_11473_1993# VGND 0.46382f
C8301 a_10596_2057# VGND 0.13193f
C8302 a_9920_1718# VGND 0.03566f ; **FLOATING
C8303 a_9736_1718# VGND 0.07509f ; **FLOATING
C8304 a_10308_1636# VGND 0.74855f
C8305 a_10116_2070# VGND 0.05387f
C8306 a_10022_2070# VGND 0.47884f
C8307 a_9506_2070# VGND 0.38248f
C8308 a_8759_1679# VGND 1.89378f
C8309 a_9110_2057# VGND 0.9399f
C8310 a_8714_1912# VGND 0.97656f
C8311 a_7822_2070# VGND 0.20533f
C8312 a_7658_2070# VGND 0.51972f
C8313 a_6914_2070# VGND 1.10065f
C8314 a_6167_1679# VGND 0.29488f
C8315 a_6518_2057# VGND 0.88876f
C8316 a_6122_1912# VGND 0.92542f
C8317 a_5230_2070# VGND 0.68219f
C8318 a_5340_1993# VGND 0.04803f
C8319 a_4640_1919# VGND 0.25795f
C8320 a_4186_1596# VGND 0.62718f
C8321 a_3790_1899# VGND 0.17679f
C8322 a_800_1718# VGND 0.08012f ; **FLOATING
C8323 sg13cmos5l_dlygate4sd3_1_20.A VGND 0.21951f
C8324 a_2266_1596# VGND 0.22015f
C8325 a_1302_1656# VGND 0.27761f
C8326 a_920_1673# VGND 0.1442f
C8327 a_28662_2398# VGND 0.08564f
C8328 a_26098_2382# VGND 0.56974f
C8329 a_28532_2680# VGND 0.92381f
C8330 a_27226_2350# VGND 0.57561f
C8331 a_25585_2459# VGND 0.33338f
C8332 a_24646_2395# VGND 0.91357f
C8333 a_24708_2395# VGND 0.95023f
C8334 a_25881_2697# VGND 0.0911f
C8335 a_24228_2382# VGND 1.20746f
C8336 a_23755_2428# VGND 1.77812f
C8337 a_24134_2382# VGND 0.39852f
C8338 a_23552_2514# VGND 0.04167f ; **FLOATING
C8339 a_23368_2514# VGND 0.1464f ; **FLOATING
C8340 a_22049_2572# VGND 0.12765f
C8341 a_20972_2680# VGND 0.02626f
C8342 sg13cmos5l_nand3_1_0.A VGND 0.07754f
C8343 a_20666_2680# VGND 0.33629f
C8344 a_19537_2459# VGND 0.48886f
C8345 a_18598_2395# VGND 0.07178f
C8346 a_18660_2395# VGND 0.10844f
C8347 a_18180_2382# VGND 1.2075f
C8348 a_18729_2773# VGND 0.8679f
C8349 a_18086_2382# VGND 0.7481f
C8350 a_17984_2514# VGND 0.03519f ; **FLOATING
C8351 a_17800_2514# VGND 0.07973f ; **FLOATING
C8352 a_17135_2386# VGND 0.30867f
C8353 a_17274_2680# VGND 0.07287f
C8354 a_16385_2572# VGND 0.13449f
C8355 a_15025_2459# VGND 0.11471f
C8356 a_14148_2395# VGND 0.03666f
C8357 a_15321_2697# VGND 0.09174f
C8358 a_13668_2382# VGND 0.02432f
C8359 a_12386_2382# VGND 0.04428f
C8360 a_14217_2773# VGND 1.13406f
C8361 a_13860_2700# VGND 0.15124f
C8362 a_13574_2382# VGND 0.25059f
C8363 a_13472_2514# VGND 0.03956f ; **FLOATING
C8364 a_13288_2514# VGND 0.14861f ; **FLOATING
C8365 a_10702_2382# VGND 0.20562f
C8366 a_10538_2382# VGND 1.28296f
C8367 a_11594_2540# VGND 0.03666f
C8368 a_11835_2773# VGND 1.77458f
C8369 a_11639_2773# VGND 0.28321f
C8370 a_9394_2382# VGND 0.51972f
C8371 a_10702_2697# VGND 0.02382f
C8372 a_8881_2459# VGND 0.33295f
C8373 a_8004_2395# VGND 0.03666f
C8374 a_9177_2697# VGND 0.31704f
C8375 a_7524_2382# VGND 0.55374f
C8376 a_5954_2382# VGND 1.53828f
C8377 a_8073_2773# VGND 0.86797f
C8378 a_7716_2700# VGND 0.59162f
C8379 a_7430_2382# VGND 0.75241f
C8380 a_5558_2395# VGND 0.88842f
C8381 a_4270_2382# VGND 0.20482f
C8382 a_4106_2382# VGND 0.49603f
C8383 a_5162_2540# VGND 0.92508f
C8384 a_5403_2773# VGND 0.05496f
C8385 a_5207_2773# VGND 3.04356f
C8386 a_4270_2697# VGND 0.19444f
C8387 a_3488_2514# VGND 0.04232f ; **FLOATING
C8388 a_3304_2514# VGND 0.14833f ; **FLOATING
C8389 a_1664_2514# VGND 0.03982f ; **FLOATING
C8390 a_1480_2514# VGND 0.12022f ; **FLOATING
C8391 a_28698_3144# VGND 0.2936f
C8392 a_28559_3514# VGND 0.96609f
C8393 a_25257_3191# VGND 1.09096f
C8394 a_26578_3582# VGND 0.15364f
C8395 a_26065_3505# VGND 0.53916f
C8396 a_25188_3569# VGND 0.4231f
C8397 a_25126_3569# VGND 0.38258f
C8398 a_24424_3230# VGND 0.08191f ; **FLOATING
C8399 a_24708_3582# VGND 1.09721f
C8400 a_24614_3582# VGND 1.44067f
C8401 a_23368_3230# VGND 0.15276f ; **FLOATING
C8402 a_23846_3144# VGND 0.39699f
C8403 a_21067_3492# VGND 0.27163f
C8404 a_20864_3230# VGND 0.04251f ; **FLOATING
C8405 a_18921_3191# VGND 1.00418f
C8406 a_20242_3582# VGND 0.71563f
C8407 a_19729_3505# VGND 0.2796f
C8408 a_20490_3144# VGND 0.10553f
C8409 a_18852_3569# VGND 0.04043f
C8410 a_18278_3582# VGND 1.41302f
C8411 a_15321_3267# VGND 0.09118f
C8412 a_17702_3144# VGND 0.31977f
C8413 a_16184_3185# VGND 0.1382f
C8414 a_14217_3191# VGND 0.92316f
C8415 a_15025_3505# VGND 0.33882f
C8416 a_14148_3569# VGND 0.14008f
C8417 a_13472_3230# VGND 0.03979f ; **FLOATING
C8418 a_13288_3230# VGND 0.15017f ; **FLOATING
C8419 a_11835_3191# VGND 0.93808f
C8420 a_13668_3582# VGND 0.55077f
C8421 a_13574_3582# VGND 0.6228f
C8422 a_11639_3191# VGND 0.5865f
C8423 a_11733_3191# VGND 0.01547f
C8424 a_11990_3569# VGND 0.07679f
C8425 a_11594_3424# VGND 0.11362f
C8426 a_10702_3582# VGND 0.23137f
C8427 a_9446_3144# VGND 0.31433f
C8428 a_8898_3510# VGND 1.00836f
C8429 a_8796_3510# VGND 0.24935f
C8430 a_8576_3230# VGND 0.04226f ; **FLOATING
C8431 a_7532_3144# VGND 0.07394f
C8432 a_5337_3267# VGND 0.2549f
C8433 sg13cmos5l_nor3_1_1.Y VGND 0.055f
C8434 a_4233_3191# VGND 0.02113f
C8435 a_5554_3582# VGND 0.5984f
C8436 a_5041_3505# VGND 0.21033f
C8437 a_4164_3569# VGND 0.9117f
C8438 a_4102_3569# VGND 0.873f
C8439 a_3488_3230# VGND 0.03928f ; **FLOATING
C8440 a_3304_3230# VGND 0.14862f ; **FLOATING
C8441 a_1340_3144# VGND 0.11102f
C8442 a_1137_3144# VGND 0.8564f
C8443 a_3684_3582# VGND 1.05051f
C8444 a_3590_3582# VGND 0.22647f
C8445 a_2054_3144# VGND 0.29794f
C8446 sg13cmos5l_xnor2_1_0.A VGND 0.06491f
C8447 a_1434_3502# VGND 0.7279f
C8448 a_808_3230# VGND 0.1315f ; **FLOATING
C8449 sg13cmos5l_dfrbpq_1_21.Q VGND 0.15017f
C8450 a_26866_3894# VGND 0.51802f
C8451 a_28758_3962# VGND 0.13815f
C8452 a_28646_3898# VGND 0.05472f
C8453 a_26353_3971# VGND 0.37244f
C8454 a_25414_3907# VGND 0.02497f
C8455 a_25476_3907# VGND 0.08448f
C8456 a_26649_4209# VGND 0.21621f
C8457 a_24996_3894# VGND 1.17537f
C8458 a_24642_3902# VGND 1.0579f
C8459 a_24540_3902# VGND 1.8426f
C8460 a_25545_4285# VGND 0.91584f
C8461 a_24902_3894# VGND 0.71803f
C8462 a_23846_3898# VGND 0.05996f
C8463 a_23368_4026# VGND 0.15422f ; **FLOATING
C8464 a_21553_3971# VGND 0.36942f
C8465 a_20614_3907# VGND 0.02569f
C8466 a_20676_3907# VGND 0.08517f
C8467 a_21849_4209# VGND 0.5045f
C8468 a_20196_3894# VGND 1.20778f
C8469 a_19474_3894# VGND 0.51802f
C8470 a_20745_4285# VGND 0.92039f
C8471 a_20102_3894# VGND 0.31217f
C8472 sg13cmos5l_buf_1_1.X VGND 12.03946f
C8473 sg13cmos5l_dfrbpq_1_5.Q VGND 0.17641f
C8474 a_18961_3971# VGND 0.13146f
C8475 a_18022_3907# VGND 0.05308f
C8476 a_18084_3907# VGND 0.21741f
C8477 a_19257_4209# VGND 0.10548f
C8478 a_17604_3894# VGND 0.49445f
C8479 a_17250_3902# VGND 1.44478f
C8480 a_17148_3902# VGND 0.96634f
C8481 a_18153_4285# VGND 1.27018f
C8482 a_17510_3894# VGND 1.85659f
C8483 a_15680_4026# VGND 0.04298f ; **FLOATING
C8484 a_14010_3910# VGND 2.9253f
C8485 a_15447_4192# VGND 0.43466f
C8486 a_15333_4192# VGND 0.51215f
C8487 sg13cmos5l_nor3_1_4.Y VGND 0.10796f
C8488 a_14630_3898# VGND 0.22477f
C8489 sg13cmos5l_xnor2_1_5.A VGND 0.12664f
C8490 a_13916_4192# VGND 0.20841f
C8491 a_13384_4026# VGND 0.13218f ; **FLOATING
C8492 a_8546_3894# VGND 0.44059f
C8493 a_14360_3898# VGND 0.11641f
C8494 a_11786_4192# VGND 1.23531f
C8495 a_11488_4192# VGND 1.07646f
C8496 a_11276_4192# VGND 0.57235f
C8497 sg13cmos5l_dfrbpq_1_17.Q VGND 0.22119f
C8498 sg13cmos5l_dlygate4sd3_1_18.X VGND 0.09014f
C8499 a_8960_4026# VGND 0.04138f ; **FLOATING
C8500 a_8776_4026# VGND 0.08341f ; **FLOATING
C8501 a_8150_3907# VGND 0.92167f
C8502 a_6862_3894# VGND 0.23973f
C8503 a_6698_3894# VGND 0.49708f
C8504 a_7754_4052# VGND 1.21833f
C8505 a_7799_4285# VGND 0.76971f
C8506 a_6972_3858# VGND 0.69451f
C8507 a_5041_3971# VGND 0.48952f
C8508 a_4102_3907# VGND 0.02541f
C8509 a_4164_3907# VGND 0.1909f
C8510 a_3684_3894# VGND 0.36902f
C8511 a_4233_4285# VGND 1.02844f
C8512 a_3876_4212# VGND 0.12339f
C8513 a_3590_3894# VGND 2.25415f
C8514 a_3488_4026# VGND 0.04214f ; **FLOATING
C8515 a_3304_4026# VGND 0.14926f ; **FLOATING
C8516 a_2165_3898# VGND 0.57015f
C8517 a_1979_3940# VGND 0.44036f
C8518 sg13cmos5l_dfrbpq_1_18.D VGND 0.73612f
C8519 a_2259_4192# VGND 0.09431f
C8520 sg13cmos5l_nand3_1_3.Y VGND 2.14946f
C8521 a_29120_4742# VGND 0.07491f ; **FLOATING
C8522 a_28936_4742# VGND 0.07642f ; **FLOATING
C8523 a_27225_4779# VGND 0.09029f
C8524 sg13cmos5l_dfrbpq_1_7.Q VGND 0.14594f
C8525 a_26121_4703# VGND 0.02044f
C8526 a_27442_5094# VGND 0.37163f
C8527 a_26929_5017# VGND 0.11471f
C8528 a_27690_4656# VGND 0.1961f
C8529 a_26052_5081# VGND 0.95231f
C8530 a_25990_5081# VGND 1.70053f
C8531 a_25288_4742# VGND 0.08148f ; **FLOATING
C8532 a_25738_4624# VGND 0.10551f
C8533 a_25572_5094# VGND 0.39979f
C8534 a_25478_5094# VGND 0.71194f
C8535 a_24641_4922# VGND 0.18106f
C8536 a_23368_4742# VGND 0.15259f ; **FLOATING
C8537 a_23846_4656# VGND 0.06425f
C8538 a_24526_4923# VGND 0.08294f
C8539 a_23958_4680# VGND 0.17294f
C8540 sg13cmos5l_dlygate4sd3_1_10.A VGND 0.23305f
C8541 a_20745_4703# VGND 1.21492f
C8542 a_22066_5094# VGND 0.51796f
C8543 a_21553_5017# VGND 0.20489f
C8544 a_20676_5081# VGND 0.15652f
C8545 a_20614_5081# VGND 0.02397f
C8546 a_20000_4742# VGND 0.03945f ; **FLOATING
C8547 a_18387_4656# VGND 1.04988f
C8548 a_20196_5094# VGND 0.59349f
C8549 a_20102_5094# VGND 1.00611f
C8550 sg13cmos5l_buf_1_4.X VGND 12.38171f
C8551 sg13cmos5l_nor3_1_0.C VGND 0.24271f
C8552 a_18293_5026# VGND 0.16645f
C8553 a_18144_4695# VGND 0.02342f
C8554 a_16078_4779# VGND 0.16588f
C8555 a_17015_4703# VGND 1.82039f
C8556 a_17366_5081# VGND 0.86826f
C8557 a_16970_4936# VGND 0.90492f
C8558 a_16078_5094# VGND 0.11495f
C8559 a_15296_4742# VGND 0.04354f ; **FLOATING
C8560 a_16188_5017# VGND 0.14298f
C8561 a_13472_4742# VGND 0.04271f ; **FLOATING
C8562 a_13288_4742# VGND 0.15092f ; **FLOATING
C8563 a_13862_4656# VGND 0.04048f
C8564 a_14938_4620# VGND 0.07495f
C8565 a_13974_4680# VGND 0.16548f
C8566 a_12386_5094# VGND 0.39733f
C8567 a_10702_4779# VGND 0.09564f
C8568 a_11639_4703# VGND 1.74642f
C8569 a_11990_5081# VGND 0.9176f
C8570 a_11594_4936# VGND 0.95457f
C8571 a_10702_5094# VGND 0.23036f
C8572 a_10538_5094# VGND 0.47004f
C8573 a_9446_4656# VGND 0.14417f
C8574 a_7328_4742# VGND 0.04166f ; **FLOATING
C8575 a_6555_4703# VGND 1.83785f
C8576 a_9176_4697# VGND 0.10972f
C8577 a_7930_4620# VGND 0.07275f
C8578 a_7534_4923# VGND 0.05017f
C8579 a_5422_4779# VGND 0.07479f
C8580 a_6359_4703# VGND 0.55124f
C8581 a_6453_4703# VGND 0.92586f
C8582 a_6314_4936# VGND 0.03666f
C8583 a_4202_4656# VGND 0.08654f
C8584 a_3904_4656# VGND 0.85605f
C8585 a_3692_4656# VGND 0.90655f
C8586 a_5422_5094# VGND 0.20616f
C8587 a_5258_5094# VGND 0.15291f
C8588 a_3488_4742# VGND 0.04258f ; **FLOATING
C8589 a_3304_4742# VGND 0.14918f ; **FLOATING
C8590 a_2259_4656# VGND 0.26824f
C8591 a_1491_4656# VGND 0.09691f
C8592 a_2165_5026# VGND 0.61494f
C8593 a_1397_5026# VGND 0.40958f
C8594 a_1211_5004# VGND 0.16821f
C8595 a_992_4742# VGND 0.04466f ; **FLOATING
C8596 a_808_4742# VGND 0.1233f ; **FLOATING
C8597 a_29120_5538# VGND 0.07483f ; **FLOATING
C8598 a_28936_5538# VGND 0.07585f ; **FLOATING
C8599 a_26929_5483# VGND 0.41687f
C8600 a_25990_5419# VGND 0.91204f
C8601 a_26052_5419# VGND 0.9487f
C8602 a_27225_5721# VGND 0.23682f
C8603 a_28174_5595# VGND 0.15128f
C8604 a_25236_5452# VGND 0.85301f
C8605 a_24815_5410# VGND 0.74232f
C8606 a_25478_5406# VGND 1.53127f
C8607 a_24954_5704# VGND 0.12663f
C8608 sg13cmos5l_nand3_1_2.B VGND 0.07852f
C8609 a_24170_5704# VGND 0.4109f
C8610 a_23872_5704# VGND 0.38218f
C8611 a_23660_5704# VGND 0.32849f
C8612 a_23368_5538# VGND 0.15372f ; **FLOATING
C8613 sg13cmos5l_nand3_1_2.Y VGND 0.17066f
C8614 a_21553_5483# VGND 0.11471f
C8615 a_20676_5419# VGND 0.03666f
C8616 a_21849_5721# VGND 0.3355f
C8617 a_17842_5406# VGND 0.15185f
C8618 a_20745_5797# VGND 1.12572f
C8619 a_20388_5724# VGND 0.14596f
C8620 a_20102_5406# VGND 1.27841f
C8621 a_17329_5483# VGND 0.27967f
C8622 a_16390_5419# VGND 0.88868f
C8623 a_16452_5419# VGND 0.92534f
C8624 a_18572_5370# VGND 0.13866f
C8625 a_16521_5797# VGND 0.29122f
C8626 a_15878_5406# VGND 0.63228f
C8627 a_15414_5474# VGND 0.17925f
C8628 a_15302_5410# VGND 0.12686f
C8629 a_14824_5538# VGND 0.08274f ; **FLOATING
C8630 a_13472_5538# VGND 0.04186f ; **FLOATING
C8631 a_13288_5538# VGND 0.14861f ; **FLOATING
C8632 a_11986_5406# VGND 0.11281f
C8633 a_11473_5483# VGND 0.27905f
C8634 a_10534_5419# VGND 0.86777f
C8635 a_10596_5419# VGND 0.90443f
C8636 a_11769_5721# VGND 0.2881f
C8637 a_10116_5406# VGND 0.27089f
C8638 a_10665_5797# VGND 0.15377f
C8639 a_10022_5406# VGND 1.55981f
C8640 a_9558_5474# VGND 0.23326f
C8641 a_7298_5406# VGND 0.06281f
C8642 a_5614_5406# VGND 0.11471f
C8643 a_6506_5564# VGND 0.24165f
C8644 a_9176_5410# VGND 0.10935f
C8645 a_6747_5797# VGND 0.86691f
C8646 a_6551_5797# VGND 0.2363f
C8647 a_3817_5452# VGND 0.24824f
C8648 a_5724_5370# VGND 0.14375f
C8649 a_5614_5721# VGND 0.16516f
C8650 a_3488_5538# VGND 0.04759f ; **FLOATING
C8651 a_3304_5538# VGND 0.15898f ; **FLOATING
C8652 a_2165_5410# VGND 1.33102f
C8653 a_4088_5410# VGND 0.47021f
C8654 sg13cmos5l_dfrbpq_1_13.RESET_B VGND 14.32759f
C8655 a_2259_5704# VGND 0.77929f
C8656 a_992_5538# VGND 0.04348f ; **FLOATING
C8657 a_808_5538# VGND 0.12092f ; **FLOATING
C8658 a_1265_5460# VGND 0.0203f
C8659 a_27784_6254# VGND 0.08221f ; **FLOATING
C8660 a_26073_6291# VGND 0.3872f
C8661 a_24969_6215# VGND 0.97174f
C8662 a_25777_6529# VGND 0.11471f
C8663 a_24900_6593# VGND 0.03666f
C8664 a_24612_6172# VGND 0.04169f
C8665 a_24326_6606# VGND 1.24145f
C8666 a_23861_6538# VGND 1.14606f
C8667 a_23368_6254# VGND 0.15564f ; **FLOATING
C8668 a_21849_6291# VGND 0.40774f
C8669 a_20745_6215# VGND 0.99835f
C8670 a_22066_6606# VGND 0.148f
C8671 a_21553_6529# VGND 0.11471f
C8672 a_20676_6593# VGND 0.15575f
C8673 a_20614_6593# VGND 0.02382f
C8674 a_20000_6254# VGND 0.04035f ; **FLOATING
C8675 a_20196_6606# VGND 1.04247f
C8676 a_20102_6606# VGND 0.28213f
C8677 a_19361_6434# VGND 0.03642f
C8678 a_18497_6434# VGND 0.08125f
C8679 a_18778_6132# VGND 0.07288f
C8680 a_18382_6435# VGND 0.08135f
C8681 a_16329_6215# VGND 0.8879f
C8682 a_17650_6606# VGND 0.15212f
C8683 a_17137_6529# VGND 0.28005f
C8684 a_16260_6593# VGND 0.03666f
C8685 a_16198_6593# VGND 0.05154f
C8686 a_15972_6172# VGND 0.45008f
C8687 a_15686_6606# VGND 1.10359f
C8688 a_14720_6254# VGND 0.04338f ; **FLOATING
C8689 a_14186_6168# VGND 0.7802f
C8690 a_13888_6168# VGND 0.89238f
C8691 a_13676_6168# VGND 0.5407f
C8692 a_15322_6132# VGND 0.07322f
C8693 a_14926_6435# VGND 0.15724f
C8694 a_13472_6254# VGND 0.04259f ; **FLOATING
C8695 a_13288_6254# VGND 0.14888f ; **FLOATING
C8696 a_10702_6291# VGND 0.36059f
C8697 a_11639_6215# VGND 1.0737f
C8698 a_11990_6593# VGND 2.01655f
C8699 a_11594_6448# VGND 1.05878f
C8700 a_10702_6606# VGND 0.20645f
C8701 a_10538_6606# VGND 0.25781f
C8702 a_8905_6516# VGND 1.93329f
C8703 a_9558_6192# VGND 0.11869f
C8704 a_9176_6209# VGND 0.07329f
C8705 a_8488_6254# VGND 0.08329f ; **FLOATING
C8706 a_7641_6291# VGND 0.92842f
C8707 sg13cmos5l_buf_8_9.A VGND 0.05807f
C8708 a_6537_6215# VGND 0.96557f
C8709 a_7345_6529# VGND 0.11471f
C8710 a_6468_6593# VGND 0.13328f
C8711 a_5334_6168# VGND 0.44175f
C8712 a_5036_6168# VGND 0.84528f
C8713 a_4730_6168# VGND 0.78239f
C8714 a_5894_6606# VGND 0.52549f
C8715 a_3688_6254# VGND 0.09911f ; **FLOATING
C8716 a_4166_6168# VGND 0.11204f
C8717 a_1985_6434# VGND 0.40258f
C8718 a_1664_6254# VGND 0.03937f ; **FLOATING
C8719 a_1480_6254# VGND 0.12017f ; **FLOATING
C8720 a_28114_6918# VGND 0.15191f
C8721 a_28931_7216# VGND 0.07651f
C8722 a_28829_7216# VGND 0.07637f
C8723 sg13cmos5l_nand3_1_2.C VGND 0.05259f
C8724 a_27601_6995# VGND 0.11471f
C8725 a_26662_6931# VGND 0.85704f
C8726 a_26724_6931# VGND 0.31523f
C8727 a_27897_7233# VGND 0.35049f
C8728 a_25522_6918# VGND 0.19978f
C8729 a_26793_7309# VGND 0.8677f
C8730 a_26150_6918# VGND 0.459f
C8731 sg13cmos5l_dlygate4sd3_1_9.X VGND 0.14509f
C8732 sg13cmos5l_dlygate4sd3_1_40.A VGND 0.14473f
C8733 a_25009_6995# VGND 0.11471f
C8734 a_24132_6931# VGND 0.03666f
C8735 a_25305_7233# VGND 0.28476f
C8736 a_25360_7138# VGND 0.48899f
C8737 a_24201_7309# VGND 1.08125f
C8738 a_23844_7236# VGND 0.67051f
C8739 a_23558_6918# VGND 0.28647f
C8740 a_23368_7050# VGND 0.15958f ; **FLOATING
C8741 a_22070_6931# VGND 0.992f
C8742 a_20782_6918# VGND 0.11471f
C8743 a_20618_6918# VGND 0.19563f
C8744 a_21674_7076# VGND 1.02866f
C8745 a_21719_7309# VGND 1.52511f
C8746 a_20782_7233# VGND 0.43156f
C8747 sg13cmos5l_buf_2_0.X VGND 0.46617f
C8748 a_17233_6995# VGND 0.20634f
C8749 a_16294_6931# VGND 0.93993f
C8750 a_16356_6931# VGND 0.97659f
C8751 a_15782_6918# VGND 0.42005f
C8752 a_15680_7050# VGND 0.03437f ; **FLOATING
C8753 a_15496_7050# VGND 0.07554f ; **FLOATING
C8754 a_13867_6964# VGND 0.2252f
C8755 a_13664_7050# VGND 0.0582f ; **FLOATING
C8756 a_11986_6918# VGND 0.25781f
C8757 a_11473_6995# VGND 0.11471f
C8758 a_10534_6931# VGND 0.99748f
C8759 a_10596_6931# VGND 1.12947f
C8760 a_11769_7233# VGND 0.45233f
C8761 a_10116_6918# VGND 1.01884f
C8762 a_10022_6918# VGND 0.22288f
C8763 a_10282_7141# VGND 0.09532f
C8764 a_8584_7050# VGND 0.08318f ; **FLOATING
C8765 a_7441_6995# VGND 0.35201f
C8766 a_6502_6931# VGND 0.02044f
C8767 a_6564_6931# VGND 0.0571f
C8768 a_7737_7233# VGND 0.18777f
C8769 a_6633_7309# VGND 0.8681f
C8770 a_5990_6918# VGND 0.25636f
C8771 a_5626_6886# VGND 0.28496f
C8772 a_4481_7108# VGND 0.18498f
C8773 a_4160_7050# VGND 0.04364f ; **FLOATING
C8774 a_3896_6926# VGND 0.03583f
C8775 a_3794_6926# VGND 0.01223f
C8776 a_2816_7050# VGND 0.03621f ; **FLOATING
C8777 a_2632_7050# VGND 0.07662f ; **FLOATING
C8778 a_2165_6922# VGND 0.6761f
C8779 a_1979_6964# VGND 0.63738f
C8780 a_2259_7216# VGND 0.49667f
C8781 a_1192_7050# VGND 0.1127f ; **FLOATING
C8782 sg13cmos5l_nor4_2_9.Y VGND 0.0766f
C8783 sg13cmos5l_nor4_2_5.Y VGND 0.1125f
C8784 a_29120_7766# VGND 0.0748f ; **FLOATING
C8785 a_28936_7766# VGND 0.07641f ; **FLOATING
C8786 a_26841_7803# VGND 0.31031f
C8787 sg13cmos5l_buf_1_4.A VGND 13.67338f
C8788 a_28652_7644# VGND 0.48949f
C8789 a_28186_7644# VGND 0.39446f
C8790 a_27790_7947# VGND 0.17873f
C8791 a_27058_8118# VGND 0.25565f
C8792 a_26545_8041# VGND 0.20561f
C8793 a_25668_8105# VGND 1.22214f
C8794 a_25606_8105# VGND 1.18548f
C8795 a_25188_8118# VGND 0.02351f
C8796 a_25094_8118# VGND 0.25912f
C8797 a_23744_7766# VGND 0.05946f ; **FLOATING
C8798 a_22466_8118# VGND 0.09812f
C8799 a_20782_7803# VGND 0.57304f
C8800 a_21719_7727# VGND 1.75501f
C8801 a_22070_8105# VGND 0.88945f
C8802 a_21674_7960# VGND 0.92611f
C8803 sg13cmos5l_xnor2_1_10.Y VGND 0.12663f
C8804 a_20782_8118# VGND 0.20645f
C8805 a_18664_7766# VGND 0.08257f ; **FLOATING
C8806 a_16569_7803# VGND 0.23336f
C8807 sg13cmos5l_buf_1_2.A VGND 0.40103f
C8808 a_17633_7946# VGND 0.24022f
C8809 sg13cmos5l_dfrbpq_1_52.Q VGND 0.2186f
C8810 a_15465_7727# VGND 0.93598f
C8811 a_16786_8118# VGND 0.16096f
C8812 a_16273_8041# VGND 0.50355f
C8813 a_15396_8105# VGND 0.03666f
C8814 a_15334_8105# VGND 0.99463f
C8815 a_14720_7766# VGND 0.0393f ; **FLOATING
C8816 a_14822_8118# VGND 0.30207f
C8817 a_13472_7766# VGND 0.04745f ; **FLOATING
C8818 a_13288_7766# VGND 0.15929f ; **FLOATING
C8819 a_12386_8118# VGND 0.99513f
C8820 a_10702_7803# VGND 0.32509f
C8821 a_11639_7727# VGND 0.23963f
C8822 a_11733_7727# VGND 0.10989f
C8823 a_11990_8105# VGND 0.93713f
C8824 a_11594_7960# VGND 1.08368f
C8825 a_8793_7803# VGND 0.12778f
C8826 a_10702_8118# VGND 0.77468f
C8827 a_6267_7727# VGND 0.224f
C8828 a_9010_8118# VGND 0.25888f
C8829 a_8497_8041# VGND 0.66713f
C8830 a_10444_8118# VGND 0.37764f
C8831 a_7620_8105# VGND 1.04708f
C8832 a_7558_8105# VGND 1.9623f
C8833 a_7046_8118# VGND 0.19877f
C8834 a_6818_8118# VGND 0.07806f
C8835 a_5134_7803# VGND 0.09669f
C8836 a_6071_7727# VGND 1.32626f
C8837 a_6422_8105# VGND 0.94463f
C8838 a_6026_7960# VGND 0.9813f
C8839 a_5134_8118# VGND 0.30543f
C8840 a_4970_8118# VGND 0.6941f
C8841 a_3488_7766# VGND 0.04643f ; **FLOATING
C8842 a_3304_7766# VGND 0.11637f ; **FLOATING
C8843 a_3878_7680# VGND 0.28377f
C8844 a_2816_7766# VGND 0.03664f ; **FLOATING
C8845 a_2632_7766# VGND 0.07585f ; **FLOATING
C8846 a_2920_7680# VGND 0.28041f
C8847 a_1664_7766# VGND 0.03998f ; **FLOATING
C8848 a_1480_7766# VGND 0.12169f ; **FLOATING
C8849 a_2266_7644# VGND 0.33374f
C8850 a_1870_7947# VGND 0.08455f
C8851 a_29120_8562# VGND 0.07571f ; **FLOATING
C8852 a_28936_8562# VGND 0.08193f ; **FLOATING
C8853 a_27442_8430# VGND 0.37163f
C8854 a_28289_8620# VGND 0.17513f
C8855 a_26929_8507# VGND 0.11471f
C8856 a_26052_8443# VGND 0.03666f
C8857 a_27225_8745# VGND 0.19121f
C8858 a_27690_8728# VGND 0.20327f
C8859 a_25572_8430# VGND 1.10358f
C8860 a_25146_8446# VGND 0.75283f
C8861 a_26121_8821# VGND 1.12272f
C8862 sg13cmos5l_dfrbpq_1_53.CLK VGND 0.0527f
C8863 a_25478_8430# VGND 3.05503f
C8864 sg13cmos5l_dlygate4sd3_1_4.X VGND 0.20518f
C8865 sg13cmos5l_dfrbpq_1_53.RESET_B VGND 14.17251f
C8866 sg13cmos5l_xnor2_1_4.A VGND 0.12382f
C8867 a_25052_8728# VGND 0.3704f
C8868 sg13cmos5l_nand3_1_2.A VGND 0.02377f
C8869 a_24170_8728# VGND 0.57895f
C8870 a_23872_8728# VGND 0.10498f
C8871 a_23660_8728# VGND 0.11274f
C8872 a_23368_8562# VGND 0.15879f ; **FLOATING
C8873 a_22066_8430# VGND 0.49232f
C8874 sg13cmos5l_dlygate4sd3_1_47.A VGND 0.36309f
C8875 a_21553_8507# VGND 1.08623f
C8876 a_20614_8443# VGND 0.91396f
C8877 a_20676_8443# VGND 0.95062f
C8878 a_20196_8430# VGND 0.05398f
C8879 a_20102_8430# VGND 1.39268f
C8880 sg13cmos5l_buf_1_0.X VGND 12.22288f
C8881 a_19526_8434# VGND 0.16984f
C8882 a_18874_8398# VGND 0.65483f
C8883 sg13cmos5l_dfrbpq_1_47.Q VGND 0.22061f
C8884 a_17729_8620# VGND 0.10393f
C8885 a_16886_8443# VGND 0.88935f
C8886 a_15598_8430# VGND 0.33448f
C8887 a_16490_8588# VGND 0.92601f
C8888 a_16535_8821# VGND 0.19934f
C8889 a_15598_8745# VGND 0.21046f
C8890 a_14816_8562# VGND 0.03989f ; **FLOATING
C8891 a_14632_8562# VGND 0.08432f ; **FLOATING
C8892 a_14166_8498# VGND 0.09202f
C8893 a_14054_8434# VGND 0.21668f
C8894 a_13664_8562# VGND 0.06259f ; **FLOATING
C8895 a_11473_8507# VGND 0.44112f
C8896 a_10534_8443# VGND 1.86239f
C8897 a_10596_8443# VGND 1.11459f
C8898 a_10116_8430# VGND 0.14282f
C8899 a_8546_8430# VGND 1.05018f
C8900 a_10308_8748# VGND 0.14797f
C8901 a_10022_8430# VGND 1.28665f
C8902 sg13cmos5l_dfrbpq_1_57.RESET_B VGND 9.69858f
C8903 a_6862_8430# VGND 0.11471f
C8904 a_6698_8430# VGND 0.15426f
C8905 a_7754_8588# VGND 0.48339f
C8906 a_7995_8821# VGND 1.02509f
C8907 a_7799_8821# VGND 0.60767f
C8908 a_5554_8430# VGND 0.49603f
C8909 a_6862_8745# VGND 0.41386f
C8910 a_5041_8507# VGND 0.20738f
C8911 a_4164_8443# VGND 0.03673f
C8912 a_3684_8430# VGND 0.07787f
C8913 a_4233_8821# VGND 1.20784f
C8914 a_3590_8430# VGND 1.40618f
C8915 a_3488_8562# VGND 0.04031f ; **FLOATING
C8916 a_3304_8562# VGND 0.11115f ; **FLOATING
C8917 sg13cmos5l_dfrbpq_1_21.RESET_B VGND 13.03588f
C8918 a_2816_8562# VGND 0.03838f ; **FLOATING
C8919 a_2632_8562# VGND 0.08292f ; **FLOATING
C8920 sg13cmos5l_dlygate4sd3_1_35.A VGND 0.22363f
C8921 sg13cmos5l_buf_1_0.A VGND 29.90433f
C8922 a_808_8562# VGND 0.12354f ; **FLOATING
C8923 a_1384_8468# VGND 6.6418f
C8924 a_1000_8468# VGND 0.43891f
C8925 sg13cmos5l_buf_1_0.A.t0 VGND 0.58069f
C8926 sg13cmos5l_buf_1_0.A.n0 VGND 21.4046f
C8927 sg13cmos5l_dfrbpq_1_21.RESET_B.n0 VGND 3.38058f
C8928 sg13cmos5l_dfrbpq_1_21.RESET_B.n1 VGND 1.45345f
C8929 sg13cmos5l_dfrbpq_1_21.RESET_B.n2 VGND 1.55946f
C8930 sg13cmos5l_dfrbpq_1_21.RESET_B.n3 VGND 0.8869f
C8931 sg13cmos5l_dfrbpq_1_21.RESET_B.n4 VGND 5.33521f
C8932 sg13cmos5l_dfrbpq_1_21.RESET_B.n5 VGND 5.40949f
C8933 sg13cmos5l_dfrbpq_1_21.RESET_B.n6 VGND 1.47562f
C8934 sg13cmos5l_dfrbpq_1_21.RESET_B.t0 VGND 0.47261f
C8935 sg13cmos5l_dfrbpq_1_57.RESET_B.n0 VGND 2.54263f
C8936 sg13cmos5l_dfrbpq_1_57.RESET_B.n1 VGND 2.7855f
C8937 sg13cmos5l_dfrbpq_1_57.RESET_B.n2 VGND 1.85762f
C8938 sg13cmos5l_dfrbpq_1_57.RESET_B.n3 VGND 1.13972f
C8939 sg13cmos5l_dfrbpq_1_57.RESET_B.n4 VGND 2.5611f
C8940 sg13cmos5l_dfrbpq_1_57.RESET_B.n5 VGND 2.03999f
C8941 sg13cmos5l_buf_1_0.X.n0 VGND 3.30742f
C8942 sg13cmos5l_buf_1_0.X.n1 VGND 1.18855f
C8943 sg13cmos5l_buf_1_0.X.n2 VGND 2.38911f
C8944 sg13cmos5l_buf_1_0.X.n3 VGND 1.98868f
C8945 sg13cmos5l_buf_1_0.X.n4 VGND 3.72277f
C8946 sg13cmos5l_buf_1_0.X.n5 VGND 6.54137f
C8947 sg13cmos5l_buf_1_0.X.t0 VGND 0.73619f
C8948 sg13cmos5l_dfrbpq_1_53.RESET_B.n0 VGND 1.21137f
C8949 sg13cmos5l_dfrbpq_1_53.RESET_B.n1 VGND 1.53561f
C8950 sg13cmos5l_dfrbpq_1_53.RESET_B.n2 VGND 0.79768f
C8951 sg13cmos5l_dfrbpq_1_53.RESET_B.n3 VGND 12.4089f
C8952 sg13cmos5l_dfrbpq_1_53.RESET_B.t0 VGND 0.45984f
C8953 sg13cmos5l_buf_1_4.A.n0 VGND 23.7345f
C8954 sg13cmos5l_buf_1_4.A.t0 VGND 0.6615f
C8955 sg13cmos5l_dfrbpq_1_13.RESET_B.n0 VGND 3.29489f
C8956 sg13cmos5l_dfrbpq_1_13.RESET_B.n1 VGND 5.47171f
C8957 sg13cmos5l_dfrbpq_1_13.RESET_B.n2 VGND 1.11857f
C8958 sg13cmos5l_dfrbpq_1_13.RESET_B.n3 VGND 1.53016f
C8959 sg13cmos5l_dfrbpq_1_13.RESET_B.n4 VGND 1.00414f
C8960 sg13cmos5l_dfrbpq_1_13.RESET_B.n5 VGND 6.90517f
C8961 sg13cmos5l_dfrbpq_1_13.RESET_B.t0 VGND 0.49317f
C8962 sg13cmos5l_buf_1_4.X.t0 VGND 0.59697f
C8963 sg13cmos5l_buf_1_4.X.n0 VGND 2.96896f
C8964 sg13cmos5l_buf_1_4.X.n1 VGND 2.66497f
C8965 sg13cmos5l_buf_1_4.X.n2 VGND 7.03058f
C8966 sg13cmos5l_buf_1_4.X.n3 VGND 10.2613f
C8967 sg13cmos5l_buf_1_1.X.t0 VGND 0.65453f
C8968 sg13cmos5l_buf_1_1.X.n0 VGND 2.64637f
C8969 sg13cmos5l_buf_1_1.X.n1 VGND 5.60214f
C8970 sg13cmos5l_buf_1_1.X.n2 VGND 2.8515f
C8971 sg13cmos5l_buf_1_1.X.n3 VGND 1.45284f
C8972 sg13cmos5l_buf_1_1.X.n4 VGND 1.40155f
C8973 sg13cmos5l_buf_1_1.X.n5 VGND 1.66331f
C8974 sg13cmos5l_buf_1_1.X.n6 VGND 3.79437f
C8975 VGND.t30 VGND 0.871f
C8976 VGND.t54 VGND 1.02725f
C8977 VGND.t20 VGND 0.36309f
C8978 VGND.t0 VGND 4.49168f
C8979 VGND.t17 VGND 1.69035f
C8980 VGND.t77 VGND 2.04467f
C8981 VGND.t203 VGND 5.63468f
C8982 VGND.t25 VGND 0.94967f
C8983 VGND.t40 VGND 0.54458f
C8984 VGND.t50 VGND 10.9111f
C8985 VGND.t32 VGND 0.41008f
C8986 VGND.t35 VGND 1.6855f
C8987 VGND.t143 VGND 5.14485f
C8988 VGND.t393 VGND 0.6841f
C8989 VGND.t286 VGND 3.09976f
C8990 VGND.t205 VGND 1.04179f
C8991 VGND.t191 VGND 1.10194f
C8992 VGND.t332 VGND 0.97409f
C8993 VGND.t254 VGND 1.36583f
C8994 VGND.t15 VGND 0.27761f
C8995 VGND.t121 VGND 7.08071f
C8996 VGND.t119 VGND 1.99389f
C8997 VGND.t449 VGND 0.32121f
C8998 VGND.t145 VGND 1.71038f
C8999 VGND.t324 VGND 0.3946f
C9000 VGND.t137 VGND 5.1311f
C9001 VGND.t133 VGND 0.85224f
C9002 VGND.t150 VGND 0.17679f
C9003 VGND.t278 VGND 0.21455f
C9004 VGND.t280 VGND 0.11122f
C9005 VGND.t861 VGND 0.12339f
C9006 VGND.t52 VGND 1.9585f
C9007 VGND.t558 VGND 1.08636f
C9008 VGND.t106 VGND 2.5179f
C9009 VGND.t316 VGND 4.08265f
C9010 VGND.t478 VGND 2.33778f
C9011 VGND.t608 VGND 0.58946f
C9012 VGND.t115 VGND 2.60942f
C9013 VGND.t396 VGND 0.47596f
C9014 VGND.t462 VGND 0.2507f
C9015 VGND.t467 VGND 0.12191f
C9016 VGND.t359 VGND 0.431f
C9017 VGND.t156 VGND 0.14226f
C9018 VGND.t154 VGND 0.60175f
C9019 VGND.t71 VGND 1.94609f
C9020 VGND.t13 VGND 0.56641f
C9021 VGND.t112 VGND 0.7316f
C9022 VGND.t235 VGND 0.37311f
C9023 VGND.t101 VGND 0.14873f
C9024 VGND.t756 VGND 0.03898f
C9025 VGND.t172 VGND 2.95216f
C9026 VGND.t411 VGND 0.55393f
C9027 VGND.t365 VGND 0.18566f
C9028 VGND.t165 VGND 0.39112f
C9029 VGND.t167 VGND 0.18853f
C9030 VGND.t508 VGND 0.18934f
C9031 VGND.t38 VGND 0.76134f
C9032 VGND.t1619 VGND 1.26502f
C9033 VGND.t216 VGND 0.4247f
C9034 VGND.t174 VGND 0.59745f
C9035 VGND.t176 VGND 1.67342f
C9036 VGND.t377 VGND 0.09081f
C9037 VGND.t11 VGND 3.70457f
C9038 VGND.t268 VGND 0.99952f
C9039 VGND.t58 VGND 4.76467f
C9040 VGND.t293 VGND 3.05326f
C9041 VGND.t851 VGND 0.60591f
C9042 VGND.t201 VGND 0.53075f
C9043 VGND.t259 VGND 0.2198f
C9044 VGND.t341 VGND 0.45976f
C9045 VGND.t630 VGND 2.24035f
C9046 VGND.t418 VGND 0.55253f
C9047 VGND.t1033 VGND 0.2501f
C9048 VGND.t453 VGND 1.08114f
C9049 VGND.t117 VGND 0.69529f
C9050 VGND.t358 VGND 1.26879f
C9051 VGND.t856 VGND 1.05f
C9052 VGND.t741 VGND 0.6277f
C9053 VGND.t803 VGND 1.36561f
C9054 VGND.t312 VGND 0.67792f
C9055 VGND.t1014 VGND 0.6372f
C9056 VGND.t91 VGND 0.99463f
C9057 VGND.t90 VGND 0.14521f
C9058 VGND.t238 VGND 0.89391f
C9059 VGND.t93 VGND 1.36084f
C9060 VGND.t842 VGND 0.61464f
C9061 VGND.t874 VGND 0.38138f
C9062 VGND.t800 VGND 0.98374f
C9063 VGND.t1016 VGND 0.65483f
C9064 VGND.t996 VGND 0.38242f
C9065 VGND.t141 VGND 0.09174f
C9066 VGND.t62 VGND 1.49051f
C9067 VGND.t299 VGND 0.4682f
C9068 VGND.t273 VGND 0.81081f
C9069 VGND.t73 VGND 0.94495f
C9070 VGND.t3 VGND 0.1468f
C9071 VGND.t88 VGND 0.16885f
C9072 VGND.t728 VGND 0.95954f
C9073 VGND.t126 VGND 1.43752f
C9074 VGND.t45 VGND 1.37878f
C9075 VGND.t197 VGND 0.19516f
C9076 VGND.t179 VGND 2.41731f
C9077 VGND.t824 VGND 0.16496f
C9078 VGND.t350 VGND 1.27485f
C9079 VGND.t86 VGND 0.58236f
C9080 VGND.t131 VGND 2.69122f
C9081 VGND.t535 VGND 0.7057f
C9082 VGND.t664 VGND 0.38542f
C9083 VGND.t1159 VGND 1.27166f
C9084 VPWR.n0 VGND 0.88488f
C9085 VPWR.n2 VGND 0.8208f
C9086 VPWR.n3 VGND 0.072f
C9087 VPWR.n4 VGND 0.02997f
C9088 VPWR.n5 VGND 0.82541f
C9089 VPWR.n6 VGND 0.20997f
C9090 VPWR.n7 VGND 0.02849f
C9091 VPWR.t43 VGND 74.23518f
C9092 VPWR.n9 VGND 0.05807f
C9093 VPWR.n10 VGND 0.80124f
C9094 VPWR.n11 VGND 0.21058f
C9095 VPWR.n12 VGND 0.15072f
C9096 VPWR.n13 VGND 0.11816f
C9097 VPWR.t7 VGND 78.95845f
C9098 VPWR.n14 VGND 0.02867f
C9099 VPWR.n15 VGND 0.04286f
C9100 VPWR.n16 VGND 0.06756f
C9101 VPWR.n18 VGND 0.34077f
C9102 VPWR.n19 VGND 0.45333f
C9103 VPWR.n20 VGND 0.07624f
C9104 VPWR.n21 VGND 0.05777f
C9105 VPWR.n22 VGND 0.10287f
C9106 VPWR.n24 VGND 0.0117f
C9107 VPWR.n25 VGND 0.17736f
C9108 VPWR.n26 VGND 0.1774f
C9109 VPWR.n27 VGND 0.13885f
C9110 VPWR.n28 VGND 0.01238f
C9111 VPWR.n29 VGND 0.0117f
C9112 VPWR.n30 VGND 0.17736f
C9113 VPWR.n31 VGND 0.1774f
C9114 VPWR.n32 VGND 0.13885f
C9115 VPWR.n33 VGND 0.01238f
C9116 VPWR.n34 VGND 0.2743f
C9117 VPWR.n36 VGND 0.15852f
C9118 VPWR.n37 VGND 0.03709f
C9119 VPWR.t105 VGND 9.80132f
C9120 VPWR.t15 VGND 46.1776f
C9121 VPWR.n38 VGND 2.23997f
C9122 VPWR.n39 VGND 0.21393f
C9123 VPWR.n40 VGND 0.19116f
C9124 VPWR.n41 VGND 0.11816f
C9125 VPWR.n42 VGND 0.19182f
C9126 VPWR.t10 VGND 61.9971f
C9127 VPWR.t91 VGND 11.02534f
C9128 VPWR.n43 VGND 0.17446f
C9129 VPWR.n44 VGND 0.17446f
C9130 VPWR.t1 VGND 9.93693f
C9131 VPWR.n45 VGND 0.04552f
C9132 VPWR.n46 VGND 0.1774f
C9133 VPWR.n47 VGND 0.10126f
C9134 VPWR.n48 VGND 0.01224f
C9135 VPWR.n49 VGND 0.03057f
C9136 VPWR.n50 VGND 0.10417f
C9137 VPWR.n51 VGND 0.02861f
C9138 VPWR.t153 VGND 15.33536f
C9139 VPWR.n52 VGND 0.23412f
C9140 VPWR.n53 VGND 0.03956f
C9141 VPWR.n54 VGND 0.04289f
C9142 VPWR.n55 VGND 0.17513f
C9143 VPWR.n56 VGND 0.06559f
C9144 VPWR.n58 VGND 0.16506f
C9145 VPWR.n59 VGND 0.04907f
C9146 VPWR.n60 VGND 0.0627f
C9147 VPWR.n61 VGND 0.16506f
C9148 VPWR.n62 VGND 0.05929f
C9149 VPWR.n63 VGND 0.07566f
C9150 VPWR.n64 VGND 0.02203f
C9151 VPWR.t108 VGND 4.65638f
C9152 VPWR.n65 VGND 0.12163f
C9153 VPWR.n66 VGND 0.05647f
C9154 VPWR.n67 VGND 0.06317f
C9155 VPWR.n68 VGND 0.05874f
C9156 VPWR.n69 VGND 0.01293f
C9157 VPWR.n70 VGND 0.06385f
C9158 VPWR.n71 VGND 0.15109f
C9159 VPWR.n72 VGND 0.1268f
C9160 VPWR.n73 VGND 0.06541f
C9161 VPWR.n74 VGND 0.11866f
C9162 VPWR.n75 VGND 0.01646f
C9163 VPWR.n76 VGND 0.01937f
C9164 VPWR.n78 VGND 0.22991f
C9165 VPWR.n79 VGND 0.06559f
C9166 VPWR.n80 VGND 0.0714f
C9167 VPWR.n81 VGND 0.11816f
C9168 VPWR.t2 VGND 77.54649f
C9169 VPWR.n83 VGND 0.11979f
C9170 VPWR.n84 VGND 0.06591f
C9171 VPWR.n85 VGND 0.08417f
C9172 VPWR.n86 VGND 0.16715f
C9173 VPWR.n87 VGND 0.48303f
C9174 VPWR.n88 VGND 0.08412f
C9175 VPWR.t6 VGND 3.79298f
C9176 VPWR.n89 VGND 0.04907f
C9177 VPWR.n90 VGND 0.06564f
C9178 VPWR.n91 VGND 0.03358f
C9179 VPWR.n92 VGND 0.01897f
C9180 VPWR.n93 VGND 0.17446f
C9181 VPWR.n94 VGND 0.17494f
C9182 VPWR.n95 VGND 0.17446f
C9183 VPWR.n96 VGND 0.03192f
C9184 VPWR.n97 VGND 0.03192f
C9185 VPWR.n98 VGND 0.03192f
C9186 VPWR.n99 VGND 0.27253f
C9187 VPWR.n101 VGND 0.0266f
C9188 VPWR.n102 VGND 5.54197f
C9189 VPWR.t94 VGND 0.9108f
C9190 VPWR.t16 VGND 1.34133f
C9191 VPWR.t738 VGND 1.01352f
C9192 VPWR.t19 VGND 0.09484f
C9193 VPWR.t187 VGND 0.44931f
C9194 VPWR.n103 VGND 0.11414f
C9195 VPWR.t20 VGND 0.41513f
C9196 VPWR.n104 VGND 0.06801f
C9197 VPWR.n106 VGND 0.01958f
C9198 VPWR.n107 VGND 0.03006f
C9199 VPWR.n108 VGND 0.01216f
C9200 VPWR.t737 VGND 0.65354f
C9201 VPWR.n109 VGND 0.07095f
C9202 VPWR.n110 VGND 0.02354f
C9203 VPWR.t1024 VGND 0.04282f
C9204 VPWR.n111 VGND 0.05906f
C9205 VPWR.n112 VGND 0.01085f
C9206 VPWR.t191 VGND 4.25741f
C9207 VPWR.t214 VGND 1.83304f
C9208 VPWR.n113 VGND 0.43644f
C9209 VPWR.t352 VGND 2.75411f
C9210 VPWR.t469 VGND 3.57256f
C9211 VPWR.n114 VGND 0.14486f
C9212 VPWR.n115 VGND 0.23563f
C9213 VPWR.t200 VGND 2.15414f
C9214 VPWR.t566 VGND 0.41696f
C9215 VPWR.n116 VGND 0.01828f
C9216 VPWR.n117 VGND 0.08964f
C9217 VPWR.t440 VGND 0.4174f
C9218 VPWR.n118 VGND 0.14194f
C9219 VPWR.n119 VGND 0.02284f
C9220 VPWR.t198 VGND 0.195f
C9221 VPWR.n121 VGND 0.0778f
C9222 VPWR.n122 VGND 0.02284f
C9223 VPWR.n123 VGND 0.08977f
C9224 VPWR.t190 VGND 0.16495f
C9225 VPWR.n124 VGND 0.0819f
C9226 VPWR.n125 VGND 0.01231f
C9227 VPWR.t464 VGND 0.33735f
C9228 VPWR.n126 VGND 0.052f
C9229 VPWR.t21 VGND 0.41359f
C9230 VPWR.n127 VGND 0.10631f
C9231 VPWR.n128 VGND 0.08196f
C9232 VPWR.n129 VGND 0.01695f
C9233 VPWR.t228 VGND 0.82422f
C9234 VPWR.n130 VGND 0.09718f
C9235 VPWR.t371 VGND 0.45298f
C9236 VPWR.n131 VGND 0.14967f
C9237 VPWR.n132 VGND 0.03432f
C9238 VPWR.t130 VGND 1.02075f
C9239 VPWR.n133 VGND 0.12402f
C9240 VPWR.t1061 VGND 0.01615f
C9241 VPWR.t351 VGND 1.2218f
C9242 VPWR.n134 VGND 0.03253f
C9243 VPWR.n135 VGND 0.06667f
C9244 VPWR.n136 VGND 0.04906f
C9245 VPWR.t439 VGND 0.03481f
C9246 VPWR.n137 VGND 0.08287f
C9247 VPWR.t499 VGND 0.01615f
C9248 VPWR.t155 VGND 0.12835f
C9249 VPWR.n138 VGND 0.03253f
C9250 VPWR.n139 VGND 0.07335f
C9251 VPWR.n140 VGND 0.0636f
C9252 VPWR.t508 VGND 0.11719f
C9253 VPWR.n141 VGND 0.12401f
C9254 VPWR.t1309 VGND 0.06313f
C9255 VPWR.t1375 VGND 0.08032f
C9256 VPWR.n142 VGND 0.03253f
C9257 VPWR.n143 VGND 0.06667f
C9258 VPWR.n144 VGND 0.04906f
C9259 VPWR.t157 VGND 1.12555f
C9260 VPWR.t379 VGND 0.19364f
C9261 VPWR.t692 VGND 0.62914f
C9262 VPWR.n145 VGND 0.07602f
C9263 VPWR.t497 VGND 0.01615f
C9264 VPWR.t144 VGND 1.29064f
C9265 VPWR.n146 VGND 0.03253f
C9266 VPWR.n147 VGND 0.05847f
C9267 VPWR.t145 VGND 0.03481f
C9268 VPWR.n148 VGND 0.09025f
C9269 VPWR.n149 VGND 0.04906f
C9270 VPWR.t146 VGND 0.08301f
C9271 VPWR.n150 VGND 0.09031f
C9272 VPWR.t452 VGND 0.0402f
C9273 VPWR.t147 VGND 0.23173f
C9274 VPWR.n151 VGND 0.03253f
C9275 VPWR.n152 VGND 0.06667f
C9276 VPWR.n153 VGND 0.04906f
C9277 VPWR.t193 VGND 1.00566f
C9278 VPWR.n154 VGND 0.08926f
C9279 VPWR.t95 VGND 0.1578f
C9280 VPWR.t256 VGND 0.49747f
C9281 VPWR.n155 VGND 0.11457f
C9282 VPWR.t183 VGND 0.4806f
C9283 VPWR.n156 VGND 0.21221f
C9284 VPWR.n157 VGND 0.01039f
C9285 VPWR.t542 VGND 0.19412f
C9286 VPWR.n158 VGND 0.1739f
C9287 VPWR.t769 VGND 0.01615f
C9288 VPWR.t203 VGND 0.23697f
C9289 VPWR.n159 VGND 0.03253f
C9290 VPWR.n160 VGND 0.07535f
C9291 VPWR.t329 VGND 1.13155f
C9292 VPWR.n161 VGND 0.14919f
C9293 VPWR.n162 VGND 0.08954f
C9294 VPWR.t152 VGND 0.05894f
C9295 VPWR.n163 VGND 0.14912f
C9296 VPWR.n164 VGND 0.06361f
C9297 VPWR.t730 VGND 0.01615f
C9298 VPWR.t151 VGND 0.12857f
C9299 VPWR.n165 VGND 0.03253f
C9300 VPWR.n166 VGND 0.075f
C9301 VPWR.n167 VGND 0.01039f
C9302 VPWR.t317 VGND 0.19641f
C9303 VPWR.n168 VGND 0.06142f
C9304 VPWR.n169 VGND 0.01646f
C9305 VPWR.t385 VGND 0.20431f
C9306 VPWR.n170 VGND 0.05777f
C9307 VPWR.n171 VGND 0.02044f
C9308 VPWR.t318 VGND 0.03404f
C9309 VPWR.n172 VGND 0.06295f
C9310 VPWR.n173 VGND 0.01872f
C9311 VPWR.t343 VGND 0.70592f
C9312 VPWR.n174 VGND 0.06295f
C9313 VPWR.n175 VGND 0.02044f
C9314 VPWR.t204 VGND 0.19437f
C9315 VPWR.n176 VGND 0.05777f
C9316 VPWR.n177 VGND 0.0139f
C9317 VPWR.t189 VGND 0.77123f
C9318 VPWR.n178 VGND 0.06187f
C9319 VPWR.n179 VGND 0.03232f
C9320 VPWR.t562 VGND 0.53607f
C9321 VPWR.n180 VGND 0.06218f
C9322 VPWR.t363 VGND 0.34657f
C9323 VPWR.t459 VGND 0.59658f
C9324 VPWR.n182 VGND 0.06683f
C9325 VPWR.n183 VGND 0.06131f
C9326 VPWR.t197 VGND 0.15644f
C9327 VPWR.n184 VGND 0.064f
C9328 VPWR.n185 VGND 0.03205f
C9329 VPWR.n186 VGND 5.54197f
C9330 VPWR.n187 VGND 7.11146f
C9331 VPWR.n188 VGND 0.83795f
C9332 VPWR.n189 VGND 0.58831f
C9333 VPWR.n190 VGND 0.38133f
C9334 VPWR.n191 VGND 0.01573f
C9335 VPWR.n192 VGND 0.06973f
C9336 VPWR.t1215 VGND 0.61089f
C9337 VPWR.n193 VGND 0.08949f
C9338 VPWR.n194 VGND 0.0218f
C9339 VPWR.n195 VGND 0.0305f
C9340 VPWR.n196 VGND 0.01894f
C9341 VPWR.t631 VGND 1.11143f
C9342 VPWR.t699 VGND 0.04779f
C9343 VPWR.n197 VGND 0.08598f
C9344 VPWR.n198 VGND 0.01922f
C9345 VPWR.t629 VGND 0.04779f
C9346 VPWR.t1231 VGND 0.04779f
C9347 VPWR.n199 VGND 0.08575f
C9348 VPWR.n200 VGND 0.01932f
C9349 VPWR.t627 VGND 0.04779f
C9350 VPWR.t1229 VGND 0.04779f
C9351 VPWR.n201 VGND 0.08572f
C9352 VPWR.n202 VGND 0.01927f
C9353 VPWR.t625 VGND 0.04779f
C9354 VPWR.t1227 VGND 0.04779f
C9355 VPWR.n203 VGND 0.08588f
C9356 VPWR.n204 VGND 0.01905f
C9357 VPWR.t624 VGND 0.04436f
C9358 VPWR.t1226 VGND 0.04436f
C9359 VPWR.n205 VGND 0.10402f
C9360 VPWR.t639 VGND 0.01615f
C9361 VPWR.t667 VGND 1.17103f
C9362 VPWR.n207 VGND 0.03253f
C9363 VPWR.n208 VGND 0.02683f
C9364 VPWR.n209 VGND 0.01707f
C9365 VPWR.n210 VGND 0.01707f
C9366 VPWR.n211 VGND 0.03281f
C9367 VPWR.n212 VGND 0.01085f
C9368 VPWR.t22 VGND 0.20603f
C9369 VPWR.n213 VGND 0.0774f
C9370 VPWR.t1087 VGND 0.76767f
C9371 VPWR.t23 VGND 0.63666f
C9372 VPWR.n214 VGND 0.1774f
C9373 VPWR.n215 VGND 0.14976f
C9374 VPWR.t25 VGND 0.46823f
C9375 VPWR.n216 VGND 0.05863f
C9376 VPWR.n217 VGND 0.01317f
C9377 VPWR.t1002 VGND 0.04732f
C9378 VPWR.n218 VGND 0.06461f
C9379 VPWR.t580 VGND 0.58132f
C9380 VPWR.t1358 VGND 0.36597f
C9381 VPWR.n219 VGND 0.06808f
C9382 VPWR.n220 VGND 0.06687f
C9383 VPWR.n221 VGND 0.0341f
C9384 VPWR.t682 VGND 0.73561f
C9385 VPWR.t1081 VGND 0.05058f
C9386 VPWR.n222 VGND 0.06818f
C9387 VPWR.t68 VGND 0.03924f
C9388 VPWR.t11 VGND 0.17995f
C9389 VPWR.t69 VGND 0.65191f
C9390 VPWR.t12 VGND 0.37028f
C9391 VPWR.t71 VGND 0.64902f
C9392 VPWR.t14 VGND 0.22667f
C9393 VPWR.t1300 VGND 0.01615f
C9394 VPWR.t935 VGND 0.12258f
C9395 VPWR.n223 VGND 0.03253f
C9396 VPWR.n224 VGND 0.05985f
C9397 VPWR.t365 VGND 0.04895f
C9398 VPWR.n225 VGND 0.07947f
C9399 VPWR.t681 VGND 0.05594f
C9400 VPWR.n226 VGND 0.15971f
C9401 VPWR.t668 VGND 0.08978f
C9402 VPWR.n227 VGND 0.16012f
C9403 VPWR.t990 VGND 0.41949f
C9404 VPWR.n228 VGND 0.07954f
C9405 VPWR.t1350 VGND 0.04779f
C9406 VPWR.t700 VGND 0.04779f
C9407 VPWR.n229 VGND 0.09456f
C9408 VPWR.n230 VGND 0.01483f
C9409 VPWR.t1276 VGND 0.04436f
C9410 VPWR.t1278 VGND 0.01615f
C9411 VPWR.t560 VGND 0.67195f
C9412 VPWR.n231 VGND 0.03253f
C9413 VPWR.n232 VGND 0.02673f
C9414 VPWR.n233 VGND 0.05453f
C9415 VPWR.t1277 VGND 0.11114f
C9416 VPWR.n234 VGND 0.06561f
C9417 VPWR.n235 VGND 0.01922f
C9418 VPWR.t559 VGND 2.00327f
C9419 VPWR.n236 VGND 0.10501f
C9420 VPWR.n237 VGND 0.06835f
C9421 VPWR.t485 VGND 2.82048f
C9422 VPWR.n238 VGND 0.1098f
C9423 VPWR.t992 VGND 0.05543f
C9424 VPWR.n239 VGND 0.07284f
C9425 VPWR.n240 VGND 0.01929f
C9426 VPWR.t1263 VGND 0.195f
C9427 VPWR.t1080 VGND 0.15707f
C9428 VPWR.n241 VGND 0.0679f
C9429 VPWR.n242 VGND 0.07304f
C9430 VPWR.t603 VGND 0.41909f
C9431 VPWR.t1302 VGND 0.19362f
C9432 VPWR.n243 VGND 0.28347f
C9433 VPWR.n244 VGND 0.03762f
C9434 VPWR.t522 VGND 0.95742f
C9435 VPWR.t529 VGND 1.13941f
C9436 VPWR.n245 VGND 0.04906f
C9437 VPWR.t1058 VGND 0.14016f
C9438 VPWR.t521 VGND 0.23384f
C9439 VPWR.n246 VGND 0.03253f
C9440 VPWR.t658 VGND 0.01615f
C9441 VPWR.t527 VGND 0.12301f
C9442 VPWR.n247 VGND 0.03253f
C9443 VPWR.n248 VGND 0.06371f
C9444 VPWR.t60 VGND 0.03924f
C9445 VPWR.t964 VGND 0.1516f
C9446 VPWR.n249 VGND 0.09703f
C9447 VPWR.t340 VGND 0.03481f
C9448 VPWR.t659 VGND 0.01615f
C9449 VPWR.t1128 VGND 0.08033f
C9450 VPWR.n251 VGND 0.03253f
C9451 VPWR.n252 VGND 0.31043f
C9452 VPWR.n253 VGND 0.05614f
C9453 VPWR.n254 VGND 0.03981f
C9454 VPWR.t92 VGND 0.04895f
C9455 VPWR.n255 VGND 0.19339f
C9456 VPWR.n256 VGND 0.07091f
C9457 VPWR.t129 VGND 0.42165f
C9458 VPWR.n257 VGND 0.06718f
C9459 VPWR.t230 VGND 0.19489f
C9460 VPWR.n259 VGND 0.07621f
C9461 VPWR.n260 VGND 0.02963f
C9462 VPWR.t314 VGND 0.19783f
C9463 VPWR.t710 VGND 0.04779f
C9464 VPWR.n261 VGND 0.06081f
C9465 VPWR.n262 VGND 0.04419f
C9466 VPWR.n263 VGND 0.0137f
C9467 VPWR.t277 VGND 0.04779f
C9468 VPWR.t369 VGND 0.55024f
C9469 VPWR.t278 VGND 1.08762f
C9470 VPWR.t280 VGND 0.04779f
C9471 VPWR.t282 VGND 0.04779f
C9472 VPWR.t436 VGND 0.46126f
C9473 VPWR.n264 VGND 0.04638f
C9474 VPWR.n265 VGND 0.0178f
C9475 VPWR.t284 VGND 0.04436f
C9476 VPWR.n266 VGND 0.05879f
C9477 VPWR.n267 VGND 0.0144f
C9478 VPWR.t1410 VGND 0.20414f
C9479 VPWR.n268 VGND 0.05757f
C9480 VPWR.n269 VGND 0.0106f
C9481 VPWR.t313 VGND 0.81475f
C9482 VPWR.n270 VGND 0.04083f
C9483 VPWR.n271 VGND 0.01719f
C9484 VPWR.t1057 VGND 0.0647f
C9485 VPWR.n272 VGND 0.05735f
C9486 VPWR.n273 VGND 0.01983f
C9487 VPWR.t1293 VGND 0.55769f
C9488 VPWR.t732 VGND 0.04143f
C9489 VPWR.n274 VGND 0.06127f
C9490 VPWR.n275 VGND 0.05823f
C9491 VPWR.t1049 VGND 0.90942f
C9492 VPWR.n276 VGND 0.1623f
C9493 VPWR.t113 VGND 0.39832f
C9494 VPWR.t614 VGND 0.04282f
C9495 VPWR.n277 VGND 0.02735f
C9496 VPWR.t419 VGND 0.04313f
C9497 VPWR.n278 VGND 0.06561f
C9498 VPWR.n279 VGND 0.0192f
C9499 VPWR.t881 VGND 0.03227f
C9500 VPWR.n280 VGND 0.07389f
C9501 VPWR.n281 VGND 0.03153f
C9502 VPWR.t815 VGND 0.30068f
C9503 VPWR.n282 VGND 0.08563f
C9504 VPWR.n283 VGND 0.01733f
C9505 VPWR.t125 VGND 0.04895f
C9506 VPWR.n284 VGND 0.22971f
C9507 VPWR.t418 VGND 1.03899f
C9508 VPWR.n285 VGND 0.16831f
C9509 VPWR.n286 VGND 0.01689f
C9510 VPWR.t414 VGND 0.90271f
C9511 VPWR.n287 VGND 0.05086f
C9512 VPWR.n288 VGND 0.03336f
C9513 VPWR.t1006 VGND 0.01615f
C9514 VPWR.t417 VGND 1.3296f
C9515 VPWR.n289 VGND 0.03253f
C9516 VPWR.n290 VGND 0.04293f
C9517 VPWR.n291 VGND 0.01702f
C9518 VPWR.t188 VGND 0.34368f
C9519 VPWR.t415 VGND 0.08033f
C9520 VPWR.n292 VGND 0.03253f
C9521 VPWR.n293 VGND 0.02505f
C9522 VPWR.n294 VGND 0.0111f
C9523 VPWR.t602 VGND 0.20907f
C9524 VPWR.n295 VGND 0.06566f
C9525 VPWR.n296 VGND 0.02773f
C9526 VPWR.t784 VGND 0.71572f
C9527 VPWR.n297 VGND 0.07028f
C9528 VPWR.n298 VGND 0.01292f
C9529 VPWR.t1257 VGND 0.64688f
C9530 VPWR.n299 VGND 0.04615f
C9531 VPWR.n300 VGND 0.01486f
C9532 VPWR.t570 VGND 0.0647f
C9533 VPWR.n301 VGND 0.05762f
C9534 VPWR.n302 VGND 0.01757f
C9535 VPWR.t432 VGND 0.78823f
C9536 VPWR.n303 VGND 0.04008f
C9537 VPWR.n304 VGND 0.01195f
C9538 VPWR.t572 VGND 0.52211f
C9539 VPWR.n305 VGND 0.05648f
C9540 VPWR.n306 VGND 0.02562f
C9541 VPWR.t563 VGND 0.16011f
C9542 VPWR.t350 VGND 0.16853f
C9543 VPWR.n307 VGND 0.05112f
C9544 VPWR.n308 VGND 0.06816f
C9545 VPWR.n309 VGND 0.0328f
C9546 VPWR.t1096 VGND 0.4159f
C9547 VPWR.t578 VGND 0.21876f
C9548 VPWR.n310 VGND 0.06811f
C9549 VPWR.n311 VGND 0.05901f
C9550 VPWR.n312 VGND 0.03435f
C9551 VPWR.t119 VGND 0.5864f
C9552 VPWR.t505 VGND 0.04895f
C9553 VPWR.n313 VGND 0.28319f
C9554 VPWR.t524 VGND 0.95798f
C9555 VPWR.t90 VGND 0.95044f
C9556 VPWR.n314 VGND 0.21356f
C9557 VPWR.n315 VGND 0.04905f
C9558 VPWR.t1050 VGND 0.01615f
C9559 VPWR.t525 VGND 0.17235f
C9560 VPWR.n316 VGND 0.03253f
C9561 VPWR.t213 VGND 0.01615f
C9562 VPWR.t518 VGND 0.08033f
C9563 VPWR.n317 VGND 0.03253f
C9564 VPWR.n318 VGND 0.08756f
C9565 VPWR.n319 VGND 0.02902f
C9566 VPWR.t63 VGND 0.03923f
C9567 VPWR.t26 VGND 0.03923f
C9568 VPWR.n320 VGND 0.13125f
C9569 VPWR.t59 VGND 0.04212f
C9570 VPWR.t27 VGND 0.15448f
C9571 VPWR.n321 VGND 0.83795f
C9572 VPWR.t75 VGND 0.03924f
C9573 VPWR.n322 VGND 0.04908f
C9574 VPWR.t56 VGND 0.21066f
C9575 VPWR.n323 VGND 0.16507f
C9576 VPWR.n324 VGND 0.06317f
C9577 VPWR.t407 VGND 0.01615f
C9578 VPWR.t132 VGND 1.07475f
C9579 VPWR.n326 VGND 0.03253f
C9580 VPWR.n327 VGND 0.02683f
C9581 VPWR.n328 VGND 0.01902f
C9582 VPWR.n329 VGND 0.01768f
C9583 VPWR.n331 VGND 0.03144f
C9584 VPWR.n332 VGND 0.02205f
C9585 VPWR.t721 VGND 0.62253f
C9586 VPWR.n333 VGND 0.06297f
C9587 VPWR.n334 VGND 0.02861f
C9588 VPWR.n335 VGND 0.03711f
C9589 VPWR.n336 VGND 0.04906f
C9590 VPWR.t846 VGND 0.9468f
C9591 VPWR.n337 VGND 0.09028f
C9592 VPWR.n338 VGND 0.05241f
C9593 VPWR.t121 VGND 0.04895f
C9594 VPWR.n339 VGND 0.20459f
C9595 VPWR.n340 VGND 0.06231f
C9596 VPWR.t215 VGND 1.06287f
C9597 VPWR.n341 VGND 0.09755f
C9598 VPWR.n342 VGND 0.0305f
C9599 VPWR.n343 VGND 0.02353f
C9600 VPWR.t1409 VGND 0.05118f
C9601 VPWR.t1270 VGND 0.05118f
C9602 VPWR.n344 VGND 0.10313f
C9603 VPWR.t1199 VGND 0.11315f
C9604 VPWR.t1271 VGND 0.98359f
C9605 VPWR.n345 VGND 0.12198f
C9606 VPWR.t1183 VGND 0.20321f
C9607 VPWR.t645 VGND 0.68593f
C9608 VPWR.t247 VGND 0.1516f
C9609 VPWR.t64 VGND 0.34742f
C9610 VPWR.t44 VGND 0.15448f
C9611 VPWR.t65 VGND 0.51092f
C9612 VPWR.n346 VGND 1.2242f
C9613 VPWR.t240 VGND 0.03924f
C9614 VPWR.t246 VGND 0.82761f
C9615 VPWR.t1345 VGND 0.20273f
C9616 VPWR.n347 VGND 0.05271f
C9617 VPWR.n349 VGND 0.02596f
C9618 VPWR.t638 VGND 0.04732f
C9619 VPWR.n350 VGND 0.0649f
C9620 VPWR.n351 VGND 0.0154f
C9621 VPWR.t88 VGND 0.6935f
C9622 VPWR.n352 VGND 0.06942f
C9623 VPWR.n353 VGND 0.01317f
C9624 VPWR.t85 VGND 0.04049f
C9625 VPWR.t86 VGND 0.6964f
C9626 VPWR.n354 VGND 0.17736f
C9627 VPWR.t637 VGND 0.04164f
C9628 VPWR.n355 VGND 0.1498f
C9629 VPWR.n356 VGND 0.0774f
C9630 VPWR.t292 VGND 0.20565f
C9631 VPWR.t1101 VGND 0.61972f
C9632 VPWR.n357 VGND 0.06716f
C9633 VPWR.n358 VGND 0.05262f
C9634 VPWR.n359 VGND 0.01898f
C9635 VPWR.t220 VGND 0.12033f
C9636 VPWR.n360 VGND 0.0658f
C9637 VPWR.t987 VGND 0.65116f
C9638 VPWR.n361 VGND 0.0459f
C9639 VPWR.n362 VGND 0.02005f
C9640 VPWR.t241 VGND 0.15826f
C9641 VPWR.t41 VGND 0.8305f
C9642 VPWR.t243 VGND 0.15537f
C9643 VPWR.t42 VGND 0.03923f
C9644 VPWR.t244 VGND 0.09483f
C9645 VPWR.n363 VGND 0.01573f
C9646 VPWR.n364 VGND 0.02357f
C9647 VPWR.n365 VGND 0.02062f
C9648 VPWR.n367 VGND 0.01894f
C9649 VPWR.t1039 VGND 0.04779f
C9650 VPWR.n368 VGND 0.04947f
C9651 VPWR.n369 VGND 0.01622f
C9652 VPWR.n370 VGND 0.01927f
C9653 VPWR.t1033 VGND 0.04779f
C9654 VPWR.n371 VGND 0.05767f
C9655 VPWR.n372 VGND 0.01905f
C9656 VPWR.t1032 VGND 0.04436f
C9657 VPWR.n373 VGND 0.06693f
C9658 VPWR.t860 VGND 0.01615f
C9659 VPWR.t845 VGND 0.08032f
C9660 VPWR.n375 VGND 0.03253f
C9661 VPWR.n376 VGND 0.05852f
C9662 VPWR.n377 VGND 0.04906f
C9663 VPWR.n378 VGND 0.04906f
C9664 VPWR.n379 VGND 0.03839f
C9665 VPWR.t1066 VGND 0.13962f
C9666 VPWR.n380 VGND 0.07363f
C9667 VPWR.n381 VGND 0.01719f
C9668 VPWR.t918 VGND 0.15645f
C9669 VPWR.n382 VGND 0.06603f
C9670 VPWR.n383 VGND 0.0217f
C9671 VPWR.n384 VGND 0.0192f
C9672 VPWR.t535 VGND 0.04313f
C9673 VPWR.n385 VGND 0.04901f
C9674 VPWR.t245 VGND 0.0933f
C9675 VPWR.n386 VGND 0.10631f
C9676 VPWR.n387 VGND 0.09248f
C9677 VPWR.n388 VGND 0.01597f
C9678 VPWR.t937 VGND 0.03227f
C9679 VPWR.n389 VGND 0.04819f
C9680 VPWR.t916 VGND 0.29667f
C9681 VPWR.n391 VGND 0.0459f
C9682 VPWR.t341 VGND 0.03404f
C9683 VPWR.n392 VGND 0.06291f
C9684 VPWR.n393 VGND 0.0175f
C9685 VPWR.t1170 VGND 0.1959f
C9686 VPWR.n394 VGND 0.11185f
C9687 VPWR.t896 VGND 0.09628f
C9688 VPWR.n395 VGND 0.08391f
C9689 VPWR.n396 VGND 0.01922f
C9690 VPWR.t897 VGND 0.08888f
C9691 VPWR.n397 VGND 0.06666f
C9692 VPWR.t421 VGND 0.0933f
C9693 VPWR.t839 VGND 0.08033f
C9694 VPWR.n398 VGND 0.03253f
C9695 VPWR.n399 VGND 0.05847f
C9696 VPWR.t840 VGND 1.00039f
C9697 VPWR.n401 VGND 0.09025f
C9698 VPWR.t644 VGND 0.90173f
C9699 VPWR.n402 VGND 0.09031f
C9700 VPWR.n403 VGND 0.03006f
C9701 VPWR.t1035 VGND 0.04779f
C9702 VPWR.n404 VGND 0.06844f
C9703 VPWR.t392 VGND 0.19445f
C9704 VPWR.n405 VGND 0.052f
C9705 VPWR.t1037 VGND 0.04779f
C9706 VPWR.n406 VGND 0.05169f
C9707 VPWR.t1323 VGND 0.04779f
C9708 VPWR.n408 VGND 0.06636f
C9709 VPWR.t939 VGND 0.10006f
C9710 VPWR.n409 VGND 0.05653f
C9711 VPWR.n410 VGND 0.02073f
C9712 VPWR.t841 VGND 0.03227f
C9713 VPWR.n411 VGND 0.05769f
C9714 VPWR.t163 VGND 0.04701f
C9715 VPWR.n412 VGND 0.03086f
C9716 VPWR.n413 VGND 0.01573f
C9717 VPWR.t719 VGND 0.34471f
C9718 VPWR.t1082 VGND 0.27086f
C9719 VPWR.n414 VGND 0.11224f
C9720 VPWR.t579 VGND 0.19355f
C9721 VPWR.t494 VGND 0.05058f
C9722 VPWR.n415 VGND 0.11796f
C9723 VPWR.n416 VGND 0.03708f
C9724 VPWR.t1396 VGND 0.19554f
C9725 VPWR.n417 VGND 0.07947f
C9726 VPWR.t634 VGND 0.01615f
C9727 VPWR.t677 VGND 1.16352f
C9728 VPWR.n418 VGND 0.03253f
C9729 VPWR.n419 VGND 0.03502f
C9730 VPWR.n420 VGND 0.01707f
C9731 VPWR.t332 VGND 0.18858f
C9732 VPWR.n421 VGND 0.15971f
C9733 VPWR.t141 VGND 0.03481f
C9734 VPWR.n422 VGND 0.16012f
C9735 VPWR.n423 VGND 0.06541f
C9736 VPWR.t483 VGND 0.04895f
C9737 VPWR.n424 VGND 0.07954f
C9738 VPWR.n425 VGND 0.01707f
C9739 VPWR.t429 VGND 0.7549f
C9740 VPWR.t142 VGND 0.08032f
C9741 VPWR.n426 VGND 0.03253f
C9742 VPWR.n427 VGND 0.02683f
C9743 VPWR.t1383 VGND 0.03924f
C9744 VPWR.t73 VGND 0.36421f
C9745 VPWR.n428 VGND 0.09703f
C9746 VPWR.t8 VGND 0.6118f
C9747 VPWR.t221 VGND 4.819f
C9748 VPWR.t264 VGND 0.05142f
C9749 VPWR.t109 VGND 0.19397f
C9750 VPWR.n430 VGND 0.11412f
C9751 VPWR.n431 VGND 0.03711f
C9752 VPWR.t834 VGND 0.32083f
C9753 VPWR.n432 VGND 0.10733f
C9754 VPWR.n433 VGND 0.03381f
C9755 VPWR.t276 VGND 0.19727f
C9756 VPWR.n434 VGND 0.09054f
C9757 VPWR.n435 VGND 0.02192f
C9758 VPWR.t889 VGND 0.04779f
C9759 VPWR.n436 VGND 0.05832f
C9760 VPWR.n437 VGND 0.01829f
C9761 VPWR.t1214 VGND 0.19226f
C9762 VPWR.n438 VGND 0.03991f
C9763 VPWR.t891 VGND 0.15318f
C9764 VPWR.n440 VGND 0.04821f
C9765 VPWR.n441 VGND 0.01922f
C9766 VPWR.t1313 VGND 0.04779f
C9767 VPWR.n442 VGND 0.05755f
C9768 VPWR.n443 VGND 0.01932f
C9769 VPWR.t1315 VGND 0.04779f
C9770 VPWR.t1115 VGND 0.03404f
C9771 VPWR.n444 VGND 0.08303f
C9772 VPWR.n445 VGND 0.01927f
C9773 VPWR.t1317 VGND 0.95038f
C9774 VPWR.n446 VGND 0.06419f
C9775 VPWR.t1319 VGND 0.04557f
C9776 VPWR.n447 VGND 0.08239f
C9777 VPWR.n448 VGND 0.22801f
C9778 VPWR.n449 VGND 0.30737f
C9779 VPWR.t3 VGND 3.90117f
C9780 VPWR.n450 VGND 0.01483f
C9781 VPWR.n451 VGND 0.04906f
C9782 VPWR.n452 VGND 0.03144f
C9783 VPWR.t851 VGND 0.06908f
C9784 VPWR.t822 VGND 0.08033f
C9785 VPWR.n453 VGND 0.03253f
C9786 VPWR.n454 VGND 0.05892f
C9787 VPWR.n455 VGND 0.01957f
C9788 VPWR.n456 VGND 0.03509f
C9789 VPWR.t820 VGND 0.19643f
C9790 VPWR.n457 VGND 0.09676f
C9791 VPWR.n458 VGND 0.03795f
C9792 VPWR.n459 VGND 0.01781f
C9793 VPWR.t858 VGND 0.55545f
C9794 VPWR.t816 VGND 0.26278f
C9795 VPWR.n460 VGND 0.04176f
C9796 VPWR.n461 VGND 0.04846f
C9797 VPWR.n463 VGND 0.01909f
C9798 VPWR.n464 VGND 0.02365f
C9799 VPWR.n465 VGND 0.02005f
C9800 VPWR.t892 VGND 0.5631f
C9801 VPWR.n466 VGND 0.0658f
C9802 VPWR.n467 VGND 0.01898f
C9803 VPWR.n469 VGND 0.02182f
C9804 VPWR.t83 VGND 0.03922f
C9805 VPWR.t37 VGND 0.10072f
C9806 VPWR.n470 VGND 0.05665f
C9807 VPWR.n471 VGND 0.05271f
C9808 VPWR.t84 VGND 0.03769f
C9809 VPWR.n472 VGND 0.09678f
C9810 VPWR.t38 VGND 0.42108f
C9811 VPWR.t40 VGND 0.3567f
C9812 VPWR.n473 VGND 0.0648f
C9813 VPWR.t512 VGND 0.04376f
C9814 VPWR.n474 VGND 0.08199f
C9815 VPWR.t911 VGND 0.55178f
C9816 VPWR.t405 VGND 0.29052f
C9817 VPWR.n475 VGND 0.05262f
C9818 VPWR.n476 VGND 0.07498f
C9819 VPWR.n477 VGND 0.03831f
C9820 VPWR.t303 VGND 0.04282f
C9821 VPWR.n478 VGND 0.05648f
C9822 VPWR.t422 VGND 0.36778f
C9823 VPWR.n479 VGND 0.0459f
C9824 VPWR.n481 VGND 0.04567f
C9825 VPWR.t675 VGND 0.43553f
C9826 VPWR.t291 VGND 0.63585f
C9827 VPWR.n482 VGND 0.08392f
C9828 VPWR.n483 VGND 0.02523f
C9829 VPWR.t239 VGND 0.20566f
C9830 VPWR.n484 VGND 0.10634f
C9831 VPWR.n485 VGND 0.08193f
C9832 VPWR.t238 VGND 0.20719f
C9833 VPWR.n486 VGND 0.06942f
C9834 VPWR.n487 VGND 0.01951f
C9835 VPWR.t893 VGND 1.88427f
C9836 VPWR.n488 VGND 0.06368f
C9837 VPWR.n489 VGND 0.02139f
C9838 VPWR.t122 VGND 0.29943f
C9839 VPWR.n490 VGND 0.06603f
C9840 VPWR.n491 VGND 0.02397f
C9841 VPWR.t819 VGND 0.17237f
C9842 VPWR.n492 VGND 0.05783f
C9843 VPWR.t349 VGND 0.19433f
C9844 VPWR.n493 VGND 0.08246f
C9845 VPWR.n494 VGND 0.01648f
C9846 VPWR.t849 VGND 0.42133f
C9847 VPWR.n495 VGND 0.09753f
C9848 VPWR.t850 VGND 0.19595f
C9849 VPWR.n496 VGND 0.08677f
C9850 VPWR.n497 VGND 0.03711f
C9851 VPWR.t673 VGND 0.03481f
C9852 VPWR.n498 VGND 0.05095f
C9853 VPWR.n499 VGND 0.01902f
C9854 VPWR.t836 VGND 0.90291f
C9855 VPWR.n500 VGND 0.05088f
C9856 VPWR.n501 VGND 0.03149f
C9857 VPWR.t420 VGND 0.01615f
C9858 VPWR.t672 VGND 1.13012f
C9859 VPWR.n502 VGND 0.03253f
C9860 VPWR.n503 VGND 0.05076f
C9861 VPWR.t979 VGND 0.01615f
C9862 VPWR.t778 VGND 0.17057f
C9863 VPWR.n504 VGND 0.03253f
C9864 VPWR.n505 VGND 0.05847f
C9865 VPWR.t406 VGND 0.03481f
C9866 VPWR.n507 VGND 0.11572f
C9867 VPWR.t853 VGND 0.04895f
C9868 VPWR.n508 VGND 0.14794f
C9869 VPWR.n509 VGND 0.0381f
C9870 VPWR.t953 VGND 0.04436f
C9871 VPWR.n510 VGND 0.09087f
C9872 VPWR.t954 VGND 0.04779f
C9873 VPWR.n511 VGND 0.05972f
C9874 VPWR.n512 VGND 0.01905f
C9875 VPWR.t956 VGND 0.04779f
C9876 VPWR.n513 VGND 0.06337f
C9877 VPWR.n514 VGND 0.01542f
C9878 VPWR.t958 VGND 0.04779f
C9879 VPWR.t347 VGND 0.19458f
C9880 VPWR.n515 VGND 0.05655f
C9881 VPWR.n516 VGND 0.04519f
C9882 VPWR.n517 VGND 0.01922f
C9883 VPWR.t960 VGND 0.94778f
C9884 VPWR.n518 VGND 0.05777f
C9885 VPWR.t901 VGND 0.67433f
C9886 VPWR.t969 VGND 0.8975f
C9887 VPWR.n519 VGND 0.0539f
C9888 VPWR.n520 VGND 0.03813f
C9889 VPWR.n521 VGND 0.01243f
C9890 VPWR.t373 VGND 0.2684f
C9891 VPWR.n522 VGND 0.07948f
C9892 VPWR.t862 VGND 0.01615f
C9893 VPWR.t599 VGND 0.12124f
C9894 VPWR.n523 VGND 0.03253f
C9895 VPWR.n524 VGND 0.03502f
C9896 VPWR.n525 VGND 0.01707f
C9897 VPWR.t600 VGND 0.03481f
C9898 VPWR.n526 VGND 0.15965f
C9899 VPWR.t708 VGND 0.03481f
C9900 VPWR.n527 VGND 0.16012f
C9901 VPWR.n528 VGND 0.06541f
C9902 VPWR.t926 VGND 0.04895f
C9903 VPWR.n529 VGND 0.07954f
C9904 VPWR.n530 VGND 0.01707f
C9905 VPWR.t975 VGND 0.01615f
C9906 VPWR.t425 VGND 0.08032f
C9907 VPWR.n531 VGND 0.03253f
C9908 VPWR.t35 VGND 0.03924f
C9909 VPWR.t1378 VGND 0.03924f
C9910 VPWR.n532 VGND 0.04901f
C9911 VPWR.n533 VGND 0.03843f
C9912 VPWR.t800 VGND 0.30201f
C9913 VPWR.n534 VGND 0.09977f
C9914 VPWR.t765 VGND 0.18818f
C9915 VPWR.n535 VGND 0.07635f
C9916 VPWR.t262 VGND 0.04895f
C9917 VPWR.n537 VGND 0.06836f
C9918 VPWR.n538 VGND 0.02918f
C9919 VPWR.t455 VGND 1.02971f
C9920 VPWR.n539 VGND 0.04738f
C9921 VPWR.t967 VGND 0.09672f
C9922 VPWR.n541 VGND 0.04798f
C9923 VPWR.n542 VGND 0.01894f
C9924 VPWR.t872 VGND 0.05545f
C9925 VPWR.n543 VGND 0.05777f
C9926 VPWR.n544 VGND 0.01584f
C9927 VPWR.t873 VGND 0.64157f
C9928 VPWR.t902 VGND 0.04436f
C9929 VPWR.n545 VGND 0.05196f
C9930 VPWR.n546 VGND 0.04605f
C9931 VPWR.n547 VGND 0.01618f
C9932 VPWR.t875 VGND 0.04779f
C9933 VPWR.t903 VGND 0.04779f
C9934 VPWR.n548 VGND 0.04393f
C9935 VPWR.n549 VGND 0.04493f
C9936 VPWR.n550 VGND 0.01629f
C9937 VPWR.t877 VGND 0.04779f
C9938 VPWR.t905 VGND 0.22957f
C9939 VPWR.n551 VGND 0.04493f
C9940 VPWR.n552 VGND 0.04393f
C9941 VPWR.n553 VGND 0.01618f
C9942 VPWR.t879 VGND 0.04436f
C9943 VPWR.t907 VGND 0.04779f
C9944 VPWR.n554 VGND 0.04605f
C9945 VPWR.n555 VGND 0.05196f
C9946 VPWR.n556 VGND 0.01584f
C9947 VPWR.t886 VGND 0.41136f
C9948 VPWR.n557 VGND 0.04821f
C9949 VPWR.t882 VGND 0.26359f
C9950 VPWR.n559 VGND 0.03072f
C9951 VPWR.n560 VGND 0.01987f
C9952 VPWR.t887 VGND 0.04779f
C9953 VPWR.n561 VGND 0.03991f
C9954 VPWR.n562 VGND 0.01268f
C9955 VPWR.t1060 VGND 0.08193f
C9956 VPWR.n563 VGND 0.07051f
C9957 VPWR.t766 VGND 0.19506f
C9958 VPWR.t263 VGND 0.19511f
C9959 VPWR.n564 VGND 0.27553f
C9960 VPWR.t173 VGND 0.31242f
C9961 VPWR.t413 VGND 0.26755f
C9962 VPWR.n565 VGND 0.14947f
C9963 VPWR.t259 VGND 0.03481f
C9964 VPWR.n566 VGND 0.12384f
C9965 VPWR.n567 VGND 0.09014f
C9966 VPWR.t597 VGND 0.01615f
C9967 VPWR.t748 VGND 0.22398f
C9968 VPWR.n568 VGND 0.03253f
C9969 VPWR.n569 VGND 0.08246f
C9970 VPWR.t948 VGND 0.04436f
C9971 VPWR.t138 VGND 0.9708f
C9972 VPWR.n570 VGND 0.01905f
C9973 VPWR.t946 VGND 0.04779f
C9974 VPWR.n571 VGND 0.05767f
C9975 VPWR.n572 VGND 0.01927f
C9976 VPWR.t944 VGND 0.04779f
C9977 VPWR.n573 VGND 0.04884f
C9978 VPWR.n574 VGND 0.01548f
C9979 VPWR.t830 VGND 0.09569f
C9980 VPWR.t139 VGND 0.12121f
C9981 VPWR.n575 VGND 0.03253f
C9982 VPWR.n576 VGND 0.01689f
C9983 VPWR.t942 VGND 0.16097f
C9984 VPWR.n578 VGND 0.04897f
C9985 VPWR.n579 VGND 0.01922f
C9986 VPWR.t941 VGND 0.04779f
C9987 VPWR.n580 VGND 0.05777f
C9988 VPWR.n581 VGND 0.01894f
C9989 VPWR.t950 VGND 0.04779f
C9990 VPWR.n582 VGND 0.07425f
C9991 VPWR.n583 VGND 0.02838f
C9992 VPWR.t140 VGND 0.10443f
C9993 VPWR.n584 VGND 0.07349f
C9994 VPWR.n585 VGND 0.01732f
C9995 VPWR.t938 VGND 0.03227f
C9996 VPWR.t428 VGND 0.04282f
C9997 VPWR.n586 VGND 0.04519f
C9998 VPWR.n587 VGND 0.0427f
C9999 VPWR.n588 VGND 0.01708f
C10000 VPWR.t427 VGND 0.04436f
C10001 VPWR.n589 VGND 0.05709f
C10002 VPWR.t1380 VGND 0.03769f
C10003 VPWR.n591 VGND 0.09678f
C10004 VPWR.t1381 VGND 0.03922f
C10005 VPWR.t36 VGND 1.2314f
C10006 VPWR.t1379 VGND 0.03923f
C10007 VPWR.t34 VGND 1.23429f
C10008 VPWR.t1377 VGND 0.04212f
C10009 VPWR.t29 VGND 0.03924f
C10010 VPWR.n592 VGND 0.06764f
C10011 VPWR.n593 VGND 0.04906f
C10012 VPWR.n594 VGND 0.03762f
C10013 VPWR.t642 VGND 0.04895f
C10014 VPWR.n595 VGND 0.22672f
C10015 VPWR.n596 VGND 0.01483f
C10016 VPWR.n597 VGND 0.01951f
C10017 VPWR.t33 VGND 0.03922f
C10018 VPWR.n598 VGND 0.06143f
C10019 VPWR.t31 VGND 0.08898f
C10020 VPWR.n600 VGND 0.07017f
C10021 VPWR.t30 VGND 0.09188f
C10022 VPWR.t107 VGND 0.04895f
C10023 VPWR.n601 VGND 0.21884f
C10024 VPWR.n602 VGND 0.02177f
C10025 VPWR.t136 VGND 0.03481f
C10026 VPWR.n603 VGND 0.19638f
C10027 VPWR.n604 VGND 0.04906f
C10028 VPWR.t165 VGND 0.92436f
C10029 VPWR.t137 VGND 0.22829f
C10030 VPWR.n605 VGND 0.03253f
C10031 VPWR.n606 VGND 0.05852f
C10032 VPWR.t1420 VGND 0.04436f
C10033 VPWR.n608 VGND 0.06693f
C10034 VPWR.n609 VGND 0.01905f
C10035 VPWR.t1418 VGND 0.04779f
C10036 VPWR.n610 VGND 0.05767f
C10037 VPWR.n611 VGND 0.01927f
C10038 VPWR.t1416 VGND 0.04779f
C10039 VPWR.n612 VGND 0.05752f
C10040 VPWR.n613 VGND 0.01932f
C10041 VPWR.t1414 VGND 0.04779f
C10042 VPWR.n614 VGND 0.05755f
C10043 VPWR.n615 VGND 0.01922f
C10044 VPWR.t1349 VGND 0.0549f
C10045 VPWR.n616 VGND 0.05777f
C10046 VPWR.t1347 VGND 0.04779f
C10047 VPWR.n617 VGND 0.06636f
C10048 VPWR.n618 VGND 0.01894f
C10049 VPWR.t962 VGND 0.32562f
C10050 VPWR.t729 VGND 0.08032f
C10051 VPWR.n619 VGND 0.03253f
C10052 VPWR.n620 VGND 0.06666f
C10053 VPWR.n621 VGND 0.04906f
C10054 VPWR.t779 VGND 1.0599f
C10055 VPWR.n622 VGND 0.19591f
C10056 VPWR.t319 VGND 0.04895f
C10057 VPWR.n623 VGND 0.22671f
C10058 VPWR.t131 VGND 2.29254f
C10059 VPWR.n624 VGND 0.19638f
C10060 VPWR.t511 VGND 0.91529f
C10061 VPWR.t665 VGND 0.08033f
C10062 VPWR.n625 VGND 0.03253f
C10063 VPWR.n626 VGND 0.09012f
C10064 VPWR.t762 VGND 0.04701f
C10065 VPWR.n627 VGND 0.07072f
C10066 VPWR.n628 VGND 0.02392f
C10067 VPWR.t32 VGND 0.03769f
C10068 VPWR.n629 VGND 0.10634f
C10069 VPWR.n630 VGND 0.09806f
C10070 VPWR.n631 VGND 0.06252f
C10071 VPWR.n632 VGND 0.02357f
C10072 VPWR.n633 VGND 0.03507f
C10073 VPWR.t866 VGND 0.43282f
C10074 VPWR.n634 VGND 0.09759f
C10075 VPWR.n635 VGND 0.03708f
C10076 VPWR.n636 VGND 0.02359f
C10077 VPWR.t167 VGND 0.25034f
C10078 VPWR.t126 VGND 0.21815f
C10079 VPWR.n637 VGND 0.19695f
C10080 VPWR.t734 VGND 0.18752f
C10081 VPWR.n638 VGND 0.11026f
C10082 VPWR.t286 VGND 0.04895f
C10083 VPWR.n639 VGND 0.22671f
C10084 VPWR.n640 VGND 0.03839f
C10085 VPWR.t586 VGND 1.15753f
C10086 VPWR.n641 VGND 0.19638f
C10087 VPWR.n642 VGND 0.04906f
C10088 VPWR.t1067 VGND 0.01615f
C10089 VPWR.t592 VGND 0.90809f
C10090 VPWR.n643 VGND 0.03253f
C10091 VPWR.n644 VGND 0.07457f
C10092 VPWR.n645 VGND 0.02242f
C10093 VPWR.t117 VGND 0.40589f
C10094 VPWR.n646 VGND 0.08067f
C10095 VPWR.n647 VGND 0.03443f
C10096 VPWR.t867 VGND 0.04143f
C10097 VPWR.n648 VGND 0.14386f
C10098 VPWR.n649 VGND 0.08589f
C10099 VPWR.t1254 VGND 0.04282f
C10100 VPWR.n650 VGND 0.21884f
C10101 VPWR.n651 VGND 0.05325f
C10102 VPWR.t97 VGND 0.04895f
C10103 VPWR.t288 VGND 0.03481f
C10104 VPWR.n652 VGND 0.19638f
C10105 VPWR.t1253 VGND 0.01615f
C10106 VPWR.t328 VGND 1.21412f
C10107 VPWR.n653 VGND 0.03253f
C10108 VPWR.n654 VGND 0.06667f
C10109 VPWR.n655 VGND 0.04906f
C10110 VPWR.t1111 VGND 0.05058f
C10111 VPWR.n656 VGND 0.08968f
C10112 VPWR.n657 VGND 0.03711f
C10113 VPWR.t728 VGND 0.20388f
C10114 VPWR.n658 VGND 0.09468f
C10115 VPWR.t1151 VGND 0.20112f
C10116 VPWR.n659 VGND 0.09466f
C10117 VPWR.n660 VGND 0.031f
C10118 VPWR.t797 VGND 0.13796f
C10119 VPWR.n661 VGND 0.09466f
C10120 VPWR.t791 VGND 0.05058f
C10121 VPWR.n662 VGND 0.08976f
C10122 VPWR.n663 VGND 0.03708f
C10123 VPWR.t1105 VGND 0.01615f
C10124 VPWR.t89 VGND 0.1232f
C10125 VPWR.n664 VGND 0.03253f
C10126 VPWR.n665 VGND 0.06666f
C10127 VPWR.t446 VGND 0.03481f
C10128 VPWR.n666 VGND 0.19585f
C10129 VPWR.n667 VGND 0.04906f
C10130 VPWR.t325 VGND 0.04895f
C10131 VPWR.n668 VGND 0.24962f
C10132 VPWR.t258 VGND 0.15169f
C10133 VPWR.n669 VGND 0.1206f
C10134 VPWR.t154 VGND 0.25072f
C10135 VPWR.n670 VGND 0.09583f
C10136 VPWR.n671 VGND 0.03711f
C10137 VPWR.n672 VGND 0.02671f
C10138 VPWR.n673 VGND 0.08657f
C10139 VPWR.t156 VGND 0.18634f
C10140 VPWR.t871 VGND 0.30556f
C10141 VPWR.n674 VGND 0.09467f
C10142 VPWR.t158 VGND 0.04701f
C10143 VPWR.t1079 VGND 0.04803f
C10144 VPWR.n675 VGND 0.09183f
C10145 VPWR.n676 VGND 0.08173f
C10146 VPWR.n677 VGND 0.03539f
C10147 VPWR.n678 VGND 0.02963f
C10148 VPWR.t0 VGND 37.063f
C10149 VPWR.n679 VGND 0.01573f
C10150 VPWR.n680 VGND 0.06911f
C10151 VPWR.n681 VGND 1.2242f
C10152 VPWR.t309 VGND 1.60359f
C10153 VPWR.t401 VGND 0.90251f
C10154 VPWR.n682 VGND 0.22314f
C10155 VPWR.t389 VGND 0.19473f
C10156 VPWR.n683 VGND 0.14017f
C10157 VPWR.n684 VGND 0.03843f
C10158 VPWR.t818 VGND 0.33627f
C10159 VPWR.n685 VGND 0.10355f
C10160 VPWR.n686 VGND 0.04878f
C10161 VPWR.t302 VGND 0.4285f
C10162 VPWR.n687 VGND 0.09861f
C10163 VPWR.n688 VGND 0.0142f
C10164 VPWR.t635 VGND 0.19454f
C10165 VPWR.n689 VGND 0.06979f
C10166 VPWR.n690 VGND 0.02181f
C10167 VPWR.t222 VGND 0.04655f
C10168 VPWR.t290 VGND 0.65682f
C10169 VPWR.n691 VGND 0.06965f
C10170 VPWR.n692 VGND 0.11406f
C10171 VPWR.n693 VGND 1.2242f
C10172 VPWR.n694 VGND 0.83795f
C10173 VPWR.t396 VGND 1.03317f
C10174 VPWR.t177 VGND 0.95036f
C10175 VPWR.t267 VGND 0.09306f
C10176 VPWR.t397 VGND 0.12121f
C10177 VPWR.n695 VGND 0.03253f
C10178 VPWR.t299 VGND 0.01615f
C10179 VPWR.t176 VGND 1.26839f
C10180 VPWR.n696 VGND 0.03253f
C10181 VPWR.n697 VGND 0.08407f
C10182 VPWR.t1243 VGND 0.04436f
C10183 VPWR.n699 VGND 0.06693f
C10184 VPWR.n700 VGND 0.01905f
C10185 VPWR.t1248 VGND 0.46441f
C10186 VPWR.t1241 VGND 0.04779f
C10187 VPWR.n701 VGND 0.04295f
C10188 VPWR.n702 VGND 0.042f
C10189 VPWR.n703 VGND 0.0175f
C10190 VPWR.t1239 VGND 0.04779f
C10191 VPWR.n704 VGND 0.05752f
C10192 VPWR.n705 VGND 0.01932f
C10193 VPWR.t1237 VGND 0.04779f
C10194 VPWR.n706 VGND 0.04849f
C10195 VPWR.t231 VGND 0.32974f
C10196 VPWR.n708 VGND 0.03991f
C10197 VPWR.n709 VGND 0.01683f
C10198 VPWR.t211 VGND 0.04779f
C10199 VPWR.n710 VGND 0.04947f
C10200 VPWR.n711 VGND 0.01894f
C10201 VPWR.t209 VGND 0.04779f
C10202 VPWR.n712 VGND 0.04798f
C10203 VPWR.t481 VGND 0.18817f
C10204 VPWR.n714 VGND 0.054f
C10205 VPWR.n715 VGND 0.02339f
C10206 VPWR.t164 VGND 0.04701f
C10207 VPWR.n716 VGND 0.05671f
C10208 VPWR.n717 VGND 0.01575f
C10209 VPWR.t571 VGND 0.1464f
C10210 VPWR.n718 VGND 0.05783f
C10211 VPWR.n719 VGND 0.02325f
C10212 VPWR.t662 VGND 0.04895f
C10213 VPWR.n720 VGND 0.06979f
C10214 VPWR.n721 VGND 0.01733f
C10215 VPWR.t1028 VGND 0.19471f
C10216 VPWR.t747 VGND 0.11219f
C10217 VPWR.n722 VGND 0.16848f
C10218 VPWR.n723 VGND 0.01689f
C10219 VPWR.t390 VGND 0.92272f
C10220 VPWR.n724 VGND 0.05087f
C10221 VPWR.n725 VGND 0.03336f
C10222 VPWR.t1269 VGND 0.35343f
C10223 VPWR.t697 VGND 0.23508f
C10224 VPWR.n726 VGND 0.03253f
C10225 VPWR.n727 VGND 0.04292f
C10226 VPWR.n728 VGND 0.01702f
C10227 VPWR.t923 VGND 0.01615f
C10228 VPWR.t364 VGND 0.53041f
C10229 VPWR.n729 VGND 0.03253f
C10230 VPWR.n730 VGND 0.02505f
C10231 VPWR.n731 VGND 0.0111f
C10232 VPWR.t575 VGND 0.05058f
C10233 VPWR.n732 VGND 0.04957f
C10234 VPWR.n733 VGND 0.01335f
C10235 VPWR.t1084 VGND 0.64995f
C10236 VPWR.n734 VGND 0.06293f
C10237 VPWR.n735 VGND 0.02595f
C10238 VPWR.t344 VGND 0.20083f
C10239 VPWR.n736 VGND 0.06291f
C10240 VPWR.n737 VGND 0.01335f
C10241 VPWR.t333 VGND 0.36162f
C10242 VPWR.n738 VGND 0.07363f
C10243 VPWR.n739 VGND 0.03039f
C10244 VPWR.t207 VGND 1.23956f
C10245 VPWR.n740 VGND 0.07425f
C10246 VPWR.n741 VGND 0.01894f
C10247 VPWR.t206 VGND 0.64367f
C10248 VPWR.n742 VGND 0.05777f
C10249 VPWR.n743 VGND 0.01922f
C10250 VPWR.t491 VGND 0.04779f
C10251 VPWR.n744 VGND 0.05755f
C10252 VPWR.n745 VGND 0.01932f
C10253 VPWR.t489 VGND 0.04779f
C10254 VPWR.n746 VGND 0.05752f
C10255 VPWR.n747 VGND 0.0181f
C10256 VPWR.t487 VGND 0.04779f
C10257 VPWR.t633 VGND 0.13945f
C10258 VPWR.n748 VGND 0.04458f
C10259 VPWR.n749 VGND 0.04246f
C10260 VPWR.n750 VGND 0.01792f
C10261 VPWR.t486 VGND 0.04436f
C10262 VPWR.t632 VGND 0.04436f
C10263 VPWR.n751 VGND 0.05465f
C10264 VPWR.n752 VGND 0.07437f
C10265 VPWR.n753 VGND 0.02884f
C10266 VPWR.t1384 VGND 1.05134f
C10267 VPWR.t52 VGND 0.09541f
C10268 VPWR.n754 VGND 0.13125f
C10269 VPWR.t1382 VGND 1.05423f
C10270 VPWR.t53 VGND 0.42328f
C10271 VPWR.n755 VGND 0.83795f
C10272 VPWR.n756 VGND 0.83795f
C10273 VPWR.t45 VGND 0.03923f
C10274 VPWR.t67 VGND 0.19984f
C10275 VPWR.t656 VGND 0.04436f
C10276 VPWR.t123 VGND 0.45828f
C10277 VPWR.t781 VGND 1.18115f
C10278 VPWR.n757 VGND 0.03253f
C10279 VPWR.n758 VGND 0.05567f
C10280 VPWR.n759 VGND 0.05453f
C10281 VPWR.t657 VGND 0.08948f
C10282 VPWR.n760 VGND 0.06561f
C10283 VPWR.n761 VGND 0.01922f
C10284 VPWR.t272 VGND 0.21005f
C10285 VPWR.n762 VGND 0.17391f
C10286 VPWR.t649 VGND 0.04895f
C10287 VPWR.n763 VGND 0.10372f
C10288 VPWR.n764 VGND 0.03762f
C10289 VPWR.t898 VGND 0.26782f
C10290 VPWR.t609 VGND 0.12887f
C10291 VPWR.n765 VGND 0.03253f
C10292 VPWR.n766 VGND 0.07457f
C10293 VPWR.t691 VGND 0.33269f
C10294 VPWR.n767 VGND 0.09753f
C10295 VPWR.n768 VGND 0.03125f
C10296 VPWR.t410 VGND 1.08461f
C10297 VPWR.n769 VGND 0.04074f
C10298 VPWR.t774 VGND 0.39744f
C10299 VPWR.n770 VGND 0.06972f
C10300 VPWR.t653 VGND 0.093f
C10301 VPWR.t218 VGND 0.77483f
C10302 VPWR.n772 VGND 0.03253f
C10303 VPWR.n773 VGND 0.04314f
C10304 VPWR.t585 VGND 0.29991f
C10305 VPWR.n774 VGND 0.07399f
C10306 VPWR.n775 VGND 0.01659f
C10307 VPWR.t111 VGND 0.58992f
C10308 VPWR.n776 VGND 0.05614f
C10309 VPWR.t306 VGND 0.46654f
C10310 VPWR.n778 VGND 0.06187f
C10311 VPWR.t720 VGND 0.03404f
C10312 VPWR.n779 VGND 0.06191f
C10313 VPWR.n780 VGND 0.03356f
C10314 VPWR.t1030 VGND 0.05058f
C10315 VPWR.n781 VGND 0.05613f
C10316 VPWR.t1174 VGND 0.04779f
C10317 VPWR.n782 VGND 0.05832f
C10318 VPWR.n783 VGND 0.02267f
C10319 VPWR.t1048 VGND 0.41259f
C10320 VPWR.n784 VGND 0.052f
C10321 VPWR.t1176 VGND 0.04779f
C10322 VPWR.n786 VGND 0.05147f
C10323 VPWR.t1331 VGND 0.04779f
C10324 VPWR.n787 VGND 0.07164f
C10325 VPWR.n788 VGND 0.01932f
C10326 VPWR.t1333 VGND 0.04779f
C10327 VPWR.n789 VGND 0.05752f
C10328 VPWR.n790 VGND 0.01927f
C10329 VPWR.t1335 VGND 0.04779f
C10330 VPWR.n791 VGND 0.05767f
C10331 VPWR.n792 VGND 0.01905f
C10332 VPWR.t1337 VGND 0.04436f
C10333 VPWR.n793 VGND 0.06693f
C10334 VPWR.t1062 VGND 0.14999f
C10335 VPWR.n795 VGND 0.06666f
C10336 VPWR.n796 VGND 0.01922f
C10337 VPWR.t1063 VGND 0.04282f
C10338 VPWR.n797 VGND 0.08895f
C10339 VPWR.n798 VGND 0.04433f
C10340 VPWR.t133 VGND 0.03481f
C10341 VPWR.n799 VGND 0.09031f
C10342 VPWR.t57 VGND 0.03924f
C10343 VPWR.n800 VGND 0.07559f
C10344 VPWR.n801 VGND 0.03136f
C10345 VPWR.t674 VGND 0.04296f
C10346 VPWR.t51 VGND 0.03769f
C10347 VPWR.n802 VGND 0.10634f
C10348 VPWR.n803 VGND 0.11f
C10349 VPWR.n804 VGND 0.01951f
C10350 VPWR.t46 VGND 0.04049f
C10351 VPWR.n806 VGND 0.0774f
C10352 VPWR.t654 VGND 0.05131f
C10353 VPWR.t47 VGND 0.4618f
C10354 VPWR.n807 VGND 0.1774f
C10355 VPWR.n808 VGND 0.14628f
C10356 VPWR.t49 VGND 0.45891f
C10357 VPWR.n809 VGND 0.05863f
C10358 VPWR.n810 VGND 0.01317f
C10359 VPWR.t50 VGND 0.03922f
C10360 VPWR.n811 VGND 0.05028f
C10361 VPWR.t482 VGND 0.0647f
C10362 VPWR.n812 VGND 0.03991f
C10363 VPWR.t478 VGND 0.18978f
C10364 VPWR.n814 VGND 0.11496f
C10365 VPWR.t1031 VGND 0.03404f
C10366 VPWR.n815 VGND 0.06821f
C10367 VPWR.n816 VGND 0.01872f
C10368 VPWR.t1107 VGND 0.51306f
C10369 VPWR.n817 VGND 0.06297f
C10370 VPWR.n818 VGND 0.02045f
C10371 VPWR.t225 VGND 0.29328f
C10372 VPWR.n819 VGND 0.05774f
C10373 VPWR.n820 VGND 0.0139f
C10374 VPWR.t362 VGND 0.38887f
C10375 VPWR.n821 VGND 0.054f
C10376 VPWR.n822 VGND 0.02794f
C10377 VPWR.t536 VGND 0.39102f
C10378 VPWR.n823 VGND 0.07778f
C10379 VPWR.n824 VGND 0.01127f
C10380 VPWR.t1202 VGND 0.37309f
C10381 VPWR.n825 VGND 0.08721f
C10382 VPWR.n826 VGND 0.05729f
C10383 VPWR.t664 VGND 0.04895f
C10384 VPWR.n827 VGND 0.1888f
C10385 VPWR.t312 VGND 0.05525f
C10386 VPWR.n828 VGND 0.15487f
C10387 VPWR.n829 VGND 0.04907f
C10388 VPWR.t1403 VGND 0.01615f
C10389 VPWR.t311 VGND 0.12121f
C10390 VPWR.n830 VGND 0.03253f
C10391 VPWR.n831 VGND 0.04855f
C10392 VPWR.t227 VGND 3.97744f
C10393 VPWR.t696 VGND 0.95065f
C10394 VPWR.n833 VGND 0.0886f
C10395 VPWR.n834 VGND 0.04767f
C10396 VPWR.t77 VGND 3.2888f
C10397 VPWR.t577 VGND 0.55859f
C10398 VPWR.t612 VGND 2.34647f
C10399 VPWR.t148 VGND 0.9552f
C10400 VPWR.t55 VGND 0.09541f
C10401 VPWR.t62 VGND 0.15101f
C10402 VPWR.n835 VGND 0.06131f
C10403 VPWR.t54 VGND 0.0983f
C10404 VPWR.t58 VGND 0.20777f
C10405 VPWR.n836 VGND 0.0217f
C10406 VPWR.n837 VGND 0.04907f
C10407 VPWR.t1185 VGND 0.01615f
C10408 VPWR.t1093 VGND 0.77499f
C10409 VPWR.n839 VGND 0.03253f
C10410 VPWR.t617 VGND 0.09296f
C10411 VPWR.t149 VGND 0.08033f
C10412 VPWR.n840 VGND 0.03253f
C10413 VPWR.n841 VGND 0.09245f
C10414 VPWR.n842 VGND 0.02282f
C10415 VPWR.t224 VGND 0.45523f
C10416 VPWR.n843 VGND 0.06836f
C10417 VPWR.t712 VGND 0.04779f
C10418 VPWR.n845 VGND 0.05146f
C10419 VPWR.n846 VGND 0.03262f
C10420 VPWR.t711 VGND 0.04779f
C10421 VPWR.n847 VGND 0.07832f
C10422 VPWR.n848 VGND 0.01922f
C10423 VPWR.t1017 VGND 0.04779f
C10424 VPWR.n849 VGND 0.05755f
C10425 VPWR.n850 VGND 0.01932f
C10426 VPWR.t1015 VGND 0.04779f
C10427 VPWR.n851 VGND 0.05752f
C10428 VPWR.n852 VGND 0.01927f
C10429 VPWR.t1013 VGND 0.52512f
C10430 VPWR.n853 VGND 0.05768f
C10431 VPWR.n854 VGND 0.01905f
C10432 VPWR.t1012 VGND 0.04436f
C10433 VPWR.n855 VGND 0.06693f
C10434 VPWR.n856 VGND 0.0144f
C10435 VPWR.t361 VGND 0.1885f
C10436 VPWR.n857 VGND 0.06575f
C10437 VPWR.n858 VGND 0.0251f
C10438 VPWR.t496 VGND 0.54702f
C10439 VPWR.n859 VGND 0.0738f
C10440 VPWR.n860 VGND 0.01757f
C10441 VPWR.t615 VGND 0.0746f
C10442 VPWR.t212 VGND 1.30499f
C10443 VPWR.n861 VGND 0.0379f
C10444 VPWR.n862 VGND 0.05204f
C10445 VPWR.n863 VGND 0.01216f
C10446 VPWR.t1341 VGND 0.01615f
C10447 VPWR.t758 VGND 1.61085f
C10448 VPWR.n864 VGND 0.03253f
C10449 VPWR.n865 VGND 0.04293f
C10450 VPWR.n866 VGND 0.03292f
C10451 VPWR.t589 VGND 0.01615f
C10452 VPWR.t718 VGND 1.28259f
C10453 VPWR.n867 VGND 0.03253f
C10454 VPWR.n868 VGND 0.04292f
C10455 VPWR.n869 VGND 0.01088f
C10456 VPWR.t749 VGND 0.03481f
C10457 VPWR.t513 VGND 0.04356f
C10458 VPWR.n870 VGND 0.05406f
C10459 VPWR.n871 VGND 0.0307f
C10460 VPWR.n872 VGND 0.01223f
C10461 VPWR.t544 VGND 1.23435f
C10462 VPWR.n873 VGND 0.07157f
C10463 VPWR.n874 VGND 0.02728f
C10464 VPWR.t1289 VGND 3.76964f
C10465 VPWR.n875 VGND 0.07425f
C10466 VPWR.n876 VGND 0.01894f
C10467 VPWR.t1000 VGND 2.43133f
C10468 VPWR.n877 VGND 0.05777f
C10469 VPWR.n878 VGND 0.01922f
C10470 VPWR.t998 VGND 0.04779f
C10471 VPWR.n879 VGND 0.05755f
C10472 VPWR.n880 VGND 0.01932f
C10473 VPWR.t996 VGND 0.04779f
C10474 VPWR.n881 VGND 0.05752f
C10475 VPWR.n882 VGND 0.01927f
C10476 VPWR.t994 VGND 0.04779f
C10477 VPWR.n883 VGND 0.05767f
C10478 VPWR.n884 VGND 0.01905f
C10479 VPWR.t993 VGND 0.04436f
C10480 VPWR.n885 VGND 0.10614f
C10481 VPWR.t561 VGND 0.04895f
C10482 VPWR.n886 VGND 0.09052f
C10483 VPWR.n887 VGND 0.02653f
C10484 VPWR.t922 VGND 0.1214f
C10485 VPWR.n888 VGND 0.07494f
C10486 VPWR.n889 VGND 0.01765f
C10487 VPWR.t360 VGND 0.48538f
C10488 VPWR.n890 VGND 0.04615f
C10489 VPWR.n891 VGND 0.01487f
C10490 VPWR.t693 VGND 0.21361f
C10491 VPWR.n892 VGND 0.06572f
C10492 VPWR.n893 VGND 0.02497f
C10493 VPWR.t814 VGND 0.23878f
C10494 VPWR.n894 VGND 0.0657f
C10495 VPWR.n895 VGND 0.01487f
C10496 VPWR.t323 VGND 0.37522f
C10497 VPWR.n896 VGND 0.05427f
C10498 VPWR.n897 VGND 0.02744f
C10499 VPWR.t601 VGND 0.32291f
C10500 VPWR.n898 VGND 0.06581f
C10501 VPWR.t621 VGND 0.12422f
C10502 VPWR.n900 VGND 0.0568f
C10503 VPWR.n901 VGND 0.03018f
C10504 VPWR.t216 VGND 0.66516f
C10505 VPWR.n902 VGND 0.05398f
C10506 VPWR.t829 VGND 0.04143f
C10507 VPWR.n904 VGND 0.07304f
C10508 VPWR.t61 VGND 0.14948f
C10509 VPWR.n905 VGND 0.09678f
C10510 VPWR.n906 VGND 0.07512f
C10511 VPWR.n907 VGND 0.0354f
C10512 VPWR.n908 VGND 0.01573f
C10513 VPWR.n909 VGND 0.0117f
C10514 VPWR.n910 VGND 0.83795f
C10515 VPWR.n911 VGND 0.0266f
C10516 VPWR.n912 VGND 0.0532f
C10517 VPWR.n913 VGND 0.0266f
C10518 VPWR.n914 VGND 1.00692f
C10519 VPWR.n915 VGND 5.54197f
C10520 VPWR.n916 VGND 0.06096f
C10521 VPWR.n917 VGND 0.45333f
C10522 VPWR.n918 VGND 0.45333f
C10523 VPWR.n919 VGND 0.06096f
C10524 VPWR.n920 VGND 0.0266f
C10525 VPWR.n921 VGND 0.0532f
C10526 VPWR.n922 VGND 0.0266f
C10527 VPWR.n923 VGND 1.00692f
C10528 VPWR.t195 VGND 1.11714f
C10529 VPWR.n924 VGND 0.13319f
C10530 VPWR.t257 VGND 0.18906f
C10531 VPWR.n925 VGND 0.06412f
C10532 VPWR.n926 VGND 0.52649f
C10533 VPWR.n927 VGND 0.33141f
C10534 VPWR.n928 VGND 0.0532f
C10535 VPWR.n929 VGND 5.54197f
C10536 VPWR.n930 VGND 0.0266f
C10537 VPWR.n931 VGND 0.06096f
C10538 VPWR.n932 VGND 1.135f
.ends
