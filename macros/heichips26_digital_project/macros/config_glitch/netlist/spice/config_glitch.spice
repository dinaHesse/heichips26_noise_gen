* NGSPICE file created from config_glitch.ext - technology: ihp-sg13cmos5l

* Black-box entry subcircuit for sg13cmos5l_decap_8 abstract view
.subckt sg13cmos5l_decap_8 VDD VSS
.ends

* Black-box entry subcircuit for sg13cmos5l_buf_16 abstract view
.subckt sg13cmos5l_buf_16 X A VDD VSS
.ends

* Black-box entry subcircuit for sg13cmos5l_fill_2 abstract view
.subckt sg13cmos5l_fill_2 VDD VSS
.ends

* Black-box entry subcircuit for sg13cmos5l_xor2_1 abstract view
.subckt sg13cmos5l_xor2_1 X A B VDD VSS
.ends

* Black-box entry subcircuit for sg13cmos5l_buf_1 abstract view
.subckt sg13cmos5l_buf_1 X A VDD VSS
.ends

* Black-box entry subcircuit for sg13cmos5l_decap_4 abstract view
.subckt sg13cmos5l_decap_4 VDD VSS
.ends

* Black-box entry subcircuit for sg13cmos5l_fill_1 abstract view
.subckt sg13cmos5l_fill_1 VDD VSS
.ends

* Black-box entry subcircuit for sg13cmos5l_and2_2 abstract view
.subckt sg13cmos5l_and2_2 X A B VDD VSS
.ends

.subckt config_glitch VGND VPWR enable glitch_en[0] glitch_en[1] glitch_en[2] glitch_en[3]
+ glitch_en[4] glitch_en[5] glitch_en[6] out_xor[0] out_xor[1] out_xor[2] out_xor[3]
+ out_xor[4] out_xor[5] out_xor[6] out_xor[7]
XFILLER_13_100 VPWR VGND sg13cmos5l_decap_8
XFILLER_12_87 VPWR VGND sg13cmos5l_decap_8
XFILLER_12_21 VPWR VGND sg13cmos5l_decap_8
XFILLER_7_7 VPWR VGND sg13cmos5l_decap_8
XFILLER_9_77 VPWR VGND sg13cmos5l_decap_8
Xgenblk1\[4\].genblk1.glitch_inst.genblk1\[2\].genblk1.buffer_inst genblk1\[4\].genblk1.glitch_inst.genblk1\[3\].genblk1.buffer_inst/A
+ genblk1\[4\].genblk1.glitch_inst.xor_inst/A VPWR VGND sg13cmos5l_buf_16
XFILLER_0_35 VPWR VGND sg13cmos5l_decap_8
Xgenblk1\[2\].genblk1.glitch_inst.genblk1\[3\].genblk1.buffer_inst genblk1\[2\].genblk1.glitch_inst.genblk1\[4\].genblk1.buffer_inst/A
+ genblk1\[2\].genblk1.glitch_inst.genblk1\[3\].genblk1.buffer_inst/A VPWR VGND sg13cmos5l_buf_16
XFILLER_18_20 VPWR VGND sg13cmos5l_fill_2
Xgenblk1\[7\].genblk1.glitch_inst.xor_inst output15/A rebuffer16/X genblk1\[7\].genblk1.glitch_inst.xor_inst/B
+ VPWR VGND sg13cmos5l_xor2_1
Xrebuffer17 rebuffer17/X _05_/A VPWR VGND sg13cmos5l_buf_1
XFILLER_15_21 VPWR VGND sg13cmos5l_decap_8
XFILLER_11_0 VPWR VGND sg13cmos5l_decap_8
XFILLER_5_130 VPWR VGND sg13cmos5l_decap_8
Xgenblk1\[0\].genblk1.glitch_inst.genblk1\[4\].genblk1.buffer_inst genblk1\[0\].genblk1.glitch_inst.genblk1\[5\].genblk1.buffer_inst/A
+ genblk1\[0\].genblk1.glitch_inst.genblk1\[4\].genblk1.buffer_inst/A VPWR VGND sg13cmos5l_buf_16
XFILLER_18_87 VPWR VGND sg13cmos5l_decap_8
XFILLER_18_65 VPWR VGND sg13cmos5l_decap_4
XFILLER_15_7 VPWR VGND sg13cmos5l_decap_8
XFILLER_0_14 VPWR VGND sg13cmos5l_decap_8
XFILLER_0_69 VPWR VGND sg13cmos5l_decap_8
XFILLER_2_144 VPWR VGND sg13cmos5l_decap_4
XFILLER_16_132 VPWR VGND sg13cmos5l_fill_1
Xoutput10 out_xor[2] _09_/X VPWR VGND sg13cmos5l_buf_1
Xoutput8 out_xor[0] _07_/X VPWR VGND sg13cmos5l_buf_1
XFILLER_13_135 VPWR VGND sg13cmos5l_decap_8
XFILLER_10_149 VPWR VGND sg13cmos5l_fill_1
XFILLER_9_139 VPWR VGND sg13cmos5l_decap_8
XFILLER_3_14 VPWR VGND sg13cmos5l_decap_8
XFILLER_9_68 VPWR VGND sg13cmos5l_fill_2
XFILLER_2_123 VPWR VGND sg13cmos5l_decap_8
XFILLER_6_14 VPWR VGND sg13cmos5l_decap_8
XFILLER_1_0 VPWR VGND sg13cmos5l_decap_8
XFILLER_1_80 VPWR VGND sg13cmos5l_decap_8
XFILLER_15_89 VPWR VGND sg13cmos5l_decap_8
XFILLER_13_114 VPWR VGND sg13cmos5l_decap_8
XFILLER_9_118 VPWR VGND sg13cmos5l_decap_8
Xoutput11 out_xor[3] _10_/X VPWR VGND sg13cmos5l_buf_1
Xoutput9 out_xor[1] _08_/X VPWR VGND sg13cmos5l_buf_1
XFILLER_12_35 VPWR VGND sg13cmos5l_fill_2
XFILLER_5_7 VPWR VGND sg13cmos5l_decap_8
Xgenblk1\[5\].genblk1.glitch_inst.genblk1\[1\].genblk1.buffer_inst genblk1\[5\].genblk1.glitch_inst.xor_inst/A
+ genblk1\[5\].genblk1.glitch_inst.genblk1\[1\].genblk1.buffer_inst/A VPWR VGND sg13cmos5l_buf_16
XFILLER_9_14 VPWR VGND sg13cmos5l_decap_8
XFILLER_2_102 VPWR VGND sg13cmos5l_decap_8
XFILLER_15_68 VPWR VGND sg13cmos5l_decap_8
Xoutput12 out_xor[4] _11_/X VPWR VGND sg13cmos5l_buf_1
XFILLER_16_123 VPWR VGND sg13cmos5l_decap_8
XFILLER_12_14 VPWR VGND sg13cmos5l_decap_8
Xgenblk1\[3\].genblk1.glitch_inst.genblk1\[2\].genblk1.buffer_inst genblk1\[3\].genblk1.glitch_inst.genblk1\[3\].genblk1.buffer_inst/A
+ genblk1\[3\].genblk1.glitch_inst.xor_inst/A VPWR VGND sg13cmos5l_buf_16
XFILLER_5_144 VPWR VGND sg13cmos5l_decap_4
XFILLER_0_28 VPWR VGND sg13cmos5l_decap_8
Xgenblk1\[1\].genblk1.glitch_inst.genblk1\[3\].genblk1.buffer_inst genblk1\[1\].genblk1.glitch_inst.genblk1\[4\].genblk1.buffer_inst/A
+ genblk1\[1\].genblk1.glitch_inst.genblk1\[3\].genblk1.buffer_inst/A VPWR VGND sg13cmos5l_buf_16
XFILLER_18_13 VPWR VGND sg13cmos5l_decap_8
Xgenblk1\[7\].genblk1.glitch_inst.genblk1\[5\].genblk1.buffer_inst genblk1\[7\].genblk1.glitch_inst.xor_inst/B
+ genblk1\[7\].genblk1.glitch_inst.genblk1\[5\].genblk1.buffer_inst/A VPWR VGND sg13cmos5l_buf_16
XFILLER_15_14 VPWR VGND sg13cmos5l_decap_8
Xoutput13 out_xor[5] _12_/X VPWR VGND sg13cmos5l_buf_1
XFILLER_13_7 VPWR VGND sg13cmos5l_decap_8
XFILLER_5_123 VPWR VGND sg13cmos5l_decap_8
XFILLER_3_28 VPWR VGND sg13cmos5l_fill_1
XFILLER_18_58 VPWR VGND sg13cmos5l_decap_8
XFILLER_2_137 VPWR VGND sg13cmos5l_decap_8
XFILLER_2_148 VPWR VGND sg13cmos5l_fill_2
XFILLER_4_93 VPWR VGND sg13cmos5l_decap_4
XFILLER_6_28 VPWR VGND sg13cmos5l_fill_2
XFILLER_1_94 VPWR VGND sg13cmos5l_decap_8
Xoutput14 out_xor[6] _13_/X VPWR VGND sg13cmos5l_buf_1
XFILLER_13_128 VPWR VGND sg13cmos5l_decap_8
XFILLER_8_143 VPWR VGND sg13cmos5l_fill_2
XFILLER_9_28 VPWR VGND sg13cmos5l_fill_1
XFILLER_2_116 VPWR VGND sg13cmos5l_decap_8
XFILLER_3_7 VPWR VGND sg13cmos5l_decap_8
XFILLER_18_26 VPWR VGND sg13cmos5l_fill_2
Xoutput15 out_xor[7] output15/A VPWR VGND sg13cmos5l_buf_1
X_09_ _09_/X _09_/A VPWR VGND sg13cmos5l_buf_1
XFILLER_13_107 VPWR VGND sg13cmos5l_decap_8
XFILLER_12_28 VPWR VGND sg13cmos5l_decap_8
Xgenblk1\[4\].genblk1.glitch_inst.genblk1\[1\].genblk1.buffer_inst genblk1\[4\].genblk1.glitch_inst.xor_inst/A
+ genblk1\[4\].genblk1.glitch_inst.genblk1\[1\].genblk1.buffer_inst/A VPWR VGND sg13cmos5l_buf_16
XFILLER_8_122 VPWR VGND sg13cmos5l_decap_8
XFILLER_13_93 VPWR VGND sg13cmos5l_decap_8
XFILLER_18_0 VPWR VGND sg13cmos5l_decap_8
Xgenblk1\[2\].genblk1.glitch_inst.genblk1\[2\].genblk1.buffer_inst genblk1\[2\].genblk1.glitch_inst.genblk1\[3\].genblk1.buffer_inst/A
+ genblk1\[2\].genblk1.glitch_inst.xor_inst/A VPWR VGND sg13cmos5l_buf_16
X_08_ _08_/X _08_/A VPWR VGND sg13cmos5l_buf_1
XFILLER_15_28 VPWR VGND sg13cmos5l_fill_1
XFILLER_11_7 VPWR VGND sg13cmos5l_decap_8
XFILLER_8_145 VPWR VGND sg13cmos5l_fill_1
XFILLER_5_148 VPWR VGND sg13cmos5l_fill_2
XFILLER_5_137 VPWR VGND sg13cmos5l_decap_8
Xgenblk1\[0\].genblk1.glitch_inst.genblk1\[3\].genblk1.buffer_inst genblk1\[0\].genblk1.glitch_inst.genblk1\[4\].genblk1.buffer_inst/A
+ genblk1\[0\].genblk1.glitch_inst.genblk1\[3\].genblk1.buffer_inst/A VPWR VGND sg13cmos5l_buf_16
XFILLER_18_28 VPWR VGND sg13cmos5l_fill_1
XFILLER_1_42 VPWR VGND sg13cmos5l_decap_8
XFILLER_1_75 VPWR VGND sg13cmos5l_fill_1
XFILLER_16_139 VPWR VGND sg13cmos5l_decap_8
X_07_ _07_/X _07_/A VPWR VGND sg13cmos5l_buf_1
XFILLER_8_0 VPWR VGND sg13cmos5l_decap_8
XFILLER_4_86 VPWR VGND sg13cmos5l_decap_8
XFILLER_4_97 VPWR VGND sg13cmos5l_fill_1
XFILLER_1_21 VPWR VGND sg13cmos5l_decap_8
XFILLER_1_7 VPWR VGND sg13cmos5l_decap_8
XFILLER_1_87 VPWR VGND sg13cmos5l_decap_8
X_06_ _06_/X _06_/A _06_/B VPWR VGND sg13cmos5l_and2_2
XFILLER_12_143 VPWR VGND sg13cmos5l_decap_8
XFILLER_8_136 VPWR VGND sg13cmos5l_decap_8
XFILLER_2_109 VPWR VGND sg13cmos5l_decap_8
XFILLER_4_21 VPWR VGND sg13cmos5l_decap_8
Xgenblk1\[5\].genblk1.glitch_inst.genblk1\[0\].genblk1.buffer_inst genblk1\[5\].genblk1.glitch_inst.genblk1\[1\].genblk1.buffer_inst/A
+ _03_/X VPWR VGND sg13cmos5l_buf_16
X_05_ _05_/X _05_/A _05_/B VPWR VGND sg13cmos5l_and2_2
XFILLER_10_86 VPWR VGND sg13cmos5l_decap_4
XFILLER_16_0 VPWR VGND sg13cmos5l_decap_8
XFILLER_15_130 VPWR VGND sg13cmos5l_decap_8
XFILLER_12_122 VPWR VGND sg13cmos5l_decap_8
Xgenblk1\[3\].genblk1.glitch_inst.genblk1\[1\].genblk1.buffer_inst genblk1\[3\].genblk1.glitch_inst.xor_inst/A
+ genblk1\[3\].genblk1.glitch_inst.genblk1\[1\].genblk1.buffer_inst/A VPWR VGND sg13cmos5l_buf_16
XFILLER_8_115 VPWR VGND sg13cmos5l_decap_8
XFILLER_7_21 VPWR VGND sg13cmos5l_decap_8
Xgenblk1\[7\].genblk1.glitch_inst.genblk1\[4\].genblk1.buffer_inst genblk1\[7\].genblk1.glitch_inst.genblk1\[5\].genblk1.buffer_inst/A
+ genblk1\[7\].genblk1.glitch_inst.genblk1\[4\].genblk1.buffer_inst/A VPWR VGND sg13cmos5l_buf_16
XFILLER_13_86 VPWR VGND sg13cmos5l_decap_8
XFILLER_1_143 VPWR VGND sg13cmos5l_fill_2
Xgenblk1\[1\].genblk1.glitch_inst.genblk1\[2\].genblk1.buffer_inst genblk1\[1\].genblk1.glitch_inst.genblk1\[3\].genblk1.buffer_inst/A
+ genblk1\[1\].genblk1.glitch_inst.xor_inst/A VPWR VGND sg13cmos5l_buf_16
XFILLER_10_54 VPWR VGND sg13cmos5l_decap_8
XFILLER_10_21 VPWR VGND sg13cmos5l_decap_8
X_04_ _05_/A _04_/A _04_/B VPWR VGND sg13cmos5l_and2_2
Xgenblk1\[5\].genblk1.glitch_inst.genblk1\[5\].genblk1.buffer_inst _04_/A genblk1\[5\].genblk1.glitch_inst.genblk1\[5\].genblk1.buffer_inst/A
+ VPWR VGND sg13cmos5l_buf_16
XFILLER_16_97 VPWR VGND sg13cmos5l_fill_1
XFILLER_12_101 VPWR VGND sg13cmos5l_decap_8
XFILLER_4_130 VPWR VGND sg13cmos5l_decap_4
XFILLER_13_21 VPWR VGND sg13cmos5l_decap_8
XFILLER_6_0 VPWR VGND sg13cmos5l_decap_8
XFILLER_1_122 VPWR VGND sg13cmos5l_decap_8
Xinput1 _06_/B glitch_en[0] VPWR VGND sg13cmos5l_buf_1
X_03_ _03_/X _03_/A _03_/B VPWR VGND sg13cmos5l_and2_2
XFILLER_1_35 VPWR VGND sg13cmos5l_decap_8
XFILLER_16_65 VPWR VGND sg13cmos5l_decap_8
XFILLER_16_32 VPWR VGND sg13cmos5l_fill_1
XFILLER_16_21 VPWR VGND sg13cmos5l_decap_8
XFILLER_15_110 VPWR VGND sg13cmos5l_decap_8
XFILLER_1_101 VPWR VGND sg13cmos5l_decap_8
XFILLER_1_145 VPWR VGND sg13cmos5l_fill_1
XFILLER_4_79 VPWR VGND sg13cmos5l_decap_8
Xinput2 _00_/B glitch_en[1] VPWR VGND sg13cmos5l_buf_1
XFILLER_1_14 VPWR VGND sg13cmos5l_decap_8
XFILLER_15_144 VPWR VGND sg13cmos5l_decap_4
X_02_ _02_/X _02_/A _02_/B VPWR VGND sg13cmos5l_and2_2
XFILLER_7_35 VPWR VGND sg13cmos5l_decap_4
XFILLER_14_0 VPWR VGND sg13cmos5l_decap_8
Xgenblk1\[4\].genblk1.glitch_inst.genblk1\[0\].genblk1.buffer_inst genblk1\[4\].genblk1.glitch_inst.genblk1\[1\].genblk1.buffer_inst/A
+ _02_/X VPWR VGND sg13cmos5l_buf_16
XFILLER_8_129 VPWR VGND sg13cmos5l_decap_8
XFILLER_4_14 VPWR VGND sg13cmos5l_decap_8
Xinput3 _01_/B glitch_en[2] VPWR VGND sg13cmos5l_buf_1
XFILLER_18_7 VPWR VGND sg13cmos5l_fill_2
Xgenblk1\[2\].genblk1.glitch_inst.genblk1\[1\].genblk1.buffer_inst genblk1\[2\].genblk1.glitch_inst.xor_inst/A
+ genblk1\[2\].genblk1.glitch_inst.genblk1\[1\].genblk1.buffer_inst/A VPWR VGND sg13cmos5l_buf_16
X_01_ _01_/X _01_/A _01_/B VPWR VGND sg13cmos5l_and2_2
XFILLER_15_123 VPWR VGND sg13cmos5l_decap_8
XFILLER_12_115 VPWR VGND sg13cmos5l_decap_8
XFILLER_7_47 VPWR VGND sg13cmos5l_fill_2
XFILLER_7_14 VPWR VGND sg13cmos5l_decap_8
Xgenblk1\[0\].genblk1.glitch_inst.genblk1\[2\].genblk1.buffer_inst genblk1\[0\].genblk1.glitch_inst.genblk1\[3\].genblk1.buffer_inst/A
+ genblk1\[0\].genblk1.glitch_inst.xor_inst/A VPWR VGND sg13cmos5l_buf_16
XFILLER_13_79 VPWR VGND sg13cmos5l_decap_8
XFILLER_1_136 VPWR VGND sg13cmos5l_decap_8
Xinput4 _02_/B glitch_en[3] VPWR VGND sg13cmos5l_buf_1
Xgenblk1\[4\].genblk1.glitch_inst.genblk1\[5\].genblk1.buffer_inst _03_/A genblk1\[4\].genblk1.glitch_inst.genblk1\[5\].genblk1.buffer_inst/A
+ VPWR VGND sg13cmos5l_buf_16
XFILLER_1_49 VPWR VGND sg13cmos5l_fill_1
X_00_ _00_/X _00_/A _00_/B VPWR VGND sg13cmos5l_and2_2
XFILLER_10_14 VPWR VGND sg13cmos5l_decap_8
XFILLER_4_0 VPWR VGND sg13cmos5l_decap_8
XFILLER_8_80 VPWR VGND sg13cmos5l_decap_8
XFILLER_7_142 VPWR VGND sg13cmos5l_decap_8
XFILLER_13_14 VPWR VGND sg13cmos5l_decap_8
XFILLER_8_7 VPWR VGND sg13cmos5l_decap_8
XFILLER_1_115 VPWR VGND sg13cmos5l_decap_8
XFILLER_4_123 VPWR VGND sg13cmos5l_decap_8
XFILLER_4_134 VPWR VGND sg13cmos5l_fill_1
XFILLER_18_122 VPWR VGND sg13cmos5l_decap_8
Xinput5 _03_/B glitch_en[4] VPWR VGND sg13cmos5l_buf_1
XFILLER_1_28 VPWR VGND sg13cmos5l_decap_8
XFILLER_16_58 VPWR VGND sg13cmos5l_decap_8
XFILLER_16_14 VPWR VGND sg13cmos5l_decap_8
XFILLER_15_103 VPWR VGND sg13cmos5l_decap_8
XFILLER_7_49 VPWR VGND sg13cmos5l_fill_1
XFILLER_12_0 VPWR VGND sg13cmos5l_decap_8
XFILLER_7_121 VPWR VGND sg13cmos5l_decap_8
XFILLER_4_28 VPWR VGND sg13cmos5l_fill_1
XFILLER_4_146 VPWR VGND sg13cmos5l_decap_4
XFILLER_14_91 VPWR VGND sg13cmos5l_decap_8
XFILLER_5_93 VPWR VGND sg13cmos5l_decap_4
Xinput6 _04_/B glitch_en[5] VPWR VGND sg13cmos5l_buf_1
XFILLER_18_145 VPWR VGND sg13cmos5l_fill_1
XFILLER_18_101 VPWR VGND sg13cmos5l_decap_8
XFILLER_15_148 VPWR VGND sg13cmos5l_fill_2
XFILLER_15_137 VPWR VGND sg13cmos5l_decap_8
Xgenblk1\[3\].genblk1.glitch_inst.genblk1\[0\].genblk1.buffer_inst genblk1\[3\].genblk1.glitch_inst.genblk1\[1\].genblk1.buffer_inst/A
+ _01_/X VPWR VGND sg13cmos5l_buf_16
XFILLER_16_7 VPWR VGND sg13cmos5l_decap_8
XFILLER_12_129 VPWR VGND sg13cmos5l_decap_4
XFILLER_7_100 VPWR VGND sg13cmos5l_decap_8
XFILLER_7_28 VPWR VGND sg13cmos5l_decap_8
Xgenblk1\[7\].genblk1.glitch_inst.genblk1\[3\].genblk1.buffer_inst genblk1\[7\].genblk1.glitch_inst.genblk1\[4\].genblk1.buffer_inst/A
+ genblk1\[7\].genblk1.glitch_inst.genblk1\[3\].genblk1.buffer_inst/A VPWR VGND sg13cmos5l_buf_16
Xgenblk1\[1\].genblk1.glitch_inst.genblk1\[1\].genblk1.buffer_inst genblk1\[1\].genblk1.glitch_inst.xor_inst/A
+ genblk1\[1\].genblk1.glitch_inst.genblk1\[1\].genblk1.buffer_inst/A VPWR VGND sg13cmos5l_buf_16
Xinput7 _05_/B glitch_en[6] VPWR VGND sg13cmos5l_buf_1
XFILLER_14_70 VPWR VGND sg13cmos5l_decap_8
XFILLER_10_28 VPWR VGND sg13cmos5l_fill_1
Xgenblk1\[5\].genblk1.glitch_inst.genblk1\[4\].genblk1.buffer_inst genblk1\[5\].genblk1.glitch_inst.genblk1\[5\].genblk1.buffer_inst/A
+ genblk1\[5\].genblk1.glitch_inst.genblk1\[4\].genblk1.buffer_inst/A VPWR VGND sg13cmos5l_buf_16
XFILLER_12_108 VPWR VGND sg13cmos5l_decap_8
XFILLER_2_0 VPWR VGND sg13cmos5l_decap_8
XFILLER_2_95 VPWR VGND sg13cmos5l_decap_8
Xgenblk1\[3\].genblk1.glitch_inst.genblk1\[5\].genblk1.buffer_inst _02_/A genblk1\[3\].genblk1.glitch_inst.genblk1\[5\].genblk1.buffer_inst/A
+ VPWR VGND sg13cmos5l_buf_16
XFILLER_13_28 VPWR VGND sg13cmos5l_fill_1
XFILLER_6_7 VPWR VGND sg13cmos5l_decap_8
XFILLER_1_129 VPWR VGND sg13cmos5l_decap_8
XFILLER_16_28 VPWR VGND sg13cmos5l_decap_4
XFILLER_15_117 VPWR VGND sg13cmos5l_fill_2
XFILLER_11_94 VPWR VGND sg13cmos5l_decap_8
XFILLER_7_135 VPWR VGND sg13cmos5l_decap_8
XFILLER_8_73 VPWR VGND sg13cmos5l_decap_8
XFILLER_1_108 VPWR VGND sg13cmos5l_decap_8
XFILLER_10_0 VPWR VGND sg13cmos5l_decap_8
XFILLER_18_137 VPWR VGND sg13cmos5l_decap_4
XFILLER_18_115 VPWR VGND sg13cmos5l_decap_8
XFILLER_14_7 VPWR VGND sg13cmos5l_decap_8
XFILLER_7_114 VPWR VGND sg13cmos5l_decap_8
XFILLER_4_139 VPWR VGND sg13cmos5l_decap_8
Xgenblk1\[2\].genblk1.glitch_inst.genblk1\[0\].genblk1.buffer_inst genblk1\[2\].genblk1.glitch_inst.genblk1\[1\].genblk1.buffer_inst/A
+ _00_/X VPWR VGND sg13cmos5l_buf_16
XFILLER_5_97 VPWR VGND sg13cmos5l_fill_1
XFILLER_5_86 VPWR VGND sg13cmos5l_decap_8
XFILLER_14_84 VPWR VGND sg13cmos5l_decap_8
XFILLER_2_21 VPWR VGND sg13cmos5l_decap_8
XFILLER_2_54 VPWR VGND sg13cmos5l_fill_1
XFILLER_11_133 VPWR VGND sg13cmos5l_fill_2
XFILLER_11_122 VPWR VGND sg13cmos5l_decap_8
XFILLER_0_0 VPWR VGND sg13cmos5l_decap_8
Xgenblk1\[0\].genblk1.glitch_inst.genblk1\[1\].genblk1.buffer_inst genblk1\[0\].genblk1.glitch_inst.xor_inst/A
+ genblk1\[0\].genblk1.glitch_inst.genblk1\[1\].genblk1.buffer_inst/A VPWR VGND sg13cmos5l_buf_16
XFILLER_8_42 VPWR VGND sg13cmos5l_decap_4
Xgenblk1\[4\].genblk1.glitch_inst.genblk1\[4\].genblk1.buffer_inst genblk1\[4\].genblk1.glitch_inst.genblk1\[5\].genblk1.buffer_inst/A
+ genblk1\[4\].genblk1.glitch_inst.genblk1\[4\].genblk1.buffer_inst/A VPWR VGND sg13cmos5l_buf_16
XFILLER_5_21 VPWR VGND sg13cmos5l_decap_8
XFILLER_0_132 VPWR VGND sg13cmos5l_decap_8
Xgenblk1\[2\].genblk1.glitch_inst.genblk1\[5\].genblk1.buffer_inst _01_/A genblk1\[2\].genblk1.glitch_inst.genblk1\[5\].genblk1.buffer_inst/A
+ VPWR VGND sg13cmos5l_buf_16
XFILLER_2_88 VPWR VGND sg13cmos5l_decap_8
XFILLER_4_7 VPWR VGND sg13cmos5l_decap_8
XFILLER_11_101 VPWR VGND sg13cmos5l_decap_8
XFILLER_8_87 VPWR VGND sg13cmos5l_fill_2
XFILLER_8_21 VPWR VGND sg13cmos5l_decap_8
XFILLER_7_149 VPWR VGND sg13cmos5l_fill_1
XFILLER_0_111 VPWR VGND sg13cmos5l_decap_8
XFILLER_18_129 VPWR VGND sg13cmos5l_decap_4
XFILLER_14_42 VPWR VGND sg13cmos5l_fill_2
XFILLER_11_87 VPWR VGND sg13cmos5l_decap_8
XFILLER_11_21 VPWR VGND sg13cmos5l_decap_8
XFILLER_7_128 VPWR VGND sg13cmos5l_decap_8
XFILLER_12_7 VPWR VGND sg13cmos5l_decap_8
XFILLER_14_98 VPWR VGND sg13cmos5l_decap_8
XFILLER_14_21 VPWR VGND sg13cmos5l_decap_8
Xgenblk1\[0\].genblk1.glitch_inst.xor_inst _07_/A genblk1\[0\].genblk1.glitch_inst.xor_inst/A
+ _06_/A VPWR VGND sg13cmos5l_xor2_1
XFILLER_18_108 VPWR VGND sg13cmos5l_decap_8
XFILLER_17_130 VPWR VGND sg13cmos5l_decap_8
Xgenblk1\[7\].genblk1.glitch_inst.genblk1\[2\].genblk1.buffer_inst genblk1\[7\].genblk1.glitch_inst.genblk1\[3\].genblk1.buffer_inst/A
+ _05_/X VPWR VGND sg13cmos5l_buf_16
XFILLER_8_89 VPWR VGND sg13cmos5l_fill_1
XFILLER_7_107 VPWR VGND sg13cmos5l_decap_8
Xgenblk1\[1\].genblk1.glitch_inst.genblk1\[0\].genblk1.buffer_inst genblk1\[1\].genblk1.glitch_inst.genblk1\[1\].genblk1.buffer_inst/A
+ _06_/X VPWR VGND sg13cmos5l_buf_16
XFILLER_5_79 VPWR VGND sg13cmos5l_decap_8
XFILLER_0_90 VPWR VGND sg13cmos5l_decap_8
XFILLER_0_146 VPWR VGND sg13cmos5l_decap_4
XFILLER_3_132 VPWR VGND sg13cmos5l_decap_8
XFILLER_14_77 VPWR VGND sg13cmos5l_decap_8
XFILLER_14_44 VPWR VGND sg13cmos5l_fill_1
Xgenblk1\[5\].genblk1.glitch_inst.genblk1\[3\].genblk1.buffer_inst genblk1\[5\].genblk1.glitch_inst.genblk1\[4\].genblk1.buffer_inst/A
+ genblk1\[5\].genblk1.glitch_inst.genblk1\[3\].genblk1.buffer_inst/A VPWR VGND sg13cmos5l_buf_16
XFILLER_14_145 VPWR VGND sg13cmos5l_decap_4
XFILLER_14_112 VPWR VGND sg13cmos5l_decap_8
XFILLER_9_0 VPWR VGND sg13cmos5l_decap_8
XFILLER_2_14 VPWR VGND sg13cmos5l_decap_8
XFILLER_2_7 VPWR VGND sg13cmos5l_decap_8
XFILLER_17_33 VPWR VGND sg13cmos5l_fill_1
XFILLER_17_11 VPWR VGND sg13cmos5l_fill_2
XFILLER_11_115 VPWR VGND sg13cmos5l_decap_8
Xgenblk1\[3\].genblk1.glitch_inst.genblk1\[4\].genblk1.buffer_inst genblk1\[3\].genblk1.glitch_inst.genblk1\[5\].genblk1.buffer_inst/A
+ genblk1\[3\].genblk1.glitch_inst.genblk1\[4\].genblk1.buffer_inst/A VPWR VGND sg13cmos5l_buf_16
XFILLER_8_46 VPWR VGND sg13cmos5l_fill_2
XFILLER_8_35 VPWR VGND sg13cmos5l_decap_8
Xgenblk1\[1\].genblk1.glitch_inst.xor_inst _08_/A genblk1\[1\].genblk1.glitch_inst.xor_inst/A
+ _00_/A VPWR VGND sg13cmos5l_xor2_1
XFILLER_6_130 VPWR VGND sg13cmos5l_decap_4
XFILLER_3_111 VPWR VGND sg13cmos5l_decap_8
Xgenblk1\[1\].genblk1.glitch_inst.genblk1\[5\].genblk1.buffer_inst _00_/A genblk1\[1\].genblk1.glitch_inst.genblk1\[5\].genblk1.buffer_inst/A
+ VPWR VGND sg13cmos5l_buf_16
XFILLER_5_14 VPWR VGND sg13cmos5l_decap_8
XFILLER_0_125 VPWR VGND sg13cmos5l_decap_8
XFILLER_8_14 VPWR VGND sg13cmos5l_decap_8
XFILLER_17_0 VPWR VGND sg13cmos5l_decap_8
XFILLER_0_104 VPWR VGND sg13cmos5l_decap_8
XFILLER_14_35 VPWR VGND sg13cmos5l_decap_8
XFILLER_10_7 VPWR VGND sg13cmos5l_decap_8
XFILLER_6_91 VPWR VGND sg13cmos5l_decap_8
XFILLER_17_144 VPWR VGND sg13cmos5l_decap_4
Xgenblk1\[2\].genblk1.glitch_inst.xor_inst _09_/A genblk1\[2\].genblk1.glitch_inst.xor_inst/A
+ _01_/A VPWR VGND sg13cmos5l_xor2_1
XFILLER_11_14 VPWR VGND sg13cmos5l_decap_8
XFILLER_11_139 VPWR VGND sg13cmos5l_decap_8
XFILLER_14_14 VPWR VGND sg13cmos5l_decap_8
XFILLER_17_123 VPWR VGND sg13cmos5l_decap_8
XFILLER_2_28 VPWR VGND sg13cmos5l_fill_1
XFILLER_14_126 VPWR VGND sg13cmos5l_decap_8
XFILLER_11_129 VPWR VGND sg13cmos5l_decap_4
XFILLER_7_0 VPWR VGND sg13cmos5l_decap_8
XFILLER_0_7 VPWR VGND sg13cmos5l_decap_8
Xgenblk1\[0\].genblk1.glitch_inst.genblk1\[0\].genblk1.buffer_inst genblk1\[0\].genblk1.glitch_inst.genblk1\[1\].genblk1.buffer_inst/A
+ enable VPWR VGND sg13cmos5l_buf_16
X_13_ _13_/X _13_/A VPWR VGND sg13cmos5l_buf_1
XFILLER_9_70 VPWR VGND sg13cmos5l_fill_1
Xgenblk1\[4\].genblk1.glitch_inst.genblk1\[3\].genblk1.buffer_inst genblk1\[4\].genblk1.glitch_inst.genblk1\[4\].genblk1.buffer_inst/A
+ genblk1\[4\].genblk1.glitch_inst.genblk1\[3\].genblk1.buffer_inst/A VPWR VGND sg13cmos5l_buf_16
XFILLER_0_83 VPWR VGND sg13cmos5l_decap_8
XFILLER_0_139 VPWR VGND sg13cmos5l_decap_8
XFILLER_3_125 VPWR VGND sg13cmos5l_decap_8
Xgenblk1\[3\].genblk1.glitch_inst.xor_inst _10_/A genblk1\[3\].genblk1.glitch_inst.xor_inst/A
+ _02_/A VPWR VGND sg13cmos5l_xor2_1
XFILLER_5_28 VPWR VGND sg13cmos5l_fill_1
XFILLER_17_113 VPWR VGND sg13cmos5l_fill_2
XFILLER_14_149 VPWR VGND sg13cmos5l_fill_1
XFILLER_14_105 VPWR VGND sg13cmos5l_decap_8
Xgenblk1\[2\].genblk1.glitch_inst.genblk1\[4\].genblk1.buffer_inst genblk1\[2\].genblk1.glitch_inst.genblk1\[5\].genblk1.buffer_inst/A
+ genblk1\[2\].genblk1.glitch_inst.genblk1\[4\].genblk1.buffer_inst/A VPWR VGND sg13cmos5l_buf_16
XFILLER_17_26 VPWR VGND sg13cmos5l_decap_8
X_12_ _12_/X _12_/A VPWR VGND sg13cmos5l_buf_1
XFILLER_11_108 VPWR VGND sg13cmos5l_decap_8
XFILLER_10_130 VPWR VGND sg13cmos5l_fill_2
XFILLER_8_28 VPWR VGND sg13cmos5l_decap_8
XFILLER_6_134 VPWR VGND sg13cmos5l_fill_1
XFILLER_6_123 VPWR VGND sg13cmos5l_decap_8
Xgenblk1\[0\].genblk1.glitch_inst.genblk1\[5\].genblk1.buffer_inst _06_/A genblk1\[0\].genblk1.glitch_inst.genblk1\[5\].genblk1.buffer_inst/A
+ VPWR VGND sg13cmos5l_buf_16
XFILLER_3_104 VPWR VGND sg13cmos5l_decap_8
XFILLER_18_80 VPWR VGND sg13cmos5l_decap_8
XFILLER_15_0 VPWR VGND sg13cmos5l_decap_8
XFILLER_0_118 VPWR VGND sg13cmos5l_decap_8
XFILLER_11_28 VPWR VGND sg13cmos5l_fill_1
XFILLER_9_132 VPWR VGND sg13cmos5l_fill_2
X_11_ _11_/X _11_/A VPWR VGND sg13cmos5l_buf_1
Xgenblk1\[4\].genblk1.glitch_inst.xor_inst _11_/A genblk1\[4\].genblk1.glitch_inst.xor_inst/A
+ _03_/A VPWR VGND sg13cmos5l_xor2_1
XFILLER_9_61 VPWR VGND sg13cmos5l_decap_8
XFILLER_14_28 VPWR VGND sg13cmos5l_decap_8
XFILLER_17_148 VPWR VGND sg13cmos5l_fill_2
XFILLER_17_137 VPWR VGND sg13cmos5l_decap_8
XFILLER_15_82 VPWR VGND sg13cmos5l_decap_8
XFILLER_6_62 VPWR VGND sg13cmos5l_decap_4
XFILLER_12_94 VPWR VGND sg13cmos5l_decap_8
X_10_ _10_/X _10_/A VPWR VGND sg13cmos5l_buf_1
XFILLER_10_132 VPWR VGND sg13cmos5l_fill_1
XFILLER_5_0 VPWR VGND sg13cmos5l_decap_8
XFILLER_9_84 VPWR VGND sg13cmos5l_fill_2
XFILLER_0_42 VPWR VGND sg13cmos5l_fill_2
XFILLER_0_97 VPWR VGND sg13cmos5l_decap_8
XFILLER_3_139 VPWR VGND sg13cmos5l_decap_8
XFILLER_9_7 VPWR VGND sg13cmos5l_decap_8
XFILLER_6_30 VPWR VGND sg13cmos5l_fill_1
Xgenblk1\[5\].genblk1.glitch_inst.genblk1\[2\].genblk1.buffer_inst genblk1\[5\].genblk1.glitch_inst.genblk1\[3\].genblk1.buffer_inst/A
+ genblk1\[5\].genblk1.glitch_inst.xor_inst/A VPWR VGND sg13cmos5l_buf_16
XFILLER_14_119 VPWR VGND sg13cmos5l_decap_8
XFILLER_9_134 VPWR VGND sg13cmos5l_fill_1
Xgenblk1\[3\].genblk1.glitch_inst.genblk1\[3\].genblk1.buffer_inst genblk1\[3\].genblk1.glitch_inst.genblk1\[4\].genblk1.buffer_inst/A
+ genblk1\[3\].genblk1.glitch_inst.genblk1\[3\].genblk1.buffer_inst/A VPWR VGND sg13cmos5l_buf_16
Xgenblk1\[5\].genblk1.glitch_inst.xor_inst _12_/A genblk1\[5\].genblk1.glitch_inst.xor_inst/A
+ _04_/A VPWR VGND sg13cmos5l_xor2_1
XFILLER_0_21 VPWR VGND sg13cmos5l_decap_8
XFILLER_0_76 VPWR VGND sg13cmos5l_decap_8
XFILLER_3_118 VPWR VGND sg13cmos5l_decap_8
XFILLER_18_94 VPWR VGND sg13cmos5l_decap_8
Xgenblk1\[1\].genblk1.glitch_inst.genblk1\[4\].genblk1.buffer_inst genblk1\[1\].genblk1.glitch_inst.genblk1\[5\].genblk1.buffer_inst/A
+ genblk1\[1\].genblk1.glitch_inst.genblk1\[4\].genblk1.buffer_inst/A VPWR VGND sg13cmos5l_buf_16
XFILLER_13_0 VPWR VGND sg13cmos5l_decap_8
XFILLER_13_142 VPWR VGND sg13cmos5l_decap_4
XFILLER_10_145 VPWR VGND sg13cmos5l_decap_4
XFILLER_9_146 VPWR VGND sg13cmos5l_decap_4
XFILLER_10_123 VPWR VGND sg13cmos5l_decap_8
XFILLER_3_21 VPWR VGND sg13cmos5l_decap_8
XFILLER_18_73 VPWR VGND sg13cmos5l_decap_8
XFILLER_17_7 VPWR VGND sg13cmos5l_decap_4
XFILLER_17_19 VPWR VGND sg13cmos5l_decap_8
XFILLER_9_86 VPWR VGND sg13cmos5l_fill_1
XFILLER_2_130 VPWR VGND sg13cmos5l_decap_8
XFILLER_6_21 VPWR VGND sg13cmos5l_decap_8
XFILLER_15_96 VPWR VGND sg13cmos5l_decap_8
Xgenblk1\[6\].genblk1.glitch_inst.xor_inst _13_/A rebuffer17/X _05_/A VPWR VGND sg13cmos5l_xor2_1
XFILLER_13_121 VPWR VGND sg13cmos5l_decap_8
XFILLER_9_125 VPWR VGND sg13cmos5l_decap_8
XFILLER_6_139 VPWR VGND sg13cmos5l_decap_8
XFILLER_3_0 VPWR VGND sg13cmos5l_decap_8
XFILLER_9_54 VPWR VGND sg13cmos5l_decap_8
XFILLER_9_21 VPWR VGND sg13cmos5l_decap_8
XFILLER_16_130 VPWR VGND sg13cmos5l_fill_2
Xrebuffer16 rebuffer16/X _05_/X VPWR VGND sg13cmos5l_buf_1
XFILLER_15_75 VPWR VGND sg13cmos5l_decap_8
.ends
