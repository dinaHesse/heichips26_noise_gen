* PEX produced on Fri Aug  7 14:47:50 CEST 2026 using scripts/sak-pex.sh with m=3 and s=1 (extresist threshold=10000 mOhm, minres=1000 mOhm, mindelay=1 ps)
* NGSPICE file created from config_glitch_pex.ext - technology: ihp-sg13cmos5l

.subckt config_glitch_pex VPWR VGND enable out_xor[0] out_xor[1] out_xor[2]
+ out_xor[3] out_xor[4] out_xor[5] out_xor[6] out_xor[7] glitch_en[0]
+ glitch_en[1] glitch_en[2] glitch_en[3] glitch_en[4] glitch_en[5] glitch_en[6]
X0 a_3668_9156# sg13cmos5l_buf_16_14.A VGND.t1 VGND.t661 sg13_lv_nmos ad=0.1406p pd=1.12u as=0.1406p ps=1.12u w=0.74u l=0.13u
X1 sg13cmos5l_buf_1_14.X a_14344_8468# VGND.t116 VGND.t416 sg13_lv_nmos ad=0.2886p pd=2.26u as=0.14875p ps=1.16u w=0.74u l=0.13u
X2 VGND.t377 VPWR.t118 VGND.t377 VGND.t156 sg13_lv_nmos ad=0.1428p pd=1.52u as=0 ps=0 w=0.42u l=1u
X3 sg13cmos5l_buf_16_37.X a_7796_12934# VGND.t315 VGND.t621 sg13_lv_nmos ad=0.1406p pd=1.12u as=0.1406p ps=1.12u w=0.74u l=0.13u
X4 VGND.t897 VPWR.t1694 VGND.t897 VGND.t938 sg13_lv_nmos ad=0.1428p pd=1.52u as=0 ps=0 w=0.42u l=1u
X5 VPWR.t297 a_13667_12956# sg13cmos5l_buf_1_17.A VPWR.t8 sg13_lv_pmos ad=0.1918p pd=1.5u as=0.2128p ps=1.5u w=1.12u l=0.13u
X6 sg13cmos5l_buf_16_30.A a_6164_2350# VPWR.t798 VPWR.t20 sg13_lv_pmos ad=0.2128p pd=1.5u as=0.2128p ps=1.5u w=1.12u l=0.13u
X7 VPWR.t1337 a_3694_7680# sg13cmos5l_buf_16_34.X VPWR.t5 sg13_lv_pmos ad=0.3976p pd=2.95u as=0.2128p ps=1.5u w=1.12u l=0.13u
X8 a_6836_9156# sg13cmos5l_and2_2_6.X VPWR.t243 VPWR.t3 sg13_lv_pmos ad=0.2128p pd=1.5u as=0.2128p ps=1.5u w=1.12u l=0.13u
X9 VGND.t504 a_6164_2350# sg13cmos5l_buf_16_30.A VGND.t508 sg13_lv_nmos ad=0.1406p pd=1.12u as=0.1406p ps=1.12u w=0.74u l=0.13u
X10 VGND.t942 a_4174_13728# sg13cmos5l_buf_16_18.A VGND.t1454 sg13_lv_nmos ad=0.1406p pd=1.12u as=0.1406p ps=1.12u w=0.74u l=0.13u
X11 VGND.t912 a_4174_13728# sg13cmos5l_buf_16_18.A VGND.t1466 sg13_lv_nmos ad=0.1406p pd=1.12u as=0.1406p ps=1.12u w=0.74u l=0.13u
X12 VPWR.t21 a_8494_3144# sg13cmos5l_buf_16_39.A VPWR.t20 sg13_lv_pmos ad=0.2128p pd=1.5u as=0.2128p ps=1.5u w=1.12u l=0.13u
X13 VGND.t130 VPWR.t281 VGND.t130 VGND.t40 sg13_lv_nmos ad=0.1428p pd=1.52u as=0 ps=0 w=0.42u l=1u
X14 sg13cmos5l_buf_16_37.A a_8948_13692# VGND.t693 VGND.t709 sg13_lv_nmos ad=0.1406p pd=1.12u as=0.1406p ps=1.12u w=0.74u l=0.13u
X15 VGND.t315 a_10292_12934# sg13cmos5l_buf_16_23.X VGND.t643 sg13_lv_nmos ad=0.1406p pd=1.12u as=0.1406p ps=1.12u w=0.74u l=0.13u
X16 VGND.t1308 VPWR.t18 VGND.t1308 VGND.t1344 sg13_lv_nmos ad=79.8f pd=0.8u as=0 ps=0 w=0.42u l=1u
X17 sg13cmos5l_buf_16_38.A a_8110_6168# VPWR.t70 VPWR.t70 sg13_lv_pmos ad=0.2128p pd=1.5u as=0.2128p ps=1.5u w=1.12u l=0.13u
X18 VGND.t1207 VPWR.t1624 VGND.t1207 VGND.t1210 sg13_lv_nmos ad=79.8f pd=0.8u as=0 ps=0 w=0.42u l=1u
X19 VGND.t1178 VPWR.t71 VGND.t1178 VGND.t1202 sg13_lv_nmos ad=0.1428p pd=1.52u as=0 ps=0 w=0.42u l=1u
X20 VGND.t315 sg13cmos5l_buf_16_24.X a_6161_12574# VGND.t744 sg13_lv_nmos ad=0.15245p pd=1.17u as=0.17462p ps=1.185u w=0.55u l=0.13u
X21 VPWR.t824 a_3694_10704# sg13cmos5l_and2_2_6.A VPWR.t55 sg13_lv_pmos ad=0.2128p pd=1.5u as=0.2128p ps=1.5u w=1.12u l=0.13u
X22 VGND.t942 a_3694_14482# sg13cmos5l_buf_16_33.A VGND.t1507 sg13_lv_nmos ad=0.1406p pd=1.12u as=0.1406p ps=1.12u w=0.74u l=0.13u
X23 VPWR.t985 VGND.t907 VPWR.t983 VPWR.t8 sg13_lv_pmos ad=0.19p pd=1.38u as=0 ps=0 w=1u l=1u
X24 VPWR.t297 VGND.t934 VPWR.t297 VPWR.t8 sg13_lv_pmos ad=0.19p pd=1.38u as=0 ps=0 w=1u l=1u
X25 VPWR.t1055 VGND.t377 VPWR.t1054 VPWR.t13 sg13_lv_pmos ad=0.34p pd=2.68u as=0 ps=0 w=1u l=1u
X26 VPWR.t771 a_3668_4620# sg13cmos5l_buf_16_8.A VPWR.t28 sg13_lv_pmos ad=0.2128p pd=1.5u as=0.2128p ps=1.5u w=1.12u l=0.13u
X27 sg13cmos5l_buf_16_34.X a_3694_7680# VPWR.t1333 VPWR.t5 sg13_lv_pmos ad=0.2128p pd=1.5u as=0.2128p ps=1.5u w=1.12u l=0.13u
X28 sg13cmos5l_buf_16_30.A a_6164_2350# VGND.t504 VGND.t505 sg13_lv_nmos ad=0.1406p pd=1.12u as=0.1406p ps=1.12u w=0.74u l=0.13u
X29 sg13cmos5l_buf_16_28.X a_5684_6132# VGND.t358 VGND.t833 sg13_lv_nmos ad=0.1406p pd=1.12u as=0.1406p ps=1.12u w=0.74u l=0.13u
X30 VPWR.t926 a_7796_12934# sg13cmos5l_buf_16_37.X VPWR.t8 sg13_lv_pmos ad=0.2128p pd=1.5u as=0.2128p ps=1.5u w=1.12u l=0.13u
X31 VPWR.t245 VGND.t1079 VPWR.t245 VPWR.t3 sg13_lv_pmos ad=0.19p pd=1.38u as=0 ps=0 w=1u l=1u
X32 sg13cmos5l_buf_1_2.X a_8104_1632# VPWR.t7 VPWR.t0 sg13_lv_pmos ad=0.42p pd=2.99u as=0.2114p ps=1.54u w=1.12u l=0.13u
X33 sg13cmos5l_buf_1_17.X a_12232_12216# VGND.t322 VGND.t356 sg13_lv_nmos ad=0.2886p pd=2.26u as=0.14875p ps=1.16u w=0.74u l=0.13u
X34 VPWR.t70 a_8110_6168# sg13cmos5l_buf_16_38.A VPWR.t70 sg13_lv_pmos ad=0.2128p pd=1.5u as=0.2128p ps=1.5u w=1.12u l=0.13u
X35 sg13cmos5l_buf_16_4.X a_9524_6886# VGND.t358 VGND.t825 sg13_lv_nmos ad=0.1406p pd=1.12u as=0.1406p ps=1.12u w=0.74u l=0.13u
X36 a_6129_12216# sg13cmos5l_buf_16_15.A VPWR.t810 VPWR.t13 sg13_lv_pmos ad=0.1225p pd=1.245u as=0.36p ps=2.72u w=1u l=0.13u
X37 VGND.t942 sg13cmos5l_and2_2_1.X a_4174_13728# VGND.t1475 sg13_lv_nmos ad=0.1406p pd=1.12u as=0.1406p ps=1.12u w=0.74u l=0.13u
X38 sg13cmos5l_buf_16_8.A a_3668_4620# VPWR.t767 VPWR.t28 sg13_lv_pmos ad=0.2128p pd=1.5u as=0.2128p ps=1.5u w=1.12u l=0.13u
X39 VGND.t11 VPWR.t1656 VGND.t11 VGND.t1114 sg13_lv_nmos ad=0.1428p pd=1.52u as=0 ps=0 w=0.42u l=1u
X40 VPWR.t78 VGND.t146 VPWR.t78 VPWR.t0 sg13_lv_pmos ad=0.34p pd=2.68u as=0 ps=0 w=1u l=1u
X41 sg13cmos5l_buf_16_35.A a_6766_8434# VGND.t800 VGND.t1555 sg13_lv_nmos ad=0.1406p pd=1.12u as=0.1406p ps=1.12u w=0.74u l=0.13u
X42 VGND.t358 a_9524_6886# sg13cmos5l_buf_16_4.X VGND.t822 sg13_lv_nmos ad=0.1406p pd=1.12u as=0.1406p ps=1.12u w=0.74u l=0.13u
X43 VPWR.t5 VGND.t1178 VPWR.t315 VPWR.t5 sg13_lv_pmos ad=0.19p pd=1.38u as=0 ps=0 w=1u l=1u
X44 VGND.t1060 VPWR.t1666 VGND.t1060 VGND.t1061 sg13_lv_nmos ad=79.8f pd=0.8u as=0 ps=0 w=0.42u l=1u
X45 sg13cmos5l_buf_16_38.A a_8110_6168# VPWR.t70 VPWR.t70 sg13_lv_pmos ad=0.2128p pd=1.5u as=0.2128p ps=1.5u w=1.12u l=0.13u
X46 VPWR.t695 sg13cmos5l_buf_16_34.X a_3694_10704# VPWR.t55 sg13_lv_pmos ad=0.2128p pd=1.5u as=0.2128p ps=1.5u w=1.12u l=0.13u
X47 VPWR.t30 VGND.t1308 VPWR.t30 VPWR.t20 sg13_lv_pmos ad=0.19p pd=1.38u as=0 ps=0 w=1u l=1u
X48 VGND.t11 VPWR.t1652 VGND.t11 VGND.t1113 sg13_lv_nmos ad=79.8f pd=0.8u as=0 ps=0 w=0.42u l=1u
X49 VPWR.t1261 sg13cmos5l_buf_16_37.X a_6548_13692# VPWR.t8 sg13_lv_pmos ad=0.3808p pd=2.92u as=0.2128p ps=1.5u w=1.12u l=0.13u
X50 VPWR.t7 VGND.t1385 VPWR.t1025 VPWR.t0 sg13_lv_pmos ad=0.19p pd=1.38u as=0 ps=0 w=1u l=1u
X51 VGND.t41 a_6094_3898# sg13cmos5l_buf_16_0.A VGND.t40 sg13_lv_nmos ad=0.1406p pd=1.12u as=0.1406p ps=1.12u w=0.74u l=0.13u
X52 VGND.t413 VPWR.t1648 VGND.t413 VGND.t1121 sg13_lv_nmos ad=0.1428p pd=1.52u as=0 ps=0 w=0.42u l=1u
X53 VPWR.t922 a_7796_12934# sg13cmos5l_buf_16_37.X VPWR.t8 sg13_lv_pmos ad=0.2128p pd=1.5u as=0.2128p ps=1.5u w=1.12u l=0.13u
X54 VPWR.t765 a_3668_4620# sg13cmos5l_buf_16_8.A VPWR.t28 sg13_lv_pmos ad=0.2128p pd=1.5u as=0.2128p ps=1.5u w=1.12u l=0.13u
X55 VPWR.t400 VGND.t806 VPWR.t400 VPWR.t70 sg13_lv_pmos ad=0.19p pd=1.38u as=0 ps=0 w=1u l=1u
X56 a_6862_9946# sg13cmos5l_buf_16_24.A VGND.t1 VGND.t95 sg13_lv_nmos ad=0.1406p pd=1.12u as=0.2516p ps=2.16u w=0.74u l=0.13u
X57 sg13cmos5l_buf_16_34.X a_3694_7680# VPWR.t1329 VPWR.t5 sg13_lv_pmos ad=0.2128p pd=1.5u as=0.2128p ps=1.5u w=1.12u l=0.13u
X58 VPWR.t980 VGND.t907 VPWR.t979 VPWR.t292 sg13_lv_pmos ad=0.34p pd=2.68u as=0 ps=0 w=1u l=1u
X59 VGND.t800 a_6766_8434# sg13cmos5l_buf_16_35.A VGND.t1552 sg13_lv_nmos ad=0.1406p pd=1.12u as=0.1406p ps=1.12u w=0.74u l=0.13u
X60 a_3668_9156# sg13cmos5l_buf_16_14.A VGND.t169 VGND.t657 sg13_lv_nmos ad=0.1406p pd=1.12u as=0.1406p ps=1.12u w=0.74u l=0.13u
X61 VGND.t116 sg13cmos5l_buf_1_23.A a_13768_7680# VGND.t220 sg13_lv_nmos ad=0.14875p pd=1.16u as=0.187p ps=1.78u w=0.55u l=0.13u
X62 sg13cmos5l_xor2_1_5.X a_9617_8484# a_9788_8728# VPWR.t3 sg13_lv_pmos ad=0.3808p pd=2.92u as=0.2128p ps=1.5u w=1.12u l=0.13u
X63 sg13cmos5l_buf_16_1.X a_10318_5410# VGND.t82 VGND.t87 sg13_lv_nmos ad=0.1406p pd=1.12u as=0.1406p ps=1.12u w=0.74u l=0.13u
X64 VPWR.t21 VGND.t1296 VPWR.t21 VPWR.t20 sg13_lv_pmos ad=0.34p pd=2.68u as=0 ps=0 w=1u l=1u
X65 VGND.t1302 VPWR.t1 VGND.t1302 VGND.t1338 sg13_lv_nmos ad=79.8f pd=0.8u as=0 ps=0 w=0.42u l=1u
X66 sg13cmos5l_buf_16_25.A a_6836_9156# VPWR.t239 VPWR.t3 sg13_lv_pmos ad=0.2128p pd=1.5u as=0.2128p ps=1.5u w=1.12u l=0.13u
X67 VGND.t806 VPWR.t319 VGND.t806 VGND.t1196 sg13_lv_nmos ad=0.1428p pd=1.52u as=0 ps=0 w=0.42u l=1u
X68 VGND.t150 VPWR.t1613 VGND.t150 VGND.t1284 sg13_lv_nmos ad=0.1428p pd=1.52u as=0 ps=0 w=0.42u l=1u
X69 VPWR.t631 a_10292_12934# sg13cmos5l_buf_16_23.X VPWR.t8 sg13_lv_pmos ad=0.2128p pd=1.5u as=0.2128p ps=1.5u w=1.12u l=0.13u
X70 VGND.t1302 VPWR.t288 VGND.t1306 VGND.t1305 sg13_lv_nmos ad=79.8f pd=0.8u as=0 ps=0 w=0.42u l=1u
X71 VPWR.t56 VGND.t157 VPWR.t56 VPWR.t55 sg13_lv_pmos ad=0.34p pd=2.68u as=0 ps=0 w=1u l=1u
X72 a_6766_8434# sg13cmos5l_buf_16_25.A VGND.t413 VGND.t579 sg13_lv_nmos ad=0.1406p pd=1.12u as=0.1406p ps=1.12u w=0.74u l=0.13u
X73 sg13cmos5l_and2_2_6.A a_3694_10704# VGND.t384 VGND.t156 sg13_lv_nmos ad=0.1406p pd=1.12u as=0.1406p ps=1.12u w=0.74u l=0.13u
X74 VGND.t112 a_8494_3144# sg13cmos5l_buf_16_39.A VGND.t40 sg13_lv_nmos ad=0.1406p pd=1.12u as=0.1406p ps=1.12u w=0.74u l=0.13u
X75 VPWR.t1257 sg13cmos5l_buf_16_37.X a_6548_13692# VPWR.t8 sg13_lv_pmos ad=0.2128p pd=1.5u as=0.2128p ps=1.5u w=1.12u l=0.13u
X76 VPWR.t896 a_3694_3898# sg13cmos5l_buf_16_10.A VPWR.t28 sg13_lv_pmos ad=0.3976p pd=2.95u as=0.2128p ps=1.5u w=1.12u l=0.13u
X77 sg13cmos5l_buf_16_23.X a_10292_12934# VGND.t315 VGND.t646 sg13_lv_nmos ad=0.1406p pd=1.12u as=0.1406p ps=1.12u w=0.74u l=0.13u
X78 a_10292_12934# sg13cmos5l_buf_1_17.A VGND.t322 VGND.t325 sg13_lv_nmos ad=0.1406p pd=1.12u as=0.1406p ps=1.12u w=0.74u l=0.13u
X79 VGND.t82 a_10318_5410# sg13cmos5l_buf_16_1.X VGND.t84 sg13_lv_nmos ad=0.1406p pd=1.12u as=0.1406p ps=1.12u w=0.74u l=0.13u
X80 VGND.t934 VPWR.t297 VGND.t934 VGND.t948 sg13_lv_nmos ad=0.1428p pd=1.52u as=0 ps=0 w=0.42u l=1u
X81 VGND.t1067 VPWR.t1663 VGND.t1060 VGND.t1066 sg13_lv_nmos ad=0.1428p pd=1.52u as=0 ps=0 w=0.42u l=1u
X82 VGND.t27 sg13cmos5l_buf_16_11.A a_3668_4620# VGND.t563 sg13_lv_nmos ad=0.1406p pd=1.12u as=0.1406p ps=1.12u w=0.74u l=0.13u
X83 VPWR.t1566 a_6766_8434# sg13cmos5l_buf_16_35.A VPWR.t3 sg13_lv_pmos ad=0.2128p pd=1.5u as=0.2128p ps=1.5u w=1.12u l=0.13u
X84 VPWR.t134 sg13cmos5l_buf_16_14.A a_6332_9192# VPWR.t3 sg13_lv_pmos ad=0.2128p pd=1.5u as=0.3808p ps=2.92u w=1.12u l=0.13u
X85 VGND.t1119 VPWR.t1649 VGND.t11 VGND.t1118 sg13_lv_nmos ad=0.1428p pd=1.52u as=0 ps=0 w=0.42u l=1u
X86 VPWR.t296 a_14444_14442# sg13cmos5l_and2_2_4.B VPWR.t292 sg13_lv_pmos ad=0.2114p pd=1.54u as=0.42p ps=2.99u w=1.12u l=0.13u
X87 VPWR.t1029 VGND.t519 VPWR.t1028 VPWR.t8 sg13_lv_pmos ad=0.34p pd=2.68u as=0 ps=0 w=1u l=1u
X88 VPWR.t284 VGND.t150 VPWR.t0 VPWR.t0 sg13_lv_pmos ad=0.34p pd=2.68u as=0 ps=0 w=1u l=1u
X89 VGND.t860 a_5108_838# sg13cmos5l_buf_16_5.X VGND.t1443 sg13_lv_nmos ad=0.1406p pd=1.12u as=0.1406p ps=1.12u w=0.74u l=0.13u
X90 sg13cmos5l_buf_16_10.A a_3694_3898# VPWR.t892 VPWR.t28 sg13_lv_pmos ad=0.2128p pd=1.5u as=0.2128p ps=1.5u w=1.12u l=0.13u
X91 VGND.t11 a_9262_7680# sg13cmos5l_buf_16_2.A VGND.t17 sg13_lv_nmos ad=0.1406p pd=1.12u as=0.1406p ps=1.12u w=0.74u l=0.13u
X92 VGND.t198 sg13cmos5l_buf_16_8.A a_3694_3898# VGND.t40 sg13_lv_nmos ad=0.1406p pd=1.12u as=0.1406p ps=1.12u w=0.74u l=0.13u
X93 sg13cmos5l_buf_16_1.X a_10318_5410# VGND.t72 VGND.t80 sg13_lv_nmos ad=0.1406p pd=1.12u as=0.1406p ps=1.12u w=0.74u l=0.13u
X94 VGND.t1020 VPWR.t125 VGND.t1020 VGND.t156 sg13_lv_nmos ad=79.8f pd=0.8u as=0 ps=0 w=0.42u l=1u
X95 sg13cmos5l_buf_16_35.A a_6766_8434# VPWR.t1562 VPWR.t3 sg13_lv_pmos ad=0.2128p pd=1.5u as=0.2128p ps=1.5u w=1.12u l=0.13u
X96 VPWR.t631 a_10292_12934# sg13cmos5l_buf_16_23.X VPWR.t8 sg13_lv_pmos ad=0.2128p pd=1.5u as=0.2128p ps=1.5u w=1.12u l=0.13u
X97 VPWR.t905 VGND.t1020 VPWR.t905 VPWR.t55 sg13_lv_pmos ad=0.34p pd=2.68u as=0 ps=0 w=1u l=1u
X98 VGND.t1020 VPWR.t905 VGND.t1020 VGND.t156 sg13_lv_nmos ad=79.8f pd=0.8u as=0 ps=0 w=0.42u l=1u
X99 sg13cmos5l_buf_16_13.A a_3668_9156# VPWR.t484 VPWR.t3 sg13_lv_pmos ad=0.2128p pd=1.5u as=0.2128p ps=1.5u w=1.12u l=0.13u
X100 sg13cmos5l_buf_16_5.X a_5108_838# VGND.t860 VGND.t1438 sg13_lv_nmos ad=0.1406p pd=1.12u as=0.1406p ps=1.12u w=0.74u l=0.13u
X101 VPWR.t319 a_10318_5410# sg13cmos5l_buf_16_1.X VPWR.t70 sg13_lv_pmos ad=0.2128p pd=1.5u as=0.2128p ps=1.5u w=1.12u l=0.13u
X102 VGND.t1004 VPWR.t1676 VGND.t1004 VGND.t156 sg13_lv_nmos ad=0.1428p pd=1.52u as=0 ps=0 w=0.42u l=1u
X103 sg13cmos5l_buf_16_5.X a_5108_838# VPWR.t19 VPWR.t0 sg13_lv_pmos ad=0.2128p pd=1.5u as=0.2128p ps=1.5u w=1.12u l=0.13u
X104 VPWR.t564 sg13cmos5l_buf_16_10.A a_3668_3108# VPWR.t20 sg13_lv_pmos ad=0.2128p pd=1.5u as=0.2128p ps=1.5u w=1.12u l=0.13u
X105 VPWR.t1488 a_6548_13692# sg13cmos5l_buf_16_27.X VPWR.t8 sg13_lv_pmos ad=0.2128p pd=1.5u as=0.2128p ps=1.5u w=1.12u l=0.13u
X106 VGND.t282 a_7220_5374# sg13cmos5l_buf_16_28.A VGND.t283 sg13_lv_nmos ad=0.1406p pd=1.12u as=0.1406p ps=1.12u w=0.74u l=0.13u
X107 sg13cmos5l_buf_16_2.A a_9262_7680# VGND.t11 VGND.t14 sg13_lv_nmos ad=0.1406p pd=1.12u as=0.1406p ps=1.12u w=0.74u l=0.13u
X108 sg13cmos5l_buf_16_20.A a_5204_11422# VPWR.t1299 VPWR.t13 sg13_lv_pmos ad=0.2128p pd=1.5u as=0.2128p ps=1.5u w=1.12u l=0.13u
X109 VGND.t322 VPWR.t129 VGND.t573 VGND.t967 sg13_lv_nmos ad=79.8f pd=0.8u as=0 ps=0 w=0.42u l=1u
X110 a_3694_3898# sg13cmos5l_buf_16_8.A VGND.t198 VGND.t40 sg13_lv_nmos ad=0.1406p pd=1.12u as=0.2516p ps=2.16u w=0.74u l=0.13u
X111 VPWR.t913 VGND.t639 VPWR.t914 VPWR.t292 sg13_lv_pmos ad=0.34p pd=2.68u as=0 ps=0 w=1u l=1u
X112 VGND.t41 a_6094_3898# sg13cmos5l_buf_16_0.A VGND.t40 sg13_lv_nmos ad=0.1406p pd=1.12u as=0.1406p ps=1.12u w=0.74u l=0.13u
X113 VPWR.t1177 VGND.t1004 VPWR.t1175 VPWR.t55 sg13_lv_pmos ad=0.19p pd=1.38u as=0 ps=0 w=1u l=1u
X114 sg13cmos5l_buf_16_3.X a_10292_4620# VPWR.t202 VPWR.t28 sg13_lv_pmos ad=0.2128p pd=1.5u as=0.2128p ps=1.5u w=1.12u l=0.13u
X115 VPWR.t421 VGND.t358 VPWR.t420 VPWR.t5 sg13_lv_pmos ad=0.34p pd=2.68u as=0 ps=0 w=1u l=1u
X116 VGND.t693 VPWR.t292 VGND.t693 VGND.t921 sg13_lv_nmos ad=79.8f pd=0.8u as=0 ps=0 w=0.42u l=1u
X117 VGND.t23 a_3668_4620# sg13cmos5l_buf_16_8.A VGND.t472 sg13_lv_nmos ad=0.1406p pd=1.12u as=0.1406p ps=1.12u w=0.74u l=0.13u
X118 VPWR.t1455 a_2147_13692# sg13cmos5l_and2_2_1.X VPWR.t8 sg13_lv_pmos ad=0.1918p pd=1.5u as=0.2128p ps=1.5u w=1.12u l=0.13u
X119 VPWR.t482 a_3668_9156# sg13cmos5l_buf_16_13.A VPWR.t3 sg13_lv_pmos ad=0.2128p pd=1.5u as=0.2128p ps=1.5u w=1.12u l=0.13u
X120 VPWR.t19 VGND.t150 VPWR.t78 VPWR.t0 sg13_lv_pmos ad=0.34p pd=2.68u as=0 ps=0 w=1u l=1u
X121 sg13cmos5l_buf_16_1.X a_10318_5410# VPWR.t400 VPWR.t70 sg13_lv_pmos ad=0.2128p pd=1.5u as=0.2128p ps=1.5u w=1.12u l=0.13u
X122 VGND.t157 VPWR.t56 VGND.t157 VGND.t156 sg13_lv_nmos ad=79.8f pd=0.8u as=0 ps=0 w=0.42u l=1u
X123 VPWR.t19 a_5108_838# sg13cmos5l_buf_16_5.X VPWR.t0 sg13_lv_pmos ad=0.2128p pd=1.5u as=0.2128p ps=1.5u w=1.12u l=0.13u
X124 VPWR.t328 VGND.t999 VPWR.t326 VPWR.t13 sg13_lv_pmos ad=0.19p pd=1.38u as=0 ps=0 w=1u l=1u
X125 VPWR.t37 VGND.t1430 VPWR.t18 VPWR.t0 sg13_lv_pmos ad=0.19p pd=1.38u as=0 ps=0 w=1u l=1u
X126 VGND.t1 sg13cmos5l_buf_16_20.A a_4436_9910# VGND.t219 sg13_lv_nmos ad=0.2516p pd=2.16u as=0.1406p ps=1.12u w=0.74u l=0.13u
X127 VGND.t1296 VPWR.t21 VGND.t1296 VGND.t1297 sg13_lv_nmos ad=79.8f pd=0.8u as=0 ps=0 w=0.42u l=1u
X128 VGND.t1403 VPWR.t1 VGND.t1405 VGND.t1404 sg13_lv_nmos ad=79.8f pd=0.8u as=0 ps=0 w=0.42u l=1u
X129 VGND.t41 a_6094_3144# sg13cmos5l_xor2_1_0.B VGND.t40 sg13_lv_nmos ad=0.1406p pd=1.12u as=0.1406p ps=1.12u w=0.74u l=0.13u
X130 VGND.t11 a_9262_7680# sg13cmos5l_buf_16_2.A VGND.t10 sg13_lv_nmos ad=0.1406p pd=1.12u as=0.1406p ps=1.12u w=0.74u l=0.13u
X131 VGND.t315 VPWR.t1684 VGND.t315 VGND.t954 sg13_lv_nmos ad=0.1428p pd=1.52u as=0 ps=0 w=0.42u l=1u
X132 sg13cmos5l_buf_16_6.X a_5518_6922# VPWR.t1214 VPWR.t5 sg13_lv_pmos ad=0.2128p pd=1.5u as=0.2128p ps=1.5u w=1.12u l=0.13u
X133 VPWR.t631 a_10292_12934# sg13cmos5l_buf_16_23.X VPWR.t8 sg13_lv_pmos ad=0.2128p pd=1.5u as=0.2128p ps=1.5u w=1.12u l=0.13u
X134 sg13cmos5l_buf_16_10.A a_3694_3898# VPWR.t888 VPWR.t28 sg13_lv_pmos ad=0.2128p pd=1.5u as=0.2128p ps=1.5u w=1.12u l=0.13u
X135 sg13cmos5l_buf_16_15.X a_3668_12180# VPWR.t645 VPWR.t13 sg13_lv_pmos ad=0.2128p pd=1.5u as=0.2128p ps=1.5u w=1.12u l=0.13u
X136 sg13cmos5l_buf_16_15.X a_3668_12180# VPWR.t657 VPWR.t13 sg13_lv_pmos ad=0.2128p pd=1.5u as=0.2128p ps=1.5u w=1.12u l=0.13u
X137 VPWR.t24 VGND.t1390 VPWR.t24 VPWR.t0 sg13_lv_pmos ad=0.19p pd=1.38u as=0 ps=0 w=1u l=1u
X138 VPWR.t202 a_10292_4620# sg13cmos5l_buf_16_3.X VPWR.t28 sg13_lv_pmos ad=0.2128p pd=1.5u as=0.2128p ps=1.5u w=1.12u l=0.13u
X139 VPWR.t604 a_7220_5374# sg13cmos5l_buf_16_28.A VPWR.t70 sg13_lv_pmos ad=0.2128p pd=1.5u as=0.2128p ps=1.5u w=1.12u l=0.13u
X140 sg13cmos5l_buf_16_6.X a_5518_6922# VGND.t358 VGND.t680 sg13_lv_nmos ad=0.1406p pd=1.12u as=0.1406p ps=1.12u w=0.74u l=0.13u
X141 sg13cmos5l_buf_16_20.A a_5204_11422# VPWR.t1295 VPWR.t13 sg13_lv_pmos ad=0.2128p pd=1.5u as=0.2128p ps=1.5u w=1.12u l=0.13u
X142 VPWR.t550 a_6862_9946# sg13cmos5l_buf_16_24.X VPWR.t55 sg13_lv_pmos ad=0.2128p pd=1.5u as=0.2128p ps=1.5u w=1.12u l=0.13u
X143 sg13cmos5l_buf_16_5.X a_5108_838# VPWR.t19 VPWR.t0 sg13_lv_pmos ad=0.2128p pd=1.5u as=0.3976p ps=2.95u w=1.12u l=0.13u
X144 VPWR.t19 sg13cmos5l_buf_16_30.A a_5710_1632# VPWR.t0 sg13_lv_pmos ad=0.2128p pd=1.5u as=0.2128p ps=1.5u w=1.12u l=0.13u
X145 VPWR.t284 VGND.t1356 VPWR.t284 VPWR.t0 sg13_lv_pmos ad=0.19p pd=1.38u as=0 ps=0 w=1u l=1u
X146 VGND.t942 VPWR.t1693 VGND.t942 VGND.t943 sg13_lv_nmos ad=79.8f pd=0.8u as=0 ps=0 w=0.42u l=1u
X147 VPWR.t34 VGND.t868 VPWR.t32 VPWR.t20 sg13_lv_pmos ad=0.34p pd=2.68u as=0 ps=0 w=1u l=1u
X148 sg13cmos5l_buf_16_28.A a_7220_5374# VPWR.t600 VPWR.t70 sg13_lv_pmos ad=0.2128p pd=1.5u as=0.2128p ps=1.5u w=1.12u l=0.13u
X149 VPWR.t189 VGND.t261 VPWR.t189 VPWR.t3 sg13_lv_pmos ad=0.34p pd=2.68u as=0 ps=0 w=1u l=1u
X150 VPWR.t107 VGND.t315 VPWR.t106 VPWR.t13 sg13_lv_pmos ad=0.34p pd=2.68u as=0 ps=0 w=1u l=1u
X151 VGND.t27 a_4462_5410# sg13cmos5l_buf_16_11.A VGND.t31 sg13_lv_nmos ad=0.1406p pd=1.12u as=0.1406p ps=1.12u w=0.74u l=0.13u
X152 VGND.t377 a_6094_10704# sg13cmos5l_buf_16_24.A VGND.t156 sg13_lv_nmos ad=0.1406p pd=1.12u as=0.1406p ps=1.12u w=0.74u l=0.13u
X153 VPWR.t994 VGND.t150 VPWR.t993 VPWR.t20 sg13_lv_pmos ad=0.34p pd=2.68u as=0 ps=0 w=1u l=1u
X154 VGND.t358 a_5518_6922# sg13cmos5l_buf_16_6.X VGND.t677 sg13_lv_nmos ad=0.1406p pd=1.12u as=0.1406p ps=1.12u w=0.74u l=0.13u
X155 VPWR.t5 VGND.t116 VPWR.t5 VPWR.t5 sg13_lv_pmos ad=0.34p pd=2.68u as=0 ps=0 w=1u l=1u
X156 VGND.t584 sg13cmos5l_buf_16_39.A a_8694_2398# VGND.t1574 sg13_lv_nmos ad=0.15245p pd=1.17u as=88.8f ps=0.98u w=0.74u l=0.13u
X157 VPWR.t118 VGND.t377 VPWR.t118 VPWR.t13 sg13_lv_pmos ad=0.19p pd=1.38u as=0 ps=0 w=1u l=1u
X158 VPWR.t292 VGND.t639 VPWR.t911 VPWR.t292 sg13_lv_pmos ad=0.34p pd=2.68u as=0 ps=0 w=1u l=1u
X159 VGND.t165 VPWR.t1662 VGND.t165 VGND.t1069 sg13_lv_nmos ad=0.1428p pd=1.52u as=0 ps=0 w=0.42u l=1u
X160 VGND.t584 VPWR.t1025 VGND.t584 VGND.t1329 sg13_lv_nmos ad=0.1428p pd=1.52u as=0 ps=0 w=0.42u l=1u
X161 VPWR.t547 sg13cmos5l_buf_16_24.A a_6862_9946# VPWR.t55 sg13_lv_pmos ad=0.2128p pd=1.5u as=0.2128p ps=1.5u w=1.12u l=0.13u
X162 sg13cmos5l_buf_16_11.A a_4462_5410# VGND.t27 VGND.t28 sg13_lv_nmos ad=0.1406p pd=1.12u as=0.1406p ps=1.12u w=0.74u l=0.13u
X163 VPWR.t816 sg13cmos5l_buf_16_15.A a_3668_12180# VPWR.t13 sg13_lv_pmos ad=0.3808p pd=2.92u as=0.2128p ps=1.5u w=1.12u l=0.13u
X164 VGND.t198 a_3668_3108# sg13cmos5l_buf_16_7.A VGND.t40 sg13_lv_nmos ad=0.1406p pd=1.12u as=0.1406p ps=1.12u w=0.74u l=0.13u
X165 VPWR.t71 VGND.t1178 VPWR.t71 VPWR.t70 sg13_lv_pmos ad=0.34p pd=2.68u as=0 ps=0 w=1u l=1u
X166 VPWR.t284 VGND.t150 VPWR.t284 VPWR.t0 sg13_lv_pmos ad=0.34p pd=2.68u as=0 ps=0 w=1u l=1u
X167 VGND.t1296 VPWR.t24 VGND.t1296 VGND.t1334 sg13_lv_nmos ad=79.8f pd=0.8u as=0 ps=0 w=0.42u l=1u
X168 VGND.t112 sg13cmos5l_buf_16_2.A a_10318_3898# VGND.t40 sg13_lv_nmos ad=0.1406p pd=1.12u as=0.1406p ps=1.12u w=0.74u l=0.13u
X169 VGND.t358 VPWR.t70 VGND.t358 VGND.t1192 sg13_lv_nmos ad=0.1428p pd=1.52u as=0 ps=0 w=0.42u l=1u
X170 VPWR.t12 VGND.t332 VPWR.t988 VPWR.t8 sg13_lv_pmos ad=0.19p pd=1.38u as=0 ps=0 w=1u l=1u
X171 VPWR.t18 VGND.t1415 VPWR.t18 VPWR.t0 sg13_lv_pmos ad=0.19p pd=1.38u as=0 ps=0 w=1u l=1u
X172 VPWR.t1458 a_4174_13728# sg13cmos5l_buf_16_18.A VPWR.t8 sg13_lv_pmos ad=0.2128p pd=1.5u as=0.2128p ps=1.5u w=1.12u l=0.13u
X173 VPWR.t1470 a_4174_13728# sg13cmos5l_buf_16_18.A VPWR.t8 sg13_lv_pmos ad=0.2128p pd=1.5u as=0.2128p ps=1.5u w=1.12u l=0.13u
X174 VGND.t639 VPWR.t297 VGND.t934 VGND.t947 sg13_lv_nmos ad=79.8f pd=0.8u as=0 ps=0 w=0.42u l=1u
X175 a_10292_4620# sg13cmos5l_buf_16_2.X VGND.t126 VGND.t127 sg13_lv_nmos ad=0.1406p pd=1.12u as=0.1406p ps=1.12u w=0.74u l=0.13u
X176 out_xor[3] a_14824_6956# VPWR.t201 VPWR.t5 sg13_lv_pmos ad=0.42p pd=2.99u as=0.2114p ps=1.54u w=1.12u l=0.13u
X177 a_3694_2386# sg13cmos5l_buf_16_7.A VPWR.t275 VPWR.t20 sg13_lv_pmos ad=0.2128p pd=1.5u as=0.2128p ps=1.5u w=1.12u l=0.13u
X178 sg13cmos5l_buf_16_37.A a_8948_13692# VPWR.t631 VPWR.t8 sg13_lv_pmos ad=0.2128p pd=1.5u as=0.2128p ps=1.5u w=1.12u l=0.13u
X179 VGND.t150 a_3694_2386# sg13cmos5l_buf_16_7.X VGND.t479 sg13_lv_nmos ad=0.1406p pd=1.12u as=0.1406p ps=1.12u w=0.74u l=0.13u
X180 VPWR.t342 VGND.t11 VPWR.t342 VPWR.t5 sg13_lv_pmos ad=0.34p pd=2.68u as=0 ps=0 w=1u l=1u
X181 sg13cmos5l_buf_16_5.A a_5710_1632# VGND.t491 VGND.t880 sg13_lv_nmos ad=0.1406p pd=1.12u as=0.1406p ps=1.12u w=0.74u l=0.13u
X182 VGND.t868 VPWR.t18 VGND.t868 VGND.t1345 sg13_lv_nmos ad=0.1428p pd=1.52u as=0 ps=0 w=0.42u l=1u
X183 VGND.t41 a_6094_3144# sg13cmos5l_xor2_1_0.B VGND.t40 sg13_lv_nmos ad=0.1406p pd=1.12u as=0.1406p ps=1.12u w=0.74u l=0.13u
X184 sg13cmos5l_buf_16_7.A a_3668_3108# VGND.t198 VGND.t40 sg13_lv_nmos ad=0.1406p pd=1.12u as=0.2516p ps=2.16u w=0.74u l=0.13u
X185 VPWR.t1027 VGND.t519 VPWR.t101 VPWR.t8 sg13_lv_pmos ad=0.19p pd=1.38u as=0 ps=0 w=1u l=1u
X186 VGND.t1 sg13cmos5l_buf_16_20.A a_4436_9910# VGND.t215 sg13_lv_nmos ad=0.1406p pd=1.12u as=0.1406p ps=1.12u w=0.74u l=0.13u
X187 VGND.t1383 VPWR.t7 VGND.t1382 VGND.t1381 sg13_lv_nmos ad=0.1428p pd=1.52u as=0 ps=0 w=0.42u l=1u
X188 VPWR.t202 a_10318_3898# sg13cmos5l_buf_16_2.X VPWR.t28 sg13_lv_pmos ad=0.2128p pd=1.5u as=0.2128p ps=1.5u w=1.12u l=0.13u
X189 sg13cmos5l_buf_16_11.A a_4462_5410# VPWR.t159 VPWR.t70 sg13_lv_pmos ad=0.2128p pd=1.5u as=0.2128p ps=1.5u w=1.12u l=0.13u
X190 VGND.t358 a_8110_6168# sg13cmos5l_buf_16_38.A VGND.t551 sg13_lv_nmos ad=0.1406p pd=1.12u as=0.1406p ps=1.12u w=0.74u l=0.13u
X191 VGND.t82 sg13cmos5l_buf_16_2.X a_10292_4620# VGND.t123 sg13_lv_nmos ad=0.1406p pd=1.12u as=0.1406p ps=1.12u w=0.74u l=0.13u
X192 VPWR.t424 VGND.t358 VPWR.t423 VPWR.t5 sg13_lv_pmos ad=0.34p pd=2.68u as=0 ps=0 w=1u l=1u
X193 sg13cmos5l_buf_16_15.X a_3668_12180# VGND.t342 VGND.t343 sg13_lv_nmos ad=0.1406p pd=1.12u as=0.1406p ps=1.12u w=0.74u l=0.13u
X194 VPWR.t812 sg13cmos5l_buf_16_15.A a_3668_12180# VPWR.t13 sg13_lv_pmos ad=0.2128p pd=1.5u as=0.2128p ps=1.5u w=1.12u l=0.13u
X195 VPWR.t245 VGND.t1079 VPWR.t245 VPWR.t3 sg13_lv_pmos ad=0.34p pd=2.68u as=0 ps=0 w=1u l=1u
X196 VPWR.t189 VGND.t11 VPWR.t189 VPWR.t3 sg13_lv_pmos ad=0.34p pd=2.68u as=0 ps=0 w=1u l=1u
X197 VGND.t584 VPWR.t21 VGND.t584 VGND.t1293 sg13_lv_nmos ad=0.1428p pd=1.52u as=0 ps=0 w=0.42u l=1u
X198 sg13cmos5l_buf_16_7.X a_3694_2386# VGND.t150 VGND.t476 sg13_lv_nmos ad=0.1406p pd=1.12u as=0.1406p ps=1.12u w=0.74u l=0.13u
X199 VPWR.t533 a_6094_3898# sg13cmos5l_buf_16_0.A VPWR.t28 sg13_lv_pmos ad=0.2128p pd=1.5u as=0.2128p ps=1.5u w=1.12u l=0.13u
X200 VGND.t1153 VPWR.t1644 VGND.t1153 VGND.t1156 sg13_lv_nmos ad=79.8f pd=0.8u as=0 ps=0 w=0.42u l=1u
X201 VPWR.t357 VGND.t1060 VPWR.t357 VPWR.t55 sg13_lv_pmos ad=0.19p pd=1.38u as=0 ps=0 w=1u l=1u
X202 out_xor[0] a_14824_1632# VPWR.t38 VPWR.t0 sg13_lv_pmos ad=0.42p pd=2.99u as=0.2114p ps=1.54u w=1.12u l=0.13u
X203 VGND.t358 sg13cmos5l_buf_16_28.A a_5684_6132# VGND.t420 sg13_lv_nmos ad=0.1406p pd=1.12u as=0.1406p ps=1.12u w=0.74u l=0.13u
X204 VPWR.t672 sg13cmos5l_buf_16_28.X a_5518_6922# VPWR.t5 sg13_lv_pmos ad=0.2128p pd=1.5u as=0.2128p ps=1.5u w=1.12u l=0.13u
X205 VPWR.t1479 sg13cmos5l_and2_2_1.X a_4174_13728# VPWR.t8 sg13_lv_pmos ad=0.2128p pd=1.5u as=0.2128p ps=1.5u w=1.12u l=0.13u
X206 a_13675_9988# sg13cmos5l_buf_16_22.X a_13581_9988# VGND.t153 sg13_lv_nmos ad=0.1216p pd=1.02u as=0.2176p ps=1.96u w=0.64u l=0.13u
X207 VPWR.t21 VGND.t1296 VPWR.t21 VPWR.t20 sg13_lv_pmos ad=0.19p pd=1.38u as=0 ps=0 w=1u l=1u
X208 VPWR.t157 a_4462_5410# sg13cmos5l_buf_16_11.A VPWR.t70 sg13_lv_pmos ad=0.2128p pd=1.5u as=0.2128p ps=1.5u w=1.12u l=0.13u
X209 VPWR.t472 a_4436_9910# sg13cmos5l_buf_16_14.A VPWR.t55 sg13_lv_pmos ad=0.2128p pd=1.5u as=0.2128p ps=1.5u w=1.12u l=0.13u
X210 VGND.t112 sg13cmos5l_buf_16_2.A a_10318_3898# VGND.t40 sg13_lv_nmos ad=0.1406p pd=1.12u as=0.1406p ps=1.12u w=0.74u l=0.13u
X211 sg13cmos5l_xor2_1_0.B a_6094_3144# VPWR.t169 VPWR.t20 sg13_lv_pmos ad=0.2128p pd=1.5u as=0.2128p ps=1.5u w=1.12u l=0.13u
X212 VPWR.t1050 VGND.t198 VPWR.t54 VPWR.t20 sg13_lv_pmos ad=0.19p pd=1.38u as=0 ps=0 w=1u l=1u
X213 VPWR.t5 VGND.t1178 VPWR.t5 VPWR.t5 sg13_lv_pmos ad=0.34p pd=2.68u as=0 ps=0 w=1u l=1u
X214 VPWR.t131 VGND.t1020 VPWR.t131 VPWR.t13 sg13_lv_pmos ad=0.19p pd=1.38u as=0 ps=0 w=1u l=1u
X215 VGND.t150 sg13cmos5l_buf_16_7.A a_3694_2386# VGND.t152 sg13_lv_nmos ad=0.1406p pd=1.12u as=0.1406p ps=1.12u w=0.74u l=0.13u
X216 VGND.t1176 VPWR.t315 VGND.t1176 VGND.t1175 sg13_lv_nmos ad=0.1428p pd=1.52u as=0 ps=0 w=0.42u l=1u
X217 sg13cmos5l_buf_16_24.A a_6094_10704# VGND.t377 VGND.t156 sg13_lv_nmos ad=0.1406p pd=1.12u as=0.1406p ps=1.12u w=0.74u l=0.13u
X218 VPWR.t864 sg13cmos5l_buf_16_11.A a_3668_4620# VPWR.t28 sg13_lv_pmos ad=0.3808p pd=2.92u as=0.2128p ps=1.5u w=1.12u l=0.13u
X219 VPWR.t808 a_6164_2350# sg13cmos5l_buf_16_30.A VPWR.t20 sg13_lv_pmos ad=0.2128p pd=1.5u as=0.2128p ps=1.5u w=1.12u l=0.13u
X220 a_5684_6132# sg13cmos5l_buf_16_28.A VGND.t358 VGND.t417 sg13_lv_nmos ad=0.1406p pd=1.12u as=0.1406p ps=1.12u w=0.74u l=0.13u
X221 VGND.t315 VPWR.t123 VGND.t315 VGND.t986 sg13_lv_nmos ad=0.1428p pd=1.52u as=0 ps=0 w=0.42u l=1u
X222 VPWR.t168 sg13cmos5l_buf_16_5.X a_6094_3144# VPWR.t20 sg13_lv_pmos ad=0.2128p pd=1.5u as=0.2128p ps=1.5u w=1.12u l=0.13u
X223 VPWR.t319 VGND.t806 VPWR.t400 VPWR.t70 sg13_lv_pmos ad=0.34p pd=2.68u as=0 ps=0 w=1u l=1u
X224 VGND.t1060 VPWR.t357 VGND.t1060 VGND.t1076 sg13_lv_nmos ad=79.8f pd=0.8u as=0 ps=0 w=0.42u l=1u
X225 a_8948_13692# sg13cmos5l_buf_16_23.X VGND.t693 VGND.t695 sg13_lv_nmos ad=0.1406p pd=1.12u as=0.1406p ps=1.12u w=0.74u l=0.13u
X226 a_3668_4620# sg13cmos5l_buf_16_11.A VPWR.t860 VPWR.t28 sg13_lv_pmos ad=0.2128p pd=1.5u as=0.2128p ps=1.5u w=1.12u l=0.13u
X227 VPWR.t468 a_4436_9910# sg13cmos5l_buf_16_14.A VPWR.t55 sg13_lv_pmos ad=0.2128p pd=1.5u as=0.2128p ps=1.5u w=1.12u l=0.13u
X228 sg13cmos5l_buf_16_30.A a_6164_2350# VPWR.t804 VPWR.t20 sg13_lv_pmos ad=0.2128p pd=1.5u as=0.2128p ps=1.5u w=1.12u l=0.13u
X229 sg13cmos5l_buf_16_23.X a_10292_12934# VGND.t315 VGND.t640 sg13_lv_nmos ad=0.1406p pd=1.12u as=0.2516p ps=2.16u w=0.74u l=0.13u
X230 VGND.t693 a_8948_13692# sg13cmos5l_buf_16_37.A VGND.t706 sg13_lv_nmos ad=0.1406p pd=1.12u as=0.1406p ps=1.12u w=0.74u l=0.13u
X231 VGND.t1308 VPWR.t288 VGND.t1308 VGND.t1307 sg13_lv_nmos ad=0.1428p pd=1.52u as=0 ps=0 w=0.42u l=1u
X232 VPWR.t905 VGND.t1020 VPWR.t905 VPWR.t55 sg13_lv_pmos ad=0.34p pd=2.68u as=0 ps=0 w=1u l=1u
X233 VPWR.t4 VGND.t397 VPWR.t4 VPWR.t3 sg13_lv_pmos ad=0.19p pd=1.38u as=0 ps=0 w=1u l=1u
X234 VGND.t584 VPWR.t24 VGND.t584 VGND.t1331 sg13_lv_nmos ad=0.1428p pd=1.52u as=0 ps=0 w=0.42u l=1u
X235 sg13cmos5l_and2_2_6.A a_3694_10704# VPWR.t695 VPWR.t55 sg13_lv_pmos ad=0.2128p pd=1.5u as=0.2128p ps=1.5u w=1.12u l=0.13u
X236 sg13cmos5l_buf_16_5.A a_5710_1632# VGND.t491 VGND.t876 sg13_lv_nmos ad=0.1406p pd=1.12u as=0.1406p ps=1.12u w=0.74u l=0.13u
X237 sg13cmos5l_buf_1_2.X a_8104_1632# VGND.t504 VGND.t872 sg13_lv_nmos ad=0.2886p pd=2.26u as=0.14875p ps=1.16u w=0.74u l=0.13u
X238 VGND.t282 sg13cmos5l_buf_16_38.A a_7220_5374# VGND.t845 sg13_lv_nmos ad=0.1406p pd=1.12u as=0.1406p ps=1.12u w=0.74u l=0.13u
X239 VGND.t1235 VPWR.t28 VGND.t72 VGND.t1236 sg13_lv_nmos ad=79.8f pd=0.8u as=0 ps=0 w=0.42u l=1u
X240 sg13cmos5l_buf_16_31.X a_6094_4656# VGND.t27 VGND.t441 sg13_lv_nmos ad=0.1406p pd=1.12u as=0.1406p ps=1.12u w=0.74u l=0.13u
X241 sg13cmos5l_buf_16_33.A a_3694_14482# VPWR.t1515 VPWR.t292 sg13_lv_pmos ad=0.2128p pd=1.5u as=0.2128p ps=1.5u w=1.12u l=0.13u
X242 sg13cmos5l_buf_16_4.X a_9524_6886# VPWR.t136 VPWR.t5 sg13_lv_pmos ad=0.2128p pd=1.5u as=0.2128p ps=1.5u w=1.12u l=0.13u
X243 VGND.t358 VPWR.t400 VGND.t358 VGND.t1194 sg13_lv_nmos ad=0.1428p pd=1.52u as=0 ps=0 w=0.42u l=1u
X244 VGND.t1004 VPWR.t1668 VGND.t1004 VGND.t156 sg13_lv_nmos ad=79.8f pd=0.8u as=0 ps=0 w=0.42u l=1u
X245 VPWR.t18 VGND.t1420 VPWR.t18 VPWR.t0 sg13_lv_pmos ad=0.19p pd=1.38u as=0 ps=0 w=1u l=1u
X246 VGND.t275 sg13cmos5l_buf_16_13.A a_3694_8434# VGND.t276 sg13_lv_nmos ad=0.1406p pd=1.12u as=0.1406p ps=1.12u w=0.74u l=0.13u
X247 sg13cmos5l_buf_16_37.A a_8948_13692# VGND.t693 VGND.t713 sg13_lv_nmos ad=0.1406p pd=1.12u as=0.1406p ps=1.12u w=0.74u l=0.13u
X248 VPWR.t369 VGND.t1060 VPWR.t367 VPWR.t3 sg13_lv_pmos ad=0.19p pd=1.38u as=0 ps=0 w=1u l=1u
X249 sg13cmos5l_buf_16_28.A a_7220_5374# VGND.t282 VGND.t296 sg13_lv_nmos ad=0.1406p pd=1.12u as=0.1406p ps=1.12u w=0.74u l=0.13u
X250 a_9524_6886# sg13cmos5l_buf_16_4.A VGND.t806 VGND.t807 sg13_lv_nmos ad=0.1406p pd=1.12u as=0.1406p ps=1.12u w=0.74u l=0.13u
X251 VPWR.t1167 VGND.t1004 VPWR.t330 VPWR.t13 sg13_lv_pmos ad=0.19p pd=1.38u as=0 ps=0 w=1u l=1u
X252 VGND.t157 sg13cmos5l_and2_2_3.X a_13745_11508# VGND.t156 sg13_lv_nmos ad=0.15245p pd=1.17u as=0.17462p ps=1.185u w=0.55u l=0.13u
X253 VPWR.t136 a_9262_7680# sg13cmos5l_buf_16_2.A VPWR.t5 sg13_lv_pmos ad=0.2128p pd=1.5u as=0.2128p ps=1.5u w=1.12u l=0.13u
X254 VGND.t907 VPWR.t1701 VGND.t907 VGND.t906 sg13_lv_nmos ad=0.1428p pd=1.52u as=0 ps=0 w=0.42u l=1u
X255 VGND.t27 sg13cmos5l_buf_16_7.X a_6094_4656# VGND.t37 sg13_lv_nmos ad=0.1406p pd=1.12u as=0.1406p ps=1.12u w=0.74u l=0.13u
X256 VGND.t693 a_8948_13692# sg13cmos5l_buf_16_37.A VGND.t702 sg13_lv_nmos ad=0.1406p pd=1.12u as=0.1406p ps=1.12u w=0.74u l=0.13u
X257 VPWR.t153 a_4462_5410# sg13cmos5l_buf_16_11.A VPWR.t70 sg13_lv_pmos ad=0.2128p pd=1.5u as=0.2128p ps=1.5u w=1.12u l=0.13u
X258 sg13cmos5l_buf_16_8.A a_3668_4620# VPWR.t773 VPWR.t28 sg13_lv_pmos ad=0.2128p pd=1.5u as=0.2128p ps=1.5u w=1.12u l=0.13u
X259 VPWR.t111 VGND.t519 VPWR.t1031 VPWR.t13 sg13_lv_pmos ad=0.34p pd=2.68u as=0 ps=0 w=1u l=1u
X260 VGND.t1 a_6862_9946# sg13cmos5l_buf_16_24.X VGND.t104 sg13_lv_nmos ad=0.1406p pd=1.12u as=0.1406p ps=1.12u w=0.74u l=0.13u
X261 VGND.t92 sg13cmos5l_buf_16_0.A a_8494_3144# VGND.t40 sg13_lv_nmos ad=0.1406p pd=1.12u as=0.1406p ps=1.12u w=0.74u l=0.13u
X262 sg13cmos5l_buf_16_35.A a_6766_8434# VGND.t11 VGND.t1561 sg13_lv_nmos ad=0.1406p pd=1.12u as=0.1406p ps=1.12u w=0.74u l=0.13u
X263 VGND.t322 sg13cmos5l_buf_1_17.A a_10292_12934# VGND.t326 sg13_lv_nmos ad=0.1406p pd=1.12u as=0.1406p ps=1.12u w=0.74u l=0.13u
X264 VPWR.t21 VGND.t584 VPWR.t21 VPWR.t20 sg13_lv_pmos ad=0.34p pd=2.68u as=0 ps=0 w=1u l=1u
X265 a_6094_3898# enable VPWR.t1424 VPWR.t28 sg13_lv_pmos ad=0.2128p pd=1.5u as=0.2128p ps=1.5u w=1.12u l=0.13u
X266 VGND.t358 sg13cmos5l_buf_16_4.A a_9524_6886# VGND.t803 sg13_lv_nmos ad=0.1406p pd=1.12u as=0.1406p ps=1.12u w=0.74u l=0.13u
X267 sg13cmos5l_buf_16_33.A a_3694_14482# VPWR.t1511 VPWR.t292 sg13_lv_pmos ad=0.2128p pd=1.5u as=0.2128p ps=1.5u w=1.12u l=0.13u
X268 sg13cmos5l_buf_16_2.A a_9262_7680# VPWR.t136 VPWR.t5 sg13_lv_pmos ad=0.2128p pd=1.5u as=0.2128p ps=1.5u w=1.12u l=0.13u
X269 VPWR.t314 VGND.t384 VPWR.t312 VPWR.t13 sg13_lv_pmos ad=0.19p pd=1.38u as=0 ps=0 w=1u l=1u
X270 a_5710_1632# sg13cmos5l_buf_16_30.A VGND.t491 VGND.t857 sg13_lv_nmos ad=0.1406p pd=1.12u as=0.1406p ps=1.12u w=0.74u l=0.13u
X271 VPWR.t357 VGND.t377 VPWR.t562 VPWR.t55 sg13_lv_pmos ad=0.19p pd=1.38u as=0 ps=0 w=1u l=1u
X272 a_6164_2350# sg13cmos5l_buf_16_39.A VGND.t504 VGND.t1569 sg13_lv_nmos ad=0.1406p pd=1.12u as=0.1406p ps=1.12u w=0.74u l=0.13u
X273 a_6094_4656# sg13cmos5l_buf_16_7.X VGND.t27 VGND.t34 sg13_lv_nmos ad=0.1406p pd=1.12u as=0.2516p ps=2.16u w=0.74u l=0.13u
X274 VGND.t377 VPWR.t1667 VGND.t377 VGND.t156 sg13_lv_nmos ad=0.1428p pd=1.52u as=0 ps=0 w=0.42u l=1u
X275 a_4052_12934# sg13cmos5l_buf_16_18.A VPWR.t1278 VPWR.t8 sg13_lv_pmos ad=0.2128p pd=1.5u as=0.2128p ps=1.5u w=1.12u l=0.13u
X276 sg13cmos5l_buf_16_5.X a_5108_838# VGND.t860 VGND.t1444 sg13_lv_nmos ad=0.1406p pd=1.12u as=0.1406p ps=1.12u w=0.74u l=0.13u
X277 VPWR.t904 VGND.t157 VPWR.t304 VPWR.t13 sg13_lv_pmos ad=0.34p pd=2.68u as=0 ps=0 w=1u l=1u
X278 VGND.t1388 VPWR.t24 VGND.t1387 VGND.t1386 sg13_lv_nmos ad=0.1428p pd=1.52u as=0 ps=0 w=0.42u l=1u
X279 VPWR.t898 sg13cmos5l_buf_16_5.X a_6094_3144# VPWR.t20 sg13_lv_pmos ad=0.2128p pd=1.5u as=0.2128p ps=1.5u w=1.12u l=0.13u
X280 a_8494_3144# sg13cmos5l_buf_16_0.A VGND.t56 VGND.t40 sg13_lv_nmos ad=0.1406p pd=1.12u as=0.2516p ps=2.16u w=0.74u l=0.13u
X281 sg13cmos5l_buf_16_24.X a_6862_9946# VGND.t1 VGND.t101 sg13_lv_nmos ad=0.1406p pd=1.12u as=0.1406p ps=1.12u w=0.74u l=0.13u
X282 VGND.t1308 VPWR.t18 VGND.t1308 VGND.t1341 sg13_lv_nmos ad=0.1428p pd=1.52u as=0 ps=0 w=0.42u l=1u
X283 VGND.t345 a_4052_12934# sg13cmos5l_buf_16_15.A VGND.t729 sg13_lv_nmos ad=0.1406p pd=1.12u as=0.1406p ps=1.12u w=0.74u l=0.13u
X284 VPWR.t118 VGND.t315 VPWR.t118 VPWR.t13 sg13_lv_pmos ad=0.34p pd=2.68u as=0 ps=0 w=1u l=1u
X285 VGND.t11 a_6766_8434# sg13cmos5l_buf_16_35.A VGND.t1558 sg13_lv_nmos ad=0.1406p pd=1.12u as=0.1406p ps=1.12u w=0.74u l=0.13u
X286 VGND.t1060 VPWR.t1664 VGND.t1060 VGND.t1064 sg13_lv_nmos ad=0.1428p pd=1.52u as=0 ps=0 w=0.42u l=1u
X287 VGND.t860 a_5108_838# sg13cmos5l_buf_16_5.X VGND.t1439 sg13_lv_nmos ad=0.1406p pd=1.12u as=0.1406p ps=1.12u w=0.74u l=0.13u
X288 sg13cmos5l_buf_16_1.X a_10318_5410# VGND.t126 VGND.t127 sg13_lv_nmos ad=0.1406p pd=1.12u as=0.1406p ps=1.12u w=0.74u l=0.13u
X289 a_3694_8434# sg13cmos5l_buf_16_13.A VPWR.t1128 VPWR.t3 sg13_lv_pmos ad=0.2128p pd=1.5u as=0.2128p ps=1.5u w=1.12u l=0.13u
X290 VGND.t11 VPWR.t1650 VGND.t11 VGND.t1116 sg13_lv_nmos ad=0.1428p pd=1.52u as=0 ps=0 w=0.42u l=1u
X291 sg13cmos5l_buf_16_35.A a_6766_8434# VPWR.t189 VPWR.t3 sg13_lv_pmos ad=0.2128p pd=1.5u as=0.2128p ps=1.5u w=1.12u l=0.13u
X292 sg13cmos5l_buf_1_6.A a_4721_6526# a_4892_6168# VPWR.t70 sg13_lv_pmos ad=0.3808p pd=2.92u as=0.2128p ps=1.5u w=1.12u l=0.13u
X293 a_3694_14482# sg13cmos5l_buf_16_15.X VPWR.t1506 VPWR.t292 sg13_lv_pmos ad=0.2128p pd=1.5u as=0.2128p ps=1.5u w=1.12u l=0.13u
X294 VGND.t11 sg13cmos5l_buf_16_1.X a_10318_8434# VGND.t60 sg13_lv_nmos ad=0.1406p pd=1.12u as=0.1406p ps=1.12u w=0.74u l=0.13u
X295 VPWR.t1373 a_5684_6132# sg13cmos5l_buf_16_28.X VPWR.t70 sg13_lv_pmos ad=0.2128p pd=1.5u as=0.2128p ps=1.5u w=1.12u l=0.13u
X296 VGND.t693 a_6548_13692# sg13cmos5l_buf_16_27.X VGND.t1496 sg13_lv_nmos ad=0.1406p pd=1.12u as=0.1406p ps=1.12u w=0.74u l=0.13u
X297 VGND.t56 a_6094_3898# sg13cmos5l_buf_16_0.A VGND.t40 sg13_lv_nmos ad=0.2516p pd=2.16u as=0.1406p ps=1.12u w=0.74u l=0.13u
X298 VGND.t82 a_10318_5410# sg13cmos5l_buf_16_1.X VGND.t123 sg13_lv_nmos ad=0.1406p pd=1.12u as=0.1406p ps=1.12u w=0.74u l=0.13u
X299 sg13cmos5l_buf_16_15.A a_4052_12934# VPWR.t1274 VPWR.t8 sg13_lv_pmos ad=0.2128p pd=1.5u as=0.2128p ps=1.5u w=1.12u l=0.13u
X300 sg13cmos5l_buf_16_10.A a_3694_3898# VGND.t207 VGND.t40 sg13_lv_nmos ad=0.1406p pd=1.12u as=0.1406p ps=1.12u w=0.74u l=0.13u
X301 VPWR.t28 VGND.t282 VPWR.t28 VPWR.t28 sg13_lv_pmos ad=0.19p pd=1.38u as=0 ps=0 w=1u l=1u
X302 sg13cmos5l_buf_16_4.X a_9524_6886# VPWR.t136 VPWR.t5 sg13_lv_pmos ad=0.2128p pd=1.5u as=0.2128p ps=1.5u w=1.12u l=0.13u
X303 a_2147_13692# sg13cmos5l_and2_2_1.B VPWR.t1455 VPWR.t8 sg13_lv_pmos ad=0.1596p pd=1.22u as=0.1918p ps=1.5u w=0.84u l=0.13u
X304 VPWR.t189 a_6766_8434# sg13cmos5l_buf_16_35.A VPWR.t3 sg13_lv_pmos ad=0.2128p pd=1.5u as=0.2128p ps=1.5u w=1.12u l=0.13u
X305 VGND.t907 VPWR.t1696 VGND.t907 VGND.t908 sg13_lv_nmos ad=79.8f pd=0.8u as=0 ps=0 w=0.42u l=1u
X306 VGND.t934 VPWR.t297 VGND.t934 VGND.t949 sg13_lv_nmos ad=79.8f pd=0.8u as=0 ps=0 w=0.42u l=1u
X307 sg13cmos5l_and2_2_6.A a_3694_10704# VGND.t350 VGND.t156 sg13_lv_nmos ad=0.1406p pd=1.12u as=0.1406p ps=1.12u w=0.74u l=0.13u
X308 VPWR.t1206 sg13cmos5l_buf_16_14.A a_3668_9156# VPWR.t3 sg13_lv_pmos ad=0.2128p pd=1.5u as=0.2128p ps=1.5u w=1.12u l=0.13u
X309 VGND.t1153 VPWR.t1635 VGND.t1153 VGND.t1156 sg13_lv_nmos ad=79.8f pd=0.8u as=0 ps=0 w=0.42u l=1u
X310 VGND.t332 a_4052_12934# sg13cmos5l_buf_16_15.A VGND.t725 sg13_lv_nmos ad=0.1406p pd=1.12u as=0.1406p ps=1.12u w=0.74u l=0.13u
X311 VGND.t1308 VPWR.t30 VGND.t1308 VGND.t1310 sg13_lv_nmos ad=0.1428p pd=1.52u as=0 ps=0 w=0.42u l=1u
X312 VPWR.t683 a_6094_10704# sg13cmos5l_buf_16_24.A VPWR.t55 sg13_lv_pmos ad=0.2128p pd=1.5u as=0.2128p ps=1.5u w=1.12u l=0.13u
X313 VGND.t519 VPWR.t1686 VGND.t519 VGND.t964 sg13_lv_nmos ad=0.1428p pd=1.52u as=0 ps=0 w=0.42u l=1u
X314 VPWR.t288 VGND.t1308 VPWR.t288 VPWR.t20 sg13_lv_pmos ad=0.34p pd=2.68u as=0 ps=0 w=1u l=1u
X315 sg13cmos5l_buf_16_28.A a_7220_5374# VGND.t282 VGND.t292 sg13_lv_nmos ad=0.1406p pd=1.12u as=0.1406p ps=1.12u w=0.74u l=0.13u
X316 sg13cmos5l_buf_16_20.A a_5204_11422# VGND.t350 VGND.t156 sg13_lv_nmos ad=0.1406p pd=1.12u as=0.1406p ps=1.12u w=0.74u l=0.13u
X317 VGND.t358 a_8110_6168# sg13cmos5l_buf_16_38.A VGND.t539 sg13_lv_nmos ad=0.1406p pd=1.12u as=0.1406p ps=1.12u w=0.74u l=0.13u
X318 VPWR.t1029 VGND.t519 VPWR.t1030 VPWR.t8 sg13_lv_pmos ad=0.19p pd=1.38u as=0 ps=0 w=1u l=1u
X319 VPWR.t6 VGND.t866 VPWR.t19 VPWR.t0 sg13_lv_pmos ad=0.34p pd=2.68u as=0 ps=0 w=1u l=1u
X320 VGND.t207 a_3694_3898# sg13cmos5l_buf_16_10.A VGND.t40 sg13_lv_nmos ad=0.1406p pd=1.12u as=0.1406p ps=1.12u w=0.74u l=0.13u
X321 VPWR.t136 a_9524_6886# sg13cmos5l_buf_16_4.X VPWR.t5 sg13_lv_pmos ad=0.2128p pd=1.5u as=0.2128p ps=1.5u w=1.12u l=0.13u
X322 sg13cmos5l_buf_16_25.A a_6836_9156# VGND.t1 VGND.t103 sg13_lv_nmos ad=0.1406p pd=1.12u as=0.1406p ps=1.12u w=0.74u l=0.13u
X323 sg13cmos5l_buf_16_35.A a_6766_8434# VPWR.t1568 VPWR.t3 sg13_lv_pmos ad=0.2128p pd=1.5u as=0.2128p ps=1.5u w=1.12u l=0.13u
X324 VPWR.t202 sg13cmos5l_buf_16_2.X a_10292_4620# VPWR.t28 sg13_lv_pmos ad=0.2128p pd=1.5u as=0.2128p ps=1.5u w=1.12u l=0.13u
X325 VPWR.t70 VGND.t358 VPWR.t70 VPWR.t70 sg13_lv_pmos ad=0.34p pd=2.68u as=0 ps=0 w=1u l=1u
X326 a_4721_6526# sg13cmos5l_buf_16_8.A VGND.t358 VGND.t682 sg13_lv_nmos ad=0.17462p pd=1.185u as=0.374p ps=2.46u w=0.55u l=0.13u
X327 VPWR.t19 a_5710_1632# sg13cmos5l_buf_16_5.A VPWR.t0 sg13_lv_pmos ad=0.2128p pd=1.5u as=0.2128p ps=1.5u w=1.12u l=0.13u
X328 VPWR.t319 a_10318_5410# sg13cmos5l_buf_16_1.X VPWR.t70 sg13_lv_pmos ad=0.3976p pd=2.95u as=0.2128p ps=1.5u w=1.12u l=0.13u
X329 VGND.t915 a_6548_13692# sg13cmos5l_buf_16_27.X VGND.t1492 sg13_lv_nmos ad=0.1406p pd=1.12u as=0.1406p ps=1.12u w=0.74u l=0.13u
X330 sg13cmos5l_buf_16_5.X a_5108_838# VPWR.t19 VPWR.t0 sg13_lv_pmos ad=0.2128p pd=1.5u as=0.2128p ps=1.5u w=1.12u l=0.13u
X331 VGND.t130 VPWR.t381 VGND.t130 VGND.t40 sg13_lv_nmos ad=0.1428p pd=1.52u as=0 ps=0 w=0.42u l=1u
X332 VPWR.t747 a_6094_4656# sg13cmos5l_buf_16_31.X VPWR.t28 sg13_lv_pmos ad=0.2128p pd=1.5u as=0.2128p ps=1.5u w=1.12u l=0.13u
X333 VPWR.t1369 a_5684_6132# sg13cmos5l_buf_16_28.X VPWR.t70 sg13_lv_pmos ad=0.2128p pd=1.5u as=0.2128p ps=1.5u w=1.12u l=0.13u
X334 VPWR.t1224 a_5518_6922# sg13cmos5l_buf_16_6.X VPWR.t5 sg13_lv_pmos ad=0.3976p pd=2.95u as=0.2128p ps=1.5u w=1.12u l=0.13u
X335 sg13cmos5l_buf_16_2.A a_9262_7680# VGND.t11 VGND.t20 sg13_lv_nmos ad=0.1406p pd=1.12u as=0.1406p ps=1.12u w=0.74u l=0.13u
X336 VGND.t1296 VPWR.t1 VGND.t1296 VGND.t1335 sg13_lv_nmos ad=0.1428p pd=1.52u as=0 ps=0 w=0.42u l=1u
X337 VGND.t860 a_5108_838# sg13cmos5l_buf_16_5.X VGND.t1445 sg13_lv_nmos ad=0.1406p pd=1.12u as=0.1406p ps=1.12u w=0.74u l=0.13u
X338 VGND.t1 a_6836_9156# sg13cmos5l_buf_16_25.A VGND.t100 sg13_lv_nmos ad=0.1406p pd=1.12u as=0.1406p ps=1.12u w=0.74u l=0.13u
X339 a_13713_11776# sg13cmos5l_buf_1_15.X VPWR.t304 VPWR.t13 sg13_lv_pmos ad=0.1225p pd=1.245u as=0.36p ps=2.72u w=1u l=0.13u
X340 VGND.t693 VPWR.t292 VGND.t636 VGND.t925 sg13_lv_nmos ad=79.8f pd=0.8u as=0 ps=0 w=0.42u l=1u
X341 a_6862_9946# sg13cmos5l_buf_16_24.A VGND.t1 VGND.t97 sg13_lv_nmos ad=0.1406p pd=1.12u as=0.1406p ps=1.12u w=0.74u l=0.13u
X342 VPWR.t488 a_3668_9156# sg13cmos5l_buf_16_13.A VPWR.t3 sg13_lv_pmos ad=0.2128p pd=1.5u as=0.2128p ps=1.5u w=1.12u l=0.13u
X343 sg13cmos5l_buf_16_20.A a_5204_11422# VGND.t384 VGND.t156 sg13_lv_nmos ad=0.1406p pd=1.12u as=0.1406p ps=1.12u w=0.74u l=0.13u
X344 sg13cmos5l_buf_16_5.X a_5108_838# VGND.t860 VGND.t1440 sg13_lv_nmos ad=0.1406p pd=1.12u as=0.1406p ps=1.12u w=0.74u l=0.13u
X345 VPWR.t19 a_5108_838# sg13cmos5l_buf_16_5.X VPWR.t0 sg13_lv_pmos ad=0.2128p pd=1.5u as=0.2128p ps=1.5u w=1.12u l=0.13u
X346 sg13cmos5l_buf_16_1.X a_10318_5410# VPWR.t319 VPWR.t70 sg13_lv_pmos ad=0.2128p pd=1.5u as=0.2128p ps=1.5u w=1.12u l=0.13u
X347 VGND.t1079 VPWR.t245 VGND.t1079 VGND.t1083 sg13_lv_nmos ad=79.8f pd=0.8u as=0 ps=0 w=0.42u l=1u
X348 VPWR.t185 VGND.t1302 VPWR.t1 VPWR.t0 sg13_lv_pmos ad=0.34p pd=2.68u as=0 ps=0 w=1u l=1u
X349 VPWR.t381 VGND.t366 VPWR.t381 VPWR.t28 sg13_lv_pmos ad=0.34p pd=2.68u as=0 ps=0 w=1u l=1u
X350 sg13cmos5l_buf_16_6.X a_5518_6922# VPWR.t1220 VPWR.t5 sg13_lv_pmos ad=0.2128p pd=1.5u as=0.2128p ps=1.5u w=1.12u l=0.13u
X351 sg13cmos5l_buf_16_37.X a_7796_12934# VPWR.t919 VPWR.t8 sg13_lv_pmos ad=0.2128p pd=1.5u as=0.3976p ps=2.95u w=1.12u l=0.13u
X352 VPWR.t610 a_7220_5374# sg13cmos5l_buf_16_28.A VPWR.t70 sg13_lv_pmos ad=0.2128p pd=1.5u as=0.2128p ps=1.5u w=1.12u l=0.13u
X353 VGND.t912 a_6548_13692# sg13cmos5l_buf_16_27.X VGND.t1488 sg13_lv_nmos ad=0.1406p pd=1.12u as=0.1406p ps=1.12u w=0.74u l=0.13u
X354 sg13cmos5l_and2_2_3.B a_13576_14516# VGND.t639 VGND.t1525 sg13_lv_nmos ad=0.2886p pd=2.26u as=0.14875p ps=1.16u w=0.74u l=0.13u
X355 VPWR.t0 VGND.t150 VPWR.t0 VPWR.t0 sg13_lv_pmos ad=0.34p pd=2.68u as=0 ps=0 w=1u l=1u
X356 VGND.t1207 VPWR.t1624 VGND.t1207 VGND.t1209 sg13_lv_nmos ad=0.1428p pd=1.52u as=0 ps=0 w=0.42u l=1u
X357 VPWR.t19 a_5710_1632# sg13cmos5l_buf_16_5.A VPWR.t0 sg13_lv_pmos ad=0.2128p pd=1.5u as=0.2128p ps=1.5u w=1.12u l=0.13u
X358 VGND.t1302 VPWR.t281 VGND.t1302 VGND.t1301 sg13_lv_nmos ad=0.1428p pd=1.52u as=0 ps=0 w=0.42u l=1u
X359 a_10318_8434# sg13cmos5l_buf_16_1.X VPWR.t190 VPWR.t3 sg13_lv_pmos ad=0.2128p pd=1.5u as=0.2128p ps=1.5u w=1.12u l=0.13u
X360 VGND.t1020 VPWR.t131 VGND.t1020 VGND.t156 sg13_lv_nmos ad=0.1428p pd=1.52u as=0 ps=0 w=0.42u l=1u
X361 VPWR.t21 VGND.t1296 VPWR.t21 VPWR.t20 sg13_lv_pmos ad=0.34p pd=2.68u as=0 ps=0 w=1u l=1u
X362 sg13cmos5l_buf_16_24.A a_6094_10704# VGND.t350 VGND.t156 sg13_lv_nmos ad=0.1406p pd=1.12u as=0.1406p ps=1.12u w=0.74u l=0.13u
X363 VPWR.t21 a_8494_3144# sg13cmos5l_buf_16_39.A VPWR.t20 sg13_lv_pmos ad=0.3976p pd=2.95u as=0.2128p ps=1.5u w=1.12u l=0.13u
X364 VGND.t377 VPWR.t357 VGND.t377 VGND.t156 sg13_lv_nmos ad=79.8f pd=0.8u as=0 ps=0 w=0.42u l=1u
X365 VGND.t150 a_3694_2386# sg13cmos5l_buf_16_7.X VGND.t489 sg13_lv_nmos ad=0.2516p pd=2.16u as=0.1406p ps=1.12u w=0.74u l=0.13u
X366 sg13cmos5l_buf_16_28.A a_7220_5374# VPWR.t606 VPWR.t70 sg13_lv_pmos ad=0.2128p pd=1.5u as=0.2128p ps=1.5u w=1.12u l=0.13u
X367 VGND.t27 a_4462_5410# sg13cmos5l_buf_16_11.A VGND.t37 sg13_lv_nmos ad=0.1406p pd=1.12u as=0.1406p ps=1.12u w=0.74u l=0.13u
X368 VGND.t56 a_6094_3144# sg13cmos5l_xor2_1_0.B VGND.t40 sg13_lv_nmos ad=0.2516p pd=2.16u as=0.1406p ps=1.12u w=0.74u l=0.13u
X369 VPWR.t125 VGND.t315 VPWR.t125 VPWR.t13 sg13_lv_pmos ad=0.19p pd=1.38u as=0 ps=0 w=1u l=1u
X370 sg13cmos5l_buf_16_7.A a_3668_3108# VGND.t207 VGND.t40 sg13_lv_nmos ad=0.1406p pd=1.12u as=0.1406p ps=1.12u w=0.74u l=0.13u
X371 sg13cmos5l_buf_16_24.A a_6094_10704# VPWR.t685 VPWR.t55 sg13_lv_pmos ad=0.2128p pd=1.5u as=0.2128p ps=1.5u w=1.12u l=0.13u
X372 VGND.t358 sg13cmos5l_buf_16_35.A a_8110_6168# VGND.t1546 sg13_lv_nmos ad=0.1406p pd=1.12u as=0.1406p ps=1.12u w=0.74u l=0.13u
X373 a_6862_9946# sg13cmos5l_buf_16_24.A VPWR.t588 VPWR.t55 sg13_lv_pmos ad=0.2128p pd=1.5u as=0.2128p ps=1.5u w=1.12u l=0.13u
X374 sg13cmos5l_buf_16_2.X a_10318_3898# VGND.t130 VGND.t40 sg13_lv_nmos ad=0.1406p pd=1.12u as=0.1406p ps=1.12u w=0.74u l=0.13u
X375 VPWR.t61 VGND.t1060 VPWR.t356 VPWR.t55 sg13_lv_pmos ad=0.34p pd=2.68u as=0 ps=0 w=1u l=1u
X376 VGND.t345 a_3668_12180# sg13cmos5l_buf_16_15.X VGND.t344 sg13_lv_nmos ad=0.1406p pd=1.12u as=0.1406p ps=1.12u w=0.74u l=0.13u
X377 VPWR.t82 VGND.t413 VPWR.t80 VPWR.t3 sg13_lv_pmos ad=0.19p pd=1.38u as=0 ps=0 w=1u l=1u
X378 VPWR.t125 VGND.t377 VPWR.t123 VPWR.t13 sg13_lv_pmos ad=0.34p pd=2.68u as=0 ps=0 w=1u l=1u
X379 VPWR.t189 sg13cmos5l_buf_16_35.A a_9788_8728# VPWR.t3 sg13_lv_pmos ad=0.2128p pd=1.5u as=0.3808p ps=2.92u w=1.12u l=0.13u
X380 sg13cmos5l_buf_16_39.A a_8494_3144# VPWR.t21 VPWR.t20 sg13_lv_pmos ad=0.2128p pd=1.5u as=0.2128p ps=1.5u w=1.12u l=0.13u
X381 sg13cmos5l_buf_16_7.X a_3694_2386# VGND.t150 VGND.t486 sg13_lv_nmos ad=0.1406p pd=1.12u as=0.1406p ps=1.12u w=0.74u l=0.13u
X382 VPWR.t631 sg13cmos5l_buf_16_37.A a_7796_12934# VPWR.t8 sg13_lv_pmos ad=0.2128p pd=1.5u as=0.2128p ps=1.5u w=1.12u l=0.13u
X383 VPWR.t782 a_3694_2386# sg13cmos5l_buf_16_7.X VPWR.t20 sg13_lv_pmos ad=0.2128p pd=1.5u as=0.2128p ps=1.5u w=1.12u l=0.13u
X384 sg13cmos5l_buf_16_11.A a_4462_5410# VGND.t27 VGND.t34 sg13_lv_nmos ad=0.1406p pd=1.12u as=0.1406p ps=1.12u w=0.74u l=0.13u
X385 VGND.t868 VPWR.t30 VGND.t868 VGND.t1312 sg13_lv_nmos ad=0.1428p pd=1.52u as=0 ps=0 w=0.42u l=1u
X386 VGND.t504 a_5710_1632# sg13cmos5l_buf_16_5.A VGND.t889 sg13_lv_nmos ad=0.2516p pd=2.16u as=0.1406p ps=1.12u w=0.74u l=0.13u
X387 VGND.t322 VPWR.t133 VGND.t322 VGND.t966 sg13_lv_nmos ad=0.1428p pd=1.52u as=0 ps=0 w=0.42u l=1u
X388 VGND.t207 a_3668_3108# sg13cmos5l_buf_16_7.A VGND.t40 sg13_lv_nmos ad=0.1406p pd=1.12u as=0.1406p ps=1.12u w=0.74u l=0.13u
X389 a_7629_8028# sg13cmos5l_and2_2_6.A VPWR.t135 VPWR.t5 sg13_lv_pmos ad=0.1596p pd=1.22u as=0.2856p ps=2.36u w=0.84u l=0.13u
X390 a_8948_13692# sg13cmos5l_buf_16_23.X VPWR.t631 VPWR.t8 sg13_lv_pmos ad=0.2128p pd=1.5u as=0.2128p ps=1.5u w=1.12u l=0.13u
X391 VPWR.t30 VGND.t1308 VPWR.t30 VPWR.t20 sg13_lv_pmos ad=0.34p pd=2.68u as=0 ps=0 w=1u l=1u
X392 sg13cmos5l_buf_16_37.X a_7796_12934# VGND.t315 VGND.t617 sg13_lv_nmos ad=0.1406p pd=1.12u as=0.1406p ps=1.12u w=0.74u l=0.13u
X393 a_8110_6168# sg13cmos5l_buf_16_35.A VGND.t358 VGND.t1542 sg13_lv_nmos ad=0.1406p pd=1.12u as=0.2516p ps=2.16u w=0.74u l=0.13u
X394 VPWR.t596 sg13cmos5l_buf_16_34.A a_3694_7680# VPWR.t5 sg13_lv_pmos ad=0.2128p pd=1.5u as=0.2128p ps=1.5u w=1.12u l=0.13u
X395 VPWR.t987 VGND.t907 VPWR.t986 VPWR.t8 sg13_lv_pmos ad=0.34p pd=2.68u as=0 ps=0 w=1u l=1u
X396 VPWR.t297 VGND.t934 VPWR.t297 VPWR.t8 sg13_lv_pmos ad=0.34p pd=2.68u as=0 ps=0 w=1u l=1u
X397 a_9585_8752# sg13cmos5l_buf_16_35.A VPWR.t189 VPWR.t3 sg13_lv_pmos ad=0.1225p pd=1.245u as=0.36p ps=2.72u w=1u l=0.13u
X398 VPWR.t7 VGND.t1382 VPWR.t7 VPWR.t0 sg13_lv_pmos ad=0.34p pd=2.68u as=0 ps=0 w=1u l=1u
X399 VGND.t130 a_10318_3898# sg13cmos5l_buf_16_2.X VGND.t40 sg13_lv_nmos ad=0.1406p pd=1.12u as=0.1406p ps=1.12u w=0.74u l=0.13u
X400 sg13cmos5l_xor2_1_0.B a_6094_3144# VPWR.t179 VPWR.t20 sg13_lv_pmos ad=0.2128p pd=1.5u as=0.2128p ps=1.5u w=1.12u l=0.13u
X401 VPWR.t342 a_11565_8028# sg13cmos5l_buf_16_4.A VPWR.t5 sg13_lv_pmos ad=0.4256p pd=3u as=0.2128p ps=1.5u w=1.12u l=0.13u
X402 VGND.t912 a_4174_13728# sg13cmos5l_buf_16_18.A VGND.t1462 sg13_lv_nmos ad=0.1406p pd=1.12u as=0.1406p ps=1.12u w=0.74u l=0.13u
X403 VPWR.t631 a_8948_13692# sg13cmos5l_buf_16_37.A VPWR.t8 sg13_lv_pmos ad=0.2128p pd=1.5u as=0.2128p ps=1.5u w=1.12u l=0.13u
X404 a_10318_8434# sg13cmos5l_buf_16_1.X VPWR.t189 VPWR.t3 sg13_lv_pmos ad=0.2128p pd=1.5u as=0.3808p ps=2.92u w=1.12u l=0.13u
X405 a_14444_14442# glitch_en[6] VGND.t934 VGND.t1479 sg13_lv_nmos ad=0.187p pd=1.78u as=0.14875p ps=1.16u w=0.55u l=0.13u
X406 sg13cmos5l_buf_16_7.X a_3694_2386# VPWR.t778 VPWR.t20 sg13_lv_pmos ad=0.2128p pd=1.5u as=0.2128p ps=1.5u w=1.12u l=0.13u
X407 VPWR.t1429 a_3020_14442# sg13cmos5l_and2_2_1.B VPWR.t292 sg13_lv_pmos ad=0.2114p pd=1.54u as=0.42p ps=2.99u w=1.12u l=0.13u
X408 sg13cmos5l_buf_1_14.X a_14344_8468# VPWR.t4 VPWR.t3 sg13_lv_pmos ad=0.42p pd=2.99u as=0.2114p ps=1.54u w=1.12u l=0.13u
X409 VGND.t315 VPWR.t1687 VGND.t519 VGND.t963 sg13_lv_nmos ad=79.8f pd=0.8u as=0 ps=0 w=0.42u l=1u
X410 a_6094_4656# sg13cmos5l_buf_16_7.X VPWR.t866 VPWR.t28 sg13_lv_pmos ad=0.2128p pd=1.5u as=0.2128p ps=1.5u w=1.12u l=0.13u
X411 a_3694_7680# sg13cmos5l_buf_16_34.A VPWR.t593 VPWR.t5 sg13_lv_pmos ad=0.2128p pd=1.5u as=0.3808p ps=2.92u w=1.12u l=0.13u
X412 VGND.t942 sg13cmos5l_buf_16_15.X a_3694_14482# VGND.t1502 sg13_lv_nmos ad=0.1406p pd=1.12u as=0.1406p ps=1.12u w=0.74u l=0.13u
X413 VGND.t332 a_3668_12180# sg13cmos5l_buf_16_15.X VGND.t339 sg13_lv_nmos ad=0.1406p pd=1.12u as=0.1406p ps=1.12u w=0.74u l=0.13u
X414 VGND.t1302 VPWR.t1 VGND.t1302 VGND.t1337 sg13_lv_nmos ad=0.1428p pd=1.52u as=0 ps=0 w=0.42u l=1u
X415 VGND.t1408 VPWR.t1 VGND.t1407 VGND.t1406 sg13_lv_nmos ad=0.1428p pd=1.52u as=0 ps=0 w=0.42u l=1u
X416 sg13cmos5l_buf_16_2.X a_10318_3898# VGND.t130 VGND.t40 sg13_lv_nmos ad=0.1406p pd=1.12u as=0.1406p ps=1.12u w=0.74u l=0.13u
X417 VGND.t942 a_3694_14482# sg13cmos5l_buf_16_33.A VGND.t1515 sg13_lv_nmos ad=0.1406p pd=1.12u as=0.1406p ps=1.12u w=0.74u l=0.13u
X418 out_xor[0] a_14824_1632# VGND.t868 VGND.t869 sg13_lv_nmos ad=0.2886p pd=2.26u as=0.14875p ps=1.16u w=0.74u l=0.13u
X419 sg13cmos5l_buf_16_11.A a_4462_5410# VPWR.t165 VPWR.t70 sg13_lv_pmos ad=0.2128p pd=1.5u as=0.2128p ps=1.5u w=1.12u l=0.13u
X420 VPWR.t18 VGND.t1422 VPWR.t18 VPWR.t0 sg13_lv_pmos ad=0.34p pd=2.68u as=0 ps=0 w=1u l=1u
X421 VGND.t70 sg13cmos5l_buf_1_4.A a_14824_6956# VGND.t69 sg13_lv_nmos ad=0.14875p pd=1.16u as=0.187p ps=1.78u w=0.55u l=0.13u
X422 VPWR.t631 a_7796_12934# sg13cmos5l_buf_16_37.X VPWR.t8 sg13_lv_pmos ad=0.2128p pd=1.5u as=0.2128p ps=1.5u w=1.12u l=0.13u
X423 VPWR.t279 sg13cmos5l_buf_16_7.A a_3694_2386# VPWR.t20 sg13_lv_pmos ad=0.2128p pd=1.5u as=0.2128p ps=1.5u w=1.12u l=0.13u
X424 sg13cmos5l_buf_16_37.A a_8948_13692# VPWR.t631 VPWR.t8 sg13_lv_pmos ad=0.2128p pd=1.5u as=0.2128p ps=1.5u w=1.12u l=0.13u
X425 sg13cmos5l_buf_16_7.X a_3694_2386# VGND.t150 VGND.t482 sg13_lv_nmos ad=0.1406p pd=1.12u as=0.1406p ps=1.12u w=0.74u l=0.13u
X426 VPWR.t539 a_6094_3898# sg13cmos5l_buf_16_0.A VPWR.t28 sg13_lv_pmos ad=0.2128p pd=1.5u as=0.2128p ps=1.5u w=1.12u l=0.13u
X427 sg13cmos5l_buf_16_37.X a_7796_12934# VGND.t315 VGND.t613 sg13_lv_nmos ad=0.1406p pd=1.12u as=0.1406p ps=1.12u w=0.74u l=0.13u
X428 sg13cmos5l_buf_16_14.A a_4436_9910# VPWR.t468 VPWR.t55 sg13_lv_pmos ad=0.2128p pd=1.5u as=0.2128p ps=1.5u w=1.12u l=0.13u
X429 VPWR.t631 a_8948_13692# sg13cmos5l_buf_16_37.A VPWR.t8 sg13_lv_pmos ad=0.2128p pd=1.5u as=0.2128p ps=1.5u w=1.12u l=0.13u
X430 VPWR.t56 a_14252_9906# sg13cmos5l_buf_1_15.X VPWR.t55 sg13_lv_pmos ad=0.2114p pd=1.54u as=0.42p ps=2.99u w=1.12u l=0.13u
X431 VGND.t165 a_3668_9156# sg13cmos5l_buf_16_13.A VGND.t183 sg13_lv_nmos ad=0.1406p pd=1.12u as=0.1406p ps=1.12u w=0.74u l=0.13u
X432 sg13cmos5l_xor2_1_0.B a_6094_3144# VPWR.t175 VPWR.t20 sg13_lv_pmos ad=0.2128p pd=1.5u as=0.2128p ps=1.5u w=1.12u l=0.13u
X433 sg13cmos5l_buf_16_31.X a_6094_4656# VGND.t282 VGND.t451 sg13_lv_nmos ad=0.1406p pd=1.12u as=0.1406p ps=1.12u w=0.74u l=0.13u
X434 VGND.t1302 VPWR.t288 VGND.t1302 VGND.t1304 sg13_lv_nmos ad=0.1428p pd=1.52u as=0 ps=0 w=0.42u l=1u
X435 sg13cmos5l_buf_16_4.X a_9524_6886# VGND.t358 VGND.t813 sg13_lv_nmos ad=0.1406p pd=1.12u as=0.1406p ps=1.12u w=0.74u l=0.13u
X436 VGND.t157 a_13745_11508# sg13cmos5l_xor2_1_7.X VGND.t156 sg13_lv_nmos ad=0.3108p pd=2.32u as=0.1628p ps=1.18u w=0.74u l=0.13u
X437 VPWR.t281 VGND.t1302 VPWR.t281 VPWR.t20 sg13_lv_pmos ad=0.34p pd=2.68u as=0 ps=0 w=1u l=1u
X438 VGND.t1359 VPWR.t284 VGND.t1358 VGND.t1357 sg13_lv_nmos ad=0.1428p pd=1.52u as=0 ps=0 w=0.42u l=1u
X439 sg13cmos5l_buf_16_14.A a_4436_9910# VPWR.t464 VPWR.t55 sg13_lv_pmos ad=0.2128p pd=1.5u as=0.2128p ps=1.5u w=1.12u l=0.13u
X440 VPWR.t385 VGND.t693 VPWR.t384 VPWR.t292 sg13_lv_pmos ad=0.34p pd=2.68u as=0 ps=0 w=1u l=1u
X441 VPWR.t342 sg13cmos5l_buf_16_4.A a_9524_6886# VPWR.t5 sg13_lv_pmos ad=0.3808p pd=2.92u as=0.2128p ps=1.5u w=1.12u l=0.13u
X442 VGND.t402 a_3694_7680# sg13cmos5l_buf_16_34.X VGND.t406 sg13_lv_nmos ad=0.1406p pd=1.12u as=0.1406p ps=1.12u w=0.74u l=0.13u
X443 VPWR.t1230 sg13cmos5l_buf_16_8.A a_3694_3898# VPWR.t28 sg13_lv_pmos ad=0.2128p pd=1.5u as=0.2128p ps=1.5u w=1.12u l=0.13u
X444 VPWR.t585 VGND.t1153 VPWR.t583 VPWR.t70 sg13_lv_pmos ad=0.19p pd=1.38u as=0 ps=0 w=1u l=1u
X445 a_3694_10704# sg13cmos5l_buf_16_34.X VGND.t384 VGND.t156 sg13_lv_nmos ad=0.1406p pd=1.12u as=0.1406p ps=1.12u w=0.74u l=0.13u
X446 sg13cmos5l_and2_2_6.A a_3694_10704# VGND.t384 VGND.t156 sg13_lv_nmos ad=0.1406p pd=1.12u as=0.1406p ps=1.12u w=0.74u l=0.13u
X447 VGND.t1079 VPWR.t905 VGND.t1079 VGND.t1080 sg13_lv_nmos ad=0.1428p pd=1.52u as=0 ps=0 w=0.42u l=1u
X448 sg13cmos5l_buf_16_5.A a_5710_1632# VGND.t491 VGND.t882 sg13_lv_nmos ad=0.1406p pd=1.12u as=0.1406p ps=1.12u w=0.74u l=0.13u
X449 VPWR.t1500 a_6548_13692# sg13cmos5l_buf_16_27.X VPWR.t8 sg13_lv_pmos ad=0.2128p pd=1.5u as=0.2128p ps=1.5u w=1.12u l=0.13u
X450 out_xor[6] a_14824_13004# VPWR.t297 VPWR.t8 sg13_lv_pmos ad=0.42p pd=2.99u as=0.2114p ps=1.54u w=1.12u l=0.13u
X451 sg13cmos5l_buf_16_31.X a_6094_4656# VGND.t282 VGND.t447 sg13_lv_nmos ad=0.1406p pd=1.12u as=0.1406p ps=1.12u w=0.74u l=0.13u
X452 VGND.t261 sg13cmos5l_and2_2_6.X a_6836_9156# VGND.t260 sg13_lv_nmos ad=0.2516p pd=2.16u as=0.1406p ps=1.12u w=0.74u l=0.13u
X453 sg13cmos5l_buf_16_34.X a_3694_7680# VGND.t402 VGND.t403 sg13_lv_nmos ad=0.1406p pd=1.12u as=0.1406p ps=1.12u w=0.74u l=0.13u
X454 VGND.t693 a_8948_13692# sg13cmos5l_buf_16_37.A VGND.t710 sg13_lv_nmos ad=0.1406p pd=1.12u as=0.1406p ps=1.12u w=0.74u l=0.13u
X455 sg13cmos5l_and2_2_6.A a_3694_10704# VPWR.t834 VPWR.t55 sg13_lv_pmos ad=0.2128p pd=1.5u as=0.2128p ps=1.5u w=1.12u l=0.13u
X456 VGND.t1060 VPWR.t245 VGND.t1079 VGND.t1078 sg13_lv_nmos ad=79.8f pd=0.8u as=0 ps=0 w=0.42u l=1u
X457 sg13cmos5l_buf_16_33.A a_3694_14482# VGND.t942 VGND.t1518 sg13_lv_nmos ad=0.1406p pd=1.12u as=0.1406p ps=1.12u w=0.74u l=0.13u
X458 a_4052_12934# sg13cmos5l_buf_16_18.A VGND.t315 VGND.t1537 sg13_lv_nmos ad=0.1406p pd=1.12u as=0.1406p ps=1.12u w=0.74u l=0.13u
X459 VGND.t275 a_3694_8434# sg13cmos5l_buf_16_34.A VGND.t399 sg13_lv_nmos ad=0.1406p pd=1.12u as=0.1406p ps=1.12u w=0.74u l=0.13u
X460 sg13cmos5l_buf_16_22.X a_10318_8434# VGND.t11 VGND.t777 sg13_lv_nmos ad=0.1406p pd=1.12u as=0.1406p ps=1.12u w=0.74u l=0.13u
X461 sg13cmos5l_buf_16_7.A a_3668_3108# VPWR.t490 VPWR.t20 sg13_lv_pmos ad=0.2128p pd=1.5u as=0.2128p ps=1.5u w=1.12u l=0.13u
X462 sg13cmos5l_buf_16_39.A a_8494_3144# VGND.t112 VGND.t40 sg13_lv_nmos ad=0.1406p pd=1.12u as=0.1406p ps=1.12u w=0.74u l=0.13u
X463 VPWR.t332 VGND.t999 VPWR.t331 VPWR.t55 sg13_lv_pmos ad=0.34p pd=2.68u as=0 ps=0 w=1u l=1u
X464 VGND.t1060 VPWR.t1666 VGND.t1060 VGND.t1059 sg13_lv_nmos ad=0.1428p pd=1.52u as=0 ps=0 w=0.42u l=1u
X465 sg13cmos5l_buf_16_24.X a_6862_9946# VGND.t1 VGND.t257 sg13_lv_nmos ad=0.1406p pd=1.12u as=0.1406p ps=1.12u w=0.74u l=0.13u
X466 a_3694_3898# sg13cmos5l_buf_16_8.A VPWR.t1226 VPWR.t28 sg13_lv_pmos ad=0.2128p pd=1.5u as=0.3808p ps=2.92u w=1.12u l=0.13u
X467 VPWR.t535 a_6094_3898# sg13cmos5l_buf_16_0.A VPWR.t28 sg13_lv_pmos ad=0.2128p pd=1.5u as=0.2128p ps=1.5u w=1.12u l=0.13u
X468 VGND.t11 VPWR.t1652 VGND.t11 VGND.t1112 sg13_lv_nmos ad=0.1428p pd=1.52u as=0 ps=0 w=0.42u l=1u
X469 VPWR.t149 a_9262_7680# sg13cmos5l_buf_16_2.A VPWR.t5 sg13_lv_pmos ad=0.2128p pd=1.5u as=0.2128p ps=1.5u w=1.12u l=0.13u
X470 a_6164_2350# sg13cmos5l_buf_16_39.A VPWR.t1578 VPWR.t20 sg13_lv_pmos ad=0.2128p pd=1.5u as=0.2128p ps=1.5u w=1.12u l=0.13u
X471 VGND.t315 VPWR.t118 VGND.t315 VGND.t985 sg13_lv_nmos ad=79.8f pd=0.8u as=0 ps=0 w=0.42u l=1u
X472 a_3694_8434# sg13cmos5l_buf_16_13.A VGND.t275 VGND.t279 sg13_lv_nmos ad=0.1406p pd=1.12u as=0.1406p ps=1.12u w=0.74u l=0.13u
X473 VGND.t11 a_10318_8434# sg13cmos5l_buf_16_22.X VGND.t774 sg13_lv_nmos ad=0.1406p pd=1.12u as=0.1406p ps=1.12u w=0.74u l=0.13u
X474 VPWR.t18 VGND.t1427 VPWR.t18 VPWR.t0 sg13_lv_pmos ad=0.34p pd=2.68u as=0 ps=0 w=1u l=1u
X475 VGND.t92 a_8494_3144# sg13cmos5l_buf_16_39.A VGND.t40 sg13_lv_nmos ad=0.1406p pd=1.12u as=0.1406p ps=1.12u w=0.74u l=0.13u
X476 VGND.t1 a_6862_9946# sg13cmos5l_buf_16_24.X VGND.t110 sg13_lv_nmos ad=0.1406p pd=1.12u as=0.1406p ps=1.12u w=0.74u l=0.13u
X477 VPWR.t1496 a_6548_13692# sg13cmos5l_buf_16_27.X VPWR.t8 sg13_lv_pmos ad=0.2128p pd=1.5u as=0.2128p ps=1.5u w=1.12u l=0.13u
X478 sg13cmos5l_buf_16_19.A a_6765_12564# VPWR.t818 VPWR.t13 sg13_lv_pmos ad=0.2128p pd=1.5u as=0.1918p ps=1.5u w=1.12u l=0.13u
X479 VPWR.t562 a_6862_9946# sg13cmos5l_buf_16_24.X VPWR.t55 sg13_lv_pmos ad=0.3976p pd=2.95u as=0.2128p ps=1.5u w=1.12u l=0.13u
X480 VPWR.t1594 VGND.t146 VPWR.t1006 VPWR.t20 sg13_lv_pmos ad=0.19p pd=1.38u as=0 ps=0 w=1u l=1u
X481 VGND.t244 VPWR.t32 VGND.t244 VGND.t40 sg13_lv_nmos ad=79.8f pd=0.8u as=0 ps=0 w=0.42u l=1u
X482 VGND.t350 a_3694_10704# sg13cmos5l_and2_2_6.A VGND.t156 sg13_lv_nmos ad=0.2516p pd=2.16u as=0.1406p ps=1.12u w=0.74u l=0.13u
X483 VPWR.t708 a_3694_8434# sg13cmos5l_buf_16_34.A VPWR.t3 sg13_lv_pmos ad=0.2128p pd=1.5u as=0.2128p ps=1.5u w=1.12u l=0.13u
X484 sg13cmos5l_buf_16_15.A a_4052_12934# VGND.t332 VGND.t726 sg13_lv_nmos ad=0.1406p pd=1.12u as=0.1406p ps=1.12u w=0.74u l=0.13u
X485 VGND.t999 VPWR.t1678 VGND.t999 VGND.t156 sg13_lv_nmos ad=79.8f pd=0.8u as=0 ps=0 w=0.42u l=1u
X486 VGND.t5 sg13cmos5l_buf_16_4.X a_9262_7680# VGND.t68 sg13_lv_nmos ad=0.1406p pd=1.12u as=0.1406p ps=1.12u w=0.74u l=0.13u
X487 a_8694_2398# sg13cmos5l_xor2_1_0.B sg13cmos5l_buf_1_2.A VGND.t582 sg13_lv_nmos ad=88.8f pd=0.98u as=0.1628p ps=1.18u w=0.74u l=0.13u
X488 VGND.t350 sg13cmos5l_buf_16_19.A a_5204_11422# VGND.t156 sg13_lv_nmos ad=0.1406p pd=1.12u as=0.1406p ps=1.12u w=0.74u l=0.13u
X489 a_5684_6132# sg13cmos5l_buf_16_28.A VPWR.t721 VPWR.t70 sg13_lv_pmos ad=0.2128p pd=1.5u as=0.2128p ps=1.5u w=1.12u l=0.13u
X490 VGND.t358 a_8110_6168# sg13cmos5l_buf_16_38.A VGND.t549 sg13_lv_nmos ad=0.1406p pd=1.12u as=0.1406p ps=1.12u w=0.74u l=0.13u
X491 VGND.t41 a_3694_3898# sg13cmos5l_buf_16_10.A VGND.t40 sg13_lv_nmos ad=0.1406p pd=1.12u as=0.1406p ps=1.12u w=0.74u l=0.13u
X492 VPWR.t438 VGND.t358 VPWR.t437 VPWR.t70 sg13_lv_pmos ad=0.34p pd=2.68u as=0 ps=0 w=1u l=1u
X493 VGND.t999 VPWR.t1671 VGND.t999 VGND.t156 sg13_lv_nmos ad=79.8f pd=0.8u as=0 ps=0 w=0.42u l=1u
X494 sg13cmos5l_buf_16_34.A a_3694_8434# VPWR.t704 VPWR.t3 sg13_lv_pmos ad=0.2128p pd=1.5u as=0.2128p ps=1.5u w=1.12u l=0.13u
X495 VGND.t244 VPWR.t1616 VGND.t1248 VGND.t40 sg13_lv_nmos ad=79.8f pd=0.8u as=0 ps=0 w=0.42u l=1u
X496 sg13cmos5l_buf_16_15.X a_3668_12180# VPWR.t653 VPWR.t13 sg13_lv_pmos ad=0.2128p pd=1.5u as=0.2128p ps=1.5u w=1.12u l=0.13u
X497 VPWR.t185 VGND.t1412 VPWR.t18 VPWR.t0 sg13_lv_pmos ad=0.34p pd=2.68u as=0 ps=0 w=1u l=1u
X498 a_5518_6922# sg13cmos5l_buf_16_28.X VGND.t358 VGND.t360 sg13_lv_nmos ad=0.1406p pd=1.12u as=0.1406p ps=1.12u w=0.74u l=0.13u
X499 VPWR.t1492 a_6548_13692# sg13cmos5l_buf_16_27.X VPWR.t8 sg13_lv_pmos ad=0.2128p pd=1.5u as=0.2128p ps=1.5u w=1.12u l=0.13u
X500 a_6426_12574# sg13cmos5l_buf_16_15.A VGND.t315 VGND.t517 sg13_lv_nmos ad=88.8f pd=0.98u as=0.15245p ps=1.17u w=0.74u l=0.13u
X501 VPWR.t281 VGND.t1302 VPWR.t288 VPWR.t20 sg13_lv_pmos ad=0.34p pd=2.68u as=0 ps=0 w=1u l=1u
X502 sg13cmos5l_buf_16_5.X a_5108_838# VGND.t860 VGND.t1446 sg13_lv_nmos ad=0.1406p pd=1.12u as=0.1406p ps=1.12u w=0.74u l=0.13u
X503 VPWR.t357 VGND.t261 VPWR.t562 VPWR.t55 sg13_lv_pmos ad=0.34p pd=2.68u as=0 ps=0 w=1u l=1u
X504 sg13cmos5l_buf_16_20.A a_5204_11422# VPWR.t1291 VPWR.t13 sg13_lv_pmos ad=0.2128p pd=1.5u as=0.2128p ps=1.5u w=1.12u l=0.13u
X505 VPWR.t720 a_5684_6132# sg13cmos5l_buf_16_28.X VPWR.t70 sg13_lv_pmos ad=0.2128p pd=1.5u as=0.2128p ps=1.5u w=1.12u l=0.13u
X506 sg13cmos5l_buf_16_3.X a_10292_4620# VGND.t72 VGND.t78 sg13_lv_nmos ad=0.1406p pd=1.12u as=0.1406p ps=1.12u w=0.74u l=0.13u
X507 VGND.t384 a_3694_10704# sg13cmos5l_and2_2_6.A VGND.t156 sg13_lv_nmos ad=0.1406p pd=1.12u as=0.1406p ps=1.12u w=0.74u l=0.13u
X508 VGND.t860 a_5108_838# sg13cmos5l_buf_16_5.X VGND.t1441 sg13_lv_nmos ad=0.1406p pd=1.12u as=0.1406p ps=1.12u w=0.74u l=0.13u
X509 a_11924_13728# sg13cmos5l_buf_1_17.X VPWR.t631 VPWR.t8 sg13_lv_pmos ad=0.3808p pd=2.92u as=0.2128p ps=1.5u w=1.12u l=0.13u
X510 sg13cmos5l_buf_16_15.A a_4052_12934# VGND.t332 VGND.t722 sg13_lv_nmos ad=0.1406p pd=1.12u as=0.2516p ps=2.16u w=0.74u l=0.13u
X511 VPWR.t703 sg13cmos5l_buf_16_13.A a_3694_8434# VPWR.t3 sg13_lv_pmos ad=0.2128p pd=1.5u as=0.2128p ps=1.5u w=1.12u l=0.13u
X512 sg13cmos5l_buf_16_34.X a_3694_7680# VGND.t275 VGND.t398 sg13_lv_nmos ad=0.1406p pd=1.12u as=0.1406p ps=1.12u w=0.74u l=0.13u
X513 VGND.t1 sg13cmos5l_and2_2_6.X a_6836_9156# VGND.t256 sg13_lv_nmos ad=0.1406p pd=1.12u as=0.1406p ps=1.12u w=0.74u l=0.13u
X514 sg13cmos5l_buf_16_24.A a_6094_10704# VPWR.t679 VPWR.t55 sg13_lv_pmos ad=0.2128p pd=1.5u as=0.2128p ps=1.5u w=1.12u l=0.13u
X515 VGND.t750 a_5204_11422# sg13cmos5l_buf_16_20.A VGND.t156 sg13_lv_nmos ad=0.1406p pd=1.12u as=0.1406p ps=1.12u w=0.74u l=0.13u
X516 VGND.t282 VPWR.t28 VGND.t282 VGND.t1232 sg13_lv_nmos ad=0.1428p pd=1.52u as=0 ps=0 w=0.42u l=1u
X517 VPWR.t92 VGND.t315 VPWR.t91 VPWR.t8 sg13_lv_pmos ad=0.34p pd=2.68u as=0 ps=0 w=1u l=1u
X518 VGND.t169 a_4436_9910# sg13cmos5l_buf_16_14.A VGND.t168 sg13_lv_nmos ad=0.1406p pd=1.12u as=0.1406p ps=1.12u w=0.74u l=0.13u
X519 sg13cmos5l_buf_16_5.A a_5710_1632# VPWR.t6 VPWR.t0 sg13_lv_pmos ad=0.2128p pd=1.5u as=0.2128p ps=1.5u w=1.12u l=0.13u
X520 VPWR.t19 sg13cmos5l_buf_16_5.A a_5108_838# VPWR.t0 sg13_lv_pmos ad=0.3808p pd=2.92u as=0.2128p ps=1.5u w=1.12u l=0.13u
X521 VPWR.t202 sg13cmos5l_buf_16_2.A a_10318_3898# VPWR.t28 sg13_lv_pmos ad=0.2128p pd=1.5u as=0.2128p ps=1.5u w=1.12u l=0.13u
X522 VGND.t315 VPWR.t1683 VGND.t315 VGND.t956 sg13_lv_nmos ad=0.1428p pd=1.52u as=0 ps=0 w=0.42u l=1u
X523 VGND.t377 VPWR.t118 VGND.t377 VGND.t156 sg13_lv_nmos ad=79.8f pd=0.8u as=0 ps=0 w=0.42u l=1u
X524 VGND.t1153 VPWR.t1644 VGND.t1153 VGND.t1155 sg13_lv_nmos ad=0.1428p pd=1.52u as=0 ps=0 w=0.42u l=1u
X525 VGND.t519 VPWR.t1686 VGND.t519 VGND.t965 sg13_lv_nmos ad=79.8f pd=0.8u as=0 ps=0 w=0.42u l=1u
X526 VPWR.t1092 VGND.t11 VPWR.t1090 VPWR.t3 sg13_lv_pmos ad=0.19p pd=1.38u as=0 ps=0 w=1u l=1u
X527 VGND.t207 a_3694_3898# sg13cmos5l_buf_16_10.A VGND.t40 sg13_lv_nmos ad=0.1406p pd=1.12u as=0.1406p ps=1.12u w=0.74u l=0.13u
X528 sg13cmos5l_buf_16_27.X a_6548_13692# VGND.t912 VGND.t1489 sg13_lv_nmos ad=0.1406p pd=1.12u as=0.1406p ps=1.12u w=0.74u l=0.13u
X529 sg13cmos5l_buf_16_25.A a_6836_9156# VGND.t1 VGND.t109 sg13_lv_nmos ad=0.1406p pd=1.12u as=0.1406p ps=1.12u w=0.74u l=0.13u
X530 VPWR.t90 VGND.t413 VPWR.t88 VPWR.t5 sg13_lv_pmos ad=0.19p pd=1.38u as=0 ps=0 w=1u l=1u
X531 VPWR.t304 VGND.t573 VPWR.t304 VPWR.t13 sg13_lv_pmos ad=0.19p pd=1.38u as=0 ps=0 w=1u l=1u
X532 VPWR.t588 sg13cmos5l_buf_16_24.A a_6862_9946# VPWR.t55 sg13_lv_pmos ad=0.2128p pd=1.5u as=0.2128p ps=1.5u w=1.12u l=0.13u
X533 sg13cmos5l_buf_16_14.A a_4436_9910# VGND.t165 VGND.t164 sg13_lv_nmos ad=0.1406p pd=1.12u as=0.2516p ps=2.16u w=0.74u l=0.13u
X534 VGND.t11 a_10318_8434# sg13cmos5l_buf_16_22.X VGND.t770 sg13_lv_nmos ad=0.1406p pd=1.12u as=0.1406p ps=1.12u w=0.74u l=0.13u
X535 VGND.t130 VPWR.t288 VGND.t130 VGND.t40 sg13_lv_nmos ad=79.8f pd=0.8u as=0 ps=0 w=0.42u l=1u
X536 sg13cmos5l_buf_16_20.A a_5204_11422# VPWR.t1287 VPWR.t13 sg13_lv_pmos ad=0.2128p pd=1.5u as=0.2128p ps=1.5u w=1.12u l=0.13u
X537 VPWR.t19 a_5710_1632# sg13cmos5l_buf_16_5.A VPWR.t0 sg13_lv_pmos ad=0.2128p pd=1.5u as=0.2128p ps=1.5u w=1.12u l=0.13u
X538 VGND.t70 VPWR.t73 VGND.t70 VGND.t1205 sg13_lv_nmos ad=79.8f pd=0.8u as=0 ps=0 w=0.42u l=1u
X539 VPWR.t753 a_6094_4656# sg13cmos5l_buf_16_31.X VPWR.t28 sg13_lv_pmos ad=0.2128p pd=1.5u as=0.2128p ps=1.5u w=1.12u l=0.13u
X540 VPWR.t129 VGND.t639 VPWR.t129 VPWR.t8 sg13_lv_pmos ad=0.34p pd=2.68u as=0 ps=0 w=1u l=1u
X541 VPWR.t292 VGND.t636 VPWR.t292 VPWR.t292 sg13_lv_pmos ad=0.19p pd=1.38u as=0 ps=0 w=1u l=1u
X542 sg13cmos5l_buf_16_3.X a_10292_4620# VGND.t72 VGND.t74 sg13_lv_nmos ad=0.1406p pd=1.12u as=0.1406p ps=1.12u w=0.74u l=0.13u
X543 VPWR.t1466 a_4174_13728# sg13cmos5l_buf_16_18.A VPWR.t8 sg13_lv_pmos ad=0.2128p pd=1.5u as=0.2128p ps=1.5u w=1.12u l=0.13u
X544 a_7220_5374# sg13cmos5l_buf_16_38.A VPWR.t70 VPWR.t70 sg13_lv_pmos ad=0.2128p pd=1.5u as=0.2128p ps=1.5u w=1.12u l=0.13u
X545 a_14252_9906# sg13cmos5l_and2_2_3.X VGND.t397 VGND.t742 sg13_lv_nmos ad=0.187p pd=1.78u as=0.14875p ps=1.16u w=0.55u l=0.13u
X546 VPWR.t239 a_6836_9156# sg13cmos5l_buf_16_25.A VPWR.t3 sg13_lv_pmos ad=0.2128p pd=1.5u as=0.2128p ps=1.5u w=1.12u l=0.13u
X547 VPWR.t1 VGND.t1397 VPWR.t24 VPWR.t0 sg13_lv_pmos ad=0.34p pd=2.68u as=0 ps=0 w=1u l=1u
X548 VGND.t358 a_8110_6168# sg13cmos5l_buf_16_38.A VGND.t545 sg13_lv_nmos ad=0.1406p pd=1.12u as=0.1406p ps=1.12u w=0.74u l=0.13u
X549 VPWR.t202 sg13cmos5l_buf_16_2.A a_10318_3898# VPWR.t28 sg13_lv_pmos ad=0.2128p pd=1.5u as=0.2128p ps=1.5u w=1.12u l=0.13u
X550 VGND.t261 VPWR.t189 VGND.t1060 VGND.t1074 sg13_lv_nmos ad=79.8f pd=0.8u as=0 ps=0 w=0.42u l=1u
X551 a_8494_3144# sg13cmos5l_buf_16_0.A VPWR.t219 VPWR.t20 sg13_lv_pmos ad=0.2128p pd=1.5u as=0.2128p ps=1.5u w=1.12u l=0.13u
X552 VGND.t11 VPWR.t1655 VGND.t11 VGND.t1117 sg13_lv_nmos ad=79.8f pd=0.8u as=0 ps=0 w=0.42u l=1u
X553 VPWR.t792 a_3694_2386# sg13cmos5l_buf_16_7.X VPWR.t20 sg13_lv_pmos ad=0.3976p pd=2.95u as=0.2128p ps=1.5u w=1.12u l=0.13u
X554 VGND.t41 sg13cmos5l_buf_16_10.A a_3668_3108# VGND.t40 sg13_lv_nmos ad=0.1406p pd=1.12u as=0.1406p ps=1.12u w=0.74u l=0.13u
X555 VGND.t491 a_6164_2350# sg13cmos5l_buf_16_30.A VGND.t498 sg13_lv_nmos ad=0.1406p pd=1.12u as=0.1406p ps=1.12u w=0.74u l=0.13u
X556 sg13cmos5l_buf_16_38.A a_8110_6168# VGND.t358 VGND.t542 sg13_lv_nmos ad=0.1406p pd=1.12u as=0.1406p ps=1.12u w=0.74u l=0.13u
X557 VGND.t358 a_5684_6132# sg13cmos5l_buf_16_28.X VGND.t828 sg13_lv_nmos ad=0.1406p pd=1.12u as=0.1406p ps=1.12u w=0.74u l=0.13u
X558 sg13cmos5l_buf_16_18.A a_4174_13728# VGND.t912 VGND.t1463 sg13_lv_nmos ad=0.1406p pd=1.12u as=0.1406p ps=1.12u w=0.74u l=0.13u
X559 sg13cmos5l_buf_16_22.X a_10318_8434# VPWR.t190 VPWR.t3 sg13_lv_pmos ad=0.2128p pd=1.5u as=0.2128p ps=1.5u w=1.12u l=0.13u
X560 a_13916_11752# sg13cmos5l_and2_2_3.X VPWR.t304 VPWR.t13 sg13_lv_pmos ad=0.2128p pd=1.5u as=0.2128p ps=1.5u w=1.12u l=0.13u
X561 VGND.t1020 VPWR.t131 VGND.t1020 VGND.t156 sg13_lv_nmos ad=79.8f pd=0.8u as=0 ps=0 w=0.42u l=1u
X562 sg13cmos5l_buf_16_7.X a_3694_2386# VPWR.t788 VPWR.t20 sg13_lv_pmos ad=0.2128p pd=1.5u as=0.2128p ps=1.5u w=1.12u l=0.13u
X563 VPWR.t763 a_3668_4620# sg13cmos5l_buf_16_8.A VPWR.t28 sg13_lv_pmos ad=0.2128p pd=1.5u as=0.2128p ps=1.5u w=1.12u l=0.13u
X564 sg13cmos5l_buf_16_34.X a_3694_7680# VPWR.t1327 VPWR.t5 sg13_lv_pmos ad=0.2128p pd=1.5u as=0.2128p ps=1.5u w=1.12u l=0.13u
X565 VPWR.t190 a_10318_8434# sg13cmos5l_buf_16_22.X VPWR.t3 sg13_lv_pmos ad=0.2128p pd=1.5u as=0.2128p ps=1.5u w=1.12u l=0.13u
X566 sg13cmos5l_buf_16_2.X a_10318_3898# VGND.t130 VGND.t40 sg13_lv_nmos ad=0.1406p pd=1.12u as=0.1406p ps=1.12u w=0.74u l=0.13u
X567 VPWR.t4 VGND.t397 VPWR.t4 VPWR.t3 sg13_lv_pmos ad=0.34p pd=2.68u as=0 ps=0 w=1u l=1u
X568 VPWR.t450 VGND.t244 VPWR.t449 VPWR.t28 sg13_lv_pmos ad=0.34p pd=2.68u as=0 ps=0 w=1u l=1u
X569 VGND.t1235 VPWR.t28 VGND.t282 VGND.t1234 sg13_lv_nmos ad=0.1428p pd=1.52u as=0 ps=0 w=0.42u l=1u
X570 VGND.t315 a_7796_12934# sg13cmos5l_buf_16_37.X VGND.t614 sg13_lv_nmos ad=0.1406p pd=1.12u as=0.1406p ps=1.12u w=0.74u l=0.13u
X571 VPWR.t19 a_5710_1632# sg13cmos5l_buf_16_5.A VPWR.t0 sg13_lv_pmos ad=0.2128p pd=1.5u as=0.2128p ps=1.5u w=1.12u l=0.13u
X572 VGND.t207 a_3668_3108# sg13cmos5l_buf_16_7.A VGND.t40 sg13_lv_nmos ad=0.1406p pd=1.12u as=0.1406p ps=1.12u w=0.74u l=0.13u
X573 VPWR.t749 a_6094_4656# sg13cmos5l_buf_16_31.X VPWR.t28 sg13_lv_pmos ad=0.2128p pd=1.5u as=0.2128p ps=1.5u w=1.12u l=0.13u
X574 sg13cmos5l_buf_16_8.A a_3668_4620# VPWR.t760 VPWR.t28 sg13_lv_pmos ad=0.2128p pd=1.5u as=0.3976p ps=2.95u w=1.12u l=0.13u
X575 sg13cmos5l_buf_16_18.A a_4174_13728# VGND.t942 VGND.t1459 sg13_lv_nmos ad=0.1406p pd=1.12u as=0.1406p ps=1.12u w=0.74u l=0.13u
X576 VPWR.t1325 a_3694_7680# sg13cmos5l_buf_16_34.X VPWR.t5 sg13_lv_pmos ad=0.2128p pd=1.5u as=0.2128p ps=1.5u w=1.12u l=0.13u
X577 VGND.t130 a_10318_3898# sg13cmos5l_buf_16_2.X VGND.t40 sg13_lv_nmos ad=0.1406p pd=1.12u as=0.1406p ps=1.12u w=0.74u l=0.13u
X578 a_6766_8434# sg13cmos5l_buf_16_25.A VGND.t413 VGND.t577 sg13_lv_nmos ad=0.1406p pd=1.12u as=0.1406p ps=1.12u w=0.74u l=0.13u
X579 VGND.t11 VPWR.t1646 VGND.t11 VGND.t1144 sg13_lv_nmos ad=79.8f pd=0.8u as=0 ps=0 w=0.42u l=1u
X580 sg13cmos5l_xor2_1_6.X a_11898_13691# VGND.t330 VGND.t329 sg13_lv_nmos ad=0.1628p pd=1.18u as=0.3108p ps=2.32u w=0.74u l=0.13u
X581 sg13cmos5l_buf_1_23.A sg13cmos5l_and2_2_6.A a_6426_9550# VGND.t2 sg13_lv_nmos ad=0.1628p pd=1.18u as=88.8f ps=0.98u w=0.74u l=0.13u
X582 sg13cmos5l_buf_16_38.A a_8110_6168# VPWR.t837 VPWR.t70 sg13_lv_pmos ad=0.2128p pd=1.5u as=0.2128p ps=1.5u w=1.12u l=0.13u
X583 sg13cmos5l_buf_16_7.X a_3694_2386# VPWR.t784 VPWR.t20 sg13_lv_pmos ad=0.2128p pd=1.5u as=0.2128p ps=1.5u w=1.12u l=0.13u
X584 VGND.t1428 VPWR.t18 VGND.t1427 VGND.t1426 sg13_lv_nmos ad=0.1428p pd=1.52u as=0 ps=0 w=0.42u l=1u
X585 VGND.t130 VPWR.t30 VGND.t130 VGND.t40 sg13_lv_nmos ad=79.8f pd=0.8u as=0 ps=0 w=0.42u l=1u
X586 a_3694_10704# sg13cmos5l_buf_16_34.X VPWR.t691 VPWR.t55 sg13_lv_pmos ad=0.2128p pd=1.5u as=0.2128p ps=1.5u w=1.12u l=0.13u
X587 sg13cmos5l_and2_2_6.A a_3694_10704# VPWR.t828 VPWR.t55 sg13_lv_pmos ad=0.2128p pd=1.5u as=0.2128p ps=1.5u w=1.12u l=0.13u
X588 VPWR.t235 a_6836_9156# sg13cmos5l_buf_16_25.A VPWR.t3 sg13_lv_pmos ad=0.2128p pd=1.5u as=0.2128p ps=1.5u w=1.12u l=0.13u
X589 sg13cmos5l_buf_16_37.X a_7796_12934# VPWR.t930 VPWR.t8 sg13_lv_pmos ad=0.2128p pd=1.5u as=0.2128p ps=1.5u w=1.12u l=0.13u
X590 VGND.t366 sg13cmos5l_buf_1_5.A a_13768_5444# VGND.t365 sg13_lv_nmos ad=0.14875p pd=1.16u as=0.187p ps=1.78u w=0.55u l=0.13u
X591 VPWR.t136 a_9262_7680# sg13cmos5l_buf_16_2.A VPWR.t5 sg13_lv_pmos ad=0.2128p pd=1.5u as=0.2128p ps=1.5u w=1.12u l=0.13u
X592 VPWR.t631 a_8948_13692# sg13cmos5l_buf_16_37.A VPWR.t8 sg13_lv_pmos ad=0.2128p pd=1.5u as=0.2128p ps=1.5u w=1.12u l=0.13u
X593 VGND.t1020 VPWR.t357 VGND.t1020 VGND.t156 sg13_lv_nmos ad=0.1428p pd=1.52u as=0 ps=0 w=0.42u l=1u
X594 VPWR.t360 VGND.t1020 VPWR.t360 VPWR.t55 sg13_lv_pmos ad=0.19p pd=1.38u as=0 ps=0 w=1u l=1u
X595 VGND.t315 a_7796_12934# sg13cmos5l_buf_16_37.X VGND.t610 sg13_lv_nmos ad=0.1406p pd=1.12u as=0.1406p ps=1.12u w=0.74u l=0.13u
X596 VGND.t999 VPWR.t1677 VGND.t1004 VGND.t156 sg13_lv_nmos ad=79.8f pd=0.8u as=0 ps=0 w=0.42u l=1u
X597 a_4105_5452# sg13cmos5l_and2_2_0.B VGND.t222 VGND.t899 sg13_lv_nmos ad=0.1216p pd=1.02u as=0.1331p ps=1.12u w=0.64u l=0.13u
X598 VGND.t5 a_9617_8484# sg13cmos5l_xor2_1_5.X VGND.t111 sg13_lv_nmos ad=0.3108p pd=2.32u as=0.1628p ps=1.18u w=0.74u l=0.13u
X599 sg13cmos5l_buf_16_1.X a_10318_5410# VGND.t72 VGND.t78 sg13_lv_nmos ad=0.1406p pd=1.12u as=0.1406p ps=1.12u w=0.74u l=0.13u
X600 VPWR.t631 a_10292_12934# sg13cmos5l_buf_16_23.X VPWR.t8 sg13_lv_pmos ad=0.2128p pd=1.5u as=0.2128p ps=1.5u w=1.12u l=0.13u
X601 VGND.t261 VPWR.t189 VGND.t261 VGND.t1071 sg13_lv_nmos ad=0.1428p pd=1.52u as=0 ps=0 w=0.42u l=1u
X602 VPWR.t130 VGND.t652 VPWR.t125 VPWR.t13 sg13_lv_pmos ad=0.34p pd=2.68u as=0 ps=0 w=1u l=1u
X603 sg13cmos5l_buf_16_25.A a_6836_9156# VPWR.t231 VPWR.t3 sg13_lv_pmos ad=0.2128p pd=1.5u as=0.2128p ps=1.5u w=1.12u l=0.13u
X604 VGND.t491 a_6164_2350# sg13cmos5l_buf_16_30.A VGND.t494 sg13_lv_nmos ad=0.1406p pd=1.12u as=0.1406p ps=1.12u w=0.74u l=0.13u
X605 VPWR.t336 VGND.t999 VPWR.t335 VPWR.t55 sg13_lv_pmos ad=0.34p pd=2.68u as=0 ps=0 w=1u l=1u
X606 VGND.t693 VPWR.t1697 VGND.t693 VGND.t916 sg13_lv_nmos ad=0.1428p pd=1.52u as=0 ps=0 w=0.42u l=1u
X607 VGND.t584 VPWR.t21 VGND.t584 VGND.t1294 sg13_lv_nmos ad=79.8f pd=0.8u as=0 ps=0 w=0.42u l=1u
X608 a_9262_7680# sg13cmos5l_buf_16_4.X VPWR.t136 VPWR.t5 sg13_lv_pmos ad=0.2128p pd=1.5u as=0.2128p ps=1.5u w=1.12u l=0.13u
X609 VGND.t1153 VPWR.t1635 VGND.t1153 VGND.t1155 sg13_lv_nmos ad=0.1428p pd=1.52u as=0 ps=0 w=0.42u l=1u
X610 VGND.t384 VPWR.t1674 VGND.t384 VGND.t156 sg13_lv_nmos ad=79.8f pd=0.8u as=0 ps=0 w=0.42u l=1u
X611 VGND.t165 a_3668_9156# sg13cmos5l_buf_16_13.A VGND.t189 sg13_lv_nmos ad=0.1406p pd=1.12u as=0.1406p ps=1.12u w=0.74u l=0.13u
X612 VGND.t1119 VPWR.t1654 VGND.t275 VGND.t1120 sg13_lv_nmos ad=79.8f pd=0.8u as=0 ps=0 w=0.42u l=1u
X613 VPWR.t19 VGND.t150 VPWR.t19 VPWR.t0 sg13_lv_pmos ad=0.19p pd=1.38u as=0 ps=0 w=1u l=1u
X614 VPWR.t1339 a_7629_8028# sg13cmos5l_and2_2_6.X VPWR.t5 sg13_lv_pmos ad=0.4256p pd=3u as=0.2128p ps=1.5u w=1.12u l=0.13u
X615 VGND.t322 a_10292_12934# sg13cmos5l_buf_16_23.X VGND.t656 sg13_lv_nmos ad=0.1406p pd=1.12u as=0.1406p ps=1.12u w=0.74u l=0.13u
X616 VGND.t315 VPWR.t1680 VGND.t315 VGND.t980 sg13_lv_nmos ad=0.1428p pd=1.52u as=0 ps=0 w=0.42u l=1u
X617 sg13cmos5l_buf_16_30.A a_6164_2350# VGND.t491 VGND.t490 sg13_lv_nmos ad=0.1406p pd=1.12u as=0.2516p ps=2.16u w=0.74u l=0.13u
X618 VGND.t23 a_3668_4620# sg13cmos5l_buf_16_8.A VGND.t470 sg13_lv_nmos ad=0.1406p pd=1.12u as=0.1406p ps=1.12u w=0.74u l=0.13u
X619 sg13cmos5l_buf_16_34.X a_3694_7680# VGND.t413 VGND.t414 sg13_lv_nmos ad=0.1406p pd=1.12u as=0.1406p ps=1.12u w=0.74u l=0.13u
X620 VPWR.t836 a_3694_10704# sg13cmos5l_and2_2_6.A VPWR.t55 sg13_lv_pmos ad=0.3976p pd=2.95u as=0.2128p ps=1.5u w=1.12u l=0.13u
X621 VGND.t116 a_13745_8484# sg13cmos5l_xor2_1_4.X VGND.t634 sg13_lv_nmos ad=0.3108p pd=2.32u as=0.1628p ps=1.18u w=0.74u l=0.13u
X622 VGND.t402 a_3694_8434# sg13cmos5l_buf_16_34.A VGND.t410 sg13_lv_nmos ad=0.1406p pd=1.12u as=0.1406p ps=1.12u w=0.74u l=0.13u
X623 VPWR.t136 sg13cmos5l_buf_16_4.X a_9262_7680# VPWR.t5 sg13_lv_pmos ad=0.2128p pd=1.5u as=0.2128p ps=1.5u w=1.12u l=0.13u
X624 sg13cmos5l_buf_16_13.A a_3668_9156# VGND.t165 VGND.t186 sg13_lv_nmos ad=0.1406p pd=1.12u as=0.1406p ps=1.12u w=0.74u l=0.13u
X625 VPWR.t545 a_6094_3898# sg13cmos5l_buf_16_0.A VPWR.t28 sg13_lv_pmos ad=0.3976p pd=2.95u as=0.2128p ps=1.5u w=1.12u l=0.13u
X626 sg13cmos5l_buf_16_10.A a_3694_3898# VPWR.t886 VPWR.t28 sg13_lv_pmos ad=0.2128p pd=1.5u as=0.2128p ps=1.5u w=1.12u l=0.13u
X627 a_6161_12574# sg13cmos5l_buf_16_15.A VGND.t315 VGND.t516 sg13_lv_nmos ad=0.17462p pd=1.185u as=0.374p ps=2.46u w=0.55u l=0.13u
X628 VPWR.t1171 VGND.t1004 VPWR.t1169 VPWR.t13 sg13_lv_pmos ad=0.19p pd=1.38u as=0 ps=0 w=1u l=1u
X629 sg13cmos5l_buf_16_0.A a_6094_3898# VGND.t41 VGND.t40 sg13_lv_nmos ad=0.1406p pd=1.12u as=0.1406p ps=1.12u w=0.74u l=0.13u
X630 a_10318_5410# sg13cmos5l_buf_16_3.X VGND.t72 VGND.t74 sg13_lv_nmos ad=0.1406p pd=1.12u as=0.1406p ps=1.12u w=0.74u l=0.13u
X631 VPWR.t202 a_10292_4620# sg13cmos5l_buf_16_3.X VPWR.t28 sg13_lv_pmos ad=0.2128p pd=1.5u as=0.2128p ps=1.5u w=1.12u l=0.13u
X632 VGND.t282 a_6094_4656# sg13cmos5l_buf_16_31.X VGND.t454 sg13_lv_nmos ad=0.1406p pd=1.12u as=0.1406p ps=1.12u w=0.74u l=0.13u
X633 out_xor[2] a_14824_5444# VPWR.t73 VPWR.t70 sg13_lv_pmos ad=0.42p pd=2.99u as=0.2114p ps=1.54u w=1.12u l=0.13u
X634 sg13cmos5l_buf_16_8.A a_3668_4620# VGND.t222 VGND.t467 sg13_lv_nmos ad=0.1406p pd=1.12u as=0.1406p ps=1.12u w=0.74u l=0.13u
X635 a_10292_12934# sg13cmos5l_buf_1_17.A VPWR.t631 VPWR.t8 sg13_lv_pmos ad=0.2128p pd=1.5u as=0.2128p ps=1.5u w=1.12u l=0.13u
X636 VGND.t332 VPWR.t1688 VGND.t332 VGND.t961 sg13_lv_nmos ad=0.1428p pd=1.52u as=0 ps=0 w=0.42u l=1u
X637 VPWR.t105 VGND.t315 VPWR.t103 VPWR.t13 sg13_lv_pmos ad=0.19p pd=1.38u as=0 ps=0 w=1u l=1u
X638 VPWR.t304 VGND.t573 VPWR.t304 VPWR.t13 sg13_lv_pmos ad=0.19p pd=1.38u as=0 ps=0 w=1u l=1u
X639 VPWR.t500 a_3668_3108# sg13cmos5l_buf_16_7.A VPWR.t20 sg13_lv_pmos ad=0.2128p pd=1.5u as=0.2128p ps=1.5u w=1.12u l=0.13u
X640 VGND.t1176 VPWR.t71 VGND.t1176 VGND.t1201 sg13_lv_nmos ad=79.8f pd=0.8u as=0 ps=0 w=0.42u l=1u
X641 VPWR.t1112 VGND.t11 VPWR.t1110 VPWR.t5 sg13_lv_pmos ad=0.19p pd=1.38u as=0 ps=0 w=1u l=1u
X642 VGND.t652 a_10292_12934# sg13cmos5l_buf_16_23.X VGND.t651 sg13_lv_nmos ad=0.1406p pd=1.12u as=0.1406p ps=1.12u w=0.74u l=0.13u
X643 a_3694_14482# sg13cmos5l_buf_16_15.X VPWR.t1503 VPWR.t292 sg13_lv_pmos ad=0.2128p pd=1.5u as=0.3808p ps=2.92u w=1.12u l=0.13u
X644 VGND.t41 enable a_6094_3898# VGND.t40 sg13_lv_nmos ad=0.1406p pd=1.12u as=0.1406p ps=1.12u w=0.74u l=0.13u
X645 VPWR.t884 a_3694_3898# sg13cmos5l_buf_16_10.A VPWR.t28 sg13_lv_pmos ad=0.2128p pd=1.5u as=0.2128p ps=1.5u w=1.12u l=0.13u
X646 VGND.t1079 VPWR.t245 VGND.t1079 VGND.t1082 sg13_lv_nmos ad=0.1428p pd=1.52u as=0 ps=0 w=0.42u l=1u
X647 VPWR.t718 a_3694_8434# sg13cmos5l_buf_16_34.A VPWR.t3 sg13_lv_pmos ad=0.3976p pd=2.95u as=0.2128p ps=1.5u w=1.12u l=0.13u
X648 VGND.t157 VPWR.t56 VGND.t157 VGND.t156 sg13_lv_nmos ad=0.1428p pd=1.52u as=0 ps=0 w=0.42u l=1u
X649 VPWR.t832 a_3694_10704# sg13cmos5l_and2_2_6.A VPWR.t55 sg13_lv_pmos ad=0.2128p pd=1.5u as=0.2128p ps=1.5u w=1.12u l=0.13u
X650 VPWR.t292 VGND.t639 VPWR.t292 VPWR.t292 sg13_lv_pmos ad=0.19p pd=1.38u as=0 ps=0 w=1u l=1u
X651 sg13cmos5l_buf_16_15.A a_4052_12934# VPWR.t1270 VPWR.t8 sg13_lv_pmos ad=0.2128p pd=1.5u as=0.2128p ps=1.5u w=1.12u l=0.13u
X652 VGND.t584 VPWR.t24 VGND.t584 VGND.t1332 sg13_lv_nmos ad=79.8f pd=0.8u as=0 ps=0 w=0.42u l=1u
X653 sg13cmos5l_buf_16_7.A a_3668_3108# VPWR.t496 VPWR.t20 sg13_lv_pmos ad=0.2128p pd=1.5u as=0.2128p ps=1.5u w=1.12u l=0.13u
X654 VGND.t1378 VPWR.t6 VGND.t1380 VGND.t1379 sg13_lv_nmos ad=79.8f pd=0.8u as=0 ps=0 w=0.42u l=1u
X655 VGND.t56 VPWR.t28 VGND.t92 VGND.t40 sg13_lv_nmos ad=79.8f pd=0.8u as=0 ps=0 w=0.42u l=1u
X656 a_6094_3898# enable VGND.t41 VGND.t40 sg13_lv_nmos ad=0.1406p pd=1.12u as=0.2516p ps=2.16u w=0.74u l=0.13u
X657 VGND.t860 a_5108_838# sg13cmos5l_buf_16_5.X VGND.t1447 sg13_lv_nmos ad=0.1406p pd=1.12u as=0.1406p ps=1.12u w=0.74u l=0.13u
X658 sg13cmos5l_buf_16_23.X a_10292_12934# VPWR.t631 VPWR.t8 sg13_lv_pmos ad=0.2128p pd=1.5u as=0.2128p ps=1.5u w=1.12u l=0.13u
X659 sg13cmos5l_buf_16_34.A a_3694_8434# VPWR.t714 VPWR.t3 sg13_lv_pmos ad=0.2128p pd=1.5u as=0.2128p ps=1.5u w=1.12u l=0.13u
X660 VGND.t11 VPWR.t1657 VGND.t11 VGND.t1113 sg13_lv_nmos ad=79.8f pd=0.8u as=0 ps=0 w=0.42u l=1u
X661 VPWR.t78 VGND.t146 VPWR.t77 VPWR.t0 sg13_lv_pmos ad=0.19p pd=1.38u as=0 ps=0 w=1u l=1u
X662 VPWR.t73 VGND.t70 VPWR.t73 VPWR.t70 sg13_lv_pmos ad=0.19p pd=1.38u as=0 ps=0 w=1u l=1u
X663 VPWR.t96 VGND.t315 VPWR.t95 VPWR.t8 sg13_lv_pmos ad=0.34p pd=2.68u as=0 ps=0 w=1u l=1u
X664 VPWR.t655 a_3668_12180# sg13cmos5l_buf_16_15.X VPWR.t13 sg13_lv_pmos ad=0.2128p pd=1.5u as=0.2128p ps=1.5u w=1.12u l=0.13u
X665 VGND.t413 VPWR.t1653 VGND.t413 VGND.t1121 sg13_lv_nmos ad=0.1428p pd=1.52u as=0 ps=0 w=0.42u l=1u
X666 VPWR.t202 a_10292_4620# sg13cmos5l_buf_16_3.X VPWR.t28 sg13_lv_pmos ad=0.2128p pd=1.5u as=0.2128p ps=1.5u w=1.12u l=0.13u
X667 VPWR.t905 VGND.t1079 VPWR.t905 VPWR.t55 sg13_lv_pmos ad=0.19p pd=1.38u as=0 ps=0 w=1u l=1u
X668 sg13cmos5l_buf_16_6.X a_5518_6922# VGND.t671 VGND.t672 sg13_lv_nmos ad=0.1406p pd=1.12u as=0.1406p ps=1.12u w=0.74u l=0.13u
X669 sg13cmos5l_buf_16_27.X a_6548_13692# VPWR.t1492 VPWR.t8 sg13_lv_pmos ad=0.2128p pd=1.5u as=0.2128p ps=1.5u w=1.12u l=0.13u
X670 a_3020_14442# glitch_en[1] VGND.t897 VGND.t1478 sg13_lv_nmos ad=0.187p pd=1.78u as=0.14875p ps=1.16u w=0.55u l=0.13u
X671 VGND.t315 a_10292_12934# sg13cmos5l_buf_16_23.X VGND.t647 sg13_lv_nmos ad=0.1406p pd=1.12u as=0.1406p ps=1.12u w=0.74u l=0.13u
X672 sg13cmos5l_buf_16_5.X a_5108_838# VGND.t860 VGND.t1442 sg13_lv_nmos ad=0.1406p pd=1.12u as=0.1406p ps=1.12u w=0.74u l=0.13u
X673 VPWR.t70 sg13cmos5l_buf_16_3.X a_10318_5410# VPWR.t70 sg13_lv_pmos ad=0.2128p pd=1.5u as=0.2128p ps=1.5u w=1.12u l=0.13u
X674 sg13cmos5l_buf_16_24.X a_6862_9946# VPWR.t558 VPWR.t55 sg13_lv_pmos ad=0.2128p pd=1.5u as=0.2128p ps=1.5u w=1.12u l=0.13u
X675 VPWR.t494 a_3668_3108# sg13cmos5l_buf_16_7.A VPWR.t20 sg13_lv_pmos ad=0.2128p pd=1.5u as=0.2128p ps=1.5u w=1.12u l=0.13u
X676 VPWR.t663 sg13cmos5l_buf_16_19.A a_5204_11422# VPWR.t13 sg13_lv_pmos ad=0.2128p pd=1.5u as=0.2128p ps=1.5u w=1.12u l=0.13u
X677 sg13cmos5l_buf_16_4.A a_11565_8028# VGND.t11 VGND.t809 sg13_lv_nmos ad=0.1406p pd=1.12u as=0.1331p ps=1.12u w=0.74u l=0.13u
X678 a_4689_6168# sg13cmos5l_buf_16_8.A VPWR.t1227 VPWR.t70 sg13_lv_pmos ad=0.1225p pd=1.245u as=0.36p ps=2.72u w=1u l=0.13u
X679 VPWR.t670 sg13cmos5l_buf_16_28.X a_5518_6922# VPWR.t5 sg13_lv_pmos ad=0.2128p pd=1.5u as=0.2128p ps=1.5u w=1.12u l=0.13u
X680 sg13cmos5l_buf_16_34.X a_3694_7680# VGND.t402 VGND.t409 sg13_lv_nmos ad=0.1406p pd=1.12u as=0.1406p ps=1.12u w=0.74u l=0.13u
X681 VPWR.t1523 a_3694_14482# sg13cmos5l_buf_16_33.A VPWR.t292 sg13_lv_pmos ad=0.2128p pd=1.5u as=0.2128p ps=1.5u w=1.12u l=0.13u
X682 VPWR.t30 VGND.t130 VPWR.t30 VPWR.t20 sg13_lv_pmos ad=0.19p pd=1.38u as=0 ps=0 w=1u l=1u
X683 VPWR.t21 a_8494_3144# sg13cmos5l_buf_16_39.A VPWR.t20 sg13_lv_pmos ad=0.2128p pd=1.5u as=0.2128p ps=1.5u w=1.12u l=0.13u
X684 VGND.t23 sg13cmos5l_and2_2_0.X a_4462_5410# VGND.t227 sg13_lv_nmos ad=0.1406p pd=1.12u as=0.1406p ps=1.12u w=0.74u l=0.13u
X685 VPWR.t21 VGND.t584 VPWR.t21 VPWR.t20 sg13_lv_pmos ad=0.19p pd=1.38u as=0 ps=0 w=1u l=1u
X686 VGND.t222 a_3875_5396# sg13cmos5l_and2_2_0.X VGND.t424 sg13_lv_nmos ad=0.1331p pd=1.12u as=0.1406p ps=1.12u w=0.74u l=0.13u
X687 VPWR.t651 a_3668_12180# sg13cmos5l_buf_16_15.X VPWR.t13 sg13_lv_pmos ad=0.2128p pd=1.5u as=0.2128p ps=1.5u w=1.12u l=0.13u
X688 VPWR.t73 VGND.t851 VPWR.t73 VPWR.t70 sg13_lv_pmos ad=0.19p pd=1.38u as=0 ps=0 w=1u l=1u
X689 VGND.t82 a_10292_4620# sg13cmos5l_buf_16_3.X VGND.t88 sg13_lv_nmos ad=0.1406p pd=1.12u as=0.1406p ps=1.12u w=0.74u l=0.13u
X690 sg13cmos5l_buf_16_8.A a_3668_4620# VGND.t222 VGND.t463 sg13_lv_nmos ad=0.1406p pd=1.12u as=0.1406p ps=1.12u w=0.74u l=0.13u
X691 sg13cmos5l_buf_16_34.A a_3694_8434# VPWR.t710 VPWR.t3 sg13_lv_pmos ad=0.2128p pd=1.5u as=0.2128p ps=1.5u w=1.12u l=0.13u
X692 VGND.t1060 VPWR.t190 VGND.t1060 VGND.t1075 sg13_lv_nmos ad=0.1428p pd=1.52u as=0 ps=0 w=0.42u l=1u
X693 VPWR.t1289 a_5204_11422# sg13cmos5l_buf_16_20.A VPWR.t13 sg13_lv_pmos ad=0.2128p pd=1.5u as=0.2128p ps=1.5u w=1.12u l=0.13u
X694 sg13cmos5l_buf_16_24.X a_6862_9946# VPWR.t554 VPWR.t55 sg13_lv_pmos ad=0.2128p pd=1.5u as=0.2128p ps=1.5u w=1.12u l=0.13u
X695 VGND.t1119 VPWR.t1654 VGND.t11 VGND.t1118 sg13_lv_nmos ad=0.1428p pd=1.52u as=0 ps=0 w=0.42u l=1u
X696 sg13cmos5l_buf_16_14.A a_4436_9910# VGND.t1 VGND.t178 sg13_lv_nmos ad=0.1406p pd=1.12u as=0.1406p ps=1.12u w=0.74u l=0.13u
X697 sg13cmos5l_xor2_1_0.B a_6094_3144# VGND.t41 VGND.t40 sg13_lv_nmos ad=0.1406p pd=1.12u as=0.1406p ps=1.12u w=0.74u l=0.13u
X698 VPWR.t1023 VGND.t912 VPWR.t1022 VPWR.t292 sg13_lv_pmos ad=0.34p pd=2.68u as=0 ps=0 w=1u l=1u
X699 sg13cmos5l_buf_16_2.X a_10318_3898# VPWR.t202 VPWR.t28 sg13_lv_pmos ad=0.2128p pd=1.5u as=0.2128p ps=1.5u w=1.12u l=0.13u
X700 VGND.t519 VPWR.t1681 VGND.t315 VGND.t979 sg13_lv_nmos ad=79.8f pd=0.8u as=0 ps=0 w=0.42u l=1u
X701 sg13cmos5l_buf_16_3.X a_10292_4620# VGND.t82 VGND.t85 sg13_lv_nmos ad=0.1406p pd=1.12u as=0.1406p ps=1.12u w=0.74u l=0.13u
X702 VPWR.t947 VGND.t1207 VPWR.t945 VPWR.t70 sg13_lv_pmos ad=0.19p pd=1.38u as=0 ps=0 w=1u l=1u
X703 sg13cmos5l_buf_16_18.A a_4174_13728# VPWR.t1466 VPWR.t8 sg13_lv_pmos ad=0.2128p pd=1.5u as=0.2128p ps=1.5u w=1.12u l=0.13u
X704 sg13cmos5l_buf_16_24.A a_6094_10704# VGND.t350 VGND.t156 sg13_lv_nmos ad=0.1406p pd=1.12u as=0.1406p ps=1.12u w=0.74u l=0.13u
X705 VGND.t150 sg13cmos5l_buf_16_7.A a_3694_2386# VGND.t149 sg13_lv_nmos ad=0.1406p pd=1.12u as=0.1406p ps=1.12u w=0.74u l=0.13u
X706 VPWR.t28 VGND.t92 VPWR.t28 VPWR.t28 sg13_lv_pmos ad=0.19p pd=1.38u as=0 ps=0 w=1u l=1u
X707 VGND.t636 VPWR.t292 VGND.t636 VGND.t927 sg13_lv_nmos ad=79.8f pd=0.8u as=0 ps=0 w=0.42u l=1u
X708 VGND.t315 VPWR.t1692 VGND.t315 VGND.t952 sg13_lv_nmos ad=0.1428p pd=1.52u as=0 ps=0 w=0.42u l=1u
X709 VPWR.t71 VGND.t1173 VPWR.t319 VPWR.t70 sg13_lv_pmos ad=0.19p pd=1.38u as=0 ps=0 w=1u l=1u
X710 VGND.t1 a_4436_9910# sg13cmos5l_buf_16_14.A VGND.t175 sg13_lv_nmos ad=0.1406p pd=1.12u as=0.1406p ps=1.12u w=0.74u l=0.13u
X711 VGND.t41 sg13cmos5l_buf_16_5.X a_6094_3144# VGND.t40 sg13_lv_nmos ad=0.1406p pd=1.12u as=0.1406p ps=1.12u w=0.74u l=0.13u
X712 VPWR.t381 sg13cmos5l_buf_1_6.A a_13768_3932# VPWR.t28 sg13_lv_pmos ad=0.2114p pd=1.54u as=0.2856p ps=2.36u w=0.84u l=0.13u
X713 VGND.t1178 VPWR.t71 VGND.t70 VGND.t1203 sg13_lv_nmos ad=79.8f pd=0.8u as=0 ps=0 w=0.42u l=1u
X714 VPWR.t202 a_10318_3898# sg13cmos5l_buf_16_2.X VPWR.t28 sg13_lv_pmos ad=0.2128p pd=1.5u as=0.2128p ps=1.5u w=1.12u l=0.13u
X715 VPWR.t24 VGND.t584 VPWR.t1025 VPWR.t0 sg13_lv_pmos ad=0.19p pd=1.38u as=0 ps=0 w=1u l=1u
X716 VPWR.t979 VGND.t907 VPWR.t981 VPWR.t292 sg13_lv_pmos ad=0.19p pd=1.38u as=0 ps=0 w=1u l=1u
X717 VGND.t1020 VPWR.t125 VGND.t377 VGND.t156 sg13_lv_nmos ad=0.1428p pd=1.52u as=0 ps=0 w=0.42u l=1u
X718 a_3694_2386# sg13cmos5l_buf_16_7.A VGND.t146 VGND.t145 sg13_lv_nmos ad=0.1406p pd=1.12u as=0.2516p ps=2.16u w=0.74u l=0.13u
X719 VPWR.t905 VGND.t1020 VPWR.t905 VPWR.t55 sg13_lv_pmos ad=0.19p pd=1.38u as=0 ps=0 w=1u l=1u
X720 VGND.t282 VPWR.t1626 VGND.t27 VGND.t1215 sg13_lv_nmos ad=0.1428p pd=1.52u as=0 ps=0 w=0.42u l=1u
X721 sg13cmos5l_buf_16_14.A a_4436_9910# VGND.t169 VGND.t172 sg13_lv_nmos ad=0.1406p pd=1.12u as=0.1406p ps=1.12u w=0.74u l=0.13u
X722 VPWR.t1077 VGND.t130 VPWR.t281 VPWR.t20 sg13_lv_pmos ad=0.19p pd=1.38u as=0 ps=0 w=1u l=1u
X723 a_6094_3144# sg13cmos5l_buf_16_5.X VGND.t41 VGND.t40 sg13_lv_nmos ad=0.1406p pd=1.12u as=0.2516p ps=2.16u w=0.74u l=0.13u
X724 VGND.t358 a_5684_6132# sg13cmos5l_buf_16_28.X VGND.t838 sg13_lv_nmos ad=0.1406p pd=1.12u as=0.1406p ps=1.12u w=0.74u l=0.13u
X725 a_6836_9156# sg13cmos5l_and2_2_6.X VPWR.t189 VPWR.t3 sg13_lv_pmos ad=0.2128p pd=1.5u as=0.2128p ps=1.5u w=1.12u l=0.13u
X726 sg13cmos5l_buf_16_2.X a_10318_3898# VPWR.t202 VPWR.t28 sg13_lv_pmos ad=0.2128p pd=1.5u as=0.2128p ps=1.5u w=1.12u l=0.13u
X727 sg13cmos5l_buf_16_18.A a_4174_13728# VPWR.t1462 VPWR.t8 sg13_lv_pmos ad=0.2128p pd=1.5u as=0.2128p ps=1.5u w=1.12u l=0.13u
X728 VPWR.t351 VGND.t1060 VPWR.t349 VPWR.t55 sg13_lv_pmos ad=0.19p pd=1.38u as=0 ps=0 w=1u l=1u
X729 a_6094_10704# sg13cmos5l_buf_16_33.A VGND.t350 VGND.t156 sg13_lv_nmos ad=0.1406p pd=1.12u as=0.1406p ps=1.12u w=0.74u l=0.13u
X730 VPWR.t21 a_8494_3144# sg13cmos5l_buf_16_39.A VPWR.t20 sg13_lv_pmos ad=0.2128p pd=1.5u as=0.2128p ps=1.5u w=1.12u l=0.13u
X731 VGND.t1219 VPWR.t71 VGND.t1219 VGND.t1221 sg13_lv_nmos ad=0.1428p pd=1.52u as=0 ps=0 w=0.42u l=1u
X732 VGND.t999 VPWR.t1670 VGND.t999 VGND.t156 sg13_lv_nmos ad=0.1428p pd=1.52u as=0 ps=0 w=0.42u l=1u
X733 VGND.t806 VPWR.t319 VGND.t806 VGND.t1197 sg13_lv_nmos ad=79.8f pd=0.8u as=0 ps=0 w=0.42u l=1u
X734 VGND.t358 sg13cmos5l_buf_16_28.X a_5518_6922# VGND.t363 sg13_lv_nmos ad=0.1406p pd=1.12u as=0.1406p ps=1.12u w=0.74u l=0.13u
X735 VPWR.t56 VGND.t157 VPWR.t56 VPWR.t55 sg13_lv_pmos ad=0.19p pd=1.38u as=0 ps=0 w=1u l=1u
X736 VGND.t1029 VPWR.t905 VGND.t1029 VGND.t156 sg13_lv_nmos ad=0.1428p pd=1.52u as=0 ps=0 w=0.42u l=1u
X737 VPWR.t800 a_6164_2350# sg13cmos5l_buf_16_30.A VPWR.t20 sg13_lv_pmos ad=0.2128p pd=1.5u as=0.2128p ps=1.5u w=1.12u l=0.13u
X738 a_6164_2350# sg13cmos5l_buf_16_39.A VGND.t504 VGND.t1567 sg13_lv_nmos ad=0.1406p pd=1.12u as=0.1406p ps=1.12u w=0.74u l=0.13u
X739 VGND.t332 a_3668_12180# sg13cmos5l_buf_16_15.X VGND.t335 sg13_lv_nmos ad=0.1406p pd=1.12u as=0.1406p ps=1.12u w=0.74u l=0.13u
X740 VGND.t345 a_3668_12180# sg13cmos5l_buf_16_15.X VGND.t349 sg13_lv_nmos ad=0.1406p pd=1.12u as=0.1406p ps=1.12u w=0.74u l=0.13u
X741 VPWR.t245 a_10318_8434# sg13cmos5l_buf_16_22.X VPWR.t3 sg13_lv_pmos ad=0.2128p pd=1.5u as=0.2128p ps=1.5u w=1.12u l=0.13u
X742 sg13cmos5l_buf_16_39.A a_8494_3144# VPWR.t21 VPWR.t20 sg13_lv_pmos ad=0.2128p pd=1.5u as=0.2128p ps=1.5u w=1.12u l=0.13u
X743 VPWR.t930 a_7796_12934# sg13cmos5l_buf_16_37.X VPWR.t8 sg13_lv_pmos ad=0.2128p pd=1.5u as=0.2128p ps=1.5u w=1.12u l=0.13u
X744 VGND.t573 a_13667_12956# sg13cmos5l_buf_1_17.A VGND.t739 sg13_lv_nmos ad=0.1331p pd=1.12u as=0.1406p ps=1.12u w=0.74u l=0.13u
X745 VPWR.t759 a_6094_4656# sg13cmos5l_buf_16_31.X VPWR.t28 sg13_lv_pmos ad=0.3976p pd=2.95u as=0.2128p ps=1.5u w=1.12u l=0.13u
X746 a_6094_10704# sg13cmos5l_buf_16_33.A VGND.t350 VGND.t156 sg13_lv_nmos ad=0.1406p pd=1.12u as=0.2516p ps=2.16u w=0.74u l=0.13u
X747 sg13cmos5l_buf_16_8.A a_3668_4620# VPWR.t771 VPWR.t28 sg13_lv_pmos ad=0.2128p pd=1.5u as=0.2128p ps=1.5u w=1.12u l=0.13u
X748 VGND.t358 a_5684_6132# sg13cmos5l_buf_16_28.X VGND.t834 sg13_lv_nmos ad=0.1406p pd=1.12u as=0.1406p ps=1.12u w=0.74u l=0.13u
X749 VPWR.t1335 a_3694_7680# sg13cmos5l_buf_16_34.X VPWR.t5 sg13_lv_pmos ad=0.2128p pd=1.5u as=0.2128p ps=1.5u w=1.12u l=0.13u
X750 a_4436_9910# sg13cmos5l_buf_16_20.A VPWR.t519 VPWR.t55 sg13_lv_pmos ad=0.2128p pd=1.5u as=0.2128p ps=1.5u w=1.12u l=0.13u
X751 VPWR.t1104 VGND.t11 VPWR.t1102 VPWR.t5 sg13_lv_pmos ad=0.19p pd=1.38u as=0 ps=0 w=1u l=1u
X752 sg13cmos5l_buf_1_11.X a_13768_9192# VPWR.t4 VPWR.t3 sg13_lv_pmos ad=0.42p pd=2.99u as=0.2114p ps=1.54u w=1.12u l=0.13u
X753 VPWR.t84 VGND.t413 VPWR.t83 VPWR.t5 sg13_lv_pmos ad=0.34p pd=2.68u as=0 ps=0 w=1u l=1u
X754 sg13cmos5l_buf_16_38.A a_8110_6168# VPWR.t70 VPWR.t70 sg13_lv_pmos ad=0.2128p pd=1.5u as=0.2128p ps=1.5u w=1.12u l=0.13u
X755 a_14444_14442# glitch_en[6] VPWR.t296 VPWR.t292 sg13_lv_pmos ad=0.2856p pd=2.36u as=0.2114p ps=1.54u w=0.84u l=0.13u
X756 VGND.t1060 VPWR.t245 VGND.t1060 VGND.t1077 sg13_lv_nmos ad=0.1428p pd=1.52u as=0 ps=0 w=0.42u l=1u
X757 VPWR.t118 VGND.t315 VPWR.t118 VPWR.t13 sg13_lv_pmos ad=0.19p pd=1.38u as=0 ps=0 w=1u l=1u
X758 sg13cmos5l_buf_1_5.A a_6161_12574# a_6332_12216# VPWR.t13 sg13_lv_pmos ad=0.3808p pd=2.92u as=0.2128p ps=1.5u w=1.12u l=0.13u
X759 a_4462_5410# sg13cmos5l_and2_2_0.X VPWR.t525 VPWR.t70 sg13_lv_pmos ad=0.2128p pd=1.5u as=0.2128p ps=1.5u w=1.12u l=0.13u
X760 VPWR.t769 a_3668_4620# sg13cmos5l_buf_16_8.A VPWR.t28 sg13_lv_pmos ad=0.2128p pd=1.5u as=0.2128p ps=1.5u w=1.12u l=0.13u
X761 VPWR.t292 VGND.t330 VPWR.t292 VPWR.t292 sg13_lv_pmos ad=0.34p pd=2.68u as=0 ps=0 w=1u l=1u
X762 VGND.t800 a_6766_8434# sg13cmos5l_buf_16_35.A VGND.t1556 sg13_lv_nmos ad=0.1406p pd=1.12u as=0.1406p ps=1.12u w=0.74u l=0.13u
X763 VGND.t1398 VPWR.t1 VGND.t1400 VGND.t1399 sg13_lv_nmos ad=79.8f pd=0.8u as=0 ps=0 w=0.42u l=1u
X764 sg13cmos5l_buf_16_4.X a_9524_6886# VGND.t358 VGND.t823 sg13_lv_nmos ad=0.1406p pd=1.12u as=0.1406p ps=1.12u w=0.74u l=0.13u
X765 VPWR.t71 VGND.t1176 VPWR.t71 VPWR.t70 sg13_lv_pmos ad=0.19p pd=1.38u as=0 ps=0 w=1u l=1u
X766 sg13cmos5l_buf_16_14.A a_4436_9910# VPWR.t460 VPWR.t55 sg13_lv_pmos ad=0.2128p pd=1.5u as=0.2128p ps=1.5u w=1.12u l=0.13u
X767 a_4436_9910# sg13cmos5l_buf_16_20.A VPWR.t472 VPWR.t55 sg13_lv_pmos ad=0.2128p pd=1.5u as=0.2128p ps=1.5u w=1.12u l=0.13u
X768 VGND.t851 VPWR.t73 VGND.t851 VGND.t1223 sg13_lv_nmos ad=79.8f pd=0.8u as=0 ps=0 w=0.42u l=1u
X769 VPWR.t1225 sg13cmos5l_buf_16_8.A a_4892_6168# VPWR.t70 sg13_lv_pmos ad=0.2128p pd=1.5u as=0.3808p ps=2.92u w=1.12u l=0.13u
X770 VPWR.t1331 a_3694_7680# sg13cmos5l_buf_16_34.X VPWR.t5 sg13_lv_pmos ad=0.2128p pd=1.5u as=0.2128p ps=1.5u w=1.12u l=0.13u
X771 VGND.t639 VPWR.t129 VGND.t639 VGND.t944 sg13_lv_nmos ad=0.1428p pd=1.52u as=0 ps=0 w=0.42u l=1u
X772 VGND.t1 sg13cmos5l_buf_16_24.A a_6862_9946# VGND.t96 sg13_lv_nmos ad=0.1406p pd=1.12u as=0.1406p ps=1.12u w=0.74u l=0.13u
X773 sg13cmos5l_buf_16_35.A a_6766_8434# VGND.t800 VGND.t1553 sg13_lv_nmos ad=0.1406p pd=1.12u as=0.1406p ps=1.12u w=0.74u l=0.13u
X774 sg13cmos5l_buf_1_5.A sg13cmos5l_buf_16_24.X a_6426_12574# VGND.t745 sg13_lv_nmos ad=0.1628p pd=1.18u as=88.8f ps=0.98u w=0.74u l=0.13u
X775 VGND.t377 a_6094_10704# sg13cmos5l_buf_16_24.A VGND.t156 sg13_lv_nmos ad=0.1406p pd=1.12u as=0.1406p ps=1.12u w=0.74u l=0.13u
X776 VGND.t1 sg13cmos5l_buf_16_14.A a_3668_9156# VGND.t658 sg13_lv_nmos ad=0.1406p pd=1.12u as=0.1406p ps=1.12u w=0.74u l=0.13u
X777 VPWR.t1114 VGND.t11 VPWR.t1113 VPWR.t5 sg13_lv_pmos ad=0.34p pd=2.68u as=0 ps=0 w=1u l=1u
X778 VGND.t82 a_10318_5410# sg13cmos5l_buf_16_1.X VGND.t88 sg13_lv_nmos ad=0.1406p pd=1.12u as=0.1406p ps=1.12u w=0.74u l=0.13u
X779 VGND.t868 VPWR.t30 VGND.t868 VGND.t1313 sg13_lv_nmos ad=79.8f pd=0.8u as=0 ps=0 w=0.42u l=1u
X780 sg13cmos5l_and2_2_6.A a_3694_10704# VGND.t384 VGND.t156 sg13_lv_nmos ad=0.1406p pd=1.12u as=0.1406p ps=1.12u w=0.74u l=0.13u
X781 VPWR.t796 a_6164_2350# sg13cmos5l_buf_16_30.A VPWR.t20 sg13_lv_pmos ad=0.2128p pd=1.5u as=0.2128p ps=1.5u w=1.12u l=0.13u
X782 VPWR.t241 a_6836_9156# sg13cmos5l_buf_16_25.A VPWR.t3 sg13_lv_pmos ad=0.2128p pd=1.5u as=0.2128p ps=1.5u w=1.12u l=0.13u
X783 VPWR.t202 VGND.t112 VPWR.t28 VPWR.t28 sg13_lv_pmos ad=0.34p pd=2.68u as=0 ps=0 w=1u l=1u
X784 VPWR.t421 VGND.t358 VPWR.t422 VPWR.t5 sg13_lv_pmos ad=0.19p pd=1.38u as=0 ps=0 w=1u l=1u
X785 VGND.t1207 VPWR.t1629 VGND.t1207 VGND.t1210 sg13_lv_nmos ad=79.8f pd=0.8u as=0 ps=0 w=0.42u l=1u
X786 VGND.t244 VPWR.t1616 VGND.t244 VGND.t40 sg13_lv_nmos ad=0.1428p pd=1.52u as=0 ps=0 w=0.42u l=1u
X787 a_3668_12180# sg13cmos5l_buf_16_15.A VGND.t345 VGND.t512 sg13_lv_nmos ad=0.1406p pd=1.12u as=0.1406p ps=1.12u w=0.74u l=0.13u
X788 VGND.t1296 VPWR.t24 VGND.t1296 VGND.t1333 sg13_lv_nmos ad=0.1428p pd=1.52u as=0 ps=0 w=0.42u l=1u
X789 sg13cmos5l_buf_16_39.A a_8494_3144# VGND.t112 VGND.t40 sg13_lv_nmos ad=0.1406p pd=1.12u as=0.1406p ps=1.12u w=0.74u l=0.13u
X790 a_4052_12934# sg13cmos5l_buf_16_18.A VGND.t315 VGND.t1533 sg13_lv_nmos ad=0.1406p pd=1.12u as=0.1406p ps=1.12u w=0.74u l=0.13u
X791 sg13cmos5l_buf_16_14.A a_4436_9910# VPWR.t457 VPWR.t55 sg13_lv_pmos ad=0.2128p pd=1.5u as=0.3976p ps=2.95u w=1.12u l=0.13u
X792 sg13cmos5l_buf_16_0.A a_6094_3898# VGND.t41 VGND.t40 sg13_lv_nmos ad=0.1406p pd=1.12u as=0.1406p ps=1.12u w=0.74u l=0.13u
X793 sg13cmos5l_buf_16_1.X a_10318_5410# VGND.t82 VGND.t85 sg13_lv_nmos ad=0.1406p pd=1.12u as=0.1406p ps=1.12u w=0.74u l=0.13u
X794 VGND.t1349 VPWR.t0 VGND.t1351 VGND.t1350 sg13_lv_nmos ad=79.8f pd=0.8u as=0 ps=0 w=0.42u l=1u
X795 sg13cmos5l_buf_1_11.X a_13768_9192# VGND.t633 VGND.t632 sg13_lv_nmos ad=0.2886p pd=2.26u as=0.14875p ps=1.16u w=0.74u l=0.13u
X796 sg13cmos5l_buf_16_30.A a_6164_2350# VPWR.t793 VPWR.t20 sg13_lv_pmos ad=0.2128p pd=1.5u as=0.3976p ps=2.95u w=1.12u l=0.13u
X797 VGND.t244 VPWR.t32 VGND.t130 VGND.t40 sg13_lv_nmos ad=0.1428p pd=1.52u as=0 ps=0 w=0.42u l=1u
X798 a_3668_4620# sg13cmos5l_buf_16_11.A VGND.t27 VGND.t564 sg13_lv_nmos ad=0.1406p pd=1.12u as=0.1406p ps=1.12u w=0.74u l=0.13u
X799 sg13cmos5l_buf_16_35.A a_6766_8434# VPWR.t1566 VPWR.t3 sg13_lv_pmos ad=0.2128p pd=1.5u as=0.2128p ps=1.5u w=1.12u l=0.13u
X800 VGND.t501 a_6164_2350# sg13cmos5l_buf_16_30.A VGND.t500 sg13_lv_nmos ad=0.1406p pd=1.12u as=0.1406p ps=1.12u w=0.74u l=0.13u
X801 a_6332_9192# sg13cmos5l_and2_2_6.A VPWR.t134 VPWR.t3 sg13_lv_pmos ad=0.2128p pd=1.5u as=0.2128p ps=1.5u w=1.12u l=0.13u
X802 VPWR.t568 sg13cmos5l_buf_16_10.A a_3668_3108# VPWR.t20 sg13_lv_pmos ad=0.3808p pd=2.92u as=0.2128p ps=1.5u w=1.12u l=0.13u
X803 VGND.t282 a_7220_5374# sg13cmos5l_buf_16_28.A VGND.t287 sg13_lv_nmos ad=0.1406p pd=1.12u as=0.1406p ps=1.12u w=0.74u l=0.13u
X804 VPWR.t1504 sg13cmos5l_buf_16_15.X a_3694_14482# VPWR.t292 sg13_lv_pmos ad=0.2128p pd=1.5u as=0.2128p ps=1.5u w=1.12u l=0.13u
X805 VPWR.t894 a_3694_3898# sg13cmos5l_buf_16_10.A VPWR.t28 sg13_lv_pmos ad=0.2128p pd=1.5u as=0.2128p ps=1.5u w=1.12u l=0.13u
X806 VPWR.t1367 a_5684_6132# sg13cmos5l_buf_16_28.X VPWR.t70 sg13_lv_pmos ad=0.2128p pd=1.5u as=0.2128p ps=1.5u w=1.12u l=0.13u
X807 VGND.t860 sg13cmos5l_buf_16_5.A a_5108_838# VGND.t863 sg13_lv_nmos ad=0.1406p pd=1.12u as=0.1406p ps=1.12u w=0.74u l=0.13u
X808 VPWR.t360 VGND.t1060 VPWR.t360 VPWR.t55 sg13_lv_pmos ad=0.34p pd=2.68u as=0 ps=0 w=1u l=1u
X809 VPWR.t1272 a_4052_12934# sg13cmos5l_buf_16_15.A VPWR.t8 sg13_lv_pmos ad=0.2128p pd=1.5u as=0.2128p ps=1.5u w=1.12u l=0.13u
X810 VPWR.t1540 sg13cmos5l_buf_16_18.A a_4052_12934# VPWR.t8 sg13_lv_pmos ad=0.3808p pd=2.92u as=0.2128p ps=1.5u w=1.12u l=0.13u
X811 VPWR.t1564 a_6766_8434# sg13cmos5l_buf_16_35.A VPWR.t3 sg13_lv_pmos ad=0.2128p pd=1.5u as=0.2128p ps=1.5u w=1.12u l=0.13u
X812 VPWR.t18 VGND.t1308 VPWR.t18 VPWR.t0 sg13_lv_pmos ad=0.19p pd=1.38u as=0 ps=0 w=1u l=1u
X813 sg13cmos5l_buf_16_3.X a_10292_4620# VPWR.t202 VPWR.t28 sg13_lv_pmos ad=0.2128p pd=1.5u as=0.2128p ps=1.5u w=1.12u l=0.13u
X814 VPWR.t486 a_3668_9156# sg13cmos5l_buf_16_13.A VPWR.t3 sg13_lv_pmos ad=0.2128p pd=1.5u as=0.2128p ps=1.5u w=1.12u l=0.13u
X815 sg13cmos5l_buf_16_5.X a_5108_838# VGND.t860 VGND.t1448 sg13_lv_nmos ad=0.1406p pd=1.12u as=0.1406p ps=1.12u w=0.74u l=0.13u
X816 VPWR.t19 a_5108_838# sg13cmos5l_buf_16_5.X VPWR.t0 sg13_lv_pmos ad=0.2128p pd=1.5u as=0.2128p ps=1.5u w=1.12u l=0.13u
X817 a_3668_3108# sg13cmos5l_buf_16_10.A VPWR.t564 VPWR.t20 sg13_lv_pmos ad=0.2128p pd=1.5u as=0.2128p ps=1.5u w=1.12u l=0.13u
X818 sg13cmos5l_buf_16_1.X a_10318_5410# VPWR.t319 VPWR.t70 sg13_lv_pmos ad=0.2128p pd=1.5u as=0.2128p ps=1.5u w=1.12u l=0.13u
X819 sg13cmos5l_buf_16_15.A a_4052_12934# VGND.t345 VGND.t734 sg13_lv_nmos ad=0.1406p pd=1.12u as=0.1406p ps=1.12u w=0.74u l=0.13u
X820 sg13cmos5l_buf_16_28.A a_7220_5374# VGND.t282 VGND.t284 sg13_lv_nmos ad=0.1406p pd=1.12u as=0.1406p ps=1.12u w=0.74u l=0.13u
X821 sg13cmos5l_buf_16_4.X a_9524_6886# VGND.t358 VGND.t819 sg13_lv_nmos ad=0.1406p pd=1.12u as=0.1406p ps=1.12u w=0.74u l=0.13u
X822 VGND.t330 VPWR.t292 VGND.t639 VGND.t929 sg13_lv_nmos ad=79.8f pd=0.8u as=0 ps=0 w=0.42u l=1u
X823 VGND.t1378 VPWR.t6 VGND.t866 VGND.t1377 sg13_lv_nmos ad=0.1428p pd=1.52u as=0 ps=0 w=0.42u l=1u
X824 VPWR.t70 a_8110_6168# sg13cmos5l_buf_16_38.A VPWR.t70 sg13_lv_pmos ad=0.2128p pd=1.5u as=0.2128p ps=1.5u w=1.12u l=0.13u
X825 VGND.t130 VPWR.t288 VGND.t130 VGND.t40 sg13_lv_nmos ad=0.1428p pd=1.52u as=0 ps=0 w=0.42u l=1u
X826 sg13cmos5l_buf_16_28.X a_5684_6132# VPWR.t1364 VPWR.t70 sg13_lv_pmos ad=0.2128p pd=1.5u as=0.3976p ps=2.95u w=1.12u l=0.13u
X827 VGND.t11 a_9262_7680# sg13cmos5l_buf_16_2.A VGND.t15 sg13_lv_nmos ad=0.1406p pd=1.12u as=0.1406p ps=1.12u w=0.74u l=0.13u
X828 VPWR.t133 VGND.t1028 VPWR.t133 VPWR.t13 sg13_lv_pmos ad=0.34p pd=2.68u as=0 ps=0 w=1u l=1u
X829 VGND.t350 a_5204_11422# sg13cmos5l_buf_16_20.A VGND.t156 sg13_lv_nmos ad=0.1406p pd=1.12u as=0.1406p ps=1.12u w=0.74u l=0.13u
X830 VGND.t868 VPWR.t18 VGND.t868 VGND.t1346 sg13_lv_nmos ad=79.8f pd=0.8u as=0 ps=0 w=0.42u l=1u
X831 sg13cmos5l_buf_16_0.A a_6094_3898# VGND.t41 VGND.t40 sg13_lv_nmos ad=0.1406p pd=1.12u as=0.1406p ps=1.12u w=0.74u l=0.13u
X832 VGND.t1207 VPWR.t1623 VGND.t1207 VGND.t1212 sg13_lv_nmos ad=79.8f pd=0.8u as=0 ps=0 w=0.42u l=1u
X833 VGND.t70 VPWR.t73 VGND.t70 VGND.t1204 sg13_lv_nmos ad=0.1428p pd=1.52u as=0 ps=0 w=0.42u l=1u
X834 sg13cmos5l_buf_16_25.A a_6836_9156# VGND.t1 VGND.t95 sg13_lv_nmos ad=0.1406p pd=1.12u as=0.2516p ps=2.16u w=0.74u l=0.13u
X835 VPWR.t202 a_10292_4620# sg13cmos5l_buf_16_3.X VPWR.t28 sg13_lv_pmos ad=0.2128p pd=1.5u as=0.2128p ps=1.5u w=1.12u l=0.13u
X836 sg13cmos5l_buf_16_13.A a_3668_9156# VPWR.t482 VPWR.t3 sg13_lv_pmos ad=0.2128p pd=1.5u as=0.2128p ps=1.5u w=1.12u l=0.13u
X837 sg13cmos5l_buf_16_5.X a_5108_838# VPWR.t19 VPWR.t0 sg13_lv_pmos ad=0.2128p pd=1.5u as=0.2128p ps=1.5u w=1.12u l=0.13u
X838 VPWR.t400 a_10318_5410# sg13cmos5l_buf_16_1.X VPWR.t70 sg13_lv_pmos ad=0.2128p pd=1.5u as=0.2128p ps=1.5u w=1.12u l=0.13u
X839 VGND.t358 a_9524_6886# sg13cmos5l_buf_16_4.X VGND.t816 sg13_lv_nmos ad=0.1406p pd=1.12u as=0.1406p ps=1.12u w=0.74u l=0.13u
X840 VGND.t5 VPWR.t189 VGND.t11 VGND.t1123 sg13_lv_nmos ad=0.1428p pd=1.52u as=0 ps=0 w=0.42u l=1u
X841 a_6548_13692# sg13cmos5l_buf_16_37.X VGND.t693 VGND.t717 sg13_lv_nmos ad=0.1406p pd=1.12u as=0.1406p ps=1.12u w=0.74u l=0.13u
X842 VPWR.t1216 a_5518_6922# sg13cmos5l_buf_16_6.X VPWR.t5 sg13_lv_pmos ad=0.2128p pd=1.5u as=0.2128p ps=1.5u w=1.12u l=0.13u
X843 VPWR.t1268 a_4052_12934# sg13cmos5l_buf_16_15.A VPWR.t8 sg13_lv_pmos ad=0.2128p pd=1.5u as=0.2128p ps=1.5u w=1.12u l=0.13u
X844 VGND.t1349 VPWR.t0 VGND.t1348 VGND.t1347 sg13_lv_nmos ad=0.1428p pd=1.52u as=0 ps=0 w=0.42u l=1u
X845 VPWR.t72 VGND.t70 VPWR.t71 VPWR.t70 sg13_lv_pmos ad=0.19p pd=1.38u as=0 ps=0 w=1u l=1u
X846 VPWR.t890 a_3694_3898# sg13cmos5l_buf_16_10.A VPWR.t28 sg13_lv_pmos ad=0.2128p pd=1.5u as=0.2128p ps=1.5u w=1.12u l=0.13u
X847 sg13cmos5l_buf_16_3.X a_10292_4620# VPWR.t202 VPWR.t28 sg13_lv_pmos ad=0.2128p pd=1.5u as=0.2128p ps=1.5u w=1.12u l=0.13u
X848 sg13cmos5l_buf_16_28.A a_7220_5374# VPWR.t604 VPWR.t70 sg13_lv_pmos ad=0.2128p pd=1.5u as=0.2128p ps=1.5u w=1.12u l=0.13u
X849 VPWR.t355 VGND.t1060 VPWR.t353 VPWR.t55 sg13_lv_pmos ad=0.19p pd=1.38u as=0 ps=0 w=1u l=1u
X850 VPWR.t78 VGND.t1371 VPWR.t78 VPWR.t0 sg13_lv_pmos ad=0.19p pd=1.38u as=0 ps=0 w=1u l=1u
X851 VPWR.t1052 VGND.t377 VPWR.t1053 VPWR.t13 sg13_lv_pmos ad=0.19p pd=1.38u as=0 ps=0 w=1u l=1u
X852 VGND.t358 a_5518_6922# sg13cmos5l_buf_16_6.X VGND.t681 sg13_lv_nmos ad=0.2516p pd=2.16u as=0.1406p ps=1.12u w=0.74u l=0.13u
X853 sg13cmos5l_buf_16_24.A a_6094_10704# VPWR.t675 VPWR.t55 sg13_lv_pmos ad=0.2128p pd=1.5u as=0.2128p ps=1.5u w=1.12u l=0.13u
X854 VGND.t350 a_5204_11422# sg13cmos5l_buf_16_20.A VGND.t156 sg13_lv_nmos ad=0.1406p pd=1.12u as=0.1406p ps=1.12u w=0.74u l=0.13u
X855 a_5710_1632# sg13cmos5l_buf_16_30.A VPWR.t19 VPWR.t0 sg13_lv_pmos ad=0.2128p pd=1.5u as=0.2128p ps=1.5u w=1.12u l=0.13u
X856 sg13cmos5l_buf_16_39.A a_8494_3144# VGND.t112 VGND.t40 sg13_lv_nmos ad=0.1406p pd=1.12u as=0.1406p ps=1.12u w=0.74u l=0.13u
X857 sg13cmos5l_buf_16_7.A a_3668_3108# VPWR.t502 VPWR.t20 sg13_lv_pmos ad=0.2128p pd=1.5u as=0.2128p ps=1.5u w=1.12u l=0.13u
X858 VPWR.t32 VGND.t868 VPWR.t30 VPWR.t20 sg13_lv_pmos ad=0.19p pd=1.38u as=0 ps=0 w=1u l=1u
X859 a_3668_4620# sg13cmos5l_buf_16_11.A VGND.t23 VGND.t560 sg13_lv_nmos ad=0.1406p pd=1.12u as=0.1406p ps=1.12u w=0.74u l=0.13u
X860 a_2147_13692# sg13cmos5l_buf_16_31.X a_2377_14076# VGND.t1530 sg13_lv_nmos ad=0.2176p pd=1.96u as=0.1216p ps=1.02u w=0.64u l=0.13u
X861 VPWR.t602 a_7220_5374# sg13cmos5l_buf_16_28.A VPWR.t70 sg13_lv_pmos ad=0.2128p pd=1.5u as=0.2128p ps=1.5u w=1.12u l=0.13u
X862 sg13cmos5l_and2_2_0.B a_1672_14516# VGND.t871 VGND.t873 sg13_lv_nmos ad=0.2886p pd=2.26u as=0.14875p ps=1.16u w=0.74u l=0.13u
X863 sg13cmos5l_buf_16_11.A a_4462_5410# VGND.t27 VGND.t32 sg13_lv_nmos ad=0.1406p pd=1.12u as=0.1406p ps=1.12u w=0.74u l=0.13u
X864 sg13cmos5l_xor2_1_0.B a_6094_3144# VGND.t41 VGND.t40 sg13_lv_nmos ad=0.1406p pd=1.12u as=0.1406p ps=1.12u w=0.74u l=0.13u
X865 sg13cmos5l_buf_16_6.X a_5518_6922# VGND.t358 VGND.t678 sg13_lv_nmos ad=0.1406p pd=1.12u as=0.1406p ps=1.12u w=0.74u l=0.13u
X866 sg13cmos5l_buf_16_27.X a_6548_13692# VGND.t912 VGND.t1485 sg13_lv_nmos ad=0.1406p pd=1.12u as=0.1406p ps=1.12u w=0.74u l=0.13u
X867 sg13cmos5l_buf_16_37.X a_7796_12934# VGND.t519 VGND.t607 sg13_lv_nmos ad=0.1406p pd=1.12u as=0.2516p ps=2.16u w=0.74u l=0.13u
X868 VPWR.t1 VGND.t1300 VPWR.t1 VPWR.t0 sg13_lv_pmos ad=0.19p pd=1.38u as=0 ps=0 w=1u l=1u
X869 VPWR.t319 VGND.t806 VPWR.t319 VPWR.t70 sg13_lv_pmos ad=0.19p pd=1.38u as=0 ps=0 w=1u l=1u
X870 VPWR.t1264 a_4052_12934# sg13cmos5l_buf_16_15.A VPWR.t8 sg13_lv_pmos ad=0.2128p pd=1.5u as=0.2128p ps=1.5u w=1.12u l=0.13u
X871 sg13cmos5l_buf_16_33.A a_3694_14482# VPWR.t1519 VPWR.t292 sg13_lv_pmos ad=0.2128p pd=1.5u as=0.2128p ps=1.5u w=1.12u l=0.13u
X872 VPWR.t75 VGND.t941 VPWR.t226 VPWR.t8 sg13_lv_pmos ad=0.34p pd=2.68u as=0 ps=0 w=1u l=1u
X873 VPWR.t308 VGND.t384 VPWR.t307 VPWR.t13 sg13_lv_pmos ad=0.34p pd=2.68u as=0 ps=0 w=1u l=1u
X874 VPWR.t878 sg13cmos5l_buf_16_25.A a_6766_8434# VPWR.t3 sg13_lv_pmos ad=0.2128p pd=1.5u as=0.2128p ps=1.5u w=1.12u l=0.13u
X875 VPWR.t1063 VGND.t377 VPWR.t1062 VPWR.t55 sg13_lv_pmos ad=0.34p pd=2.68u as=0 ps=0 w=1u l=1u
X876 a_6094_10704# sg13cmos5l_buf_16_33.A VPWR.t1435 VPWR.t55 sg13_lv_pmos ad=0.2128p pd=1.5u as=0.2128p ps=1.5u w=1.12u l=0.13u
X877 VGND.t11 VPWR.t1655 VGND.t11 VGND.t1116 sg13_lv_nmos ad=0.1428p pd=1.52u as=0 ps=0 w=0.42u l=1u
X878 VGND.t1302 VPWR.t185 VGND.t1306 VGND.t1340 sg13_lv_nmos ad=79.8f pd=0.8u as=0 ps=0 w=0.42u l=1u
X879 VGND.t27 a_4462_5410# sg13cmos5l_buf_16_11.A VGND.t29 sg13_lv_nmos ad=0.1406p pd=1.12u as=0.1406p ps=1.12u w=0.74u l=0.13u
X880 VGND.t806 VPWR.t319 VGND.t806 VGND.t1198 sg13_lv_nmos ad=0.1428p pd=1.52u as=0 ps=0 w=0.42u l=1u
X881 VPWR.t5 VGND.t70 VPWR.t5 VPWR.t5 sg13_lv_pmos ad=0.19p pd=1.38u as=0 ps=0 w=1u l=1u
X882 VGND.t519 a_6765_12564# sg13cmos5l_buf_16_19.A VGND.t520 sg13_lv_nmos ad=0.2812p pd=2.24u as=0.1406p ps=1.12u w=0.74u l=0.13u
X883 VPWR.t281 VGND.t130 VPWR.t281 VPWR.t20 sg13_lv_pmos ad=0.19p pd=1.38u as=0 ps=0 w=1u l=1u
X884 sg13cmos5l_and2_2_5.B a_11272_13728# VPWR.t631 VPWR.t8 sg13_lv_pmos ad=0.42p pd=2.99u as=0.2114p ps=1.54u w=1.12u l=0.13u
X885 sg13cmos5l_buf_16_2.X a_10318_3898# VGND.t112 VGND.t40 sg13_lv_nmos ad=0.1406p pd=1.12u as=0.1406p ps=1.12u w=0.74u l=0.13u
X886 VGND.t639 glitch_en[5] a_13576_14516# VGND.t898 sg13_lv_nmos ad=0.14875p pd=1.16u as=0.187p ps=1.78u w=0.55u l=0.13u
X887 VGND.t1125 VPWR.t245 VGND.t1127 VGND.t1126 sg13_lv_nmos ad=79.8f pd=0.8u as=0 ps=0 w=0.42u l=1u
X888 VPWR.t18 VGND.t1308 VPWR.t18 VPWR.t0 sg13_lv_pmos ad=0.19p pd=1.38u as=0 ps=0 w=1u l=1u
X889 VGND.t1354 VPWR.t284 VGND.t1356 VGND.t1355 sg13_lv_nmos ad=79.8f pd=0.8u as=0 ps=0 w=0.42u l=1u
X890 VGND.t126 sg13cmos5l_buf_16_2.X a_10292_4620# VGND.t128 sg13_lv_nmos ad=0.2516p pd=2.16u as=0.1406p ps=1.12u w=0.74u l=0.13u
X891 VPWR.t961 VGND.t1207 VPWR.t959 VPWR.t28 sg13_lv_pmos ad=0.19p pd=1.38u as=0 ps=0 w=1u l=1u
X892 sg13cmos5l_buf_16_13.A a_3668_9156# VPWR.t478 VPWR.t3 sg13_lv_pmos ad=0.2128p pd=1.5u as=0.2128p ps=1.5u w=1.12u l=0.13u
X893 VPWR.t277 sg13cmos5l_buf_16_7.A a_3694_2386# VPWR.t20 sg13_lv_pmos ad=0.2128p pd=1.5u as=0.2128p ps=1.5u w=1.12u l=0.13u
X894 sg13cmos5l_buf_16_7.X a_3694_2386# VGND.t150 VGND.t480 sg13_lv_nmos ad=0.1406p pd=1.12u as=0.1406p ps=1.12u w=0.74u l=0.13u
X895 VPWR.t400 a_10318_5410# sg13cmos5l_buf_16_1.X VPWR.t70 sg13_lv_pmos ad=0.2128p pd=1.5u as=0.2128p ps=1.5u w=1.12u l=0.13u
X896 VGND.t11 VPWR.t1646 VGND.t11 VGND.t1143 sg13_lv_nmos ad=0.1428p pd=1.52u as=0 ps=0 w=0.42u l=1u
X897 VGND.t907 VPWR.t1701 VGND.t907 VGND.t908 sg13_lv_nmos ad=79.8f pd=0.8u as=0 ps=0 w=0.42u l=1u
X898 a_4436_9910# sg13cmos5l_buf_16_20.A VGND.t1 VGND.t216 sg13_lv_nmos ad=0.1406p pd=1.12u as=0.1406p ps=1.12u w=0.74u l=0.13u
X899 sg13cmos5l_xor2_1_0.B a_6094_3144# VGND.t41 VGND.t40 sg13_lv_nmos ad=0.1406p pd=1.12u as=0.1406p ps=1.12u w=0.74u l=0.13u
X900 VPWR.t1212 a_5518_6922# sg13cmos5l_buf_16_6.X VPWR.t5 sg13_lv_pmos ad=0.2128p pd=1.5u as=0.2128p ps=1.5u w=1.12u l=0.13u
X901 sg13cmos5l_buf_16_2.A a_9262_7680# VGND.t5 VGND.t7 sg13_lv_nmos ad=0.1406p pd=1.12u as=0.1406p ps=1.12u w=0.74u l=0.13u
X902 a_14252_9906# sg13cmos5l_and2_2_3.X VPWR.t56 VPWR.t55 sg13_lv_pmos ad=0.2856p pd=2.36u as=0.2114p ps=1.54u w=0.84u l=0.13u
X903 sg13cmos5l_buf_16_2.X a_10318_3898# VPWR.t202 VPWR.t28 sg13_lv_pmos ad=0.2128p pd=1.5u as=0.2128p ps=1.5u w=1.12u l=0.13u
X904 VGND.t315 sg13cmos5l_buf_16_37.A a_7796_12934# VGND.t318 sg13_lv_nmos ad=0.1406p pd=1.12u as=0.1406p ps=1.12u w=0.74u l=0.13u
X905 VGND.t222 VPWR.t1622 VGND.t222 VGND.t1214 sg13_lv_nmos ad=79.8f pd=0.8u as=0 ps=0 w=0.42u l=1u
X906 VPWR.t161 a_4462_5410# sg13cmos5l_buf_16_11.A VPWR.t70 sg13_lv_pmos ad=0.2128p pd=1.5u as=0.2128p ps=1.5u w=1.12u l=0.13u
X907 sg13cmos5l_buf_16_38.A a_8110_6168# VGND.t358 VGND.t552 sg13_lv_nmos ad=0.1406p pd=1.12u as=0.1406p ps=1.12u w=0.74u l=0.13u
X908 a_6094_10704# sg13cmos5l_buf_16_33.A VPWR.t1432 VPWR.t55 sg13_lv_pmos ad=0.2128p pd=1.5u as=0.3808p ps=2.92u w=1.12u l=0.13u
X909 VPWR.t360 VGND.t1060 VPWR.t357 VPWR.t55 sg13_lv_pmos ad=0.19p pd=1.38u as=0 ps=0 w=1u l=1u
X910 a_10292_4620# sg13cmos5l_buf_16_2.X VGND.t82 VGND.t124 sg13_lv_nmos ad=0.1406p pd=1.12u as=0.1406p ps=1.12u w=0.74u l=0.13u
X911 VGND.t358 VPWR.t1641 VGND.t358 VGND.t1162 sg13_lv_nmos ad=79.8f pd=0.8u as=0 ps=0 w=0.42u l=1u
X912 VPWR.t1106 VGND.t11 VPWR.t1105 VPWR.t5 sg13_lv_pmos ad=0.34p pd=2.68u as=0 ps=0 w=1u l=1u
X913 VPWR.t342 VGND.t806 VPWR.t342 VPWR.t5 sg13_lv_pmos ad=0.19p pd=1.38u as=0 ps=0 w=1u l=1u
X914 a_3694_2386# sg13cmos5l_buf_16_7.A VPWR.t274 VPWR.t20 sg13_lv_pmos ad=0.2128p pd=1.5u as=0.3808p ps=2.92u w=1.12u l=0.13u
X915 VGND.t150 a_3694_2386# sg13cmos5l_buf_16_7.X VGND.t477 sg13_lv_nmos ad=0.1406p pd=1.12u as=0.1406p ps=1.12u w=0.74u l=0.13u
X916 VPWR.t288 VGND.t1306 VPWR.t288 VPWR.t20 sg13_lv_pmos ad=0.19p pd=1.38u as=0 ps=0 w=1u l=1u
X917 sg13cmos5l_buf_16_6.X a_5518_6922# VPWR.t672 VPWR.t5 sg13_lv_pmos ad=0.2128p pd=1.5u as=0.2128p ps=1.5u w=1.12u l=0.13u
X918 VPWR.t202 a_10318_3898# sg13cmos5l_buf_16_2.X VPWR.t28 sg13_lv_pmos ad=0.2128p pd=1.5u as=0.2128p ps=1.5u w=1.12u l=0.13u
X919 a_5684_6132# sg13cmos5l_buf_16_28.A VGND.t358 VGND.t421 sg13_lv_nmos ad=0.1406p pd=1.12u as=0.1406p ps=1.12u w=0.74u l=0.13u
X920 a_10318_3898# sg13cmos5l_buf_16_2.A VGND.t112 VGND.t40 sg13_lv_nmos ad=0.1406p pd=1.12u as=0.1406p ps=1.12u w=0.74u l=0.13u
X921 sg13cmos5l_buf_16_33.A a_3694_14482# VGND.t942 VGND.t1512 sg13_lv_nmos ad=0.1406p pd=1.12u as=0.1406p ps=1.12u w=0.74u l=0.13u
X922 VPWR.t30 VGND.t130 VPWR.t288 VPWR.t20 sg13_lv_pmos ad=0.34p pd=2.68u as=0 ps=0 w=1u l=1u
X923 VPWR.t201 sg13cmos5l_buf_1_4.A a_14824_6956# VPWR.t5 sg13_lv_pmos ad=0.2114p pd=1.54u as=0.2856p ps=2.36u w=0.84u l=0.13u
X924 VPWR.t171 a_6094_3144# sg13cmos5l_xor2_1_0.B VPWR.t20 sg13_lv_pmos ad=0.2128p pd=1.5u as=0.2128p ps=1.5u w=1.12u l=0.13u
X925 sg13cmos5l_and2_2_6.B a_7432_14516# VGND.t915 VGND.t1524 sg13_lv_nmos ad=0.2886p pd=2.26u as=0.14875p ps=1.16u w=0.74u l=0.13u
X926 VPWR.t19 VGND.t1376 VPWR.t19 VPWR.t0 sg13_lv_pmos ad=0.19p pd=1.38u as=0 ps=0 w=1u l=1u
X927 VGND.t157 VPWR.t904 VGND.t157 VGND.t156 sg13_lv_nmos ad=0.1428p pd=1.52u as=0 ps=0 w=0.42u l=1u
X928 sg13cmos5l_and2_2_3.X a_13581_9988# VPWR.t56 VPWR.t55 sg13_lv_pmos ad=0.2128p pd=1.5u as=0.1918p ps=1.5u w=1.12u l=0.13u
X929 VGND.t315 a_7796_12934# sg13cmos5l_buf_16_37.X VGND.t622 sg13_lv_nmos ad=0.1406p pd=1.12u as=0.1406p ps=1.12u w=0.74u l=0.13u
X930 VGND.t350 sg13cmos5l_buf_16_33.A a_6094_10704# VGND.t156 sg13_lv_nmos ad=0.1406p pd=1.12u as=0.1406p ps=1.12u w=0.74u l=0.13u
X931 VGND.t1079 VPWR.t905 VGND.t1079 VGND.t1083 sg13_lv_nmos ad=79.8f pd=0.8u as=0 ps=0 w=0.42u l=1u
X932 a_6426_9550# sg13cmos5l_buf_16_14.A VGND.t1 VGND.t663 sg13_lv_nmos ad=88.8f pd=0.98u as=0.15245p ps=1.17u w=0.74u l=0.13u
X933 a_6164_2350# sg13cmos5l_buf_16_39.A VPWR.t808 VPWR.t20 sg13_lv_pmos ad=0.2128p pd=1.5u as=0.2128p ps=1.5u w=1.12u l=0.13u
X934 VGND.t358 sg13cmos5l_buf_16_28.A a_5684_6132# VGND.t418 sg13_lv_nmos ad=0.1406p pd=1.12u as=0.1406p ps=1.12u w=0.74u l=0.13u
X935 sg13cmos5l_buf_16_18.A a_4174_13728# VGND.t942 VGND.t1455 sg13_lv_nmos ad=0.1406p pd=1.12u as=0.1406p ps=1.12u w=0.74u l=0.13u
X936 sg13cmos5l_buf_16_18.A a_4174_13728# VGND.t912 VGND.t1467 sg13_lv_nmos ad=0.1406p pd=1.12u as=0.1406p ps=1.12u w=0.74u l=0.13u
X937 VGND.t23 a_4462_5410# sg13cmos5l_buf_16_11.A VGND.t24 sg13_lv_nmos ad=0.1406p pd=1.12u as=0.1406p ps=1.12u w=0.74u l=0.13u
X938 VPWR.t687 a_6094_10704# sg13cmos5l_buf_16_24.A VPWR.t55 sg13_lv_pmos ad=0.2128p pd=1.5u as=0.2128p ps=1.5u w=1.12u l=0.13u
X939 a_3875_5396# sg13cmos5l_and2_2_0.B VPWR.t727 VPWR.t70 sg13_lv_pmos ad=0.1596p pd=1.22u as=0.1918p ps=1.5u w=0.84u l=0.13u
X940 VPWR.t1 VGND.t1302 VPWR.t1 VPWR.t0 sg13_lv_pmos ad=0.19p pd=1.38u as=0 ps=0 w=1u l=1u
X941 sg13cmos5l_and2_2_6.A a_3694_10704# VPWR.t824 VPWR.t55 sg13_lv_pmos ad=0.2128p pd=1.5u as=0.2128p ps=1.5u w=1.12u l=0.13u
X942 VPWR.t862 sg13cmos5l_buf_16_11.A a_3668_4620# VPWR.t28 sg13_lv_pmos ad=0.2128p pd=1.5u as=0.2128p ps=1.5u w=1.12u l=0.13u
X943 sg13cmos5l_buf_16_33.A a_3694_14482# VGND.t942 VGND.t1508 sg13_lv_nmos ad=0.1406p pd=1.12u as=0.1406p ps=1.12u w=0.74u l=0.13u
X944 VPWR.t357 VGND.t261 VPWR.t357 VPWR.t55 sg13_lv_pmos ad=0.34p pd=2.68u as=0 ps=0 w=1u l=1u
X945 VPWR.t284 VGND.t1361 VPWR.t284 VPWR.t0 sg13_lv_pmos ad=0.19p pd=1.38u as=0 ps=0 w=1u l=1u
X946 sg13cmos5l_buf_16_37.X a_7796_12934# VPWR.t926 VPWR.t8 sg13_lv_pmos ad=0.2128p pd=1.5u as=0.2128p ps=1.5u w=1.12u l=0.13u
X947 VGND.t491 a_5710_1632# sg13cmos5l_buf_16_5.A VGND.t877 sg13_lv_nmos ad=0.1406p pd=1.12u as=0.1406p ps=1.12u w=0.74u l=0.13u
X948 VGND.t1207 VPWR.t1625 VGND.t1207 VGND.t1208 sg13_lv_nmos ad=79.8f pd=0.8u as=0 ps=0 w=0.42u l=1u
X949 VGND.t1176 VPWR.t71 VGND.t1173 VGND.t1200 sg13_lv_nmos ad=0.1428p pd=1.52u as=0 ps=0 w=0.42u l=1u
X950 VGND.t330 VPWR.t292 VGND.t330 VGND.t928 sg13_lv_nmos ad=0.1428p pd=1.52u as=0 ps=0 w=0.42u l=1u
X951 VPWR.t136 a_9262_7680# sg13cmos5l_buf_16_2.A VPWR.t5 sg13_lv_pmos ad=0.2128p pd=1.5u as=0.2128p ps=1.5u w=1.12u l=0.13u
X952 VPWR.t517 sg13cmos5l_buf_16_20.A a_4436_9910# VPWR.t55 sg13_lv_pmos ad=0.2128p pd=1.5u as=0.2128p ps=1.5u w=1.12u l=0.13u
X953 VGND.t27 a_6094_4656# sg13cmos5l_buf_16_31.X VGND.t442 sg13_lv_nmos ad=0.1406p pd=1.12u as=0.1406p ps=1.12u w=0.74u l=0.13u
X954 a_4174_13728# sg13cmos5l_and2_2_1.X VGND.t942 VGND.t1476 sg13_lv_nmos ad=0.1406p pd=1.12u as=0.1406p ps=1.12u w=0.74u l=0.13u
X955 VPWR.t322 VGND.t999 VPWR.t321 VPWR.t13 sg13_lv_pmos ad=0.34p pd=2.68u as=0 ps=0 w=1u l=1u
X956 VGND.t332 VPWR.t1682 VGND.t958 VGND.t959 sg13_lv_nmos ad=0.1428p pd=1.52u as=0 ps=0 w=0.42u l=1u
X957 VGND.t377 VPWR.t118 VGND.t377 VGND.t156 sg13_lv_nmos ad=79.8f pd=0.8u as=0 ps=0 w=0.42u l=1u
X958 a_3694_8434# sg13cmos5l_buf_16_13.A VGND.t275 VGND.t277 sg13_lv_nmos ad=0.1406p pd=1.12u as=0.1406p ps=1.12u w=0.74u l=0.13u
X959 VPWR.t357 VGND.t377 VPWR.t357 VPWR.t55 sg13_lv_pmos ad=0.19p pd=1.38u as=0 ps=0 w=1u l=1u
X960 sg13cmos5l_buf_16_35.A a_6766_8434# VGND.t11 VGND.t1565 sg13_lv_nmos ad=0.1406p pd=1.12u as=0.1406p ps=1.12u w=0.74u l=0.13u
X961 sg13cmos5l_buf_16_0.A a_6094_3898# VPWR.t530 VPWR.t28 sg13_lv_pmos ad=0.2128p pd=1.5u as=0.2128p ps=1.5u w=1.12u l=0.13u
X962 VGND.t806 sg13cmos5l_buf_16_4.A a_9524_6886# VGND.t808 sg13_lv_nmos ad=0.2516p pd=2.16u as=0.1406p ps=1.12u w=0.74u l=0.13u
X963 sg13cmos5l_buf_16_2.A a_9262_7680# VPWR.t136 VPWR.t5 sg13_lv_pmos ad=0.2128p pd=1.5u as=0.2128p ps=1.5u w=1.12u l=0.13u
X964 VGND.t384 a_3694_10704# sg13cmos5l_and2_2_6.A VGND.t156 sg13_lv_nmos ad=0.1406p pd=1.12u as=0.1406p ps=1.12u w=0.74u l=0.13u
X965 VPWR.t281 VGND.t112 VPWR.t21 VPWR.t20 sg13_lv_pmos ad=0.34p pd=2.68u as=0 ps=0 w=1u l=1u
X966 a_6094_4656# sg13cmos5l_buf_16_7.X VGND.t27 VGND.t38 sg13_lv_nmos ad=0.1406p pd=1.12u as=0.1406p ps=1.12u w=0.74u l=0.13u
X967 a_3694_14482# sg13cmos5l_buf_16_15.X VGND.t942 VGND.t1503 sg13_lv_nmos ad=0.1406p pd=1.12u as=0.1406p ps=1.12u w=0.74u l=0.13u
X968 VPWR.t123 VGND.t315 VPWR.t118 VPWR.t13 sg13_lv_pmos ad=0.34p pd=2.68u as=0 ps=0 w=1u l=1u
X969 sg13cmos5l_buf_16_37.X a_7796_12934# VPWR.t922 VPWR.t8 sg13_lv_pmos ad=0.2128p pd=1.5u as=0.2128p ps=1.5u w=1.12u l=0.13u
X970 VGND.t1418 VPWR.t18 VGND.t1420 VGND.t1419 sg13_lv_nmos ad=79.8f pd=0.8u as=0 ps=0 w=0.42u l=1u
X971 VPWR.t775 a_3668_4620# sg13cmos5l_buf_16_8.A VPWR.t28 sg13_lv_pmos ad=0.2128p pd=1.5u as=0.2128p ps=1.5u w=1.12u l=0.13u
X972 sg13cmos5l_buf_16_11.A a_4462_5410# VPWR.t153 VPWR.t70 sg13_lv_pmos ad=0.2128p pd=1.5u as=0.2128p ps=1.5u w=1.12u l=0.13u
X973 sg13cmos5l_buf_16_24.X a_6862_9946# VGND.t1 VGND.t105 sg13_lv_nmos ad=0.1406p pd=1.12u as=0.1406p ps=1.12u w=0.74u l=0.13u
X974 a_8494_3144# sg13cmos5l_buf_16_0.A VGND.t92 VGND.t40 sg13_lv_nmos ad=0.1406p pd=1.12u as=0.1406p ps=1.12u w=0.74u l=0.13u
X975 VPWR.t71 sg13cmos5l_buf_1_5.A a_13768_5444# VPWR.t70 sg13_lv_pmos ad=0.2114p pd=1.54u as=0.2856p ps=2.36u w=0.84u l=0.13u
X976 VGND.t358 VPWR.t1640 VGND.t358 VGND.t1164 sg13_lv_nmos ad=79.8f pd=0.8u as=0 ps=0 w=0.42u l=1u
X977 VPWR.t1110 VGND.t11 VPWR.t1109 VPWR.t5 sg13_lv_pmos ad=0.34p pd=2.68u as=0 ps=0 w=1u l=1u
X978 VGND.t11 a_6766_8434# sg13cmos5l_buf_16_35.A VGND.t1562 sg13_lv_nmos ad=0.1406p pd=1.12u as=0.1406p ps=1.12u w=0.74u l=0.13u
X979 VPWR.t1426 enable a_6094_3898# VPWR.t28 sg13_lv_pmos ad=0.2128p pd=1.5u as=0.2128p ps=1.5u w=1.12u l=0.13u
X980 sg13cmos5l_and2_2_2.B a_5992_14516# VGND.t912 VGND.t1505 sg13_lv_nmos ad=0.2886p pd=2.26u as=0.14875p ps=1.16u w=0.74u l=0.13u
X981 VPWR.t304 VGND.t573 VPWR.t304 VPWR.t13 sg13_lv_pmos ad=0.34p pd=2.68u as=0 ps=0 w=1u l=1u
X982 VPWR.t136 a_9262_7680# sg13cmos5l_buf_16_2.A VPWR.t5 sg13_lv_pmos ad=0.2128p pd=1.5u as=0.2128p ps=1.5u w=1.12u l=0.13u
X983 a_4174_13728# sg13cmos5l_and2_2_1.X VGND.t942 VGND.t1472 sg13_lv_nmos ad=0.1406p pd=1.12u as=0.2516p ps=2.16u w=0.74u l=0.13u
X984 VGND.t491 sg13cmos5l_buf_16_30.A a_5710_1632# VGND.t858 sg13_lv_nmos ad=0.1406p pd=1.12u as=0.1406p ps=1.12u w=0.74u l=0.13u
X985 VGND.t504 sg13cmos5l_buf_16_39.A a_6164_2350# VGND.t1570 sg13_lv_nmos ad=0.1406p pd=1.12u as=0.1406p ps=1.12u w=0.74u l=0.13u
X986 VGND.t222 VPWR.t1622 VGND.t1207 VGND.t1213 sg13_lv_nmos ad=0.1428p pd=1.52u as=0 ps=0 w=0.42u l=1u
X987 VGND.t358 a_5684_6132# sg13cmos5l_buf_16_28.X VGND.t840 sg13_lv_nmos ad=0.1406p pd=1.12u as=0.1406p ps=1.12u w=0.74u l=0.13u
X988 a_5108_838# sg13cmos5l_buf_16_5.A VGND.t860 VGND.t864 sg13_lv_nmos ad=0.1406p pd=1.12u as=0.1406p ps=1.12u w=0.74u l=0.13u
X989 a_10292_12934# sg13cmos5l_buf_1_17.A VPWR.t631 VPWR.t8 sg13_lv_pmos ad=0.2128p pd=1.5u as=0.2128p ps=1.5u w=1.12u l=0.13u
X990 a_6094_3144# sg13cmos5l_buf_16_5.X VPWR.t898 VPWR.t20 sg13_lv_pmos ad=0.2128p pd=1.5u as=0.2128p ps=1.5u w=1.12u l=0.13u
X991 sg13cmos5l_buf_16_35.A a_6766_8434# VGND.t11 VGND.t1559 sg13_lv_nmos ad=0.1406p pd=1.12u as=0.1406p ps=1.12u w=0.74u l=0.13u
X992 VGND.t384 a_3694_10704# sg13cmos5l_and2_2_6.A VGND.t156 sg13_lv_nmos ad=0.1406p pd=1.12u as=0.1406p ps=1.12u w=0.74u l=0.13u
X993 a_6094_3898# enable VPWR.t1423 VPWR.t28 sg13_lv_pmos ad=0.2128p pd=1.5u as=0.3808p ps=2.92u w=1.12u l=0.13u
X994 VGND.t860 a_5108_838# sg13cmos5l_buf_16_5.X VGND.t1449 sg13_lv_nmos ad=0.1406p pd=1.12u as=0.1406p ps=1.12u w=0.74u l=0.13u
X995 a_6548_13692# sg13cmos5l_buf_16_37.X VPWR.t1257 VPWR.t8 sg13_lv_pmos ad=0.2128p pd=1.5u as=0.2128p ps=1.5u w=1.12u l=0.13u
X996 VGND.t126 a_10318_5410# sg13cmos5l_buf_16_1.X VGND.t128 sg13_lv_nmos ad=0.2516p pd=2.16u as=0.1406p ps=1.12u w=0.74u l=0.13u
X997 VPWR.t1130 sg13cmos5l_buf_16_13.A a_3694_8434# VPWR.t3 sg13_lv_pmos ad=0.2128p pd=1.5u as=0.2128p ps=1.5u w=1.12u l=0.13u
X998 VGND.t851 sg13cmos5l_buf_1_5.X a_14824_5444# VGND.t852 sg13_lv_nmos ad=0.14875p pd=1.16u as=0.187p ps=1.78u w=0.55u l=0.13u
X999 VPWR.t73 VGND.t70 VPWR.t73 VPWR.t70 sg13_lv_pmos ad=0.34p pd=2.68u as=0 ps=0 w=1u l=1u
X1000 VPWR.t802 a_6164_2350# sg13cmos5l_buf_16_30.A VPWR.t20 sg13_lv_pmos ad=0.2128p pd=1.5u as=0.2128p ps=1.5u w=1.12u l=0.13u
X1001 VGND.t1153 VPWR.t1643 VGND.t358 VGND.t1158 sg13_lv_nmos ad=79.8f pd=0.8u as=0 ps=0 w=0.42u l=1u
X1002 VPWR.t189 a_6766_8434# sg13cmos5l_buf_16_35.A VPWR.t3 sg13_lv_pmos ad=0.3976p pd=2.95u as=0.2128p ps=1.5u w=1.12u l=0.13u
X1003 sg13cmos5l_buf_16_28.X a_5684_6132# VPWR.t1373 VPWR.t70 sg13_lv_pmos ad=0.2128p pd=1.5u as=0.2128p ps=1.5u w=1.12u l=0.13u
X1004 VGND.t116 sg13cmos5l_xor2_1_5.X a_14344_8468# VGND.t163 sg13_lv_nmos ad=0.14875p pd=1.16u as=0.187p ps=1.78u w=0.55u l=0.13u
X1005 VGND.t358 VPWR.t1632 VGND.t358 VGND.t1162 sg13_lv_nmos ad=79.8f pd=0.8u as=0 ps=0 w=0.42u l=1u
X1006 sg13cmos5l_buf_16_1.X a_10318_5410# VGND.t82 VGND.t124 sg13_lv_nmos ad=0.1406p pd=1.12u as=0.1406p ps=1.12u w=0.74u l=0.13u
X1007 a_3694_8434# sg13cmos5l_buf_16_13.A VPWR.t1127 VPWR.t3 sg13_lv_pmos ad=0.2128p pd=1.5u as=0.3808p ps=2.92u w=1.12u l=0.13u
X1008 VGND.t207 a_3694_3898# sg13cmos5l_buf_16_10.A VGND.t40 sg13_lv_nmos ad=0.1406p pd=1.12u as=0.1406p ps=1.12u w=0.74u l=0.13u
X1009 VPWR.t136 a_9524_6886# sg13cmos5l_buf_16_4.X VPWR.t5 sg13_lv_pmos ad=0.2128p pd=1.5u as=0.2128p ps=1.5u w=1.12u l=0.13u
X1010 VGND.t275 sg13cmos5l_buf_16_34.A a_3694_7680# VGND.t276 sg13_lv_nmos ad=0.1406p pd=1.12u as=0.1406p ps=1.12u w=0.74u l=0.13u
X1011 sg13cmos5l_buf_16_23.X a_10292_12934# VPWR.t631 VPWR.t8 sg13_lv_pmos ad=0.2128p pd=1.5u as=0.2128p ps=1.5u w=1.12u l=0.13u
X1012 a_3668_9156# sg13cmos5l_buf_16_14.A VPWR.t1206 VPWR.t3 sg13_lv_pmos ad=0.2128p pd=1.5u as=0.2128p ps=1.5u w=1.12u l=0.13u
X1013 sg13cmos5l_buf_16_35.A a_6766_8434# VPWR.t189 VPWR.t3 sg13_lv_pmos ad=0.2128p pd=1.5u as=0.2128p ps=1.5u w=1.12u l=0.13u
X1014 VGND.t322 sg13cmos5l_buf_1_17.A a_12232_12216# VGND.t321 sg13_lv_nmos ad=0.14875p pd=1.16u as=0.187p ps=1.78u w=0.55u l=0.13u
X1015 a_5108_838# sg13cmos5l_buf_16_5.A VPWR.t19 VPWR.t0 sg13_lv_pmos ad=0.2128p pd=1.5u as=0.2128p ps=1.5u w=1.12u l=0.13u
X1016 sg13cmos5l_buf_16_27.X a_6548_13692# VPWR.t1488 VPWR.t8 sg13_lv_pmos ad=0.2128p pd=1.5u as=0.2128p ps=1.5u w=1.12u l=0.13u
X1017 VGND.t282 a_7220_5374# sg13cmos5l_buf_16_28.A VGND.t293 sg13_lv_nmos ad=0.1406p pd=1.12u as=0.1406p ps=1.12u w=0.74u l=0.13u
X1018 VGND.t358 sg13cmos5l_buf_16_31.X a_4721_6526# VGND.t1531 sg13_lv_nmos ad=0.15245p pd=1.17u as=0.17462p ps=1.185u w=0.55u l=0.13u
X1019 VPWR.t319 VGND.t806 VPWR.t319 VPWR.t70 sg13_lv_pmos ad=0.34p pd=2.68u as=0 ps=0 w=1u l=1u
X1020 VPWR.t660 a_5204_11422# sg13cmos5l_buf_16_20.A VPWR.t13 sg13_lv_pmos ad=0.2128p pd=1.5u as=0.2128p ps=1.5u w=1.12u l=0.13u
X1021 VGND.t41 a_6094_3898# sg13cmos5l_buf_16_0.A VGND.t40 sg13_lv_nmos ad=0.1406p pd=1.12u as=0.1406p ps=1.12u w=0.74u l=0.13u
X1022 VPWR.t71 VGND.t851 VPWR.t73 VPWR.t70 sg13_lv_pmos ad=0.34p pd=2.68u as=0 ps=0 w=1u l=1u
X1023 VGND.t261 VPWR.t189 VGND.t261 VGND.t1072 sg13_lv_nmos ad=79.8f pd=0.8u as=0 ps=0 w=0.42u l=1u
X1024 sg13cmos5l_buf_16_10.A a_3694_3898# VGND.t207 VGND.t40 sg13_lv_nmos ad=0.1406p pd=1.12u as=0.1406p ps=1.12u w=0.74u l=0.13u
X1025 VGND.t1 a_6836_9156# sg13cmos5l_buf_16_25.A VGND.t104 sg13_lv_nmos ad=0.1406p pd=1.12u as=0.1406p ps=1.12u w=0.74u l=0.13u
X1026 VPWR.t1025 VGND.t584 VPWR.t1025 VPWR.t0 sg13_lv_pmos ad=0.34p pd=2.68u as=0 ps=0 w=1u l=1u
X1027 sg13cmos5l_buf_16_4.X a_9524_6886# VPWR.t136 VPWR.t5 sg13_lv_pmos ad=0.2128p pd=1.5u as=0.2128p ps=1.5u w=1.12u l=0.13u
X1028 a_10292_4620# sg13cmos5l_buf_16_2.X VPWR.t202 VPWR.t28 sg13_lv_pmos ad=0.2128p pd=1.5u as=0.2128p ps=1.5u w=1.12u l=0.13u
X1029 a_10318_8434# sg13cmos5l_buf_16_1.X VGND.t11 VGND.t61 sg13_lv_nmos ad=0.1406p pd=1.12u as=0.1406p ps=1.12u w=0.74u l=0.13u
X1030 VPWR.t294 VGND.t871 VPWR.t293 VPWR.t292 sg13_lv_pmos ad=0.34p pd=2.68u as=0 ps=0 w=1u l=1u
X1031 sg13cmos5l_buf_16_5.A a_5710_1632# VPWR.t19 VPWR.t0 sg13_lv_pmos ad=0.2128p pd=1.5u as=0.2128p ps=1.5u w=1.12u l=0.13u
X1032 VPWR.t1 VGND.t1296 VPWR.t24 VPWR.t0 sg13_lv_pmos ad=0.19p pd=1.38u as=0 ps=0 w=1u l=1u
X1033 VPWR.t19 a_5108_838# sg13cmos5l_buf_16_5.X VPWR.t0 sg13_lv_pmos ad=0.2128p pd=1.5u as=0.2128p ps=1.5u w=1.12u l=0.13u
X1034 sg13cmos5l_buf_16_28.A a_7220_5374# VGND.t282 VGND.t290 sg13_lv_nmos ad=0.1406p pd=1.12u as=0.1406p ps=1.12u w=0.74u l=0.13u
X1035 sg13cmos5l_buf_16_28.X a_5684_6132# VPWR.t1369 VPWR.t70 sg13_lv_pmos ad=0.2128p pd=1.5u as=0.2128p ps=1.5u w=1.12u l=0.13u
X1036 VGND.t11 a_9262_7680# sg13cmos5l_buf_16_2.A VGND.t21 sg13_lv_nmos ad=0.2516p pd=2.16u as=0.1406p ps=1.12u w=0.74u l=0.13u
X1037 VGND.t1403 VPWR.t1 VGND.t1402 VGND.t1401 sg13_lv_nmos ad=0.1428p pd=1.52u as=0 ps=0 w=0.42u l=1u
X1038 VPWR.t281 VGND.t130 VPWR.t281 VPWR.t20 sg13_lv_pmos ad=0.34p pd=2.68u as=0 ps=0 w=1u l=1u
X1039 sg13cmos5l_buf_16_23.X a_10292_12934# VPWR.t631 VPWR.t8 sg13_lv_pmos ad=0.2128p pd=1.5u as=0.2128p ps=1.5u w=1.12u l=0.13u
X1040 VGND.t866 sg13cmos5l_buf_16_5.A a_5108_838# VGND.t865 sg13_lv_nmos ad=0.2516p pd=2.16u as=0.1406p ps=1.12u w=0.74u l=0.13u
X1041 VPWR.t647 a_3668_12180# sg13cmos5l_buf_16_15.X VPWR.t13 sg13_lv_pmos ad=0.2128p pd=1.5u as=0.2128p ps=1.5u w=1.12u l=0.13u
X1042 VPWR.t659 a_3668_12180# sg13cmos5l_buf_16_15.X VPWR.t13 sg13_lv_pmos ad=0.2128p pd=1.5u as=0.2128p ps=1.5u w=1.12u l=0.13u
X1043 sg13cmos5l_buf_16_25.A a_6836_9156# VGND.t1 VGND.t101 sg13_lv_nmos ad=0.1406p pd=1.12u as=0.1406p ps=1.12u w=0.74u l=0.13u
X1044 VPWR.t202 sg13cmos5l_buf_16_2.X a_10292_4620# VPWR.t28 sg13_lv_pmos ad=0.2128p pd=1.5u as=0.2128p ps=1.5u w=1.12u l=0.13u
X1045 VPWR.t18 VGND.t868 VPWR.t18 VPWR.t0 sg13_lv_pmos ad=0.34p pd=2.68u as=0 ps=0 w=1u l=1u
X1046 VPWR.t70 a_7220_5374# sg13cmos5l_buf_16_28.A VPWR.t70 sg13_lv_pmos ad=0.2128p pd=1.5u as=0.2128p ps=1.5u w=1.12u l=0.13u
X1047 VGND.t652 VPWR.t130 VGND.t322 VGND.t991 sg13_lv_nmos ad=79.8f pd=0.8u as=0 ps=0 w=0.42u l=1u
X1048 VGND.t1 sg13cmos5l_buf_16_24.A a_6862_9946# VGND.t98 sg13_lv_nmos ad=0.1406p pd=1.12u as=0.1406p ps=1.12u w=0.74u l=0.13u
X1049 a_3020_14442# glitch_en[1] VPWR.t1429 VPWR.t292 sg13_lv_pmos ad=0.2856p pd=2.36u as=0.2114p ps=1.54u w=0.84u l=0.13u
X1050 VPWR.t1297 a_5204_11422# sg13cmos5l_buf_16_20.A VPWR.t13 sg13_lv_pmos ad=0.2128p pd=1.5u as=0.2128p ps=1.5u w=1.12u l=0.13u
X1051 sg13cmos5l_buf_16_24.X a_6862_9946# VPWR.t550 VPWR.t55 sg13_lv_pmos ad=0.2128p pd=1.5u as=0.2128p ps=1.5u w=1.12u l=0.13u
X1052 VGND.t1060 VPWR.t360 VGND.t1079 VGND.t1078 sg13_lv_nmos ad=79.8f pd=0.8u as=0 ps=0 w=0.42u l=1u
X1053 a_5108_838# sg13cmos5l_buf_16_5.A VGND.t860 VGND.t859 sg13_lv_nmos ad=0.1406p pd=1.12u as=0.1406p ps=1.12u w=0.74u l=0.13u
X1054 sg13cmos5l_buf_16_5.X a_5108_838# VPWR.t19 VPWR.t0 sg13_lv_pmos ad=0.2128p pd=1.5u as=0.2128p ps=1.5u w=1.12u l=0.13u
X1055 sg13cmos5l_buf_16_38.A a_8110_6168# VGND.t358 VGND.t540 sg13_lv_nmos ad=0.1406p pd=1.12u as=0.1406p ps=1.12u w=0.74u l=0.13u
X1056 VPWR.t373 VGND.t1060 VPWR.t371 VPWR.t3 sg13_lv_pmos ad=0.19p pd=1.38u as=0 ps=0 w=1u l=1u
X1057 VGND.t130 sg13cmos5l_buf_1_6.A a_13768_3932# VGND.t40 sg13_lv_nmos ad=0.14875p pd=1.16u as=0.187p ps=1.78u w=0.55u l=0.13u
X1058 VGND.t11 VPWR.t1657 VGND.t11 VGND.t1112 sg13_lv_nmos ad=0.1428p pd=1.52u as=0 ps=0 w=0.42u l=1u
X1059 sg13cmos5l_buf_16_28.A a_7220_5374# VPWR.t610 VPWR.t70 sg13_lv_pmos ad=0.2128p pd=1.5u as=0.2128p ps=1.5u w=1.12u l=0.13u
X1060 sg13cmos5l_buf_16_20.A a_5204_11422# VGND.t350 VGND.t156 sg13_lv_nmos ad=0.1406p pd=1.12u as=0.1406p ps=1.12u w=0.74u l=0.13u
X1061 VPWR.t342 VGND.t806 VPWR.t318 VPWR.t5 sg13_lv_pmos ad=0.34p pd=2.68u as=0 ps=0 w=1u l=1u
X1062 a_10318_8434# sg13cmos5l_buf_16_1.X VGND.t5 VGND.t57 sg13_lv_nmos ad=0.1406p pd=1.12u as=0.2516p ps=2.16u w=0.74u l=0.13u
X1063 VGND.t1423 VPWR.t18 VGND.t1425 VGND.t1424 sg13_lv_nmos ad=79.8f pd=0.8u as=0 ps=0 w=0.42u l=1u
X1064 VGND.t1 sg13cmos5l_and2_2_6.A a_6161_9550# VGND.t0 sg13_lv_nmos ad=0.15245p pd=1.17u as=0.17462p ps=1.185u w=0.55u l=0.13u
X1065 VPWR.t0 VGND.t1351 VPWR.t0 VPWR.t0 sg13_lv_pmos ad=0.19p pd=1.38u as=0 ps=0 w=1u l=1u
X1066 VPWR.t190 sg13cmos5l_buf_16_1.X a_10318_8434# VPWR.t3 sg13_lv_pmos ad=0.2128p pd=1.5u as=0.2128p ps=1.5u w=1.12u l=0.13u
X1067 VGND.t1398 VPWR.t1 VGND.t1397 VGND.t1396 sg13_lv_nmos ad=0.1428p pd=1.52u as=0 ps=0 w=0.42u l=1u
X1068 VPWR.t34 sg13cmos5l_buf_1_1.A a_14824_3144# VPWR.t20 sg13_lv_pmos ad=0.2114p pd=1.54u as=0.2856p ps=2.36u w=0.84u l=0.13u
X1069 VGND.t358 VPWR.t1642 VGND.t358 VGND.t1160 sg13_lv_nmos ad=79.8f pd=0.8u as=0 ps=0 w=0.42u l=1u
X1070 a_3668_9156# sg13cmos5l_buf_16_14.A VPWR.t488 VPWR.t3 sg13_lv_pmos ad=0.2128p pd=1.5u as=0.2128p ps=1.5u w=1.12u l=0.13u
X1071 VPWR.t608 a_7220_5374# sg13cmos5l_buf_16_28.A VPWR.t70 sg13_lv_pmos ad=0.2128p pd=1.5u as=0.2128p ps=1.5u w=1.12u l=0.13u
X1072 sg13cmos5l_buf_16_24.X a_6862_9946# VPWR.t547 VPWR.t55 sg13_lv_pmos ad=0.2128p pd=1.5u as=0.2128p ps=1.5u w=1.12u l=0.13u
X1073 sg13cmos5l_buf_16_11.A a_4462_5410# VGND.t27 VGND.t38 sg13_lv_nmos ad=0.1406p pd=1.12u as=0.1406p ps=1.12u w=0.74u l=0.13u
X1074 VGND.t639 VPWR.t911 VGND.t639 VGND.t930 sg13_lv_nmos ad=0.1428p pd=1.52u as=0 ps=0 w=0.42u l=1u
X1075 VGND.t207 a_3668_3108# sg13cmos5l_buf_16_7.A VGND.t40 sg13_lv_nmos ad=0.1406p pd=1.12u as=0.1406p ps=1.12u w=0.74u l=0.13u
X1076 a_8110_6168# sg13cmos5l_buf_16_35.A VGND.t358 VGND.t1547 sg13_lv_nmos ad=0.1406p pd=1.12u as=0.1406p ps=1.12u w=0.74u l=0.13u
X1077 VPWR.t21 sg13cmos5l_buf_16_39.A a_8990_2704# VPWR.t20 sg13_lv_pmos ad=0.36p pd=2.72u as=0.1225p ps=1.245u w=1u l=0.13u
X1078 VGND.t130 a_10318_3898# sg13cmos5l_buf_16_2.X VGND.t40 sg13_lv_nmos ad=0.1406p pd=1.12u as=0.1406p ps=1.12u w=0.74u l=0.13u
X1079 VPWR.t1433 sg13cmos5l_buf_16_33.A a_6094_10704# VPWR.t55 sg13_lv_pmos ad=0.2128p pd=1.5u as=0.2128p ps=1.5u w=1.12u l=0.13u
X1080 VGND.t244 VPWR.t450 VGND.t244 VGND.t40 sg13_lv_nmos ad=0.1428p pd=1.52u as=0 ps=0 w=0.42u l=1u
X1081 sg13cmos5l_buf_16_10.A a_3694_3898# VGND.t198 VGND.t40 sg13_lv_nmos ad=0.1406p pd=1.12u as=0.1406p ps=1.12u w=0.74u l=0.13u
X1082 sg13cmos5l_buf_16_18.A a_4174_13728# VPWR.t1458 VPWR.t8 sg13_lv_pmos ad=0.2128p pd=1.5u as=0.2128p ps=1.5u w=1.12u l=0.13u
X1083 sg13cmos5l_buf_16_18.A a_4174_13728# VPWR.t1470 VPWR.t8 sg13_lv_pmos ad=0.2128p pd=1.5u as=0.2128p ps=1.5u w=1.12u l=0.13u
X1084 a_9788_8728# sg13cmos5l_buf_16_6.X VPWR.t189 VPWR.t3 sg13_lv_pmos ad=0.2128p pd=1.5u as=0.2128p ps=1.5u w=1.12u l=0.13u
X1085 VGND.t150 a_3694_2386# sg13cmos5l_buf_16_7.X VGND.t487 sg13_lv_nmos ad=0.1406p pd=1.12u as=0.1406p ps=1.12u w=0.74u l=0.13u
X1086 VPWR.t21 a_8494_3144# sg13cmos5l_buf_16_39.A VPWR.t20 sg13_lv_pmos ad=0.2128p pd=1.5u as=0.2128p ps=1.5u w=1.12u l=0.13u
X1087 sg13cmos5l_buf_16_7.X a_3694_2386# VPWR.t782 VPWR.t20 sg13_lv_pmos ad=0.2128p pd=1.5u as=0.2128p ps=1.5u w=1.12u l=0.13u
X1088 sg13cmos5l_buf_16_5.A a_5710_1632# VPWR.t19 VPWR.t0 sg13_lv_pmos ad=0.2128p pd=1.5u as=0.2128p ps=1.5u w=1.12u l=0.13u
X1089 VGND.t41 a_6094_3144# sg13cmos5l_xor2_1_0.B VGND.t40 sg13_lv_nmos ad=0.1406p pd=1.12u as=0.1406p ps=1.12u w=0.74u l=0.13u
X1090 VPWR.t1338 sg13cmos5l_and2_2_6.B a_7629_8028# VPWR.t5 sg13_lv_pmos ad=0.1918p pd=1.5u as=0.1596p ps=1.22u w=0.84u l=0.13u
X1091 VGND.t150 VPWR.t284 VGND.t150 VGND.t1287 sg13_lv_nmos ad=79.8f pd=0.8u as=0 ps=0 w=0.42u l=1u
X1092 sg13cmos5l_buf_16_7.A a_3668_3108# VGND.t207 VGND.t40 sg13_lv_nmos ad=0.1406p pd=1.12u as=0.1406p ps=1.12u w=0.74u l=0.13u
X1093 sg13cmos5l_buf_16_31.X a_6094_4656# VPWR.t744 VPWR.t28 sg13_lv_pmos ad=0.2128p pd=1.5u as=0.2128p ps=1.5u w=1.12u l=0.13u
X1094 VGND.t1374 VPWR.t19 VGND.t1376 VGND.t1375 sg13_lv_nmos ad=79.8f pd=0.8u as=0 ps=0 w=0.42u l=1u
X1095 VPWR.t71 VGND.t1173 VPWR.t71 VPWR.t70 sg13_lv_pmos ad=0.34p pd=2.68u as=0 ps=0 w=1u l=1u
X1096 VGND.t358 sg13cmos5l_buf_16_35.A a_8110_6168# VGND.t1544 sg13_lv_nmos ad=0.1406p pd=1.12u as=0.1406p ps=1.12u w=0.74u l=0.13u
X1097 sg13cmos5l_buf_16_2.X a_10318_3898# VGND.t130 VGND.t40 sg13_lv_nmos ad=0.1406p pd=1.12u as=0.1406p ps=1.12u w=0.74u l=0.13u
X1098 VPWR.t334 VGND.t999 VPWR.t332 VPWR.t55 sg13_lv_pmos ad=0.19p pd=1.38u as=0 ps=0 w=1u l=1u
X1099 sg13cmos5l_buf_16_25.A a_6836_9156# VGND.t1 VGND.t97 sg13_lv_nmos ad=0.1406p pd=1.12u as=0.1406p ps=1.12u w=0.74u l=0.13u
X1100 VGND.t1086 VPWR.t245 VGND.t1085 VGND.t1084 sg13_lv_nmos ad=0.1428p pd=1.52u as=0 ps=0 w=0.42u l=1u
X1101 VPWR.t190 sg13cmos5l_buf_16_1.X a_10318_8434# VPWR.t3 sg13_lv_pmos ad=0.2128p pd=1.5u as=0.2128p ps=1.5u w=1.12u l=0.13u
X1102 VPWR.t77 VGND.t1363 VPWR.t77 VPWR.t0 sg13_lv_pmos ad=0.34p pd=2.68u as=0 ps=0 w=1u l=1u
X1103 a_3668_12180# sg13cmos5l_buf_16_15.A VPWR.t812 VPWR.t13 sg13_lv_pmos ad=0.2128p pd=1.5u as=0.2128p ps=1.5u w=1.12u l=0.13u
X1104 VPWR.t780 a_3694_2386# sg13cmos5l_buf_16_7.X VPWR.t20 sg13_lv_pmos ad=0.2128p pd=1.5u as=0.2128p ps=1.5u w=1.12u l=0.13u
X1105 VGND.t1308 VPWR.t18 VGND.t1308 VGND.t1343 sg13_lv_nmos ad=0.1428p pd=1.52u as=0 ps=0 w=0.42u l=1u
X1106 VGND.t1153 VPWR.t1634 VGND.t358 VGND.t1158 sg13_lv_nmos ad=79.8f pd=0.8u as=0 ps=0 w=0.42u l=1u
X1107 VPWR.t868 sg13cmos5l_buf_16_7.X a_6094_4656# VPWR.t28 sg13_lv_pmos ad=0.2128p pd=1.5u as=0.2128p ps=1.5u w=1.12u l=0.13u
X1108 VPWR.t1218 a_5518_6922# sg13cmos5l_buf_16_6.X VPWR.t5 sg13_lv_pmos ad=0.2128p pd=1.5u as=0.2128p ps=1.5u w=1.12u l=0.13u
X1109 VGND.t912 a_4174_13728# sg13cmos5l_buf_16_18.A VGND.t1468 sg13_lv_nmos ad=0.2516p pd=2.16u as=0.1406p ps=1.12u w=0.74u l=0.13u
X1110 a_4174_13728# sg13cmos5l_and2_2_1.X VPWR.t1479 VPWR.t8 sg13_lv_pmos ad=0.2128p pd=1.5u as=0.2128p ps=1.5u w=1.12u l=0.13u
X1111 VPWR.t167 a_4462_5410# sg13cmos5l_buf_16_11.A VPWR.t70 sg13_lv_pmos ad=0.3976p pd=2.95u as=0.2128p ps=1.5u w=1.12u l=0.13u
X1112 VGND.t332 VPWR.t1689 VGND.t332 VGND.t960 sg13_lv_nmos ad=79.8f pd=0.8u as=0 ps=0 w=0.42u l=1u
X1113 VGND.t999 VPWR.t1669 VGND.t999 VGND.t156 sg13_lv_nmos ad=0.1428p pd=1.52u as=0 ps=0 w=0.42u l=1u
X1114 VGND.t1207 VPWR.t1629 VGND.t1207 VGND.t1209 sg13_lv_nmos ad=0.1428p pd=1.52u as=0 ps=0 w=0.42u l=1u
X1115 VGND.t150 a_3694_2386# sg13cmos5l_buf_16_7.X VGND.t483 sg13_lv_nmos ad=0.1406p pd=1.12u as=0.1406p ps=1.12u w=0.74u l=0.13u
X1116 VPWR.t576 VGND.t1153 VPWR.t574 VPWR.t5 sg13_lv_pmos ad=0.19p pd=1.38u as=0 ps=0 w=1u l=1u
X1117 VPWR.t826 a_3694_10704# sg13cmos5l_and2_2_6.A VPWR.t55 sg13_lv_pmos ad=0.2128p pd=1.5u as=0.2128p ps=1.5u w=1.12u l=0.13u
X1118 a_5710_1632# sg13cmos5l_buf_16_30.A VPWR.t19 VPWR.t0 sg13_lv_pmos ad=0.2128p pd=1.5u as=0.2128p ps=1.5u w=1.12u l=0.13u
X1119 VGND.t244 sg13cmos5l_buf_1_1.A a_14824_3144# VGND.t40 sg13_lv_nmos ad=0.14875p pd=1.16u as=0.187p ps=1.78u w=0.55u l=0.13u
X1120 VGND.t1153 VPWR.t1645 VGND.t1153 VGND.t1154 sg13_lv_nmos ad=79.8f pd=0.8u as=0 ps=0 w=0.42u l=1u
X1121 VPWR.t326 VGND.t999 VPWR.t325 VPWR.t13 sg13_lv_pmos ad=0.34p pd=2.68u as=0 ps=0 w=1u l=1u
X1122 a_6094_4656# sg13cmos5l_buf_16_7.X VPWR.t865 VPWR.t28 sg13_lv_pmos ad=0.2128p pd=1.5u as=0.3808p ps=2.92u w=1.12u l=0.13u
X1123 VGND.t377 VPWR.t1672 VGND.t377 VGND.t156 sg13_lv_nmos ad=0.1428p pd=1.52u as=0 ps=0 w=0.42u l=1u
X1124 VGND.t851 VPWR.t73 VGND.t851 VGND.t1222 sg13_lv_nmos ad=0.1428p pd=1.52u as=0 ps=0 w=0.42u l=1u
X1125 VPWR.t28 VGND.t72 VPWR.t28 VPWR.t28 sg13_lv_pmos ad=0.19p pd=1.38u as=0 ps=0 w=1u l=1u
X1126 sg13cmos5l_buf_16_13.A a_3668_9156# VGND.t165 VGND.t184 sg13_lv_nmos ad=0.1406p pd=1.12u as=0.1406p ps=1.12u w=0.74u l=0.13u
X1127 VPWR.t177 a_6094_3144# sg13cmos5l_xor2_1_0.B VPWR.t20 sg13_lv_pmos ad=0.2128p pd=1.5u as=0.2128p ps=1.5u w=1.12u l=0.13u
X1128 VPWR.t133 VGND.t322 VPWR.t131 VPWR.t13 sg13_lv_pmos ad=0.34p pd=2.68u as=0 ps=0 w=1u l=1u
X1129 sg13cmos5l_buf_16_37.X a_7796_12934# VGND.t315 VGND.t619 sg13_lv_nmos ad=0.1406p pd=1.12u as=0.1406p ps=1.12u w=0.74u l=0.13u
X1130 VPWR.t315 VGND.t1176 VPWR.t315 VPWR.t5 sg13_lv_pmos ad=0.34p pd=2.68u as=0 ps=0 w=1u l=1u
X1131 VGND.t282 a_6094_4656# sg13cmos5l_buf_16_31.X VGND.t452 sg13_lv_nmos ad=0.1406p pd=1.12u as=0.1406p ps=1.12u w=0.74u l=0.13u
X1132 VGND.t636 sg13cmos5l_buf_16_23.X a_8948_13692# VGND.t696 sg13_lv_nmos ad=0.1406p pd=1.12u as=0.1406p ps=1.12u w=0.74u l=0.13u
X1133 a_4174_13728# sg13cmos5l_and2_2_1.X VPWR.t1476 VPWR.t8 sg13_lv_pmos ad=0.2128p pd=1.5u as=0.3808p ps=2.92u w=1.12u l=0.13u
X1134 VGND.t315 a_10292_12934# sg13cmos5l_buf_16_23.X VGND.t641 sg13_lv_nmos ad=0.1406p pd=1.12u as=0.1406p ps=1.12u w=0.74u l=0.13u
X1135 VPWR.t292 VGND.t693 VPWR.t292 VPWR.t292 sg13_lv_pmos ad=0.34p pd=2.68u as=0 ps=0 w=1u l=1u
X1136 VGND.t942 VPWR.t1693 VGND.t941 VGND.t940 sg13_lv_nmos ad=0.1428p pd=1.52u as=0 ps=0 w=0.42u l=1u
X1137 sg13cmos5l_buf_16_37.A a_8948_13692# VGND.t693 VGND.t707 sg13_lv_nmos ad=0.1406p pd=1.12u as=0.1406p ps=1.12u w=0.74u l=0.13u
X1138 sg13cmos5l_buf_1_22.X a_14344_11492# VPWR.t304 VPWR.t13 sg13_lv_pmos ad=0.42p pd=2.99u as=0.2114p ps=1.54u w=1.12u l=0.13u
X1139 VPWR.t400 VGND.t358 VPWR.t400 VPWR.t70 sg13_lv_pmos ad=0.34p pd=2.68u as=0 ps=0 w=1u l=1u
X1140 sg13cmos5l_buf_16_0.A a_6094_3898# VPWR.t539 VPWR.t28 sg13_lv_pmos ad=0.2128p pd=1.5u as=0.2128p ps=1.5u w=1.12u l=0.13u
X1141 VGND.t261 VPWR.t357 VGND.t1060 VGND.t1074 sg13_lv_nmos ad=79.8f pd=0.8u as=0 ps=0 w=0.42u l=1u
X1142 VPWR.t822 a_3694_10704# sg13cmos5l_and2_2_6.A VPWR.t55 sg13_lv_pmos ad=0.2128p pd=1.5u as=0.2128p ps=1.5u w=1.12u l=0.13u
X1143 sg13cmos5l_buf_16_5.A a_5710_1632# VGND.t504 VGND.t886 sg13_lv_nmos ad=0.1406p pd=1.12u as=0.1406p ps=1.12u w=0.74u l=0.13u
X1144 sg13cmos5l_buf_16_7.A a_3668_3108# VGND.t198 VGND.t40 sg13_lv_nmos ad=0.1406p pd=1.12u as=0.1406p ps=1.12u w=0.74u l=0.13u
X1145 VPWR.t1517 a_3694_14482# sg13cmos5l_buf_16_33.A VPWR.t292 sg13_lv_pmos ad=0.2128p pd=1.5u as=0.2128p ps=1.5u w=1.12u l=0.13u
X1146 VPWR.t436 VGND.t358 VPWR.t434 VPWR.t70 sg13_lv_pmos ad=0.19p pd=1.38u as=0 ps=0 w=1u l=1u
X1147 a_11565_8028# sg13cmos5l_buf_16_6.X VPWR.t342 VPWR.t5 sg13_lv_pmos ad=0.1596p pd=1.22u as=0.2856p ps=2.36u w=0.84u l=0.13u
X1148 VPWR.t1102 VGND.t11 VPWR.t1101 VPWR.t5 sg13_lv_pmos ad=0.34p pd=2.68u as=0 ps=0 w=1u l=1u
X1149 VPWR.t94 VGND.t315 VPWR.t92 VPWR.t8 sg13_lv_pmos ad=0.19p pd=1.38u as=0 ps=0 w=1u l=1u
X1150 VGND.t358 VPWR.t1642 VGND.t358 VGND.t1159 sg13_lv_nmos ad=0.1428p pd=1.52u as=0 ps=0 w=0.42u l=1u
X1151 VGND.t157 sg13cmos5l_xor2_1_7.X a_14344_11492# VGND.t156 sg13_lv_nmos ad=0.14875p pd=1.16u as=0.187p ps=1.78u w=0.55u l=0.13u
X1152 VGND.t402 a_3694_8434# sg13cmos5l_buf_16_34.A VGND.t404 sg13_lv_nmos ad=0.1406p pd=1.12u as=0.1406p ps=1.12u w=0.74u l=0.13u
X1153 VGND.t693 a_8948_13692# sg13cmos5l_buf_16_37.A VGND.t714 sg13_lv_nmos ad=0.1406p pd=1.12u as=0.1406p ps=1.12u w=0.74u l=0.13u
X1154 VGND.t942 sg13cmos5l_and2_2_1.X a_4174_13728# VGND.t1473 sg13_lv_nmos ad=0.1406p pd=1.12u as=0.1406p ps=1.12u w=0.74u l=0.13u
X1155 VGND.t504 a_5710_1632# sg13cmos5l_buf_16_5.A VGND.t883 sg13_lv_nmos ad=0.1406p pd=1.12u as=0.1406p ps=1.12u w=0.74u l=0.13u
X1156 VGND.t282 a_6094_4656# sg13cmos5l_buf_16_31.X VGND.t448 sg13_lv_nmos ad=0.1406p pd=1.12u as=0.1406p ps=1.12u w=0.74u l=0.13u
X1157 sg13cmos5l_buf_16_37.A a_8948_13692# VGND.t693 VGND.t703 sg13_lv_nmos ad=0.1406p pd=1.12u as=0.1406p ps=1.12u w=0.74u l=0.13u
X1158 VPWR.t163 a_4462_5410# sg13cmos5l_buf_16_11.A VPWR.t70 sg13_lv_pmos ad=0.2128p pd=1.5u as=0.2128p ps=1.5u w=1.12u l=0.13u
X1159 VPWR.t492 a_3668_3108# sg13cmos5l_buf_16_7.A VPWR.t20 sg13_lv_pmos ad=0.2128p pd=1.5u as=0.2128p ps=1.5u w=1.12u l=0.13u
X1160 VGND.t1 a_6862_9946# sg13cmos5l_buf_16_24.X VGND.t258 sg13_lv_nmos ad=0.1406p pd=1.12u as=0.1406p ps=1.12u w=0.74u l=0.13u
X1161 sg13cmos5l_buf_16_34.A a_3694_8434# VGND.t275 VGND.t400 sg13_lv_nmos ad=0.1406p pd=1.12u as=0.1406p ps=1.12u w=0.74u l=0.13u
X1162 VPWR.t78 VGND.t1368 VPWR.t78 VPWR.t0 sg13_lv_pmos ad=0.34p pd=2.68u as=0 ps=0 w=1u l=1u
X1163 VGND.t112 a_8494_3144# sg13cmos5l_buf_16_39.A VGND.t40 sg13_lv_nmos ad=0.1406p pd=1.12u as=0.1406p ps=1.12u w=0.74u l=0.13u
X1164 a_10292_12934# sg13cmos5l_buf_1_17.A VGND.t322 VGND.t327 sg13_lv_nmos ad=0.1406p pd=1.12u as=0.1406p ps=1.12u w=0.74u l=0.13u
X1165 VPWR.t365 VGND.t1060 VPWR.t363 VPWR.t3 sg13_lv_pmos ad=0.19p pd=1.38u as=0 ps=0 w=1u l=1u
X1166 sg13cmos5l_buf_16_0.A a_6094_3898# VPWR.t535 VPWR.t28 sg13_lv_pmos ad=0.2128p pd=1.5u as=0.2128p ps=1.5u w=1.12u l=0.13u
X1167 VGND.t1207 VPWR.t1623 VGND.t1207 VGND.t1211 sg13_lv_nmos ad=0.1428p pd=1.52u as=0 ps=0 w=0.42u l=1u
X1168 VGND.t358 VPWR.t1633 VGND.t358 VGND.t1160 sg13_lv_nmos ad=79.8f pd=0.8u as=0 ps=0 w=0.42u l=1u
X1169 sg13cmos5l_buf_16_2.A a_9262_7680# VPWR.t149 VPWR.t5 sg13_lv_pmos ad=0.2128p pd=1.5u as=0.2128p ps=1.5u w=1.12u l=0.13u
X1170 VPWR.t1513 a_3694_14482# sg13cmos5l_buf_16_33.A VPWR.t292 sg13_lv_pmos ad=0.2128p pd=1.5u as=0.2128p ps=1.5u w=1.12u l=0.13u
X1171 VPWR.t1580 sg13cmos5l_buf_16_39.A a_6164_2350# VPWR.t20 sg13_lv_pmos ad=0.2128p pd=1.5u as=0.2128p ps=1.5u w=1.12u l=0.13u
X1172 VGND.t261 VPWR.t189 VGND.t261 VGND.t1073 sg13_lv_nmos ad=0.1428p pd=1.52u as=0 ps=0 w=0.42u l=1u
X1173 sg13cmos5l_buf_16_31.X a_6094_4656# VGND.t282 VGND.t445 sg13_lv_nmos ad=0.1406p pd=1.12u as=0.1406p ps=1.12u w=0.74u l=0.13u
X1174 VPWR.t1536 sg13cmos5l_buf_16_18.A a_4052_12934# VPWR.t8 sg13_lv_pmos ad=0.2128p pd=1.5u as=0.2128p ps=1.5u w=1.12u l=0.13u
X1175 VGND.t275 sg13cmos5l_buf_16_13.A a_3694_8434# VGND.t280 sg13_lv_nmos ad=0.1406p pd=1.12u as=0.1406p ps=1.12u w=0.74u l=0.13u
X1176 sg13cmos5l_buf_16_7.A a_3668_3108# VPWR.t489 VPWR.t20 sg13_lv_pmos ad=0.2128p pd=1.5u as=0.3976p ps=2.95u w=1.12u l=0.13u
X1177 sg13cmos5l_buf_16_24.X a_6862_9946# VGND.t1 VGND.t255 sg13_lv_nmos ad=0.1406p pd=1.12u as=0.1406p ps=1.12u w=0.74u l=0.13u
X1178 VPWR.t173 a_6094_3144# sg13cmos5l_xor2_1_0.B VPWR.t20 sg13_lv_pmos ad=0.2128p pd=1.5u as=0.2128p ps=1.5u w=1.12u l=0.13u
X1179 sg13cmos5l_buf_16_39.A a_8494_3144# VGND.t92 VGND.t40 sg13_lv_nmos ad=0.1406p pd=1.12u as=0.1406p ps=1.12u w=0.74u l=0.13u
X1180 VPWR.t4 VGND.t1129 VPWR.t4 VPWR.t3 sg13_lv_pmos ad=0.34p pd=2.68u as=0 ps=0 w=1u l=1u
X1181 sg13cmos5l_buf_16_15.A a_4052_12934# VGND.t345 VGND.t730 sg13_lv_nmos ad=0.1406p pd=1.12u as=0.1406p ps=1.12u w=0.74u l=0.13u
X1182 VGND.t1029 VPWR.t133 VGND.t1028 VGND.t156 sg13_lv_nmos ad=0.1428p pd=1.52u as=0 ps=0 w=0.42u l=1u
X1183 VGND.t1219 VPWR.t382 VGND.t1219 VGND.t1220 sg13_lv_nmos ad=79.8f pd=0.8u as=0 ps=0 w=0.42u l=1u
X1184 VPWR.t1 VGND.t1296 VPWR.t1 VPWR.t0 sg13_lv_pmos ad=0.34p pd=2.68u as=0 ps=0 w=1u l=1u
X1185 VGND.t1354 VPWR.t284 VGND.t1353 VGND.t1352 sg13_lv_nmos ad=0.1428p pd=1.52u as=0 ps=0 w=0.42u l=1u
X1186 VPWR.t70 a_8110_6168# sg13cmos5l_buf_16_38.A VPWR.t70 sg13_lv_pmos ad=0.2128p pd=1.5u as=0.2128p ps=1.5u w=1.12u l=0.13u
X1187 sg13cmos5l_buf_16_34.A a_3694_8434# VPWR.t708 VPWR.t3 sg13_lv_pmos ad=0.2128p pd=1.5u as=0.2128p ps=1.5u w=1.12u l=0.13u
X1188 sg13cmos5l_buf_16_2.A a_9262_7680# VGND.t5 VGND.t4 sg13_lv_nmos ad=0.1406p pd=1.12u as=0.1406p ps=1.12u w=0.74u l=0.13u
X1189 sg13cmos5l_buf_16_23.X a_10292_12934# VGND.t315 VGND.t644 sg13_lv_nmos ad=0.1406p pd=1.12u as=0.1406p ps=1.12u w=0.74u l=0.13u
X1190 VPWR.t1508 sg13cmos5l_buf_16_15.X a_3694_14482# VPWR.t292 sg13_lv_pmos ad=0.2128p pd=1.5u as=0.2128p ps=1.5u w=1.12u l=0.13u
X1191 VPWR.t723 sg13cmos5l_buf_16_28.A a_5684_6132# VPWR.t70 sg13_lv_pmos ad=0.2128p pd=1.5u as=0.2128p ps=1.5u w=1.12u l=0.13u
X1192 sg13cmos5l_buf_16_27.X a_6548_13692# VGND.t693 VGND.t1497 sg13_lv_nmos ad=0.1406p pd=1.12u as=0.1406p ps=1.12u w=0.74u l=0.13u
X1193 sg13cmos5l_buf_16_10.A a_3694_3898# VGND.t41 VGND.t40 sg13_lv_nmos ad=0.1406p pd=1.12u as=0.1406p ps=1.12u w=0.74u l=0.13u
X1194 VGND.t222 a_3668_4620# sg13cmos5l_buf_16_8.A VGND.t458 sg13_lv_nmos ad=0.1406p pd=1.12u as=0.1406p ps=1.12u w=0.74u l=0.13u
X1195 VPWR.t1276 a_4052_12934# sg13cmos5l_buf_16_15.A VPWR.t8 sg13_lv_pmos ad=0.2128p pd=1.5u as=0.2128p ps=1.5u w=1.12u l=0.13u
X1196 VPWR.t30 VGND.t868 VPWR.t30 VPWR.t20 sg13_lv_pmos ad=0.34p pd=2.68u as=0 ps=0 w=1u l=1u
X1197 VGND.t261 VPWR.t357 VGND.t261 VGND.t1071 sg13_lv_nmos ad=0.1428p pd=1.52u as=0 ps=0 w=0.42u l=1u
X1198 VPWR.t67 VGND.t1060 VPWR.t374 VPWR.t3 sg13_lv_pmos ad=0.34p pd=2.68u as=0 ps=0 w=1u l=1u
X1199 VPWR.t706 a_3694_8434# sg13cmos5l_buf_16_34.A VPWR.t3 sg13_lv_pmos ad=0.2128p pd=1.5u as=0.2128p ps=1.5u w=1.12u l=0.13u
X1200 a_9524_6886# sg13cmos5l_buf_16_4.A VPWR.t149 VPWR.t5 sg13_lv_pmos ad=0.2128p pd=1.5u as=0.2128p ps=1.5u w=1.12u l=0.13u
X1201 VGND.t377 VPWR.t1673 VGND.t377 VGND.t156 sg13_lv_nmos ad=79.8f pd=0.8u as=0 ps=0 w=0.42u l=1u
X1202 VGND.t1125 VPWR.t245 VGND.t11 VGND.t1124 sg13_lv_nmos ad=0.1428p pd=1.52u as=0 ps=0 w=0.42u l=1u
X1203 VPWR.t1533 sg13cmos5l_buf_16_31.X a_2147_13692# VPWR.t8 sg13_lv_pmos ad=0.2856p pd=2.36u as=0.1596p ps=1.22u w=0.84u l=0.13u
X1204 VGND.t358 sg13cmos5l_buf_16_28.X a_5518_6922# VGND.t361 sg13_lv_nmos ad=0.1406p pd=1.12u as=0.1406p ps=1.12u w=0.74u l=0.13u
X1205 VPWR.t357 VGND.t1020 VPWR.t357 VPWR.t55 sg13_lv_pmos ad=0.34p pd=2.68u as=0 ps=0 w=1u l=1u
X1206 a_7220_5374# sg13cmos5l_buf_16_38.A VGND.t282 VGND.t848 sg13_lv_nmos ad=0.1406p pd=1.12u as=0.1406p ps=1.12u w=0.74u l=0.13u
X1207 a_5684_6132# sg13cmos5l_buf_16_28.A VPWR.t720 VPWR.t70 sg13_lv_pmos ad=0.2128p pd=1.5u as=0.2128p ps=1.5u w=1.12u l=0.13u
X1208 VGND.t871 VPWR.t1700 VGND.t871 VGND.t909 sg13_lv_nmos ad=0.1428p pd=1.52u as=0 ps=0 w=0.42u l=1u
X1209 VPWR.t631 a_10292_12934# sg13cmos5l_buf_16_23.X VPWR.t8 sg13_lv_pmos ad=0.2128p pd=1.5u as=0.2128p ps=1.5u w=1.12u l=0.13u
X1210 VGND.t350 a_5204_11422# sg13cmos5l_buf_16_20.A VGND.t156 sg13_lv_nmos ad=0.1406p pd=1.12u as=0.1406p ps=1.12u w=0.74u l=0.13u
X1211 VPWR.t284 VGND.t1353 VPWR.t0 VPWR.t0 sg13_lv_pmos ad=0.34p pd=2.68u as=0 ps=0 w=1u l=1u
X1212 sg13cmos5l_buf_1_4.A a_13768_7680# VPWR.t5 VPWR.t5 sg13_lv_pmos ad=0.42p pd=2.99u as=0.2114p ps=1.54u w=1.12u l=0.13u
X1213 VPWR.t118 VGND.t315 VPWR.t118 VPWR.t13 sg13_lv_pmos ad=0.19p pd=1.38u as=0 ps=0 w=1u l=1u
X1214 VGND.t860 sg13cmos5l_buf_16_5.A a_5108_838# VGND.t861 sg13_lv_nmos ad=0.1406p pd=1.12u as=0.1406p ps=1.12u w=0.74u l=0.13u
X1215 a_6836_9156# sg13cmos5l_and2_2_6.X VGND.t1 VGND.t257 sg13_lv_nmos ad=0.1406p pd=1.12u as=0.1406p ps=1.12u w=0.74u l=0.13u
X1216 VPWR.t149 a_9524_6886# sg13cmos5l_buf_16_4.X VPWR.t5 sg13_lv_pmos ad=0.2128p pd=1.5u as=0.2128p ps=1.5u w=1.12u l=0.13u
X1217 VGND.t275 a_3694_7680# sg13cmos5l_buf_16_34.X VGND.t399 sg13_lv_nmos ad=0.1406p pd=1.12u as=0.1406p ps=1.12u w=0.74u l=0.13u
X1218 VGND.t1153 VPWR.t1636 VGND.t1153 VGND.t1154 sg13_lv_nmos ad=79.8f pd=0.8u as=0 ps=0 w=0.42u l=1u
X1219 VGND.t358 VPWR.t1641 VGND.t358 VGND.t1161 sg13_lv_nmos ad=0.1428p pd=1.52u as=0 ps=0 w=0.42u l=1u
X1220 sg13cmos5l_buf_16_14.A a_4436_9910# VGND.t169 VGND.t170 sg13_lv_nmos ad=0.1406p pd=1.12u as=0.1406p ps=1.12u w=0.74u l=0.13u
X1221 VPWR.t7 a_5710_1632# sg13cmos5l_buf_16_5.A VPWR.t0 sg13_lv_pmos ad=0.3976p pd=2.95u as=0.2128p ps=1.5u w=1.12u l=0.13u
X1222 sg13cmos5l_buf_16_27.X a_6548_13692# VGND.t915 VGND.t1493 sg13_lv_nmos ad=0.1406p pd=1.12u as=0.1406p ps=1.12u w=0.74u l=0.13u
X1223 sg13cmos5l_buf_16_2.X a_10318_3898# VPWR.t202 VPWR.t28 sg13_lv_pmos ad=0.2128p pd=1.5u as=0.2128p ps=1.5u w=1.12u l=0.13u
X1224 VGND.t384 VPWR.t1675 VGND.t384 VGND.t156 sg13_lv_nmos ad=0.1428p pd=1.52u as=0 ps=0 w=0.42u l=1u
X1225 a_3694_7680# sg13cmos5l_buf_16_34.A VGND.t275 VGND.t279 sg13_lv_nmos ad=0.1406p pd=1.12u as=0.1406p ps=1.12u w=0.74u l=0.13u
X1226 VGND.t1 a_6836_9156# sg13cmos5l_buf_16_25.A VGND.t110 sg13_lv_nmos ad=0.1406p pd=1.12u as=0.1406p ps=1.12u w=0.74u l=0.13u
X1227 VPWR.t62 VGND.t165 VPWR.t61 VPWR.t55 sg13_lv_pmos ad=0.19p pd=1.38u as=0 ps=0 w=1u l=1u
X1228 sg13cmos5l_buf_16_22.X a_10318_8434# VGND.t11 VGND.t771 sg13_lv_nmos ad=0.1406p pd=1.12u as=0.1406p ps=1.12u w=0.74u l=0.13u
X1229 VGND.t165 a_4436_9910# sg13cmos5l_buf_16_14.A VGND.t166 sg13_lv_nmos ad=0.1406p pd=1.12u as=0.1406p ps=1.12u w=0.74u l=0.13u
X1230 sg13cmos5l_buf_16_24.X a_6862_9946# VGND.t1 VGND.t107 sg13_lv_nmos ad=0.1406p pd=1.12u as=0.1406p ps=1.12u w=0.74u l=0.13u
X1231 sg13cmos5l_buf_16_39.A a_8494_3144# VGND.t92 VGND.t40 sg13_lv_nmos ad=0.1406p pd=1.12u as=0.1406p ps=1.12u w=0.74u l=0.13u
X1232 VPWR.t19 VGND.t1373 VPWR.t78 VPWR.t0 sg13_lv_pmos ad=0.34p pd=2.68u as=0 ps=0 w=1u l=1u
X1233 VGND.t1433 VPWR.t38 VGND.t1432 VGND.t1431 sg13_lv_nmos ad=0.1428p pd=1.52u as=0 ps=0 w=0.42u l=1u
X1234 VPWR.t19 sg13cmos5l_buf_16_5.A a_5108_838# VPWR.t0 sg13_lv_pmos ad=0.2128p pd=1.5u as=0.2128p ps=1.5u w=1.12u l=0.13u
X1235 VGND.t244 VPWR.t381 VGND.t244 VGND.t40 sg13_lv_nmos ad=79.8f pd=0.8u as=0 ps=0 w=0.42u l=1u
X1236 VPWR.t293 VGND.t897 VPWR.t1585 VPWR.t292 sg13_lv_pmos ad=0.19p pd=1.38u as=0 ps=0 w=1u l=1u
X1237 VPWR.t428 VGND.t358 VPWR.t427 VPWR.t70 sg13_lv_pmos ad=0.19p pd=1.38u as=0 ps=0 w=1u l=1u
X1238 VPWR.t920 a_7796_12934# sg13cmos5l_buf_16_37.X VPWR.t8 sg13_lv_pmos ad=0.2128p pd=1.5u as=0.2128p ps=1.5u w=1.12u l=0.13u
X1239 VGND.t1079 VPWR.t905 VGND.t1079 VGND.t1082 sg13_lv_nmos ad=0.1428p pd=1.52u as=0 ps=0 w=0.42u l=1u
X1240 VGND.t72 a_10292_4620# sg13cmos5l_buf_16_3.X VGND.t75 sg13_lv_nmos ad=0.1406p pd=1.12u as=0.1406p ps=1.12u w=0.74u l=0.13u
X1241 VPWR.t548 a_6862_9946# sg13cmos5l_buf_16_24.X VPWR.t55 sg13_lv_pmos ad=0.2128p pd=1.5u as=0.2128p ps=1.5u w=1.12u l=0.13u
X1242 sg13cmos5l_buf_16_20.A a_5204_11422# VPWR.t1293 VPWR.t13 sg13_lv_pmos ad=0.2128p pd=1.5u as=0.2128p ps=1.5u w=1.12u l=0.13u
X1243 VPWR.t70 sg13cmos5l_buf_16_38.A a_7220_5374# VPWR.t70 sg13_lv_pmos ad=0.3808p pd=2.92u as=0.2128p ps=1.5u w=1.12u l=0.13u
X1244 VGND.t11 a_10318_8434# sg13cmos5l_buf_16_22.X VGND.t768 sg13_lv_nmos ad=0.1406p pd=1.12u as=0.1406p ps=1.12u w=0.74u l=0.13u
X1245 a_9262_7680# sg13cmos5l_buf_16_4.X VGND.t5 VGND.t65 sg13_lv_nmos ad=0.1406p pd=1.12u as=0.1406p ps=1.12u w=0.74u l=0.13u
X1246 VGND.t1079 VPWR.t245 VGND.t1079 VGND.t1081 sg13_lv_nmos ad=79.8f pd=0.8u as=0 ps=0 w=0.42u l=1u
X1247 sg13cmos5l_buf_16_38.A a_8110_6168# VGND.t358 VGND.t546 sg13_lv_nmos ad=0.1406p pd=1.12u as=0.1406p ps=1.12u w=0.74u l=0.13u
X1248 VGND.t1219 VPWR.t381 VGND.t366 VGND.t1241 sg13_lv_nmos ad=79.8f pd=0.8u as=0 ps=0 w=0.42u l=1u
X1249 VGND.t358 VPWR.t1633 VGND.t358 VGND.t1159 sg13_lv_nmos ad=0.1428p pd=1.52u as=0 ps=0 w=0.42u l=1u
X1250 VPWR.t1 VGND.t1302 VPWR.t1 VPWR.t0 sg13_lv_pmos ad=0.34p pd=2.68u as=0 ps=0 w=1u l=1u
X1251 a_10318_3898# sg13cmos5l_buf_16_2.A VPWR.t202 VPWR.t28 sg13_lv_pmos ad=0.2128p pd=1.5u as=0.2128p ps=1.5u w=1.12u l=0.13u
X1252 sg13cmos5l_buf_16_10.A a_3694_3898# VGND.t207 VGND.t40 sg13_lv_nmos ad=0.1406p pd=1.12u as=0.1406p ps=1.12u w=0.74u l=0.13u
X1253 VGND.t244 VPWR.t1620 VGND.t1248 VGND.t40 sg13_lv_nmos ad=79.8f pd=0.8u as=0 ps=0 w=0.42u l=1u
X1254 VPWR.t1472 a_4174_13728# sg13cmos5l_buf_16_18.A VPWR.t8 sg13_lv_pmos ad=0.3976p pd=2.95u as=0.2128p ps=1.5u w=1.12u l=0.13u
X1255 sg13cmos5l_buf_16_22.X a_10318_8434# VPWR.t245 VPWR.t3 sg13_lv_pmos ad=0.2128p pd=1.5u as=0.2128p ps=1.5u w=1.12u l=0.13u
X1256 VPWR.t21 sg13cmos5l_buf_16_0.A a_8494_3144# VPWR.t20 sg13_lv_pmos ad=0.2128p pd=1.5u as=0.2128p ps=1.5u w=1.12u l=0.13u
X1257 VGND.t350 a_6094_10704# sg13cmos5l_buf_16_24.A VGND.t156 sg13_lv_nmos ad=0.1406p pd=1.12u as=0.1406p ps=1.12u w=0.74u l=0.13u
X1258 a_7220_5374# sg13cmos5l_buf_16_38.A VPWR.t70 VPWR.t70 sg13_lv_pmos ad=0.2128p pd=1.5u as=0.2128p ps=1.5u w=1.12u l=0.13u
X1259 sg13cmos5l_and2_2_3.X a_13581_9988# VGND.t633 VGND.t765 sg13_lv_nmos ad=0.1406p pd=1.12u as=0.1331p ps=1.12u w=0.74u l=0.13u
X1260 a_3668_3108# sg13cmos5l_buf_16_10.A VGND.t41 VGND.t40 sg13_lv_nmos ad=0.1406p pd=1.12u as=0.1406p ps=1.12u w=0.74u l=0.13u
X1261 sg13cmos5l_buf_16_31.X a_6094_4656# VPWR.t753 VPWR.t28 sg13_lv_pmos ad=0.2128p pd=1.5u as=0.2128p ps=1.5u w=1.12u l=0.13u
X1262 VPWR.t14 VGND.t315 VPWR.t110 VPWR.t13 sg13_lv_pmos ad=0.34p pd=2.68u as=0 ps=0 w=1u l=1u
X1263 VPWR.t449 VGND.t851 VPWR.t381 VPWR.t28 sg13_lv_pmos ad=0.34p pd=2.68u as=0 ps=0 w=1u l=1u
X1264 VGND.t358 a_8110_6168# sg13cmos5l_buf_16_38.A VGND.t543 sg13_lv_nmos ad=0.1406p pd=1.12u as=0.1406p ps=1.12u w=0.74u l=0.13u
X1265 sg13cmos5l_buf_16_28.X a_5684_6132# VGND.t358 VGND.t829 sg13_lv_nmos ad=0.1406p pd=1.12u as=0.1406p ps=1.12u w=0.74u l=0.13u
X1266 VPWR.t914 glitch_en[5] a_13576_14516# VPWR.t292 sg13_lv_pmos ad=0.2114p pd=1.54u as=0.2856p ps=2.36u w=0.84u l=0.13u
X1267 VPWR.t590 sg13cmos5l_buf_16_24.A a_6862_9946# VPWR.t55 sg13_lv_pmos ad=0.2128p pd=1.5u as=0.2128p ps=1.5u w=1.12u l=0.13u
X1268 VPWR.t245 a_10318_8434# sg13cmos5l_buf_16_22.X VPWR.t3 sg13_lv_pmos ad=0.2128p pd=1.5u as=0.2128p ps=1.5u w=1.12u l=0.13u
X1269 VGND.t584 sg13cmos5l_buf_16_39.A a_8538_2578# VGND.t1573 sg13_lv_nmos ad=0.374p pd=2.46u as=0.17462p ps=1.185u w=0.55u l=0.13u
X1270 a_8494_3144# sg13cmos5l_buf_16_0.A VPWR.t218 VPWR.t20 sg13_lv_pmos ad=0.2128p pd=1.5u as=0.3808p ps=2.92u w=1.12u l=0.13u
X1271 sg13cmos5l_buf_16_15.X a_3668_12180# VGND.t345 VGND.t346 sg13_lv_nmos ad=0.1406p pd=1.12u as=0.1406p ps=1.12u w=0.74u l=0.13u
X1272 VPWR.t790 a_3694_2386# sg13cmos5l_buf_16_7.X VPWR.t20 sg13_lv_pmos ad=0.2128p pd=1.5u as=0.2128p ps=1.5u w=1.12u l=0.13u
X1273 a_7796_12934# sg13cmos5l_buf_16_37.A VPWR.t631 VPWR.t8 sg13_lv_pmos ad=0.2128p pd=1.5u as=0.2128p ps=1.5u w=1.12u l=0.13u
X1274 sg13cmos5l_buf_1_1.A a_13768_3932# VPWR.t381 VPWR.t28 sg13_lv_pmos ad=0.42p pd=2.99u as=0.2114p ps=1.54u w=1.12u l=0.13u
X1275 VPWR.t1118 VGND.t11 VPWR.t1116 VPWR.t5 sg13_lv_pmos ad=0.19p pd=1.38u as=0 ps=0 w=1u l=1u
X1276 VPWR.t631 sg13cmos5l_buf_16_23.X a_8948_13692# VPWR.t8 sg13_lv_pmos ad=0.2128p pd=1.5u as=0.2128p ps=1.5u w=1.12u l=0.13u
X1277 VPWR.t1329 a_3694_7680# sg13cmos5l_buf_16_34.X VPWR.t5 sg13_lv_pmos ad=0.2128p pd=1.5u as=0.2128p ps=1.5u w=1.12u l=0.13u
X1278 VGND.t315 a_7796_12934# sg13cmos5l_buf_16_37.X VGND.t618 sg13_lv_nmos ad=0.1406p pd=1.12u as=0.1406p ps=1.12u w=0.74u l=0.13u
X1279 VPWR.t284 VGND.t1358 VPWR.t284 VPWR.t0 sg13_lv_pmos ad=0.34p pd=2.68u as=0 ps=0 w=1u l=1u
X1280 VGND.t130 a_10318_3898# sg13cmos5l_buf_16_2.X VGND.t40 sg13_lv_nmos ad=0.2516p pd=2.16u as=0.1406p ps=1.12u w=0.74u l=0.13u
X1281 sg13cmos5l_buf_16_22.X a_10318_8434# VPWR.t190 VPWR.t3 sg13_lv_pmos ad=0.2128p pd=1.5u as=0.2128p ps=1.5u w=1.12u l=0.13u
X1282 sg13cmos5l_buf_16_37.A a_8948_13692# VPWR.t631 VPWR.t8 sg13_lv_pmos ad=0.2128p pd=1.5u as=0.2128p ps=1.5u w=1.12u l=0.13u
X1283 VPWR.t381 VGND.t244 VPWR.t381 VPWR.t28 sg13_lv_pmos ad=0.19p pd=1.38u as=0 ps=0 w=1u l=1u
X1284 VGND.t1248 VPWR.t1615 VGND.t1248 VGND.t40 sg13_lv_nmos ad=79.8f pd=0.8u as=0 ps=0 w=0.42u l=1u
X1285 VGND.t358 VPWR.t1640 VGND.t358 VGND.t1163 sg13_lv_nmos ad=0.1428p pd=1.52u as=0 ps=0 w=0.42u l=1u
X1286 VGND.t1060 VPWR.t357 VGND.t1060 VGND.t1075 sg13_lv_nmos ad=0.1428p pd=1.52u as=0 ps=0 w=0.42u l=1u
X1287 sg13cmos5l_buf_16_5.A a_5710_1632# VPWR.t19 VPWR.t0 sg13_lv_pmos ad=0.2128p pd=1.5u as=0.2128p ps=1.5u w=1.12u l=0.13u
X1288 VPWR.t384 VGND.t693 VPWR.t386 VPWR.t292 sg13_lv_pmos ad=0.19p pd=1.38u as=0 ps=0 w=1u l=1u
X1289 sg13cmos5l_buf_16_31.X a_6094_4656# VPWR.t749 VPWR.t28 sg13_lv_pmos ad=0.2128p pd=1.5u as=0.2128p ps=1.5u w=1.12u l=0.13u
X1290 sg13cmos5l_buf_16_34.X a_3694_7680# VPWR.t1325 VPWR.t5 sg13_lv_pmos ad=0.2128p pd=1.5u as=0.2128p ps=1.5u w=1.12u l=0.13u
X1291 sg13cmos5l_buf_16_15.X a_3668_12180# VGND.t332 VGND.t340 sg13_lv_nmos ad=0.1406p pd=1.12u as=0.1406p ps=1.12u w=0.74u l=0.13u
X1292 sg13cmos5l_buf_16_2.X a_10318_3898# VGND.t130 VGND.t40 sg13_lv_nmos ad=0.1406p pd=1.12u as=0.1406p ps=1.12u w=0.74u l=0.13u
X1293 VGND.t112 VPWR.t202 VGND.t112 VGND.t40 sg13_lv_nmos ad=0.1428p pd=1.52u as=0 ps=0 w=0.42u l=1u
X1294 a_7796_12934# sg13cmos5l_buf_16_37.A VPWR.t631 VPWR.t8 sg13_lv_pmos ad=0.2128p pd=1.5u as=0.2128p ps=1.5u w=1.12u l=0.13u
X1295 VPWR.t786 a_3694_2386# sg13cmos5l_buf_16_7.X VPWR.t20 sg13_lv_pmos ad=0.2128p pd=1.5u as=0.2128p ps=1.5u w=1.12u l=0.13u
X1296 VPWR.t70 a_8110_6168# sg13cmos5l_buf_16_38.A VPWR.t70 sg13_lv_pmos ad=0.2128p pd=1.5u as=0.2128p ps=1.5u w=1.12u l=0.13u
X1297 VPWR.t631 a_8948_13692# sg13cmos5l_buf_16_37.A VPWR.t8 sg13_lv_pmos ad=0.2128p pd=1.5u as=0.2128p ps=1.5u w=1.12u l=0.13u
X1298 VPWR.t40 VGND.t1248 VPWR.t39 VPWR.t28 sg13_lv_pmos ad=0.19p pd=1.38u as=0 ps=0 w=1u l=1u
X1299 VPWR.t1477 sg13cmos5l_and2_2_1.X a_4174_13728# VPWR.t8 sg13_lv_pmos ad=0.2128p pd=1.5u as=0.2128p ps=1.5u w=1.12u l=0.13u
X1300 sg13cmos5l_buf_16_25.A a_6836_9156# VPWR.t235 VPWR.t3 sg13_lv_pmos ad=0.2128p pd=1.5u as=0.2128p ps=1.5u w=1.12u l=0.13u
X1301 VPWR.t470 a_4436_9910# sg13cmos5l_buf_16_14.A VPWR.t55 sg13_lv_pmos ad=0.2128p pd=1.5u as=0.2128p ps=1.5u w=1.12u l=0.13u
X1302 VGND.t999 VPWR.t1679 VGND.t999 VGND.t156 sg13_lv_nmos ad=0.1428p pd=1.52u as=0 ps=0 w=0.42u l=1u
X1303 sg13cmos5l_buf_16_37.A a_8948_13692# VPWR.t631 VPWR.t8 sg13_lv_pmos ad=0.2128p pd=1.5u as=0.2128p ps=1.5u w=1.12u l=0.13u
X1304 a_13581_9988# sg13cmos5l_buf_16_22.X VPWR.t56 VPWR.t55 sg13_lv_pmos ad=0.1596p pd=1.22u as=0.2856p ps=2.36u w=0.84u l=0.13u
X1305 VGND.t169 a_3668_9156# sg13cmos5l_buf_16_13.A VGND.t193 sg13_lv_nmos ad=0.1406p pd=1.12u as=0.1406p ps=1.12u w=0.74u l=0.13u
X1306 VPWR.t1096 VGND.t11 VPWR.t1094 VPWR.t3 sg13_lv_pmos ad=0.19p pd=1.38u as=0 ps=0 w=1u l=1u
X1307 VGND.t693 VPWR.t292 VGND.t693 VGND.t924 sg13_lv_nmos ad=0.1428p pd=1.52u as=0 ps=0 w=0.42u l=1u
X1308 sg13cmos5l_buf_16_24.A a_6094_10704# VGND.t377 VGND.t156 sg13_lv_nmos ad=0.1406p pd=1.12u as=0.1406p ps=1.12u w=0.74u l=0.13u
X1309 a_3668_3108# sg13cmos5l_buf_16_10.A VGND.t207 VGND.t40 sg13_lv_nmos ad=0.1406p pd=1.12u as=0.1406p ps=1.12u w=0.74u l=0.13u
X1310 VPWR.t367 VGND.t1060 VPWR.t366 VPWR.t3 sg13_lv_pmos ad=0.34p pd=2.68u as=0 ps=0 w=1u l=1u
X1311 VPWR.t131 VGND.t1020 VPWR.t133 VPWR.t13 sg13_lv_pmos ad=0.19p pd=1.38u as=0 ps=0 w=1u l=1u
X1312 VPWR.t233 a_6836_9156# sg13cmos5l_buf_16_25.A VPWR.t3 sg13_lv_pmos ad=0.2128p pd=1.5u as=0.2128p ps=1.5u w=1.12u l=0.13u
X1313 sg13cmos5l_buf_16_30.A a_6164_2350# VGND.t491 VGND.t495 sg13_lv_nmos ad=0.1406p pd=1.12u as=0.1406p ps=1.12u w=0.74u l=0.13u
X1314 sg13cmos5l_buf_16_15.X a_3668_12180# VGND.t332 VGND.t336 sg13_lv_nmos ad=0.1406p pd=1.12u as=0.1406p ps=1.12u w=0.74u l=0.13u
X1315 VGND.t358 VPWR.t1632 VGND.t358 VGND.t1161 sg13_lv_nmos ad=0.1428p pd=1.52u as=0 ps=0 w=0.42u l=1u
X1316 a_3694_14482# sg13cmos5l_buf_16_15.X VGND.t942 VGND.t1499 sg13_lv_nmos ad=0.1406p pd=1.12u as=0.2516p ps=2.16u w=0.74u l=0.13u
X1317 VGND.t315 VPWR.t1684 VGND.t315 VGND.t955 sg13_lv_nmos ad=79.8f pd=0.8u as=0 ps=0 w=0.42u l=1u
X1318 VGND.t413 a_3694_8434# sg13cmos5l_buf_16_34.A VGND.t415 sg13_lv_nmos ad=0.2516p pd=2.16u as=0.1406p ps=1.12u w=0.74u l=0.13u
X1319 VPWR.t136 sg13cmos5l_buf_16_4.X a_9262_7680# VPWR.t5 sg13_lv_pmos ad=0.2128p pd=1.5u as=0.2128p ps=1.5u w=1.12u l=0.13u
X1320 a_8948_13692# sg13cmos5l_buf_16_23.X VGND.t693 VGND.t692 sg13_lv_nmos ad=0.1406p pd=1.12u as=0.1406p ps=1.12u w=0.74u l=0.13u
X1321 sg13cmos5l_buf_16_13.A a_3668_9156# VGND.t165 VGND.t190 sg13_lv_nmos ad=0.1406p pd=1.12u as=0.1406p ps=1.12u w=0.74u l=0.13u
X1322 VPWR.t466 a_4436_9910# sg13cmos5l_buf_16_14.A VPWR.t55 sg13_lv_pmos ad=0.2128p pd=1.5u as=0.2128p ps=1.5u w=1.12u l=0.13u
X1323 VGND.t491 a_6164_2350# sg13cmos5l_buf_16_30.A VGND.t492 sg13_lv_nmos ad=0.1406p pd=1.12u as=0.1406p ps=1.12u w=0.74u l=0.13u
X1324 VGND.t1153 VPWR.t1643 VGND.t1153 VGND.t1157 sg13_lv_nmos ad=0.1428p pd=1.52u as=0 ps=0 w=0.42u l=1u
X1325 sg13cmos5l_buf_16_34.A a_3694_8434# VGND.t402 VGND.t411 sg13_lv_nmos ad=0.1406p pd=1.12u as=0.1406p ps=1.12u w=0.74u l=0.13u
X1326 sg13cmos5l_buf_1_17.X a_12232_12216# VPWR.t131 VPWR.t13 sg13_lv_pmos ad=0.42p pd=2.99u as=0.2114p ps=1.54u w=1.12u l=0.13u
X1327 VGND.t1207 VPWR.t1625 VGND.t1207 VGND.t1206 sg13_lv_nmos ad=0.1428p pd=1.52u as=0 ps=0 w=0.42u l=1u
X1328 VPWR.t905 VGND.t1029 VPWR.t905 VPWR.t55 sg13_lv_pmos ad=0.34p pd=2.68u as=0 ps=0 w=1u l=1u
X1329 VGND.t165 a_3668_9156# sg13cmos5l_buf_16_13.A VGND.t187 sg13_lv_nmos ad=0.1406p pd=1.12u as=0.1406p ps=1.12u w=0.74u l=0.13u
X1330 VGND.t384 sg13cmos5l_buf_16_34.X a_3694_10704# VGND.t156 sg13_lv_nmos ad=0.1406p pd=1.12u as=0.1406p ps=1.12u w=0.74u l=0.13u
X1331 VGND.t384 a_3694_10704# sg13cmos5l_and2_2_6.A VGND.t156 sg13_lv_nmos ad=0.1406p pd=1.12u as=0.1406p ps=1.12u w=0.74u l=0.13u
X1332 VGND.t41 a_6094_3898# sg13cmos5l_buf_16_0.A VGND.t40 sg13_lv_nmos ad=0.1406p pd=1.12u as=0.1406p ps=1.12u w=0.74u l=0.13u
X1333 VPWR.t888 a_3694_3898# sg13cmos5l_buf_16_10.A VPWR.t28 sg13_lv_pmos ad=0.2128p pd=1.5u as=0.2128p ps=1.5u w=1.12u l=0.13u
X1334 VGND.t72 sg13cmos5l_buf_16_3.X a_10318_5410# VGND.t75 sg13_lv_nmos ad=0.1406p pd=1.12u as=0.1406p ps=1.12u w=0.74u l=0.13u
X1335 sg13cmos5l_buf_16_3.X a_10292_4620# VPWR.t202 VPWR.t28 sg13_lv_pmos ad=0.2128p pd=1.5u as=0.2128p ps=1.5u w=1.12u l=0.13u
X1336 sg13cmos5l_buf_16_31.X a_6094_4656# VGND.t282 VGND.t455 sg13_lv_nmos ad=0.1406p pd=1.12u as=0.1406p ps=1.12u w=0.74u l=0.13u
X1337 sg13cmos5l_buf_16_27.X a_6548_13692# VPWR.t1500 VPWR.t8 sg13_lv_pmos ad=0.2128p pd=1.5u as=0.2128p ps=1.5u w=1.12u l=0.13u
X1338 VGND.t1423 VPWR.t18 VGND.t1422 VGND.t1421 sg13_lv_nmos ad=0.1428p pd=1.52u as=0 ps=0 w=0.42u l=1u
X1339 sg13cmos5l_buf_16_34.X a_3694_7680# VPWR.t598 VPWR.t5 sg13_lv_pmos ad=0.2128p pd=1.5u as=0.2128p ps=1.5u w=1.12u l=0.13u
X1340 VGND.t315 VPWR.t1692 VGND.t315 VGND.t953 sg13_lv_nmos ad=79.8f pd=0.8u as=0 ps=0 w=0.42u l=1u
X1341 sg13cmos5l_buf_16_37.A a_8948_13692# VGND.t693 VGND.t711 sg13_lv_nmos ad=0.1406p pd=1.12u as=0.1406p ps=1.12u w=0.74u l=0.13u
X1342 VPWR.t183 a_6094_3144# sg13cmos5l_xor2_1_0.B VPWR.t20 sg13_lv_pmos ad=0.3976p pd=2.95u as=0.2128p ps=1.5u w=1.12u l=0.13u
X1343 VGND.t345 a_4052_12934# sg13cmos5l_buf_16_15.A VGND.t731 sg13_lv_nmos ad=0.1406p pd=1.12u as=0.1406p ps=1.12u w=0.74u l=0.13u
X1344 sg13cmos5l_buf_16_7.A a_3668_3108# VPWR.t500 VPWR.t20 sg13_lv_pmos ad=0.2128p pd=1.5u as=0.2128p ps=1.5u w=1.12u l=0.13u
X1345 VGND.t912 a_3694_14482# sg13cmos5l_buf_16_33.A VGND.t1519 sg13_lv_nmos ad=0.1406p pd=1.12u as=0.1406p ps=1.12u w=0.74u l=0.13u
X1346 VGND.t315 sg13cmos5l_buf_16_18.A a_4052_12934# VGND.t1538 sg13_lv_nmos ad=0.2516p pd=2.16u as=0.1406p ps=1.12u w=0.74u l=0.13u
X1347 VPWR.t543 a_6094_3898# sg13cmos5l_buf_16_0.A VPWR.t28 sg13_lv_pmos ad=0.2128p pd=1.5u as=0.2128p ps=1.5u w=1.12u l=0.13u
X1348 VPWR.t1549 sg13cmos5l_buf_16_35.A a_8110_6168# VPWR.t70 sg13_lv_pmos ad=0.2128p pd=1.5u as=0.2128p ps=1.5u w=1.12u l=0.13u
X1349 VPWR.t581 VGND.t1153 VPWR.t579 VPWR.t70 sg13_lv_pmos ad=0.19p pd=1.38u as=0 ps=0 w=1u l=1u
X1350 VPWR.t136 a_9524_6886# sg13cmos5l_buf_16_4.X VPWR.t5 sg13_lv_pmos ad=0.2128p pd=1.5u as=0.2128p ps=1.5u w=1.12u l=0.13u
X1351 VGND.t1248 VPWR.t1614 VGND.t198 VGND.t40 sg13_lv_nmos ad=79.8f pd=0.8u as=0 ps=0 w=0.42u l=1u
X1352 sg13cmos5l_buf_16_10.A a_3694_3898# VPWR.t884 VPWR.t28 sg13_lv_pmos ad=0.2128p pd=1.5u as=0.2128p ps=1.5u w=1.12u l=0.13u
X1353 VGND.t693 a_8948_13692# sg13cmos5l_buf_16_37.A VGND.t700 sg13_lv_nmos ad=0.1406p pd=1.12u as=0.1406p ps=1.12u w=0.74u l=0.13u
X1354 VGND.t1060 VPWR.t360 VGND.t1060 VGND.t1077 sg13_lv_nmos ad=0.1428p pd=1.52u as=0 ps=0 w=0.42u l=1u
X1355 a_6094_3898# enable VGND.t41 VGND.t40 sg13_lv_nmos ad=0.1406p pd=1.12u as=0.1406p ps=1.12u w=0.74u l=0.13u
X1356 VPWR.t28 VGND.t282 VPWR.t1590 VPWR.t28 sg13_lv_pmos ad=0.34p pd=2.68u as=0 ps=0 w=1u l=1u
X1357 sg13cmos5l_buf_16_33.A a_3694_14482# VPWR.t1508 VPWR.t292 sg13_lv_pmos ad=0.2128p pd=1.5u as=0.2128p ps=1.5u w=1.12u l=0.13u
X1358 sg13cmos5l_buf_16_34.A a_3694_8434# VGND.t402 VGND.t407 sg13_lv_nmos ad=0.1406p pd=1.12u as=0.1406p ps=1.12u w=0.74u l=0.13u
X1359 VPWR.t498 a_3668_3108# sg13cmos5l_buf_16_7.A VPWR.t20 sg13_lv_pmos ad=0.2128p pd=1.5u as=0.2128p ps=1.5u w=1.12u l=0.13u
X1360 a_8110_6168# sg13cmos5l_buf_16_35.A VPWR.t1545 VPWR.t70 sg13_lv_pmos ad=0.2128p pd=1.5u as=0.3808p ps=2.92u w=1.12u l=0.13u
X1361 sg13cmos5l_buf_16_4.X a_9524_6886# VPWR.t136 VPWR.t5 sg13_lv_pmos ad=0.2128p pd=1.5u as=0.3976p ps=2.95u w=1.12u l=0.13u
X1362 sg13cmos5l_buf_16_27.X a_6548_13692# VPWR.t1496 VPWR.t8 sg13_lv_pmos ad=0.2128p pd=1.5u as=0.2128p ps=1.5u w=1.12u l=0.13u
X1363 VPWR.t819 a_6765_12564# sg13cmos5l_buf_16_19.A VPWR.t13 sg13_lv_pmos ad=0.4256p pd=3u as=0.2128p ps=1.5u w=1.12u l=0.13u
X1364 VPWR.t114 VGND.t315 VPWR.t113 VPWR.t13 sg13_lv_pmos ad=0.34p pd=2.68u as=0 ps=0 w=1u l=1u
X1365 sg13cmos5l_buf_16_15.A a_4052_12934# VPWR.t1276 VPWR.t8 sg13_lv_pmos ad=0.2128p pd=1.5u as=0.2128p ps=1.5u w=1.12u l=0.13u
X1366 VPWR.t716 a_3694_8434# sg13cmos5l_buf_16_34.A VPWR.t3 sg13_lv_pmos ad=0.2128p pd=1.5u as=0.2128p ps=1.5u w=1.12u l=0.13u
X1367 VPWR.t73 sg13cmos5l_buf_1_5.X a_14824_5444# VPWR.t70 sg13_lv_pmos ad=0.2114p pd=1.54u as=0.2856p ps=2.36u w=0.84u l=0.13u
X1368 VPWR.t245 VGND.t1085 VPWR.t245 VPWR.t3 sg13_lv_pmos ad=0.34p pd=2.68u as=0 ps=0 w=1u l=1u
X1369 sg13cmos5l_buf_16_3.X a_10292_4620# VPWR.t202 VPWR.t28 sg13_lv_pmos ad=0.2128p pd=1.5u as=0.2128p ps=1.5u w=1.12u l=0.13u
X1370 VGND.t358 a_5518_6922# sg13cmos5l_buf_16_6.X VGND.t673 sg13_lv_nmos ad=0.1406p pd=1.12u as=0.1406p ps=1.12u w=0.74u l=0.13u
X1371 a_7723_8028# sg13cmos5l_and2_2_6.A a_7629_8028# VGND.t3 sg13_lv_nmos ad=0.1216p pd=1.02u as=0.2176p ps=1.96u w=0.64u l=0.13u
X1372 VGND.t342 a_4052_12934# sg13cmos5l_buf_16_15.A VGND.t727 sg13_lv_nmos ad=0.1406p pd=1.12u as=0.1406p ps=1.12u w=0.74u l=0.13u
X1373 VGND.t377 VPWR.t562 VGND.t377 VGND.t156 sg13_lv_nmos ad=0.1428p pd=1.52u as=0 ps=0 w=0.42u l=1u
X1374 VGND.t1374 VPWR.t19 VGND.t1373 VGND.t1372 sg13_lv_nmos ad=0.1428p pd=1.52u as=0 ps=0 w=0.42u l=1u
X1375 a_5108_838# sg13cmos5l_buf_16_5.A VGND.t860 VGND.t862 sg13_lv_nmos ad=0.1406p pd=1.12u as=0.1406p ps=1.12u w=0.74u l=0.13u
X1376 a_5204_11422# sg13cmos5l_buf_16_19.A VGND.t350 VGND.t156 sg13_lv_nmos ad=0.1406p pd=1.12u as=0.1406p ps=1.12u w=0.74u l=0.13u
X1377 VGND.t11 a_11565_8028# sg13cmos5l_buf_16_4.A VGND.t810 sg13_lv_nmos ad=0.2812p pd=2.24u as=0.1406p ps=1.12u w=0.74u l=0.13u
X1378 VPWR.t4 sg13cmos5l_xor2_1_5.X a_14344_8468# VPWR.t3 sg13_lv_pmos ad=0.2114p pd=1.54u as=0.2856p ps=2.36u w=0.84u l=0.13u
X1379 VPWR.t371 VGND.t1060 VPWR.t370 VPWR.t3 sg13_lv_pmos ad=0.34p pd=2.68u as=0 ps=0 w=1u l=1u
X1380 a_6766_8434# sg13cmos5l_buf_16_25.A VPWR.t873 VPWR.t3 sg13_lv_pmos ad=0.2128p pd=1.5u as=0.3808p ps=2.92u w=1.12u l=0.13u
X1381 VPWR.t430 VGND.t358 VPWR.t429 VPWR.t70 sg13_lv_pmos ad=0.34p pd=2.68u as=0 ps=0 w=1u l=1u
X1382 VGND.t402 a_3694_7680# sg13cmos5l_buf_16_34.X VGND.t410 sg13_lv_nmos ad=0.1406p pd=1.12u as=0.1406p ps=1.12u w=0.74u l=0.13u
X1383 VGND.t573 VPWR.t304 VGND.t573 VGND.t998 sg13_lv_nmos ad=0.1428p pd=1.52u as=0 ps=0 w=0.42u l=1u
X1384 VGND.t915 a_6548_13692# sg13cmos5l_buf_16_27.X VGND.t1494 sg13_lv_nmos ad=0.1406p pd=1.12u as=0.1406p ps=1.12u w=0.74u l=0.13u
X1385 sg13cmos5l_buf_16_15.A a_4052_12934# VPWR.t1272 VPWR.t8 sg13_lv_pmos ad=0.2128p pd=1.5u as=0.2128p ps=1.5u w=1.12u l=0.13u
X1386 VPWR.t1293 a_5204_11422# sg13cmos5l_buf_16_20.A VPWR.t13 sg13_lv_pmos ad=0.2128p pd=1.5u as=0.2128p ps=1.5u w=1.12u l=0.13u
X1387 VGND.t150 VPWR.t284 VGND.t150 VGND.t1286 sg13_lv_nmos ad=0.1428p pd=1.52u as=0 ps=0 w=0.42u l=1u
X1388 a_10292_4620# sg13cmos5l_buf_16_2.X VGND.t82 VGND.t122 sg13_lv_nmos ad=0.1406p pd=1.12u as=0.1406p ps=1.12u w=0.74u l=0.13u
X1389 sg13cmos5l_and2_2_6.A a_3694_10704# VGND.t384 VGND.t156 sg13_lv_nmos ad=0.1406p pd=1.12u as=0.1406p ps=1.12u w=0.74u l=0.13u
X1390 VGND.t222 a_3668_4620# sg13cmos5l_buf_16_8.A VGND.t464 sg13_lv_nmos ad=0.1406p pd=1.12u as=0.1406p ps=1.12u w=0.74u l=0.13u
X1391 VGND.t332 a_4052_12934# sg13cmos5l_buf_16_15.A VGND.t723 sg13_lv_nmos ad=0.1406p pd=1.12u as=0.1406p ps=1.12u w=0.74u l=0.13u
X1392 VPWR.t474 a_3668_9156# sg13cmos5l_buf_16_13.A VPWR.t3 sg13_lv_pmos ad=0.2128p pd=1.5u as=0.2128p ps=1.5u w=1.12u l=0.13u
X1393 VPWR.t712 a_3694_8434# sg13cmos5l_buf_16_34.A VPWR.t3 sg13_lv_pmos ad=0.2128p pd=1.5u as=0.2128p ps=1.5u w=1.12u l=0.13u
X1394 VGND.t244 VPWR.t1617 VGND.t244 VGND.t40 sg13_lv_nmos ad=79.8f pd=0.8u as=0 ps=0 w=0.42u l=1u
X1395 a_10318_5410# sg13cmos5l_buf_16_3.X VPWR.t70 VPWR.t70 sg13_lv_pmos ad=0.2128p pd=1.5u as=0.2128p ps=1.5u w=1.12u l=0.13u
X1396 VPWR.t681 a_6094_10704# sg13cmos5l_buf_16_24.A VPWR.t55 sg13_lv_pmos ad=0.2128p pd=1.5u as=0.2128p ps=1.5u w=1.12u l=0.13u
X1397 sg13cmos5l_buf_1_4.A a_13768_7680# VGND.t116 VGND.t624 sg13_lv_nmos ad=0.2886p pd=2.26u as=0.14875p ps=1.16u w=0.74u l=0.13u
X1398 sg13cmos5l_buf_16_20.A a_5204_11422# VGND.t750 VGND.t156 sg13_lv_nmos ad=0.1406p pd=1.12u as=0.1406p ps=1.12u w=0.74u l=0.13u
X1399 VPWR.t56 VGND.t397 VPWR.t56 VPWR.t55 sg13_lv_pmos ad=0.34p pd=2.68u as=0 ps=0 w=1u l=1u
X1400 VGND.t41 a_6094_3144# sg13cmos5l_xor2_1_0.B VGND.t40 sg13_lv_nmos ad=0.1406p pd=1.12u as=0.1406p ps=1.12u w=0.74u l=0.13u
X1401 VGND.t1 a_4436_9910# sg13cmos5l_buf_16_14.A VGND.t179 sg13_lv_nmos ad=0.1406p pd=1.12u as=0.1406p ps=1.12u w=0.74u l=0.13u
X1402 a_5518_6922# sg13cmos5l_buf_16_28.X VPWR.t670 VPWR.t5 sg13_lv_pmos ad=0.2128p pd=1.5u as=0.2128p ps=1.5u w=1.12u l=0.13u
X1403 VGND.t871 glitch_en[0] a_1672_14516# VGND.t870 sg13_lv_nmos ad=0.14875p pd=1.16u as=0.187p ps=1.78u w=0.55u l=0.13u
X1404 VPWR.t202 a_10318_3898# sg13cmos5l_buf_16_2.X VPWR.t28 sg13_lv_pmos ad=0.2128p pd=1.5u as=0.2128p ps=1.5u w=1.12u l=0.13u
X1405 VGND.t951 sg13cmos5l_xor2_1_6.X a_14824_14516# VGND.t1471 sg13_lv_nmos ad=0.14875p pd=1.16u as=0.187p ps=1.78u w=0.55u l=0.13u
X1406 a_6859_12564# sg13cmos5l_buf_16_24.X a_6765_12564# VGND.t746 sg13_lv_nmos ad=0.1216p pd=1.02u as=0.2176p ps=1.96u w=0.64u l=0.13u
X1407 sg13cmos5l_buf_16_10.A a_3694_3898# VPWR.t881 VPWR.t28 sg13_lv_pmos ad=0.2128p pd=1.5u as=0.2128p ps=1.5u w=1.12u l=0.13u
X1408 out_xor[4] a_14824_9192# VPWR.t4 VPWR.t3 sg13_lv_pmos ad=0.42p pd=2.99u as=0.2114p ps=1.54u w=1.12u l=0.13u
X1409 VGND.t82 a_10292_4620# sg13cmos5l_buf_16_3.X VGND.t86 sg13_lv_nmos ad=0.1406p pd=1.12u as=0.1406p ps=1.12u w=0.74u l=0.13u
X1410 VGND.t871 VPWR.t1700 VGND.t897 VGND.t910 sg13_lv_nmos ad=79.8f pd=0.8u as=0 ps=0 w=0.42u l=1u
X1411 sg13cmos5l_buf_16_8.A a_3668_4620# VGND.t222 VGND.t461 sg13_lv_nmos ad=0.1406p pd=1.12u as=0.1406p ps=1.12u w=0.74u l=0.13u
X1412 VGND.t915 a_6548_13692# sg13cmos5l_buf_16_27.X VGND.t1490 sg13_lv_nmos ad=0.1406p pd=1.12u as=0.1406p ps=1.12u w=0.74u l=0.13u
X1413 VGND.t11 a_10318_8434# sg13cmos5l_buf_16_22.X VGND.t780 sg13_lv_nmos ad=0.1406p pd=1.12u as=0.1406p ps=1.12u w=0.74u l=0.13u
X1414 a_6094_3144# sg13cmos5l_buf_16_5.X VGND.t41 VGND.t40 sg13_lv_nmos ad=0.1406p pd=1.12u as=0.1406p ps=1.12u w=0.74u l=0.13u
X1415 sg13cmos5l_buf_16_14.A a_4436_9910# VGND.t1 VGND.t176 sg13_lv_nmos ad=0.1406p pd=1.12u as=0.1406p ps=1.12u w=0.74u l=0.13u
X1416 sg13cmos5l_buf_16_2.X a_10318_3898# VPWR.t202 VPWR.t28 sg13_lv_pmos ad=0.2128p pd=1.5u as=0.2128p ps=1.5u w=1.12u l=0.13u
X1417 VPWR.t905 VGND.t1028 VPWR.t905 VPWR.t55 sg13_lv_pmos ad=0.19p pd=1.38u as=0 ps=0 w=1u l=1u
X1418 VPWR.t357 VGND.t261 VPWR.t357 VPWR.t55 sg13_lv_pmos ad=0.19p pd=1.38u as=0 ps=0 w=1u l=1u
X1419 VPWR.t1088 VGND.t11 VPWR.t1086 VPWR.t3 sg13_lv_pmos ad=0.19p pd=1.38u as=0 ps=0 w=1u l=1u
X1420 sg13cmos5l_buf_16_20.A a_5204_11422# VGND.t384 VGND.t156 sg13_lv_nmos ad=0.1406p pd=1.12u as=0.2516p ps=2.16u w=0.74u l=0.13u
X1421 VGND.t358 a_5518_6922# sg13cmos5l_buf_16_6.X VGND.t668 sg13_lv_nmos ad=0.1406p pd=1.12u as=0.1406p ps=1.12u w=0.74u l=0.13u
X1422 VPWR.t80 VGND.t413 VPWR.t79 VPWR.t3 sg13_lv_pmos ad=0.34p pd=2.68u as=0 ps=0 w=1u l=1u
X1423 VPWR.t28 VGND.t282 VPWR.t28 VPWR.t28 sg13_lv_pmos ad=0.34p pd=2.68u as=0 ps=0 w=1u l=1u
X1424 a_10318_5410# sg13cmos5l_buf_16_3.X VPWR.t70 VPWR.t70 sg13_lv_pmos ad=0.2128p pd=1.5u as=0.3808p ps=2.92u w=1.12u l=0.13u
X1425 VGND.t1153 VPWR.t1634 VGND.t1153 VGND.t1157 sg13_lv_nmos ad=0.1428p pd=1.52u as=0 ps=0 w=0.42u l=1u
X1426 VGND.t1248 VPWR.t1614 VGND.t1248 VGND.t40 sg13_lv_nmos ad=0.1428p pd=1.52u as=0 ps=0 w=0.42u l=1u
X1427 sg13cmos5l_buf_16_28.X a_5684_6132# VGND.t358 VGND.t839 sg13_lv_nmos ad=0.1406p pd=1.12u as=0.1406p ps=1.12u w=0.74u l=0.13u
X1428 VPWR.t189 sg13cmos5l_and2_2_6.X a_6836_9156# VPWR.t3 sg13_lv_pmos ad=0.3808p pd=2.92u as=0.2128p ps=1.5u w=1.12u l=0.13u
X1429 VGND.t397 VPWR.t4 VGND.t397 VGND.t1111 sg13_lv_nmos ad=79.8f pd=0.8u as=0 ps=0 w=0.42u l=1u
X1430 a_5518_6922# sg13cmos5l_buf_16_28.X VPWR.t667 VPWR.t5 sg13_lv_pmos ad=0.2128p pd=1.5u as=0.3808p ps=2.92u w=1.12u l=0.13u
X1431 sg13cmos5l_buf_16_39.A a_8494_3144# VPWR.t21 VPWR.t20 sg13_lv_pmos ad=0.2128p pd=1.5u as=0.2128p ps=1.5u w=1.12u l=0.13u
X1432 a_4462_5410# sg13cmos5l_and2_2_0.X VGND.t222 VGND.t224 sg13_lv_nmos ad=0.1406p pd=1.12u as=0.1406p ps=1.12u w=0.74u l=0.13u
X1433 VGND.t315 VPWR.t1683 VGND.t958 VGND.t957 sg13_lv_nmos ad=79.8f pd=0.8u as=0 ps=0 w=0.42u l=1u
X1434 sg13cmos5l_buf_16_6.X a_5518_6922# VGND.t358 VGND.t665 sg13_lv_nmos ad=0.1406p pd=1.12u as=0.1406p ps=1.12u w=0.74u l=0.13u
X1435 VPWR.t0 VGND.t1348 VPWR.t0 VPWR.t0 sg13_lv_pmos ad=0.34p pd=2.68u as=0 ps=0 w=1u l=1u
X1436 VPWR.t112 VGND.t315 VPWR.t111 VPWR.t13 sg13_lv_pmos ad=0.19p pd=1.38u as=0 ps=0 w=1u l=1u
X1437 VGND.t504 sg13cmos5l_buf_16_39.A a_6164_2350# VGND.t1568 sg13_lv_nmos ad=0.1406p pd=1.12u as=0.1406p ps=1.12u w=0.74u l=0.13u
X1438 VGND.t1060 VPWR.t1660 VGND.t1060 VGND.t1063 sg13_lv_nmos ad=79.8f pd=0.8u as=0 ps=0 w=0.42u l=1u
X1439 VGND.t92 VPWR.t28 VGND.t112 VGND.t40 sg13_lv_nmos ad=79.8f pd=0.8u as=0 ps=0 w=0.42u l=1u
X1440 VGND.t912 a_4174_13728# sg13cmos5l_buf_16_18.A VGND.t1464 sg13_lv_nmos ad=0.1406p pd=1.12u as=0.1406p ps=1.12u w=0.74u l=0.13u
X1441 VPWR.t434 VGND.t358 VPWR.t433 VPWR.t70 sg13_lv_pmos ad=0.34p pd=2.68u as=0 ps=0 w=1u l=1u
X1442 sg13cmos5l_xor2_1_7.X a_13745_11508# a_13916_11752# VPWR.t13 sg13_lv_pmos ad=0.3808p pd=2.92u as=0.2128p ps=1.5u w=1.12u l=0.13u
X1443 sg13cmos5l_buf_16_22.X a_10318_8434# VPWR.t245 VPWR.t3 sg13_lv_pmos ad=0.2128p pd=1.5u as=0.2128p ps=1.5u w=1.12u l=0.13u
X1444 VPWR.t21 a_8494_3144# sg13cmos5l_buf_16_39.A VPWR.t20 sg13_lv_pmos ad=0.2128p pd=1.5u as=0.2128p ps=1.5u w=1.12u l=0.13u
X1445 out_xor[4] a_14824_9192# VGND.t397 VGND.t574 sg13_lv_nmos ad=0.2886p pd=2.26u as=0.14875p ps=1.16u w=0.74u l=0.13u
X1446 VPWR.t880 sg13cmos5l_xor2_1_0.B a_8564_2680# VPWR.t20 sg13_lv_pmos ad=0.2128p pd=1.5u as=0.2128p ps=1.5u w=1.12u l=0.13u
X1447 VPWR.t1608 VGND.t275 VPWR.t1114 VPWR.t5 sg13_lv_pmos ad=0.19p pd=1.38u as=0 ps=0 w=1u l=1u
X1448 sg13cmos5l_buf_16_24.A a_6094_10704# VPWR.t683 VPWR.t55 sg13_lv_pmos ad=0.2128p pd=1.5u as=0.2128p ps=1.5u w=1.12u l=0.13u
X1449 VPWR.t1098 VGND.t11 VPWR.t1097 VPWR.t3 sg13_lv_pmos ad=0.34p pd=2.68u as=0 ps=0 w=1u l=1u
X1450 VGND.t915 glitch_en[3] a_7432_14516# VGND.t1481 sg13_lv_nmos ad=0.14875p pd=1.16u as=0.187p ps=1.78u w=0.55u l=0.13u
X1451 VPWR.t773 a_3668_4620# sg13cmos5l_buf_16_8.A VPWR.t28 sg13_lv_pmos ad=0.2128p pd=1.5u as=0.2128p ps=1.5u w=1.12u l=0.13u
X1452 sg13cmos5l_buf_16_34.X a_3694_7680# VPWR.t1335 VPWR.t5 sg13_lv_pmos ad=0.2128p pd=1.5u as=0.2128p ps=1.5u w=1.12u l=0.13u
X1453 VGND.t639 VPWR.t914 VGND.t639 VGND.t932 sg13_lv_nmos ad=0.1428p pd=1.52u as=0 ps=0 w=0.42u l=1u
X1454 VPWR.t1020 VGND.t912 VPWR.t1019 VPWR.t292 sg13_lv_pmos ad=0.34p pd=2.68u as=0 ps=0 w=1u l=1u
X1455 VGND.t82 a_10292_4620# sg13cmos5l_buf_16_3.X VGND.t81 sg13_lv_nmos ad=0.1406p pd=1.12u as=0.1406p ps=1.12u w=0.74u l=0.13u
X1456 VPWR.t245 a_10318_8434# sg13cmos5l_buf_16_22.X VPWR.t3 sg13_lv_pmos ad=0.2128p pd=1.5u as=0.2128p ps=1.5u w=1.12u l=0.13u
X1457 VGND.t693 VPWR.t1697 VGND.t693 VGND.t917 sg13_lv_nmos ad=79.8f pd=0.8u as=0 ps=0 w=0.42u l=1u
X1458 VPWR.t631 sg13cmos5l_buf_16_37.A a_7796_12934# VPWR.t8 sg13_lv_pmos ad=0.2128p pd=1.5u as=0.2128p ps=1.5u w=1.12u l=0.13u
X1459 VPWR.t64 VGND.t165 VPWR.t63 VPWR.t55 sg13_lv_pmos ad=0.34p pd=2.68u as=0 ps=0 w=1u l=1u
X1460 VPWR.t70 a_8110_6168# sg13cmos5l_buf_16_38.A VPWR.t70 sg13_lv_pmos ad=0.2128p pd=1.5u as=0.2128p ps=1.5u w=1.12u l=0.13u
X1461 a_8948_13692# sg13cmos5l_buf_16_23.X VPWR.t631 VPWR.t8 sg13_lv_pmos ad=0.2128p pd=1.5u as=0.2128p ps=1.5u w=1.12u l=0.13u
X1462 VPWR.t118 VGND.t377 VPWR.t1057 VPWR.t13 sg13_lv_pmos ad=0.34p pd=2.68u as=0 ps=0 w=1u l=1u
X1463 VPWR.t34 VGND.t244 VPWR.t32 VPWR.t20 sg13_lv_pmos ad=0.19p pd=1.38u as=0 ps=0 w=1u l=1u
X1464 VGND.t491 sg13cmos5l_buf_16_30.A a_5710_1632# VGND.t856 sg13_lv_nmos ad=0.1406p pd=1.12u as=0.1406p ps=1.12u w=0.74u l=0.13u
X1465 sg13cmos5l_buf_16_37.X a_7796_12934# VGND.t315 VGND.t615 sg13_lv_nmos ad=0.1406p pd=1.12u as=0.1406p ps=1.12u w=0.74u l=0.13u
X1466 VPWR.t757 a_6094_4656# sg13cmos5l_buf_16_31.X VPWR.t28 sg13_lv_pmos ad=0.2128p pd=1.5u as=0.2128p ps=1.5u w=1.12u l=0.13u
X1467 VGND.t573 VPWR.t304 VGND.t573 VGND.t994 sg13_lv_nmos ad=0.1428p pd=1.52u as=0 ps=0 w=0.42u l=1u
X1468 sg13cmos5l_buf_16_8.A a_3668_4620# VPWR.t769 VPWR.t28 sg13_lv_pmos ad=0.2128p pd=1.5u as=0.2128p ps=1.5u w=1.12u l=0.13u
X1469 VPWR.t527 sg13cmos5l_and2_2_0.X a_4462_5410# VPWR.t70 sg13_lv_pmos ad=0.2128p pd=1.5u as=0.2128p ps=1.5u w=1.12u l=0.13u
X1470 VGND.t1125 VPWR.t315 VGND.t1125 VGND.t1147 sg13_lv_nmos ad=0.1428p pd=1.52u as=0 ps=0 w=0.42u l=1u
X1471 VGND.t942 a_4174_13728# sg13cmos5l_buf_16_18.A VGND.t1460 sg13_lv_nmos ad=0.1406p pd=1.12u as=0.1406p ps=1.12u w=0.74u l=0.13u
X1472 VPWR.t56 sg13cmos5l_and2_2_3.B a_13581_9988# VPWR.t55 sg13_lv_pmos ad=0.1918p pd=1.5u as=0.1596p ps=1.22u w=0.84u l=0.13u
X1473 sg13cmos5l_buf_16_35.A a_6766_8434# VGND.t800 VGND.t1557 sg13_lv_nmos ad=0.1406p pd=1.12u as=0.1406p ps=1.12u w=0.74u l=0.13u
X1474 VGND.t1 sg13cmos5l_buf_16_14.A a_3668_9156# VGND.t662 sg13_lv_nmos ad=0.2516p pd=2.16u as=0.1406p ps=1.12u w=0.74u l=0.13u
X1475 a_13897_13012# sg13cmos5l_and2_2_4.B VGND.t573 VGND.t1526 sg13_lv_nmos ad=0.1216p pd=1.02u as=0.1331p ps=1.12u w=0.64u l=0.13u
X1476 a_5710_1632# sg13cmos5l_buf_16_30.A VGND.t150 VGND.t853 sg13_lv_nmos ad=0.1406p pd=1.12u as=0.2516p ps=2.16u w=0.74u l=0.13u
X1477 VGND.t1219 VPWR.t382 VGND.t126 VGND.t1218 sg13_lv_nmos ad=0.1428p pd=1.52u as=0 ps=0 w=0.42u l=1u
X1478 VPWR.t693 sg13cmos5l_buf_16_34.X a_3694_10704# VPWR.t55 sg13_lv_pmos ad=0.2128p pd=1.5u as=0.2128p ps=1.5u w=1.12u l=0.13u
X1479 VPWR.t830 a_3694_10704# sg13cmos5l_and2_2_6.A VPWR.t55 sg13_lv_pmos ad=0.2128p pd=1.5u as=0.2128p ps=1.5u w=1.12u l=0.13u
X1480 VPWR.t48 VGND.t1248 VPWR.t47 VPWR.t20 sg13_lv_pmos ad=0.19p pd=1.38u as=0 ps=0 w=1u l=1u
X1481 sg13cmos5l_buf_16_28.X a_5684_6132# VGND.t358 VGND.t835 sg13_lv_nmos ad=0.1406p pd=1.12u as=0.1406p ps=1.12u w=0.74u l=0.13u
X1482 VGND.t942 sg13cmos5l_buf_16_15.X a_3694_14482# VGND.t1500 sg13_lv_nmos ad=0.1406p pd=1.12u as=0.1406p ps=1.12u w=0.74u l=0.13u
X1483 VPWR.t189 sg13cmos5l_and2_2_6.X a_6836_9156# VPWR.t3 sg13_lv_pmos ad=0.2128p pd=1.5u as=0.2128p ps=1.5u w=1.12u l=0.13u
X1484 a_4462_5410# sg13cmos5l_and2_2_0.X VPWR.t524 VPWR.t70 sg13_lv_pmos ad=0.2128p pd=1.5u as=0.3808p ps=2.92u w=1.12u l=0.13u
X1485 VGND.t1393 VPWR.t24 VGND.t1395 VGND.t1394 sg13_lv_nmos ad=79.8f pd=0.8u as=0 ps=0 w=0.42u l=1u
X1486 VGND.t806 VPWR.t342 VGND.t806 VGND.t1170 sg13_lv_nmos ad=0.1428p pd=1.52u as=0 ps=0 w=0.42u l=1u
X1487 VPWR.t930 a_7796_12934# sg13cmos5l_buf_16_37.X VPWR.t8 sg13_lv_pmos ad=0.2128p pd=1.5u as=0.2128p ps=1.5u w=1.12u l=0.13u
X1488 VGND.t868 VPWR.t34 VGND.t868 VGND.t1314 sg13_lv_nmos ad=0.1428p pd=1.52u as=0 ps=0 w=0.42u l=1u
X1489 VGND.t800 a_6766_8434# sg13cmos5l_buf_16_35.A VGND.t1554 sg13_lv_nmos ad=0.1406p pd=1.12u as=0.1406p ps=1.12u w=0.74u l=0.13u
X1490 sg13cmos5l_buf_16_37.A a_8948_13692# VPWR.t631 VPWR.t8 sg13_lv_pmos ad=0.2128p pd=1.5u as=0.2128p ps=1.5u w=1.12u l=0.13u
X1491 a_3668_9156# sg13cmos5l_buf_16_14.A VGND.t1 VGND.t659 sg13_lv_nmos ad=0.1406p pd=1.12u as=0.1406p ps=1.12u w=0.74u l=0.13u
X1492 VPWR.t951 VGND.t1207 VPWR.t949 VPWR.t70 sg13_lv_pmos ad=0.19p pd=1.38u as=0 ps=0 w=1u l=1u
X1493 sg13cmos5l_buf_16_37.X a_7796_12934# VGND.t315 VGND.t611 sg13_lv_nmos ad=0.1406p pd=1.12u as=0.1406p ps=1.12u w=0.74u l=0.13u
X1494 sg13cmos5l_buf_16_1.X a_10318_5410# VGND.t82 VGND.t122 sg13_lv_nmos ad=0.1406p pd=1.12u as=0.1406p ps=1.12u w=0.74u l=0.13u
X1495 VPWR.t583 VGND.t1153 VPWR.t582 VPWR.t70 sg13_lv_pmos ad=0.34p pd=2.68u as=0 ps=0 w=1u l=1u
X1496 sg13cmos5l_buf_16_23.X a_10292_12934# VPWR.t631 VPWR.t8 sg13_lv_pmos ad=0.2128p pd=1.5u as=0.2128p ps=1.5u w=1.12u l=0.13u
X1497 VGND.t1153 VPWR.t1645 VGND.t1153 VGND.t1152 sg13_lv_nmos ad=0.1428p pd=1.52u as=0 ps=0 w=0.42u l=1u
X1498 VGND.t942 a_4174_13728# sg13cmos5l_buf_16_18.A VGND.t1456 sg13_lv_nmos ad=0.1406p pd=1.12u as=0.1406p ps=1.12u w=0.74u l=0.13u
X1499 VPWR.t930 a_8948_13692# sg13cmos5l_buf_16_37.A VPWR.t8 sg13_lv_pmos ad=0.2128p pd=1.5u as=0.2128p ps=1.5u w=1.12u l=0.13u
X1500 sg13cmos5l_buf_16_30.A a_6164_2350# VPWR.t796 VPWR.t20 sg13_lv_pmos ad=0.2128p pd=1.5u as=0.2128p ps=1.5u w=1.12u l=0.13u
X1501 sg13cmos5l_buf_16_25.A a_6836_9156# VPWR.t241 VPWR.t3 sg13_lv_pmos ad=0.2128p pd=1.5u as=0.2128p ps=1.5u w=1.12u l=0.13u
X1502 VGND.t504 a_6164_2350# sg13cmos5l_buf_16_30.A VGND.t506 sg13_lv_nmos ad=0.1406p pd=1.12u as=0.1406p ps=1.12u w=0.74u l=0.13u
X1503 sg13cmos5l_buf_16_37.A a_8948_13692# VGND.t693 VGND.t699 sg13_lv_nmos ad=0.1406p pd=1.12u as=0.2516p ps=2.16u w=0.74u l=0.13u
X1504 VPWR.t24 VGND.t584 VPWR.t24 VPWR.t0 sg13_lv_pmos ad=0.19p pd=1.38u as=0 ps=0 w=1u l=1u
X1505 sg13cmos5l_xor2_1_4.X sg13cmos5l_buf_16_22.X a_14010_8446# VGND.t155 sg13_lv_nmos ad=0.1628p pd=1.18u as=88.8f ps=0.98u w=0.74u l=0.13u
X1506 VGND.t41 a_6094_3898# sg13cmos5l_buf_16_0.A VGND.t40 sg13_lv_nmos ad=0.1406p pd=1.12u as=0.1406p ps=1.12u w=0.74u l=0.13u
X1507 VGND.t82 a_10318_5410# sg13cmos5l_buf_16_1.X VGND.t86 sg13_lv_nmos ad=0.1406p pd=1.12u as=0.1406p ps=1.12u w=0.74u l=0.13u
X1508 a_10292_12934# sg13cmos5l_buf_1_17.A VGND.t322 VGND.t323 sg13_lv_nmos ad=0.1406p pd=1.12u as=0.1406p ps=1.12u w=0.74u l=0.13u
X1509 VPWR.t794 a_6164_2350# sg13cmos5l_buf_16_30.A VPWR.t20 sg13_lv_pmos ad=0.2128p pd=1.5u as=0.2128p ps=1.5u w=1.12u l=0.13u
X1510 VPWR.t38 sg13cmos5l_buf_1_2.X a_14824_1632# VPWR.t0 sg13_lv_pmos ad=0.2114p pd=1.54u as=0.2856p ps=2.36u w=0.84u l=0.13u
X1511 sg13cmos5l_buf_16_34.X a_3694_7680# VPWR.t1331 VPWR.t5 sg13_lv_pmos ad=0.2128p pd=1.5u as=0.2128p ps=1.5u w=1.12u l=0.13u
X1512 VGND.t912 glitch_en[2] a_5992_14516# VGND.t1482 sg13_lv_nmos ad=0.14875p pd=1.16u as=0.187p ps=1.78u w=0.55u l=0.13u
X1513 sg13cmos5l_buf_1_23.A a_6161_9550# a_6332_9192# VPWR.t3 sg13_lv_pmos ad=0.3808p pd=2.92u as=0.2128p ps=1.5u w=1.12u l=0.13u
X1514 sg13cmos5l_buf_16_30.A a_6164_2350# VGND.t501 VGND.t502 sg13_lv_nmos ad=0.1406p pd=1.12u as=0.1406p ps=1.12u w=0.74u l=0.13u
X1515 VPWR.t288 VGND.t130 VPWR.t288 VPWR.t20 sg13_lv_pmos ad=0.19p pd=1.38u as=0 ps=0 w=1u l=1u
X1516 sg13cmos5l_buf_16_28.X a_5684_6132# VGND.t358 VGND.t831 sg13_lv_nmos ad=0.1406p pd=1.12u as=0.1406p ps=1.12u w=0.74u l=0.13u
X1517 out_xor[7] a_14824_14516# VGND.t951 VGND.t1523 sg13_lv_nmos ad=0.2886p pd=2.26u as=0.14875p ps=1.16u w=0.74u l=0.13u
X1518 sg13cmos5l_buf_16_28.A a_7220_5374# VGND.t282 VGND.t288 sg13_lv_nmos ad=0.1406p pd=1.12u as=0.1406p ps=1.12u w=0.74u l=0.13u
X1519 VPWR.t70 a_8110_6168# sg13cmos5l_buf_16_38.A VPWR.t70 sg13_lv_pmos ad=0.2128p pd=1.5u as=0.2128p ps=1.5u w=1.12u l=0.13u
X1520 VPWR.t28 VGND.t112 VPWR.t28 VPWR.t28 sg13_lv_pmos ad=0.19p pd=1.38u as=0 ps=0 w=1u l=1u
X1521 sg13cmos5l_buf_1_6.A sg13cmos5l_buf_16_31.X a_4986_6526# VGND.t1532 sg13_lv_nmos ad=0.1628p pd=1.18u as=88.8f ps=0.98u w=0.74u l=0.13u
X1522 sg13cmos5l_buf_16_13.A a_3668_9156# VGND.t169 VGND.t196 sg13_lv_nmos ad=0.1406p pd=1.12u as=0.1406p ps=1.12u w=0.74u l=0.13u
X1523 sg13cmos5l_buf_16_10.A a_3694_3898# VPWR.t894 VPWR.t28 sg13_lv_pmos ad=0.2128p pd=1.5u as=0.2128p ps=1.5u w=1.12u l=0.13u
X1524 VPWR.t202 a_10292_4620# sg13cmos5l_buf_16_3.X VPWR.t28 sg13_lv_pmos ad=0.2128p pd=1.5u as=0.2128p ps=1.5u w=1.12u l=0.13u
X1525 sg13cmos5l_buf_16_8.A a_3668_4620# VPWR.t765 VPWR.t28 sg13_lv_pmos ad=0.2128p pd=1.5u as=0.2128p ps=1.5u w=1.12u l=0.13u
X1526 VPWR.t386 VGND.t693 VPWR.t386 VPWR.t292 sg13_lv_pmos ad=0.34p pd=2.68u as=0 ps=0 w=1u l=1u
X1527 VPWR.t296 VGND.t934 VPWR.t296 VPWR.t292 sg13_lv_pmos ad=0.34p pd=2.68u as=0 ps=0 w=1u l=1u
X1528 a_13916_8728# sg13cmos5l_buf_16_22.X VPWR.t4 VPWR.t3 sg13_lv_pmos ad=0.2128p pd=1.5u as=0.2128p ps=1.5u w=1.12u l=0.13u
X1529 VPWR.t631 sg13cmos5l_buf_1_17.A a_10292_12934# VPWR.t8 sg13_lv_pmos ad=0.3808p pd=2.92u as=0.2128p ps=1.5u w=1.12u l=0.13u
X1530 sg13cmos5l_buf_16_5.X a_5108_838# VPWR.t19 VPWR.t0 sg13_lv_pmos ad=0.2128p pd=1.5u as=0.2128p ps=1.5u w=1.12u l=0.13u
X1531 VPWR.t566 sg13cmos5l_buf_16_10.A a_3668_3108# VPWR.t20 sg13_lv_pmos ad=0.2128p pd=1.5u as=0.2128p ps=1.5u w=1.12u l=0.13u
X1532 VGND.t282 a_7220_5374# sg13cmos5l_buf_16_28.A VGND.t285 sg13_lv_nmos ad=0.1406p pd=1.12u as=0.1406p ps=1.12u w=0.74u l=0.13u
X1533 sg13cmos5l_buf_16_38.A a_8110_6168# VPWR.t70 VPWR.t70 sg13_lv_pmos ad=0.2128p pd=1.5u as=0.2128p ps=1.5u w=1.12u l=0.13u
X1534 VGND.t358 a_9524_6886# sg13cmos5l_buf_16_4.X VGND.t820 sg13_lv_nmos ad=0.1406p pd=1.12u as=0.1406p ps=1.12u w=0.74u l=0.13u
X1535 VPWR.t1498 a_6548_13692# sg13cmos5l_buf_16_27.X VPWR.t8 sg13_lv_pmos ad=0.2128p pd=1.5u as=0.2128p ps=1.5u w=1.12u l=0.13u
X1536 VPWR.t1365 a_5684_6132# sg13cmos5l_buf_16_28.X VPWR.t70 sg13_lv_pmos ad=0.2128p pd=1.5u as=0.2128p ps=1.5u w=1.12u l=0.13u
X1537 sg13cmos5l_buf_16_2.A a_9262_7680# VGND.t11 VGND.t16 sg13_lv_nmos ad=0.1406p pd=1.12u as=0.1406p ps=1.12u w=0.74u l=0.13u
X1538 sg13cmos5l_buf_16_23.X a_10292_12934# VGND.t652 VGND.t653 sg13_lv_nmos ad=0.1406p pd=1.12u as=0.1406p ps=1.12u w=0.74u l=0.13u
X1539 VGND.t1 a_6836_9156# sg13cmos5l_buf_16_25.A VGND.t96 sg13_lv_nmos ad=0.1406p pd=1.12u as=0.1406p ps=1.12u w=0.74u l=0.13u
X1540 VPWR.t245 VGND.t1079 VPWR.t245 VPWR.t3 sg13_lv_pmos ad=0.34p pd=2.68u as=0 ps=0 w=1u l=1u
X1541 VGND.t41 a_6094_3898# sg13cmos5l_buf_16_0.A VGND.t40 sg13_lv_nmos ad=0.1406p pd=1.12u as=0.1406p ps=1.12u w=0.74u l=0.13u
X1542 VGND.t1020 VPWR.t905 VGND.t1028 VGND.t156 sg13_lv_nmos ad=79.8f pd=0.8u as=0 ps=0 w=0.42u l=1u
X1543 sg13cmos5l_buf_16_3.X a_10292_4620# VPWR.t202 VPWR.t28 sg13_lv_pmos ad=0.2128p pd=1.5u as=0.2128p ps=1.5u w=1.12u l=0.13u
X1544 sg13cmos5l_and2_2_6.A a_3694_10704# VPWR.t832 VPWR.t55 sg13_lv_pmos ad=0.2128p pd=1.5u as=0.2128p ps=1.5u w=1.12u l=0.13u
X1545 sg13cmos5l_buf_16_33.A a_3694_14482# VGND.t942 VGND.t1516 sg13_lv_nmos ad=0.1406p pd=1.12u as=0.1406p ps=1.12u w=0.74u l=0.13u
X1546 VGND.t413 sg13cmos5l_buf_16_25.A a_6766_8434# VGND.t580 sg13_lv_nmos ad=0.1406p pd=1.12u as=0.1406p ps=1.12u w=0.74u l=0.13u
X1547 VPWR.t19 a_5108_838# sg13cmos5l_buf_16_5.X VPWR.t0 sg13_lv_pmos ad=0.2128p pd=1.5u as=0.2128p ps=1.5u w=1.12u l=0.13u
X1548 sg13cmos5l_buf_16_4.X a_9524_6886# VGND.t358 VGND.t817 sg13_lv_nmos ad=0.1406p pd=1.12u as=0.1406p ps=1.12u w=0.74u l=0.13u
X1549 VPWR.t297 VGND.t573 VPWR.t297 VPWR.t8 sg13_lv_pmos ad=0.34p pd=2.68u as=0 ps=0 w=1u l=1u
X1550 VPWR.t363 VGND.t1060 VPWR.t362 VPWR.t3 sg13_lv_pmos ad=0.34p pd=2.68u as=0 ps=0 w=1u l=1u
X1551 VPWR.t125 VGND.t1020 VPWR.t125 VPWR.t13 sg13_lv_pmos ad=0.19p pd=1.38u as=0 ps=0 w=1u l=1u
X1552 VGND.t1004 VPWR.t1668 VGND.t1004 VGND.t156 sg13_lv_nmos ad=0.1428p pd=1.52u as=0 ps=0 w=0.42u l=1u
X1553 VPWR.t345 VGND.t1060 VPWR.t344 VPWR.t55 sg13_lv_pmos ad=0.34p pd=2.68u as=0 ps=0 w=1u l=1u
X1554 sg13cmos5l_buf_16_0.A a_6094_3898# VGND.t41 VGND.t40 sg13_lv_nmos ad=0.1406p pd=1.12u as=0.1406p ps=1.12u w=0.74u l=0.13u
X1555 VGND.t1219 VPWR.t381 VGND.t1219 VGND.t1240 sg13_lv_nmos ad=0.1428p pd=1.52u as=0 ps=0 w=0.42u l=1u
X1556 VPWR.t631 a_10292_12934# sg13cmos5l_buf_16_23.X VPWR.t8 sg13_lv_pmos ad=0.2128p pd=1.5u as=0.2128p ps=1.5u w=1.12u l=0.13u
X1557 VPWR.t631 sg13cmos5l_buf_1_17.A a_10292_12934# VPWR.t8 sg13_lv_pmos ad=0.2128p pd=1.5u as=0.2128p ps=1.5u w=1.12u l=0.13u
X1558 VGND.t244 VPWR.t1620 VGND.t244 VGND.t40 sg13_lv_nmos ad=0.1428p pd=1.52u as=0 ps=0 w=0.42u l=1u
X1559 VPWR.t606 a_7220_5374# sg13cmos5l_buf_16_28.A VPWR.t70 sg13_lv_pmos ad=0.2128p pd=1.5u as=0.2128p ps=1.5u w=1.12u l=0.13u
X1560 sg13cmos5l_buf_16_15.X a_3668_12180# VPWR.t655 VPWR.t13 sg13_lv_pmos ad=0.2128p pd=1.5u as=0.2128p ps=1.5u w=1.12u l=0.13u
X1561 VGND.t322 VPWR.t133 VGND.t573 VGND.t967 sg13_lv_nmos ad=79.8f pd=0.8u as=0 ps=0 w=0.42u l=1u
X1562 VPWR.t1494 a_6548_13692# sg13cmos5l_buf_16_27.X VPWR.t8 sg13_lv_pmos ad=0.2128p pd=1.5u as=0.2128p ps=1.5u w=1.12u l=0.13u
X1563 sg13cmos5l_buf_16_23.X a_10292_12934# VGND.t315 VGND.t648 sg13_lv_nmos ad=0.1406p pd=1.12u as=0.1406p ps=1.12u w=0.74u l=0.13u
X1564 VPWR.t504 a_3668_3108# sg13cmos5l_buf_16_7.A VPWR.t20 sg13_lv_pmos ad=0.2128p pd=1.5u as=0.2128p ps=1.5u w=1.12u l=0.13u
X1565 VGND.t112 a_8494_3144# sg13cmos5l_buf_16_39.A VGND.t40 sg13_lv_nmos ad=0.1406p pd=1.12u as=0.1406p ps=1.12u w=0.74u l=0.13u
X1566 VGND.t244 VPWR.t381 VGND.t130 VGND.t40 sg13_lv_nmos ad=0.1428p pd=1.52u as=0 ps=0 w=0.42u l=1u
X1567 a_5204_11422# sg13cmos5l_buf_16_19.A VPWR.t663 VPWR.t13 sg13_lv_pmos ad=0.2128p pd=1.5u as=0.2128p ps=1.5u w=1.12u l=0.13u
X1568 a_13745_11508# sg13cmos5l_buf_1_15.X VGND.t157 VGND.t156 sg13_lv_nmos ad=0.17462p pd=1.185u as=0.374p ps=2.46u w=0.55u l=0.13u
X1569 VPWR.t560 a_6862_9946# sg13cmos5l_buf_16_24.X VPWR.t55 sg13_lv_pmos ad=0.2128p pd=1.5u as=0.2128p ps=1.5u w=1.12u l=0.13u
X1570 VGND.t82 a_10318_5410# sg13cmos5l_buf_16_1.X VGND.t81 sg13_lv_nmos ad=0.1406p pd=1.12u as=0.1406p ps=1.12u w=0.74u l=0.13u
X1571 VPWR.t427 VGND.t1153 VPWR.t586 VPWR.t70 sg13_lv_pmos ad=0.34p pd=2.68u as=0 ps=0 w=1u l=1u
X1572 sg13cmos5l_and2_2_3.B a_13576_14516# VPWR.t914 VPWR.t292 sg13_lv_pmos ad=0.42p pd=2.99u as=0.2114p ps=1.54u w=1.12u l=0.13u
X1573 VGND.t27 sg13cmos5l_buf_16_11.A a_3668_4620# VGND.t561 sg13_lv_nmos ad=0.1406p pd=1.12u as=0.1406p ps=1.12u w=0.74u l=0.13u
X1574 sg13cmos5l_buf_16_28.A a_7220_5374# VPWR.t602 VPWR.t70 sg13_lv_pmos ad=0.2128p pd=1.5u as=0.2128p ps=1.5u w=1.12u l=0.13u
X1575 sg13cmos5l_buf_16_33.A a_3694_14482# VPWR.t1523 VPWR.t292 sg13_lv_pmos ad=0.2128p pd=1.5u as=0.2128p ps=1.5u w=1.12u l=0.13u
X1576 VPWR.t1090 VGND.t11 VPWR.t1089 VPWR.t3 sg13_lv_pmos ad=0.34p pd=2.68u as=0 ps=0 w=1u l=1u
X1577 VGND.t27 a_4462_5410# sg13cmos5l_buf_16_11.A VGND.t33 sg13_lv_nmos ad=0.1406p pd=1.12u as=0.1406p ps=1.12u w=0.74u l=0.13u
X1578 VGND.t41 a_6094_3144# sg13cmos5l_xor2_1_0.B VGND.t40 sg13_lv_nmos ad=0.1406p pd=1.12u as=0.1406p ps=1.12u w=0.74u l=0.13u
X1579 VPWR.t360 VGND.t1020 VPWR.t360 VPWR.t55 sg13_lv_pmos ad=0.34p pd=2.68u as=0 ps=0 w=1u l=1u
X1580 sg13cmos5l_buf_16_10.A a_3694_3898# VPWR.t890 VPWR.t28 sg13_lv_pmos ad=0.2128p pd=1.5u as=0.2128p ps=1.5u w=1.12u l=0.13u
X1581 VGND.t198 sg13cmos5l_buf_16_8.A a_3694_3898# VGND.t40 sg13_lv_nmos ad=0.1406p pd=1.12u as=0.1406p ps=1.12u w=0.74u l=0.13u
X1582 sg13cmos5l_buf_16_15.X a_3668_12180# VPWR.t651 VPWR.t13 sg13_lv_pmos ad=0.2128p pd=1.5u as=0.2128p ps=1.5u w=1.12u l=0.13u
X1583 sg13cmos5l_buf_16_35.A a_6766_8434# VPWR.t878 VPWR.t3 sg13_lv_pmos ad=0.2128p pd=1.5u as=0.2128p ps=1.5u w=1.12u l=0.13u
X1584 VPWR.t30 VGND.t130 VPWR.t30 VPWR.t20 sg13_lv_pmos ad=0.19p pd=1.38u as=0 ps=0 w=1u l=1u
X1585 VGND.t315 VPWR.t1691 VGND.t315 VGND.t954 sg13_lv_nmos ad=0.1428p pd=1.52u as=0 ps=0 w=0.42u l=1u
X1586 sg13cmos5l_buf_16_20.A a_5204_11422# VPWR.t1289 VPWR.t13 sg13_lv_pmos ad=0.2128p pd=1.5u as=0.2128p ps=1.5u w=1.12u l=0.13u
X1587 VPWR.t556 a_6862_9946# sg13cmos5l_buf_16_24.X VPWR.t55 sg13_lv_pmos ad=0.2128p pd=1.5u as=0.2128p ps=1.5u w=1.12u l=0.13u
X1588 VGND.t1207 VPWR.t1628 VGND.t1207 VGND.t1212 sg13_lv_nmos ad=79.8f pd=0.8u as=0 ps=0 w=0.42u l=1u
X1589 sg13cmos5l_buf_16_2.A a_9262_7680# VGND.t11 VGND.t12 sg13_lv_nmos ad=0.1406p pd=1.12u as=0.1406p ps=1.12u w=0.74u l=0.13u
X1590 a_14010_8446# sg13cmos5l_buf_16_2.A VGND.t116 VGND.t115 sg13_lv_nmos ad=88.8f pd=0.98u as=0.15245p ps=1.17u w=0.74u l=0.13u
X1591 VPWR.t324 VGND.t999 VPWR.t322 VPWR.t13 sg13_lv_pmos ad=0.19p pd=1.38u as=0 ps=0 w=1u l=1u
X1592 VPWR.t876 sg13cmos5l_buf_16_25.A a_6766_8434# VPWR.t3 sg13_lv_pmos ad=0.2128p pd=1.5u as=0.2128p ps=1.5u w=1.12u l=0.13u
X1593 VPWR.t1468 a_4174_13728# sg13cmos5l_buf_16_18.A VPWR.t8 sg13_lv_pmos ad=0.2128p pd=1.5u as=0.2128p ps=1.5u w=1.12u l=0.13u
X1594 VPWR.t905 VGND.t1085 VPWR.t905 VPWR.t55 sg13_lv_pmos ad=0.34p pd=2.68u as=0 ps=0 w=1u l=1u
X1595 VPWR.t480 a_3668_9156# sg13cmos5l_buf_16_13.A VPWR.t3 sg13_lv_pmos ad=0.2128p pd=1.5u as=0.2128p ps=1.5u w=1.12u l=0.13u
X1596 sg13cmos5l_buf_16_1.X a_10318_5410# VPWR.t400 VPWR.t70 sg13_lv_pmos ad=0.2128p pd=1.5u as=0.2128p ps=1.5u w=1.12u l=0.13u
X1597 VGND.t1153 VPWR.t1636 VGND.t1153 VGND.t1152 sg13_lv_nmos ad=0.1428p pd=1.52u as=0 ps=0 w=0.42u l=1u
X1598 VGND.t350 a_6094_10704# sg13cmos5l_buf_16_24.A VGND.t156 sg13_lv_nmos ad=0.1406p pd=1.12u as=0.1406p ps=1.12u w=0.74u l=0.13u
X1599 VGND.t150 a_3694_2386# sg13cmos5l_buf_16_7.X VGND.t481 sg13_lv_nmos ad=0.1406p pd=1.12u as=0.1406p ps=1.12u w=0.74u l=0.13u
X1600 VPWR.t19 a_5108_838# sg13cmos5l_buf_16_5.X VPWR.t0 sg13_lv_pmos ad=0.2128p pd=1.5u as=0.2128p ps=1.5u w=1.12u l=0.13u
X1601 VGND.t1 sg13cmos5l_buf_16_20.A a_4436_9910# VGND.t217 sg13_lv_nmos ad=0.1406p pd=1.12u as=0.1406p ps=1.12u w=0.74u l=0.13u
X1602 VGND.t41 a_6094_3144# sg13cmos5l_xor2_1_0.B VGND.t40 sg13_lv_nmos ad=0.1406p pd=1.12u as=0.1406p ps=1.12u w=0.74u l=0.13u
X1603 VGND.t5 a_9262_7680# sg13cmos5l_buf_16_2.A VGND.t8 sg13_lv_nmos ad=0.1406p pd=1.12u as=0.1406p ps=1.12u w=0.74u l=0.13u
X1604 sg13cmos5l_buf_16_15.X a_3668_12180# VPWR.t647 VPWR.t13 sg13_lv_pmos ad=0.2128p pd=1.5u as=0.2128p ps=1.5u w=1.12u l=0.13u
X1605 VGND.t1413 VPWR.t18 VGND.t1415 VGND.t1414 sg13_lv_nmos ad=79.8f pd=0.8u as=0 ps=0 w=0.42u l=1u
X1606 sg13cmos5l_buf_16_6.X a_5518_6922# VPWR.t1212 VPWR.t5 sg13_lv_pmos ad=0.2128p pd=1.5u as=0.2128p ps=1.5u w=1.12u l=0.13u
X1607 VPWR.t202 a_10318_3898# sg13cmos5l_buf_16_2.X VPWR.t28 sg13_lv_pmos ad=0.3976p pd=2.95u as=0.2128p ps=1.5u w=1.12u l=0.13u
X1608 VGND.t358 a_8110_6168# sg13cmos5l_buf_16_38.A VGND.t553 sg13_lv_nmos ad=0.2516p pd=2.16u as=0.1406p ps=1.12u w=0.74u l=0.13u
X1609 a_4986_6526# sg13cmos5l_buf_16_8.A VGND.t358 VGND.t684 sg13_lv_nmos ad=88.8f pd=0.98u as=0.15245p ps=1.17u w=0.74u l=0.13u
X1610 VGND.t261 VPWR.t357 VGND.t261 VGND.t1072 sg13_lv_nmos ad=79.8f pd=0.8u as=0 ps=0 w=0.42u l=1u
X1611 VPWR.t943 VGND.t1207 VPWR.t941 VPWR.t70 sg13_lv_pmos ad=0.19p pd=1.38u as=0 ps=0 w=1u l=1u
X1612 VPWR.t292 VGND.t693 VPWR.t292 VPWR.t292 sg13_lv_pmos ad=0.19p pd=1.38u as=0 ps=0 w=1u l=1u
X1613 sg13cmos5l_buf_16_20.A a_5204_11422# VPWR.t1286 VPWR.t13 sg13_lv_pmos ad=0.2128p pd=1.5u as=0.3976p ps=2.95u w=1.12u l=0.13u
X1614 VPWR.t7 sg13cmos5l_buf_1_2.A a_8104_1632# VPWR.t0 sg13_lv_pmos ad=0.2114p pd=1.54u as=0.2856p ps=2.36u w=0.84u l=0.13u
X1615 VPWR.t381 VGND.t130 VPWR.t381 VPWR.t28 sg13_lv_pmos ad=0.34p pd=2.68u as=0 ps=0 w=1u l=1u
X1616 VGND.t11 a_7629_8028# sg13cmos5l_and2_2_6.X VGND.t801 sg13_lv_nmos ad=0.2812p pd=2.24u as=0.1406p ps=1.12u w=0.74u l=0.13u
X1617 sg13cmos5l_buf_16_13.A a_3668_9156# VPWR.t476 VPWR.t3 sg13_lv_pmos ad=0.2128p pd=1.5u as=0.2128p ps=1.5u w=1.12u l=0.13u
X1618 VPWR.t400 a_10318_5410# sg13cmos5l_buf_16_1.X VPWR.t70 sg13_lv_pmos ad=0.2128p pd=1.5u as=0.2128p ps=1.5u w=1.12u l=0.13u
X1619 a_12054_14086# sg13cmos5l_buf_16_27.X sg13cmos5l_xor2_1_6.X VGND.t1527 sg13_lv_nmos ad=88.8f pd=0.98u as=0.1628p ps=1.18u w=0.74u l=0.13u
X1620 out_xor[5] a_14824_10704# VPWR.t56 VPWR.t55 sg13_lv_pmos ad=0.42p pd=2.99u as=0.2114p ps=1.54u w=1.12u l=0.13u
X1621 sg13cmos5l_buf_16_7.X a_3694_2386# VGND.t150 VGND.t478 sg13_lv_nmos ad=0.1406p pd=1.12u as=0.1406p ps=1.12u w=0.74u l=0.13u
X1622 VGND.t1248 VPWR.t1615 VGND.t1248 VGND.t40 sg13_lv_nmos ad=0.1428p pd=1.52u as=0 ps=0 w=0.42u l=1u
X1623 a_4436_9910# sg13cmos5l_buf_16_20.A VGND.t1 VGND.t214 sg13_lv_nmos ad=0.1406p pd=1.12u as=0.1406p ps=1.12u w=0.74u l=0.13u
X1624 sg13cmos5l_xor2_1_0.B a_6094_3144# VGND.t41 VGND.t40 sg13_lv_nmos ad=0.1406p pd=1.12u as=0.1406p ps=1.12u w=0.74u l=0.13u
X1625 VGND.t358 sg13cmos5l_buf_16_28.A a_5684_6132# VGND.t422 sg13_lv_nmos ad=0.2516p pd=2.16u as=0.1406p ps=1.12u w=0.74u l=0.13u
X1626 VPWR.t1210 a_5518_6922# sg13cmos5l_buf_16_6.X VPWR.t5 sg13_lv_pmos ad=0.2128p pd=1.5u as=0.2128p ps=1.5u w=1.12u l=0.13u
X1627 sg13cmos5l_buf_16_2.X a_10318_3898# VPWR.t202 VPWR.t28 sg13_lv_pmos ad=0.2128p pd=1.5u as=0.2128p ps=1.5u w=1.12u l=0.13u
X1628 VGND.t112 sg13cmos5l_buf_16_2.A a_10318_3898# VGND.t40 sg13_lv_nmos ad=0.1406p pd=1.12u as=0.1406p ps=1.12u w=0.74u l=0.13u
X1629 VGND.t851 VPWR.t381 VGND.t366 VGND.t1242 sg13_lv_nmos ad=0.1428p pd=1.52u as=0 ps=0 w=0.42u l=1u
X1630 VPWR.t1464 a_4174_13728# sg13cmos5l_buf_16_18.A VPWR.t8 sg13_lv_pmos ad=0.2128p pd=1.5u as=0.2128p ps=1.5u w=1.12u l=0.13u
X1631 sg13cmos5l_buf_16_28.A a_7220_5374# VPWR.t599 VPWR.t70 sg13_lv_pmos ad=0.2128p pd=1.5u as=0.3976p ps=2.95u w=1.12u l=0.13u
X1632 VPWR.t129 VGND.t322 VPWR.t129 VPWR.t8 sg13_lv_pmos ad=0.34p pd=2.68u as=0 ps=0 w=1u l=1u
X1633 VGND.t350 sg13cmos5l_buf_16_33.A a_6094_10704# VGND.t156 sg13_lv_nmos ad=0.1406p pd=1.12u as=0.1406p ps=1.12u w=0.74u l=0.13u
X1634 VPWR.t297 VGND.t639 VPWR.t297 VPWR.t8 sg13_lv_pmos ad=0.34p pd=2.68u as=0 ps=0 w=1u l=1u
X1635 VGND.t397 VPWR.t56 VGND.t397 VGND.t1088 sg13_lv_nmos ad=79.8f pd=0.8u as=0 ps=0 w=0.42u l=1u
X1636 VGND.t358 a_5518_6922# sg13cmos5l_buf_16_6.X VGND.t675 sg13_lv_nmos ad=0.1406p pd=1.12u as=0.1406p ps=1.12u w=0.74u l=0.13u
X1637 VPWR.t1578 sg13cmos5l_buf_16_39.A a_6164_2350# VPWR.t20 sg13_lv_pmos ad=0.2128p pd=1.5u as=0.2128p ps=1.5u w=1.12u l=0.13u
X1638 VPWR.t905 VGND.t1079 VPWR.t905 VPWR.t55 sg13_lv_pmos ad=0.34p pd=2.68u as=0 ps=0 w=1u l=1u
X1639 sg13cmos5l_buf_16_11.A a_4462_5410# VGND.t23 VGND.t25 sg13_lv_nmos ad=0.1406p pd=1.12u as=0.1406p ps=1.12u w=0.74u l=0.13u
X1640 VGND.t912 VPWR.t1699 VGND.t912 VGND.t911 sg13_lv_nmos ad=0.1428p pd=1.52u as=0 ps=0 w=0.42u l=1u
X1641 VPWR.t1094 VGND.t11 VPWR.t1093 VPWR.t3 sg13_lv_pmos ad=0.34p pd=2.68u as=0 ps=0 w=1u l=1u
X1642 VGND.t198 a_3668_3108# sg13cmos5l_buf_16_7.A VGND.t40 sg13_lv_nmos ad=0.1406p pd=1.12u as=0.1406p ps=1.12u w=0.74u l=0.13u
X1643 VPWR.t953 VGND.t1207 VPWR.t952 VPWR.t70 sg13_lv_pmos ad=0.34p pd=2.68u as=0 ps=0 w=1u l=1u
X1644 VGND.t315 VPWR.t125 VGND.t315 VGND.t988 sg13_lv_nmos ad=0.1428p pd=1.52u as=0 ps=0 w=0.42u l=1u
X1645 a_3668_4620# sg13cmos5l_buf_16_11.A VPWR.t862 VPWR.t28 sg13_lv_pmos ad=0.2128p pd=1.5u as=0.2128p ps=1.5u w=1.12u l=0.13u
X1646 sg13cmos5l_buf_1_5.X a_13768_5444# VGND.t366 VGND.t690 sg13_lv_nmos ad=0.2886p pd=2.26u as=0.14875p ps=1.16u w=0.74u l=0.13u
X1647 VPWR.t1460 a_4174_13728# sg13cmos5l_buf_16_18.A VPWR.t8 sg13_lv_pmos ad=0.2128p pd=1.5u as=0.2128p ps=1.5u w=1.12u l=0.13u
X1648 VPWR.t521 sg13cmos5l_buf_16_20.A a_4436_9910# VPWR.t55 sg13_lv_pmos ad=0.3808p pd=2.92u as=0.2128p ps=1.5u w=1.12u l=0.13u
X1649 sg13cmos5l_buf_16_37.A a_8948_13692# VPWR.t930 VPWR.t8 sg13_lv_pmos ad=0.2128p pd=1.5u as=0.3976p ps=2.95u w=1.12u l=0.13u
X1650 VPWR.t245 VGND.t1127 VPWR.t245 VPWR.t3 sg13_lv_pmos ad=0.19p pd=1.38u as=0 ps=0 w=1u l=1u
X1651 VPWR.t24 VGND.t1296 VPWR.t24 VPWR.t0 sg13_lv_pmos ad=0.34p pd=2.68u as=0 ps=0 w=1u l=1u
X1652 sg13cmos5l_buf_16_5.A a_5710_1632# VGND.t491 VGND.t878 sg13_lv_nmos ad=0.1406p pd=1.12u as=0.1406p ps=1.12u w=0.74u l=0.13u
X1653 VGND.t1020 VPWR.t131 VGND.t1020 VGND.t156 sg13_lv_nmos ad=79.8f pd=0.8u as=0 ps=0 w=0.42u l=1u
X1654 sg13cmos5l_buf_16_31.X a_6094_4656# VGND.t27 VGND.t443 sg13_lv_nmos ad=0.1406p pd=1.12u as=0.1406p ps=1.12u w=0.74u l=0.13u
X1655 VGND.t222 VPWR.t1627 VGND.t222 VGND.t1214 sg13_lv_nmos ad=79.8f pd=0.8u as=0 ps=0 w=0.42u l=1u
X1656 VGND.t633 sg13cmos5l_and2_2_3.B a_13675_9988# VGND.t1452 sg13_lv_nmos ad=0.1331p pd=1.12u as=0.1216p ps=1.02u w=0.64u l=0.13u
X1657 sg13cmos5l_buf_16_11.A a_4462_5410# VPWR.t157 VPWR.t70 sg13_lv_pmos ad=0.2128p pd=1.5u as=0.2128p ps=1.5u w=1.12u l=0.13u
X1658 sg13cmos5l_buf_16_15.X a_3668_12180# VGND.t332 VGND.t331 sg13_lv_nmos ad=0.1406p pd=1.12u as=0.2516p ps=2.16u w=0.74u l=0.13u
X1659 VGND.t275 sg13cmos5l_buf_16_13.A a_3694_8434# VGND.t278 sg13_lv_nmos ad=0.1406p pd=1.12u as=0.1406p ps=1.12u w=0.74u l=0.13u
X1660 a_11924_13728# a_11898_13691# sg13cmos5l_xor2_1_6.X VPWR.t8 sg13_lv_pmos ad=0.2128p pd=1.5u as=0.3808p ps=2.92u w=1.12u l=0.13u
X1661 VGND.t11 a_6766_8434# sg13cmos5l_buf_16_35.A VGND.t1566 sg13_lv_nmos ad=0.2516p pd=2.16u as=0.1406p ps=1.12u w=0.74u l=0.13u
X1662 sg13cmos5l_buf_16_7.X a_3694_2386# VGND.t150 VGND.t474 sg13_lv_nmos ad=0.1406p pd=1.12u as=0.1406p ps=1.12u w=0.74u l=0.13u
X1663 VPWR.t531 a_6094_3898# sg13cmos5l_buf_16_0.A VPWR.t28 sg13_lv_pmos ad=0.2128p pd=1.5u as=0.2128p ps=1.5u w=1.12u l=0.13u
X1664 VPWR.t136 a_9262_7680# sg13cmos5l_buf_16_2.A VPWR.t5 sg13_lv_pmos ad=0.2128p pd=1.5u as=0.2128p ps=1.5u w=1.12u l=0.13u
X1665 VGND.t27 sg13cmos5l_buf_16_7.X a_6094_4656# VGND.t39 sg13_lv_nmos ad=0.1406p pd=1.12u as=0.1406p ps=1.12u w=0.74u l=0.13u
X1666 VPWR.t462 a_4436_9910# sg13cmos5l_buf_16_14.A VPWR.t55 sg13_lv_pmos ad=0.2128p pd=1.5u as=0.2128p ps=1.5u w=1.12u l=0.13u
X1667 VGND.t150 VPWR.t1612 VGND.t150 VGND.t1287 sg13_lv_nmos ad=79.8f pd=0.8u as=0 ps=0 w=0.42u l=1u
X1668 VPWR.t155 a_4462_5410# sg13cmos5l_buf_16_11.A VPWR.t70 sg13_lv_pmos ad=0.2128p pd=1.5u as=0.2128p ps=1.5u w=1.12u l=0.13u
X1669 a_3694_8434# sg13cmos5l_buf_16_13.A VGND.t275 VGND.t274 sg13_lv_nmos ad=0.1406p pd=1.12u as=0.2516p ps=2.16u w=0.74u l=0.13u
X1670 sg13cmos5l_xor2_1_0.B a_6094_3144# VPWR.t168 VPWR.t20 sg13_lv_pmos ad=0.2128p pd=1.5u as=0.2128p ps=1.5u w=1.12u l=0.13u
X1671 VGND.t92 sg13cmos5l_buf_16_0.A a_8494_3144# VGND.t40 sg13_lv_nmos ad=0.1406p pd=1.12u as=0.1406p ps=1.12u w=0.74u l=0.13u
X1672 VGND.t1 a_6862_9946# sg13cmos5l_buf_16_24.X VGND.t106 sg13_lv_nmos ad=0.1406p pd=1.12u as=0.1406p ps=1.12u w=0.74u l=0.13u
X1673 VPWR.t1589 VGND.t897 VPWR.t1587 VPWR.t8 sg13_lv_pmos ad=0.19p pd=1.38u as=0 ps=0 w=1u l=1u
X1674 sg13cmos5l_buf_16_35.A a_6766_8434# VGND.t11 VGND.t1563 sg13_lv_nmos ad=0.1406p pd=1.12u as=0.1406p ps=1.12u w=0.74u l=0.13u
X1675 sg13cmos5l_buf_16_24.A a_6094_10704# VGND.t377 VGND.t156 sg13_lv_nmos ad=0.1406p pd=1.12u as=0.1406p ps=1.12u w=0.74u l=0.13u
X1676 a_6094_3898# enable VPWR.t1426 VPWR.t28 sg13_lv_pmos ad=0.2128p pd=1.5u as=0.2128p ps=1.5u w=1.12u l=0.13u
X1677 VPWR.t965 VGND.t1207 VPWR.t963 VPWR.t28 sg13_lv_pmos ad=0.19p pd=1.38u as=0 ps=0 w=1u l=1u
X1678 sg13cmos5l_buf_16_5.A a_5710_1632# VGND.t491 VGND.t874 sg13_lv_nmos ad=0.1406p pd=1.12u as=0.1406p ps=1.12u w=0.74u l=0.13u
X1679 a_13745_8484# sg13cmos5l_buf_16_22.X a_13713_8752# VPWR.t3 sg13_lv_pmos ad=0.34p pd=2.68u as=0.1225p ps=1.245u w=1u l=0.13u
X1680 a_6164_2350# sg13cmos5l_buf_16_39.A VGND.t504 VGND.t1571 sg13_lv_nmos ad=0.1406p pd=1.12u as=0.1406p ps=1.12u w=0.74u l=0.13u
X1681 sg13cmos5l_buf_16_28.X a_5684_6132# VGND.t358 VGND.t841 sg13_lv_nmos ad=0.1406p pd=1.12u as=0.1406p ps=1.12u w=0.74u l=0.13u
X1682 VPWR.t133 VGND.t1029 VPWR.t304 VPWR.t13 sg13_lv_pmos ad=0.19p pd=1.38u as=0 ps=0 w=1u l=1u
X1683 VPWR.t806 a_6164_2350# sg13cmos5l_buf_16_30.A VPWR.t20 sg13_lv_pmos ad=0.2128p pd=1.5u as=0.2128p ps=1.5u w=1.12u l=0.13u
X1684 sg13cmos5l_buf_16_11.A a_4462_5410# VPWR.t152 VPWR.t70 sg13_lv_pmos ad=0.2128p pd=1.5u as=0.2128p ps=1.5u w=1.12u l=0.13u
X1685 VPWR.t900 sg13cmos5l_buf_16_5.X a_6094_3144# VPWR.t20 sg13_lv_pmos ad=0.2128p pd=1.5u as=0.2128p ps=1.5u w=1.12u l=0.13u
X1686 VGND.t315 sg13cmos5l_buf_16_15.A a_3668_12180# VGND.t513 sg13_lv_nmos ad=0.1406p pd=1.12u as=0.1406p ps=1.12u w=0.74u l=0.13u
X1687 VGND.t315 sg13cmos5l_buf_16_18.A a_4052_12934# VGND.t1534 sg13_lv_nmos ad=0.1406p pd=1.12u as=0.1406p ps=1.12u w=0.74u l=0.13u
X1688 VGND.t1020 VPWR.t360 VGND.t1020 VGND.t156 sg13_lv_nmos ad=0.1428p pd=1.52u as=0 ps=0 w=0.42u l=1u
X1689 VPWR.t458 a_4436_9910# sg13cmos5l_buf_16_14.A VPWR.t55 sg13_lv_pmos ad=0.2128p pd=1.5u as=0.2128p ps=1.5u w=1.12u l=0.13u
X1690 VGND.t1004 VPWR.t1676 VGND.t1004 VGND.t156 sg13_lv_nmos ad=79.8f pd=0.8u as=0 ps=0 w=0.42u l=1u
X1691 sg13cmos5l_buf_16_30.A a_6164_2350# VPWR.t802 VPWR.t20 sg13_lv_pmos ad=0.2128p pd=1.5u as=0.2128p ps=1.5u w=1.12u l=0.13u
X1692 a_3668_4620# sg13cmos5l_buf_16_11.A VPWR.t775 VPWR.t28 sg13_lv_pmos ad=0.2128p pd=1.5u as=0.2128p ps=1.5u w=1.12u l=0.13u
X1693 VPWR.t136 a_9524_6886# sg13cmos5l_buf_16_4.X VPWR.t5 sg13_lv_pmos ad=0.2128p pd=1.5u as=0.2128p ps=1.5u w=1.12u l=0.13u
X1694 out_xor[3] a_14824_6956# VGND.t70 VGND.t625 sg13_lv_nmos ad=0.2886p pd=2.26u as=0.14875p ps=1.16u w=0.74u l=0.13u
X1695 VPWR.t17 VGND.t958 VPWR.t16 VPWR.t13 sg13_lv_pmos ad=0.34p pd=2.68u as=0 ps=0 w=1u l=1u
X1696 VGND.t868 sg13cmos5l_buf_1_2.X a_14824_1632# VGND.t867 sg13_lv_nmos ad=0.14875p pd=1.16u as=0.187p ps=1.78u w=0.55u l=0.13u
X1697 VGND.t1207 VPWR.t1630 VGND.t1207 VGND.t1208 sg13_lv_nmos ad=79.8f pd=0.8u as=0 ps=0 w=0.42u l=1u
X1698 VPWR.t340 VGND.t999 VPWR.t339 VPWR.t55 sg13_lv_pmos ad=0.34p pd=2.68u as=0 ps=0 w=1u l=1u
X1699 VPWR.t349 VGND.t1060 VPWR.t348 VPWR.t55 sg13_lv_pmos ad=0.34p pd=2.68u as=0 ps=0 w=1u l=1u
X1700 VPWR.t18 VGND.t868 VPWR.t18 VPWR.t0 sg13_lv_pmos ad=0.19p pd=1.38u as=0 ps=0 w=1u l=1u
X1701 a_6094_3144# sg13cmos5l_buf_16_5.X VPWR.t897 VPWR.t20 sg13_lv_pmos ad=0.2128p pd=1.5u as=0.3808p ps=2.92u w=1.12u l=0.13u
X1702 VGND.t693 VPWR.t386 VGND.t693 VGND.t918 sg13_lv_nmos ad=0.1428p pd=1.52u as=0 ps=0 w=0.42u l=1u
X1703 VPWR.t1375 a_5684_6132# sg13cmos5l_buf_16_28.X VPWR.t70 sg13_lv_pmos ad=0.2128p pd=1.5u as=0.2128p ps=1.5u w=1.12u l=0.13u
X1704 VPWR.t129 VGND.t639 VPWR.t297 VPWR.t8 sg13_lv_pmos ad=0.19p pd=1.38u as=0 ps=0 w=1u l=1u
X1705 VGND.t282 a_7220_5374# sg13cmos5l_buf_16_28.A VGND.t297 sg13_lv_nmos ad=0.1406p pd=1.12u as=0.1406p ps=1.12u w=0.74u l=0.13u
X1706 a_3694_14482# sg13cmos5l_buf_16_15.X VPWR.t1504 VPWR.t292 sg13_lv_pmos ad=0.2128p pd=1.5u as=0.2128p ps=1.5u w=1.12u l=0.13u
X1707 sg13cmos5l_buf_16_33.A a_3694_14482# VPWR.t1517 VPWR.t292 sg13_lv_pmos ad=0.2128p pd=1.5u as=0.2128p ps=1.5u w=1.12u l=0.13u
X1708 VGND.t413 VPWR.t1647 VGND.t413 VGND.t1142 sg13_lv_nmos ad=79.8f pd=0.8u as=0 ps=0 w=0.42u l=1u
X1709 VGND.t56 VPWR.t28 VGND.t56 VGND.t40 sg13_lv_nmos ad=0.1428p pd=1.52u as=0 ps=0 w=0.42u l=1u
X1710 sg13cmos5l_buf_16_4.X a_9524_6886# VPWR.t136 VPWR.t5 sg13_lv_pmos ad=0.2128p pd=1.5u as=0.2128p ps=1.5u w=1.12u l=0.13u
X1711 a_3694_7680# sg13cmos5l_buf_16_34.A VGND.t275 VGND.t277 sg13_lv_nmos ad=0.1406p pd=1.12u as=0.1406p ps=1.12u w=0.74u l=0.13u
X1712 VPWR.t189 a_6766_8434# sg13cmos5l_buf_16_35.A VPWR.t3 sg13_lv_pmos ad=0.2128p pd=1.5u as=0.2128p ps=1.5u w=1.12u l=0.13u
X1713 VGND.t345 a_4052_12934# sg13cmos5l_buf_16_15.A VGND.t735 sg13_lv_nmos ad=0.1406p pd=1.12u as=0.1406p ps=1.12u w=0.74u l=0.13u
X1714 VPWR.t19 sg13cmos5l_buf_16_5.A a_5108_838# VPWR.t0 sg13_lv_pmos ad=0.2128p pd=1.5u as=0.2128p ps=1.5u w=1.12u l=0.13u
X1715 a_9524_6886# sg13cmos5l_buf_16_4.A VGND.t358 VGND.t804 sg13_lv_nmos ad=0.1406p pd=1.12u as=0.1406p ps=1.12u w=0.74u l=0.13u
X1716 VGND.t1369 VPWR.t78 VGND.t1371 VGND.t1370 sg13_lv_nmos ad=79.8f pd=0.8u as=0 ps=0 w=0.42u l=1u
X1717 sg13cmos5l_buf_16_28.A a_7220_5374# VGND.t282 VGND.t294 sg13_lv_nmos ad=0.1406p pd=1.12u as=0.1406p ps=1.12u w=0.74u l=0.13u
X1718 a_5204_11422# sg13cmos5l_buf_16_19.A VGND.t350 VGND.t156 sg13_lv_nmos ad=0.1406p pd=1.12u as=0.1406p ps=1.12u w=0.74u l=0.13u
X1719 sg13cmos5l_buf_16_0.A a_6094_3898# VGND.t41 VGND.t40 sg13_lv_nmos ad=0.1406p pd=1.12u as=0.1406p ps=1.12u w=0.74u l=0.13u
X1720 VGND.t27 sg13cmos5l_buf_16_7.X a_6094_4656# VGND.t35 sg13_lv_nmos ad=0.1406p pd=1.12u as=0.1406p ps=1.12u w=0.74u l=0.13u
X1721 VPWR.t136 a_9524_6886# sg13cmos5l_buf_16_4.X VPWR.t5 sg13_lv_pmos ad=0.2128p pd=1.5u as=0.2128p ps=1.5u w=1.12u l=0.13u
X1722 sg13cmos5l_buf_16_25.A a_6836_9156# VGND.t1 VGND.t105 sg13_lv_nmos ad=0.1406p pd=1.12u as=0.1406p ps=1.12u w=0.74u l=0.13u
X1723 VPWR.t185 VGND.t1306 VPWR.t18 VPWR.t0 sg13_lv_pmos ad=0.19p pd=1.38u as=0 ps=0 w=1u l=1u
X1724 a_14010_11470# sg13cmos5l_buf_1_15.X VGND.t157 VGND.t156 sg13_lv_nmos ad=88.8f pd=0.98u as=0.15245p ps=1.17u w=0.74u l=0.13u
X1725 VPWR.t202 sg13cmos5l_buf_16_2.X a_10292_4620# VPWR.t28 sg13_lv_pmos ad=0.3808p pd=2.92u as=0.2128p ps=1.5u w=1.12u l=0.13u
X1726 VGND.t11 sg13cmos5l_buf_16_1.X a_10318_8434# VGND.t62 sg13_lv_nmos ad=0.1406p pd=1.12u as=0.1406p ps=1.12u w=0.74u l=0.13u
X1727 VGND.t315 a_10292_12934# sg13cmos5l_buf_16_23.X VGND.t649 sg13_lv_nmos ad=0.1406p pd=1.12u as=0.1406p ps=1.12u w=0.74u l=0.13u
X1728 VGND.t1 a_6862_9946# sg13cmos5l_buf_16_24.X VGND.t102 sg13_lv_nmos ad=0.1406p pd=1.12u as=0.1406p ps=1.12u w=0.74u l=0.13u
X1729 VPWR.t30 VGND.t130 VPWR.t30 VPWR.t20 sg13_lv_pmos ad=0.34p pd=2.68u as=0 ps=0 w=1u l=1u
X1730 VGND.t56 sg13cmos5l_buf_16_0.A a_8494_3144# VGND.t40 sg13_lv_nmos ad=0.1406p pd=1.12u as=0.1406p ps=1.12u w=0.74u l=0.13u
X1731 sg13cmos5l_buf_16_5.X a_5108_838# VPWR.t19 VPWR.t0 sg13_lv_pmos ad=0.2128p pd=1.5u as=0.2128p ps=1.5u w=1.12u l=0.13u
X1732 VGND.t282 a_7220_5374# sg13cmos5l_buf_16_28.A VGND.t291 sg13_lv_nmos ad=0.1406p pd=1.12u as=0.1406p ps=1.12u w=0.74u l=0.13u
X1733 VPWR.t579 VGND.t1153 VPWR.t578 VPWR.t70 sg13_lv_pmos ad=0.34p pd=2.68u as=0 ps=0 w=1u l=1u
X1734 VGND.t358 a_9524_6886# sg13cmos5l_buf_16_4.X VGND.t826 sg13_lv_nmos ad=0.1406p pd=1.12u as=0.1406p ps=1.12u w=0.74u l=0.13u
X1735 VGND.t222 VPWR.t1627 VGND.t1207 VGND.t1213 sg13_lv_nmos ad=0.1428p pd=1.52u as=0 ps=0 w=0.42u l=1u
X1736 sg13cmos5l_buf_16_2.A a_9262_7680# VPWR.t136 VPWR.t5 sg13_lv_pmos ad=0.2128p pd=1.5u as=0.2128p ps=1.5u w=1.12u l=0.13u
X1737 VGND.t693 sg13cmos5l_buf_16_37.X a_6548_13692# VGND.t718 sg13_lv_nmos ad=0.1406p pd=1.12u as=0.1406p ps=1.12u w=0.74u l=0.13u
X1738 VPWR.t1371 a_5684_6132# sg13cmos5l_buf_16_28.X VPWR.t70 sg13_lv_pmos ad=0.2128p pd=1.5u as=0.2128p ps=1.5u w=1.12u l=0.13u
X1739 sg13cmos5l_buf_16_15.A a_4052_12934# VPWR.t1268 VPWR.t8 sg13_lv_pmos ad=0.2128p pd=1.5u as=0.2128p ps=1.5u w=1.12u l=0.13u
X1740 a_10292_4620# sg13cmos5l_buf_16_2.X VPWR.t202 VPWR.t28 sg13_lv_pmos ad=0.2128p pd=1.5u as=0.2128p ps=1.5u w=1.12u l=0.13u
X1741 VPWR.t1525 a_3694_14482# sg13cmos5l_buf_16_33.A VPWR.t292 sg13_lv_pmos ad=0.3976p pd=2.95u as=0.2128p ps=1.5u w=1.12u l=0.13u
X1742 a_7220_5374# sg13cmos5l_buf_16_38.A VPWR.t70 VPWR.t70 sg13_lv_pmos ad=0.2128p pd=1.5u as=0.2128p ps=1.5u w=1.12u l=0.13u
X1743 VPWR.t1000 VGND.t150 VPWR.t998 VPWR.t20 sg13_lv_pmos ad=0.19p pd=1.38u as=0 ps=0 w=1u l=1u
X1744 a_6862_9946# sg13cmos5l_buf_16_24.A VGND.t1 VGND.t99 sg13_lv_nmos ad=0.1406p pd=1.12u as=0.1406p ps=1.12u w=0.74u l=0.13u
X1745 VPWR.t677 a_6094_10704# sg13cmos5l_buf_16_24.A VPWR.t55 sg13_lv_pmos ad=0.2128p pd=1.5u as=0.2128p ps=1.5u w=1.12u l=0.13u
X1746 VGND.t573 VPWR.t297 VGND.t573 VGND.t968 sg13_lv_nmos ad=0.1428p pd=1.52u as=0 ps=0 w=0.42u l=1u
X1747 sg13cmos5l_buf_16_20.A a_5204_11422# VGND.t350 VGND.t156 sg13_lv_nmos ad=0.1406p pd=1.12u as=0.1406p ps=1.12u w=0.74u l=0.13u
X1748 VGND.t1364 VPWR.t77 VGND.t1366 VGND.t1365 sg13_lv_nmos ad=79.8f pd=0.8u as=0 ps=0 w=0.42u l=1u
X1749 a_4721_6526# sg13cmos5l_buf_16_31.X a_4689_6168# VPWR.t70 sg13_lv_pmos ad=0.34p pd=2.68u as=0.1225p ps=1.245u w=1u l=0.13u
X1750 VGND.t261 VPWR.t357 VGND.t261 VGND.t1073 sg13_lv_nmos ad=0.1428p pd=1.52u as=0 ps=0 w=0.42u l=1u
X1751 VGND.t1060 VPWR.t1660 VGND.t1060 VGND.t1062 sg13_lv_nmos ad=0.1428p pd=1.52u as=0 ps=0 w=0.42u l=1u
X1752 VPWR.t78 VGND.t1366 VPWR.t77 VPWR.t0 sg13_lv_pmos ad=0.19p pd=1.38u as=0 ps=0 w=1u l=1u
X1753 VPWR.t612 a_7220_5374# sg13cmos5l_buf_16_28.A VPWR.t70 sg13_lv_pmos ad=0.2128p pd=1.5u as=0.2128p ps=1.5u w=1.12u l=0.13u
X1754 VPWR.t945 VGND.t1207 VPWR.t944 VPWR.t70 sg13_lv_pmos ad=0.34p pd=2.68u as=0 ps=0 w=1u l=1u
X1755 VGND.t358 VPWR.t1631 VGND.t358 VGND.t1191 sg13_lv_nmos ad=0.1428p pd=1.52u as=0 ps=0 w=0.42u l=1u
X1756 VPWR.t9 VGND.t315 VPWR.t99 VPWR.t8 sg13_lv_pmos ad=0.34p pd=2.68u as=0 ps=0 w=1u l=1u
X1757 VGND.t912 a_6548_13692# sg13cmos5l_buf_16_27.X VGND.t1486 sg13_lv_nmos ad=0.1406p pd=1.12u as=0.1406p ps=1.12u w=0.74u l=0.13u
X1758 VGND.t693 a_6548_13692# sg13cmos5l_buf_16_27.X VGND.t1498 sg13_lv_nmos ad=0.1406p pd=1.12u as=0.1406p ps=1.12u w=0.74u l=0.13u
X1759 VGND.t11 sg13cmos5l_buf_16_1.X a_10318_8434# VGND.t58 sg13_lv_nmos ad=0.1406p pd=1.12u as=0.1406p ps=1.12u w=0.74u l=0.13u
X1760 VPWR.t28 VGND.t56 VPWR.t29 VPWR.t28 sg13_lv_pmos ad=0.34p pd=2.68u as=0 ps=0 w=1u l=1u
X1761 sg13cmos5l_buf_16_15.A a_4052_12934# VPWR.t1264 VPWR.t8 sg13_lv_pmos ad=0.2128p pd=1.5u as=0.2128p ps=1.5u w=1.12u l=0.13u
X1762 VGND.t315 a_7796_12934# sg13cmos5l_buf_16_37.X VGND.t608 sg13_lv_nmos ad=0.1406p pd=1.12u as=0.1406p ps=1.12u w=0.74u l=0.13u
X1763 VGND.t397 VPWR.t4 VGND.t397 VGND.t1110 sg13_lv_nmos ad=0.1428p pd=1.52u as=0 ps=0 w=0.42u l=1u
X1764 VPWR.t1521 a_3694_14482# sg13cmos5l_buf_16_33.A VPWR.t292 sg13_lv_pmos ad=0.2128p pd=1.5u as=0.2128p ps=1.5u w=1.12u l=0.13u
X1765 sg13cmos5l_buf_16_22.X a_10318_8434# VPWR.t190 VPWR.t3 sg13_lv_pmos ad=0.2128p pd=1.5u as=0.2128p ps=1.5u w=1.12u l=0.13u
X1766 VPWR.t1570 a_6766_8434# sg13cmos5l_buf_16_35.A VPWR.t3 sg13_lv_pmos ad=0.2128p pd=1.5u as=0.2128p ps=1.5u w=1.12u l=0.13u
X1767 VGND.t934 a_14444_14442# sg13cmos5l_and2_2_4.B VGND.t1480 sg13_lv_nmos ad=0.14875p pd=1.16u as=0.2886p ps=2.26u w=0.74u l=0.13u
X1768 VPWR.t1202 sg13cmos5l_buf_16_14.A a_3668_9156# VPWR.t3 sg13_lv_pmos ad=0.2128p pd=1.5u as=0.2128p ps=1.5u w=1.12u l=0.13u
X1769 VGND.t639 sg13cmos5l_buf_1_17.X a_11898_13691# VGND.t638 sg13_lv_nmos ad=0.374p pd=2.46u as=0.17462p ps=1.185u w=0.55u l=0.13u
X1770 VPWR.t674 sg13cmos5l_buf_16_33.A a_6094_10704# VPWR.t55 sg13_lv_pmos ad=0.2128p pd=1.5u as=0.2128p ps=1.5u w=1.12u l=0.13u
X1771 VGND.t27 a_4462_5410# sg13cmos5l_buf_16_11.A VGND.t39 sg13_lv_nmos ad=0.2516p pd=2.16u as=0.1406p ps=1.12u w=0.74u l=0.13u
X1772 VPWR.t1404 glitch_en[0] a_1672_14516# VPWR.t292 sg13_lv_pmos ad=0.2114p pd=1.54u as=0.2856p ps=2.36u w=0.84u l=0.13u
X1773 VPWR.t1475 sg13cmos5l_xor2_1_6.X a_14824_14516# VPWR.t292 sg13_lv_pmos ad=0.2114p pd=1.54u as=0.2856p ps=2.36u w=0.84u l=0.13u
X1774 VGND.t358 sg13cmos5l_buf_16_35.A a_8110_6168# VGND.t1548 sg13_lv_nmos ad=0.1406p pd=1.12u as=0.1406p ps=1.12u w=0.74u l=0.13u
X1775 sg13cmos5l_and2_2_1.X a_2147_13692# VGND.t871 VGND.t1469 sg13_lv_nmos ad=0.1406p pd=1.12u as=0.2812p ps=2.24u w=0.74u l=0.13u
X1776 VGND.t1020 VPWR.t357 VGND.t1020 VGND.t156 sg13_lv_nmos ad=79.8f pd=0.8u as=0 ps=0 w=0.42u l=1u
X1777 sg13cmos5l_buf_16_2.X a_10318_3898# VGND.t130 VGND.t40 sg13_lv_nmos ad=0.1406p pd=1.12u as=0.1406p ps=1.12u w=0.74u l=0.13u
X1778 VGND.t198 a_3694_3898# sg13cmos5l_buf_16_10.A VGND.t40 sg13_lv_nmos ad=0.1406p pd=1.12u as=0.1406p ps=1.12u w=0.74u l=0.13u
X1779 VGND.t92 VPWR.t28 VGND.t92 VGND.t40 sg13_lv_nmos ad=0.1428p pd=1.52u as=0 ps=0 w=0.42u l=1u
X1780 sg13cmos5l_buf_16_24.X a_6862_9946# VPWR.t552 VPWR.t55 sg13_lv_pmos ad=0.2128p pd=1.5u as=0.2128p ps=1.5u w=1.12u l=0.13u
X1781 VGND.t146 VPWR.t78 VGND.t150 VGND.t1324 sg13_lv_nmos ad=79.8f pd=0.8u as=0 ps=0 w=0.42u l=1u
X1782 sg13cmos5l_buf_16_39.A a_8494_3144# VPWR.t21 VPWR.t20 sg13_lv_pmos ad=0.2128p pd=1.5u as=0.2128p ps=1.5u w=1.12u l=0.13u
X1783 VGND.t244 VPWR.t1617 VGND.t244 VGND.t40 sg13_lv_nmos ad=0.1428p pd=1.52u as=0 ps=0 w=0.42u l=1u
X1784 VPWR.t131 VGND.t322 VPWR.t130 VPWR.t13 sg13_lv_pmos ad=0.19p pd=1.38u as=0 ps=0 w=1u l=1u
X1785 VPWR.t784 a_3694_2386# sg13cmos5l_buf_16_7.X VPWR.t20 sg13_lv_pmos ad=0.2128p pd=1.5u as=0.2128p ps=1.5u w=1.12u l=0.13u
X1786 sg13cmos5l_buf_16_7.X a_3694_2386# VGND.t150 VGND.t488 sg13_lv_nmos ad=0.1406p pd=1.12u as=0.1406p ps=1.12u w=0.74u l=0.13u
X1787 VPWR.t19 a_5710_1632# sg13cmos5l_buf_16_5.A VPWR.t0 sg13_lv_pmos ad=0.2128p pd=1.5u as=0.2128p ps=1.5u w=1.12u l=0.13u
X1788 VPWR.t319 a_10318_5410# sg13cmos5l_buf_16_1.X VPWR.t70 sg13_lv_pmos ad=0.2128p pd=1.5u as=0.2128p ps=1.5u w=1.12u l=0.13u
X1789 sg13cmos5l_xor2_1_0.B a_6094_3144# VGND.t41 VGND.t40 sg13_lv_nmos ad=0.1406p pd=1.12u as=0.1406p ps=1.12u w=0.74u l=0.13u
X1790 VGND.t693 VPWR.t292 VGND.t693 VGND.t923 sg13_lv_nmos ad=79.8f pd=0.8u as=0 ps=0 w=0.42u l=1u
X1791 VPWR.t745 a_6094_4656# sg13cmos5l_buf_16_31.X VPWR.t28 sg13_lv_pmos ad=0.2128p pd=1.5u as=0.2128p ps=1.5u w=1.12u l=0.13u
X1792 a_8110_6168# sg13cmos5l_buf_16_35.A VGND.t358 VGND.t1545 sg13_lv_nmos ad=0.1406p pd=1.12u as=0.1406p ps=1.12u w=0.74u l=0.13u
X1793 sg13cmos5l_buf_16_2.A a_9262_7680# VGND.t11 VGND.t18 sg13_lv_nmos ad=0.1406p pd=1.12u as=0.1406p ps=1.12u w=0.74u l=0.13u
X1794 VPWR.t125 VGND.t1020 VPWR.t125 VPWR.t13 sg13_lv_pmos ad=0.34p pd=2.68u as=0 ps=0 w=1u l=1u
X1795 VPWR.t1222 a_5518_6922# sg13cmos5l_buf_16_6.X VPWR.t5 sg13_lv_pmos ad=0.2128p pd=1.5u as=0.2128p ps=1.5u w=1.12u l=0.13u
X1796 VGND.t871 VPWR.t1695 VGND.t907 VGND.t937 sg13_lv_nmos ad=0.1428p pd=1.52u as=0 ps=0 w=0.42u l=1u
X1797 VGND.t951 VPWR.t297 VGND.t934 VGND.t950 sg13_lv_nmos ad=0.1428p pd=1.52u as=0 ps=0 w=0.42u l=1u
X1798 a_6161_9550# sg13cmos5l_and2_2_6.A a_6129_9192# VPWR.t3 sg13_lv_pmos ad=0.34p pd=2.68u as=0.1225p ps=1.245u w=1u l=0.13u
X1799 VGND.t130 a_10318_3898# sg13cmos5l_buf_16_2.X VGND.t40 sg13_lv_nmos ad=0.1406p pd=1.12u as=0.1406p ps=1.12u w=0.74u l=0.13u
X1800 a_3694_3898# sg13cmos5l_buf_16_8.A VGND.t198 VGND.t40 sg13_lv_nmos ad=0.1406p pd=1.12u as=0.1406p ps=1.12u w=0.74u l=0.13u
X1801 a_7796_12934# sg13cmos5l_buf_16_37.A VGND.t315 VGND.t319 sg13_lv_nmos ad=0.1406p pd=1.12u as=0.1406p ps=1.12u w=0.74u l=0.13u
X1802 VGND.t1 a_6836_9156# sg13cmos5l_buf_16_25.A VGND.t98 sg13_lv_nmos ad=0.1406p pd=1.12u as=0.1406p ps=1.12u w=0.74u l=0.13u
X1803 sg13cmos5l_buf_16_24.A a_6094_10704# VGND.t350 VGND.t156 sg13_lv_nmos ad=0.1406p pd=1.12u as=0.1406p ps=1.12u w=0.74u l=0.13u
X1804 a_10318_8434# sg13cmos5l_buf_16_1.X VPWR.t190 VPWR.t3 sg13_lv_pmos ad=0.2128p pd=1.5u as=0.2128p ps=1.5u w=1.12u l=0.13u
X1805 sg13cmos5l_xor2_1_5.X sg13cmos5l_buf_16_6.X a_9882_8446# VGND.t161 sg13_lv_nmos ad=0.1628p pd=1.18u as=88.8f ps=0.98u w=0.74u l=0.13u
X1806 VPWR.t957 VGND.t1207 VPWR.t955 VPWR.t28 sg13_lv_pmos ad=0.19p pd=1.38u as=0 ps=0 w=1u l=1u
X1807 VGND.t315 VPWR.t1680 VGND.t315 VGND.t981 sg13_lv_nmos ad=79.8f pd=0.8u as=0 ps=0 w=0.42u l=1u
X1808 sg13cmos5l_buf_16_7.X a_3694_2386# VPWR.t780 VPWR.t20 sg13_lv_pmos ad=0.2128p pd=1.5u as=0.2128p ps=1.5u w=1.12u l=0.13u
X1809 VPWR.t32 VGND.t130 VPWR.t30 VPWR.t20 sg13_lv_pmos ad=0.34p pd=2.68u as=0 ps=0 w=1u l=1u
X1810 VGND.t504 sg13cmos5l_buf_1_2.A a_8104_1632# VGND.t509 sg13_lv_nmos ad=0.14875p pd=1.16u as=0.187p ps=1.78u w=0.55u l=0.13u
X1811 a_6094_4656# sg13cmos5l_buf_16_7.X VPWR.t868 VPWR.t28 sg13_lv_pmos ad=0.2128p pd=1.5u as=0.2128p ps=1.5u w=1.12u l=0.13u
X1812 VGND.t1130 VPWR.t201 VGND.t1130 VGND.t1151 sg13_lv_nmos ad=0.1428p pd=1.52u as=0 ps=0 w=0.42u l=1u
X1813 sg13cmos5l_buf_16_6.X a_5518_6922# VPWR.t1218 VPWR.t5 sg13_lv_pmos ad=0.2128p pd=1.5u as=0.2128p ps=1.5u w=1.12u l=0.13u
X1814 VPWR.t413 VGND.t358 VPWR.t411 VPWR.t5 sg13_lv_pmos ad=0.19p pd=1.38u as=0 ps=0 w=1u l=1u
X1815 VGND.t942 a_3694_14482# sg13cmos5l_buf_16_33.A VGND.t1513 sg13_lv_nmos ad=0.1406p pd=1.12u as=0.1406p ps=1.12u w=0.74u l=0.13u
X1816 VPWR.t1086 VGND.t11 VPWR.t1085 VPWR.t3 sg13_lv_pmos ad=0.34p pd=2.68u as=0 ps=0 w=1u l=1u
X1817 VGND.t377 VPWR.t118 VGND.t377 VGND.t156 sg13_lv_nmos ad=0.1428p pd=1.52u as=0 ps=0 w=0.42u l=1u
X1818 VGND.t851 VPWR.t449 VGND.t851 VGND.t1244 sg13_lv_nmos ad=0.1428p pd=1.52u as=0 ps=0 w=0.42u l=1u
X1819 sg13cmos5l_and2_2_6.X a_7629_8028# VPWR.t1338 VPWR.t5 sg13_lv_pmos ad=0.2128p pd=1.5u as=0.1918p ps=1.5u w=1.12u l=0.13u
X1820 sg13cmos5l_buf_16_25.A a_6836_9156# VPWR.t228 VPWR.t3 sg13_lv_pmos ad=0.2128p pd=1.5u as=0.3976p ps=2.95u w=1.12u l=0.13u
X1821 a_13667_12956# sg13cmos5l_and2_2_4.B VPWR.t297 VPWR.t8 sg13_lv_pmos ad=0.1596p pd=1.22u as=0.1918p ps=1.5u w=0.84u l=0.13u
X1822 VGND.t377 VPWR.t357 VGND.t377 VGND.t156 sg13_lv_nmos ad=0.1428p pd=1.52u as=0 ps=0 w=0.42u l=1u
X1823 VPWR.t56 a_13581_9988# sg13cmos5l_and2_2_3.X VPWR.t55 sg13_lv_pmos ad=0.4256p pd=3u as=0.2128p ps=1.5u w=1.12u l=0.13u
X1824 VPWR.t19 sg13cmos5l_buf_16_30.A a_5710_1632# VPWR.t0 sg13_lv_pmos ad=0.2128p pd=1.5u as=0.2128p ps=1.5u w=1.12u l=0.13u
X1825 VGND.t1130 VPWR.t4 VGND.t1129 VGND.t1128 sg13_lv_nmos ad=0.1428p pd=1.52u as=0 ps=0 w=0.42u l=1u
X1826 a_7796_12934# sg13cmos5l_buf_16_37.A VGND.t315 VGND.t314 sg13_lv_nmos ad=0.1406p pd=1.12u as=0.1406p ps=1.12u w=0.74u l=0.13u
X1827 a_6094_10704# sg13cmos5l_buf_16_33.A VGND.t350 VGND.t156 sg13_lv_nmos ad=0.1406p pd=1.12u as=0.1406p ps=1.12u w=0.74u l=0.13u
X1828 VPWR.t1077 VGND.t130 VPWR.t288 VPWR.t20 sg13_lv_pmos ad=0.34p pd=2.68u as=0 ps=0 w=1u l=1u
X1829 VGND.t322 VPWR.t129 VGND.t322 VGND.t966 sg13_lv_nmos ad=0.1428p pd=1.52u as=0 ps=0 w=0.42u l=1u
X1830 VGND.t165 a_3668_9156# sg13cmos5l_buf_16_13.A VGND.t185 sg13_lv_nmos ad=0.1406p pd=1.12u as=0.1406p ps=1.12u w=0.74u l=0.13u
X1831 VPWR.t949 VGND.t1207 VPWR.t948 VPWR.t70 sg13_lv_pmos ad=0.34p pd=2.68u as=0 ps=0 w=1u l=1u
X1832 VGND.t27 a_4462_5410# sg13cmos5l_buf_16_11.A VGND.t35 sg13_lv_nmos ad=0.1406p pd=1.12u as=0.1406p ps=1.12u w=0.74u l=0.13u
X1833 sg13cmos5l_buf_16_24.A a_6094_10704# VPWR.t687 VPWR.t55 sg13_lv_pmos ad=0.2128p pd=1.5u as=0.2128p ps=1.5u w=1.12u l=0.13u
X1834 VGND.t397 a_14252_9906# sg13cmos5l_buf_1_15.X VGND.t764 sg13_lv_nmos ad=0.14875p pd=1.16u as=0.2886p ps=2.26u w=0.74u l=0.13u
X1835 sg13cmos5l_buf_16_31.X a_6094_4656# VGND.t282 VGND.t453 sg13_lv_nmos ad=0.1406p pd=1.12u as=0.1406p ps=1.12u w=0.74u l=0.13u
X1836 VPWR.t28 VGND.t92 VPWR.t28 VPWR.t28 sg13_lv_pmos ad=0.34p pd=2.68u as=0 ps=0 w=1u l=1u
X1837 VPWR.t967 VGND.t1207 VPWR.t966 VPWR.t28 sg13_lv_pmos ad=0.34p pd=2.68u as=0 ps=0 w=1u l=1u
X1838 VGND.t1079 VPWR.t905 VGND.t1079 VGND.t1081 sg13_lv_nmos ad=79.8f pd=0.8u as=0 ps=0 w=0.42u l=1u
X1839 VPWR.t1485 glitch_en[3] a_7432_14516# VPWR.t292 sg13_lv_pmos ad=0.2114p pd=1.54u as=0.2856p ps=2.36u w=0.84u l=0.13u
X1840 VGND.t332 a_3668_12180# sg13cmos5l_buf_16_15.X VGND.t333 sg13_lv_nmos ad=0.1406p pd=1.12u as=0.1406p ps=1.12u w=0.74u l=0.13u
X1841 VGND.t942 a_3694_14482# sg13cmos5l_buf_16_33.A VGND.t1509 sg13_lv_nmos ad=0.1406p pd=1.12u as=0.1406p ps=1.12u w=0.74u l=0.13u
X1842 VPWR.t24 VGND.t584 VPWR.t24 VPWR.t0 sg13_lv_pmos ad=0.34p pd=2.68u as=0 ps=0 w=1u l=1u
X1843 VPWR.t71 VGND.t1219 VPWR.t71 VPWR.t70 sg13_lv_pmos ad=0.19p pd=1.38u as=0 ps=0 w=1u l=1u
X1844 VPWR.t928 a_7796_12934# sg13cmos5l_buf_16_37.X VPWR.t8 sg13_lv_pmos ad=0.2128p pd=1.5u as=0.2128p ps=1.5u w=1.12u l=0.13u
X1845 VGND.t1 a_6161_9550# sg13cmos5l_buf_1_23.A VGND.t1539 sg13_lv_nmos ad=0.3108p pd=2.32u as=0.1628p ps=1.18u w=0.74u l=0.13u
X1846 sg13cmos5l_buf_16_39.A a_8494_3144# VPWR.t21 VPWR.t20 sg13_lv_pmos ad=0.2128p pd=1.5u as=0.2128p ps=1.5u w=1.12u l=0.13u
X1847 sg13cmos5l_buf_16_13.A a_3668_9156# VGND.t165 VGND.t182 sg13_lv_nmos ad=0.1406p pd=1.12u as=0.2516p ps=2.16u w=0.74u l=0.13u
X1848 sg13cmos5l_buf_16_7.X a_3694_2386# VGND.t150 VGND.t484 sg13_lv_nmos ad=0.1406p pd=1.12u as=0.1406p ps=1.12u w=0.74u l=0.13u
X1849 VPWR.t541 a_6094_3898# sg13cmos5l_buf_16_0.A VPWR.t28 sg13_lv_pmos ad=0.2128p pd=1.5u as=0.2128p ps=1.5u w=1.12u l=0.13u
X1850 a_9617_8484# sg13cmos5l_buf_16_35.A VGND.t5 VGND.t1541 sg13_lv_nmos ad=0.17462p pd=1.185u as=0.374p ps=2.46u w=0.55u l=0.13u
X1851 VGND.t504 a_5710_1632# sg13cmos5l_buf_16_5.A VGND.t887 sg13_lv_nmos ad=0.1406p pd=1.12u as=0.1406p ps=1.12u w=0.74u l=0.13u
X1852 a_4436_9910# sg13cmos5l_buf_16_20.A VPWR.t517 VPWR.t55 sg13_lv_pmos ad=0.2128p pd=1.5u as=0.2128p ps=1.5u w=1.12u l=0.13u
X1853 VGND.t198 a_3668_3108# sg13cmos5l_buf_16_7.A VGND.t40 sg13_lv_nmos ad=0.1406p pd=1.12u as=0.1406p ps=1.12u w=0.74u l=0.13u
X1854 VPWR.t594 sg13cmos5l_buf_16_34.A a_3694_7680# VPWR.t5 sg13_lv_pmos ad=0.2128p pd=1.5u as=0.2128p ps=1.5u w=1.12u l=0.13u
X1855 VGND.t942 sg13cmos5l_and2_2_1.X a_4174_13728# VGND.t1477 sg13_lv_nmos ad=0.1406p pd=1.12u as=0.1406p ps=1.12u w=0.74u l=0.13u
X1856 VPWR.t631 glitch_en[4] a_11272_13728# VPWR.t8 sg13_lv_pmos ad=0.2114p pd=1.54u as=0.2856p ps=2.36u w=0.84u l=0.13u
X1857 VGND.t130 a_10318_3898# sg13cmos5l_buf_16_2.X VGND.t40 sg13_lv_nmos ad=0.1406p pd=1.12u as=0.1406p ps=1.12u w=0.74u l=0.13u
X1858 sg13cmos5l_xor2_1_0.B a_6094_3144# VPWR.t177 VPWR.t20 sg13_lv_pmos ad=0.2128p pd=1.5u as=0.2128p ps=1.5u w=1.12u l=0.13u
X1859 VPWR.t342 sg13cmos5l_and2_2_5.B a_11565_8028# VPWR.t5 sg13_lv_pmos ad=0.1918p pd=1.5u as=0.1596p ps=1.22u w=0.84u l=0.13u
X1860 sg13cmos5l_buf_16_34.A a_3694_8434# VGND.t402 VGND.t405 sg13_lv_nmos ad=0.1406p pd=1.12u as=0.1406p ps=1.12u w=0.74u l=0.13u
X1861 VGND.t150 VPWR.t19 VGND.t150 VGND.t1326 sg13_lv_nmos ad=79.8f pd=0.8u as=0 ps=0 w=0.42u l=1u
X1862 VGND.t377 a_6094_10704# sg13cmos5l_buf_16_24.A VGND.t156 sg13_lv_nmos ad=0.2516p pd=2.16u as=0.1406p ps=1.12u w=0.74u l=0.13u
X1863 sg13cmos5l_buf_16_7.X a_3694_2386# VPWR.t279 VPWR.t20 sg13_lv_pmos ad=0.2128p pd=1.5u as=0.2128p ps=1.5u w=1.12u l=0.13u
X1864 sg13cmos5l_buf_16_5.A a_5710_1632# VGND.t504 VGND.t884 sg13_lv_nmos ad=0.1406p pd=1.12u as=0.1406p ps=1.12u w=0.74u l=0.13u
X1865 VPWR.t817 sg13cmos5l_buf_16_15.A a_6332_12216# VPWR.t13 sg13_lv_pmos ad=0.2128p pd=1.5u as=0.3808p ps=2.92u w=1.12u l=0.13u
X1866 sg13cmos5l_buf_16_7.A a_3668_3108# VGND.t198 VGND.t40 sg13_lv_nmos ad=0.1406p pd=1.12u as=0.1406p ps=1.12u w=0.74u l=0.13u
X1867 sg13cmos5l_and2_2_6.A a_3694_10704# VGND.t384 VGND.t156 sg13_lv_nmos ad=0.1406p pd=1.12u as=0.1406p ps=1.12u w=0.74u l=0.13u
X1868 VGND.t942 sg13cmos5l_buf_16_15.X a_3694_14482# VGND.t1504 sg13_lv_nmos ad=0.1406p pd=1.12u as=0.1406p ps=1.12u w=0.74u l=0.13u
X1869 sg13cmos5l_buf_16_31.X a_6094_4656# VGND.t282 VGND.t449 sg13_lv_nmos ad=0.1406p pd=1.12u as=0.1406p ps=1.12u w=0.74u l=0.13u
X1870 VPWR.t68 VGND.t165 VPWR.t67 VPWR.t3 sg13_lv_pmos ad=0.19p pd=1.38u as=0 ps=0 w=1u l=1u
X1871 VGND.t358 VPWR.t1637 VGND.t358 VGND.t1169 sg13_lv_nmos ad=79.8f pd=0.8u as=0 ps=0 w=0.42u l=1u
X1872 VPWR.t924 a_7796_12934# sg13cmos5l_buf_16_37.X VPWR.t8 sg13_lv_pmos ad=0.2128p pd=1.5u as=0.2128p ps=1.5u w=1.12u l=0.13u
X1873 sg13cmos5l_buf_16_11.A a_4462_5410# VPWR.t163 VPWR.t70 sg13_lv_pmos ad=0.2128p pd=1.5u as=0.2128p ps=1.5u w=1.12u l=0.13u
X1874 VGND.t636 sg13cmos5l_buf_16_23.X a_8948_13692# VGND.t698 sg13_lv_nmos ad=0.2516p pd=2.16u as=0.1406p ps=1.12u w=0.74u l=0.13u
X1875 VGND.t402 a_3694_8434# sg13cmos5l_buf_16_34.A VGND.t401 sg13_lv_nmos ad=0.1406p pd=1.12u as=0.1406p ps=1.12u w=0.74u l=0.13u
X1876 sg13cmos5l_buf_16_39.A a_8494_3144# VGND.t112 VGND.t40 sg13_lv_nmos ad=0.1406p pd=1.12u as=0.1406p ps=1.12u w=0.74u l=0.13u
X1877 sg13cmos5l_buf_16_24.X a_6862_9946# VGND.t1 VGND.t259 sg13_lv_nmos ad=0.1406p pd=1.12u as=0.1406p ps=1.12u w=0.74u l=0.13u
X1878 sg13cmos5l_buf_16_14.A a_4436_9910# VPWR.t458 VPWR.t55 sg13_lv_pmos ad=0.2128p pd=1.5u as=0.2128p ps=1.5u w=1.12u l=0.13u
X1879 VPWR.t537 a_6094_3898# sg13cmos5l_buf_16_0.A VPWR.t28 sg13_lv_pmos ad=0.2128p pd=1.5u as=0.2128p ps=1.5u w=1.12u l=0.13u
X1880 VPWR.t149 a_9262_7680# sg13cmos5l_buf_16_2.A VPWR.t5 sg13_lv_pmos ad=0.3976p pd=2.95u as=0.2128p ps=1.5u w=1.12u l=0.13u
X1881 a_6164_2350# sg13cmos5l_buf_16_39.A VPWR.t1580 VPWR.t20 sg13_lv_pmos ad=0.2128p pd=1.5u as=0.2128p ps=1.5u w=1.12u l=0.13u
X1882 VGND.t150 VPWR.t284 VGND.t150 VGND.t1289 sg13_lv_nmos ad=79.8f pd=0.8u as=0 ps=0 w=0.42u l=1u
X1883 VGND.t358 a_9524_6886# sg13cmos5l_buf_16_4.X VGND.t814 sg13_lv_nmos ad=0.1406p pd=1.12u as=0.1406p ps=1.12u w=0.74u l=0.13u
X1884 VPWR.t18 VGND.t1308 VPWR.t18 VPWR.t0 sg13_lv_pmos ad=0.34p pd=2.68u as=0 ps=0 w=1u l=1u
X1885 VPWR.t417 VGND.t358 VPWR.t415 VPWR.t5 sg13_lv_pmos ad=0.19p pd=1.38u as=0 ps=0 w=1u l=1u
X1886 sg13cmos5l_xor2_1_0.B a_6094_3144# VPWR.t173 VPWR.t20 sg13_lv_pmos ad=0.2128p pd=1.5u as=0.2128p ps=1.5u w=1.12u l=0.13u
X1887 VGND.t639 VPWR.t297 VGND.t639 VGND.t946 sg13_lv_nmos ad=0.1428p pd=1.52u as=0 ps=0 w=0.42u l=1u
X1888 sg13cmos5l_and2_2_6.A a_3694_10704# VGND.t384 VGND.t156 sg13_lv_nmos ad=0.1406p pd=1.12u as=0.1406p ps=1.12u w=0.74u l=0.13u
X1889 sg13cmos5l_buf_16_0.A a_6094_3898# VPWR.t533 VPWR.t28 sg13_lv_pmos ad=0.2128p pd=1.5u as=0.2128p ps=1.5u w=1.12u l=0.13u
X1890 a_6765_12564# sg13cmos5l_buf_16_24.X VPWR.t1285 VPWR.t13 sg13_lv_pmos ad=0.1596p pd=1.22u as=0.2856p ps=2.36u w=0.84u l=0.13u
X1891 sg13cmos5l_buf_16_38.A a_8110_6168# VPWR.t70 VPWR.t70 sg13_lv_pmos ad=0.2128p pd=1.5u as=0.2128p ps=1.5u w=1.12u l=0.13u
X1892 VPWR.t1259 sg13cmos5l_buf_16_37.X a_6548_13692# VPWR.t8 sg13_lv_pmos ad=0.2128p pd=1.5u as=0.2128p ps=1.5u w=1.12u l=0.13u
X1893 VPWR.t710 a_3694_8434# sg13cmos5l_buf_16_34.A VPWR.t3 sg13_lv_pmos ad=0.2128p pd=1.5u as=0.2128p ps=1.5u w=1.12u l=0.13u
X1894 VPWR.t1486 glitch_en[2] a_5992_14516# VPWR.t292 sg13_lv_pmos ad=0.2114p pd=1.54u as=0.2856p ps=2.36u w=0.84u l=0.13u
X1895 sg13cmos5l_buf_16_4.X a_9524_6886# VGND.t358 VGND.t811 sg13_lv_nmos ad=0.1406p pd=1.12u as=0.2516p ps=2.16u w=0.74u l=0.13u
X1896 VPWR.t101 VGND.t315 VPWR.t100 VPWR.t8 sg13_lv_pmos ad=0.34p pd=2.68u as=0 ps=0 w=1u l=1u
X1897 a_3668_12180# sg13cmos5l_buf_16_15.A VGND.t345 VGND.t510 sg13_lv_nmos ad=0.1406p pd=1.12u as=0.1406p ps=1.12u w=0.74u l=0.13u
X1898 VGND.t1413 VPWR.t18 VGND.t1412 VGND.t1411 sg13_lv_nmos ad=0.1428p pd=1.52u as=0 ps=0 w=0.42u l=1u
X1899 sg13cmos5l_buf_16_15.A a_4052_12934# VGND.t345 VGND.t736 sg13_lv_nmos ad=0.1406p pd=1.12u as=0.1406p ps=1.12u w=0.74u l=0.13u
X1900 VGND.t1020 VPWR.t125 VGND.t1020 VGND.t156 sg13_lv_nmos ad=79.8f pd=0.8u as=0 ps=0 w=0.42u l=1u
X1901 a_8990_2704# sg13cmos5l_xor2_1_0.B a_8538_2578# VPWR.t20 sg13_lv_pmos ad=0.1225p pd=1.245u as=0.34p ps=2.68u w=1u l=0.13u
X1902 a_5684_6132# sg13cmos5l_buf_16_28.A VPWR.t723 VPWR.t70 sg13_lv_pmos ad=0.2128p pd=1.5u as=0.2128p ps=1.5u w=1.12u l=0.13u
X1903 VPWR.t419 VGND.t358 VPWR.t418 VPWR.t5 sg13_lv_pmos ad=0.34p pd=2.68u as=0 ps=0 w=1u l=1u
X1904 VGND.t413 VPWR.t1648 VGND.t413 VGND.t1122 sg13_lv_nmos ad=79.8f pd=0.8u as=0 ps=0 w=0.42u l=1u
X1905 sg13cmos5l_buf_16_8.A a_3668_4620# VGND.t222 VGND.t459 sg13_lv_nmos ad=0.1406p pd=1.12u as=0.1406p ps=1.12u w=0.74u l=0.13u
X1906 sg13cmos5l_buf_16_34.A a_3694_8434# VPWR.t706 VPWR.t3 sg13_lv_pmos ad=0.2128p pd=1.5u as=0.2128p ps=1.5u w=1.12u l=0.13u
X1907 VPWR.t342 sg13cmos5l_buf_16_4.A a_9524_6886# VPWR.t5 sg13_lv_pmos ad=0.2128p pd=1.5u as=0.2128p ps=1.5u w=1.12u l=0.13u
X1908 VPWR.t405 VGND.t358 VPWR.t404 VPWR.t5 sg13_lv_pmos ad=0.19p pd=1.38u as=0 ps=0 w=1u l=1u
X1909 VGND.t402 a_3694_7680# sg13cmos5l_buf_16_34.X VGND.t404 sg13_lv_nmos ad=0.1406p pd=1.12u as=0.1406p ps=1.12u w=0.74u l=0.13u
X1910 VPWR.t292 VGND.t693 VPWR.t292 VPWR.t292 sg13_lv_pmos ad=0.34p pd=2.68u as=0 ps=0 w=1u l=1u
X1911 VPWR.t631 a_10292_12934# sg13cmos5l_buf_16_23.X VPWR.t8 sg13_lv_pmos ad=0.2128p pd=1.5u as=0.2128p ps=1.5u w=1.12u l=0.13u
X1912 a_3694_10704# sg13cmos5l_buf_16_34.X VGND.t384 VGND.t156 sg13_lv_nmos ad=0.1406p pd=1.12u as=0.1406p ps=1.12u w=0.74u l=0.13u
X1913 VPWR.t1490 a_6548_13692# sg13cmos5l_buf_16_27.X VPWR.t8 sg13_lv_pmos ad=0.2128p pd=1.5u as=0.2128p ps=1.5u w=1.12u l=0.13u
X1914 VPWR.t1256 a_6548_13692# sg13cmos5l_buf_16_27.X VPWR.t8 sg13_lv_pmos ad=0.2128p pd=1.5u as=0.2128p ps=1.5u w=1.12u l=0.13u
X1915 VPWR.t1228 sg13cmos5l_buf_16_8.A a_3694_3898# VPWR.t28 sg13_lv_pmos ad=0.2128p pd=1.5u as=0.2128p ps=1.5u w=1.12u l=0.13u
X1916 VGND.t72 sg13cmos5l_buf_16_38.A a_7220_5374# VGND.t849 sg13_lv_nmos ad=0.2516p pd=2.16u as=0.1406p ps=1.12u w=0.74u l=0.13u
X1917 VPWR.t721 sg13cmos5l_buf_16_28.A a_5684_6132# VPWR.t70 sg13_lv_pmos ad=0.2128p pd=1.5u as=0.2128p ps=1.5u w=1.12u l=0.13u
X1918 VGND.t999 VPWR.t1670 VGND.t999 VGND.t156 sg13_lv_nmos ad=79.8f pd=0.8u as=0 ps=0 w=0.42u l=1u
X1919 a_5204_11422# sg13cmos5l_buf_16_19.A VPWR.t660 VPWR.t13 sg13_lv_pmos ad=0.2128p pd=1.5u as=0.2128p ps=1.5u w=1.12u l=0.13u
X1920 VGND.t1029 VPWR.t905 VGND.t157 VGND.t156 sg13_lv_nmos ad=79.8f pd=0.8u as=0 ps=0 w=0.42u l=1u
X1921 a_9524_6886# sg13cmos5l_buf_16_4.A VPWR.t149 VPWR.t5 sg13_lv_pmos ad=0.2128p pd=1.5u as=0.2128p ps=1.5u w=1.12u l=0.13u
X1922 sg13cmos5l_buf_16_34.X a_3694_7680# VGND.t275 VGND.t400 sg13_lv_nmos ad=0.1406p pd=1.12u as=0.1406p ps=1.12u w=0.74u l=0.13u
X1923 VGND.t1 sg13cmos5l_and2_2_6.X a_6836_9156# VGND.t258 sg13_lv_nmos ad=0.1406p pd=1.12u as=0.1406p ps=1.12u w=0.74u l=0.13u
X1924 sg13cmos5l_buf_16_15.A a_4052_12934# VGND.t345 VGND.t732 sg13_lv_nmos ad=0.1406p pd=1.12u as=0.1406p ps=1.12u w=0.74u l=0.13u
X1925 VGND.t169 a_4436_9910# sg13cmos5l_buf_16_14.A VGND.t171 sg13_lv_nmos ad=0.1406p pd=1.12u as=0.1406p ps=1.12u w=0.74u l=0.13u
X1926 sg13cmos5l_buf_16_22.X a_10318_8434# VGND.t11 VGND.t775 sg13_lv_nmos ad=0.1406p pd=1.12u as=0.1406p ps=1.12u w=0.74u l=0.13u
X1927 VGND.t1207 VPWR.t1628 VGND.t1207 VGND.t1211 sg13_lv_nmos ad=0.1428p pd=1.52u as=0 ps=0 w=0.42u l=1u
X1928 VGND.t350 a_5204_11422# sg13cmos5l_buf_16_20.A VGND.t156 sg13_lv_nmos ad=0.1406p pd=1.12u as=0.1406p ps=1.12u w=0.74u l=0.13u
X1929 a_7220_5374# sg13cmos5l_buf_16_38.A VGND.t282 VGND.t846 sg13_lv_nmos ad=0.1406p pd=1.12u as=0.1406p ps=1.12u w=0.74u l=0.13u
X1930 VPWR.t56 sg13cmos5l_buf_1_11.X a_14824_10704# VPWR.t55 sg13_lv_pmos ad=0.2114p pd=1.54u as=0.2856p ps=2.36u w=0.84u l=0.13u
X1931 a_6836_9156# sg13cmos5l_and2_2_6.X VGND.t1 VGND.t255 sg13_lv_nmos ad=0.1406p pd=1.12u as=0.1406p ps=1.12u w=0.74u l=0.13u
X1932 a_5518_6922# sg13cmos5l_buf_16_28.X VGND.t358 VGND.t362 sg13_lv_nmos ad=0.1406p pd=1.12u as=0.1406p ps=1.12u w=0.74u l=0.13u
X1933 VGND.t275 sg13cmos5l_buf_16_34.A a_3694_7680# VGND.t280 sg13_lv_nmos ad=0.1406p pd=1.12u as=0.1406p ps=1.12u w=0.74u l=0.13u
X1934 VGND.t1219 VPWR.t71 VGND.t1219 VGND.t1220 sg13_lv_nmos ad=79.8f pd=0.8u as=0 ps=0 w=0.42u l=1u
X1935 a_6548_13692# sg13cmos5l_buf_16_37.X VGND.t693 VGND.t715 sg13_lv_nmos ad=0.1406p pd=1.12u as=0.1406p ps=1.12u w=0.74u l=0.13u
X1936 VGND.t11 a_10318_8434# sg13cmos5l_buf_16_22.X VGND.t772 sg13_lv_nmos ad=0.1406p pd=1.12u as=0.1406p ps=1.12u w=0.74u l=0.13u
X1937 VPWR.t284 VGND.t150 VPWR.t284 VPWR.t0 sg13_lv_pmos ad=0.19p pd=1.38u as=0 ps=0 w=1u l=1u
X1938 VGND.t92 a_8494_3144# sg13cmos5l_buf_16_39.A VGND.t40 sg13_lv_nmos ad=0.1406p pd=1.12u as=0.1406p ps=1.12u w=0.74u l=0.13u
X1939 sg13cmos5l_and2_2_5.B a_11272_13728# VGND.t636 VGND.t635 sg13_lv_nmos ad=0.2886p pd=2.26u as=0.14875p ps=1.16u w=0.74u l=0.13u
X1940 VGND.t1 a_6862_9946# sg13cmos5l_buf_16_24.X VGND.t108 sg13_lv_nmos ad=0.1406p pd=1.12u as=0.1406p ps=1.12u w=0.74u l=0.13u
X1941 VGND.t897 VPWR.t1694 VGND.t897 VGND.t939 sg13_lv_nmos ad=79.8f pd=0.8u as=0 ps=0 w=0.42u l=1u
X1942 sg13cmos5l_buf_16_20.A a_5204_11422# VPWR.t1297 VPWR.t13 sg13_lv_pmos ad=0.2128p pd=1.5u as=0.2128p ps=1.5u w=1.12u l=0.13u
X1943 VPWR.t552 a_6862_9946# sg13cmos5l_buf_16_24.X VPWR.t55 sg13_lv_pmos ad=0.2128p pd=1.5u as=0.2128p ps=1.5u w=1.12u l=0.13u
X1944 VGND.t397 VPWR.t56 VGND.t397 VGND.t1087 sg13_lv_nmos ad=0.1428p pd=1.52u as=0 ps=0 w=0.42u l=1u
X1945 a_5108_838# sg13cmos5l_buf_16_5.A VPWR.t19 VPWR.t0 sg13_lv_pmos ad=0.2128p pd=1.5u as=0.2128p ps=1.5u w=1.12u l=0.13u
X1946 sg13cmos5l_buf_16_38.A a_8110_6168# VGND.t358 VGND.t550 sg13_lv_nmos ad=0.1406p pd=1.12u as=0.1406p ps=1.12u w=0.74u l=0.13u
X1947 VGND.t999 VPWR.t1679 VGND.t999 VGND.t156 sg13_lv_nmos ad=79.8f pd=0.8u as=0 ps=0 w=0.42u l=1u
X1948 VPWR.t201 VGND.t1130 VPWR.t5 VPWR.t5 sg13_lv_pmos ad=0.34p pd=2.68u as=0 ps=0 w=1u l=1u
X1949 sg13cmos5l_buf_16_24.A a_6094_10704# VPWR.t674 VPWR.t55 sg13_lv_pmos ad=0.2128p pd=1.5u as=0.2128p ps=1.5u w=1.12u l=0.13u
X1950 VGND.t1291 VPWR.t77 VGND.t146 VGND.t1292 sg13_lv_nmos ad=79.8f pd=0.8u as=0 ps=0 w=0.42u l=1u
X1951 VGND.t350 a_5204_11422# sg13cmos5l_buf_16_20.A VGND.t156 sg13_lv_nmos ad=0.1406p pd=1.12u as=0.1406p ps=1.12u w=0.74u l=0.13u
X1952 VPWR.t18 VGND.t1308 VPWR.t18 VPWR.t0 sg13_lv_pmos ad=0.34p pd=2.68u as=0 ps=0 w=1u l=1u
X1953 VPWR.t959 VGND.t1207 VPWR.t958 VPWR.t28 sg13_lv_pmos ad=0.34p pd=2.68u as=0 ps=0 w=1u l=1u
X1954 VGND.t5 sg13cmos5l_buf_16_4.X a_9262_7680# VGND.t66 sg13_lv_nmos ad=0.1406p pd=1.12u as=0.1406p ps=1.12u w=0.74u l=0.13u
X1955 sg13cmos5l_buf_16_22.X a_10318_8434# VGND.t11 VGND.t769 sg13_lv_nmos ad=0.1406p pd=1.12u as=0.1406p ps=1.12u w=0.74u l=0.13u
X1956 VPWR.t1055 VGND.t377 VPWR.t1056 VPWR.t13 sg13_lv_pmos ad=0.19p pd=1.38u as=0 ps=0 w=1u l=1u
X1957 VGND.t358 a_8110_6168# sg13cmos5l_buf_16_38.A VGND.t547 sg13_lv_nmos ad=0.1406p pd=1.12u as=0.1406p ps=1.12u w=0.74u l=0.13u
X1958 VPWR.t202 sg13cmos5l_buf_16_2.A a_10318_3898# VPWR.t28 sg13_lv_pmos ad=0.2128p pd=1.5u as=0.2128p ps=1.5u w=1.12u l=0.13u
X1959 VGND.t207 a_3694_3898# sg13cmos5l_buf_16_10.A VGND.t40 sg13_lv_nmos ad=0.1406p pd=1.12u as=0.1406p ps=1.12u w=0.74u l=0.13u
X1960 sg13cmos5l_buf_16_15.X a_3668_12180# VPWR.t644 VPWR.t13 sg13_lv_pmos ad=0.2128p pd=1.5u as=0.3976p ps=2.95u w=1.12u l=0.13u
X1961 VPWR.t245 a_10318_8434# sg13cmos5l_buf_16_22.X VPWR.t3 sg13_lv_pmos ad=0.2128p pd=1.5u as=0.2128p ps=1.5u w=1.12u l=0.13u
X1962 a_8494_3144# sg13cmos5l_buf_16_0.A VPWR.t21 VPWR.t20 sg13_lv_pmos ad=0.2128p pd=1.5u as=0.2128p ps=1.5u w=1.12u l=0.13u
X1963 sg13cmos5l_buf_16_34.A a_3694_8434# VPWR.t703 VPWR.t3 sg13_lv_pmos ad=0.2128p pd=1.5u as=0.2128p ps=1.5u w=1.12u l=0.13u
X1964 VPWR.t70 sg13cmos5l_buf_16_38.A a_7220_5374# VPWR.t70 sg13_lv_pmos ad=0.2128p pd=1.5u as=0.2128p ps=1.5u w=1.12u l=0.13u
X1965 a_5518_6922# sg13cmos5l_buf_16_28.X VGND.t358 VGND.t357 sg13_lv_nmos ad=0.1406p pd=1.12u as=0.2516p ps=2.16u w=0.74u l=0.13u
X1966 VGND.t315 VPWR.t1690 VGND.t315 VGND.t956 sg13_lv_nmos ad=0.1428p pd=1.52u as=0 ps=0 w=0.42u l=1u
X1967 VPWR.t245 VGND.t11 VPWR.t245 VPWR.t3 sg13_lv_pmos ad=0.34p pd=2.68u as=0 ps=0 w=1u l=1u
X1968 a_9262_7680# sg13cmos5l_buf_16_4.X VGND.t11 VGND.t63 sg13_lv_nmos ad=0.1406p pd=1.12u as=0.2516p ps=2.16u w=0.74u l=0.13u
X1969 VGND.t633 a_13581_9988# sg13cmos5l_and2_2_3.X VGND.t766 sg13_lv_nmos ad=0.2812p pd=2.24u as=0.1406p ps=1.12u w=0.74u l=0.13u
X1970 VPWR.t755 a_6094_4656# sg13cmos5l_buf_16_31.X VPWR.t28 sg13_lv_pmos ad=0.2128p pd=1.5u as=0.2128p ps=1.5u w=1.12u l=0.13u
X1971 VPWR.t1377 a_5684_6132# sg13cmos5l_buf_16_28.X VPWR.t70 sg13_lv_pmos ad=0.2128p pd=1.5u as=0.2128p ps=1.5u w=1.12u l=0.13u
X1972 sg13cmos5l_buf_16_38.A a_8110_6168# VGND.t358 VGND.t544 sg13_lv_nmos ad=0.1406p pd=1.12u as=0.1406p ps=1.12u w=0.74u l=0.13u
X1973 VGND.t639 VPWR.t129 VGND.t639 VGND.t945 sg13_lv_nmos ad=79.8f pd=0.8u as=0 ps=0 w=0.42u l=1u
X1974 out_xor[6] a_14824_13004# VGND.t573 VGND.t623 sg13_lv_nmos ad=0.2886p pd=2.26u as=0.14875p ps=1.16u w=0.74u l=0.13u
X1975 sg13cmos5l_buf_16_3.X a_10292_4620# VGND.t72 VGND.t76 sg13_lv_nmos ad=0.1406p pd=1.12u as=0.1406p ps=1.12u w=0.74u l=0.13u
X1976 a_6094_10704# sg13cmos5l_buf_16_33.A VPWR.t1433 VPWR.t55 sg13_lv_pmos ad=0.2128p pd=1.5u as=0.2128p ps=1.5u w=1.12u l=0.13u
X1977 sg13cmos5l_buf_16_22.X a_10318_8434# VPWR.t245 VPWR.t3 sg13_lv_pmos ad=0.2128p pd=1.5u as=0.2128p ps=1.5u w=1.12u l=0.13u
X1978 VPWR.t312 VGND.t384 VPWR.t311 VPWR.t13 sg13_lv_pmos ad=0.34p pd=2.68u as=0 ps=0 w=1u l=1u
X1979 VGND.t1173 VPWR.t318 VGND.t1173 VGND.t1174 sg13_lv_nmos ad=79.8f pd=0.8u as=0 ps=0 w=0.42u l=1u
X1980 sg13cmos5l_buf_16_7.X a_3694_2386# VPWR.t790 VPWR.t20 sg13_lv_pmos ad=0.2128p pd=1.5u as=0.2128p ps=1.5u w=1.12u l=0.13u
X1981 VPWR.t562 VGND.t377 VPWR.t562 VPWR.t55 sg13_lv_pmos ad=0.34p pd=2.68u as=0 ps=0 w=1u l=1u
X1982 sg13cmos5l_buf_16_5.A a_5710_1632# VPWR.t19 VPWR.t0 sg13_lv_pmos ad=0.2128p pd=1.5u as=0.2128p ps=1.5u w=1.12u l=0.13u
X1983 VGND.t150 VPWR.t19 VGND.t150 VGND.t1327 sg13_lv_nmos ad=0.1428p pd=1.52u as=0 ps=0 w=0.42u l=1u
X1984 VGND.t1418 VPWR.t18 VGND.t1417 VGND.t1416 sg13_lv_nmos ad=0.1428p pd=1.52u as=0 ps=0 w=0.42u l=1u
X1985 VGND.t150 VPWR.t1612 VGND.t150 VGND.t1286 sg13_lv_nmos ad=0.1428p pd=1.52u as=0 ps=0 w=0.42u l=1u
X1986 sg13cmos5l_buf_16_25.A a_6836_9156# VGND.t1 VGND.t107 sg13_lv_nmos ad=0.1406p pd=1.12u as=0.1406p ps=1.12u w=0.74u l=0.13u
X1987 VPWR.t814 sg13cmos5l_buf_16_15.A a_3668_12180# VPWR.t13 sg13_lv_pmos ad=0.2128p pd=1.5u as=0.2128p ps=1.5u w=1.12u l=0.13u
X1988 VPWR.t19 a_5710_1632# sg13cmos5l_buf_16_5.A VPWR.t0 sg13_lv_pmos ad=0.2128p pd=1.5u as=0.2128p ps=1.5u w=1.12u l=0.13u
X1989 VGND.t150 VPWR.t0 VGND.t150 VGND.t1285 sg13_lv_nmos ad=79.8f pd=0.8u as=0 ps=0 w=0.42u l=1u
X1990 VGND.t315 sg13cmos5l_buf_16_37.A a_7796_12934# VGND.t316 sg13_lv_nmos ad=0.1406p pd=1.12u as=0.1406p ps=1.12u w=0.74u l=0.13u
X1991 VPWR.t751 a_6094_4656# sg13cmos5l_buf_16_31.X VPWR.t28 sg13_lv_pmos ad=0.2128p pd=1.5u as=0.2128p ps=1.5u w=1.12u l=0.13u
X1992 VPWR.t1457 sg13cmos5l_and2_2_1.X a_4174_13728# VPWR.t8 sg13_lv_pmos ad=0.2128p pd=1.5u as=0.2128p ps=1.5u w=1.12u l=0.13u
X1993 sg13cmos5l_buf_16_3.X a_10292_4620# VGND.t72 VGND.t71 sg13_lv_nmos ad=0.1406p pd=1.12u as=0.2516p ps=2.16u w=0.74u l=0.13u
X1994 VPWR.t941 VGND.t1207 VPWR.t940 VPWR.t70 sg13_lv_pmos ad=0.34p pd=2.68u as=0 ps=0 w=1u l=1u
X1995 VGND.t573 sg13cmos5l_buf_1_22.X a_14824_13004# VGND.t572 sg13_lv_nmos ad=0.14875p pd=1.16u as=0.187p ps=1.78u w=0.55u l=0.13u
X1996 VPWR.t297 VGND.t934 VPWR.t297 VPWR.t8 sg13_lv_pmos ad=0.34p pd=2.68u as=0 ps=0 w=1u l=1u
X1997 VPWR.t905 VGND.t1079 VPWR.t360 VPWR.t55 sg13_lv_pmos ad=0.19p pd=1.38u as=0 ps=0 w=1u l=1u
X1998 sg13cmos5l_and2_2_0.X a_3875_5396# VPWR.t726 VPWR.t70 sg13_lv_pmos ad=0.2128p pd=1.5u as=0.4256p ps=3u w=1.12u l=0.13u
X1999 VPWR.t689 a_6094_10704# sg13cmos5l_buf_16_24.A VPWR.t55 sg13_lv_pmos ad=0.3976p pd=2.95u as=0.2128p ps=1.5u w=1.12u l=0.13u
X2000 VPWR.t237 a_6836_9156# sg13cmos5l_buf_16_25.A VPWR.t3 sg13_lv_pmos ad=0.2128p pd=1.5u as=0.2128p ps=1.5u w=1.12u l=0.13u
X2001 sg13cmos5l_buf_16_30.A a_6164_2350# VGND.t491 VGND.t499 sg13_lv_nmos ad=0.1406p pd=1.12u as=0.1406p ps=1.12u w=0.74u l=0.13u
X2002 sg13cmos5l_and2_2_6.A a_3694_10704# VPWR.t826 VPWR.t55 sg13_lv_pmos ad=0.2128p pd=1.5u as=0.2128p ps=1.5u w=1.12u l=0.13u
X2003 sg13cmos5l_buf_16_31.X a_6094_4656# VPWR.t747 VPWR.t28 sg13_lv_pmos ad=0.2128p pd=1.5u as=0.2128p ps=1.5u w=1.12u l=0.13u
X2004 VGND.t1369 VPWR.t78 VGND.t1368 VGND.t1367 sg13_lv_nmos ad=0.1428p pd=1.52u as=0 ps=0 w=0.42u l=1u
X2005 VPWR.t631 sg13cmos5l_buf_16_23.X a_8948_13692# VPWR.t8 sg13_lv_pmos ad=0.3808p pd=2.92u as=0.2128p ps=1.5u w=1.12u l=0.13u
X2006 sg13cmos5l_buf_16_13.A a_3668_9156# VGND.t169 VGND.t194 sg13_lv_nmos ad=0.1406p pd=1.12u as=0.1406p ps=1.12u w=0.74u l=0.13u
X2007 VPWR.t963 VGND.t1207 VPWR.t962 VPWR.t28 sg13_lv_pmos ad=0.34p pd=2.68u as=0 ps=0 w=1u l=1u
X2008 VGND.t116 sg13cmos5l_buf_16_22.X a_13745_8484# VGND.t154 sg13_lv_nmos ad=0.15245p pd=1.17u as=0.17462p ps=1.185u w=0.55u l=0.13u
X2009 VGND.t315 a_7796_12934# sg13cmos5l_buf_16_37.X VGND.t620 sg13_lv_nmos ad=0.1406p pd=1.12u as=0.1406p ps=1.12u w=0.74u l=0.13u
X2010 VGND.t207 sg13cmos5l_buf_16_10.A a_3668_3108# VGND.t40 sg13_lv_nmos ad=0.1406p pd=1.12u as=0.1406p ps=1.12u w=0.74u l=0.13u
X2011 sg13cmos5l_buf_1_17.A a_13667_12956# VPWR.t297 VPWR.t8 sg13_lv_pmos ad=0.2128p pd=1.5u as=0.4256p ps=3u w=1.12u l=0.13u
X2012 sg13cmos5l_buf_16_25.A a_6836_9156# VPWR.t233 VPWR.t3 sg13_lv_pmos ad=0.2128p pd=1.5u as=0.2128p ps=1.5u w=1.12u l=0.13u
X2013 VPWR.t572 VGND.t1153 VPWR.t570 VPWR.t5 sg13_lv_pmos ad=0.19p pd=1.38u as=0 ps=0 w=1u l=1u
X2014 sg13cmos5l_buf_16_18.A a_4174_13728# VGND.t942 VGND.t1453 sg13_lv_nmos ad=0.1406p pd=1.12u as=0.1406p ps=1.12u w=0.74u l=0.13u
X2015 a_8948_13692# sg13cmos5l_buf_16_23.X VGND.t636 VGND.t697 sg13_lv_nmos ad=0.1406p pd=1.12u as=0.1406p ps=1.12u w=0.74u l=0.13u
X2016 VGND.t491 a_6164_2350# sg13cmos5l_buf_16_30.A VGND.t496 sg13_lv_nmos ad=0.1406p pd=1.12u as=0.1406p ps=1.12u w=0.74u l=0.13u
X2017 VPWR.t245 VGND.t1079 VPWR.t245 VPWR.t3 sg13_lv_pmos ad=0.19p pd=1.38u as=0 ps=0 w=1u l=1u
X2018 VGND.t1291 VPWR.t77 VGND.t150 VGND.t1290 sg13_lv_nmos ad=0.1428p pd=1.52u as=0 ps=0 w=0.42u l=1u
X2019 VGND.t693 a_8948_13692# sg13cmos5l_buf_16_37.A VGND.t708 sg13_lv_nmos ad=0.1406p pd=1.12u as=0.1406p ps=1.12u w=0.74u l=0.13u
X2020 sg13cmos5l_buf_16_23.X a_10292_12934# VGND.t315 VGND.t642 sg13_lv_nmos ad=0.1406p pd=1.12u as=0.1406p ps=1.12u w=0.74u l=0.13u
X2021 VPWR.t382 VGND.t1219 VPWR.t381 VPWR.t28 sg13_lv_pmos ad=0.19p pd=1.38u as=0 ps=0 w=1u l=1u
X2022 sg13cmos5l_buf_16_38.A a_8110_6168# VPWR.t70 VPWR.t70 sg13_lv_pmos ad=0.2128p pd=1.5u as=0.2128p ps=1.5u w=1.12u l=0.13u
X2023 sg13cmos5l_buf_16_2.A a_9262_7680# VPWR.t136 VPWR.t5 sg13_lv_pmos ad=0.2128p pd=1.5u as=0.2128p ps=1.5u w=1.12u l=0.13u
X2024 sg13cmos5l_buf_16_7.X a_3694_2386# VPWR.t786 VPWR.t20 sg13_lv_pmos ad=0.2128p pd=1.5u as=0.2128p ps=1.5u w=1.12u l=0.13u
X2025 VGND.t116 VPWR.t5 VGND.t1129 VGND.t1150 sg13_lv_nmos ad=79.8f pd=0.8u as=0 ps=0 w=0.42u l=1u
X2026 VGND.t165 a_3668_9156# sg13cmos5l_buf_16_13.A VGND.t191 sg13_lv_nmos ad=0.1406p pd=1.12u as=0.1406p ps=1.12u w=0.74u l=0.13u
X2027 sg13cmos5l_and2_2_6.A a_3694_10704# VPWR.t822 VPWR.t55 sg13_lv_pmos ad=0.2128p pd=1.5u as=0.2128p ps=1.5u w=1.12u l=0.13u
X2028 sg13cmos5l_buf_16_33.A a_3694_14482# VGND.t942 VGND.t1506 sg13_lv_nmos ad=0.1406p pd=1.12u as=0.1406p ps=1.12u w=0.74u l=0.13u
X2029 VGND.t999 VPWR.t1669 VGND.t1004 VGND.t156 sg13_lv_nmos ad=79.8f pd=0.8u as=0 ps=0 w=0.42u l=1u
X2030 sg13cmos5l_buf_16_30.A a_6164_2350# VGND.t491 VGND.t493 sg13_lv_nmos ad=0.1406p pd=1.12u as=0.1406p ps=1.12u w=0.74u l=0.13u
X2031 VPWR.t761 a_3668_4620# sg13cmos5l_buf_16_8.A VPWR.t28 sg13_lv_pmos ad=0.2128p pd=1.5u as=0.2128p ps=1.5u w=1.12u l=0.13u
X2032 VGND.t915 VPWR.t1698 VGND.t912 VGND.t914 sg13_lv_nmos ad=0.1428p pd=1.52u as=0 ps=0 w=0.42u l=1u
X2033 VGND.t851 VPWR.t381 VGND.t851 VGND.t1243 sg13_lv_nmos ad=79.8f pd=0.8u as=0 ps=0 w=0.42u l=1u
X2034 VGND.t413 a_3694_8434# sg13cmos5l_buf_16_34.A VGND.t412 sg13_lv_nmos ad=0.1406p pd=1.12u as=0.1406p ps=1.12u w=0.74u l=0.13u
X2035 VGND.t1248 VPWR.t1619 VGND.t1248 VGND.t40 sg13_lv_nmos ad=79.8f pd=0.8u as=0 ps=0 w=0.42u l=1u
X2036 VGND.t1176 VPWR.t315 VGND.t1178 VGND.t1177 sg13_lv_nmos ad=79.8f pd=0.8u as=0 ps=0 w=0.42u l=1u
X2037 VGND.t1060 VPWR.t1665 VGND.t1060 VGND.t1063 sg13_lv_nmos ad=79.8f pd=0.8u as=0 ps=0 w=0.42u l=1u
X2038 VGND.t315 VPWR.t118 VGND.t315 VGND.t982 sg13_lv_nmos ad=0.1428p pd=1.52u as=0 ps=0 w=0.42u l=1u
X2039 sg13cmos5l_buf_16_0.A a_6094_3898# VGND.t41 VGND.t40 sg13_lv_nmos ad=0.1406p pd=1.12u as=0.1406p ps=1.12u w=0.74u l=0.13u
X2040 VGND.t11 VPWR.t1651 VGND.t11 VGND.t1115 sg13_lv_nmos ad=79.8f pd=0.8u as=0 ps=0 w=0.42u l=1u
X2041 a_4174_13728# sg13cmos5l_and2_2_1.X VGND.t942 VGND.t1474 sg13_lv_nmos ad=0.1406p pd=1.12u as=0.1406p ps=1.12u w=0.74u l=0.13u
X2042 VGND.t413 VPWR.t1647 VGND.t413 VGND.t1141 sg13_lv_nmos ad=0.1428p pd=1.52u as=0 ps=0 w=0.42u l=1u
X2043 VGND.t693 a_8948_13692# sg13cmos5l_buf_16_37.A VGND.t704 sg13_lv_nmos ad=0.1406p pd=1.12u as=0.1406p ps=1.12u w=0.74u l=0.13u
X2044 VPWR.t631 sg13cmos5l_buf_1_17.X a_12350_13728# VPWR.t8 sg13_lv_pmos ad=0.36p pd=2.72u as=0.1225p ps=1.245u w=1u l=0.13u
X2045 VPWR.t432 VGND.t358 VPWR.t430 VPWR.t70 sg13_lv_pmos ad=0.19p pd=1.38u as=0 ps=0 w=1u l=1u
X2046 VPWR.t1323 a_3694_7680# sg13cmos5l_buf_16_34.X VPWR.t5 sg13_lv_pmos ad=0.2128p pd=1.5u as=0.2128p ps=1.5u w=1.12u l=0.13u
X2047 VGND.t897 a_3020_14442# sg13cmos5l_and2_2_1.B VGND.t896 sg13_lv_nmos ad=0.14875p pd=1.16u as=0.2886p ps=2.26u w=0.74u l=0.13u
X2048 a_6766_8434# sg13cmos5l_buf_16_25.A VGND.t413 VGND.t575 sg13_lv_nmos ad=0.1406p pd=1.12u as=0.2516p ps=2.16u w=0.74u l=0.13u
X2049 VPWR.t407 VGND.t358 VPWR.t406 VPWR.t5 sg13_lv_pmos ad=0.34p pd=2.68u as=0 ps=0 w=1u l=1u
X2050 VPWR.t310 VGND.t384 VPWR.t308 VPWR.t13 sg13_lv_pmos ad=0.19p pd=1.38u as=0 ps=0 w=1u l=1u
X2051 VPWR.t502 a_3668_3108# sg13cmos5l_buf_16_7.A VPWR.t20 sg13_lv_pmos ad=0.2128p pd=1.5u as=0.2128p ps=1.5u w=1.12u l=0.13u
X2052 VPWR.t76 VGND.t942 VPWR.t75 VPWR.t8 sg13_lv_pmos ad=0.19p pd=1.38u as=0 ps=0 w=1u l=1u
X2053 a_3694_10704# sg13cmos5l_buf_16_34.X VPWR.t693 VPWR.t55 sg13_lv_pmos ad=0.2128p pd=1.5u as=0.2128p ps=1.5u w=1.12u l=0.13u
X2054 a_3875_5396# sg13cmos5l_xor2_1_0.B a_4105_5452# VGND.t581 sg13_lv_nmos ad=0.2176p pd=1.96u as=0.1216p ps=1.02u w=0.64u l=0.13u
X2055 a_8110_6168# sg13cmos5l_buf_16_35.A VPWR.t1549 VPWR.t70 sg13_lv_pmos ad=0.2128p pd=1.5u as=0.2128p ps=1.5u w=1.12u l=0.13u
X2056 sg13cmos5l_buf_16_0.A a_6094_3898# VPWR.t543 VPWR.t28 sg13_lv_pmos ad=0.2128p pd=1.5u as=0.2128p ps=1.5u w=1.12u l=0.13u
X2057 sg13cmos5l_buf_16_4.X a_9524_6886# VPWR.t136 VPWR.t5 sg13_lv_pmos ad=0.2128p pd=1.5u as=0.2128p ps=1.5u w=1.12u l=0.13u
X2058 VGND.t322 sg13cmos5l_buf_1_17.A a_10292_12934# VGND.t328 sg13_lv_nmos ad=0.2516p pd=2.16u as=0.1406p ps=1.12u w=0.74u l=0.13u
X2059 VGND.t41 enable a_6094_3898# VGND.t40 sg13_lv_nmos ad=0.1406p pd=1.12u as=0.1406p ps=1.12u w=0.74u l=0.13u
X2060 sg13cmos5l_buf_16_37.X a_7796_12934# VPWR.t920 VPWR.t8 sg13_lv_pmos ad=0.2128p pd=1.5u as=0.2128p ps=1.5u w=1.12u l=0.13u
X2061 sg13cmos5l_buf_16_33.A a_3694_14482# VPWR.t1513 VPWR.t292 sg13_lv_pmos ad=0.2128p pd=1.5u as=0.2128p ps=1.5u w=1.12u l=0.13u
X2062 a_3694_7680# sg13cmos5l_buf_16_34.A VPWR.t596 VPWR.t5 sg13_lv_pmos ad=0.2128p pd=1.5u as=0.2128p ps=1.5u w=1.12u l=0.13u
X2063 VPWR.t109 VGND.t315 VPWR.t107 VPWR.t13 sg13_lv_pmos ad=0.19p pd=1.38u as=0 ps=0 w=1u l=1u
X2064 VPWR.t118 VGND.t315 VPWR.t117 VPWR.t13 sg13_lv_pmos ad=0.34p pd=2.68u as=0 ps=0 w=1u l=1u
X2065 a_4052_12934# sg13cmos5l_buf_16_18.A VPWR.t1536 VPWR.t8 sg13_lv_pmos ad=0.2128p pd=1.5u as=0.2128p ps=1.5u w=1.12u l=0.13u
X2066 VPWR.t181 a_6094_3144# sg13cmos5l_xor2_1_0.B VPWR.t20 sg13_lv_pmos ad=0.2128p pd=1.5u as=0.2128p ps=1.5u w=1.12u l=0.13u
X2067 sg13cmos5l_buf_16_7.A a_3668_3108# VPWR.t498 VPWR.t20 sg13_lv_pmos ad=0.2128p pd=1.5u as=0.2128p ps=1.5u w=1.12u l=0.13u
X2068 VPWR.t190 VGND.t1060 VPWR.t190 VPWR.t3 sg13_lv_pmos ad=0.19p pd=1.38u as=0 ps=0 w=1u l=1u
X2069 VGND.t402 a_3694_8434# sg13cmos5l_buf_16_34.A VGND.t408 sg13_lv_nmos ad=0.1406p pd=1.12u as=0.1406p ps=1.12u w=0.74u l=0.13u
X2070 a_10318_5410# sg13cmos5l_buf_16_3.X VGND.t72 VGND.t76 sg13_lv_nmos ad=0.1406p pd=1.12u as=0.1406p ps=1.12u w=0.74u l=0.13u
X2071 VPWR.t1547 sg13cmos5l_buf_16_35.A a_8110_6168# VPWR.t70 sg13_lv_pmos ad=0.2128p pd=1.5u as=0.2128p ps=1.5u w=1.12u l=0.13u
X2072 VPWR.t136 a_9524_6886# sg13cmos5l_buf_16_4.X VPWR.t5 sg13_lv_pmos ad=0.2128p pd=1.5u as=0.2128p ps=1.5u w=1.12u l=0.13u
X2073 VPWR.t913 VGND.t639 VPWR.t911 VPWR.t292 sg13_lv_pmos ad=0.19p pd=1.38u as=0 ps=0 w=1u l=1u
X2074 sg13cmos5l_buf_16_25.A a_6836_9156# VPWR.t229 VPWR.t3 sg13_lv_pmos ad=0.2128p pd=1.5u as=0.2128p ps=1.5u w=1.12u l=0.13u
X2075 VGND.t11 VPWR.t342 VGND.t11 VGND.t1146 sg13_lv_nmos ad=79.8f pd=0.8u as=0 ps=0 w=0.42u l=1u
X2076 VGND.t413 a_3694_7680# sg13cmos5l_buf_16_34.X VGND.t415 sg13_lv_nmos ad=0.2516p pd=2.16u as=0.1406p ps=1.12u w=0.74u l=0.13u
X2077 sg13cmos5l_buf_16_34.A a_3694_8434# VPWR.t716 VPWR.t3 sg13_lv_pmos ad=0.2128p pd=1.5u as=0.2128p ps=1.5u w=1.12u l=0.13u
X2078 sg13cmos5l_buf_16_23.X a_10292_12934# VPWR.t631 VPWR.t8 sg13_lv_pmos ad=0.2128p pd=1.5u as=0.2128p ps=1.5u w=1.12u l=0.13u
X2079 VPWR.t202 a_10292_4620# sg13cmos5l_buf_16_3.X VPWR.t28 sg13_lv_pmos ad=0.2128p pd=1.5u as=0.2128p ps=1.5u w=1.12u l=0.13u
X2080 a_9262_7680# sg13cmos5l_buf_16_4.X VPWR.t136 VPWR.t5 sg13_lv_pmos ad=0.2128p pd=1.5u as=0.2128p ps=1.5u w=1.12u l=0.13u
X2081 VGND.t800 sg13cmos5l_and2_2_6.B a_7723_8028# VGND.t1529 sg13_lv_nmos ad=0.1331p pd=1.12u as=0.1216p ps=1.02u w=0.64u l=0.13u
X2082 a_6548_13692# sg13cmos5l_buf_16_37.X VPWR.t1256 VPWR.t8 sg13_lv_pmos ad=0.2128p pd=1.5u as=0.2128p ps=1.5u w=1.12u l=0.13u
X2083 VGND.t315 a_10292_12934# sg13cmos5l_buf_16_23.X VGND.t645 sg13_lv_nmos ad=0.1406p pd=1.12u as=0.1406p ps=1.12u w=0.74u l=0.13u
X2084 sg13cmos5l_and2_2_0.B a_1672_14516# VPWR.t1404 VPWR.t292 sg13_lv_pmos ad=0.42p pd=2.99u as=0.2114p ps=1.54u w=1.12u l=0.13u
X2085 VGND.t322 sg13cmos5l_buf_1_17.A a_10292_12934# VGND.t324 sg13_lv_nmos ad=0.1406p pd=1.12u as=0.1406p ps=1.12u w=0.74u l=0.13u
X2086 VPWR.t874 sg13cmos5l_buf_16_25.A a_6766_8434# VPWR.t3 sg13_lv_pmos ad=0.2128p pd=1.5u as=0.2128p ps=1.5u w=1.12u l=0.13u
X2087 VGND.t23 a_3668_4620# sg13cmos5l_buf_16_8.A VGND.t468 sg13_lv_nmos ad=0.1406p pd=1.12u as=0.1406p ps=1.12u w=0.74u l=0.13u
X2088 sg13cmos5l_buf_16_34.X a_3694_7680# VGND.t402 VGND.t411 sg13_lv_nmos ad=0.1406p pd=1.12u as=0.1406p ps=1.12u w=0.74u l=0.13u
X2089 VPWR.t44 VGND.t1248 VPWR.t42 VPWR.t28 sg13_lv_pmos ad=0.19p pd=1.38u as=0 ps=0 w=1u l=1u
X2090 VGND.t315 VPWR.t1687 VGND.t315 VGND.t962 sg13_lv_nmos ad=0.1428p pd=1.52u as=0 ps=0 w=0.42u l=1u
X2091 VGND.t1207 VPWR.t1630 VGND.t1207 VGND.t1206 sg13_lv_nmos ad=0.1428p pd=1.52u as=0 ps=0 w=0.42u l=1u
X2092 VGND.t146 VPWR.t78 VGND.t146 VGND.t1323 sg13_lv_nmos ad=0.1428p pd=1.52u as=0 ps=0 w=0.42u l=1u
X2093 VPWR.t381 VGND.t366 VPWR.t381 VPWR.t28 sg13_lv_pmos ad=0.19p pd=1.38u as=0 ps=0 w=1u l=1u
X2094 a_10318_5410# sg13cmos5l_buf_16_3.X VGND.t72 VGND.t71 sg13_lv_nmos ad=0.1406p pd=1.12u as=0.2516p ps=2.16u w=0.74u l=0.13u
X2095 VPWR.t976 VGND.t27 VPWR.t975 VPWR.t70 sg13_lv_pmos ad=0.34p pd=2.68u as=0 ps=0 w=1u l=1u
X2096 sg13cmos5l_buf_16_23.X a_10292_12934# VPWR.t631 VPWR.t8 sg13_lv_pmos ad=0.2128p pd=1.5u as=0.2128p ps=1.5u w=1.12u l=0.13u
X2097 sg13cmos5l_buf_16_8.A a_3668_4620# VGND.t222 VGND.t465 sg13_lv_nmos ad=0.1406p pd=1.12u as=0.1406p ps=1.12u w=0.74u l=0.13u
X2098 VGND.t358 VPWR.t1638 VGND.t358 VGND.t1166 sg13_lv_nmos ad=0.1428p pd=1.52u as=0 ps=0 w=0.42u l=1u
X2099 sg13cmos5l_buf_16_13.A a_3668_9156# VPWR.t474 VPWR.t3 sg13_lv_pmos ad=0.2128p pd=1.5u as=0.2128p ps=1.5u w=1.12u l=0.13u
X2100 VGND.t72 VPWR.t70 VGND.t72 VGND.t1217 sg13_lv_nmos ad=79.8f pd=0.8u as=0 ps=0 w=0.42u l=1u
X2101 VPWR.t70 sg13cmos5l_buf_16_3.X a_10318_5410# VPWR.t70 sg13_lv_pmos ad=0.2128p pd=1.5u as=0.2128p ps=1.5u w=1.12u l=0.13u
X2102 VGND.t1248 VPWR.t1618 VGND.t198 VGND.t40 sg13_lv_nmos ad=79.8f pd=0.8u as=0 ps=0 w=0.42u l=1u
X2103 VPWR.t1299 a_5204_11422# sg13cmos5l_buf_16_20.A VPWR.t13 sg13_lv_pmos ad=0.2128p pd=1.5u as=0.2128p ps=1.5u w=1.12u l=0.13u
X2104 sg13cmos5l_buf_16_14.A a_4436_9910# VGND.t1 VGND.t180 sg13_lv_nmos ad=0.1406p pd=1.12u as=0.1406p ps=1.12u w=0.74u l=0.13u
X2105 sg13cmos5l_xor2_1_0.B a_6094_3144# VGND.t41 VGND.t40 sg13_lv_nmos ad=0.1406p pd=1.12u as=0.1406p ps=1.12u w=0.74u l=0.13u
X2106 VPWR.t71 VGND.t1219 VPWR.t71 VPWR.t70 sg13_lv_pmos ad=0.34p pd=2.68u as=0 ps=0 w=1u l=1u
X2107 VGND.t1296 VPWR.t21 VGND.t1300 VGND.t1299 sg13_lv_nmos ad=79.8f pd=0.8u as=0 ps=0 w=0.42u l=1u
X2108 sg13cmos5l_buf_1_2.A a_8538_2578# VGND.t584 VGND.t691 sg13_lv_nmos ad=0.1628p pd=1.18u as=0.3108p ps=2.32u w=0.74u l=0.13u
X2109 sg13cmos5l_buf_16_2.X a_10318_3898# VPWR.t202 VPWR.t28 sg13_lv_pmos ad=0.2128p pd=1.5u as=0.2128p ps=1.5u w=1.12u l=0.13u
X2110 VPWR.t882 a_3694_3898# sg13cmos5l_buf_16_10.A VPWR.t28 sg13_lv_pmos ad=0.2128p pd=1.5u as=0.2128p ps=1.5u w=1.12u l=0.13u
X2111 VGND.t41 enable a_6094_3898# VGND.t40 sg13_lv_nmos ad=0.1406p pd=1.12u as=0.1406p ps=1.12u w=0.74u l=0.13u
X2112 a_9882_8446# sg13cmos5l_buf_16_35.A VGND.t5 VGND.t1543 sg13_lv_nmos ad=88.8f pd=0.98u as=0.15245p ps=1.17u w=0.74u l=0.13u
X2113 VGND.t222 a_3668_4620# sg13cmos5l_buf_16_8.A VGND.t462 sg13_lv_nmos ad=0.1406p pd=1.12u as=0.1406p ps=1.12u w=0.74u l=0.13u
X2114 sg13cmos5l_and2_2_1.X a_2147_13692# VPWR.t1473 VPWR.t8 sg13_lv_pmos ad=0.2128p pd=1.5u as=0.4256p ps=3u w=1.12u l=0.13u
X2115 sg13cmos5l_buf_16_34.X a_3694_7680# VGND.t402 VGND.t407 sg13_lv_nmos ad=0.1406p pd=1.12u as=0.1406p ps=1.12u w=0.74u l=0.13u
X2116 VPWR.t411 VGND.t358 VPWR.t410 VPWR.t5 sg13_lv_pmos ad=0.34p pd=2.68u as=0 ps=0 w=1u l=1u
X2117 VPWR.t905 VGND.t1079 VPWR.t905 VPWR.t55 sg13_lv_pmos ad=0.19p pd=1.38u as=0 ps=0 w=1u l=1u
X2118 sg13cmos5l_buf_16_7.A a_3668_3108# VPWR.t494 VPWR.t20 sg13_lv_pmos ad=0.2128p pd=1.5u as=0.2128p ps=1.5u w=1.12u l=0.13u
X2119 VGND.t1 a_4436_9910# sg13cmos5l_buf_16_14.A VGND.t177 sg13_lv_nmos ad=0.1406p pd=1.12u as=0.1406p ps=1.12u w=0.74u l=0.13u
X2120 sg13cmos5l_buf_16_22.X a_10318_8434# VGND.t11 VGND.t781 sg13_lv_nmos ad=0.1406p pd=1.12u as=0.1406p ps=1.12u w=0.74u l=0.13u
X2121 VGND.t41 sg13cmos5l_buf_16_5.X a_6094_3144# VGND.t40 sg13_lv_nmos ad=0.1406p pd=1.12u as=0.1406p ps=1.12u w=0.74u l=0.13u
X2122 VPWR.t1606 VGND.t275 VPWR.t1098 VPWR.t3 sg13_lv_pmos ad=0.19p pd=1.38u as=0 ps=0 w=1u l=1u
X2123 VGND.t315 VPWR.t123 VGND.t315 VGND.t987 sg13_lv_nmos ad=79.8f pd=0.8u as=0 ps=0 w=0.42u l=1u
X2124 VPWR.t202 a_10318_3898# sg13cmos5l_buf_16_2.X VPWR.t28 sg13_lv_pmos ad=0.2128p pd=1.5u as=0.2128p ps=1.5u w=1.12u l=0.13u
X2125 a_3694_3898# sg13cmos5l_buf_16_8.A VPWR.t1230 VPWR.t28 sg13_lv_pmos ad=0.2128p pd=1.5u as=0.2128p ps=1.5u w=1.12u l=0.13u
X2126 VPWR.t645 a_3668_12180# sg13cmos5l_buf_16_15.X VPWR.t13 sg13_lv_pmos ad=0.2128p pd=1.5u as=0.2128p ps=1.5u w=1.12u l=0.13u
X2127 sg13cmos5l_buf_16_34.A a_3694_8434# VPWR.t712 VPWR.t3 sg13_lv_pmos ad=0.2128p pd=1.5u as=0.2128p ps=1.5u w=1.12u l=0.13u
X2128 sg13cmos5l_buf_16_6.X a_5518_6922# VGND.t358 VGND.t669 sg13_lv_nmos ad=0.1406p pd=1.12u as=0.1406p ps=1.12u w=0.74u l=0.13u
X2129 VPWR.t1295 a_5204_11422# sg13cmos5l_buf_16_20.A VPWR.t13 sg13_lv_pmos ad=0.2128p pd=1.5u as=0.2128p ps=1.5u w=1.12u l=0.13u
X2130 sg13cmos5l_buf_16_24.X a_6862_9946# VPWR.t548 VPWR.t55 sg13_lv_pmos ad=0.2128p pd=1.5u as=0.2128p ps=1.5u w=1.12u l=0.13u
X2131 VGND.t11 a_10318_8434# sg13cmos5l_buf_16_22.X VGND.t778 sg13_lv_nmos ad=0.1406p pd=1.12u as=0.1406p ps=1.12u w=0.74u l=0.13u
X2132 VPWR.t70 sg13cmos5l_buf_16_3.X a_10318_5410# VPWR.t70 sg13_lv_pmos ad=0.2128p pd=1.5u as=0.2128p ps=1.5u w=1.12u l=0.13u
X2133 VGND.t1020 VPWR.t125 VGND.t1020 VGND.t156 sg13_lv_nmos ad=0.1428p pd=1.52u as=0 ps=0 w=0.42u l=1u
X2134 VPWR.t245 VGND.t1079 VPWR.t245 VPWR.t3 sg13_lv_pmos ad=0.19p pd=1.38u as=0 ps=0 w=1u l=1u
X2135 VPWR.t7 VGND.t1380 VPWR.t6 VPWR.t0 sg13_lv_pmos ad=0.19p pd=1.38u as=0 ps=0 w=1u l=1u
X2136 a_11659_8028# sg13cmos5l_buf_16_6.X a_11565_8028# VGND.t162 sg13_lv_nmos ad=0.1216p pd=1.02u as=0.2176p ps=1.96u w=0.64u l=0.13u
X2137 sg13cmos5l_and2_2_6.B a_7432_14516# VPWR.t1485 VPWR.t292 sg13_lv_pmos ad=0.42p pd=2.99u as=0.2114p ps=1.54u w=1.12u l=0.13u
X2138 VGND.t315 VPWR.t1685 VGND.t315 VGND.t952 sg13_lv_nmos ad=0.1428p pd=1.52u as=0 ps=0 w=0.42u l=1u
X2139 VGND.t315 a_6161_12574# sg13cmos5l_buf_1_5.A VGND.t743 sg13_lv_nmos ad=0.3108p pd=2.32u as=0.1628p ps=1.18u w=0.74u l=0.13u
X2140 VPWR.t668 sg13cmos5l_buf_16_28.X a_5518_6922# VPWR.t5 sg13_lv_pmos ad=0.2128p pd=1.5u as=0.2128p ps=1.5u w=1.12u l=0.13u
X2141 VGND.t1125 VPWR.t315 VGND.t1127 VGND.t1148 sg13_lv_nmos ad=79.8f pd=0.8u as=0 ps=0 w=0.42u l=1u
X2142 VPWR.t21 a_8494_3144# sg13cmos5l_buf_16_39.A VPWR.t20 sg13_lv_pmos ad=0.2128p pd=1.5u as=0.2128p ps=1.5u w=1.12u l=0.13u
X2143 VGND.t23 sg13cmos5l_and2_2_0.X a_4462_5410# VGND.t225 sg13_lv_nmos ad=0.1406p pd=1.12u as=0.1406p ps=1.12u w=0.74u l=0.13u
X2144 VGND.t358 a_5518_6922# sg13cmos5l_buf_16_6.X VGND.t666 sg13_lv_nmos ad=0.1406p pd=1.12u as=0.1406p ps=1.12u w=0.74u l=0.13u
X2145 VPWR.t125 VGND.t315 VPWR.t123 VPWR.t13 sg13_lv_pmos ad=0.19p pd=1.38u as=0 ps=0 w=1u l=1u
X2146 sg13cmos5l_buf_16_24.A a_6094_10704# VGND.t350 VGND.t156 sg13_lv_nmos ad=0.1406p pd=1.12u as=0.1406p ps=1.12u w=0.74u l=0.13u
X2147 VPWR.t71 VGND.t126 VPWR.t319 VPWR.t70 sg13_lv_pmos ad=0.34p pd=2.68u as=0 ps=0 w=1u l=1u
X2148 VGND.t1388 VPWR.t24 VGND.t1390 VGND.t1389 sg13_lv_nmos ad=79.8f pd=0.8u as=0 ps=0 w=0.42u l=1u
X2149 VGND.t1296 VPWR.t1 VGND.t1300 VGND.t1336 sg13_lv_nmos ad=79.8f pd=0.8u as=0 ps=0 w=0.42u l=1u
X2150 VPWR.t1175 VGND.t1004 VPWR.t1174 VPWR.t55 sg13_lv_pmos ad=0.34p pd=2.68u as=0 ps=0 w=1u l=1u
X2151 VGND.t244 VPWR.t1621 VGND.t244 VGND.t40 sg13_lv_nmos ad=79.8f pd=0.8u as=0 ps=0 w=0.42u l=1u
X2152 VGND.t157 VPWR.t56 VGND.t157 VGND.t156 sg13_lv_nmos ad=0.1428p pd=1.52u as=0 ps=0 w=0.42u l=1u
X2153 a_6862_9946# sg13cmos5l_buf_16_24.A VPWR.t590 VPWR.t55 sg13_lv_pmos ad=0.2128p pd=1.5u as=0.2128p ps=1.5u w=1.12u l=0.13u
X2154 VPWR.t245 a_10318_8434# sg13cmos5l_buf_16_22.X VPWR.t3 sg13_lv_pmos ad=0.3976p pd=2.95u as=0.2128p ps=1.5u w=1.12u l=0.13u
X2155 sg13cmos5l_buf_16_39.A a_8494_3144# VPWR.t21 VPWR.t20 sg13_lv_pmos ad=0.2128p pd=1.5u as=0.2128p ps=1.5u w=1.12u l=0.13u
X2156 a_4462_5410# sg13cmos5l_and2_2_0.X VGND.t222 VGND.t221 sg13_lv_nmos ad=0.1406p pd=1.12u as=0.2516p ps=2.16u w=0.74u l=0.13u
X2157 VPWR.t315 VGND.t1125 VPWR.t315 VPWR.t5 sg13_lv_pmos ad=0.34p pd=2.68u as=0 ps=0 w=1u l=1u
X2158 VGND.t345 a_3668_12180# sg13cmos5l_buf_16_15.X VGND.t347 sg13_lv_nmos ad=0.1406p pd=1.12u as=0.1406p ps=1.12u w=0.74u l=0.13u
X2159 a_8564_2680# sg13cmos5l_buf_16_39.A VPWR.t880 VPWR.t20 sg13_lv_pmos ad=0.3808p pd=2.92u as=0.2128p ps=1.5u w=1.12u l=0.13u
X2160 VGND.t150 VPWR.t19 VGND.t150 VGND.t1325 sg13_lv_nmos ad=0.1428p pd=1.52u as=0 ps=0 w=0.42u l=1u
X2161 VGND.t330 sg13cmos5l_buf_1_17.X a_12054_14086# VGND.t637 sg13_lv_nmos ad=0.15245p pd=1.17u as=88.8f ps=0.98u w=0.74u l=0.13u
X2162 VPWR.t990 VGND.t332 VPWR.t989 VPWR.t8 sg13_lv_pmos ad=0.34p pd=2.68u as=0 ps=0 w=1u l=1u
X2163 VPWR.t631 sg13cmos5l_buf_16_37.A a_7796_12934# VPWR.t8 sg13_lv_pmos ad=0.3808p pd=2.92u as=0.2128p ps=1.5u w=1.12u l=0.13u
X2164 VPWR.t574 VGND.t1153 VPWR.t573 VPWR.t5 sg13_lv_pmos ad=0.34p pd=2.68u as=0 ps=0 w=1u l=1u
X2165 sg13cmos5l_buf_16_18.A a_4174_13728# VPWR.t1457 VPWR.t8 sg13_lv_pmos ad=0.2128p pd=1.5u as=0.2128p ps=1.5u w=1.12u l=0.13u
X2166 a_8948_13692# sg13cmos5l_buf_16_23.X VPWR.t631 VPWR.t8 sg13_lv_pmos ad=0.2128p pd=1.5u as=0.2128p ps=1.5u w=1.12u l=0.13u
X2167 VPWR.t131 VGND.t1020 VPWR.t130 VPWR.t13 sg13_lv_pmos ad=0.34p pd=2.68u as=0 ps=0 w=1u l=1u
X2168 sg13cmos5l_buf_16_3.X a_10292_4620# VGND.t82 VGND.t83 sg13_lv_nmos ad=0.1406p pd=1.12u as=0.1406p ps=1.12u w=0.74u l=0.13u
X2169 sg13cmos5l_buf_16_24.A a_6094_10704# VGND.t350 VGND.t156 sg13_lv_nmos ad=0.1406p pd=1.12u as=0.1406p ps=1.12u w=0.74u l=0.13u
X2170 VGND.t358 VPWR.t1637 VGND.t358 VGND.t1168 sg13_lv_nmos ad=0.1428p pd=1.52u as=0 ps=0 w=0.42u l=1u
X2171 sg13cmos5l_buf_16_22.X a_10318_8434# VPWR.t245 VPWR.t3 sg13_lv_pmos ad=0.2128p pd=1.5u as=0.2128p ps=1.5u w=1.12u l=0.13u
X2172 VPWR.t631 a_8948_13692# sg13cmos5l_buf_16_37.A VPWR.t8 sg13_lv_pmos ad=0.2128p pd=1.5u as=0.2128p ps=1.5u w=1.12u l=0.13u
X2173 VGND.t146 sg13cmos5l_buf_16_7.A a_3694_2386# VGND.t147 sg13_lv_nmos ad=0.1406p pd=1.12u as=0.1406p ps=1.12u w=0.74u l=0.13u
X2174 VGND.t169 a_4436_9910# sg13cmos5l_buf_16_14.A VGND.t173 sg13_lv_nmos ad=0.1406p pd=1.12u as=0.1406p ps=1.12u w=0.74u l=0.13u
X2175 VGND.t41 sg13cmos5l_buf_16_5.X a_6094_3144# VGND.t40 sg13_lv_nmos ad=0.1406p pd=1.12u as=0.1406p ps=1.12u w=0.74u l=0.13u
X2176 VGND.t377 VPWR.t1667 VGND.t377 VGND.t156 sg13_lv_nmos ad=79.8f pd=0.8u as=0 ps=0 w=0.42u l=1u
X2177 VGND.t1302 VPWR.t281 VGND.t1302 VGND.t1303 sg13_lv_nmos ad=79.8f pd=0.8u as=0 ps=0 w=0.42u l=1u
X2178 VPWR.t202 a_10318_3898# sg13cmos5l_buf_16_2.X VPWR.t28 sg13_lv_pmos ad=0.2128p pd=1.5u as=0.2128p ps=1.5u w=1.12u l=0.13u
X2179 sg13cmos5l_buf_16_31.X a_6094_4656# VPWR.t757 VPWR.t28 sg13_lv_pmos ad=0.2128p pd=1.5u as=0.2128p ps=1.5u w=1.12u l=0.13u
X2180 VGND.t999 VPWR.t1678 VGND.t999 VGND.t156 sg13_lv_nmos ad=0.1428p pd=1.52u as=0 ps=0 w=0.42u l=1u
X2181 VPWR.t281 VGND.t1300 VPWR.t21 VPWR.t20 sg13_lv_pmos ad=0.19p pd=1.38u as=0 ps=0 w=1u l=1u
X2182 a_4462_5410# sg13cmos5l_and2_2_0.X VPWR.t527 VPWR.t70 sg13_lv_pmos ad=0.2128p pd=1.5u as=0.2128p ps=1.5u w=1.12u l=0.13u
X2183 VGND.t72 a_10292_4620# sg13cmos5l_buf_16_3.X VGND.t79 sg13_lv_nmos ad=0.1406p pd=1.12u as=0.1406p ps=1.12u w=0.74u l=0.13u
X2184 VPWR.t15 VGND.t958 VPWR.t14 VPWR.t13 sg13_lv_pmos ad=0.19p pd=1.38u as=0 ps=0 w=1u l=1u
X2185 VGND.t342 a_3668_12180# sg13cmos5l_buf_16_15.X VGND.t341 sg13_lv_nmos ad=0.1406p pd=1.12u as=0.1406p ps=1.12u w=0.74u l=0.13u
X2186 a_3668_12180# sg13cmos5l_buf_16_15.A VPWR.t659 VPWR.t13 sg13_lv_pmos ad=0.2128p pd=1.5u as=0.2128p ps=1.5u w=1.12u l=0.13u
X2187 VPWR.t955 VGND.t1207 VPWR.t954 VPWR.t28 sg13_lv_pmos ad=0.34p pd=2.68u as=0 ps=0 w=1u l=1u
X2188 VPWR.t347 VGND.t1060 VPWR.t345 VPWR.t55 sg13_lv_pmos ad=0.19p pd=1.38u as=0 ps=0 w=1u l=1u
X2189 VGND.t1248 VPWR.t1618 VGND.t1248 VGND.t40 sg13_lv_nmos ad=0.1428p pd=1.52u as=0 ps=0 w=0.42u l=1u
X2190 VGND.t1178 VPWR.t5 VGND.t1178 VGND.t1179 sg13_lv_nmos ad=0.1428p pd=1.52u as=0 ps=0 w=0.42u l=1u
X2191 VPWR.t415 VGND.t358 VPWR.t414 VPWR.t5 sg13_lv_pmos ad=0.34p pd=2.68u as=0 ps=0 w=1u l=1u
X2192 VGND.t150 sg13cmos5l_buf_16_30.A a_5710_1632# VGND.t854 sg13_lv_nmos ad=0.1406p pd=1.12u as=0.1406p ps=1.12u w=0.74u l=0.13u
X2193 sg13cmos5l_buf_16_30.A a_6164_2350# VPWR.t800 VPWR.t20 sg13_lv_pmos ad=0.2128p pd=1.5u as=0.2128p ps=1.5u w=1.12u l=0.13u
X2194 VGND.t671 a_5684_6132# sg13cmos5l_buf_16_28.X VGND.t836 sg13_lv_nmos ad=0.1406p pd=1.12u as=0.1406p ps=1.12u w=0.74u l=0.13u
X2195 a_4174_13728# sg13cmos5l_and2_2_1.X VPWR.t1477 VPWR.t8 sg13_lv_pmos ad=0.2128p pd=1.5u as=0.2128p ps=1.5u w=1.12u l=0.13u
X2196 a_6836_9156# sg13cmos5l_and2_2_6.X VPWR.t189 VPWR.t3 sg13_lv_pmos ad=0.2128p pd=1.5u as=0.2128p ps=1.5u w=1.12u l=0.13u
X2197 sg13cmos5l_and2_2_2.B a_5992_14516# VPWR.t1486 VPWR.t292 sg13_lv_pmos ad=0.42p pd=2.99u as=0.2114p ps=1.54u w=1.12u l=0.13u
X2198 VPWR.t525 sg13cmos5l_and2_2_0.X a_4462_5410# VPWR.t70 sg13_lv_pmos ad=0.2128p pd=1.5u as=0.2128p ps=1.5u w=1.12u l=0.13u
X2199 sg13cmos5l_buf_16_14.A a_4436_9910# VPWR.t470 VPWR.t55 sg13_lv_pmos ad=0.2128p pd=1.5u as=0.2128p ps=1.5u w=1.12u l=0.13u
X2200 VPWR.t631 a_8948_13692# sg13cmos5l_buf_16_37.A VPWR.t8 sg13_lv_pmos ad=0.2128p pd=1.5u as=0.2128p ps=1.5u w=1.12u l=0.13u
X2201 VGND.t1 sg13cmos5l_buf_16_14.A a_3668_9156# VGND.t660 sg13_lv_nmos ad=0.1406p pd=1.12u as=0.1406p ps=1.12u w=0.74u l=0.13u
X2202 VGND.t377 a_6094_10704# sg13cmos5l_buf_16_24.A VGND.t156 sg13_lv_nmos ad=0.1406p pd=1.12u as=0.1406p ps=1.12u w=0.74u l=0.13u
X2203 VPWR.t446 VGND.t244 VPWR.t444 VPWR.t28 sg13_lv_pmos ad=0.19p pd=1.38u as=0 ps=0 w=1u l=1u
X2204 VPWR.t798 a_6164_2350# sg13cmos5l_buf_16_30.A VPWR.t20 sg13_lv_pmos ad=0.2128p pd=1.5u as=0.2128p ps=1.5u w=1.12u l=0.13u
X2205 VPWR.t12 VGND.t958 VPWR.t11 VPWR.t8 sg13_lv_pmos ad=0.34p pd=2.68u as=0 ps=0 w=1u l=1u
X2206 VPWR.t243 a_6836_9156# sg13cmos5l_buf_16_25.A VPWR.t3 sg13_lv_pmos ad=0.2128p pd=1.5u as=0.2128p ps=1.5u w=1.12u l=0.13u
X2207 sg13cmos5l_buf_16_30.A a_6164_2350# VGND.t504 VGND.t507 sg13_lv_nmos ad=0.1406p pd=1.12u as=0.1406p ps=1.12u w=0.74u l=0.13u
X2208 VGND.t332 a_3668_12180# sg13cmos5l_buf_16_15.X VGND.t337 sg13_lv_nmos ad=0.1406p pd=1.12u as=0.1406p ps=1.12u w=0.74u l=0.13u
X2209 VGND.t150 VPWR.t284 VGND.t150 VGND.t1288 sg13_lv_nmos ad=0.1428p pd=1.52u as=0 ps=0 w=0.42u l=1u
X2210 VPWR.t330 VGND.t999 VPWR.t329 VPWR.t13 sg13_lv_pmos ad=0.34p pd=2.68u as=0 ps=0 w=1u l=1u
X2211 a_9617_8484# sg13cmos5l_buf_16_6.X a_9585_8752# VPWR.t3 sg13_lv_pmos ad=0.34p pd=2.68u as=0.1225p ps=1.245u w=1u l=0.13u
X2212 sg13cmos5l_buf_16_39.A a_8494_3144# VPWR.t21 VPWR.t20 sg13_lv_pmos ad=0.2128p pd=1.5u as=0.2128p ps=1.5u w=1.12u l=0.13u
X2213 VGND.t693 sg13cmos5l_buf_16_23.X a_8948_13692# VGND.t694 sg13_lv_nmos ad=0.1406p pd=1.12u as=0.1406p ps=1.12u w=0.74u l=0.13u
X2214 sg13cmos5l_buf_16_0.A a_6094_3898# VGND.t41 VGND.t40 sg13_lv_nmos ad=0.1406p pd=1.12u as=0.1406p ps=1.12u w=0.74u l=0.13u
X2215 VPWR.t304 VGND.t573 VPWR.t133 VPWR.t13 sg13_lv_pmos ad=0.34p pd=2.68u as=0 ps=0 w=1u l=1u
X2216 sg13cmos5l_buf_16_14.A a_4436_9910# VPWR.t466 VPWR.t55 sg13_lv_pmos ad=0.2128p pd=1.5u as=0.2128p ps=1.5u w=1.12u l=0.13u
X2217 sg13cmos5l_buf_16_30.A a_6164_2350# VPWR.t794 VPWR.t20 sg13_lv_pmos ad=0.2128p pd=1.5u as=0.2128p ps=1.5u w=1.12u l=0.13u
X2218 sg13cmos5l_buf_16_37.A a_8948_13692# VGND.t693 VGND.t705 sg13_lv_nmos ad=0.1406p pd=1.12u as=0.1406p ps=1.12u w=0.74u l=0.13u
X2219 VGND.t504 a_6164_2350# sg13cmos5l_buf_16_30.A VGND.t503 sg13_lv_nmos ad=0.1406p pd=1.12u as=0.1406p ps=1.12u w=0.74u l=0.13u
X2220 VPWR.t1333 a_3694_7680# sg13cmos5l_buf_16_34.X VPWR.t5 sg13_lv_pmos ad=0.2128p pd=1.5u as=0.2128p ps=1.5u w=1.12u l=0.13u
X2221 VGND.t358 a_5684_6132# sg13cmos5l_buf_16_28.X VGND.t832 sg13_lv_nmos ad=0.1406p pd=1.12u as=0.1406p ps=1.12u w=0.74u l=0.13u
X2222 VPWR.t18 VGND.t1425 VPWR.t18 VPWR.t0 sg13_lv_pmos ad=0.19p pd=1.38u as=0 ps=0 w=1u l=1u
X2223 VGND.t282 a_7220_5374# sg13cmos5l_buf_16_28.A VGND.t289 sg13_lv_nmos ad=0.1406p pd=1.12u as=0.1406p ps=1.12u w=0.74u l=0.13u
X2224 VGND.t358 a_9524_6886# sg13cmos5l_buf_16_4.X VGND.t824 sg13_lv_nmos ad=0.1406p pd=1.12u as=0.1406p ps=1.12u w=0.74u l=0.13u
X2225 sg13cmos5l_buf_16_38.A a_8110_6168# VPWR.t70 VPWR.t70 sg13_lv_pmos ad=0.2128p pd=1.5u as=0.2128p ps=1.5u w=1.12u l=0.13u
X2226 VPWR.t292 VGND.t636 VPWR.t292 VPWR.t292 sg13_lv_pmos ad=0.34p pd=2.68u as=0 ps=0 w=1u l=1u
X2227 VGND.t169 a_3668_9156# sg13cmos5l_buf_16_13.A VGND.t197 sg13_lv_nmos ad=0.1406p pd=1.12u as=0.1406p ps=1.12u w=0.74u l=0.13u
X2228 VPWR.t190 VGND.t1060 VPWR.t189 VPWR.t3 sg13_lv_pmos ad=0.19p pd=1.38u as=0 ps=0 w=1u l=1u
X2229 VPWR.t1515 a_3694_14482# sg13cmos5l_buf_16_33.A VPWR.t292 sg13_lv_pmos ad=0.2128p pd=1.5u as=0.2128p ps=1.5u w=1.12u l=0.13u
X2230 a_10292_4620# sg13cmos5l_buf_16_2.X VPWR.t202 VPWR.t28 sg13_lv_pmos ad=0.2128p pd=1.5u as=0.2128p ps=1.5u w=1.12u l=0.13u
X2231 VPWR.t767 a_3668_4620# sg13cmos5l_buf_16_8.A VPWR.t28 sg13_lv_pmos ad=0.2128p pd=1.5u as=0.2128p ps=1.5u w=1.12u l=0.13u
X2232 VPWR.t404 VGND.t1153 VPWR.t577 VPWR.t5 sg13_lv_pmos ad=0.34p pd=2.68u as=0 ps=0 w=1u l=1u
X2233 VPWR.t46 VGND.t1248 VPWR.t45 VPWR.t28 sg13_lv_pmos ad=0.34p pd=2.68u as=0 ps=0 w=1u l=1u
X2234 VPWR.t1538 sg13cmos5l_buf_16_18.A a_4052_12934# VPWR.t8 sg13_lv_pmos ad=0.2128p pd=1.5u as=0.2128p ps=1.5u w=1.12u l=0.13u
X2235 sg13cmos5l_xor2_1_4.X a_13745_8484# a_13916_8728# VPWR.t3 sg13_lv_pmos ad=0.3808p pd=2.92u as=0.2128p ps=1.5u w=1.12u l=0.13u
X2236 a_3668_3108# sg13cmos5l_buf_16_10.A VPWR.t566 VPWR.t20 sg13_lv_pmos ad=0.2128p pd=1.5u as=0.2128p ps=1.5u w=1.12u l=0.13u
X2237 VGND.t693 a_8948_13692# sg13cmos5l_buf_16_37.A VGND.t712 sg13_lv_nmos ad=0.1406p pd=1.12u as=0.1406p ps=1.12u w=0.74u l=0.13u
X2238 VGND.t1060 VPWR.t1659 VGND.t1060 VGND.t1065 sg13_lv_nmos ad=79.8f pd=0.8u as=0 ps=0 w=0.42u l=1u
X2239 VGND.t1219 VPWR.t71 VGND.t126 VGND.t1218 sg13_lv_nmos ad=0.1428p pd=1.52u as=0 ps=0 w=0.42u l=1u
X2240 sg13cmos5l_buf_16_28.A a_7220_5374# VGND.t282 VGND.t286 sg13_lv_nmos ad=0.1406p pd=1.12u as=0.1406p ps=1.12u w=0.74u l=0.13u
X2241 VPWR.t70 a_8110_6168# sg13cmos5l_buf_16_38.A VPWR.t70 sg13_lv_pmos ad=0.2128p pd=1.5u as=0.2128p ps=1.5u w=1.12u l=0.13u
X2242 sg13cmos5l_buf_16_4.X a_9524_6886# VGND.t358 VGND.t821 sg13_lv_nmos ad=0.1406p pd=1.12u as=0.1406p ps=1.12u w=0.74u l=0.13u
X2243 VPWR.t905 VGND.t1079 VPWR.t905 VPWR.t55 sg13_lv_pmos ad=0.34p pd=2.68u as=0 ps=0 w=1u l=1u
X2244 sg13cmos5l_buf_16_33.A a_3694_14482# VGND.t912 VGND.t1520 sg13_lv_nmos ad=0.1406p pd=1.12u as=0.1406p ps=1.12u w=0.74u l=0.13u
X2245 sg13cmos5l_buf_16_14.A a_4436_9910# VPWR.t462 VPWR.t55 sg13_lv_pmos ad=0.2128p pd=1.5u as=0.2128p ps=1.5u w=1.12u l=0.13u
X2246 sg13cmos5l_buf_16_28.X a_5684_6132# VPWR.t1365 VPWR.t70 sg13_lv_pmos ad=0.2128p pd=1.5u as=0.2128p ps=1.5u w=1.12u l=0.13u
X2247 sg13cmos5l_buf_16_37.A a_8948_13692# VGND.t693 VGND.t701 sg13_lv_nmos ad=0.1406p pd=1.12u as=0.1406p ps=1.12u w=0.74u l=0.13u
X2248 sg13cmos5l_buf_16_0.A a_6094_3898# VGND.t41 VGND.t40 sg13_lv_nmos ad=0.1406p pd=1.12u as=0.1406p ps=1.12u w=0.74u l=0.13u
X2249 VPWR.t202 a_10292_4620# sg13cmos5l_buf_16_3.X VPWR.t28 sg13_lv_pmos ad=0.2128p pd=1.5u as=0.2128p ps=1.5u w=1.12u l=0.13u
X2250 VPWR.t281 VGND.t1302 VPWR.t281 VPWR.t20 sg13_lv_pmos ad=0.19p pd=1.38u as=0 ps=0 w=1u l=1u
X2251 sg13cmos5l_buf_16_8.A a_3668_4620# VPWR.t763 VPWR.t28 sg13_lv_pmos ad=0.2128p pd=1.5u as=0.2128p ps=1.5u w=1.12u l=0.13u
X2252 VGND.t639 VPWR.t911 VGND.t639 VGND.t931 sg13_lv_nmos ad=79.8f pd=0.8u as=0 ps=0 w=0.42u l=1u
X2253 sg13cmos5l_buf_16_35.A a_6766_8434# VGND.t413 VGND.t1551 sg13_lv_nmos ad=0.1406p pd=1.12u as=0.1406p ps=1.12u w=0.74u l=0.13u
X2254 VGND.t112 a_8494_3144# sg13cmos5l_buf_16_39.A VGND.t40 sg13_lv_nmos ad=0.2516p pd=2.16u as=0.1406p ps=1.12u w=0.74u l=0.13u
X2255 VGND.t358 a_9524_6886# sg13cmos5l_buf_16_4.X VGND.t818 sg13_lv_nmos ad=0.1406p pd=1.12u as=0.1406p ps=1.12u w=0.74u l=0.13u
X2256 VPWR.t1511 a_3694_14482# sg13cmos5l_buf_16_33.A VPWR.t292 sg13_lv_pmos ad=0.2128p pd=1.5u as=0.2128p ps=1.5u w=1.12u l=0.13u
X2257 a_3694_10704# sg13cmos5l_buf_16_34.X VGND.t384 VGND.t156 sg13_lv_nmos ad=0.1406p pd=1.12u as=0.2516p ps=2.16u w=0.74u l=0.13u
X2258 VGND.t27 sg13cmos5l_buf_16_11.A a_3668_4620# VGND.t565 sg13_lv_nmos ad=0.2516p pd=2.16u as=0.1406p ps=1.12u w=0.74u l=0.13u
X2259 VPWR.t1278 a_4052_12934# sg13cmos5l_buf_16_15.A VPWR.t8 sg13_lv_pmos ad=0.2128p pd=1.5u as=0.2128p ps=1.5u w=1.12u l=0.13u
X2260 sg13cmos5l_buf_16_15.A a_4052_12934# VGND.t342 VGND.t728 sg13_lv_nmos ad=0.1406p pd=1.12u as=0.1406p ps=1.12u w=0.74u l=0.13u
X2261 VGND.t413 sg13cmos5l_buf_16_25.A a_6766_8434# VGND.t578 sg13_lv_nmos ad=0.1406p pd=1.12u as=0.1406p ps=1.12u w=0.74u l=0.13u
X2262 sg13cmos5l_buf_16_39.A a_8494_3144# VGND.t112 VGND.t40 sg13_lv_nmos ad=0.1406p pd=1.12u as=0.1406p ps=1.12u w=0.74u l=0.13u
X2263 VPWR.t1 VGND.t1410 VPWR.t185 VPWR.t0 sg13_lv_pmos ad=0.19p pd=1.38u as=0 ps=0 w=1u l=1u
X2264 sg13cmos5l_buf_16_1.X a_10318_5410# VGND.t82 VGND.t83 sg13_lv_nmos ad=0.1406p pd=1.12u as=0.1406p ps=1.12u w=0.74u l=0.13u
X2265 VGND.t350 sg13cmos5l_buf_16_19.A a_5204_11422# VGND.t156 sg13_lv_nmos ad=0.2516p pd=2.16u as=0.1406p ps=1.12u w=0.74u l=0.13u
X2266 a_3668_4620# sg13cmos5l_buf_16_11.A VGND.t27 VGND.t562 sg13_lv_nmos ad=0.1406p pd=1.12u as=0.1406p ps=1.12u w=0.74u l=0.13u
X2267 sg13cmos5l_buf_16_35.A a_6766_8434# VPWR.t1564 VPWR.t3 sg13_lv_pmos ad=0.2128p pd=1.5u as=0.2128p ps=1.5u w=1.12u l=0.13u
X2268 VPWR.t52 VGND.t1248 VPWR.t50 VPWR.t20 sg13_lv_pmos ad=0.19p pd=1.38u as=0 ps=0 w=1u l=1u
X2269 sg13cmos5l_xor2_1_0.B a_6094_3144# VGND.t41 VGND.t40 sg13_lv_nmos ad=0.1406p pd=1.12u as=0.1406p ps=1.12u w=0.74u l=0.13u
X2270 VGND.t1173 VPWR.t318 VGND.t806 VGND.t1172 sg13_lv_nmos ad=0.1428p pd=1.52u as=0 ps=0 w=0.42u l=1u
X2271 VPWR.t892 a_3694_3898# sg13cmos5l_buf_16_10.A VPWR.t28 sg13_lv_pmos ad=0.2128p pd=1.5u as=0.2128p ps=1.5u w=1.12u l=0.13u
X2272 sg13cmos5l_buf_16_27.X a_6548_13692# VGND.t915 VGND.t1495 sg13_lv_nmos ad=0.1406p pd=1.12u as=0.1406p ps=1.12u w=0.74u l=0.13u
X2273 VGND.t72 a_10318_5410# sg13cmos5l_buf_16_1.X VGND.t79 sg13_lv_nmos ad=0.1406p pd=1.12u as=0.1406p ps=1.12u w=0.74u l=0.13u
X2274 VPWR.t1274 a_4052_12934# sg13cmos5l_buf_16_15.A VPWR.t8 sg13_lv_pmos ad=0.2128p pd=1.5u as=0.2128p ps=1.5u w=1.12u l=0.13u
X2275 a_3694_3898# sg13cmos5l_buf_16_8.A VGND.t198 VGND.t40 sg13_lv_nmos ad=0.1406p pd=1.12u as=0.1406p ps=1.12u w=0.74u l=0.13u
X2276 VPWR.t1562 a_6766_8434# sg13cmos5l_buf_16_35.A VPWR.t3 sg13_lv_pmos ad=0.2128p pd=1.5u as=0.2128p ps=1.5u w=1.12u l=0.13u
X2277 VPWR.t131 VGND.t1020 VPWR.t131 VPWR.t13 sg13_lv_pmos ad=0.34p pd=2.68u as=0 ps=0 w=1u l=1u
X2278 VGND.t350 a_3694_10704# sg13cmos5l_and2_2_6.A VGND.t156 sg13_lv_nmos ad=0.1406p pd=1.12u as=0.1406p ps=1.12u w=0.74u l=0.13u
X2279 VPWR.t983 VGND.t907 VPWR.t982 VPWR.t8 sg13_lv_pmos ad=0.34p pd=2.68u as=0 ps=0 w=1u l=1u
X2280 sg13cmos5l_buf_16_15.A a_4052_12934# VGND.t332 VGND.t724 sg13_lv_nmos ad=0.1406p pd=1.12u as=0.1406p ps=1.12u w=0.74u l=0.13u
X2281 VPWR.t484 a_3668_9156# sg13cmos5l_buf_16_13.A VPWR.t3 sg13_lv_pmos ad=0.2128p pd=1.5u as=0.2128p ps=1.5u w=1.12u l=0.13u
X2282 sg13cmos5l_buf_16_1.X a_10318_5410# VPWR.t400 VPWR.t70 sg13_lv_pmos ad=0.2128p pd=1.5u as=0.2128p ps=1.5u w=1.12u l=0.13u
X2283 VGND.t377 VPWR.t1672 VGND.t377 VGND.t156 sg13_lv_nmos ad=79.8f pd=0.8u as=0 ps=0 w=0.42u l=1u
X2284 sg13cmos5l_buf_16_24.A a_6094_10704# VPWR.t681 VPWR.t55 sg13_lv_pmos ad=0.2128p pd=1.5u as=0.2128p ps=1.5u w=1.12u l=0.13u
X2285 a_3668_3108# sg13cmos5l_buf_16_10.A VPWR.t504 VPWR.t20 sg13_lv_pmos ad=0.2128p pd=1.5u as=0.2128p ps=1.5u w=1.12u l=0.13u
X2286 VGND.t350 a_5204_11422# sg13cmos5l_buf_16_20.A VGND.t156 sg13_lv_nmos ad=0.1406p pd=1.12u as=0.1406p ps=1.12u w=0.74u l=0.13u
X2287 out_xor[2] a_14824_5444# VGND.t851 VGND.t850 sg13_lv_nmos ad=0.2886p pd=2.26u as=0.14875p ps=1.16u w=0.74u l=0.13u
X2288 sg13cmos5l_buf_16_28.A a_7220_5374# VGND.t282 VGND.t281 sg13_lv_nmos ad=0.1406p pd=1.12u as=0.2516p ps=2.16u w=0.74u l=0.13u
X2289 VPWR.t131 sg13cmos5l_buf_1_17.A a_12232_12216# VPWR.t13 sg13_lv_pmos ad=0.2114p pd=1.54u as=0.2856p ps=2.36u w=0.84u l=0.13u
X2290 sg13cmos5l_buf_16_6.X a_5518_6922# VPWR.t1216 VPWR.t5 sg13_lv_pmos ad=0.2128p pd=1.5u as=0.2128p ps=1.5u w=1.12u l=0.13u
X2291 VGND.t11 a_9262_7680# sg13cmos5l_buf_16_2.A VGND.t13 sg13_lv_nmos ad=0.1406p pd=1.12u as=0.1406p ps=1.12u w=0.74u l=0.13u
X2292 VGND.t519 sg13cmos5l_and2_2_2.B a_6859_12564# VGND.t1522 sg13_lv_nmos ad=0.1331p pd=1.12u as=0.1216p ps=1.02u w=0.64u l=0.13u
X2293 VGND.t377 VPWR.t562 VGND.t377 VGND.t156 sg13_lv_nmos ad=79.8f pd=0.8u as=0 ps=0 w=0.42u l=1u
X2294 VPWR.t133 VGND.t573 VPWR.t133 VPWR.t13 sg13_lv_pmos ad=0.19p pd=1.38u as=0 ps=0 w=1u l=1u
X2295 a_6766_8434# sg13cmos5l_buf_16_25.A VPWR.t876 VPWR.t3 sg13_lv_pmos ad=0.2128p pd=1.5u as=0.2128p ps=1.5u w=1.12u l=0.13u
X2296 VPWR.t202 a_10292_4620# sg13cmos5l_buf_16_3.X VPWR.t28 sg13_lv_pmos ad=0.2128p pd=1.5u as=0.2128p ps=1.5u w=1.12u l=0.13u
X2297 sg13cmos5l_buf_16_8.A a_3668_4620# VGND.t23 VGND.t471 sg13_lv_nmos ad=0.1406p pd=1.12u as=0.1406p ps=1.12u w=0.74u l=0.13u
X2298 sg13cmos5l_buf_16_13.A a_3668_9156# VPWR.t480 VPWR.t3 sg13_lv_pmos ad=0.2128p pd=1.5u as=0.2128p ps=1.5u w=1.12u l=0.13u
X2299 sg13cmos5l_buf_16_5.X a_5108_838# VPWR.t19 VPWR.t0 sg13_lv_pmos ad=0.2128p pd=1.5u as=0.2128p ps=1.5u w=1.12u l=0.13u
X2300 VPWR.t400 a_10318_5410# sg13cmos5l_buf_16_1.X VPWR.t70 sg13_lv_pmos ad=0.2128p pd=1.5u as=0.2128p ps=1.5u w=1.12u l=0.13u
X2301 sg13cmos5l_buf_16_27.X a_6548_13692# VGND.t915 VGND.t1491 sg13_lv_nmos ad=0.1406p pd=1.12u as=0.1406p ps=1.12u w=0.74u l=0.13u
X2302 VGND.t1067 VPWR.t1658 VGND.t165 VGND.t1068 sg13_lv_nmos ad=79.8f pd=0.8u as=0 ps=0 w=0.42u l=1u
X2303 VPWR.t19 sg13cmos5l_buf_16_30.A a_5710_1632# VPWR.t0 sg13_lv_pmos ad=0.2128p pd=1.5u as=0.2128p ps=1.5u w=1.12u l=0.13u
X2304 sg13cmos5l_xor2_1_0.B a_6094_3144# VGND.t41 VGND.t40 sg13_lv_nmos ad=0.1406p pd=1.12u as=0.1406p ps=1.12u w=0.74u l=0.13u
X2305 VPWR.t969 VGND.t222 VPWR.t953 VPWR.t70 sg13_lv_pmos ad=0.19p pd=1.38u as=0 ps=0 w=1u l=1u
X2306 a_4436_9910# sg13cmos5l_buf_16_20.A VGND.t1 VGND.t218 sg13_lv_nmos ad=0.1406p pd=1.12u as=0.1406p ps=1.12u w=0.74u l=0.13u
X2307 VPWR.t38 VGND.t1432 VPWR.t37 VPWR.t0 sg13_lv_pmos ad=0.34p pd=2.68u as=0 ps=0 w=1u l=1u
X2308 VPWR.t1214 a_5518_6922# sg13cmos5l_buf_16_6.X VPWR.t5 sg13_lv_pmos ad=0.2128p pd=1.5u as=0.2128p ps=1.5u w=1.12u l=0.13u
X2309 sg13cmos5l_buf_16_2.A a_9262_7680# VGND.t5 VGND.t9 sg13_lv_nmos ad=0.1406p pd=1.12u as=0.1406p ps=1.12u w=0.74u l=0.13u
X2310 VPWR.t292 VGND.t636 VPWR.t292 VPWR.t292 sg13_lv_pmos ad=0.19p pd=1.38u as=0 ps=0 w=1u l=1u
X2311 VGND.t384 VPWR.t1674 VGND.t384 VGND.t156 sg13_lv_nmos ad=0.1428p pd=1.52u as=0 ps=0 w=0.42u l=1u
X2312 sg13cmos5l_buf_16_24.A a_6094_10704# VPWR.t677 VPWR.t55 sg13_lv_pmos ad=0.2128p pd=1.5u as=0.2128p ps=1.5u w=1.12u l=0.13u
X2313 VPWR.t478 a_3668_9156# sg13cmos5l_buf_16_13.A VPWR.t3 sg13_lv_pmos ad=0.2128p pd=1.5u as=0.2128p ps=1.5u w=1.12u l=0.13u
X2314 VPWR.t4 sg13cmos5l_xor2_1_4.X a_13768_9192# VPWR.t3 sg13_lv_pmos ad=0.2114p pd=1.54u as=0.2856p ps=2.36u w=0.84u l=0.13u
X2315 VGND.t358 a_5518_6922# sg13cmos5l_buf_16_6.X VGND.t679 sg13_lv_nmos ad=0.1406p pd=1.12u as=0.1406p ps=1.12u w=0.74u l=0.13u
X2316 VGND.t384 a_5204_11422# sg13cmos5l_buf_16_20.A VGND.t156 sg13_lv_nmos ad=0.1406p pd=1.12u as=0.1406p ps=1.12u w=0.74u l=0.13u
X2317 sg13cmos5l_buf_16_1.X a_10318_5410# VPWR.t400 VPWR.t70 sg13_lv_pmos ad=0.2128p pd=1.5u as=0.2128p ps=1.5u w=1.12u l=0.13u
X2318 a_5710_1632# sg13cmos5l_buf_16_30.A VPWR.t19 VPWR.t0 sg13_lv_pmos ad=0.2128p pd=1.5u as=0.3808p ps=2.92u w=1.12u l=0.13u
X2319 sg13cmos5l_buf_16_6.X a_5518_6922# VPWR.t1210 VPWR.t5 sg13_lv_pmos ad=0.2128p pd=1.5u as=0.2128p ps=1.5u w=1.12u l=0.13u
X2320 VPWR.t1116 VGND.t11 VPWR.t1115 VPWR.t5 sg13_lv_pmos ad=0.34p pd=2.68u as=0 ps=0 w=1u l=1u
X2321 VPWR.t600 a_7220_5374# sg13cmos5l_buf_16_28.A VPWR.t70 sg13_lv_pmos ad=0.2128p pd=1.5u as=0.2128p ps=1.5u w=1.12u l=0.13u
X2322 VGND.t282 VPWR.t28 VGND.t282 VGND.t1233 sg13_lv_nmos ad=79.8f pd=0.8u as=0 ps=0 w=0.42u l=1u
X2323 sg13cmos5l_buf_16_11.A a_4462_5410# VGND.t27 VGND.t30 sg13_lv_nmos ad=0.1406p pd=1.12u as=0.1406p ps=1.12u w=0.74u l=0.13u
X2324 sg13cmos5l_buf_16_6.X a_5518_6922# VGND.t358 VGND.t676 sg13_lv_nmos ad=0.1406p pd=1.12u as=0.1406p ps=1.12u w=0.74u l=0.13u
X2325 VPWR.t382 VGND.t126 VPWR.t28 VPWR.t28 sg13_lv_pmos ad=0.34p pd=2.68u as=0 ps=0 w=1u l=1u
X2326 VGND.t350 a_6094_10704# sg13cmos5l_buf_16_24.A VGND.t156 sg13_lv_nmos ad=0.1406p pd=1.12u as=0.1406p ps=1.12u w=0.74u l=0.13u
X2327 VPWR.t70 VGND.t72 VPWR.t70 VPWR.t70 sg13_lv_pmos ad=0.34p pd=2.68u as=0 ps=0 w=1u l=1u
X2328 VPWR.t202 VGND.t72 VPWR.t28 VPWR.t28 sg13_lv_pmos ad=0.34p pd=2.68u as=0 ps=0 w=1u l=1u
X2329 sg13cmos5l_buf_16_18.A a_4174_13728# VGND.t912 VGND.t1465 sg13_lv_nmos ad=0.1406p pd=1.12u as=0.1406p ps=1.12u w=0.74u l=0.13u
X2330 VGND.t27 a_4462_5410# sg13cmos5l_buf_16_11.A VGND.t26 sg13_lv_nmos ad=0.1406p pd=1.12u as=0.1406p ps=1.12u w=0.74u l=0.13u
X2331 VGND.t1060 VPWR.t1665 VGND.t1060 VGND.t1062 sg13_lv_nmos ad=0.1428p pd=1.52u as=0 ps=0 w=0.42u l=1u
X2332 sg13cmos5l_buf_16_7.A a_3668_3108# VGND.t198 VGND.t40 sg13_lv_nmos ad=0.1406p pd=1.12u as=0.1406p ps=1.12u w=0.74u l=0.13u
X2333 VPWR.t292 VGND.t693 VPWR.t292 VPWR.t292 sg13_lv_pmos ad=0.34p pd=2.68u as=0 ps=0 w=1u l=1u
X2334 VPWR.t685 a_6094_10704# sg13cmos5l_buf_16_24.A VPWR.t55 sg13_lv_pmos ad=0.2128p pd=1.5u as=0.2128p ps=1.5u w=1.12u l=0.13u
X2335 VPWR.t39 VGND.t244 VPWR.t447 VPWR.t28 sg13_lv_pmos ad=0.34p pd=2.68u as=0 ps=0 w=1u l=1u
X2336 VGND.t11 VPWR.t1651 VGND.t11 VGND.t1114 sg13_lv_nmos ad=0.1428p pd=1.52u as=0 ps=0 w=0.42u l=1u
X2337 a_10318_3898# sg13cmos5l_buf_16_2.A VGND.t112 VGND.t40 sg13_lv_nmos ad=0.1406p pd=1.12u as=0.1406p ps=1.12u w=0.74u l=0.13u
X2338 VPWR.t24 VGND.t1387 VPWR.t1025 VPWR.t0 sg13_lv_pmos ad=0.34p pd=2.68u as=0 ps=0 w=1u l=1u
X2339 VGND.t1060 VPWR.t1661 VGND.t1060 VGND.t1061 sg13_lv_nmos ad=79.8f pd=0.8u as=0 ps=0 w=0.42u l=1u
X2340 VGND.t1408 VPWR.t1 VGND.t1410 VGND.t1409 sg13_lv_nmos ad=79.8f pd=0.8u as=0 ps=0 w=0.42u l=1u
X2341 VGND.t126 sg13cmos5l_buf_16_2.X a_10292_4620# VGND.t125 sg13_lv_nmos ad=0.1406p pd=1.12u as=0.1406p ps=1.12u w=0.74u l=0.13u
X2342 a_11898_13691# sg13cmos5l_buf_16_27.X VGND.t330 VGND.t1528 sg13_lv_nmos ad=0.17462p pd=1.185u as=0.15245p ps=1.17u w=0.55u l=0.13u
X2343 VPWR.t275 sg13cmos5l_buf_16_7.A a_3694_2386# VPWR.t20 sg13_lv_pmos ad=0.2128p pd=1.5u as=0.2128p ps=1.5u w=1.12u l=0.13u
X2344 VGND.t116 VPWR.t5 VGND.t116 VGND.t1149 sg13_lv_nmos ad=0.1428p pd=1.52u as=0 ps=0 w=0.42u l=1u
X2345 a_7796_12934# sg13cmos5l_buf_16_37.A VPWR.t631 VPWR.t8 sg13_lv_pmos ad=0.2128p pd=1.5u as=0.2128p ps=1.5u w=1.12u l=0.13u
X2346 sg13cmos5l_buf_16_11.A a_4462_5410# VGND.t23 VGND.t22 sg13_lv_nmos ad=0.1406p pd=1.12u as=0.1406p ps=1.12u w=0.74u l=0.13u
X2347 VGND.t491 a_5710_1632# sg13cmos5l_buf_16_5.A VGND.t879 sg13_lv_nmos ad=0.1406p pd=1.12u as=0.1406p ps=1.12u w=0.74u l=0.13u
X2348 VPWR.t1 VGND.t1400 VPWR.t1 VPWR.t0 sg13_lv_pmos ad=0.19p pd=1.38u as=0 ps=0 w=1u l=1u
X2349 VPWR.t631 sg13cmos5l_buf_16_23.X a_8948_13692# VPWR.t8 sg13_lv_pmos ad=0.2128p pd=1.5u as=0.2128p ps=1.5u w=1.12u l=0.13u
X2350 VGND.t282 a_6094_4656# sg13cmos5l_buf_16_31.X VGND.t444 sg13_lv_nmos ad=0.1406p pd=1.12u as=0.1406p ps=1.12u w=0.74u l=0.13u
X2351 VGND.t315 a_7796_12934# sg13cmos5l_buf_16_37.X VGND.t616 sg13_lv_nmos ad=0.1406p pd=1.12u as=0.1406p ps=1.12u w=0.74u l=0.13u
X2352 VGND.t633 sg13cmos5l_xor2_1_4.X a_13768_9192# VGND.t1540 sg13_lv_nmos ad=0.14875p pd=1.16u as=0.187p ps=1.78u w=0.55u l=0.13u
X2353 sg13cmos5l_buf_16_37.A a_8948_13692# VPWR.t631 VPWR.t8 sg13_lv_pmos ad=0.2128p pd=1.5u as=0.2128p ps=1.5u w=1.12u l=0.13u
X2354 VGND.t1302 VPWR.t185 VGND.t1302 VGND.t1339 sg13_lv_nmos ad=0.1428p pd=1.52u as=0 ps=0 w=0.42u l=1u
X2355 VPWR.t159 a_4462_5410# sg13cmos5l_buf_16_11.A VPWR.t70 sg13_lv_pmos ad=0.2128p pd=1.5u as=0.2128p ps=1.5u w=1.12u l=0.13u
X2356 sg13cmos5l_buf_16_18.A a_4174_13728# VGND.t942 VGND.t1461 sg13_lv_nmos ad=0.1406p pd=1.12u as=0.1406p ps=1.12u w=0.74u l=0.13u
X2357 a_6161_12574# sg13cmos5l_buf_16_24.X a_6129_12216# VPWR.t13 sg13_lv_pmos ad=0.34p pd=2.68u as=0.1225p ps=1.245u w=1u l=0.13u
X2358 VGND.t1248 VPWR.t1619 VGND.t1248 VGND.t40 sg13_lv_nmos ad=0.1428p pd=1.52u as=0 ps=0 w=0.42u l=1u
X2359 VPWR.t297 sg13cmos5l_buf_1_22.X a_14824_13004# VPWR.t8 sg13_lv_pmos ad=0.2114p pd=1.54u as=0.2856p ps=2.36u w=0.84u l=0.13u
X2360 VGND.t150 a_3694_2386# sg13cmos5l_buf_16_7.X VGND.t475 sg13_lv_nmos ad=0.1406p pd=1.12u as=0.1406p ps=1.12u w=0.74u l=0.13u
X2361 sg13cmos5l_buf_16_0.A a_6094_3898# VPWR.t531 VPWR.t28 sg13_lv_pmos ad=0.2128p pd=1.5u as=0.2128p ps=1.5u w=1.12u l=0.13u
X2362 sg13cmos5l_buf_16_2.A a_9262_7680# VPWR.t136 VPWR.t5 sg13_lv_pmos ad=0.2128p pd=1.5u as=0.2128p ps=1.5u w=1.12u l=0.13u
X2363 VPWR.t190 VGND.t1060 VPWR.t190 VPWR.t3 sg13_lv_pmos ad=0.34p pd=2.68u as=0 ps=0 w=1u l=1u
X2364 VGND.t150 VPWR.t0 VGND.t150 VGND.t1284 sg13_lv_nmos ad=0.1428p pd=1.52u as=0 ps=0 w=0.42u l=1u
X2365 a_13667_12956# sg13cmos5l_and2_2_3.X a_13897_13012# VGND.t740 sg13_lv_nmos ad=0.2176p pd=1.96u as=0.1216p ps=1.02u w=0.64u l=0.13u
X2366 sg13cmos5l_buf_16_15.X a_3668_12180# VGND.t332 VGND.t338 sg13_lv_nmos ad=0.1406p pd=1.12u as=0.1406p ps=1.12u w=0.74u l=0.13u
X2367 a_5684_6132# sg13cmos5l_buf_16_28.A VGND.t358 VGND.t419 sg13_lv_nmos ad=0.1406p pd=1.12u as=0.1406p ps=1.12u w=0.74u l=0.13u
X2368 a_3694_14482# sg13cmos5l_buf_16_15.X VGND.t942 VGND.t1501 sg13_lv_nmos ad=0.1406p pd=1.12u as=0.1406p ps=1.12u w=0.74u l=0.13u
X2369 sg13cmos5l_buf_16_33.A a_3694_14482# VGND.t942 VGND.t1514 sg13_lv_nmos ad=0.1406p pd=1.12u as=0.1406p ps=1.12u w=0.74u l=0.13u
X2370 VPWR.t357 VGND.t1020 VPWR.t357 VPWR.t55 sg13_lv_pmos ad=0.19p pd=1.38u as=0 ps=0 w=1u l=1u
X2371 VGND.t130 VPWR.t382 VGND.t130 VGND.t40 sg13_lv_nmos ad=79.8f pd=0.8u as=0 ps=0 w=0.42u l=1u
X2372 a_10318_3898# sg13cmos5l_buf_16_2.A VGND.t112 VGND.t40 sg13_lv_nmos ad=0.1406p pd=1.12u as=0.2516p ps=2.16u w=0.74u l=0.13u
X2373 sg13cmos5l_buf_16_11.A a_4462_5410# VPWR.t155 VPWR.t70 sg13_lv_pmos ad=0.2128p pd=1.5u as=0.2128p ps=1.5u w=1.12u l=0.13u
X2374 VGND.t11 VPWR.t342 VGND.t11 VGND.t1145 sg13_lv_nmos ad=0.1428p pd=1.52u as=0 ps=0 w=0.42u l=1u
X2375 sg13cmos5l_buf_16_37.X a_7796_12934# VPWR.t930 VPWR.t8 sg13_lv_pmos ad=0.2128p pd=1.5u as=0.2128p ps=1.5u w=1.12u l=0.13u
X2376 VPWR.t169 a_6094_3144# sg13cmos5l_xor2_1_0.B VPWR.t20 sg13_lv_pmos ad=0.2128p pd=1.5u as=0.2128p ps=1.5u w=1.12u l=0.13u
X2377 VGND.t11 a_6766_8434# sg13cmos5l_buf_16_35.A VGND.t1564 sg13_lv_nmos ad=0.1406p pd=1.12u as=0.1406p ps=1.12u w=0.74u l=0.13u
X2378 VPWR.t631 a_8948_13692# sg13cmos5l_buf_16_37.A VPWR.t8 sg13_lv_pmos ad=0.2128p pd=1.5u as=0.2128p ps=1.5u w=1.12u l=0.13u
X2379 VPWR.t125 VGND.t315 VPWR.t125 VPWR.t13 sg13_lv_pmos ad=0.34p pd=2.68u as=0 ps=0 w=1u l=1u
X2380 a_3694_2386# sg13cmos5l_buf_16_7.A VGND.t150 VGND.t151 sg13_lv_nmos ad=0.1406p pd=1.12u as=0.1406p ps=1.12u w=0.74u l=0.13u
X2381 VGND.t1359 VPWR.t284 VGND.t1361 VGND.t1360 sg13_lv_nmos ad=79.8f pd=0.8u as=0 ps=0 w=0.42u l=1u
X2382 VPWR.t530 enable a_6094_3898# VPWR.t28 sg13_lv_pmos ad=0.2128p pd=1.5u as=0.2128p ps=1.5u w=1.12u l=0.13u
X2383 VPWR.t879 sg13cmos5l_xor2_1_0.B a_3875_5396# VPWR.t70 sg13_lv_pmos ad=0.2856p pd=2.36u as=0.1596p ps=1.22u w=0.84u l=0.13u
X2384 VGND.t315 a_7796_12934# sg13cmos5l_buf_16_37.X VGND.t612 sg13_lv_nmos ad=0.1406p pd=1.12u as=0.1406p ps=1.12u w=0.74u l=0.13u
X2385 VGND.t1067 VPWR.t1658 VGND.t1060 VGND.t1066 sg13_lv_nmos ad=0.1428p pd=1.52u as=0 ps=0 w=0.42u l=1u
X2386 VPWR.t631 a_10292_12934# sg13cmos5l_buf_16_23.X VPWR.t8 sg13_lv_pmos ad=0.2128p pd=1.5u as=0.2128p ps=1.5u w=1.12u l=0.13u
X2387 VGND.t584 sg13cmos5l_buf_16_39.A a_6164_2350# VGND.t1572 sg13_lv_nmos ad=0.2516p pd=2.16u as=0.1406p ps=1.12u w=0.74u l=0.13u
X2388 VGND.t491 a_5710_1632# sg13cmos5l_buf_16_5.A VGND.t875 sg13_lv_nmos ad=0.1406p pd=1.12u as=0.1406p ps=1.12u w=0.74u l=0.13u
X2389 VPWR.t454 VGND.t244 VPWR.t452 VPWR.t20 sg13_lv_pmos ad=0.19p pd=1.38u as=0 ps=0 w=1u l=1u
X2390 sg13cmos5l_buf_16_18.A a_4174_13728# VGND.t942 VGND.t1457 sg13_lv_nmos ad=0.1406p pd=1.12u as=0.1406p ps=1.12u w=0.74u l=0.13u
X2391 sg13cmos5l_buf_16_37.A a_8948_13692# VPWR.t930 VPWR.t8 sg13_lv_pmos ad=0.2128p pd=1.5u as=0.2128p ps=1.5u w=1.12u l=0.13u
X2392 sg13cmos5l_buf_16_30.A a_6164_2350# VPWR.t806 VPWR.t20 sg13_lv_pmos ad=0.2128p pd=1.5u as=0.2128p ps=1.5u w=1.12u l=0.13u
X2393 VGND.t358 a_5684_6132# sg13cmos5l_buf_16_28.X VGND.t842 sg13_lv_nmos ad=0.1406p pd=1.12u as=0.1406p ps=1.12u w=0.74u l=0.13u
X2394 VPWR.t342 VGND.t806 VPWR.t342 VPWR.t5 sg13_lv_pmos ad=0.34p pd=2.68u as=0 ps=0 w=1u l=1u
X2395 VGND.t1020 VPWR.t905 VGND.t1020 VGND.t156 sg13_lv_nmos ad=0.1428p pd=1.52u as=0 ps=0 w=0.42u l=1u
X2396 VGND.t358 VPWR.t1639 VGND.t358 VGND.t1165 sg13_lv_nmos ad=0.1428p pd=1.52u as=0 ps=0 w=0.42u l=1u
X2397 VGND.t384 VPWR.t1675 VGND.t384 VGND.t156 sg13_lv_nmos ad=79.8f pd=0.8u as=0 ps=0 w=0.42u l=1u
X2398 a_6094_3144# sg13cmos5l_buf_16_5.X VPWR.t900 VPWR.t20 sg13_lv_pmos ad=0.2128p pd=1.5u as=0.2128p ps=1.5u w=1.12u l=0.13u
X2399 VGND.t519 VPWR.t1681 VGND.t519 VGND.t978 sg13_lv_nmos ad=0.1428p pd=1.52u as=0 ps=0 w=0.42u l=1u
X2400 VPWR.t381 VGND.t1219 VPWR.t381 VPWR.t28 sg13_lv_pmos ad=0.34p pd=2.68u as=0 ps=0 w=1u l=1u
X2401 a_3694_10704# sg13cmos5l_buf_16_34.X VPWR.t690 VPWR.t55 sg13_lv_pmos ad=0.2128p pd=1.5u as=0.3808p ps=2.92u w=1.12u l=0.13u
X2402 VPWR.t570 VGND.t1153 VPWR.t569 VPWR.t5 sg13_lv_pmos ad=0.34p pd=2.68u as=0 ps=0 w=1u l=1u
X2403 VGND.t332 VPWR.t1689 VGND.t958 VGND.t959 sg13_lv_nmos ad=0.1428p pd=1.52u as=0 ps=0 w=0.42u l=1u
X2404 VPWR.t860 sg13cmos5l_buf_16_11.A a_3668_4620# VPWR.t28 sg13_lv_pmos ad=0.2128p pd=1.5u as=0.2128p ps=1.5u w=1.12u l=0.13u
X2405 sg13cmos5l_buf_16_4.X a_9524_6886# VPWR.t136 VPWR.t5 sg13_lv_pmos ad=0.2128p pd=1.5u as=0.2128p ps=1.5u w=1.12u l=0.13u
X2406 VGND.t636 VPWR.t292 VGND.t636 VGND.t926 sg13_lv_nmos ad=0.1428p pd=1.52u as=0 ps=0 w=0.42u l=1u
X2407 VPWR.t804 a_6164_2350# sg13cmos5l_buf_16_30.A VPWR.t20 sg13_lv_pmos ad=0.2128p pd=1.5u as=0.2128p ps=1.5u w=1.12u l=0.13u
X2408 VGND.t912 a_3694_14482# sg13cmos5l_buf_16_33.A VGND.t1521 sg13_lv_nmos ad=0.2516p pd=2.16u as=0.1406p ps=1.12u w=0.74u l=0.13u
X2409 VPWR.t464 a_4436_9910# sg13cmos5l_buf_16_14.A VPWR.t55 sg13_lv_pmos ad=0.2128p pd=1.5u as=0.2128p ps=1.5u w=1.12u l=0.13u
X2410 a_7220_5374# sg13cmos5l_buf_16_38.A VGND.t282 VGND.t844 sg13_lv_nmos ad=0.1406p pd=1.12u as=0.1406p ps=1.12u w=0.74u l=0.13u
X2411 sg13cmos5l_buf_16_28.X a_5684_6132# VPWR.t1375 VPWR.t70 sg13_lv_pmos ad=0.2128p pd=1.5u as=0.2128p ps=1.5u w=1.12u l=0.13u
X2412 VGND.t315 VPWR.t118 VGND.t315 VGND.t984 sg13_lv_nmos ad=0.1428p pd=1.52u as=0 ps=0 w=0.42u l=1u
X2413 VGND.t1296 VPWR.t21 VGND.t1296 VGND.t1298 sg13_lv_nmos ad=0.1428p pd=1.52u as=0 ps=0 w=0.42u l=1u
X2414 VPWR.t357 VGND.t377 VPWR.t357 VPWR.t55 sg13_lv_pmos ad=0.34p pd=2.68u as=0 ps=0 w=1u l=1u
X2415 VPWR.t42 VGND.t1248 VPWR.t41 VPWR.t28 sg13_lv_pmos ad=0.34p pd=2.68u as=0 ps=0 w=1u l=1u
X2416 VPWR.t136 a_9524_6886# sg13cmos5l_buf_16_4.X VPWR.t5 sg13_lv_pmos ad=0.2128p pd=1.5u as=0.2128p ps=1.5u w=1.12u l=0.13u
X2417 VGND.t275 sg13cmos5l_buf_16_34.A a_3694_7680# VGND.t278 sg13_lv_nmos ad=0.1406p pd=1.12u as=0.1406p ps=1.12u w=0.74u l=0.13u
X2418 VPWR.t24 VGND.t1392 VPWR.t24 VPWR.t0 sg13_lv_pmos ad=0.34p pd=2.68u as=0 ps=0 w=1u l=1u
X2419 VPWR.t54 VGND.t1248 VPWR.t53 VPWR.t20 sg13_lv_pmos ad=0.34p pd=2.68u as=0 ps=0 w=1u l=1u
X2420 a_5108_838# sg13cmos5l_buf_16_5.A VPWR.t19 VPWR.t0 sg13_lv_pmos ad=0.2128p pd=1.5u as=0.2128p ps=1.5u w=1.12u l=0.13u
X2421 VGND.t384 sg13cmos5l_buf_16_34.X a_3694_10704# VGND.t156 sg13_lv_nmos ad=0.1406p pd=1.12u as=0.1406p ps=1.12u w=0.74u l=0.13u
X2422 VGND.t282 a_7220_5374# sg13cmos5l_buf_16_28.A VGND.t295 sg13_lv_nmos ad=0.1406p pd=1.12u as=0.1406p ps=1.12u w=0.74u l=0.13u
X2423 VGND.t806 sg13cmos5l_buf_16_4.A a_9524_6886# VGND.t805 sg13_lv_nmos ad=0.1406p pd=1.12u as=0.1406p ps=1.12u w=0.74u l=0.13u
X2424 VPWR.t1 VGND.t1405 VPWR.t1 VPWR.t0 sg13_lv_pmos ad=0.19p pd=1.38u as=0 ps=0 w=1u l=1u
X2425 VPWR.t381 VGND.t130 VPWR.t382 VPWR.t28 sg13_lv_pmos ad=0.19p pd=1.38u as=0 ps=0 w=1u l=1u
X2426 sg13cmos5l_buf_16_2.A a_9262_7680# VPWR.t136 VPWR.t5 sg13_lv_pmos ad=0.2128p pd=1.5u as=0.2128p ps=1.5u w=1.12u l=0.13u
X2427 sg13cmos5l_buf_16_27.X a_6548_13692# VPWR.t1498 VPWR.t8 sg13_lv_pmos ad=0.2128p pd=1.5u as=0.2128p ps=1.5u w=1.12u l=0.13u
X2428 VGND.t652 a_10292_12934# sg13cmos5l_buf_16_23.X VGND.t654 sg13_lv_nmos ad=0.1406p pd=1.12u as=0.1406p ps=1.12u w=0.74u l=0.13u
X2429 a_6094_4656# sg13cmos5l_buf_16_7.X VGND.t27 VGND.t36 sg13_lv_nmos ad=0.1406p pd=1.12u as=0.1406p ps=1.12u w=0.74u l=0.13u
X2430 VGND.t1 a_6836_9156# sg13cmos5l_buf_16_25.A VGND.t106 sg13_lv_nmos ad=0.1406p pd=1.12u as=0.1406p ps=1.12u w=0.74u l=0.13u
X2431 a_3694_7680# sg13cmos5l_buf_16_34.A VGND.t275 VGND.t274 sg13_lv_nmos ad=0.1406p pd=1.12u as=0.2516p ps=2.16u w=0.74u l=0.13u
X2432 VGND.t72 VPWR.t70 VGND.t72 VGND.t1216 sg13_lv_nmos ad=0.1428p pd=1.52u as=0 ps=0 w=0.42u l=1u
X2433 VPWR.t834 a_3694_10704# sg13cmos5l_and2_2_6.A VPWR.t55 sg13_lv_pmos ad=0.2128p pd=1.5u as=0.2128p ps=1.5u w=1.12u l=0.13u
X2434 VGND.t942 a_3694_14482# sg13cmos5l_buf_16_33.A VGND.t1517 sg13_lv_nmos ad=0.1406p pd=1.12u as=0.1406p ps=1.12u w=0.74u l=0.13u
X2435 sg13cmos5l_buf_16_22.X a_10318_8434# VGND.t11 VGND.t767 sg13_lv_nmos ad=0.1406p pd=1.12u as=0.1406p ps=1.12u w=0.74u l=0.13u
X2436 a_8494_3144# sg13cmos5l_buf_16_0.A VGND.t56 VGND.t40 sg13_lv_nmos ad=0.1406p pd=1.12u as=0.1406p ps=1.12u w=0.74u l=0.13u
X2437 sg13cmos5l_buf_16_24.X a_6862_9946# VGND.t1 VGND.t103 sg13_lv_nmos ad=0.1406p pd=1.12u as=0.1406p ps=1.12u w=0.74u l=0.13u
X2438 VGND.t11 a_6766_8434# sg13cmos5l_buf_16_35.A VGND.t1560 sg13_lv_nmos ad=0.1406p pd=1.12u as=0.1406p ps=1.12u w=0.74u l=0.13u
X2439 VPWR.t19 a_5108_838# sg13cmos5l_buf_16_5.X VPWR.t0 sg13_lv_pmos ad=0.2128p pd=1.5u as=0.2128p ps=1.5u w=1.12u l=0.13u
X2440 VPWR.t1424 enable a_6094_3898# VPWR.t28 sg13_lv_pmos ad=0.2128p pd=1.5u as=0.2128p ps=1.5u w=1.12u l=0.13u
X2441 a_9524_6886# sg13cmos5l_buf_16_4.A VGND.t358 VGND.t802 sg13_lv_nmos ad=0.1406p pd=1.12u as=0.1406p ps=1.12u w=0.74u l=0.13u
X2442 VPWR.t136 a_9262_7680# sg13cmos5l_buf_16_2.A VPWR.t5 sg13_lv_pmos ad=0.2128p pd=1.5u as=0.2128p ps=1.5u w=1.12u l=0.13u
X2443 VPWR.t245 VGND.t1060 VPWR.t190 VPWR.t3 sg13_lv_pmos ad=0.34p pd=2.68u as=0 ps=0 w=1u l=1u
X2444 sg13cmos5l_buf_16_23.X a_10292_12934# VPWR.t631 VPWR.t8 sg13_lv_pmos ad=0.2128p pd=1.5u as=0.2128p ps=1.5u w=1.12u l=0.13u
X2445 a_10292_12934# sg13cmos5l_buf_1_17.A VPWR.t631 VPWR.t8 sg13_lv_pmos ad=0.2128p pd=1.5u as=0.2128p ps=1.5u w=1.12u l=0.13u
X2446 sg13cmos5l_buf_16_5.X a_5108_838# VGND.t860 VGND.t1434 sg13_lv_nmos ad=0.1406p pd=1.12u as=0.2516p ps=2.16u w=0.74u l=0.13u
X2447 VPWR.t70 sg13cmos5l_buf_16_38.A a_7220_5374# VPWR.t70 sg13_lv_pmos ad=0.2128p pd=1.5u as=0.2128p ps=1.5u w=1.12u l=0.13u
X2448 VPWR.t657 a_3668_12180# sg13cmos5l_buf_16_15.X VPWR.t13 sg13_lv_pmos ad=0.2128p pd=1.5u as=0.2128p ps=1.5u w=1.12u l=0.13u
X2449 VGND.t1 sg13cmos5l_buf_16_24.A a_6862_9946# VGND.t100 sg13_lv_nmos ad=0.1406p pd=1.12u as=0.1406p ps=1.12u w=0.74u l=0.13u
X2450 sg13cmos5l_buf_16_27.X a_6548_13692# VPWR.t1494 VPWR.t8 sg13_lv_pmos ad=0.2128p pd=1.5u as=0.2128p ps=1.5u w=1.12u l=0.13u
X2451 VPWR.t665 sg13cmos5l_buf_16_19.A a_5204_11422# VPWR.t13 sg13_lv_pmos ad=0.3808p pd=2.92u as=0.2128p ps=1.5u w=1.12u l=0.13u
X2452 sg13cmos5l_buf_16_24.X a_6862_9946# VPWR.t560 VPWR.t55 sg13_lv_pmos ad=0.2128p pd=1.5u as=0.2128p ps=1.5u w=1.12u l=0.13u
X2453 VGND.t126 a_10318_5410# sg13cmos5l_buf_16_1.X VGND.t125 sg13_lv_nmos ad=0.1406p pd=1.12u as=0.1406p ps=1.12u w=0.74u l=0.13u
X2454 VPWR.t1128 sg13cmos5l_buf_16_13.A a_3694_8434# VPWR.t3 sg13_lv_pmos ad=0.2128p pd=1.5u as=0.2128p ps=1.5u w=1.12u l=0.13u
X2455 VPWR.t1208 sg13cmos5l_buf_16_14.A a_3668_9156# VPWR.t3 sg13_lv_pmos ad=0.3808p pd=2.92u as=0.2128p ps=1.5u w=1.12u l=0.13u
X2456 VPWR.t18 VGND.t1417 VPWR.t18 VPWR.t0 sg13_lv_pmos ad=0.34p pd=2.68u as=0 ps=0 w=1u l=1u
X2457 sg13cmos5l_buf_16_28.A a_7220_5374# VPWR.t612 VPWR.t70 sg13_lv_pmos ad=0.2128p pd=1.5u as=0.2128p ps=1.5u w=1.12u l=0.13u
X2458 a_4892_6168# sg13cmos5l_buf_16_31.X VPWR.t1225 VPWR.t70 sg13_lv_pmos ad=0.2128p pd=1.5u as=0.2128p ps=1.5u w=1.12u l=0.13u
X2459 VGND.t150 VPWR.t1611 VGND.t150 VGND.t1289 sg13_lv_nmos ad=79.8f pd=0.8u as=0 ps=0 w=0.42u l=1u
X2460 a_5204_11422# sg13cmos5l_buf_16_19.A VGND.t350 VGND.t156 sg13_lv_nmos ad=0.1406p pd=1.12u as=0.1406p ps=1.12u w=0.74u l=0.13u
X2461 a_10318_8434# sg13cmos5l_buf_16_1.X VGND.t11 VGND.t59 sg13_lv_nmos ad=0.1406p pd=1.12u as=0.1406p ps=1.12u w=0.74u l=0.13u
X2462 a_8538_2578# sg13cmos5l_xor2_1_0.B VGND.t584 VGND.t583 sg13_lv_nmos ad=0.17462p pd=1.185u as=0.15245p ps=1.17u w=0.55u l=0.13u
X2463 sg13cmos5l_buf_16_28.X a_5684_6132# VPWR.t1371 VPWR.t70 sg13_lv_pmos ad=0.2128p pd=1.5u as=0.2128p ps=1.5u w=1.12u l=0.13u
X2464 VGND.t207 a_3694_3898# sg13cmos5l_buf_16_10.A VGND.t40 sg13_lv_nmos ad=0.1406p pd=1.12u as=0.1406p ps=1.12u w=0.74u l=0.13u
X2465 VPWR.t653 a_3668_12180# sg13cmos5l_buf_16_15.X VPWR.t13 sg13_lv_pmos ad=0.2128p pd=1.5u as=0.2128p ps=1.5u w=1.12u l=0.13u
X2466 VPWR.t297 VGND.t573 VPWR.t297 VPWR.t8 sg13_lv_pmos ad=0.19p pd=1.38u as=0 ps=0 w=1u l=1u
X2467 a_3668_9156# sg13cmos5l_buf_16_14.A VPWR.t1202 VPWR.t3 sg13_lv_pmos ad=0.2128p pd=1.5u as=0.2128p ps=1.5u w=1.12u l=0.13u
X2468 sg13cmos5l_buf_16_35.A a_6766_8434# VPWR.t1570 VPWR.t3 sg13_lv_pmos ad=0.2128p pd=1.5u as=0.2128p ps=1.5u w=1.12u l=0.13u
X2469 VPWR.t1291 a_5204_11422# sg13cmos5l_buf_16_20.A VPWR.t13 sg13_lv_pmos ad=0.2128p pd=1.5u as=0.2128p ps=1.5u w=1.12u l=0.13u
X2470 sg13cmos5l_buf_16_24.X a_6862_9946# VPWR.t556 VPWR.t55 sg13_lv_pmos ad=0.2128p pd=1.5u as=0.2128p ps=1.5u w=1.12u l=0.13u
X2471 sg13cmos5l_buf_16_38.A a_8110_6168# VGND.t358 VGND.t538 sg13_lv_nmos ad=0.1406p pd=1.12u as=0.1406p ps=1.12u w=0.74u l=0.13u
X2472 sg13cmos5l_and2_2_6.A a_3694_10704# VGND.t384 VGND.t156 sg13_lv_nmos ad=0.1406p pd=1.12u as=0.1406p ps=1.12u w=0.74u l=0.13u
X2473 VPWR.t631 sg13cmos5l_buf_16_27.X a_11924_13728# VPWR.t8 sg13_lv_pmos ad=0.2128p pd=1.5u as=0.2128p ps=1.5u w=1.12u l=0.13u
X2474 VGND.t413 VPWR.t1653 VGND.t413 VGND.t1122 sg13_lv_nmos ad=79.8f pd=0.8u as=0 ps=0 w=0.42u l=1u
X2475 sg13cmos5l_buf_16_10.A a_3694_3898# VGND.t198 VGND.t40 sg13_lv_nmos ad=0.1406p pd=1.12u as=0.1406p ps=1.12u w=0.74u l=0.13u
X2476 VPWR.t679 a_6094_10704# sg13cmos5l_buf_16_24.A VPWR.t55 sg13_lv_pmos ad=0.2128p pd=1.5u as=0.2128p ps=1.5u w=1.12u l=0.13u
X2477 VGND.t1 a_6836_9156# sg13cmos5l_buf_16_25.A VGND.t102 sg13_lv_nmos ad=0.1406p pd=1.12u as=0.1406p ps=1.12u w=0.74u l=0.13u
X2478 VPWR.t1568 a_6766_8434# sg13cmos5l_buf_16_35.A VPWR.t3 sg13_lv_pmos ad=0.2128p pd=1.5u as=0.2128p ps=1.5u w=1.12u l=0.13u
X2479 sg13cmos5l_buf_16_18.A a_4174_13728# VPWR.t1468 VPWR.t8 sg13_lv_pmos ad=0.2128p pd=1.5u as=0.2128p ps=1.5u w=1.12u l=0.13u
X2480 sg13cmos5l_buf_16_5.A a_5710_1632# VPWR.t19 VPWR.t0 sg13_lv_pmos ad=0.2128p pd=1.5u as=0.2128p ps=1.5u w=1.12u l=0.13u
X2481 VPWR.t19 a_5108_838# sg13cmos5l_buf_16_5.X VPWR.t0 sg13_lv_pmos ad=0.2128p pd=1.5u as=0.2128p ps=1.5u w=1.12u l=0.13u
X2482 sg13cmos5l_buf_16_1.X a_10318_5410# VPWR.t319 VPWR.t70 sg13_lv_pmos ad=0.2128p pd=1.5u as=0.2128p ps=1.5u w=1.12u l=0.13u
X2483 out_xor[5] a_14824_10704# VGND.t157 VGND.t156 sg13_lv_nmos ad=0.2886p pd=2.26u as=0.14875p ps=1.16u w=0.74u l=0.13u
X2484 sg13cmos5l_buf_16_31.X a_6094_4656# VPWR.t745 VPWR.t28 sg13_lv_pmos ad=0.2128p pd=1.5u as=0.2128p ps=1.5u w=1.12u l=0.13u
X2485 VPWR.t971 VGND.t222 VPWR.t967 VPWR.t28 sg13_lv_pmos ad=0.19p pd=1.38u as=0 ps=0 w=1u l=1u
X2486 VGND.t315 VPWR.t125 VGND.t315 VGND.t989 sg13_lv_nmos ad=79.8f pd=0.8u as=0 ps=0 w=0.42u l=1u
X2487 sg13cmos5l_buf_16_28.X a_5684_6132# VPWR.t1367 VPWR.t70 sg13_lv_pmos ad=0.2128p pd=1.5u as=0.2128p ps=1.5u w=1.12u l=0.13u
X2488 sg13cmos5l_buf_16_6.X a_5518_6922# VPWR.t1222 VPWR.t5 sg13_lv_pmos ad=0.2128p pd=1.5u as=0.2128p ps=1.5u w=1.12u l=0.13u
X2489 VGND.t11 a_9262_7680# sg13cmos5l_buf_16_2.A VGND.t19 sg13_lv_nmos ad=0.1406p pd=1.12u as=0.1406p ps=1.12u w=0.74u l=0.13u
X2490 VPWR.t649 a_3668_12180# sg13cmos5l_buf_16_15.X VPWR.t13 sg13_lv_pmos ad=0.2128p pd=1.5u as=0.2128p ps=1.5u w=1.12u l=0.13u
X2491 VGND.t860 a_5108_838# sg13cmos5l_buf_16_5.X VGND.t1435 sg13_lv_nmos ad=0.1406p pd=1.12u as=0.1406p ps=1.12u w=0.74u l=0.13u
X2492 VGND.t198 sg13cmos5l_buf_16_8.A a_3694_3898# VGND.t40 sg13_lv_nmos ad=0.1406p pd=1.12u as=0.1406p ps=1.12u w=0.74u l=0.13u
X2493 sg13cmos5l_buf_16_25.A a_6836_9156# VGND.t1 VGND.t99 sg13_lv_nmos ad=0.1406p pd=1.12u as=0.1406p ps=1.12u w=0.74u l=0.13u
X2494 VPWR.t190 sg13cmos5l_buf_16_1.X a_10318_8434# VPWR.t3 sg13_lv_pmos ad=0.2128p pd=1.5u as=0.2128p ps=1.5u w=1.12u l=0.13u
X2495 VPWR.t1287 a_5204_11422# sg13cmos5l_buf_16_20.A VPWR.t13 sg13_lv_pmos ad=0.2128p pd=1.5u as=0.2128p ps=1.5u w=1.12u l=0.13u
X2496 a_6862_9946# sg13cmos5l_buf_16_24.A VPWR.t587 VPWR.t55 sg13_lv_pmos ad=0.2128p pd=1.5u as=0.3808p ps=2.92u w=1.12u l=0.13u
X2497 sg13cmos5l_buf_16_13.A a_3668_9156# VPWR.t486 VPWR.t3 sg13_lv_pmos ad=0.2128p pd=1.5u as=0.2128p ps=1.5u w=1.12u l=0.13u
X2498 VPWR.t319 a_10318_5410# sg13cmos5l_buf_16_1.X VPWR.t70 sg13_lv_pmos ad=0.2128p pd=1.5u as=0.2128p ps=1.5u w=1.12u l=0.13u
X2499 VPWR.t1 VGND.t1402 VPWR.t1 VPWR.t0 sg13_lv_pmos ad=0.34p pd=2.68u as=0 ps=0 w=1u l=1u
X2500 VPWR.t338 VGND.t999 VPWR.t336 VPWR.t55 sg13_lv_pmos ad=0.19p pd=1.38u as=0 ps=0 w=1u l=1u
X2501 VPWR.t744 sg13cmos5l_buf_16_7.X a_6094_4656# VPWR.t28 sg13_lv_pmos ad=0.2128p pd=1.5u as=0.2128p ps=1.5u w=1.12u l=0.13u
X2502 VPWR.t1220 a_5518_6922# sg13cmos5l_buf_16_6.X VPWR.t5 sg13_lv_pmos ad=0.2128p pd=1.5u as=0.2128p ps=1.5u w=1.12u l=0.13u
X2503 VGND.t1060 VPWR.t190 VGND.t1060 VGND.t1076 sg13_lv_nmos ad=79.8f pd=0.8u as=0 ps=0 w=0.42u l=1u
X2504 sg13cmos5l_buf_16_18.A a_4174_13728# VPWR.t1464 VPWR.t8 sg13_lv_pmos ad=0.2128p pd=1.5u as=0.2128p ps=1.5u w=1.12u l=0.13u
X2505 VGND.t1020 VPWR.t905 VGND.t1020 VGND.t156 sg13_lv_nmos ad=0.1428p pd=1.52u as=0 ps=0 w=0.42u l=1u
X2506 VPWR.t56 VGND.t157 VPWR.t905 VPWR.t55 sg13_lv_pmos ad=0.19p pd=1.38u as=0 ps=0 w=1u l=1u
X2507 a_6161_9550# sg13cmos5l_buf_16_14.A VGND.t1 VGND.t664 sg13_lv_nmos ad=0.17462p pd=1.185u as=0.374p ps=2.46u w=0.55u l=0.13u
X2508 sg13cmos5l_buf_16_28.A a_7220_5374# VPWR.t608 VPWR.t70 sg13_lv_pmos ad=0.2128p pd=1.5u as=0.2128p ps=1.5u w=1.12u l=0.13u
X2509 VGND.t1393 VPWR.t24 VGND.t1392 VGND.t1391 sg13_lv_nmos ad=0.1428p pd=1.52u as=0 ps=0 w=0.42u l=1u
X2510 VPWR.t229 a_6836_9156# sg13cmos5l_buf_16_25.A VPWR.t3 sg13_lv_pmos ad=0.2128p pd=1.5u as=0.2128p ps=1.5u w=1.12u l=0.13u
X2511 sg13cmos5l_buf_16_5.A a_5710_1632# VPWR.t19 VPWR.t0 sg13_lv_pmos ad=0.2128p pd=1.5u as=0.2128p ps=1.5u w=1.12u l=0.13u
X2512 VGND.t693 VPWR.t292 VGND.t693 VGND.t922 sg13_lv_nmos ad=0.1428p pd=1.52u as=0 ps=0 w=0.42u l=1u
X2513 sg13cmos5l_buf_16_11.A a_4462_5410# VGND.t27 VGND.t36 sg13_lv_nmos ad=0.1406p pd=1.12u as=0.1406p ps=1.12u w=0.74u l=0.13u
X2514 VGND.t1291 VPWR.t1610 VGND.t146 VGND.t1292 sg13_lv_nmos ad=79.8f pd=0.8u as=0 ps=0 w=0.42u l=1u
X2515 VGND.t332 VPWR.t1682 VGND.t332 VGND.t960 sg13_lv_nmos ad=79.8f pd=0.8u as=0 ps=0 w=0.42u l=1u
X2516 VPWR.t1004 VGND.t150 VPWR.t1002 VPWR.t20 sg13_lv_pmos ad=0.19p pd=1.38u as=0 ps=0 w=1u l=1u
X2517 VGND.t207 a_3668_3108# sg13cmos5l_buf_16_7.A VGND.t40 sg13_lv_nmos ad=0.1406p pd=1.12u as=0.1406p ps=1.12u w=0.74u l=0.13u
X2518 VGND.t5 sg13cmos5l_buf_16_6.X a_9617_8484# VGND.t160 sg13_lv_nmos ad=0.15245p pd=1.17u as=0.17462p ps=1.185u w=0.55u l=0.13u
X2519 VPWR.t47 VGND.t244 VPWR.t455 VPWR.t20 sg13_lv_pmos ad=0.34p pd=2.68u as=0 ps=0 w=1u l=1u
X2520 sg13cmos5l_buf_16_18.A a_4174_13728# VPWR.t1460 VPWR.t8 sg13_lv_pmos ad=0.2128p pd=1.5u as=0.2128p ps=1.5u w=1.12u l=0.13u
X2521 VGND.t244 VPWR.t1621 VGND.t244 VGND.t40 sg13_lv_nmos ad=0.1428p pd=1.52u as=0 ps=0 w=0.42u l=1u
X2522 VPWR.t116 VGND.t315 VPWR.t114 VPWR.t13 sg13_lv_pmos ad=0.19p pd=1.38u as=0 ps=0 w=1u l=1u
X2523 VGND.t150 a_3694_2386# sg13cmos5l_buf_16_7.X VGND.t485 sg13_lv_nmos ad=0.1406p pd=1.12u as=0.1406p ps=1.12u w=0.74u l=0.13u
X2524 VPWR.t21 a_8494_3144# sg13cmos5l_buf_16_39.A VPWR.t20 sg13_lv_pmos ad=0.2128p pd=1.5u as=0.2128p ps=1.5u w=1.12u l=0.13u
X2525 VGND.t907 VPWR.t1696 VGND.t907 VGND.t906 sg13_lv_nmos ad=0.1428p pd=1.52u as=0 ps=0 w=0.42u l=1u
X2526 sg13cmos5l_buf_16_0.A a_6094_3898# VPWR.t541 VPWR.t28 sg13_lv_pmos ad=0.2128p pd=1.5u as=0.2128p ps=1.5u w=1.12u l=0.13u
X2527 sg13cmos5l_buf_16_5.A a_5710_1632# VGND.t504 VGND.t888 sg13_lv_nmos ad=0.1406p pd=1.12u as=0.1406p ps=1.12u w=0.74u l=0.13u
X2528 VGND.t1428 VPWR.t18 VGND.t1430 VGND.t1429 sg13_lv_nmos ad=79.8f pd=0.8u as=0 ps=0 w=0.42u l=1u
X2529 sg13cmos5l_buf_16_7.A a_3668_3108# VGND.t198 VGND.t40 sg13_lv_nmos ad=0.1406p pd=1.12u as=0.1406p ps=1.12u w=0.74u l=0.13u
X2530 VPWR.t1052 VGND.t377 VPWR.t1051 VPWR.t13 sg13_lv_pmos ad=0.34p pd=2.68u as=0 ps=0 w=1u l=1u
X2531 a_3694_7680# sg13cmos5l_buf_16_34.A VPWR.t594 VPWR.t5 sg13_lv_pmos ad=0.2128p pd=1.5u as=0.2128p ps=1.5u w=1.12u l=0.13u
X2532 VGND.t999 VPWR.t1677 VGND.t999 VGND.t156 sg13_lv_nmos ad=0.1428p pd=1.52u as=0 ps=0 w=0.42u l=1u
X2533 sg13cmos5l_buf_16_2.X a_10318_3898# VGND.t130 VGND.t40 sg13_lv_nmos ad=0.1406p pd=1.12u as=0.1406p ps=1.12u w=0.74u l=0.13u
X2534 sg13cmos5l_buf_16_4.A a_11565_8028# VPWR.t342 VPWR.t5 sg13_lv_pmos ad=0.2128p pd=1.5u as=0.1918p ps=1.5u w=1.12u l=0.13u
X2535 VPWR.t179 a_6094_3144# sg13cmos5l_xor2_1_0.B VPWR.t20 sg13_lv_pmos ad=0.2128p pd=1.5u as=0.2128p ps=1.5u w=1.12u l=0.13u
X2536 VPWR.t992 VGND.t332 VPWR.t17 VPWR.t13 sg13_lv_pmos ad=0.19p pd=1.38u as=0 ps=0 w=1u l=1u
X2537 VGND.t402 a_3694_8434# sg13cmos5l_buf_16_34.A VGND.t406 sg13_lv_nmos ad=0.1406p pd=1.12u as=0.1406p ps=1.12u w=0.74u l=0.13u
X2538 VPWR.t778 a_3694_2386# sg13cmos5l_buf_16_7.X VPWR.t20 sg13_lv_pmos ad=0.2128p pd=1.5u as=0.2128p ps=1.5u w=1.12u l=0.13u
X2539 VGND.t130 VPWR.t30 VGND.t130 VGND.t40 sg13_lv_nmos ad=79.8f pd=0.8u as=0 ps=0 w=0.42u l=1u
X2540 VGND.t504 a_5710_1632# sg13cmos5l_buf_16_5.A VGND.t885 sg13_lv_nmos ad=0.1406p pd=1.12u as=0.1406p ps=1.12u w=0.74u l=0.13u
X2541 VGND.t942 a_4174_13728# sg13cmos5l_buf_16_18.A VGND.t1458 sg13_lv_nmos ad=0.1406p pd=1.12u as=0.1406p ps=1.12u w=0.74u l=0.13u
X2542 VPWR.t98 VGND.t315 VPWR.t96 VPWR.t8 sg13_lv_pmos ad=0.19p pd=1.38u as=0 ps=0 w=1u l=1u
X2543 VGND.t198 a_3668_3108# sg13cmos5l_buf_16_7.A VGND.t40 sg13_lv_nmos ad=0.1406p pd=1.12u as=0.1406p ps=1.12u w=0.74u l=0.13u
X2544 VPWR.t866 sg13cmos5l_buf_16_7.X a_6094_4656# VPWR.t28 sg13_lv_pmos ad=0.2128p pd=1.5u as=0.2128p ps=1.5u w=1.12u l=0.13u
X2545 VPWR.t118 VGND.t377 VPWR.t118 VPWR.t13 sg13_lv_pmos ad=0.34p pd=2.68u as=0 ps=0 w=1u l=1u
X2546 VGND.t282 a_6094_4656# sg13cmos5l_buf_16_31.X VGND.t450 sg13_lv_nmos ad=0.1406p pd=1.12u as=0.1406p ps=1.12u w=0.74u l=0.13u
X2547 VGND.t130 a_10318_3898# sg13cmos5l_buf_16_2.X VGND.t40 sg13_lv_nmos ad=0.1406p pd=1.12u as=0.1406p ps=1.12u w=0.74u l=0.13u
X2548 VPWR.t165 a_4462_5410# sg13cmos5l_buf_16_11.A VPWR.t70 sg13_lv_pmos ad=0.2128p pd=1.5u as=0.2128p ps=1.5u w=1.12u l=0.13u
X2549 VGND.t573 VPWR.t304 VGND.t573 VGND.t996 sg13_lv_nmos ad=0.1428p pd=1.52u as=0 ps=0 w=0.42u l=1u
X2550 sg13cmos5l_buf_16_34.A a_3694_8434# VGND.t402 VGND.t403 sg13_lv_nmos ad=0.1406p pd=1.12u as=0.1406p ps=1.12u w=0.74u l=0.13u
X2551 VGND.t261 a_6862_9946# sg13cmos5l_buf_16_24.X VGND.t260 sg13_lv_nmos ad=0.2516p pd=2.16u as=0.1406p ps=1.12u w=0.74u l=0.13u
X2552 VGND.t1060 VPWR.t1659 VGND.t1060 VGND.t1064 sg13_lv_nmos ad=0.1428p pd=1.52u as=0 ps=0 w=0.42u l=1u
X2553 VGND.t112 a_8494_3144# sg13cmos5l_buf_16_39.A VGND.t40 sg13_lv_nmos ad=0.1406p pd=1.12u as=0.1406p ps=1.12u w=0.74u l=0.13u
X2554 a_3694_2386# sg13cmos5l_buf_16_7.A VPWR.t277 VPWR.t20 sg13_lv_pmos ad=0.2128p pd=1.5u as=0.2128p ps=1.5u w=1.12u l=0.13u
X2555 VPWR.t691 sg13cmos5l_buf_16_34.X a_3694_10704# VPWR.t55 sg13_lv_pmos ad=0.2128p pd=1.5u as=0.2128p ps=1.5u w=1.12u l=0.13u
X2556 sg13cmos5l_buf_16_0.A a_6094_3898# VPWR.t537 VPWR.t28 sg13_lv_pmos ad=0.2128p pd=1.5u as=0.2128p ps=1.5u w=1.12u l=0.13u
X2557 VPWR.t1582 sg13cmos5l_buf_16_39.A a_6164_2350# VPWR.t20 sg13_lv_pmos ad=0.3808p pd=2.92u as=0.2128p ps=1.5u w=1.12u l=0.13u
X2558 VPWR.t1 VGND.t1407 VPWR.t1 VPWR.t0 sg13_lv_pmos ad=0.34p pd=2.68u as=0 ps=0 w=1u l=1u
X2559 VPWR.t56 VGND.t397 VPWR.t56 VPWR.t55 sg13_lv_pmos ad=0.19p pd=1.38u as=0 ps=0 w=1u l=1u
X2560 VGND.t150 VPWR.t1613 VGND.t150 VGND.t1285 sg13_lv_nmos ad=79.8f pd=0.8u as=0 ps=0 w=0.42u l=1u
X2561 VPWR.t86 VGND.t413 VPWR.t84 VPWR.t5 sg13_lv_pmos ad=0.19p pd=1.38u as=0 ps=0 w=1u l=1u
X2562 sg13cmos5l_buf_16_11.A a_4462_5410# VPWR.t161 VPWR.t70 sg13_lv_pmos ad=0.2128p pd=1.5u as=0.2128p ps=1.5u w=1.12u l=0.13u
X2563 sg13cmos5l_buf_16_4.X a_9524_6886# VGND.t358 VGND.t815 sg13_lv_nmos ad=0.1406p pd=1.12u as=0.1406p ps=1.12u w=0.74u l=0.13u
X2564 VGND.t130 VPWR.t281 VGND.t130 VGND.t40 sg13_lv_nmos ad=79.8f pd=0.8u as=0 ps=0 w=0.42u l=1u
X2565 sg13cmos5l_buf_16_37.X a_7796_12934# VGND.t315 VGND.t609 sg13_lv_nmos ad=0.1406p pd=1.12u as=0.1406p ps=1.12u w=0.74u l=0.13u
X2566 VPWR.t175 a_6094_3144# sg13cmos5l_xor2_1_0.B VPWR.t20 sg13_lv_pmos ad=0.2128p pd=1.5u as=0.2128p ps=1.5u w=1.12u l=0.13u
X2567 sg13cmos5l_buf_16_23.X a_10292_12934# VPWR.t631 VPWR.t8 sg13_lv_pmos ad=0.2128p pd=1.5u as=0.3976p ps=2.95u w=1.12u l=0.13u
X2568 a_3668_12180# sg13cmos5l_buf_16_15.A VGND.t315 VGND.t514 sg13_lv_nmos ad=0.1406p pd=1.12u as=0.1406p ps=1.12u w=0.74u l=0.13u
X2569 VPWR.t444 VGND.t244 VPWR.t443 VPWR.t28 sg13_lv_pmos ad=0.34p pd=2.68u as=0 ps=0 w=1u l=1u
X2570 VPWR.t70 a_8110_6168# sg13cmos5l_buf_16_38.A VPWR.t70 sg13_lv_pmos ad=0.3976p pd=2.95u as=0.2128p ps=1.5u w=1.12u l=0.13u
X2571 a_4052_12934# sg13cmos5l_buf_16_18.A VGND.t315 VGND.t1535 sg13_lv_nmos ad=0.1406p pd=1.12u as=0.1406p ps=1.12u w=0.74u l=0.13u
X2572 VPWR.t304 VGND.t573 VPWR.t304 VPWR.t13 sg13_lv_pmos ad=0.34p pd=2.68u as=0 ps=0 w=1u l=1u
X2573 VGND.t358 a_9524_6886# sg13cmos5l_buf_16_4.X VGND.t812 sg13_lv_nmos ad=0.1406p pd=1.12u as=0.1406p ps=1.12u w=0.74u l=0.13u
X2574 sg13cmos5l_xor2_1_0.B a_6094_3144# VPWR.t171 VPWR.t20 sg13_lv_pmos ad=0.2128p pd=1.5u as=0.2128p ps=1.5u w=1.12u l=0.13u
X2575 VPWR.t357 VGND.t1060 VPWR.t357 VPWR.t55 sg13_lv_pmos ad=0.34p pd=2.68u as=0 ps=0 w=1u l=1u
X2576 sg13cmos5l_buf_16_23.X a_10292_12934# VGND.t652 VGND.t655 sg13_lv_nmos ad=0.1406p pd=1.12u as=0.1406p ps=1.12u w=0.74u l=0.13u
X2577 VPWR.t725 sg13cmos5l_buf_16_28.A a_5684_6132# VPWR.t70 sg13_lv_pmos ad=0.3808p pd=2.92u as=0.2128p ps=1.5u w=1.12u l=0.13u
X2578 VPWR.t1506 sg13cmos5l_buf_16_15.X a_3694_14482# VPWR.t292 sg13_lv_pmos ad=0.2128p pd=1.5u as=0.2128p ps=1.5u w=1.12u l=0.13u
X2579 VGND.t1086 VPWR.t905 VGND.t1085 VGND.t1084 sg13_lv_nmos ad=0.1428p pd=1.52u as=0 ps=0 w=0.42u l=1u
X2580 VPWR.t1519 a_3694_14482# sg13cmos5l_buf_16_33.A VPWR.t292 sg13_lv_pmos ad=0.2128p pd=1.5u as=0.2128p ps=1.5u w=1.12u l=0.13u
X2581 VGND.t222 a_3668_4620# sg13cmos5l_buf_16_8.A VGND.t460 sg13_lv_nmos ad=0.1406p pd=1.12u as=0.1406p ps=1.12u w=0.74u l=0.13u
X2582 VPWR.t50 VGND.t1248 VPWR.t49 VPWR.t20 sg13_lv_pmos ad=0.34p pd=2.68u as=0 ps=0 w=1u l=1u
X2583 a_9524_6886# sg13cmos5l_buf_16_4.A VPWR.t342 VPWR.t5 sg13_lv_pmos ad=0.2128p pd=1.5u as=0.2128p ps=1.5u w=1.12u l=0.13u
X2584 sg13cmos5l_buf_16_34.X a_3694_7680# VGND.t402 VGND.t405 sg13_lv_nmos ad=0.1406p pd=1.12u as=0.1406p ps=1.12u w=0.74u l=0.13u
X2585 VGND.t1291 VPWR.t1610 VGND.t150 VGND.t1290 sg13_lv_nmos ad=0.1428p pd=1.52u as=0 ps=0 w=0.42u l=1u
X2586 a_12350_13728# sg13cmos5l_buf_16_27.X a_11898_13691# VPWR.t8 sg13_lv_pmos ad=0.1225p pd=1.245u as=0.34p ps=2.68u w=1u l=0.13u
X2587 a_3694_3898# sg13cmos5l_buf_16_8.A VPWR.t1228 VPWR.t28 sg13_lv_pmos ad=0.2128p pd=1.5u as=0.2128p ps=1.5u w=1.12u l=0.13u
X2588 VGND.t491 a_5710_1632# sg13cmos5l_buf_16_5.A VGND.t881 sg13_lv_nmos ad=0.1406p pd=1.12u as=0.1406p ps=1.12u w=0.74u l=0.13u
X2589 VGND.t350 sg13cmos5l_buf_16_19.A a_5204_11422# VGND.t156 sg13_lv_nmos ad=0.1406p pd=1.12u as=0.1406p ps=1.12u w=0.74u l=0.13u
X2590 VGND.t282 a_6094_4656# sg13cmos5l_buf_16_31.X VGND.t446 sg13_lv_nmos ad=0.1406p pd=1.12u as=0.1406p ps=1.12u w=0.74u l=0.13u
X2591 sg13cmos5l_buf_16_8.A a_3668_4620# VGND.t222 VGND.t457 sg13_lv_nmos ad=0.1406p pd=1.12u as=0.2516p ps=2.16u w=0.74u l=0.13u
X2592 VPWR.t631 sg13cmos5l_buf_1_17.A a_10292_12934# VPWR.t8 sg13_lv_pmos ad=0.2128p pd=1.5u as=0.2128p ps=1.5u w=1.12u l=0.13u
X2593 VPWR.t149 sg13cmos5l_buf_16_4.A a_9524_6886# VPWR.t5 sg13_lv_pmos ad=0.2128p pd=1.5u as=0.2128p ps=1.5u w=1.12u l=0.13u
X2594 VGND.t402 a_3694_7680# sg13cmos5l_buf_16_34.X VGND.t401 sg13_lv_nmos ad=0.1406p pd=1.12u as=0.1406p ps=1.12u w=0.74u l=0.13u
X2595 a_6836_9156# sg13cmos5l_and2_2_6.X VGND.t1 VGND.t259 sg13_lv_nmos ad=0.1406p pd=1.12u as=0.1406p ps=1.12u w=0.74u l=0.13u
X2596 VGND.t11 a_10318_8434# sg13cmos5l_buf_16_22.X VGND.t776 sg13_lv_nmos ad=0.1406p pd=1.12u as=0.1406p ps=1.12u w=0.74u l=0.13u
X2597 VPWR.t490 a_3668_3108# sg13cmos5l_buf_16_7.A VPWR.t20 sg13_lv_pmos ad=0.2128p pd=1.5u as=0.2128p ps=1.5u w=1.12u l=0.13u
X2598 sg13cmos5l_buf_16_23.X a_10292_12934# VGND.t315 VGND.t650 sg13_lv_nmos ad=0.1406p pd=1.12u as=0.1406p ps=1.12u w=0.74u l=0.13u
X2599 VGND.t1 a_6862_9946# sg13cmos5l_buf_16_24.X VGND.t256 sg13_lv_nmos ad=0.1406p pd=1.12u as=0.1406p ps=1.12u w=0.74u l=0.13u
X2600 sg13cmos5l_buf_16_34.A a_3694_8434# VGND.t275 VGND.t398 sg13_lv_nmos ad=0.1406p pd=1.12u as=0.1406p ps=1.12u w=0.74u l=0.13u
X2601 VGND.t112 a_8494_3144# sg13cmos5l_buf_16_39.A VGND.t40 sg13_lv_nmos ad=0.1406p pd=1.12u as=0.1406p ps=1.12u w=0.74u l=0.13u
X2602 VGND.t282 sg13cmos5l_buf_16_38.A a_7220_5374# VGND.t847 sg13_lv_nmos ad=0.1406p pd=1.12u as=0.1406p ps=1.12u w=0.74u l=0.13u
X2603 sg13cmos5l_buf_16_2.A a_9262_7680# VPWR.t136 VPWR.t5 sg13_lv_pmos ad=0.2128p pd=1.5u as=0.2128p ps=1.5u w=1.12u l=0.13u
X2604 a_6548_13692# sg13cmos5l_buf_16_37.X VGND.t693 VGND.t719 sg13_lv_nmos ad=0.1406p pd=1.12u as=0.1406p ps=1.12u w=0.74u l=0.13u
X2605 VPWR.t1270 a_4052_12934# sg13cmos5l_buf_16_15.A VPWR.t8 sg13_lv_pmos ad=0.2128p pd=1.5u as=0.2128p ps=1.5u w=1.12u l=0.13u
X2606 VGND.t1020 VPWR.t131 VGND.t1020 VGND.t156 sg13_lv_nmos ad=0.1428p pd=1.52u as=0 ps=0 w=0.42u l=1u
X2607 VPWR.t1173 VGND.t1004 VPWR.t340 VPWR.t55 sg13_lv_pmos ad=0.19p pd=1.38u as=0 ps=0 w=1u l=1u
X2608 sg13cmos5l_and2_2_6.A a_3694_10704# VPWR.t830 VPWR.t55 sg13_lv_pmos ad=0.2128p pd=1.5u as=0.2128p ps=1.5u w=1.12u l=0.13u
X2609 VGND.t11 VPWR.t1656 VGND.t11 VGND.t1115 sg13_lv_nmos ad=79.8f pd=0.8u as=0 ps=0 w=0.42u l=1u
X2610 VPWR.t78 VGND.t150 VPWR.t78 VPWR.t0 sg13_lv_pmos ad=0.19p pd=1.38u as=0 ps=0 w=1u l=1u
X2611 out_xor[1] a_14824_3144# VPWR.t34 VPWR.t20 sg13_lv_pmos ad=0.42p pd=2.99u as=0.2114p ps=1.54u w=1.12u l=0.13u
X2612 sg13cmos5l_buf_16_22.X a_10318_8434# VGND.t11 VGND.t773 sg13_lv_nmos ad=0.1406p pd=1.12u as=0.1406p ps=1.12u w=0.74u l=0.13u
X2613 VGND.t5 a_9262_7680# sg13cmos5l_buf_16_2.A VGND.t6 sg13_lv_nmos ad=0.1406p pd=1.12u as=0.1406p ps=1.12u w=0.74u l=0.13u
X2614 sg13cmos5l_buf_16_24.X a_6862_9946# VGND.t1 VGND.t109 sg13_lv_nmos ad=0.1406p pd=1.12u as=0.1406p ps=1.12u w=0.74u l=0.13u
X2615 sg13cmos5l_buf_16_39.A a_8494_3144# VGND.t92 VGND.t40 sg13_lv_nmos ad=0.1406p pd=1.12u as=0.1406p ps=1.12u w=0.74u l=0.13u
X2616 VPWR.t1019 VGND.t912 VPWR.t1021 VPWR.t292 sg13_lv_pmos ad=0.19p pd=1.38u as=0 ps=0 w=1u l=1u
X2617 VGND.t150 VPWR.t19 VGND.t150 VGND.t1328 sg13_lv_nmos ad=79.8f pd=0.8u as=0 ps=0 w=0.42u l=1u
X2618 VGND.t1364 VPWR.t77 VGND.t1363 VGND.t1362 sg13_lv_nmos ad=0.1428p pd=1.52u as=0 ps=0 w=0.42u l=1u
X2619 VGND.t41 a_3694_3898# sg13cmos5l_buf_16_10.A VGND.t40 sg13_lv_nmos ad=0.2516p pd=2.16u as=0.1406p ps=1.12u w=0.74u l=0.13u
X2620 VPWR.t66 VGND.t165 VPWR.t64 VPWR.t55 sg13_lv_pmos ad=0.19p pd=1.38u as=0 ps=0 w=1u l=1u
X2621 VPWR.t125 VGND.t1020 VPWR.t125 VPWR.t13 sg13_lv_pmos ad=0.19p pd=1.38u as=0 ps=0 w=1u l=1u
X2622 a_9262_7680# sg13cmos5l_buf_16_4.X VGND.t5 VGND.t67 sg13_lv_nmos ad=0.1406p pd=1.12u as=0.1406p ps=1.12u w=0.74u l=0.13u
X2623 a_5204_11422# sg13cmos5l_buf_16_19.A VPWR.t661 VPWR.t13 sg13_lv_pmos ad=0.2128p pd=1.5u as=0.2128p ps=1.5u w=1.12u l=0.13u
X2624 VPWR.t558 a_6862_9946# sg13cmos5l_buf_16_24.X VPWR.t55 sg13_lv_pmos ad=0.2128p pd=1.5u as=0.2128p ps=1.5u w=1.12u l=0.13u
X2625 VPWR.t996 VGND.t150 VPWR.t994 VPWR.t20 sg13_lv_pmos ad=0.19p pd=1.38u as=0 ps=0 w=1u l=1u
X2626 VGND.t573 VPWR.t304 VGND.t573 VGND.t995 sg13_lv_nmos ad=79.8f pd=0.8u as=0 ps=0 w=0.42u l=1u
X2627 VPWR.t1169 VGND.t1004 VPWR.t1168 VPWR.t13 sg13_lv_pmos ad=0.34p pd=2.68u as=0 ps=0 w=1u l=1u
X2628 VPWR.t1587 VGND.t897 VPWR.t1586 VPWR.t8 sg13_lv_pmos ad=0.34p pd=2.68u as=0 ps=0 w=1u l=1u
X2629 sg13cmos5l_buf_16_27.X a_6548_13692# VGND.t912 VGND.t1487 sg13_lv_nmos ad=0.1406p pd=1.12u as=0.1406p ps=1.12u w=0.74u l=0.13u
X2630 sg13cmos5l_buf_16_38.A a_8110_6168# VGND.t358 VGND.t548 sg13_lv_nmos ad=0.1406p pd=1.12u as=0.1406p ps=1.12u w=0.74u l=0.13u
X2631 VPWR.t1266 a_4052_12934# sg13cmos5l_buf_16_15.A VPWR.t8 sg13_lv_pmos ad=0.2128p pd=1.5u as=0.2128p ps=1.5u w=1.12u l=0.13u
X2632 sg13cmos5l_buf_16_10.A a_3694_3898# VGND.t207 VGND.t40 sg13_lv_nmos ad=0.1406p pd=1.12u as=0.1406p ps=1.12u w=0.74u l=0.13u
X2633 sg13cmos5l_buf_16_33.A a_3694_14482# VPWR.t1521 VPWR.t292 sg13_lv_pmos ad=0.2128p pd=1.5u as=0.2128p ps=1.5u w=1.12u l=0.13u
X2634 VPWR.t704 a_3694_8434# sg13cmos5l_buf_16_34.A VPWR.t3 sg13_lv_pmos ad=0.2128p pd=1.5u as=0.2128p ps=1.5u w=1.12u l=0.13u
X2635 sg13cmos5l_buf_16_22.X a_10318_8434# VPWR.t245 VPWR.t3 sg13_lv_pmos ad=0.2128p pd=1.5u as=0.2128p ps=1.5u w=1.12u l=0.13u
X2636 VPWR.t21 sg13cmos5l_buf_16_0.A a_8494_3144# VPWR.t20 sg13_lv_pmos ad=0.2128p pd=1.5u as=0.2128p ps=1.5u w=1.12u l=0.13u
X2637 sg13cmos5l_buf_16_5.X a_5108_838# VGND.t860 VGND.t1436 sg13_lv_nmos ad=0.1406p pd=1.12u as=0.1406p ps=1.12u w=0.74u l=0.13u
X2638 VGND.t358 sg13cmos5l_buf_16_28.X a_5518_6922# VGND.t359 sg13_lv_nmos ad=0.1406p pd=1.12u as=0.1406p ps=1.12u w=0.74u l=0.13u
X2639 VGND.t5 sg13cmos5l_buf_16_4.X a_9262_7680# VGND.t64 sg13_lv_nmos ad=0.1406p pd=1.12u as=0.1406p ps=1.12u w=0.74u l=0.13u
X2640 sg13cmos5l_buf_16_31.X a_6094_4656# VPWR.t755 VPWR.t28 sg13_lv_pmos ad=0.2128p pd=1.5u as=0.2128p ps=1.5u w=1.12u l=0.13u
X2641 sg13cmos5l_buf_16_28.X a_5684_6132# VPWR.t1377 VPWR.t70 sg13_lv_pmos ad=0.2128p pd=1.5u as=0.2128p ps=1.5u w=1.12u l=0.13u
X2642 sg13cmos5l_buf_16_15.X a_3668_12180# VPWR.t649 VPWR.t13 sg13_lv_pmos ad=0.2128p pd=1.5u as=0.2128p ps=1.5u w=1.12u l=0.13u
X2643 VGND.t72 a_10292_4620# sg13cmos5l_buf_16_3.X VGND.t77 sg13_lv_nmos ad=0.1406p pd=1.12u as=0.1406p ps=1.12u w=0.74u l=0.13u
X2644 VGND.t871 a_2147_13692# sg13cmos5l_and2_2_1.X VGND.t1470 sg13_lv_nmos ad=0.1331p pd=1.12u as=0.1406p ps=1.12u w=0.74u l=0.13u
X2645 VGND.t573 VPWR.t297 VGND.t573 VGND.t969 sg13_lv_nmos ad=79.8f pd=0.8u as=0 ps=0 w=0.42u l=1u
X2646 sg13cmos5l_xor2_1_7.X sg13cmos5l_and2_2_3.X a_14010_11470# VGND.t156 sg13_lv_nmos ad=0.1628p pd=1.18u as=88.8f ps=0.98u w=0.74u l=0.13u
X2647 a_3694_8434# sg13cmos5l_buf_16_13.A VPWR.t1130 VPWR.t3 sg13_lv_pmos ad=0.2128p pd=1.5u as=0.2128p ps=1.5u w=1.12u l=0.13u
X2648 VPWR.t245 a_10318_8434# sg13cmos5l_buf_16_22.X VPWR.t3 sg13_lv_pmos ad=0.2128p pd=1.5u as=0.2128p ps=1.5u w=1.12u l=0.13u
X2649 VPWR.t554 a_6862_9946# sg13cmos5l_buf_16_24.X VPWR.t55 sg13_lv_pmos ad=0.2128p pd=1.5u as=0.2128p ps=1.5u w=1.12u l=0.13u
X2650 sg13cmos5l_buf_16_27.X a_6548_13692# VGND.t912 VGND.t1483 sg13_lv_nmos ad=0.1406p pd=1.12u as=0.2516p ps=2.16u w=0.74u l=0.13u
X2651 sg13cmos5l_buf_16_14.A a_4436_9910# VGND.t165 VGND.t167 sg13_lv_nmos ad=0.1406p pd=1.12u as=0.1406p ps=1.12u w=0.74u l=0.13u
X2652 VPWR.t6 a_5710_1632# sg13cmos5l_buf_16_5.A VPWR.t0 sg13_lv_pmos ad=0.2128p pd=1.5u as=0.2128p ps=1.5u w=1.12u l=0.13u
X2653 out_xor[1] a_14824_3144# VGND.t244 VGND.t40 sg13_lv_nmos ad=0.2886p pd=2.26u as=0.14875p ps=1.16u w=0.74u l=0.13u
X2654 a_10318_3898# sg13cmos5l_buf_16_2.A VPWR.t202 VPWR.t28 sg13_lv_pmos ad=0.2128p pd=1.5u as=0.2128p ps=1.5u w=1.12u l=0.13u
X2655 VPWR.t1006 VGND.t150 VPWR.t1005 VPWR.t20 sg13_lv_pmos ad=0.34p pd=2.68u as=0 ps=0 w=1u l=1u
X2656 VPWR.t10 VGND.t958 VPWR.t9 VPWR.t8 sg13_lv_pmos ad=0.19p pd=1.38u as=0 ps=0 w=1u l=1u
X2657 sg13cmos5l_buf_16_10.A a_3694_3898# VGND.t207 VGND.t40 sg13_lv_nmos ad=0.1406p pd=1.12u as=0.1406p ps=1.12u w=0.74u l=0.13u
X2658 VGND.t315 sg13cmos5l_buf_16_37.A a_7796_12934# VGND.t320 sg13_lv_nmos ad=0.2516p pd=2.16u as=0.1406p ps=1.12u w=0.74u l=0.13u
X2659 VGND.t1 a_6836_9156# sg13cmos5l_buf_16_25.A VGND.t108 sg13_lv_nmos ad=0.1406p pd=1.12u as=0.1406p ps=1.12u w=0.74u l=0.13u
X2660 VGND.t130 VPWR.t382 VGND.t130 VGND.t40 sg13_lv_nmos ad=0.1428p pd=1.52u as=0 ps=0 w=0.42u l=1u
X2661 VGND.t350 a_6094_10704# sg13cmos5l_buf_16_24.A VGND.t156 sg13_lv_nmos ad=0.1406p pd=1.12u as=0.1406p ps=1.12u w=0.74u l=0.13u
X2662 sg13cmos5l_buf_16_5.A a_5710_1632# VPWR.t19 VPWR.t0 sg13_lv_pmos ad=0.2128p pd=1.5u as=0.2128p ps=1.5u w=1.12u l=0.13u
X2663 sg13cmos5l_buf_16_31.X a_6094_4656# VPWR.t751 VPWR.t28 sg13_lv_pmos ad=0.2128p pd=1.5u as=0.2128p ps=1.5u w=1.12u l=0.13u
X2664 VPWR.t381 VGND.t130 VPWR.t381 VPWR.t28 sg13_lv_pmos ad=0.34p pd=2.68u as=0 ps=0 w=1u l=1u
X2665 VPWR.t19 VGND.t150 VPWR.t19 VPWR.t0 sg13_lv_pmos ad=0.19p pd=1.38u as=0 ps=0 w=1u l=1u
X2666 VGND.t72 a_10292_4620# sg13cmos5l_buf_16_3.X VGND.t73 sg13_lv_nmos ad=0.1406p pd=1.12u as=0.1406p ps=1.12u w=0.74u l=0.13u
X2667 VGND.t806 VPWR.t319 VGND.t1173 VGND.t1199 sg13_lv_nmos ad=79.8f pd=0.8u as=0 ps=0 w=0.42u l=1u
X2668 VPWR.t189 VGND.t261 VPWR.t189 VPWR.t3 sg13_lv_pmos ad=0.19p pd=1.38u as=0 ps=0 w=1u l=1u
X2669 VPWR.t727 a_3875_5396# sg13cmos5l_and2_2_0.X VPWR.t70 sg13_lv_pmos ad=0.1918p pd=1.5u as=0.2128p ps=1.5u w=1.12u l=0.13u
X2670 VGND.t41 sg13cmos5l_buf_16_10.A a_3668_3108# VGND.t40 sg13_lv_nmos ad=0.2516p pd=2.16u as=0.1406p ps=1.12u w=0.74u l=0.13u
X2671 VPWR.t386 VGND.t693 VPWR.t292 VPWR.t292 sg13_lv_pmos ad=0.19p pd=1.38u as=0 ps=0 w=1u l=1u
X2672 sg13cmos5l_buf_16_25.A a_6836_9156# VPWR.t237 VPWR.t3 sg13_lv_pmos ad=0.2128p pd=1.5u as=0.2128p ps=1.5u w=1.12u l=0.13u
X2673 VPWR.t5 VGND.t1129 VPWR.t5 VPWR.t5 sg13_lv_pmos ad=0.19p pd=1.38u as=0 ps=0 w=1u l=1u
X2674 VPWR.t1462 a_4174_13728# sg13cmos5l_buf_16_18.A VPWR.t8 sg13_lv_pmos ad=0.2128p pd=1.5u as=0.2128p ps=1.5u w=1.12u l=0.13u
X2675 a_10318_3898# sg13cmos5l_buf_16_2.A VPWR.t202 VPWR.t28 sg13_lv_pmos ad=0.2128p pd=1.5u as=0.3808p ps=2.92u w=1.12u l=0.13u
X2676 VGND.t358 a_5684_6132# sg13cmos5l_buf_16_28.X VGND.t830 sg13_lv_nmos ad=0.1406p pd=1.12u as=0.1406p ps=1.12u w=0.74u l=0.13u
X2677 VPWR.t297 sg13cmos5l_and2_2_3.X a_13667_12956# VPWR.t8 sg13_lv_pmos ad=0.2856p pd=2.36u as=0.1596p ps=1.22u w=0.84u l=0.13u
X2678 VPWR.t4 sg13cmos5l_buf_1_14.X a_14824_9192# VPWR.t3 sg13_lv_pmos ad=0.2114p pd=1.54u as=0.2856p ps=2.36u w=0.84u l=0.13u
X2679 VGND.t350 sg13cmos5l_buf_16_33.A a_6094_10704# VGND.t156 sg13_lv_nmos ad=0.1406p pd=1.12u as=0.1406p ps=1.12u w=0.74u l=0.13u
X2680 VPWR.t219 sg13cmos5l_buf_16_0.A a_8494_3144# VPWR.t20 sg13_lv_pmos ad=0.2128p pd=1.5u as=0.2128p ps=1.5u w=1.12u l=0.13u
X2681 VPWR.t409 VGND.t358 VPWR.t407 VPWR.t5 sg13_lv_pmos ad=0.19p pd=1.38u as=0 ps=0 w=1u l=1u
X2682 VGND.t169 a_3668_9156# sg13cmos5l_buf_16_13.A VGND.t195 sg13_lv_nmos ad=0.1406p pd=1.12u as=0.1406p ps=1.12u w=0.74u l=0.13u
X2683 a_3668_3108# sg13cmos5l_buf_16_10.A VGND.t207 VGND.t40 sg13_lv_nmos ad=0.1406p pd=1.12u as=0.1406p ps=1.12u w=0.74u l=0.13u
X2684 VGND.t358 a_8110_6168# sg13cmos5l_buf_16_38.A VGND.t541 sg13_lv_nmos ad=0.1406p pd=1.12u as=0.1406p ps=1.12u w=0.74u l=0.13u
X2685 sg13cmos5l_buf_16_30.A a_6164_2350# VGND.t491 VGND.t497 sg13_lv_nmos ad=0.1406p pd=1.12u as=0.1406p ps=1.12u w=0.74u l=0.13u
X2686 VPWR.t284 VGND.t150 VPWR.t284 VPWR.t0 sg13_lv_pmos ad=0.19p pd=1.38u as=0 ps=0 w=1u l=1u
X2687 sg13cmos5l_buf_16_28.X a_5684_6132# VGND.t358 VGND.t827 sg13_lv_nmos ad=0.1406p pd=1.12u as=0.2516p ps=2.16u w=0.74u l=0.13u
X2688 VPWR.t1108 VGND.t11 VPWR.t1106 VPWR.t5 sg13_lv_pmos ad=0.19p pd=1.38u as=0 ps=0 w=1u l=1u
X2689 a_13745_8484# sg13cmos5l_buf_16_2.A VGND.t114 VGND.t113 sg13_lv_nmos ad=0.17462p pd=1.185u as=0.374p ps=2.46u w=0.55u l=0.13u
X2690 VPWR.t4 sg13cmos5l_buf_16_2.A a_13916_8728# VPWR.t3 sg13_lv_pmos ad=0.2128p pd=1.5u as=0.3808p ps=2.92u w=1.12u l=0.13u
X2691 sg13cmos5l_buf_16_15.X a_3668_12180# VGND.t332 VGND.t334 sg13_lv_nmos ad=0.1406p pd=1.12u as=0.1406p ps=1.12u w=0.74u l=0.13u
X2692 sg13cmos5l_buf_16_15.X a_3668_12180# VGND.t345 VGND.t348 sg13_lv_nmos ad=0.1406p pd=1.12u as=0.1406p ps=1.12u w=0.74u l=0.13u
X2693 VPWR.t190 a_10318_8434# sg13cmos5l_buf_16_22.X VPWR.t3 sg13_lv_pmos ad=0.2128p pd=1.5u as=0.2128p ps=1.5u w=1.12u l=0.13u
X2694 VPWR.t88 VGND.t413 VPWR.t87 VPWR.t5 sg13_lv_pmos ad=0.34p pd=2.68u as=0 ps=0 w=1u l=1u
X2695 sg13cmos5l_buf_16_33.A a_3694_14482# VGND.t942 VGND.t1510 sg13_lv_nmos ad=0.1406p pd=1.12u as=0.1406p ps=1.12u w=0.74u l=0.13u
X2696 sg13cmos5l_buf_1_17.A a_13667_12956# VGND.t573 VGND.t738 sg13_lv_nmos ad=0.1406p pd=1.12u as=0.2812p ps=2.24u w=0.74u l=0.13u
X2697 VGND.t999 VPWR.t1671 VGND.t999 VGND.t156 sg13_lv_nmos ad=0.1428p pd=1.52u as=0 ps=0 w=0.42u l=1u
X2698 VPWR.t788 a_3694_2386# sg13cmos5l_buf_16_7.X VPWR.t20 sg13_lv_pmos ad=0.2128p pd=1.5u as=0.2128p ps=1.5u w=1.12u l=0.13u
X2699 out_xor[7] a_14824_14516# VPWR.t1475 VPWR.t292 sg13_lv_pmos ad=0.42p pd=2.99u as=0.2114p ps=1.54u w=1.12u l=0.13u
X2700 sg13cmos5l_buf_16_37.X a_7796_12934# VPWR.t928 VPWR.t8 sg13_lv_pmos ad=0.2128p pd=1.5u as=0.2128p ps=1.5u w=1.12u l=0.13u
X2701 VGND.t1079 VPWR.t245 VGND.t1079 VGND.t1080 sg13_lv_nmos ad=0.1428p pd=1.52u as=0 ps=0 w=0.42u l=1u
X2702 sg13cmos5l_buf_16_13.A a_3668_9156# VGND.t165 VGND.t192 sg13_lv_nmos ad=0.1406p pd=1.12u as=0.1406p ps=1.12u w=0.74u l=0.13u
X2703 a_13713_8752# sg13cmos5l_buf_16_2.A VPWR.t245 VPWR.t3 sg13_lv_pmos ad=0.1225p pd=1.245u as=0.36p ps=2.72u w=1u l=0.13u
X2704 VGND.t165 VPWR.t1662 VGND.t165 VGND.t1070 sg13_lv_nmos ad=79.8f pd=0.8u as=0 ps=0 w=0.42u l=1u
X2705 VPWR.t382 VGND.t130 VPWR.t28 VPWR.t28 sg13_lv_pmos ad=0.34p pd=2.68u as=0 ps=0 w=1u l=1u
X2706 sg13cmos5l_buf_16_8.A a_3668_4620# VPWR.t761 VPWR.t28 sg13_lv_pmos ad=0.2128p pd=1.5u as=0.2128p ps=1.5u w=1.12u l=0.13u
X2707 VGND.t652 VPWR.t130 VGND.t652 VGND.t990 sg13_lv_nmos ad=0.1428p pd=1.52u as=0 ps=0 w=0.42u l=1u
X2708 VPWR.t519 sg13cmos5l_buf_16_20.A a_4436_9910# VPWR.t55 sg13_lv_pmos ad=0.2128p pd=1.5u as=0.2128p ps=1.5u w=1.12u l=0.13u
X2709 VPWR.t1327 a_3694_7680# sg13cmos5l_buf_16_34.X VPWR.t5 sg13_lv_pmos ad=0.2128p pd=1.5u as=0.2128p ps=1.5u w=1.12u l=0.13u
X2710 VGND.t584 VPWR.t1025 VGND.t584 VGND.t1330 sg13_lv_nmos ad=79.8f pd=0.8u as=0 ps=0 w=0.42u l=1u
X2711 VGND.t130 a_10318_3898# sg13cmos5l_buf_16_2.X VGND.t40 sg13_lv_nmos ad=0.1406p pd=1.12u as=0.1406p ps=1.12u w=0.74u l=0.13u
X2712 VGND.t1060 VPWR.t1661 VGND.t1060 VGND.t1059 sg13_lv_nmos ad=0.1428p pd=1.52u as=0 ps=0 w=0.42u l=1u
X2713 sg13cmos5l_buf_16_34.A a_3694_8434# VGND.t413 VGND.t414 sg13_lv_nmos ad=0.1406p pd=1.12u as=0.1406p ps=1.12u w=0.74u l=0.13u
X2714 VGND.t41 a_6094_3898# sg13cmos5l_buf_16_0.A VGND.t40 sg13_lv_nmos ad=0.1406p pd=1.12u as=0.1406p ps=1.12u w=0.74u l=0.13u
X2715 VGND.t358 VPWR.t70 VGND.t358 VGND.t1193 sg13_lv_nmos ad=79.8f pd=0.8u as=0 ps=0 w=0.42u l=1u
X2716 a_6332_12216# sg13cmos5l_buf_16_24.X VPWR.t817 VPWR.t13 sg13_lv_pmos ad=0.2128p pd=1.5u as=0.2128p ps=1.5u w=1.12u l=0.13u
X2717 VGND.t384 a_3694_10704# sg13cmos5l_and2_2_6.A VGND.t156 sg13_lv_nmos ad=0.1406p pd=1.12u as=0.1406p ps=1.12u w=0.74u l=0.13u
X2718 sg13cmos5l_buf_16_7.A a_3668_3108# VGND.t207 VGND.t40 sg13_lv_nmos ad=0.1406p pd=1.12u as=0.1406p ps=1.12u w=0.74u l=0.13u
X2719 VGND.t1029 VPWR.t133 VGND.t1029 VGND.t156 sg13_lv_nmos ad=79.8f pd=0.8u as=0 ps=0 w=0.42u l=1u
X2720 sg13cmos5l_buf_16_34.X a_3694_7680# VPWR.t1323 VPWR.t5 sg13_lv_pmos ad=0.2128p pd=1.5u as=0.2128p ps=1.5u w=1.12u l=0.13u
X2721 VGND.t413 sg13cmos5l_buf_16_25.A a_6766_8434# VGND.t576 sg13_lv_nmos ad=0.1406p pd=1.12u as=0.1406p ps=1.12u w=0.74u l=0.13u
X2722 VPWR.t70 VGND.t72 VPWR.t70 VPWR.t70 sg13_lv_pmos ad=0.19p pd=1.38u as=0 ps=0 w=1u l=1u
X2723 sg13cmos5l_buf_16_37.X a_7796_12934# VPWR.t924 VPWR.t8 sg13_lv_pmos ad=0.2128p pd=1.5u as=0.2128p ps=1.5u w=1.12u l=0.13u
X2724 VPWR.t56 VGND.t157 VPWR.t56 VPWR.t55 sg13_lv_pmos ad=0.34p pd=2.68u as=0 ps=0 w=1u l=1u
X2725 VPWR.t342 VGND.t11 VPWR.t342 VPWR.t5 sg13_lv_pmos ad=0.19p pd=1.38u as=0 ps=0 w=1u l=1u
X2726 VGND.t315 sg13cmos5l_buf_16_15.A a_3668_12180# VGND.t515 sg13_lv_nmos ad=0.2516p pd=2.16u as=0.1406p ps=1.12u w=0.74u l=0.13u
X2727 VGND.t397 sg13cmos5l_buf_1_14.X a_14824_9192# VGND.t396 sg13_lv_nmos ad=0.14875p pd=1.16u as=0.187p ps=1.78u w=0.55u l=0.13u
X2728 VPWR.t837 sg13cmos5l_buf_16_35.A a_8110_6168# VPWR.t70 sg13_lv_pmos ad=0.2128p pd=1.5u as=0.2128p ps=1.5u w=1.12u l=0.13u
X2729 VGND.t315 sg13cmos5l_buf_16_18.A a_4052_12934# VGND.t1536 sg13_lv_nmos ad=0.1406p pd=1.12u as=0.1406p ps=1.12u w=0.74u l=0.13u
X2730 VPWR.t460 a_4436_9910# sg13cmos5l_buf_16_14.A VPWR.t55 sg13_lv_pmos ad=0.2128p pd=1.5u as=0.2128p ps=1.5u w=1.12u l=0.13u
X2731 VGND.t315 VPWR.t1691 VGND.t315 VGND.t955 sg13_lv_nmos ad=79.8f pd=0.8u as=0 ps=0 w=0.42u l=1u
X2732 VPWR.t426 VGND.t358 VPWR.t424 VPWR.t5 sg13_lv_pmos ad=0.19p pd=1.38u as=0 ps=0 w=1u l=1u
X2733 VGND.t130 VPWR.t281 VGND.t130 VGND.t40 sg13_lv_nmos ad=79.8f pd=0.8u as=0 ps=0 w=0.42u l=1u
X2734 VGND.t358 VPWR.t1638 VGND.t358 VGND.t1167 sg13_lv_nmos ad=79.8f pd=0.8u as=0 ps=0 w=0.42u l=1u
X2735 VPWR.t5 sg13cmos5l_buf_1_23.A a_13768_7680# VPWR.t5 sg13_lv_pmos ad=0.2114p pd=1.54u as=0.2856p ps=2.36u w=0.84u l=0.13u
X2736 VPWR.t598 sg13cmos5l_buf_16_34.A a_3694_7680# VPWR.t5 sg13_lv_pmos ad=0.2128p pd=1.5u as=0.2128p ps=1.5u w=1.12u l=0.13u
X2737 VPWR.t118 VGND.t377 VPWR.t118 VPWR.t13 sg13_lv_pmos ad=0.19p pd=1.38u as=0 ps=0 w=1u l=1u
X2738 sg13cmos5l_xor2_1_0.B a_6094_3144# VPWR.t181 VPWR.t20 sg13_lv_pmos ad=0.2128p pd=1.5u as=0.2128p ps=1.5u w=1.12u l=0.13u
X2739 VGND.t358 a_4721_6526# sg13cmos5l_buf_1_6.A VGND.t364 sg13_lv_nmos ad=0.3108p pd=2.32u as=0.1628p ps=1.18u w=0.74u l=0.13u
X2740 VGND.t72 sg13cmos5l_buf_16_3.X a_10318_5410# VGND.t77 sg13_lv_nmos ad=0.1406p pd=1.12u as=0.1406p ps=1.12u w=0.74u l=0.13u
X2741 VGND.t315 VPWR.t1685 VGND.t315 VGND.t953 sg13_lv_nmos ad=79.8f pd=0.8u as=0 ps=0 w=0.42u l=1u
X2742 VGND.t573 VPWR.t304 VGND.t573 VGND.t997 sg13_lv_nmos ad=79.8f pd=0.8u as=0 ps=0 w=0.42u l=1u
X2743 a_8110_6168# sg13cmos5l_buf_16_35.A VPWR.t1547 VPWR.t70 sg13_lv_pmos ad=0.2128p pd=1.5u as=0.2128p ps=1.5u w=1.12u l=0.13u
X2744 sg13cmos5l_buf_16_4.X a_9524_6886# VPWR.t136 VPWR.t5 sg13_lv_pmos ad=0.2128p pd=1.5u as=0.2128p ps=1.5u w=1.12u l=0.13u
X2745 VGND.t384 a_3694_10704# sg13cmos5l_and2_2_6.A VGND.t156 sg13_lv_nmos ad=0.1406p pd=1.12u as=0.1406p ps=1.12u w=0.74u l=0.13u
X2746 VPWR.t818 sg13cmos5l_and2_2_2.B a_6765_12564# VPWR.t13 sg13_lv_pmos ad=0.1918p pd=1.5u as=0.1596p ps=1.22u w=0.84u l=0.13u
X2747 VPWR.t1065 VGND.t377 VPWR.t1063 VPWR.t55 sg13_lv_pmos ad=0.19p pd=1.38u as=0 ps=0 w=1u l=1u
X2748 VPWR.t231 a_6836_9156# sg13cmos5l_buf_16_25.A VPWR.t3 sg13_lv_pmos ad=0.2128p pd=1.5u as=0.2128p ps=1.5u w=1.12u l=0.13u
X2749 VPWR.t452 VGND.t244 VPWR.t451 VPWR.t20 sg13_lv_pmos ad=0.34p pd=2.68u as=0 ps=0 w=1u l=1u
X2750 a_6548_13692# sg13cmos5l_buf_16_37.X VPWR.t1259 VPWR.t8 sg13_lv_pmos ad=0.2128p pd=1.5u as=0.2128p ps=1.5u w=1.12u l=0.13u
X2751 VPWR.t136 sg13cmos5l_buf_16_4.X a_9262_7680# VPWR.t5 sg13_lv_pmos ad=0.2128p pd=1.5u as=0.2128p ps=1.5u w=1.12u l=0.13u
X2752 VGND.t315 a_4052_12934# sg13cmos5l_buf_16_15.A VGND.t737 sg13_lv_nmos ad=0.1406p pd=1.12u as=0.1406p ps=1.12u w=0.74u l=0.13u
X2753 VGND.t345 sg13cmos5l_buf_16_15.A a_3668_12180# VGND.t511 sg13_lv_nmos ad=0.1406p pd=1.12u as=0.1406p ps=1.12u w=0.74u l=0.13u
X2754 sg13cmos5l_buf_1_1.A a_13768_3932# VGND.t130 VGND.t40 sg13_lv_nmos ad=0.2886p pd=2.26u as=0.14875p ps=1.16u w=0.74u l=0.13u
X2755 sg13cmos5l_buf_16_13.A a_3668_9156# VGND.t165 VGND.t188 sg13_lv_nmos ad=0.1406p pd=1.12u as=0.1406p ps=1.12u w=0.74u l=0.13u
X2756 a_6766_8434# sg13cmos5l_buf_16_25.A VPWR.t874 VPWR.t3 sg13_lv_pmos ad=0.2128p pd=1.5u as=0.2128p ps=1.5u w=1.12u l=0.13u
X2757 VGND.t282 a_6094_4656# sg13cmos5l_buf_16_31.X VGND.t456 sg13_lv_nmos ad=0.2516p pd=2.16u as=0.1406p ps=1.12u w=0.74u l=0.13u
X2758 sg13cmos5l_buf_1_22.X a_14344_11492# VGND.t157 VGND.t156 sg13_lv_nmos ad=0.2886p pd=2.26u as=0.14875p ps=1.16u w=0.74u l=0.13u
X2759 sg13cmos5l_buf_16_8.A a_3668_4620# VGND.t23 VGND.t469 sg13_lv_nmos ad=0.1406p pd=1.12u as=0.1406p ps=1.12u w=0.74u l=0.13u
X2760 VGND.t413 a_3694_7680# sg13cmos5l_buf_16_34.X VGND.t412 sg13_lv_nmos ad=0.1406p pd=1.12u as=0.1406p ps=1.12u w=0.74u l=0.13u
X2761 sg13cmos5l_buf_16_34.A a_3694_8434# VGND.t402 VGND.t409 sg13_lv_nmos ad=0.1406p pd=1.12u as=0.1406p ps=1.12u w=0.74u l=0.13u
X2762 VGND.t150 VPWR.t1611 VGND.t150 VGND.t1288 sg13_lv_nmos ad=0.1428p pd=1.52u as=0 ps=0 w=0.42u l=1u
X2763 a_9262_7680# sg13cmos5l_buf_16_4.X VPWR.t195 VPWR.t5 sg13_lv_pmos ad=0.2128p pd=1.5u as=0.3808p ps=2.92u w=1.12u l=0.13u
X2764 VGND.t384 sg13cmos5l_buf_16_34.X a_3694_10704# VGND.t156 sg13_lv_nmos ad=0.1406p pd=1.12u as=0.1406p ps=1.12u w=0.74u l=0.13u
X2765 VPWR.t998 VGND.t150 VPWR.t997 VPWR.t20 sg13_lv_pmos ad=0.34p pd=2.68u as=0 ps=0 w=1u l=1u
X2766 VGND.t130 VPWR.t30 VGND.t130 VGND.t40 sg13_lv_nmos ad=0.1428p pd=1.52u as=0 ps=0 w=0.42u l=1u
X2767 VPWR.t353 VGND.t1060 VPWR.t352 VPWR.t55 sg13_lv_pmos ad=0.34p pd=2.68u as=0 ps=0 w=1u l=1u
X2768 VGND.t693 VPWR.t292 VGND.t693 VGND.t920 sg13_lv_nmos ad=0.1428p pd=1.52u as=0 ps=0 w=0.42u l=1u
X2769 VGND.t693 sg13cmos5l_buf_16_37.X a_6548_13692# VGND.t720 sg13_lv_nmos ad=0.2516p pd=2.16u as=0.1406p ps=1.12u w=0.74u l=0.13u
X2770 sg13cmos5l_buf_16_27.X a_6548_13692# VPWR.t1490 VPWR.t8 sg13_lv_pmos ad=0.2128p pd=1.5u as=0.2128p ps=1.5u w=1.12u l=0.13u
X2771 VPWR.t886 a_3694_3898# sg13cmos5l_buf_16_10.A VPWR.t28 sg13_lv_pmos ad=0.2128p pd=1.5u as=0.2128p ps=1.5u w=1.12u l=0.13u
X2772 VPWR.t297 VGND.t934 VPWR.t297 VPWR.t8 sg13_lv_pmos ad=0.19p pd=1.38u as=0 ps=0 w=1u l=1u
X2773 VPWR.t297 VGND.t573 VPWR.t129 VPWR.t8 sg13_lv_pmos ad=0.19p pd=1.38u as=0 ps=0 w=1u l=1u
X2774 sg13cmos5l_buf_16_3.X a_10292_4620# VPWR.t202 VPWR.t28 sg13_lv_pmos ad=0.2128p pd=1.5u as=0.2128p ps=1.5u w=1.12u l=0.13u
X2775 VGND.t72 sg13cmos5l_buf_16_3.X a_10318_5410# VGND.t73 sg13_lv_nmos ad=0.1406p pd=1.12u as=0.1406p ps=1.12u w=0.74u l=0.13u
X2776 a_4052_12934# sg13cmos5l_buf_16_18.A VPWR.t1538 VPWR.t8 sg13_lv_pmos ad=0.2128p pd=1.5u as=0.2128p ps=1.5u w=1.12u l=0.13u
X2777 VPWR.t661 sg13cmos5l_buf_16_19.A a_5204_11422# VPWR.t13 sg13_lv_pmos ad=0.2128p pd=1.5u as=0.2128p ps=1.5u w=1.12u l=0.13u
X2778 VGND.t157 sg13cmos5l_buf_1_11.X a_14824_10704# VGND.t156 sg13_lv_nmos ad=0.14875p pd=1.16u as=0.187p ps=1.78u w=0.55u l=0.13u
X2779 VGND.t222 a_3668_4620# sg13cmos5l_buf_16_8.A VGND.t466 sg13_lv_nmos ad=0.1406p pd=1.12u as=0.1406p ps=1.12u w=0.74u l=0.13u
X2780 sg13cmos5l_and2_2_6.X a_7629_8028# VGND.t800 VGND.t799 sg13_lv_nmos ad=0.1406p pd=1.12u as=0.1331p ps=1.12u w=0.74u l=0.13u
X2781 VPWR.t476 a_3668_9156# sg13cmos5l_buf_16_13.A VPWR.t3 sg13_lv_pmos ad=0.2128p pd=1.5u as=0.2128p ps=1.5u w=1.12u l=0.13u
X2782 VGND.t1308 VPWR.t288 VGND.t1308 VGND.t1309 sg13_lv_nmos ad=79.8f pd=0.8u as=0 ps=0 w=0.42u l=1u
X2783 sg13cmos5l_buf_16_1.X a_10318_5410# VPWR.t70 VPWR.t70 sg13_lv_pmos ad=0.2128p pd=1.5u as=0.2128p ps=1.5u w=1.12u l=0.13u
X2784 VGND.t345 a_4052_12934# sg13cmos5l_buf_16_15.A VGND.t733 sg13_lv_nmos ad=0.1406p pd=1.12u as=0.1406p ps=1.12u w=0.74u l=0.13u
X2785 VGND.t41 a_6094_3144# sg13cmos5l_xor2_1_0.B VGND.t40 sg13_lv_nmos ad=0.1406p pd=1.12u as=0.1406p ps=1.12u w=0.74u l=0.13u
X2786 VGND.t1 a_4436_9910# sg13cmos5l_buf_16_14.A VGND.t181 sg13_lv_nmos ad=0.1406p pd=1.12u as=0.1406p ps=1.12u w=0.74u l=0.13u
X2787 sg13cmos5l_buf_16_20.A a_5204_11422# VGND.t350 VGND.t156 sg13_lv_nmos ad=0.1406p pd=1.12u as=0.1406p ps=1.12u w=0.74u l=0.13u
X2788 a_6094_3898# enable VGND.t41 VGND.t40 sg13_lv_nmos ad=0.1406p pd=1.12u as=0.1406p ps=1.12u w=0.74u l=0.13u
X2789 sg13cmos5l_buf_16_10.A a_3694_3898# VPWR.t882 VPWR.t28 sg13_lv_pmos ad=0.2128p pd=1.5u as=0.2128p ps=1.5u w=1.12u l=0.13u
X2790 VGND.t358 VPWR.t400 VGND.t806 VGND.t1195 sg13_lv_nmos ad=79.8f pd=0.8u as=0 ps=0 w=0.42u l=1u
X2791 VGND.t912 VPWR.t1699 VGND.t912 VGND.t913 sg13_lv_nmos ad=79.8f pd=0.8u as=0 ps=0 w=0.42u l=1u
X2792 sg13cmos5l_buf_16_13.A a_3668_9156# VPWR.t473 VPWR.t3 sg13_lv_pmos ad=0.2128p pd=1.5u as=0.3976p ps=2.95u w=1.12u l=0.13u
X2793 sg13cmos5l_buf_16_6.X a_5518_6922# VGND.t358 VGND.t674 sg13_lv_nmos ad=0.1406p pd=1.12u as=0.1406p ps=1.12u w=0.74u l=0.13u
X2794 VGND.t402 a_3694_7680# sg13cmos5l_buf_16_34.X VGND.t408 sg13_lv_nmos ad=0.1406p pd=1.12u as=0.1406p ps=1.12u w=0.74u l=0.13u
X2795 VPWR.t315 VGND.t1127 VPWR.t315 VPWR.t5 sg13_lv_pmos ad=0.19p pd=1.38u as=0 ps=0 w=1u l=1u
X2796 VGND.t693 sg13cmos5l_buf_16_37.X a_6548_13692# VGND.t716 sg13_lv_nmos ad=0.1406p pd=1.12u as=0.1406p ps=1.12u w=0.74u l=0.13u
X2797 sg13cmos5l_buf_16_27.X a_6548_13692# VPWR.t1487 VPWR.t8 sg13_lv_pmos ad=0.2128p pd=1.5u as=0.3976p ps=2.95u w=1.12u l=0.13u
X2798 VGND.t11 a_10318_8434# sg13cmos5l_buf_16_22.X VGND.t782 sg13_lv_nmos ad=0.2516p pd=2.16u as=0.1406p ps=1.12u w=0.74u l=0.13u
X2799 VPWR.t496 a_3668_3108# sg13cmos5l_buf_16_7.A VPWR.t20 sg13_lv_pmos ad=0.2128p pd=1.5u as=0.2128p ps=1.5u w=1.12u l=0.13u
X2800 VPWR.t292 VGND.t693 VPWR.t292 VPWR.t292 sg13_lv_pmos ad=0.19p pd=1.38u as=0 ps=0 w=1u l=1u
X2801 sg13cmos5l_buf_16_15.A a_4052_12934# VPWR.t1266 VPWR.t8 sg13_lv_pmos ad=0.2128p pd=1.5u as=0.2128p ps=1.5u w=1.12u l=0.13u
X2802 VPWR.t881 sg13cmos5l_buf_16_8.A a_3694_3898# VPWR.t28 sg13_lv_pmos ad=0.2128p pd=1.5u as=0.2128p ps=1.5u w=1.12u l=0.13u
X2803 VGND.t1178 VPWR.t5 VGND.t70 VGND.t1180 sg13_lv_nmos ad=79.8f pd=0.8u as=0 ps=0 w=0.42u l=1u
X2804 VGND.t1060 VPWR.t1664 VGND.t1060 VGND.t1065 sg13_lv_nmos ad=79.8f pd=0.8u as=0 ps=0 w=0.42u l=1u
X2805 VGND.t860 a_5108_838# sg13cmos5l_buf_16_5.X VGND.t1437 sg13_lv_nmos ad=0.1406p pd=1.12u as=0.1406p ps=1.12u w=0.74u l=0.13u
X2806 VPWR.t714 a_3694_8434# sg13cmos5l_buf_16_34.A VPWR.t3 sg13_lv_pmos ad=0.2128p pd=1.5u as=0.2128p ps=1.5u w=1.12u l=0.13u
X2807 VGND.t11 VPWR.t1650 VGND.t11 VGND.t1117 sg13_lv_nmos ad=79.8f pd=0.8u as=0 ps=0 w=0.42u l=1u
X2808 VPWR.t24 VGND.t1395 VPWR.t24 VPWR.t0 sg13_lv_pmos ad=0.19p pd=1.38u as=0 ps=0 w=1u l=1u
X2809 sg13cmos5l_buf_16_3.X a_10292_4620# VPWR.t202 VPWR.t28 sg13_lv_pmos ad=0.2128p pd=1.5u as=0.3976p ps=2.95u w=1.12u l=0.13u
X2810 VGND.t671 a_5518_6922# sg13cmos5l_buf_16_6.X VGND.t670 sg13_lv_nmos ad=0.1406p pd=1.12u as=0.1406p ps=1.12u w=0.74u l=0.13u
X2811 VPWR.t675 a_6094_10704# sg13cmos5l_buf_16_24.A VPWR.t55 sg13_lv_pmos ad=0.2128p pd=1.5u as=0.2128p ps=1.5u w=1.12u l=0.13u
X2812 sg13cmos5l_buf_16_20.A a_5204_11422# VGND.t350 VGND.t156 sg13_lv_nmos ad=0.1406p pd=1.12u as=0.1406p ps=1.12u w=0.74u l=0.13u
X2813 a_10318_5410# sg13cmos5l_buf_16_3.X VPWR.t70 VPWR.t70 sg13_lv_pmos ad=0.2128p pd=1.5u as=0.2128p ps=1.5u w=1.12u l=0.13u
X2814 sg13cmos5l_buf_16_22.X a_10318_8434# VGND.t11 VGND.t779 sg13_lv_nmos ad=0.1406p pd=1.12u as=0.1406p ps=1.12u w=0.74u l=0.13u
X2815 VPWR.t0 VGND.t150 VPWR.t0 VPWR.t0 sg13_lv_pmos ad=0.19p pd=1.38u as=0 ps=0 w=1u l=1u
X2816 sg13cmos5l_buf_16_7.A a_3668_3108# VPWR.t492 VPWR.t20 sg13_lv_pmos ad=0.2128p pd=1.5u as=0.2128p ps=1.5u w=1.12u l=0.13u
X2817 VGND.t11 sg13cmos5l_and2_2_5.B a_11659_8028# VGND.t721 sg13_lv_nmos ad=0.1331p pd=1.12u as=0.1216p ps=1.02u w=0.64u l=0.13u
X2818 a_5518_6922# sg13cmos5l_buf_16_28.X VPWR.t668 VPWR.t5 sg13_lv_pmos ad=0.2128p pd=1.5u as=0.2128p ps=1.5u w=1.12u l=0.13u
X2819 a_2377_14076# sg13cmos5l_and2_2_1.B VGND.t871 VGND.t1451 sg13_lv_nmos ad=0.1216p pd=1.02u as=0.1331p ps=1.12u w=0.64u l=0.13u
X2820 VGND.t130 VPWR.t281 VGND.t112 VGND.t40 sg13_lv_nmos ad=0.1428p pd=1.52u as=0 ps=0 w=0.42u l=1u
X2821 VPWR.t19 VGND.t150 VPWR.t19 VPWR.t0 sg13_lv_pmos ad=0.34p pd=2.68u as=0 ps=0 w=1u l=1u
X2822 VGND.t1308 VPWR.t18 VGND.t1308 VGND.t1342 sg13_lv_nmos ad=79.8f pd=0.8u as=0 ps=0 w=0.42u l=1u
X2823 sg13cmos5l_buf_16_39.A a_8494_3144# VPWR.t21 VPWR.t20 sg13_lv_pmos ad=0.2128p pd=1.5u as=0.2128p ps=1.5u w=1.12u l=0.13u
X2824 a_4462_5410# sg13cmos5l_and2_2_0.X VGND.t23 VGND.t226 sg13_lv_nmos ad=0.1406p pd=1.12u as=0.1406p ps=1.12u w=0.74u l=0.13u
X2825 VPWR.t304 sg13cmos5l_xor2_1_7.X a_14344_11492# VPWR.t13 sg13_lv_pmos ad=0.2114p pd=1.54u as=0.2856p ps=2.36u w=0.84u l=0.13u
X2826 sg13cmos5l_buf_16_6.X a_5518_6922# VGND.t358 VGND.t667 sg13_lv_nmos ad=0.1406p pd=1.12u as=0.1406p ps=1.12u w=0.74u l=0.13u
X2827 VGND.t912 a_6548_13692# sg13cmos5l_buf_16_27.X VGND.t1484 sg13_lv_nmos ad=0.1406p pd=1.12u as=0.1406p ps=1.12u w=0.74u l=0.13u
X2828 VPWR.t189 VGND.t261 VPWR.t189 VPWR.t3 sg13_lv_pmos ad=0.34p pd=2.68u as=0 ps=0 w=1u l=1u
X2829 sg13cmos5l_buf_16_15.A a_4052_12934# VPWR.t1263 VPWR.t8 sg13_lv_pmos ad=0.2128p pd=1.5u as=0.3976p ps=2.95u w=1.12u l=0.13u
X2830 sg13cmos5l_and2_2_0.X a_3875_5396# VGND.t222 VGND.t423 sg13_lv_nmos ad=0.1406p pd=1.12u as=0.2812p ps=2.24u w=0.74u l=0.13u
X2831 sg13cmos5l_buf_16_3.X a_10292_4620# VGND.t82 VGND.t87 sg13_lv_nmos ad=0.1406p pd=1.12u as=0.1406p ps=1.12u w=0.74u l=0.13u
X2832 VPWR.t1435 sg13cmos5l_buf_16_33.A a_6094_10704# VPWR.t55 sg13_lv_pmos ad=0.2128p pd=1.5u as=0.2128p ps=1.5u w=1.12u l=0.13u
X2833 VGND.t934 VPWR.t296 VGND.t934 VGND.t933 sg13_lv_nmos ad=0.1428p pd=1.52u as=0 ps=0 w=0.42u l=1u
X2834 sg13cmos5l_buf_1_5.X a_13768_5444# VPWR.t71 VPWR.t70 sg13_lv_pmos ad=0.42p pd=2.99u as=0.2114p ps=1.54u w=1.12u l=0.13u
X2835 VGND.t222 sg13cmos5l_and2_2_0.X a_4462_5410# VGND.t223 sg13_lv_nmos ad=0.1406p pd=1.12u as=0.1406p ps=1.12u w=0.74u l=0.13u
X2836 VPWR.t304 sg13cmos5l_buf_1_15.X a_13916_11752# VPWR.t13 sg13_lv_pmos ad=0.2128p pd=1.5u as=0.3808p ps=2.92u w=1.12u l=0.13u
X2837 sg13cmos5l_buf_16_19.A a_6765_12564# VGND.t519 VGND.t518 sg13_lv_nmos ad=0.1406p pd=1.12u as=0.1331p ps=1.12u w=0.74u l=0.13u
X2838 VPWR.t1002 VGND.t150 VPWR.t1001 VPWR.t20 sg13_lv_pmos ad=0.34p pd=2.68u as=0 ps=0 w=1u l=1u
X2839 VGND.t130 VPWR.t30 VGND.t130 VGND.t40 sg13_lv_nmos ad=0.1428p pd=1.52u as=0 ps=0 w=0.42u l=1u
X2840 a_6129_9192# sg13cmos5l_buf_16_14.A VPWR.t1205 VPWR.t3 sg13_lv_pmos ad=0.1225p pd=1.245u as=0.36p ps=2.72u w=1u l=0.13u
X2841 VPWR.t77 VGND.t150 VPWR.t77 VPWR.t0 sg13_lv_pmos ad=0.34p pd=2.68u as=0 ps=0 w=1u l=1u
X2842 VGND.t82 a_10292_4620# sg13cmos5l_buf_16_3.X VGND.t84 sg13_lv_nmos ad=0.1406p pd=1.12u as=0.1406p ps=1.12u w=0.74u l=0.13u
X2843 VGND.t1020 VPWR.t360 VGND.t1020 VGND.t156 sg13_lv_nmos ad=79.8f pd=0.8u as=0 ps=0 w=0.42u l=1u
X2844 VGND.t806 VPWR.t342 VGND.t806 VGND.t1171 sg13_lv_nmos ad=79.8f pd=0.8u as=0 ps=0 w=0.42u l=1u
X2845 VPWR.t315 VGND.t1173 VPWR.t318 VPWR.t5 sg13_lv_pmos ad=0.19p pd=1.38u as=0 ps=0 w=1u l=1u
X2846 a_3694_2386# sg13cmos5l_buf_16_7.A VGND.t146 VGND.t148 sg13_lv_nmos ad=0.1406p pd=1.12u as=0.1406p ps=1.12u w=0.74u l=0.13u
X2847 VGND.t1308 VPWR.t30 VGND.t1308 VGND.t1311 sg13_lv_nmos ad=79.8f pd=0.8u as=0 ps=0 w=0.42u l=1u
X2848 VPWR.t30 VGND.t1308 VPWR.t288 VPWR.t20 sg13_lv_pmos ad=0.19p pd=1.38u as=0 ps=0 w=1u l=1u
X2849 a_8564_2680# a_8538_2578# sg13cmos5l_buf_1_2.A VPWR.t20 sg13_lv_pmos ad=0.2128p pd=1.5u as=0.3808p ps=2.92u w=1.12u l=0.13u
X2850 a_6094_3144# sg13cmos5l_buf_16_5.X VGND.t41 VGND.t40 sg13_lv_nmos ad=0.1406p pd=1.12u as=0.1406p ps=1.12u w=0.74u l=0.13u
X2851 a_3668_12180# sg13cmos5l_buf_16_15.A VPWR.t814 VPWR.t13 sg13_lv_pmos ad=0.2128p pd=1.5u as=0.2128p ps=1.5u w=1.12u l=0.13u
X2852 sg13cmos5l_buf_16_14.A a_4436_9910# VGND.t169 VGND.t174 sg13_lv_nmos ad=0.1406p pd=1.12u as=0.1406p ps=1.12u w=0.74u l=0.13u
X2853 VPWR.t103 VGND.t315 VPWR.t102 VPWR.t13 sg13_lv_pmos ad=0.34p pd=2.68u as=0 ps=0 w=1u l=1u
X2854 sg13cmos5l_buf_16_2.X a_10318_3898# VPWR.t202 VPWR.t28 sg13_lv_pmos ad=0.2128p pd=1.5u as=0.2128p ps=1.5u w=1.12u l=0.13u
X2855 VPWR.t381 VGND.t851 VPWR.t381 VPWR.t28 sg13_lv_pmos ad=0.19p pd=1.38u as=0 ps=0 w=1u l=1u
X2856 VPWR.t152 sg13cmos5l_and2_2_0.X a_4462_5410# VPWR.t70 sg13_lv_pmos ad=0.2128p pd=1.5u as=0.2128p ps=1.5u w=1.12u l=0.13u
X2857 VGND.t315 VPWR.t1690 VGND.t958 VGND.t957 sg13_lv_nmos ad=79.8f pd=0.8u as=0 ps=0 w=0.42u l=1u
X2858 a_7796_12934# sg13cmos5l_buf_16_37.A VGND.t315 VGND.t317 sg13_lv_nmos ad=0.1406p pd=1.12u as=0.1406p ps=1.12u w=0.74u l=0.13u
X2859 VPWR.t70 VGND.t358 VPWR.t70 VPWR.t70 sg13_lv_pmos ad=0.19p pd=1.38u as=0 ps=0 w=1u l=1u
X2860 VGND.t693 VPWR.t386 VGND.t693 VGND.t919 sg13_lv_nmos ad=79.8f pd=0.8u as=0 ps=0 w=0.42u l=1u
X2861 sg13cmos5l_buf_16_3.X a_10292_4620# VGND.t72 VGND.t80 sg13_lv_nmos ad=0.1406p pd=1.12u as=0.1406p ps=1.12u w=0.74u l=0.13u
X2862 VGND.t1296 VPWR.t21 VGND.t1296 VGND.t1295 sg13_lv_nmos ad=0.1428p pd=1.52u as=0 ps=0 w=0.42u l=1u
X2863 VGND.t377 VPWR.t1673 VGND.t377 VGND.t156 sg13_lv_nmos ad=0.1428p pd=1.52u as=0 ps=0 w=0.42u l=1u
X2864 a_5710_1632# sg13cmos5l_buf_16_30.A VGND.t150 VGND.t855 sg13_lv_nmos ad=0.1406p pd=1.12u as=0.1406p ps=1.12u w=0.74u l=0.13u
X2865 VGND.t636 glitch_en[4] a_11272_13728# VGND.t1450 sg13_lv_nmos ad=0.14875p pd=1.16u as=0.187p ps=1.78u w=0.55u l=0.13u
X2866 VGND.t315 VPWR.t118 VGND.t315 VGND.t983 sg13_lv_nmos ad=79.8f pd=0.8u as=0 ps=0 w=0.42u l=1u
X2867 a_13745_11508# sg13cmos5l_and2_2_3.X a_13713_11776# VPWR.t13 sg13_lv_pmos ad=0.34p pd=2.68u as=0.1225p ps=1.245u w=1u l=0.13u
X2868 VPWR.t202 a_10318_3898# sg13cmos5l_buf_16_2.X VPWR.t28 sg13_lv_pmos ad=0.2128p pd=1.5u as=0.2128p ps=1.5u w=1.12u l=0.13u
X2869 sg13cmos5l_buf_16_28.X a_5684_6132# VGND.t671 VGND.t837 sg13_lv_nmos ad=0.1406p pd=1.12u as=0.1406p ps=1.12u w=0.74u l=0.13u
X2870 VPWR.t189 sg13cmos5l_and2_2_6.X a_6836_9156# VPWR.t3 sg13_lv_pmos ad=0.2128p pd=1.5u as=0.2128p ps=1.5u w=1.12u l=0.13u
X2871 VGND.t1383 VPWR.t7 VGND.t1385 VGND.t1384 sg13_lv_nmos ad=79.8f pd=0.8u as=0 ps=0 w=0.42u l=1u
X2872 VGND.t72 VPWR.t202 VGND.t72 VGND.t1237 sg13_lv_nmos ad=0.1428p pd=1.52u as=0 ps=0 w=0.42u l=1u
X2873 VPWR.t828 a_3694_10704# sg13cmos5l_and2_2_6.A VPWR.t55 sg13_lv_pmos ad=0.2128p pd=1.5u as=0.2128p ps=1.5u w=1.12u l=0.13u
X2874 VGND.t1067 VPWR.t1663 VGND.t165 VGND.t1068 sg13_lv_nmos ad=79.8f pd=0.8u as=0 ps=0 w=0.42u l=1u
X2875 VGND.t942 a_3694_14482# sg13cmos5l_buf_16_33.A VGND.t1511 sg13_lv_nmos ad=0.1406p pd=1.12u as=0.1406p ps=1.12u w=0.74u l=0.13u
X2876 VPWR.t1048 VGND.t198 VPWR.t46 VPWR.t28 sg13_lv_pmos ad=0.19p pd=1.38u as=0 ps=0 w=1u l=1u
X2877 VGND.t1119 VPWR.t1649 VGND.t275 VGND.t1120 sg13_lv_nmos ad=79.8f pd=0.8u as=0 ps=0 w=0.42u l=1u
R0 VPWR.n181 VPWR.t1225 17.2247
R1 VPWR.n40 VPWR.t134 17.2247
R2 VPWR.n359 VPWR.t817 17.2247
R3 VPWR.n482 VPWR.t1485 17.2247
R4 VPWR.n462 VPWR.t1486 17.2247
R5 VPWR.n477 VPWR.t1429 17.2247
R6 VPWR.n493 VPWR.t1404 17.2247
R7 VPWR.t20 VPWR.n73 17.0005
R8 VPWR.t20 VPWR.n967 17.0005
R9 VPWR.t20 VPWR.n74 17.0005
R10 VPWR.t20 VPWR.n964 17.0005
R11 VPWR.t20 VPWR.n75 17.0005
R12 VPWR.t20 VPWR.n961 17.0005
R13 VPWR.t20 VPWR.n76 17.0005
R14 VPWR.t20 VPWR.n958 17.0005
R15 VPWR.t20 VPWR.n77 17.0005
R16 VPWR.t20 VPWR.n955 17.0005
R17 VPWR.t20 VPWR.n78 17.0005
R18 VPWR.t20 VPWR.n952 17.0005
R19 VPWR.t20 VPWR.n81 17.0005
R20 VPWR.t20 VPWR.n949 17.0005
R21 VPWR.t20 VPWR.n82 17.0005
R22 VPWR.t20 VPWR.n946 17.0005
R23 VPWR.t20 VPWR.n83 17.0005
R24 VPWR.t20 VPWR.n943 17.0005
R25 VPWR.t20 VPWR.n84 17.0005
R26 VPWR.t20 VPWR.n940 17.0005
R27 VPWR.t20 VPWR.n85 17.0005
R28 VPWR.t20 VPWR.n937 17.0005
R29 VPWR.t20 VPWR.n86 17.0005
R30 VPWR.t20 VPWR.n100 17.0005
R31 VPWR.t20 VPWR.n914 17.0005
R32 VPWR.t28 VPWR.n55 5.64879
R33 VPWR.t28 VPWR.n36 17.0005
R34 VPWR.n907 VPWR.t28 17.0005
R35 VPWR.t70 VPWR.n170 17.0005
R36 VPWR.t70 VPWR.n232 17.0005
R37 VPWR.t70 VPWR.n171 17.0005
R38 VPWR.t70 VPWR.n229 17.0005
R39 VPWR.t70 VPWR.n172 17.0005
R40 VPWR.t70 VPWR.n226 17.0005
R41 VPWR.t70 VPWR.n173 17.0005
R42 VPWR.t70 VPWR.n223 17.0005
R43 VPWR.t70 VPWR.n174 17.0005
R44 VPWR.t70 VPWR.n220 17.0005
R45 VPWR.t70 VPWR.n175 17.0005
R46 VPWR.t70 VPWR.n217 17.0005
R47 VPWR.t70 VPWR.n176 17.0005
R48 VPWR.t70 VPWR.n214 17.0005
R49 VPWR.t70 VPWR.n177 17.0005
R50 VPWR.t70 VPWR.n57 5.64741
R51 VPWR.t70 VPWR.n125 17.0005
R52 VPWR.t70 VPWR.n54 17.0005
R53 VPWR.n825 VPWR.t70 17.0005
R54 VPWR.t5 VPWR.n3 0.955419
R55 VPWR.t5 VPWR.n30 3.31609
R56 VPWR.n30 VPWR.n29 0.0709887
R57 VPWR.t5 VPWR.n764 17.0005
R58 VPWR.t5 VPWR.n743 17.0005
R59 VPWR.n34 VPWR.n33 0.119913
R60 VPWR.t5 VPWR.n758 17.0005
R61 VPWR.t5 VPWR.n58 5.64741
R62 VPWR.n18 VPWR.n17 0.207922
R63 VPWR.t5 VPWR.n822 17.0005
R64 VPWR.t5 VPWR.n783 17.0005
R65 VPWR.t5 VPWR.n786 17.0005
R66 VPWR.t5 VPWR.n811 17.0005
R67 VPWR.t3 VPWR.n5 1.00641
R68 VPWR.t3 VPWR.n734 17.0005
R69 VPWR.t3 VPWR.n234 17.0005
R70 VPWR.t3 VPWR.n731 17.0005
R71 VPWR.t3 VPWR.n235 17.0005
R72 VPWR.t3 VPWR.n725 17.0005
R73 VPWR.t3 VPWR.n236 17.0005
R74 VPWR.t3 VPWR.n723 17.0005
R75 VPWR.t3 VPWR.n237 17.0005
R76 VPWR.t3 VPWR.n720 17.0005
R77 VPWR.t3 VPWR.n238 17.0005
R78 VPWR.t3 VPWR.n717 17.0005
R79 VPWR.t3 VPWR.n239 17.0005
R80 VPWR.t3 VPWR.n714 17.0005
R81 VPWR.t3 VPWR.n240 17.0005
R82 VPWR.t3 VPWR.n711 17.0005
R83 VPWR.t3 VPWR.n243 17.0005
R84 VPWR.t3 VPWR.n257 17.0005
R85 VPWR.t3 VPWR.n687 17.0005
R86 VPWR.t55 VPWR.n670 17.0005
R87 VPWR.t55 VPWR.n573 17.0005
R88 VPWR.t55 VPWR.n668 17.0005
R89 VPWR.t55 VPWR.n574 17.0005
R90 VPWR.t55 VPWR.n665 17.0005
R91 VPWR.t55 VPWR.n575 17.0005
R92 VPWR.t55 VPWR.n662 17.0005
R93 VPWR.t55 VPWR.n598 17.0005
R94 VPWR.t55 VPWR.n659 17.0005
R95 VPWR.t55 VPWR.n599 17.0005
R96 VPWR.t55 VPWR.n656 17.0005
R97 VPWR.t55 VPWR.n600 17.0005
R98 VPWR.t55 VPWR.n653 17.0005
R99 VPWR.t55 VPWR.n601 17.0005
R100 VPWR.t55 VPWR.n602 17.0005
R101 VPWR.t55 VPWR.n635 17.0005
R102 VPWR.t55 VPWR.n571 17.0005
R103 VPWR.n681 VPWR.t55 17.0005
R104 VPWR.t13 VPWR.n286 17.0005
R105 VPWR.t13 VPWR.n355 17.0005
R106 VPWR.t13 VPWR.n287 17.0005
R107 VPWR.t13 VPWR.n352 17.0005
R108 VPWR.t13 VPWR.n288 17.0005
R109 VPWR.t13 VPWR.n349 17.0005
R110 VPWR.t13 VPWR.n289 17.0005
R111 VPWR.t13 VPWR.n346 17.0005
R112 VPWR.t13 VPWR.n290 17.0005
R113 VPWR.t13 VPWR.n343 17.0005
R114 VPWR.t13 VPWR.n291 17.0005
R115 VPWR.t13 VPWR.n335 17.0005
R116 VPWR.t13 VPWR.n333 17.0005
R117 VPWR.t13 VPWR.n298 17.0005
R118 VPWR.t13 VPWR.n281 17.0005
R119 VPWR.n568 VPWR.t13 17.0005
R120 VPWR.t8 VPWR.n402 17.0005
R121 VPWR.t8 VPWR.n403 17.0005
R122 VPWR.t8 VPWR.n552 17.0005
R123 VPWR.t8 VPWR.n404 17.0005
R124 VPWR.t8 VPWR.n549 17.0005
R125 VPWR.t8 VPWR.n405 17.0005
R126 VPWR.t8 VPWR.n546 17.0005
R127 VPWR.t8 VPWR.n406 17.0005
R128 VPWR.t8 VPWR.n543 17.0005
R129 VPWR.t8 VPWR.n407 17.0005
R130 VPWR.t8 VPWR.n540 17.0005
R131 VPWR.t8 VPWR.n408 17.0005
R132 VPWR.t8 VPWR.n537 17.0005
R133 VPWR.t8 VPWR.n409 17.0005
R134 VPWR.t8 VPWR.n534 17.0005
R135 VPWR.t8 VPWR.n412 17.0005
R136 VPWR.t8 VPWR.n531 17.0005
R137 VPWR.t8 VPWR.n413 17.0005
R138 VPWR.t8 VPWR.n528 17.0005
R139 VPWR.t8 VPWR.n414 17.0005
R140 VPWR.t8 VPWR.n525 17.0005
R141 VPWR.t8 VPWR.n415 17.0005
R142 VPWR.t8 VPWR.n522 17.0005
R143 VPWR.t8 VPWR.n416 17.0005
R144 VPWR.t8 VPWR.n519 17.0005
R145 VPWR.t8 VPWR.n417 17.0005
R146 VPWR.t8 VPWR.n513 17.0005
R147 VPWR.n25 VPWR.n24 0.169602
R148 VPWR.n14 VPWR.n13 0.182353
R149 VPWR.t8 VPWR.n424 17.0005
R150 VPWR.t8 VPWR.n440 17.0005
R151 VPWR.t8 VPWR.n425 17.0005
R152 VPWR.t8 VPWR.n437 17.0005
R153 VPWR.t8 VPWR.n23 3.28357
R154 VPWR.n211 VPWR.t1626 15.2621
R155 VPWR.n776 VPWR.t1639 15.2621
R156 VPWR.n511 VPWR.t1688 15.2621
R157 VPWR.n479 VPWR.t1698 15.2621
R158 VPWR.n188 VPWR.t1631 15.2617
R159 VPWR.n21 VPWR.t1695 15.2617
R160 VPWR.n975 VPWR.n63 9.0005
R161 VPWR.n910 VPWR.n63 9.0005
R162 VPWR.n507 VPWR.n505 9.0005
R163 VPWR.n509 VPWR.n503 9.0005
R164 VPWR.n566 VPWR.n379 9.0005
R165 VPWR.n562 VPWR.n379 9.0005
R166 VPWR.n67 VPWR.n66 9.0005
R167 VPWR.n971 VPWR.n970 9.0005
R168 VPWR.n15 VPWR.t1329 8.79392
R169 VPWR.n38 VPWR.t1210 8.78742
R170 VPWR.n820 VPWR.t594 8.78642
R171 VPWR.n17 VPWR.t1323 8.78642
R172 VPWR.n637 VPWR.t691 8.78642
R173 VPWR.n331 VPWR.t645 8.78642
R174 VPWR.n48 VPWR.t651 8.78642
R175 VPWR.n442 VPWR.t1533 8.78642
R176 VPWR.n554 VPWR.t1488 8.78642
R177 VPWR.n52 VPWR.t1494 8.78642
R178 VPWR.n962 VPWR.t1580 8.76154
R179 VPWR.n959 VPWR.t1578 8.76154
R180 VPWR.n956 VPWR.t808 8.76154
R181 VPWR.n953 VPWR.t806 8.76154
R182 VPWR.n950 VPWR.t804 8.76154
R183 VPWR.n80 VPWR.t802 8.76154
R184 VPWR.n948 VPWR.t800 8.76154
R185 VPWR.n945 VPWR.t798 8.76154
R186 VPWR.n939 VPWR.t794 8.76154
R187 VPWR.n94 VPWR.t275 8.76154
R188 VPWR.n92 VPWR.t277 8.76154
R189 VPWR.n90 VPWR.t279 8.76154
R190 VPWR.n88 VPWR.t778 8.76154
R191 VPWR.n920 VPWR.t780 8.76154
R192 VPWR.n922 VPWR.t782 8.76154
R193 VPWR.n924 VPWR.t784 8.76154
R194 VPWR.n926 VPWR.t786 8.76154
R195 VPWR.n930 VPWR.t790 8.76154
R196 VPWR.n885 VPWR.t1228 8.76154
R197 VPWR.n887 VPWR.t1230 8.76154
R198 VPWR.n889 VPWR.t881 8.76154
R199 VPWR.n891 VPWR.t882 8.76154
R200 VPWR.n892 VPWR.t884 8.76154
R201 VPWR.n851 VPWR.t886 8.76154
R202 VPWR.n849 VPWR.t888 8.76154
R203 VPWR.n847 VPWR.t890 8.76154
R204 VPWR.n843 VPWR.t894 8.76154
R205 VPWR.n837 VPWR.t1424 8.76154
R206 VPWR.n835 VPWR.t1426 8.76154
R207 VPWR.n833 VPWR.t530 8.76154
R208 VPWR.n831 VPWR.t531 8.76154
R209 VPWR.n894 VPWR.t533 8.76154
R210 VPWR.n896 VPWR.t535 8.76154
R211 VPWR.n898 VPWR.t537 8.76154
R212 VPWR.n900 VPWR.t539 8.76154
R213 VPWR.n904 VPWR.t543 8.76154
R214 VPWR.n163 VPWR.t879 8.76154
R215 VPWR.n161 VPWR.t727 8.76154
R216 VPWR.n204 VPWR.t165 8.76154
R217 VPWR.n198 VPWR.t161 8.76154
R218 VPWR.n195 VPWR.t159 8.76154
R219 VPWR.n192 VPWR.t157 8.76154
R220 VPWR.n190 VPWR.t155 8.76154
R221 VPWR.n179 VPWR.t153 8.76154
R222 VPWR.n182 VPWR.t152 8.76154
R223 VPWR.n184 VPWR.t527 8.76154
R224 VPWR.n187 VPWR.t525 8.76154
R225 VPWR.t837 VPWR.t612 8.76154
R226 VPWR.n167 VPWR.t610 8.76154
R227 VPWR.n230 VPWR.t608 8.76154
R228 VPWR.n227 VPWR.t606 8.76154
R229 VPWR.n224 VPWR.t604 8.76154
R230 VPWR.n218 VPWR.t600 8.76154
R231 VPWR.n744 VPWR.t672 8.76154
R232 VPWR.n748 VPWR.t670 8.76154
R233 VPWR.n751 VPWR.t668 8.76154
R234 VPWR.n33 VPWR.t1216 8.76154
R235 VPWR.n761 VPWR.t1214 8.76154
R236 VPWR.n757 VPWR.t1212 8.76154
R237 VPWR.n767 VPWR.t1222 8.76154
R238 VPWR.n31 VPWR.t1218 8.76154
R239 VPWR.n251 VPWR.t1128 8.76154
R240 VPWR.n249 VPWR.t1130 8.76154
R241 VPWR.n247 VPWR.t703 8.76154
R242 VPWR.n245 VPWR.t704 8.76154
R243 VPWR.n693 VPWR.t706 8.76154
R244 VPWR.n695 VPWR.t708 8.76154
R245 VPWR.n697 VPWR.t710 8.76154
R246 VPWR.n699 VPWR.t712 8.76154
R247 VPWR.n703 VPWR.t716 8.76154
R248 VPWR.n732 VPWR.t1570 8.76154
R249 VPWR.n729 VPWR.t1568 8.76154
R250 VPWR.n727 VPWR.t1566 8.76154
R251 VPWR.n724 VPWR.t1564 8.76154
R252 VPWR.n722 VPWR.t1562 8.76154
R253 VPWR.n719 VPWR.t878 8.76154
R254 VPWR.n716 VPWR.t876 8.76154
R255 VPWR.n713 VPWR.t874 8.76154
R256 VPWR.n680 VPWR.t556 8.76154
R257 VPWR.n676 VPWR.t554 8.76154
R258 VPWR.n673 VPWR.t552 8.76154
R259 VPWR.n669 VPWR.t550 8.76154
R260 VPWR.n667 VPWR.t548 8.76154
R261 VPWR.n664 VPWR.t547 8.76154
R262 VPWR.n661 VPWR.t590 8.76154
R263 VPWR.n578 VPWR.t588 8.76154
R264 VPWR.n592 VPWR.t470 8.76154
R265 VPWR.n595 VPWR.t468 8.76154
R266 VPWR.n657 VPWR.t466 8.76154
R267 VPWR.n654 VPWR.t464 8.76154
R268 VPWR.n651 VPWR.t462 8.76154
R269 VPWR.n647 VPWR.t458 8.76154
R270 VPWR.n589 VPWR.t472 8.76154
R271 VPWR.n587 VPWR.t517 8.76154
R272 VPWR.n585 VPWR.t519 8.76154
R273 VPWR.t1065 VPWR.t560 8.76154
R274 VPWR.n370 VPWR.t663 8.76154
R275 VPWR.n367 VPWR.t661 8.76154
R276 VPWR.n364 VPWR.t660 8.76154
R277 VPWR.n361 VPWR.t1299 8.76154
R278 VPWR.n358 VPWR.t1297 8.76154
R279 VPWR.n356 VPWR.t1295 8.76154
R280 VPWR.n354 VPWR.t1293 8.76154
R281 VPWR.n351 VPWR.t1291 8.76154
R282 VPWR.n345 VPWR.t1287 8.76154
R283 VPWR.n384 VPWR.t928 8.76154
R284 VPWR.n386 VPWR.t926 8.76154
R285 VPWR.n389 VPWR.t924 8.76154
R286 VPWR.n395 VPWR.t920 8.76154
R287 VPWR.n545 VPWR.t1538 8.76154
R288 VPWR.n542 VPWR.t1536 8.76154
R289 VPWR.n539 VPWR.t1278 8.76154
R290 VPWR.n536 VPWR.t1276 8.76154
R291 VPWR.n533 VPWR.t1274 8.76154
R292 VPWR.n529 VPWR.t1272 8.76154
R293 VPWR.n526 VPWR.t1270 8.76154
R294 VPWR.n523 VPWR.t1268 8.76154
R295 VPWR.n517 VPWR.t1264 8.76154
R296 VPWR.n450 VPWR.t1523 8.76154
R297 VPWR.n446 VPWR.t1519 8.76154
R298 VPWR.n444 VPWR.t1517 8.76154
R299 VPWR.n464 VPWR.t1515 8.76154
R300 VPWR.n466 VPWR.t1513 8.76154
R301 VPWR.n468 VPWR.t1511 8.76154
R302 VPWR.n470 VPWR.t1508 8.76154
R303 VPWR.n472 VPWR.t1506 8.76154
R304 VPWR.n474 VPWR.t1504 8.76154
R305 VPWR.n94 VPWR.t490 8.76054
R306 VPWR.n90 VPWR.t494 8.76054
R307 VPWR.n88 VPWR.t496 8.76054
R308 VPWR.n920 VPWR.t498 8.76054
R309 VPWR.n922 VPWR.t500 8.76054
R310 VPWR.n924 VPWR.t502 8.76054
R311 VPWR.n926 VPWR.t504 8.76054
R312 VPWR.n928 VPWR.t564 8.76054
R313 VPWR.n930 VPWR.t566 8.76054
R314 VPWR.n935 VPWR.t898 8.76054
R315 VPWR.n938 VPWR.t900 8.76054
R316 VPWR.n941 VPWR.t168 8.76054
R317 VPWR.n944 VPWR.t169 8.76054
R318 VPWR.n947 VPWR.t171 8.76054
R319 VPWR.n951 VPWR.t173 8.76054
R320 VPWR.n954 VPWR.t175 8.76054
R321 VPWR.n957 VPWR.t177 8.76054
R322 VPWR.n963 VPWR.t181 8.76054
R323 VPWR.t880 VPWR.t219 8.76054
R324 VPWR.n885 VPWR.t761 8.76054
R325 VPWR.n889 VPWR.t765 8.76054
R326 VPWR.n891 VPWR.t767 8.76054
R327 VPWR.n892 VPWR.t769 8.76054
R328 VPWR.n851 VPWR.t771 8.76054
R329 VPWR.n849 VPWR.t773 8.76054
R330 VPWR.n847 VPWR.t775 8.76054
R331 VPWR.n845 VPWR.t860 8.76054
R332 VPWR.n843 VPWR.t862 8.76054
R333 VPWR.n837 VPWR.t866 8.76054
R334 VPWR.n835 VPWR.t868 8.76054
R335 VPWR.n833 VPWR.t744 8.76054
R336 VPWR.n831 VPWR.t745 8.76054
R337 VPWR.n894 VPWR.t747 8.76054
R338 VPWR.n896 VPWR.t749 8.76054
R339 VPWR.n898 VPWR.t751 8.76054
R340 VPWR.n900 VPWR.t753 8.76054
R341 VPWR.n904 VPWR.t757 8.76054
R342 VPWR.n196 VPWR.t1365 8.76054
R343 VPWR.n202 VPWR.t1369 8.76054
R344 VPWR.n205 VPWR.t1371 8.76054
R345 VPWR.n208 VPWR.t1373 8.76054
R346 VPWR.n213 VPWR.t1375 8.76054
R347 VPWR.n216 VPWR.t1377 8.76054
R348 VPWR.n219 VPWR.t720 8.76054
R349 VPWR.n222 VPWR.t721 8.76054
R350 VPWR.n225 VPWR.t723 8.76054
R351 VPWR.n169 VPWR.t1547 8.76054
R352 VPWR.n166 VPWR.t1549 8.76054
R353 VPWR.n781 VPWR.t596 8.76054
R354 VPWR.n777 VPWR.t598 8.76054
R355 VPWR.n17 VPWR.t1325 8.76054
R356 VPWR.n17 VPWR.t1327 8.76054
R357 VPWR.n756 VPWR.t1331 8.76054
R358 VPWR.n750 VPWR.t1335 8.76054
R359 VPWR.n769 VPWR.t135 8.76054
R360 VPWR.n27 VPWR.t1338 8.76054
R361 VPWR.n251 VPWR.t474 8.76054
R362 VPWR.n247 VPWR.t478 8.76054
R363 VPWR.n245 VPWR.t480 8.76054
R364 VPWR.n693 VPWR.t482 8.76054
R365 VPWR.n695 VPWR.t484 8.76054
R366 VPWR.n697 VPWR.t486 8.76054
R367 VPWR.n699 VPWR.t488 8.76054
R368 VPWR.n701 VPWR.t1202 8.76054
R369 VPWR.n703 VPWR.t1206 8.76054
R370 VPWR.n712 VPWR.t229 8.76054
R371 VPWR.n718 VPWR.t233 8.76054
R372 VPWR.n721 VPWR.t235 8.76054
R373 VPWR.n726 VPWR.t237 8.76054
R374 VPWR.n730 VPWR.t239 8.76054
R375 VPWR.n733 VPWR.t241 8.76054
R376 VPWR.t189 VPWR.t243 8.76054
R377 VPWR.n639 VPWR.t693 8.76054
R378 VPWR.n642 VPWR.t695 8.76054
R379 VPWR.n645 VPWR.t822 8.76054
R380 VPWR.n648 VPWR.t824 8.76054
R381 VPWR.n652 VPWR.t826 8.76054
R382 VPWR.n655 VPWR.t828 8.76054
R383 VPWR.n658 VPWR.t830 8.76054
R384 VPWR.n594 VPWR.t834 8.76054
R385 VPWR.n587 VPWR.t1433 8.76054
R386 VPWR.n585 VPWR.t1435 8.76054
R387 VPWR.n583 VPWR.t674 8.76054
R388 VPWR.n580 VPWR.t675 8.76054
R389 VPWR.n577 VPWR.t677 8.76054
R390 VPWR.n660 VPWR.t679 8.76054
R391 VPWR.n663 VPWR.t681 8.76054
R392 VPWR.n666 VPWR.t683 8.76054
R393 VPWR.n674 VPWR.t687 8.76054
R394 VPWR.n292 VPWR.t649 8.76054
R395 VPWR.n334 VPWR.t653 8.76054
R396 VPWR.n338 VPWR.t655 8.76054
R397 VPWR.n339 VPWR.t657 8.76054
R398 VPWR.n341 VPWR.t659 8.76054
R399 VPWR.n344 VPWR.t812 8.76054
R400 VPWR.n347 VPWR.t814 8.76054
R401 VPWR.n363 VPWR.t1285 8.76054
R402 VPWR.n366 VPWR.t818 8.76054
R403 VPWR.n50 VPWR.t1496 8.76054
R404 VPWR.n399 VPWR.t1498 8.76054
R405 VPWR.n396 VPWR.t1500 8.76054
R406 VPWR.n393 VPWR.t1256 8.76054
R407 VPWR.n390 VPWR.t1257 8.76054
R408 VPWR.n387 VPWR.t1259 8.76054
R409 VPWR.n438 VPWR.t1455 8.76054
R410 VPWR.n521 VPWR.t1477 8.76054
R411 VPWR.n524 VPWR.t1479 8.76054
R412 VPWR.n527 VPWR.t1457 8.76054
R413 VPWR.n530 VPWR.t1458 8.76054
R414 VPWR.n411 VPWR.t1460 8.76054
R415 VPWR.n532 VPWR.t1462 8.76054
R416 VPWR.n535 VPWR.t1464 8.76054
R417 VPWR.n538 VPWR.t1466 8.76054
R418 VPWR.n544 VPWR.t1470 8.76054
R419 VPWR.n560 VPWR.t1492 8.76054
R420 VPWR.n35 VPWR.t73 0.773623
R421 VPWR.t0 VPWR.n56 0.381008
R422 VPWR.t5 VPWR.t201 0.755303
R423 VPWR.t449 VPWR.n55 0.0296542
R424 VPWR.n189 VPWR.n57 0.0317231
R425 VPWR.n15 VPWR.n58 0.0317231
R426 VPWR.n60 VPWR.t292 5.64879
R427 VPWR.n61 VPWR.t914 0.266785
R428 VPWR.t296 VPWR.n62 0.280345
R429 VPWR.n39 VPWR.n38 0.0341352
R430 VPWR.n43 VPWR.n42 0.0341352
R431 VPWR.n46 VPWR.n45 0.0341352
R432 VPWR.n49 VPWR.n48 0.0341352
R433 VPWR.n53 VPWR.n52 0.0341352
R434 VPWR.t20 VPWR.n71 8.47111
R435 VPWR.t20 VPWR.n79 8.47111
R436 VPWR.t20 VPWR.n934 8.47111
R437 VPWR.t20 VPWR.n931 8.47111
R438 VPWR.t20 VPWR.n929 8.47111
R439 VPWR.t20 VPWR.n927 8.47111
R440 VPWR.t20 VPWR.n925 8.47111
R441 VPWR.t20 VPWR.n923 8.47111
R442 VPWR.t20 VPWR.n87 8.47111
R443 VPWR.t20 VPWR.n89 8.47111
R444 VPWR.t20 VPWR.n91 8.47111
R445 VPWR.t20 VPWR.n93 8.47111
R446 VPWR.t20 VPWR.n95 8.47111
R447 VPWR.t20 VPWR.n98 8.47111
R448 VPWR.t20 VPWR.n122 8.47111
R449 VPWR.t20 VPWR.n117 8.47111
R450 VPWR.t20 VPWR.n102 8.47111
R451 VPWR.t20 VPWR.n104 8.47111
R452 VPWR.t28 VPWR.n0 0.569078
R453 VPWR.t28 VPWR.n905 8.47111
R454 VPWR.t28 VPWR.n903 8.47111
R455 VPWR.t28 VPWR.n901 8.47111
R456 VPWR.t28 VPWR.n899 8.47111
R457 VPWR.t28 VPWR.n897 8.47111
R458 VPWR.t28 VPWR.n830 8.47111
R459 VPWR.t28 VPWR.n832 8.47111
R460 VPWR.t28 VPWR.n834 8.47111
R461 VPWR.t28 VPWR.n836 8.47111
R462 VPWR.t28 VPWR.n838 8.47111
R463 VPWR.t28 VPWR.n840 8.47111
R464 VPWR.t28 VPWR.n842 8.47111
R465 VPWR.t28 VPWR.n844 8.47111
R466 VPWR.t28 VPWR.n846 8.47111
R467 VPWR.t28 VPWR.n848 8.47111
R468 VPWR.t28 VPWR.n850 8.47111
R469 VPWR.t28 VPWR.n893 8.47111
R470 VPWR.t28 VPWR.n890 8.47111
R471 VPWR.t28 VPWR.n888 8.47111
R472 VPWR.t28 VPWR.n886 8.47111
R473 VPWR.t28 VPWR.n884 8.47111
R474 VPWR.t28 VPWR.n880 8.47111
R475 VPWR.t28 VPWR.n854 8.47111
R476 VPWR.t28 VPWR.n856 8.47111
R477 VPWR.t28 VPWR.n871 8.47111
R478 VPWR.t28 VPWR.n866 8.47111
R479 VPWR.t70 VPWR.n2 0.806079
R480 VPWR.t70 VPWR.n19 0.965039
R481 VPWR.t70 VPWR.n168 8.47111
R482 VPWR.t70 VPWR.n210 8.47111
R483 VPWR.t70 VPWR.n206 8.47111
R484 VPWR.t70 VPWR.n203 8.47111
R485 VPWR.t70 VPWR.n200 8.47111
R486 VPWR.t70 VPWR.n197 8.47111
R487 VPWR.t70 VPWR.n194 8.47111
R488 VPWR.t70 VPWR.n178 8.47111
R489 VPWR.t70 VPWR.n180 8.47111
R490 VPWR.t70 VPWR.n183 8.47111
R491 VPWR.t70 VPWR.n185 8.47111
R492 VPWR.t70 VPWR.n165 8.47111
R493 VPWR.t70 VPWR.n126 8.47111
R494 VPWR.t70 VPWR.n128 8.47111
R495 VPWR.t70 VPWR.n157 8.47111
R496 VPWR.t70 VPWR.n131 8.47111
R497 VPWR.t70 VPWR.n133 8.47111
R498 VPWR.t70 VPWR.n148 8.47111
R499 VPWR.t70 VPWR.n143 8.47111
R500 VPWR.t5 VPWR.n737 8.47111
R501 VPWR.t5 VPWR.n741 8.47111
R502 VPWR.t5 VPWR.n771 8.47111
R503 VPWR.t5 VPWR.n768 8.47111
R504 VPWR.t5 VPWR.n766 8.47111
R505 VPWR.t5 VPWR.n34 4.17692
R506 VPWR.t5 VPWR.n760 8.47111
R507 VPWR.t5 VPWR.n39 4.22715
R508 VPWR.t5 VPWR.n746 8.47111
R509 VPWR.t5 VPWR.n749 8.47111
R510 VPWR.t5 VPWR.n752 8.47111
R511 VPWR.t5 VPWR.n755 8.47111
R512 VPWR.t5 VPWR.n18 1.99767
R513 VPWR.t5 VPWR.n779 8.47111
R514 VPWR.t5 VPWR.n818 8.47111
R515 VPWR.t5 VPWR.n784 8.47111
R516 VPWR.t5 VPWR.n808 8.47111
R517 VPWR.t5 VPWR.n803 8.47111
R518 VPWR.t5 VPWR.n788 8.47111
R519 VPWR.t5 VPWR.n790 8.47111
R520 VPWR.t3 VPWR.n728 8.47111
R521 VPWR.t3 VPWR.n241 8.47111
R522 VPWR.t3 VPWR.n43 4.22715
R523 VPWR.t3 VPWR.n706 8.47111
R524 VPWR.t3 VPWR.n704 8.47111
R525 VPWR.t3 VPWR.n702 8.47111
R526 VPWR.t3 VPWR.n700 8.47111
R527 VPWR.t3 VPWR.n698 8.47111
R528 VPWR.t3 VPWR.n696 8.47111
R529 VPWR.t3 VPWR.n244 8.47111
R530 VPWR.t3 VPWR.n246 8.47111
R531 VPWR.t3 VPWR.n248 8.47111
R532 VPWR.t3 VPWR.n250 8.47111
R533 VPWR.t3 VPWR.n252 8.47111
R534 VPWR.t3 VPWR.n255 8.47111
R535 VPWR.t3 VPWR.n279 8.47111
R536 VPWR.t3 VPWR.n274 8.47111
R537 VPWR.t3 VPWR.n259 8.47111
R538 VPWR.t3 VPWR.n261 8.47111
R539 VPWR.t55 VPWR.n46 4.22715
R540 VPWR.t55 VPWR.n678 8.47111
R541 VPWR.t55 VPWR.n675 8.47111
R542 VPWR.t55 VPWR.n672 8.47111
R543 VPWR.t55 VPWR.n576 8.47111
R544 VPWR.t55 VPWR.n579 8.47111
R545 VPWR.t55 VPWR.n582 8.47111
R546 VPWR.t55 VPWR.n584 8.47111
R547 VPWR.t55 VPWR.n586 8.47111
R548 VPWR.t55 VPWR.n588 8.47111
R549 VPWR.t55 VPWR.n590 8.47111
R550 VPWR.t55 VPWR.n593 8.47111
R551 VPWR.t55 VPWR.n596 8.47111
R552 VPWR.t55 VPWR.n650 8.47111
R553 VPWR.t55 VPWR.n646 8.47111
R554 VPWR.t55 VPWR.n643 8.47111
R555 VPWR.t55 VPWR.n641 8.47111
R556 VPWR.t55 VPWR.n603 8.47111
R557 VPWR.t55 VPWR.n632 8.47111
R558 VPWR.t55 VPWR.n606 8.47111
R559 VPWR.t55 VPWR.n608 8.47111
R560 VPWR.t55 VPWR.n623 8.47111
R561 VPWR.t55 VPWR.n618 8.47111
R562 VPWR.t13 VPWR.n378 8.47111
R563 VPWR.t13 VPWR.n377 8.47111
R564 VPWR.t13 VPWR.n374 8.47111
R565 VPWR.n7 VPWR.n372 0.169267
R566 VPWR.n8 VPWR.n7 0.135263
R567 VPWR.t13 VPWR.n8 2.30471
R568 VPWR.n10 VPWR.n285 0.169267
R569 VPWR.n11 VPWR.n10 0.135263
R570 VPWR.t13 VPWR.n11 2.30471
R571 VPWR.t13 VPWR.n368 8.47111
R572 VPWR.t13 VPWR.n365 8.47111
R573 VPWR.t13 VPWR.n362 8.47111
R574 VPWR.t13 VPWR.n360 8.47111
R575 VPWR.t13 VPWR.n340 8.47111
R576 VPWR.t13 VPWR.n337 8.47111
R577 VPWR.t13 VPWR.n49 4.22715
R578 VPWR.t13 VPWR.n294 8.47111
R579 VPWR.t13 VPWR.n329 8.47111
R580 VPWR.t13 VPWR.n300 8.47111
R581 VPWR.t13 VPWR.n322 8.47111
R582 VPWR.t13 VPWR.n317 8.47111
R583 VPWR.t13 VPWR.n302 8.47111
R584 VPWR.t13 VPWR.n304 8.47111
R585 VPWR.t8 VPWR.n385 8.47111
R586 VPWR.t8 VPWR.n388 8.47111
R587 VPWR.t8 VPWR.n391 8.47111
R588 VPWR.t8 VPWR.n394 8.47111
R589 VPWR.t8 VPWR.n397 8.47111
R590 VPWR.t8 VPWR.n400 8.47111
R591 VPWR.t8 VPWR.n53 4.22715
R592 VPWR.t8 VPWR.n558 8.47111
R593 VPWR.t8 VPWR.n410 8.47111
R594 VPWR.t8 VPWR.n516 8.47111
R595 VPWR.t8 VPWR.n25 4.15208
R596 VPWR.t8 VPWR.n420 8.47111
R597 VPWR.n13 VPWR.n423 0.16977
R598 VPWR.n23 VPWR.n436 0.385917
R599 VPWR.n23 VPWR.n22 0.236732
R600 VPWR.t8 VPWR.n433 8.47111
R601 VPWR.n490 VPWR.t292 8.47111
R602 VPWR.n499 VPWR.t292 8.47111
R603 VPWR.n501 VPWR.t292 8.47111
R604 VPWR.t292 VPWR.n475 8.47111
R605 VPWR.t292 VPWR.n473 8.47111
R606 VPWR.t292 VPWR.n471 8.47111
R607 VPWR.t292 VPWR.n469 8.47111
R608 VPWR.t292 VPWR.n467 8.47111
R609 VPWR.t292 VPWR.n443 8.47111
R610 VPWR.t292 VPWR.n445 8.47111
R611 VPWR.t292 VPWR.n447 8.47111
R612 VPWR.t292 VPWR.n449 8.47111
R613 VPWR.t292 VPWR.n451 8.47111
R614 VPWR.t292 VPWR.n460 8.47111
R615 VPWR.t292 VPWR.n456 8.47111
R616 VPWR.t292 VPWR.n481 8.47111
R617 VPWR.n109 VPWR.t1613 7.62628
R618 VPWR.n113 VPWR.t1612 7.62628
R619 VPWR.n120 VPWR.t1611 7.62628
R620 VPWR.n916 VPWR.t1610 7.62628
R621 VPWR.n862 VPWR.t1621 7.62628
R622 VPWR.n869 VPWR.t1620 7.62628
R623 VPWR.n873 VPWR.t1619 7.62628
R624 VPWR.n878 VPWR.t1618 7.62628
R625 VPWR.n139 VPWR.t1630 7.62628
R626 VPWR.n146 VPWR.t1629 7.62628
R627 VPWR.n150 VPWR.t1628 7.62628
R628 VPWR.n155 VPWR.t1627 7.62628
R629 VPWR.n795 VPWR.t1645 7.62628
R630 VPWR.n799 VPWR.t1644 7.62628
R631 VPWR.n806 VPWR.t1643 7.62628
R632 VPWR.n813 VPWR.t1642 7.62628
R633 VPWR.n819 VPWR.t1641 7.62628
R634 VPWR.n16 VPWR.t1640 7.62628
R635 VPWR.n28 VPWR.t1638 7.62628
R636 VPWR.n773 VPWR.t1637 7.62628
R637 VPWR.n266 VPWR.t1657 7.62628
R638 VPWR.n270 VPWR.t1656 7.62628
R639 VPWR.n277 VPWR.t1655 7.62628
R640 VPWR.n689 VPWR.t1654 7.62628
R641 VPWR.n41 VPWR.t1653 7.62628
R642 VPWR.n614 VPWR.t1666 7.62628
R643 VPWR.n621 VPWR.t1665 7.62628
R644 VPWR.n625 VPWR.t1664 7.62628
R645 VPWR.n630 VPWR.t1663 7.62628
R646 VPWR.n636 VPWR.t1662 7.62628
R647 VPWR.n309 VPWR.t1679 7.62628
R648 VPWR.n313 VPWR.t1678 7.62628
R649 VPWR.n320 VPWR.t1677 7.62628
R650 VPWR.n324 VPWR.t1676 7.62628
R651 VPWR.n330 VPWR.t1675 7.62628
R652 VPWR.n47 VPWR.t1674 7.62628
R653 VPWR.n283 VPWR.t1673 7.62628
R654 VPWR.n371 VPWR.t1672 7.62628
R655 VPWR.n429 VPWR.t1692 7.62628
R656 VPWR.n22 VPWR.t1691 7.62628
R657 VPWR.n441 VPWR.t1690 7.62628
R658 VPWR.n421 VPWR.t1689 7.62628
R659 VPWR.n553 VPWR.t1687 7.62628
R660 VPWR.n51 VPWR.t1686 7.62628
R661 VPWR.n484 VPWR.t1697 7.62628
R662 VPWR.n458 VPWR.t1699 7.62628
R663 VPWR.n497 VPWR.t1700 7.62628
R664 VPWR.n488 VPWR.t1701 7.62628
R665 VPWR.n108 VPWR.t1617 7.62594
R666 VPWR.n112 VPWR.t1616 7.62594
R667 VPWR.n119 VPWR.t1615 7.62594
R668 VPWR.n915 VPWR.t1614 7.62594
R669 VPWR.n861 VPWR.t1625 7.62594
R670 VPWR.n868 VPWR.t1624 7.62594
R671 VPWR.n872 VPWR.t1623 7.62594
R672 VPWR.n877 VPWR.t1622 7.62594
R673 VPWR.n138 VPWR.t1636 7.62594
R674 VPWR.n145 VPWR.t1635 7.62594
R675 VPWR.n149 VPWR.t1634 7.62594
R676 VPWR.n154 VPWR.t1633 7.62594
R677 VPWR.n158 VPWR.t1632 7.62594
R678 VPWR.n794 VPWR.t1652 7.62594
R679 VPWR.n798 VPWR.t1651 7.62594
R680 VPWR.n805 VPWR.t1650 7.62594
R681 VPWR.n812 VPWR.t1649 7.62594
R682 VPWR.n37 VPWR.t1648 7.62594
R683 VPWR.n32 VPWR.t1647 7.62594
R684 VPWR.n738 VPWR.t1646 7.62594
R685 VPWR.n265 VPWR.t1661 7.62594
R686 VPWR.n269 VPWR.t1660 7.62594
R687 VPWR.n276 VPWR.t1659 7.62594
R688 VPWR.n688 VPWR.t1658 7.62594
R689 VPWR.n613 VPWR.t1671 7.62594
R690 VPWR.n620 VPWR.t1670 7.62594
R691 VPWR.n624 VPWR.t1669 7.62594
R692 VPWR.n629 VPWR.t1668 7.62594
R693 VPWR.n44 VPWR.t1667 7.62594
R694 VPWR.n308 VPWR.t1685 7.62594
R695 VPWR.n312 VPWR.t1684 7.62594
R696 VPWR.n319 VPWR.t1683 7.62594
R697 VPWR.n323 VPWR.t1682 7.62594
R698 VPWR.n9 VPWR.t1681 7.62594
R699 VPWR.n6 VPWR.t1680 7.62594
R700 VPWR.n428 VPWR.t1696 7.62594
R701 VPWR.n12 VPWR.t1694 7.62594
R702 VPWR.n24 VPWR.t1693 7.62594
R703 VPWR.n487 VPWR.t980 6.10712
R704 VPWR.n189 VPWR.t524 6.00573
R705 VPWR.n159 VPWR.t726 5.99801
R706 VPWR.n45 VPWR.t558 5.99801
R707 VPWR.n774 VPWR.t1118 5.99545
R708 VPWR.n965 VPWR.t1582 5.97235
R709 VPWR.n96 VPWR.t274 5.97235
R710 VPWR.n883 VPWR.t1226 5.97235
R711 VPWR.n839 VPWR.t1423 5.97235
R712 VPWR.n754 VPWR.t667 5.97235
R713 VPWR.n253 VPWR.t1127 5.97235
R714 VPWR.n710 VPWR.t873 5.97235
R715 VPWR.n581 VPWR.t587 5.97235
R716 VPWR.n583 VPWR.t521 5.97235
R717 VPWR.n10 VPWR.t665 5.97235
R718 VPWR.n548 VPWR.t1540 5.97235
R719 VPWR.n476 VPWR.t1503 5.97235
R720 VPWR.n942 VPWR.t796 5.97212
R721 VPWR.n936 VPWR.t793 5.97212
R722 VPWR.n928 VPWR.t788 5.97212
R723 VPWR.n932 VPWR.t792 5.97212
R724 VPWR.n845 VPWR.t892 5.97212
R725 VPWR.n841 VPWR.t896 5.97212
R726 VPWR.n902 VPWR.t541 5.97212
R727 VPWR.n906 VPWR.t545 5.97212
R728 VPWR.n207 VPWR.t167 5.97212
R729 VPWR.n201 VPWR.t163 5.97212
R730 VPWR.n221 VPWR.t602 5.97212
R731 VPWR.n215 VPWR.t599 5.97212
R732 VPWR.n770 VPWR.t1224 5.97212
R733 VPWR.n765 VPWR.t1220 5.97212
R734 VPWR.n701 VPWR.t714 5.97212
R735 VPWR.n705 VPWR.t718 5.97212
R736 VPWR.n649 VPWR.t460 5.97212
R737 VPWR.n644 VPWR.t457 5.97212
R738 VPWR.n348 VPWR.t1289 5.97212
R739 VPWR.n342 VPWR.t1286 5.97212
R740 VPWR.n392 VPWR.t922 5.97212
R741 VPWR.n398 VPWR.t919 5.97212
R742 VPWR.n520 VPWR.t1266 5.97212
R743 VPWR.n515 VPWR.t1263 5.97212
R744 VPWR.n452 VPWR.t1525 5.97212
R745 VPWR.n448 VPWR.t1521 5.97212
R746 VPWR.n932 VPWR.t568 5.97192
R747 VPWR.n933 VPWR.t897 5.97192
R748 VPWR.n72 VPWR.t218 5.97192
R749 VPWR.n841 VPWR.t864 5.97192
R750 VPWR.n839 VPWR.t865 5.97192
R751 VPWR.n228 VPWR.t725 5.97192
R752 VPWR.n231 VPWR.t1545 5.97192
R753 VPWR.n821 VPWR.t593 5.97192
R754 VPWR.n705 VPWR.t1208 5.97192
R755 VPWR.n633 VPWR.t690 5.97192
R756 VPWR.n589 VPWR.t1432 5.97192
R757 VPWR.n350 VPWR.t816 5.97192
R758 VPWR.n383 VPWR.t1261 5.97192
R759 VPWR.n518 VPWR.t1476 5.97192
R760 VPWR.n96 VPWR.t489 5.97169
R761 VPWR.n92 VPWR.t492 5.97169
R762 VPWR.n960 VPWR.t179 5.97169
R763 VPWR.n966 VPWR.t183 5.97169
R764 VPWR.n883 VPWR.t760 5.97169
R765 VPWR.n887 VPWR.t763 5.97169
R766 VPWR.n902 VPWR.t755 5.97169
R767 VPWR.n906 VPWR.t759 5.97169
R768 VPWR.n186 VPWR.t1227 5.97169
R769 VPWR.n193 VPWR.t1364 5.97169
R770 VPWR.n199 VPWR.t1367 5.97169
R771 VPWR.n753 VPWR.t1333 5.97169
R772 VPWR.n747 VPWR.t1337 5.97169
R773 VPWR.n29 VPWR.t1339 5.97169
R774 VPWR.n253 VPWR.t473 5.97169
R775 VPWR.n249 VPWR.t476 5.97169
R776 VPWR.n708 VPWR.t1205 5.97169
R777 VPWR.n709 VPWR.t228 5.97169
R778 VPWR.n715 VPWR.t231 5.97169
R779 VPWR.n597 VPWR.t832 5.97169
R780 VPWR.n591 VPWR.t836 5.97169
R781 VPWR.n671 VPWR.t685 5.97169
R782 VPWR.n677 VPWR.t689 5.97169
R783 VPWR.n332 VPWR.t644 5.97169
R784 VPWR.n296 VPWR.t647 5.97169
R785 VPWR.n353 VPWR.t810 5.97169
R786 VPWR.n369 VPWR.t819 5.97169
R787 VPWR.n435 VPWR.t1473 5.97169
R788 VPWR.n541 VPWR.t1468 5.97169
R789 VPWR.n547 VPWR.t1472 5.97169
R790 VPWR.n550 VPWR.t1487 5.97169
R791 VPWR.n556 VPWR.t1490 5.97169
R792 VPWR.n107 VPWR.t993 5.97001
R793 VPWR.n105 VPWR.t996 5.97001
R794 VPWR.n103 VPWR.t997 5.97001
R795 VPWR.n116 VPWR.t1000 5.97001
R796 VPWR.n118 VPWR.t1001 5.97001
R797 VPWR.n913 VPWR.t1004 5.97001
R798 VPWR.n99 VPWR.t1005 5.97001
R799 VPWR.n918 VPWR.t1594 5.97001
R800 VPWR.n859 VPWR.t443 5.97001
R801 VPWR.n865 VPWR.t446 5.97001
R802 VPWR.n867 VPWR.t447 5.97001
R803 VPWR.n857 VPWR.t40 5.97001
R804 VPWR.n855 VPWR.t41 5.97001
R805 VPWR.n828 VPWR.t44 5.97001
R806 VPWR.n876 VPWR.t45 5.97001
R807 VPWR.n881 VPWR.t1048 5.97001
R808 VPWR.n829 VPWR.t29 5.97001
R809 VPWR.n136 VPWR.t940 5.97001
R810 VPWR.n142 VPWR.t943 5.97001
R811 VPWR.n144 VPWR.t944 5.97001
R812 VPWR.n134 VPWR.t947 5.97001
R813 VPWR.n132 VPWR.t948 5.97001
R814 VPWR.n124 VPWR.t951 5.97001
R815 VPWR.n153 VPWR.t952 5.97001
R816 VPWR.n129 VPWR.t969 5.97001
R817 VPWR.n793 VPWR.t569 5.97001
R818 VPWR.n791 VPWR.t572 5.97001
R819 VPWR.n789 VPWR.t573 5.97001
R820 VPWR.n802 VPWR.t576 5.97001
R821 VPWR.n804 VPWR.t577 5.97001
R822 VPWR.n810 VPWR.t405 5.97001
R823 VPWR.n785 VPWR.t406 5.97001
R824 VPWR.n817 VPWR.t410 5.97001
R825 VPWR.n816 VPWR.t409 5.97001
R826 VPWR.n778 VPWR.t414 5.97001
R827 VPWR.n780 VPWR.t413 5.97001
R828 VPWR.n17 VPWR.t417 5.97001
R829 VPWR.n772 VPWR.t420 5.97001
R830 VPWR.n739 VPWR.t423 5.97001
R831 VPWR.n742 VPWR.t422 5.97001
R832 VPWR.t195 VPWR.t426 5.97001
R833 VPWR.n264 VPWR.t1085 5.97001
R834 VPWR.n262 VPWR.t1088 5.97001
R835 VPWR.n260 VPWR.t1089 5.97001
R836 VPWR.n273 VPWR.t1092 5.97001
R837 VPWR.n275 VPWR.t1093 5.97001
R838 VPWR.n686 VPWR.t1096 5.97001
R839 VPWR.n256 VPWR.t1097 5.97001
R840 VPWR.n707 VPWR.t79 5.97001
R841 VPWR.n691 VPWR.t1606 5.97001
R842 VPWR.n242 VPWR.t82 5.97001
R843 VPWR.n611 VPWR.t344 5.97001
R844 VPWR.n617 VPWR.t347 5.97001
R845 VPWR.n619 VPWR.t348 5.97001
R846 VPWR.n609 VPWR.t351 5.97001
R847 VPWR.n607 VPWR.t352 5.97001
R848 VPWR.n572 VPWR.t355 5.97001
R849 VPWR.n628 VPWR.t356 5.97001
R850 VPWR.n634 VPWR.t63 5.97001
R851 VPWR.n604 VPWR.t62 5.97001
R852 VPWR.n640 VPWR.t66 5.97001
R853 VPWR.n307 VPWR.t321 5.97001
R854 VPWR.n305 VPWR.t324 5.97001
R855 VPWR.n303 VPWR.t325 5.97001
R856 VPWR.n316 VPWR.t328 5.97001
R857 VPWR.n318 VPWR.t329 5.97001
R858 VPWR.n282 VPWR.t1167 5.97001
R859 VPWR.n299 VPWR.t1168 5.97001
R860 VPWR.n328 VPWR.t307 5.97001
R861 VPWR.n327 VPWR.t1171 5.97001
R862 VPWR.n293 VPWR.t311 5.97001
R863 VPWR.n295 VPWR.t310 5.97001
R864 VPWR.n10 VPWR.t1051 5.97001
R865 VPWR.n336 VPWR.t314 5.97001
R866 VPWR.n7 VPWR.t1054 5.97001
R867 VPWR.n7 VPWR.t1053 5.97001
R868 VPWR.t118 VPWR.t1057 5.97001
R869 VPWR.n376 VPWR.t1056 5.97001
R870 VPWR.n401 VPWR.t1030 5.97001
R871 VPWR.n426 VPWR.t91 5.97001
R872 VPWR.n20 VPWR.t95 5.97001
R873 VPWR.n432 VPWR.t94 5.97001
R874 VPWR.n439 VPWR.t99 5.97001
R875 VPWR.n436 VPWR.t98 5.97001
R876 VPWR.n13 VPWR.t11 5.97001
R877 VPWR.n13 VPWR.t10 5.97001
R878 VPWR.n418 VPWR.t988 5.97001
R879 VPWR.n551 VPWR.t100 5.97001
R880 VPWR.n559 VPWR.t1028 5.97001
R881 VPWR.n557 VPWR.t1027 5.97001
R882 VPWR.n486 VPWR.t385 5.97001
R883 VPWR.n457 VPWR.t1021 5.97001
R884 VPWR.n461 VPWR.t1020 5.97001
R885 VPWR.n500 VPWR.t1585 5.97001
R886 VPWR.n495 VPWR.t294 5.97001
R887 VPWR.n491 VPWR.t981 5.97001
R888 VPWR.n107 VPWR.t451 5.96957
R889 VPWR.n105 VPWR.t454 5.96957
R890 VPWR.n103 VPWR.t455 5.96957
R891 VPWR.n116 VPWR.t48 5.96957
R892 VPWR.n118 VPWR.t49 5.96957
R893 VPWR.n913 VPWR.t52 5.96957
R894 VPWR.n99 VPWR.t53 5.96957
R895 VPWR.n918 VPWR.t1050 5.96957
R896 VPWR.n859 VPWR.t954 5.96957
R897 VPWR.n865 VPWR.t957 5.96957
R898 VPWR.n867 VPWR.t958 5.96957
R899 VPWR.n857 VPWR.t961 5.96957
R900 VPWR.n855 VPWR.t962 5.96957
R901 VPWR.n828 VPWR.t965 5.96957
R902 VPWR.n876 VPWR.t966 5.96957
R903 VPWR.n881 VPWR.t971 5.96957
R904 VPWR.n829 VPWR.t1590 5.96957
R905 VPWR.n136 VPWR.t578 5.96957
R906 VPWR.n142 VPWR.t581 5.96957
R907 VPWR.n144 VPWR.t582 5.96957
R908 VPWR.n134 VPWR.t585 5.96957
R909 VPWR.n132 VPWR.t586 5.96957
R910 VPWR.n124 VPWR.t428 5.96957
R911 VPWR.n153 VPWR.t429 5.96957
R912 VPWR.n129 VPWR.t432 5.96957
R913 VPWR.n127 VPWR.t433 5.96957
R914 VPWR.n162 VPWR.t436 5.96957
R915 VPWR.n793 VPWR.t1101 5.96957
R916 VPWR.n791 VPWR.t1104 5.96957
R917 VPWR.n789 VPWR.t1105 5.96957
R918 VPWR.n802 VPWR.t1108 5.96957
R919 VPWR.n804 VPWR.t1109 5.96957
R920 VPWR.n810 VPWR.t1112 5.96957
R921 VPWR.n785 VPWR.t1113 5.96957
R922 VPWR.n816 VPWR.t1608 5.96957
R923 VPWR.n745 VPWR.t83 5.96957
R924 VPWR.n759 VPWR.t86 5.96957
R925 VPWR.n762 VPWR.t87 5.96957
R926 VPWR.n763 VPWR.t90 5.96957
R927 VPWR.n29 VPWR.t1115 5.96957
R928 VPWR.n264 VPWR.t362 5.96957
R929 VPWR.n262 VPWR.t365 5.96957
R930 VPWR.n260 VPWR.t366 5.96957
R931 VPWR.n273 VPWR.t369 5.96957
R932 VPWR.n275 VPWR.t370 5.96957
R933 VPWR.n686 VPWR.t373 5.96957
R934 VPWR.n256 VPWR.t374 5.96957
R935 VPWR.n691 VPWR.t68 5.96957
R936 VPWR.n611 VPWR.t331 5.96957
R937 VPWR.n617 VPWR.t334 5.96957
R938 VPWR.n619 VPWR.t335 5.96957
R939 VPWR.n609 VPWR.t338 5.96957
R940 VPWR.n607 VPWR.t339 5.96957
R941 VPWR.n572 VPWR.t1173 5.96957
R942 VPWR.n628 VPWR.t1174 5.96957
R943 VPWR.n604 VPWR.t1177 5.96957
R944 VPWR.n679 VPWR.t1062 5.96957
R945 VPWR.n307 VPWR.t102 5.96957
R946 VPWR.n305 VPWR.t105 5.96957
R947 VPWR.n303 VPWR.t106 5.96957
R948 VPWR.n316 VPWR.t109 5.96957
R949 VPWR.n318 VPWR.t110 5.96957
R950 VPWR.n282 VPWR.t15 5.96957
R951 VPWR.n299 VPWR.t16 5.96957
R952 VPWR.n327 VPWR.t992 5.96957
R953 VPWR.n10 VPWR.t1031 5.96957
R954 VPWR.n284 VPWR.t112 5.96957
R955 VPWR.n7 VPWR.t113 5.96957
R956 VPWR.n373 VPWR.t116 5.96957
R957 VPWR.n375 VPWR.t117 5.96957
R958 VPWR.n426 VPWR.t982 5.96957
R959 VPWR.n432 VPWR.t985 5.96957
R960 VPWR.n13 VPWR.t1586 5.96957
R961 VPWR.n422 VPWR.t1589 5.96957
R962 VPWR.n419 VPWR.t226 5.96957
R963 VPWR.n514 VPWR.t76 5.96957
R964 VPWR.n209 VPWR.t975 5.96091
R965 VPWR.n17 VPWR.t418 5.96091
R966 VPWR.n24 VPWR.t990 5.96091
R967 VPWR.n455 VPWR.t1023 5.96091
R968 VPWR.n164 VPWR.t437 5.96047
R969 VPWR.n434 VPWR.t986 5.96047
R970 VPWR.t4 VPWR.t3 0.733596
R971 VPWR.n108 VPWR.t452 5.65005
R972 VPWR.n109 VPWR.t994 5.65005
R973 VPWR.n112 VPWR.t47 5.65005
R974 VPWR.n113 VPWR.t998 5.65005
R975 VPWR.n119 VPWR.t50 5.65005
R976 VPWR.n120 VPWR.t1002 5.65005
R977 VPWR.n915 VPWR.t54 5.65005
R978 VPWR.n916 VPWR.t1006 5.65005
R979 VPWR.n861 VPWR.t955 5.65005
R980 VPWR.n862 VPWR.t444 5.65005
R981 VPWR.n868 VPWR.t959 5.65005
R982 VPWR.n869 VPWR.t39 5.65005
R983 VPWR.n872 VPWR.t963 5.65005
R984 VPWR.n873 VPWR.t42 5.65005
R985 VPWR.n877 VPWR.t967 5.65005
R986 VPWR.n878 VPWR.t46 5.65005
R987 VPWR.n138 VPWR.t579 5.65005
R988 VPWR.n139 VPWR.t941 5.65005
R989 VPWR.n145 VPWR.t583 5.65005
R990 VPWR.n146 VPWR.t945 5.65005
R991 VPWR.n149 VPWR.t427 5.65005
R992 VPWR.n150 VPWR.t949 5.65005
R993 VPWR.n154 VPWR.t430 5.65005
R994 VPWR.n155 VPWR.t953 5.65005
R995 VPWR.n158 VPWR.t434 5.65005
R996 VPWR.n794 VPWR.t1102 5.65005
R997 VPWR.n795 VPWR.t570 5.65005
R998 VPWR.n798 VPWR.t1106 5.65005
R999 VPWR.n799 VPWR.t574 5.65005
R1000 VPWR.n805 VPWR.t1110 5.65005
R1001 VPWR.n806 VPWR.t404 5.65005
R1002 VPWR.n812 VPWR.t1114 5.65005
R1003 VPWR.n813 VPWR.t407 5.65005
R1004 VPWR.n819 VPWR.t411 5.65005
R1005 VPWR.n16 VPWR.t415 5.65005
R1006 VPWR.n37 VPWR.t84 5.65005
R1007 VPWR.n32 VPWR.t88 5.65005
R1008 VPWR.n28 VPWR.t421 5.65005
R1009 VPWR.n738 VPWR.t1116 5.65005
R1010 VPWR.n773 VPWR.t424 5.65005
R1011 VPWR.n265 VPWR.t363 5.65005
R1012 VPWR.n266 VPWR.t1086 5.65005
R1013 VPWR.n269 VPWR.t367 5.65005
R1014 VPWR.n270 VPWR.t1090 5.65005
R1015 VPWR.n276 VPWR.t371 5.65005
R1016 VPWR.n277 VPWR.t1094 5.65005
R1017 VPWR.n688 VPWR.t67 5.65005
R1018 VPWR.n689 VPWR.t1098 5.65005
R1019 VPWR.n41 VPWR.t80 5.65005
R1020 VPWR.n613 VPWR.t332 5.65005
R1021 VPWR.n614 VPWR.t345 5.65005
R1022 VPWR.n620 VPWR.t336 5.65005
R1023 VPWR.n621 VPWR.t349 5.65005
R1024 VPWR.n624 VPWR.t340 5.65005
R1025 VPWR.n625 VPWR.t353 5.65005
R1026 VPWR.n629 VPWR.t1175 5.65005
R1027 VPWR.n630 VPWR.t61 5.65005
R1028 VPWR.n636 VPWR.t64 5.65005
R1029 VPWR.n44 VPWR.t1063 5.65005
R1030 VPWR.n308 VPWR.t103 5.65005
R1031 VPWR.n309 VPWR.t322 5.65005
R1032 VPWR.n312 VPWR.t107 5.65005
R1033 VPWR.n313 VPWR.t326 5.65005
R1034 VPWR.n319 VPWR.t14 5.65005
R1035 VPWR.n320 VPWR.t330 5.65005
R1036 VPWR.n323 VPWR.t17 5.65005
R1037 VPWR.n324 VPWR.t1169 5.65005
R1038 VPWR.n330 VPWR.t308 5.65005
R1039 VPWR.n47 VPWR.t312 5.65005
R1040 VPWR.n9 VPWR.t111 5.65005
R1041 VPWR.n283 VPWR.t1052 5.65005
R1042 VPWR.n6 VPWR.t114 5.65005
R1043 VPWR.n371 VPWR.t1055 5.65005
R1044 VPWR.n428 VPWR.t983 5.65005
R1045 VPWR.n429 VPWR.t92 5.65005
R1046 VPWR.n22 VPWR.t96 5.65005
R1047 VPWR.n441 VPWR.t9 5.65005
R1048 VPWR.n12 VPWR.t1587 5.65005
R1049 VPWR.n421 VPWR.t12 5.65005
R1050 VPWR.n24 VPWR.t75 5.65005
R1051 VPWR.n553 VPWR.t101 5.65005
R1052 VPWR.n51 VPWR.t1029 5.65005
R1053 VPWR.n484 VPWR.t384 5.65005
R1054 VPWR.n458 VPWR.t1019 5.65005
R1055 VPWR.n497 VPWR.t293 5.65005
R1056 VPWR.n488 VPWR.t979 5.65005
R1057 VPWR.n188 VPWR.t438 5.64493
R1058 VPWR.n211 VPWR.t976 5.64493
R1059 VPWR.n776 VPWR.t419 5.64493
R1060 VPWR.n21 VPWR.t987 5.64493
R1061 VPWR.n511 VPWR.t989 5.64493
R1062 VPWR.n479 VPWR.t1022 5.64493
R1063 VPWR.t20 VPWR.n919 5.64096
R1064 VPWR.t20 VPWR.n101 5.64096
R1065 VPWR.t20 VPWR.n115 5.64096
R1066 VPWR.t20 VPWR.n106 5.64096
R1067 VPWR.t28 VPWR.n853 5.64096
R1068 VPWR.t28 VPWR.n875 5.64096
R1069 VPWR.t28 VPWR.n858 5.64096
R1070 VPWR.t28 VPWR.n864 5.64096
R1071 VPWR.t70 VPWR.n160 5.64096
R1072 VPWR.t70 VPWR.n130 5.64096
R1073 VPWR.t70 VPWR.n152 5.64096
R1074 VPWR.t70 VPWR.n135 5.64096
R1075 VPWR.t70 VPWR.n141 5.64096
R1076 VPWR.t5 VPWR.n775 5.64096
R1077 VPWR.t5 VPWR.n782 5.64096
R1078 VPWR.t5 VPWR.n815 5.64096
R1079 VPWR.t5 VPWR.n787 5.64096
R1080 VPWR.t5 VPWR.n801 5.64096
R1081 VPWR.t5 VPWR.n792 5.64096
R1082 VPWR.t3 VPWR.n692 5.64096
R1083 VPWR.t3 VPWR.n258 5.64096
R1084 VPWR.t3 VPWR.n272 5.64096
R1085 VPWR.t3 VPWR.n263 5.64096
R1086 VPWR.t55 VPWR.n638 5.64096
R1087 VPWR.t55 VPWR.n605 5.64096
R1088 VPWR.t55 VPWR.n627 5.64096
R1089 VPWR.t55 VPWR.n610 5.64096
R1090 VPWR.t55 VPWR.n616 5.64096
R1091 VPWR.t13 VPWR.n297 5.64096
R1092 VPWR.t13 VPWR.n326 5.64096
R1093 VPWR.t13 VPWR.n301 5.64096
R1094 VPWR.t13 VPWR.n315 5.64096
R1095 VPWR.t13 VPWR.n306 5.64096
R1096 VPWR.t8 VPWR.n555 5.64096
R1097 VPWR.t8 VPWR.n14 1.99043
R1098 VPWR.t8 VPWR.n431 5.64096
R1099 VPWR.n496 VPWR.t292 5.64013
R1100 VPWR.t292 VPWR.n454 5.64013
R1101 VPWR.n4 VPWR.n486 0.222554
R1102 VPWR.t20 VPWR.n111 5.62104
R1103 VPWR.t28 VPWR.n860 5.62104
R1104 VPWR.t70 VPWR.n137 5.62104
R1105 VPWR.t5 VPWR.n797 5.62104
R1106 VPWR.t3 VPWR.n268 5.62104
R1107 VPWR.t55 VPWR.n612 5.62104
R1108 VPWR.t13 VPWR.n311 5.62104
R1109 VPWR.t8 VPWR.n427 5.62104
R1110 VPWR.t20 VPWR.n921 5.61485
R1111 VPWR.t20 VPWR.n97 5.61485
R1112 VPWR.t28 VPWR.n895 5.61485
R1113 VPWR.t28 VPWR.n852 5.61485
R1114 VPWR.t28 VPWR.n882 5.61485
R1115 VPWR.t70 VPWR.n191 5.61485
R1116 VPWR.t3 VPWR.n694 5.61485
R1117 VPWR.t3 VPWR.n254 5.61485
R1118 VPWR.t13 VPWR.n357 5.61485
R1119 VPWR.n494 VPWR.t292 5.61485
R1120 VPWR.t292 VPWR.n59 5.61485
R1121 VPWR.t292 VPWR.n465 5.61485
R1122 VPWR.t292 VPWR.n453 5.61485
R1123 VPWR.t292 VPWR.n463 5.61485
R1124 VPWR.t292 VPWR.n483 5.61485
R1125 VPWR.n510 VPWR.n502 5.16578
R1126 VPWR.n561 VPWR.t911 5.16578
R1127 VPWR.t18 VPWR.n973 4.9845
R1128 VPWR.n13 VPWR.n510 4.5005
R1129 VPWR.n570 VPWR.n569 4.5005
R1130 VPWR.n683 VPWR.n682 4.5005
R1131 VPWR.n685 VPWR.n684 4.5005
R1132 VPWR.n809 VPWR.n123 4.5005
R1133 VPWR.n827 VPWR.n826 4.5005
R1134 VPWR.n909 VPWR.n908 4.5005
R1135 VPWR.n912 VPWR.n911 4.5005
R1136 VPWR.n974 VPWR.t77 4.5005
R1137 VPWR.n561 VPWR.t129 4.5005
R1138 VPWR.t133 VPWR.n567 4.5005
R1139 VPWR.t905 VPWR.n233 4.5005
R1140 VPWR.n735 VPWR.t245 4.5005
R1141 VPWR.n823 VPWR.t342 4.5005
R1142 VPWR.t319 VPWR.n824 4.5005
R1143 VPWR.n968 VPWR.t288 4.5005
R1144 VPWR.n506 VPWR.n280 4.49573
R1145 VPWR.n973 VPWR.n972 4.49573
R1146 VPWR.n978 VPWR.n977 4.49046
R1147 VPWR.n976 VPWR.n63 4.49046
R1148 VPWR.n978 VPWR.n64 4.49046
R1149 VPWR.n504 VPWR.n503 4.49046
R1150 VPWR.n508 VPWR.n507 4.49046
R1151 VPWR.n565 VPWR.n380 4.49046
R1152 VPWR.n564 VPWR.n379 4.49046
R1153 VPWR.n563 VPWR.n380 4.49046
R1154 VPWR.n971 VPWR.n68 4.49046
R1155 VPWR.n969 VPWR.n67 4.49046
R1156 VPWR.n487 VPWR.t292 4.20293
R1157 VPWR.n492 VPWR.t292 3.30723
R1158 VPWR.t292 VPWR.n61 2.00611
R1159 VPWR.t292 VPWR.n478 2.72142
R1160 VPWR.n62 VPWR.t292 1.99426
R1161 VPWR.t20 VPWR.n70 2.72092
R1162 VPWR.n507 VPWR.n379 2.17938
R1163 VPWR.n971 VPWR.n63 2.17938
R1164 VPWR.n485 VPWR.t292 1.75382
R1165 VPWR.t0 VPWR.t185 1.34764
R1166 VPWR.t0 VPWR.t284 1.28728
R1167 VPWR.t28 VPWR.t202 0.268393
R1168 VPWR.n26 VPWR.n69 4.87397
R1169 VPWR.t880 VPWR.t21 1.16606
R1170 VPWR.t19 VPWR.t6 1.11104
R1171 VPWR.n19 VPWR.t837 0.0104222
R1172 VPWR.t304 VPWR.t133 1.08467
R1173 VPWR.t56 VPWR.t905 1.08195
R1174 VPWR.t930 VPWR.t631 1.07797
R1175 VPWR.t189 VPWR.n5 0.00321781
R1176 VPWR.t32 VPWR.t30 1.06555
R1177 VPWR.t72 VPWR.t71 1.06077
R1178 VPWR.t6 VPWR.t7 1.05789
R1179 VPWR.t37 VPWR.t18 1.04832
R1180 VPWR.t1 VPWR.n65 1.0476
R1181 VPWR.t562 VPWR.t357 1.04727
R1182 VPWR.n736 VPWR.t136 1.04625
R1183 VPWR.t292 VPWR.t911 1.03097
R1184 VPWR.t382 VPWR.t381 1.02346
R1185 VPWR.t129 VPWR.n382 1.01996
R1186 VPWR.t360 VPWR.t905 1.01797
R1187 VPWR.t21 VPWR.t281 1.01784
R1188 VPWR.t131 VPWR.t130 1.01476
R1189 VPWR.t24 VPWR.t1025 1.01428
R1190 VPWR.n3 VPWR.t315 0.00205267
R1191 VPWR.t19 VPWR.t78 1.00662
R1192 VPWR.t123 VPWR.t125 1.00499
R1193 VPWR.t77 VPWR.t78 0.997282
R1194 VPWR.t118 VPWR.t123 0.994964
R1195 VPWR.t38 VPWR.n56 0.849196
R1196 VPWR.t1065 VPWR.t562 0.980553
R1197 VPWR.n384 VPWR.t930 0.967265
R1198 VPWR.t360 VPWR.t357 0.959645
R1199 VPWR.n382 VPWR.t631 0.957928
R1200 VPWR.n1 VPWR.t245 0.339399
R1201 VPWR.n736 VPWR.t195 0.94065
R1202 VPWR.n65 VPWR.t24 0.927858
R1203 VPWR.t281 VPWR.t1077 0.924442
R1204 VPWR.t125 VPWR.t130 0.905559
R1205 VPWR.n35 VPWR.t72 0.047952
R1206 VPWR.t1077 VPWR.t20 0.882501
R1207 VPWR.t129 VPWR.n381 0.855139
R1208 VPWR.t342 VPWR.t149 0.853209
R1209 VPWR.t136 VPWR.t149 0.850283
R1210 VPWR.t297 VPWR.n381 0.848722
R1211 VPWR.t1025 VPWR.t7 0.834838
R1212 VPWR.t904 VPWR.t304 0.826615
R1213 VPWR.t288 VPWR.t1077 0.803556
R1214 VPWR.t382 VPWR.n26 0.177362
R1215 VPWR.t34 VPWR.t32 0.718
R1216 VPWR.n1 VPWR.t190 0.67679
R1217 VPWR.n2 VPWR.t319 0.0124327
R1218 VPWR.n911 VPWR.n909 0.66578
R1219 VPWR.n909 VPWR.n827 0.66578
R1220 VPWR.n827 VPWR.n123 0.66578
R1221 VPWR.n684 VPWR.n123 0.66578
R1222 VPWR.n684 VPWR.n683 0.66578
R1223 VPWR.n683 VPWR.n570 0.66578
R1224 VPWR.n968 VPWR.n69 0.66578
R1225 VPWR.n824 VPWR.n69 0.66578
R1226 VPWR.n824 VPWR.n823 0.66578
R1227 VPWR.n823 VPWR.n735 0.66578
R1228 VPWR.n735 VPWR.n233 0.66578
R1229 VPWR.n567 VPWR.n233 0.66578
R1230 VPWR.n4 VPWR.t292 0.739986
R1231 VPWR.t5 VPWR.t149 0.636529
R1232 VPWR.t185 VPWR.t18 0.621806
R1233 VPWR.n0 VPWR.n829 0.00630072
R1234 VPWR.t20 VPWR.t32 0.614103
R1235 VPWR.t13 VPWR.t123 0.604965
R1236 VPWR.t13 VPWR.t130 0.604686
R1237 VPWR.t0 VPWR.t1025 0.604558
R1238 VPWR.t1 VPWR.t185 0.562356
R1239 VPWR.t55 VPWR.t562 0.552247
R1240 VPWR.t0 VPWR.n65 0.552196
R1241 VPWR.n485 VPWR.t296 0.524107
R1242 VPWR.t70 VPWR.n35 0.446131
R1243 VPWR.n382 VPWR.t8 0.505694
R1244 VPWR.t8 VPWR.t930 0.505218
R1245 VPWR.t55 VPWR.t360 0.505164
R1246 VPWR.n975 VPWR.n974 0.4845
R1247 VPWR.n56 VPWR.t37 0.0453158
R1248 VPWR VPWR.n978 0.42994
R1249 VPWR.t0 VPWR.t6 0.399095
R1250 VPWR.t8 VPWR.n381 0.391967
R1251 VPWR.t13 VPWR.t304 0.384234
R1252 VPWR.t914 VPWR.n62 0.478293
R1253 VPWR.t55 VPWR.t56 0.3799
R1254 VPWR.n61 VPWR.t913 0.0865478
R1255 VPWR.n70 VPWR.t288 0.355888
R1256 VPWR.n974 VPWR 0.3525
R1257 VPWR.n478 VPWR.n477 0.339861
R1258 VPWR.n478 VPWR.n476 0.334092
R1259 VPWR.n510 VPWR.n509 0.31202
R1260 VPWR.n562 VPWR.n561 0.31202
R1261 VPWR.t20 VPWR.t21 0.294144
R1262 VPWR.t0 VPWR.t78 0.291807
R1263 VPWR.n493 VPWR.n492 0.283933
R1264 VPWR.n492 VPWR.n491 0.248945
R1265 VPWR.n70 VPWR.t30 0.235241
R1266 VPWR.n570 VPWR.n280 0.22754
R1267 VPWR.n567 VPWR.n566 0.22754
R1268 VPWR.n502 VPWR.n59 0.200486
R1269 VPWR.t913 VPWR.t911 0.199137
R1270 VPWR.n477 VPWR.n59 0.195825
R1271 VPWR.n483 VPWR.n482 0.195486
R1272 VPWR.n463 VPWR.n462 0.195486
R1273 VPWR.n494 VPWR.n493 0.195486
R1274 VPWR.n106 VPWR.n105 0.190118
R1275 VPWR.n116 VPWR.n115 0.190118
R1276 VPWR.n913 VPWR.n101 0.190118
R1277 VPWR.n919 VPWR.n918 0.190118
R1278 VPWR.n865 VPWR.n864 0.190118
R1279 VPWR.n858 VPWR.n857 0.190118
R1280 VPWR.n875 VPWR.n828 0.190118
R1281 VPWR.n881 VPWR.n853 0.190118
R1282 VPWR.n142 VPWR.n141 0.190118
R1283 VPWR.n135 VPWR.n134 0.190118
R1284 VPWR.n152 VPWR.n124 0.190118
R1285 VPWR.n130 VPWR.n129 0.190118
R1286 VPWR.n792 VPWR.n791 0.190118
R1287 VPWR.n802 VPWR.n801 0.190118
R1288 VPWR.n810 VPWR.n787 0.190118
R1289 VPWR.n816 VPWR.n815 0.190118
R1290 VPWR.t195 VPWR.n775 0.190118
R1291 VPWR.n263 VPWR.n262 0.190118
R1292 VPWR.n273 VPWR.n272 0.190118
R1293 VPWR.n686 VPWR.n258 0.190118
R1294 VPWR.n692 VPWR.n691 0.190118
R1295 VPWR.n617 VPWR.n616 0.190118
R1296 VPWR.n610 VPWR.n609 0.190118
R1297 VPWR.n627 VPWR.n572 0.190118
R1298 VPWR.n605 VPWR.n604 0.190118
R1299 VPWR.n306 VPWR.n305 0.190118
R1300 VPWR.n316 VPWR.n315 0.190118
R1301 VPWR.n301 VPWR.n282 0.190118
R1302 VPWR.n327 VPWR.n326 0.190118
R1303 VPWR.n432 VPWR.n431 0.190118
R1304 VPWR.n461 VPWR.n454 0.183859
R1305 VPWR.n496 VPWR.n495 0.183859
R1306 VPWR.n920 VPWR.n87 0.173289
R1307 VPWR.n923 VPWR.n922 0.173289
R1308 VPWR.n893 VPWR.n892 0.173289
R1309 VPWR.n851 VPWR.n850 0.173289
R1310 VPWR.n894 VPWR.n830 0.173289
R1311 VPWR.n897 VPWR.n896 0.173289
R1312 VPWR.n190 VPWR.n178 0.173289
R1313 VPWR.n693 VPWR.n244 0.173289
R1314 VPWR.n696 VPWR.n695 0.173289
R1315 VPWR.n340 VPWR.n338 0.173289
R1316 VPWR.n467 VPWR.n466 0.173289
R1317 VPWR.n464 VPWR.n443 0.173289
R1318 VPWR.n460 VPWR.n457 0.169539
R1319 VPWR.n500 VPWR.n499 0.169539
R1320 VPWR.n491 VPWR.n490 0.169539
R1321 VPWR.n189 VPWR.n188 0.16689
R1322 VPWR.n15 VPWR.n776 0.166554
R1323 VPWR.n480 VPWR.n479 0.166554
R1324 VPWR.n462 VPWR.n453 0.165825
R1325 VPWR.n103 VPWR.n102 0.162039
R1326 VPWR.n122 VPWR.n118 0.162039
R1327 VPWR.n99 VPWR.n98 0.162039
R1328 VPWR.n871 VPWR.n867 0.162039
R1329 VPWR.n855 VPWR.n854 0.162039
R1330 VPWR.n880 VPWR.n876 0.162039
R1331 VPWR.n148 VPWR.n144 0.162039
R1332 VPWR.n132 VPWR.n131 0.162039
R1333 VPWR.n157 VPWR.n153 0.162039
R1334 VPWR.n127 VPWR.n126 0.162039
R1335 VPWR.n789 VPWR.n788 0.162039
R1336 VPWR.n808 VPWR.n804 0.162039
R1337 VPWR.n785 VPWR.n784 0.162039
R1338 VPWR.n34 VPWR.n762 0.281447
R1339 VPWR.n739 VPWR.n737 0.162039
R1340 VPWR.n260 VPWR.n259 0.162039
R1341 VPWR.n279 VPWR.n275 0.162039
R1342 VPWR.n256 VPWR.n255 0.162039
R1343 VPWR.n623 VPWR.n619 0.162039
R1344 VPWR.n607 VPWR.n606 0.162039
R1345 VPWR.n632 VPWR.n628 0.162039
R1346 VPWR.n303 VPWR.n302 0.162039
R1347 VPWR.n322 VPWR.n318 0.162039
R1348 VPWR.n300 VPWR.n299 0.162039
R1349 VPWR.n22 VPWR.n20 0.162039
R1350 VPWR.n89 VPWR.n88 0.158289
R1351 VPWR.n925 VPWR.n924 0.158289
R1352 VPWR.n891 VPWR.n890 0.158289
R1353 VPWR.n849 VPWR.n848 0.158289
R1354 VPWR.n832 VPWR.n831 0.158289
R1355 VPWR.n899 VPWR.n898 0.158289
R1356 VPWR.n180 VPWR.n179 0.158289
R1357 VPWR.n246 VPWR.n245 0.158289
R1358 VPWR.n698 VPWR.n697 0.158289
R1359 VPWR.n362 VPWR.n361 0.158289
R1360 VPWR.n469 VPWR.n468 0.158289
R1361 VPWR.n445 VPWR.n444 0.158289
R1362 VPWR.n97 VPWR.n96 0.157986
R1363 VPWR.n883 VPWR.n882 0.157986
R1364 VPWR.n254 VPWR.n253 0.157986
R1365 VPWR.n453 VPWR.n452 0.157986
R1366 VPWR.n481 VPWR.n480 0.153289
R1367 VPWR.n161 VPWR.n160 0.152618
R1368 VPWR.n782 VPWR.n781 0.148868
R1369 VPWR.n639 VPWR.n638 0.148868
R1370 VPWR.n297 VPWR.n296 0.148868
R1371 VPWR.n556 VPWR.n555 0.148868
R1372 VPWR.n96 VPWR.n95 0.143289
R1373 VPWR.n91 VPWR.n90 0.143289
R1374 VPWR.n927 VPWR.n926 0.143289
R1375 VPWR.n932 VPWR.n931 0.143289
R1376 VPWR.n72 VPWR.n71 0.143289
R1377 VPWR.n884 VPWR.n883 0.143289
R1378 VPWR.n889 VPWR.n888 0.143289
R1379 VPWR.n847 VPWR.n846 0.143289
R1380 VPWR.n842 VPWR.n841 0.143289
R1381 VPWR.n839 VPWR.n838 0.143289
R1382 VPWR.n834 VPWR.n833 0.143289
R1383 VPWR.n901 VPWR.n900 0.143289
R1384 VPWR.n906 VPWR.n905 0.143289
R1385 VPWR.n183 VPWR.n182 0.143289
R1386 VPWR.n194 VPWR.n193 0.143289
R1387 VPWR.n207 VPWR.n206 0.143289
R1388 VPWR.n756 VPWR.n755 0.143289
R1389 VPWR.n253 VPWR.n252 0.143289
R1390 VPWR.n248 VPWR.n247 0.143289
R1391 VPWR.n700 VPWR.n699 0.143289
R1392 VPWR.n705 VPWR.n704 0.143289
R1393 VPWR.n642 VPWR.n641 0.143289
R1394 VPWR.n589 VPWR.n588 0.143289
R1395 VPWR.n584 VPWR.n583 0.143289
R1396 VPWR.n46 VPWR.n680 0.176809
R1397 VPWR.n365 VPWR.n364 0.143289
R1398 VPWR.n398 VPWR.n397 0.143289
R1399 VPWR.n383 VPWR.n385 0.143289
R1400 VPWR.n476 VPWR.n475 0.143289
R1401 VPWR.n471 VPWR.n470 0.143289
R1402 VPWR.n447 VPWR.n446 0.143289
R1403 VPWR.n452 VPWR.n451 0.143289
R1404 VPWR.n486 VPWR.n483 0.139575
R1405 VPWR.n463 VPWR.n461 0.139575
R1406 VPWR.n495 VPWR.n494 0.139575
R1407 VPWR.n22 VPWR.n21 0.13351
R1408 VPWR.n212 VPWR.n211 0.133174
R1409 VPWR.n512 VPWR.n511 0.133174
R1410 VPWR.n918 VPWR.n97 0.132075
R1411 VPWR.n882 VPWR.n881 0.132075
R1412 VPWR.n691 VPWR.n254 0.132075
R1413 VPWR.n29 VPWR.n27 0.194107
R1414 VPWR.n110 VPWR.n108 0.12922
R1415 VPWR.n114 VPWR.n112 0.12922
R1416 VPWR.n121 VPWR.n119 0.12922
R1417 VPWR.n917 VPWR.n915 0.12922
R1418 VPWR.n863 VPWR.n861 0.12922
R1419 VPWR.n870 VPWR.n868 0.12922
R1420 VPWR.n874 VPWR.n872 0.12922
R1421 VPWR.n879 VPWR.n877 0.12922
R1422 VPWR.n140 VPWR.n138 0.12922
R1423 VPWR.n147 VPWR.n145 0.12922
R1424 VPWR.n151 VPWR.n149 0.12922
R1425 VPWR.n156 VPWR.n154 0.12922
R1426 VPWR.n159 VPWR.n158 0.12922
R1427 VPWR.n796 VPWR.n794 0.12922
R1428 VPWR.n800 VPWR.n798 0.12922
R1429 VPWR.n807 VPWR.n805 0.12922
R1430 VPWR.n814 VPWR.n812 0.12922
R1431 VPWR.n38 VPWR.n37 0.12922
R1432 VPWR.n267 VPWR.n265 0.12922
R1433 VPWR.n271 VPWR.n269 0.12922
R1434 VPWR.n278 VPWR.n276 0.12922
R1435 VPWR.n690 VPWR.n688 0.12922
R1436 VPWR.n615 VPWR.n613 0.12922
R1437 VPWR.n622 VPWR.n620 0.12922
R1438 VPWR.n626 VPWR.n624 0.12922
R1439 VPWR.n631 VPWR.n629 0.12922
R1440 VPWR.n45 VPWR.n44 0.12922
R1441 VPWR.n310 VPWR.n308 0.12922
R1442 VPWR.n314 VPWR.n312 0.12922
R1443 VPWR.n321 VPWR.n319 0.12922
R1444 VPWR.n325 VPWR.n323 0.12922
R1445 VPWR.n430 VPWR.n428 0.12922
R1446 VPWR.n110 VPWR.n109 0.128884
R1447 VPWR.n114 VPWR.n113 0.128884
R1448 VPWR.n121 VPWR.n120 0.128884
R1449 VPWR.n917 VPWR.n916 0.128884
R1450 VPWR.n863 VPWR.n862 0.128884
R1451 VPWR.n870 VPWR.n869 0.128884
R1452 VPWR.n874 VPWR.n873 0.128884
R1453 VPWR.n879 VPWR.n878 0.128884
R1454 VPWR.n140 VPWR.n139 0.128884
R1455 VPWR.n147 VPWR.n146 0.128884
R1456 VPWR.n151 VPWR.n150 0.128884
R1457 VPWR.n156 VPWR.n155 0.128884
R1458 VPWR.n796 VPWR.n795 0.128884
R1459 VPWR.n800 VPWR.n799 0.128884
R1460 VPWR.n807 VPWR.n806 0.128884
R1461 VPWR.n814 VPWR.n813 0.128884
R1462 VPWR.n820 VPWR.n819 0.128884
R1463 VPWR.n17 VPWR.n16 0.128884
R1464 VPWR.n774 VPWR.n773 0.128884
R1465 VPWR.n267 VPWR.n266 0.128884
R1466 VPWR.n271 VPWR.n270 0.128884
R1467 VPWR.n278 VPWR.n277 0.128884
R1468 VPWR.n690 VPWR.n689 0.128884
R1469 VPWR.n42 VPWR.n41 0.128884
R1470 VPWR.n615 VPWR.n614 0.128884
R1471 VPWR.n622 VPWR.n621 0.128884
R1472 VPWR.n626 VPWR.n625 0.128884
R1473 VPWR.n631 VPWR.n630 0.128884
R1474 VPWR.n637 VPWR.n636 0.128884
R1475 VPWR.n310 VPWR.n309 0.128884
R1476 VPWR.n314 VPWR.n313 0.128884
R1477 VPWR.n321 VPWR.n320 0.128884
R1478 VPWR.n325 VPWR.n324 0.128884
R1479 VPWR.n331 VPWR.n330 0.128884
R1480 VPWR.n48 VPWR.n47 0.128884
R1481 VPWR.n430 VPWR.n429 0.128884
R1482 VPWR.n442 VPWR.n441 0.128884
R1483 VPWR.n554 VPWR.n553 0.128884
R1484 VPWR.n52 VPWR.n51 0.128884
R1485 VPWR.t386 VPWR.n484 0.128884
R1486 VPWR.n459 VPWR.n458 0.128884
R1487 VPWR.n498 VPWR.n497 0.128884
R1488 VPWR.n489 VPWR.n488 0.128884
R1489 VPWR.n921 VPWR.n920 0.128325
R1490 VPWR.n892 VPWR.n852 0.128325
R1491 VPWR.n895 VPWR.n894 0.128325
R1492 VPWR.n191 VPWR.n190 0.128325
R1493 VPWR.n694 VPWR.n693 0.128325
R1494 VPWR.n357 VPWR.n356 0.128325
R1495 VPWR.n465 VPWR.n464 0.128325
R1496 VPWR.n94 VPWR.n93 0.128289
R1497 VPWR.n93 VPWR.n92 0.128289
R1498 VPWR.n929 VPWR.n928 0.128289
R1499 VPWR.n930 VPWR.n929 0.128289
R1500 VPWR.n886 VPWR.n885 0.128289
R1501 VPWR.n887 VPWR.n886 0.128289
R1502 VPWR.n845 VPWR.n844 0.128289
R1503 VPWR.n844 VPWR.n843 0.128289
R1504 VPWR.n837 VPWR.n836 0.128289
R1505 VPWR.n836 VPWR.n835 0.128289
R1506 VPWR.n903 VPWR.n902 0.128289
R1507 VPWR.n904 VPWR.n903 0.128289
R1508 VPWR.n185 VPWR.n184 0.128289
R1509 VPWR.n197 VPWR.n196 0.128289
R1510 VPWR.n204 VPWR.n203 0.128289
R1511 VPWR.n169 VPWR.n168 0.128289
R1512 VPWR.n753 VPWR.n752 0.128289
R1513 VPWR.n749 VPWR.n748 0.128289
R1514 VPWR.n766 VPWR.n765 0.128289
R1515 VPWR.n767 VPWR.n766 0.128289
R1516 VPWR.n251 VPWR.n250 0.128289
R1517 VPWR.n250 VPWR.n249 0.128289
R1518 VPWR.n702 VPWR.n701 0.128289
R1519 VPWR.n703 VPWR.n702 0.128289
R1520 VPWR.n650 VPWR.n649 0.128289
R1521 VPWR.n597 VPWR.n596 0.128289
R1522 VPWR.n587 VPWR.n586 0.128289
R1523 VPWR.n586 VPWR.n585 0.128289
R1524 VPWR.n661 VPWR.n576 0.128289
R1525 VPWR.n672 VPWR.n671 0.128289
R1526 VPWR.n368 VPWR.n367 0.128289
R1527 VPWR.n395 VPWR.n394 0.128289
R1528 VPWR.n388 VPWR.n387 0.128289
R1529 VPWR.n474 VPWR.n473 0.128289
R1530 VPWR.n473 VPWR.n472 0.128289
R1531 VPWR.n449 VPWR.n448 0.128289
R1532 VPWR.n450 VPWR.n449 0.128289
R1533 VPWR.n922 VPWR.n921 0.127986
R1534 VPWR.n852 VPWR.n851 0.127986
R1535 VPWR.n896 VPWR.n895 0.127986
R1536 VPWR.n192 VPWR.n191 0.127986
R1537 VPWR.n695 VPWR.n694 0.127986
R1538 VPWR.n358 VPWR.n357 0.127986
R1539 VPWR.n466 VPWR.n465 0.127986
R1540 VPWR.n369 VPWR.n368 0.124539
R1541 VPWR.t133 VPWR.n378 0.120789
R1542 VPWR.n111 VPWR.n110 0.119294
R1543 VPWR.n863 VPWR.n860 0.119294
R1544 VPWR.n140 VPWR.n137 0.119294
R1545 VPWR.n797 VPWR.n796 0.119294
R1546 VPWR.n268 VPWR.n267 0.119294
R1547 VPWR.n615 VPWR.n612 0.119294
R1548 VPWR.n311 VPWR.n310 0.119294
R1549 VPWR.n430 VPWR.n427 0.119294
R1550 VPWR.n209 VPWR.n177 0.11425
R1551 VPWR.n455 VPWR.n60 0.172055
R1552 VPWR.n757 VPWR.n38 0.114125
R1553 VPWR.n334 VPWR.n48 0.114125
R1554 VPWR.n52 VPWR.n50 0.114125
R1555 VPWR.n95 VPWR.n94 0.113289
R1556 VPWR.n92 VPWR.n91 0.113289
R1557 VPWR.n928 VPWR.n927 0.113289
R1558 VPWR.n931 VPWR.n930 0.113289
R1559 VPWR.t880 VPWR.n71 0.113289
R1560 VPWR.n885 VPWR.n884 0.113289
R1561 VPWR.n888 VPWR.n887 0.113289
R1562 VPWR.n846 VPWR.n845 0.113289
R1563 VPWR.n843 VPWR.n842 0.113289
R1564 VPWR.n838 VPWR.n837 0.113289
R1565 VPWR.n835 VPWR.n834 0.113289
R1566 VPWR.n902 VPWR.n901 0.113289
R1567 VPWR.n905 VPWR.n904 0.113289
R1568 VPWR.n184 VPWR.n183 0.113289
R1569 VPWR.n200 VPWR.n199 0.113289
R1570 VPWR.n201 VPWR.n200 0.113289
R1571 VPWR.n166 VPWR.n19 0.186446
R1572 VPWR.n752 VPWR.n751 0.113289
R1573 VPWR.n750 VPWR.n749 0.113289
R1574 VPWR.n768 VPWR.n767 0.113289
R1575 VPWR.n252 VPWR.n251 0.113289
R1576 VPWR.n249 VPWR.n248 0.113289
R1577 VPWR.n701 VPWR.n700 0.113289
R1578 VPWR.n704 VPWR.n703 0.113289
R1579 VPWR.n647 VPWR.n646 0.113289
R1580 VPWR.n594 VPWR.n593 0.113289
R1581 VPWR.n588 VPWR.n587 0.113289
R1582 VPWR.n585 VPWR.n584 0.113289
R1583 VPWR.n579 VPWR.n578 0.113289
R1584 VPWR.n675 VPWR.n674 0.113289
R1585 VPWR.n11 VPWR.n370 0.45341
R1586 VPWR.n392 VPWR.n391 0.113289
R1587 VPWR.n391 VPWR.n390 0.113289
R1588 VPWR.n475 VPWR.n474 0.113289
R1589 VPWR.n472 VPWR.n471 0.113289
R1590 VPWR.n448 VPWR.n447 0.113289
R1591 VPWR.n451 VPWR.n450 0.113289
R1592 VPWR.n949 VPWR.n947 0.113
R1593 VPWR.n81 VPWR.n80 0.113
R1594 VPWR.n952 VPWR.n951 0.113
R1595 VPWR.n950 VPWR.n78 0.113
R1596 VPWR.n214 VPWR.n213 0.113
R1597 VPWR.n232 VPWR.n230 0.113
R1598 VPWR.n724 VPWR.n236 0.113
R1599 VPWR.n726 VPWR.n725 0.113
R1600 VPWR.n727 VPWR.n235 0.113
R1601 VPWR.n731 VPWR.n730 0.113
R1602 VPWR.n653 VPWR.n652 0.113
R1603 VPWR.n659 VPWR.n657 0.113
R1604 VPWR.n660 VPWR.n575 0.113
R1605 VPWR.n669 VPWR.n573 0.113
R1606 VPWR.n356 VPWR.n286 0.113
R1607 VPWR.n531 VPWR.n529 0.113
R1608 VPWR.n412 VPWR.n411 0.113
R1609 VPWR.n534 VPWR.n533 0.113
R1610 VPWR.n532 VPWR.n409 0.113
R1611 VPWR.n366 VPWR.n365 0.109539
R1612 VPWR.n759 VPWR.n758 0.10925
R1613 VPWR.n763 VPWR.n743 0.10925
R1614 VPWR.n30 VPWR.n742 0.392694
R1615 VPWR.n243 VPWR.n242 0.10925
R1616 VPWR.n336 VPWR.n335 0.10925
R1617 VPWR.n402 VPWR.n401 0.10925
R1618 VPWR.n514 VPWR.n513 0.10925
R1619 VPWR.n111 VPWR.n107 0.108516
R1620 VPWR.n860 VPWR.n859 0.108516
R1621 VPWR.n137 VPWR.n136 0.108516
R1622 VPWR.n797 VPWR.n793 0.108516
R1623 VPWR.n268 VPWR.n264 0.108516
R1624 VPWR.n612 VPWR.n611 0.108516
R1625 VPWR.n311 VPWR.n307 0.108516
R1626 VPWR.n427 VPWR.n426 0.108516
R1627 VPWR.n285 VPWR.n284 0.108
R1628 VPWR.n373 VPWR.n372 0.108
R1629 VPWR.n423 VPWR.n422 0.108
R1630 VPWR.n482 VPWR.n481 0.105789
R1631 VPWR.n33 VPWR.n32 0.103337
R1632 VPWR.n740 VPWR.n738 0.103337
R1633 VPWR.n10 VPWR.n9 0.103337
R1634 VPWR.n7 VPWR.n6 0.103337
R1635 VPWR.n13 VPWR.n12 0.103337
R1636 VPWR.n485 VPWR.t1475 0.103052
R1637 VPWR.n29 VPWR.n28 0.103002
R1638 VPWR.n285 VPWR.n283 0.103002
R1639 VPWR.n372 VPWR.n371 0.103002
R1640 VPWR.n423 VPWR.n421 0.103002
R1641 VPWR.n817 VPWR.n783 0.10175
R1642 VPWR.n635 VPWR.n634 0.10175
R1643 VPWR.n328 VPWR.n298 0.10175
R1644 VPWR.n440 VPWR.n439 0.10175
R1645 VPWR.n552 VPWR.n551 0.10175
R1646 VPWR.n42 VPWR.n40 0.101625
R1647 VPWR.n502 VPWR.n501 0.100789
R1648 VPWR.n186 VPWR.n185 0.099539
R1649 VPWR.n43 VPWR.n708 0.133059
R1650 VPWR.n90 VPWR.n89 0.098289
R1651 VPWR.n926 VPWR.n925 0.098289
R1652 VPWR.n934 VPWR.n932 0.098289
R1653 VPWR.n934 VPWR.n933 0.098289
R1654 VPWR.n890 VPWR.n889 0.098289
R1655 VPWR.n848 VPWR.n847 0.098289
R1656 VPWR.n841 VPWR.n840 0.098289
R1657 VPWR.n840 VPWR.n839 0.098289
R1658 VPWR.n833 VPWR.n832 0.098289
R1659 VPWR.n900 VPWR.n899 0.098289
R1660 VPWR.n0 VPWR.n906 0.171846
R1661 VPWR.n198 VPWR.n197 0.098289
R1662 VPWR.n203 VPWR.n202 0.098289
R1663 VPWR.n777 VPWR.n18 0.341708
R1664 VPWR.n755 VPWR.n754 0.098289
R1665 VPWR.n747 VPWR.n746 0.098289
R1666 VPWR.n744 VPWR.n39 0.131809
R1667 VPWR.n771 VPWR.n770 0.098289
R1668 VPWR.n247 VPWR.n246 0.098289
R1669 VPWR.n699 VPWR.n698 0.098289
R1670 VPWR.n706 VPWR.n705 0.098289
R1671 VPWR.n710 VPWR.n241 0.098289
R1672 VPWR.n643 VPWR.n642 0.098289
R1673 VPWR.n644 VPWR.n643 0.098289
R1674 VPWR.n591 VPWR.n590 0.098289
R1675 VPWR.n590 VPWR.n589 0.098289
R1676 VPWR.n583 VPWR.n582 0.098289
R1677 VPWR.n582 VPWR.n581 0.098289
R1678 VPWR.n678 VPWR.n677 0.098289
R1679 VPWR.n292 VPWR.n49 0.131809
R1680 VPWR.n394 VPWR.n393 0.098289
R1681 VPWR.n389 VPWR.n388 0.098289
R1682 VPWR.n516 VPWR.n515 0.098289
R1683 VPWR.n53 VPWR.n560 0.131809
R1684 VPWR.n470 VPWR.n469 0.098289
R1685 VPWR.n446 VPWR.n445 0.098289
R1686 VPWR.n946 VPWR.n944 0.098
R1687 VPWR.n948 VPWR.n82 0.098
R1688 VPWR.n955 VPWR.n954 0.098
R1689 VPWR.n953 VPWR.n77 0.098
R1690 VPWR.n217 VPWR.n216 0.098
R1691 VPWR.n229 VPWR.n227 0.098
R1692 VPWR.n722 VPWR.n237 0.098
R1693 VPWR.n723 VPWR.n721 0.098
R1694 VPWR.n729 VPWR.n234 0.098
R1695 VPWR.n734 VPWR.n733 0.098
R1696 VPWR.n656 VPWR.n655 0.098
R1697 VPWR.n656 VPWR.n654 0.098
R1698 VPWR.n663 VPWR.n574 0.098
R1699 VPWR.n667 VPWR.n574 0.098
R1700 VPWR.n339 VPWR.n291 0.098
R1701 VPWR.n354 VPWR.n287 0.098
R1702 VPWR.n528 VPWR.n526 0.098
R1703 VPWR.n530 VPWR.n413 0.098
R1704 VPWR.n537 VPWR.n536 0.098
R1705 VPWR.n535 VPWR.n408 0.098
R1706 VPWR.n769 VPWR.n768 0.094539
R1707 VPWR.n363 VPWR.n362 0.094539
R1708 VPWR.n359 VPWR.n358 0.093
R1709 VPWR.n489 VPWR.n487 0.0905716
R1710 VPWR.n376 VPWR.n375 0.0905
R1711 VPWR.n419 VPWR.n418 0.0905
R1712 VPWR.t381 VPWR.n55 0.0695551
R1713 VPWR.n189 VPWR.n125 0.08675
R1714 VPWR.n17 VPWR.n15 0.162006
R1715 VPWR.n480 VPWR.n60 0.0296542
R1716 VPWR.n88 VPWR.n87 0.083289
R1717 VPWR.n924 VPWR.n923 0.083289
R1718 VPWR.n893 VPWR.n891 0.083289
R1719 VPWR.n850 VPWR.n849 0.083289
R1720 VPWR.n831 VPWR.n830 0.083289
R1721 VPWR.n898 VPWR.n897 0.083289
R1722 VPWR.n179 VPWR.n178 0.083289
R1723 VPWR.n195 VPWR.n194 0.083289
R1724 VPWR.n206 VPWR.n205 0.083289
R1725 VPWR.n245 VPWR.n244 0.083289
R1726 VPWR.n697 VPWR.n696 0.083289
R1727 VPWR.n646 VPWR.n645 0.083289
R1728 VPWR.n593 VPWR.n592 0.083289
R1729 VPWR.n580 VPWR.n579 0.083289
R1730 VPWR.n676 VPWR.n675 0.083289
R1731 VPWR.n340 VPWR.n339 0.083289
R1732 VPWR.n361 VPWR.n360 0.083289
R1733 VPWR.n397 VPWR.n396 0.083289
R1734 VPWR.n386 VPWR.n385 0.083289
R1735 VPWR.n468 VPWR.n467 0.083289
R1736 VPWR.n444 VPWR.n443 0.083289
R1737 VPWR.n933 VPWR.n86 0.083
R1738 VPWR.n937 VPWR.n936 0.083
R1739 VPWR.n943 VPWR.n941 0.083
R1740 VPWR.n945 VPWR.n83 0.083
R1741 VPWR.n958 VPWR.n957 0.083
R1742 VPWR.n956 VPWR.n76 0.083
R1743 VPWR.n966 VPWR.n74 0.083
R1744 VPWR.n967 VPWR.n965 0.083
R1745 VPWR.n215 VPWR.n175 0.083
R1746 VPWR.n220 VPWR.n219 0.083
R1747 VPWR.n226 VPWR.n224 0.083
R1748 VPWR.n228 VPWR.n172 0.083
R1749 VPWR.n232 VPWR.n231 0.083
R1750 VPWR.n822 VPWR.n821 0.083
R1751 VPWR.n31 VPWR.n743 0.083
R1752 VPWR.n711 VPWR.n710 0.083
R1753 VPWR.n709 VPWR.n240 0.083
R1754 VPWR.n719 VPWR.n238 0.083
R1755 VPWR.n720 VPWR.n718 0.083
R1756 VPWR.n633 VPWR.n602 0.083
R1757 VPWR.n653 VPWR.n651 0.083
R1758 VPWR.n659 VPWR.n658 0.083
R1759 VPWR.n664 VPWR.n575 0.083
R1760 VPWR.n666 VPWR.n573 0.083
R1761 VPWR.n333 VPWR.n332 0.083
R1762 VPWR.n343 VPWR.n342 0.083
R1763 VPWR.n341 VPWR.n290 0.083
R1764 VPWR.n351 VPWR.n288 0.083
R1765 VPWR.n352 VPWR.n350 0.083
R1766 VPWR.n515 VPWR.n417 0.083
R1767 VPWR.n519 VPWR.n518 0.083
R1768 VPWR.n525 VPWR.n523 0.083
R1769 VPWR.n527 VPWR.n414 0.083
R1770 VPWR.n540 VPWR.n539 0.083
R1771 VPWR.n538 VPWR.n407 0.083
R1772 VPWR.n548 VPWR.n405 0.083
R1773 VPWR.n549 VPWR.n547 0.083
R1774 VPWR.n550 VPWR.n403 0.083
R1775 VPWR.n355 VPWR.n353 0.08175
R1776 VPWR.n181 VPWR.n180 0.080789
R1777 VPWR.n360 VPWR.n359 0.080789
R1778 VPWR.n912 VPWR.n100 0.0805
R1779 VPWR.n908 VPWR.n36 0.0805
R1780 VPWR.n826 VPWR.n54 0.0805
R1781 VPWR.n164 VPWR.n163 0.0805
R1782 VPWR.n809 VPWR.n786 0.0805
R1783 VPWR.n685 VPWR.n257 0.0805
R1784 VPWR.n682 VPWR.n571 0.0805
R1785 VPWR.n569 VPWR.n281 0.0805
R1786 VPWR.n104 VPWR.n103 0.079539
R1787 VPWR.n118 VPWR.n117 0.079539
R1788 VPWR.n867 VPWR.n866 0.079539
R1789 VPWR.n856 VPWR.n855 0.079539
R1790 VPWR.n144 VPWR.n143 0.079539
R1791 VPWR.n133 VPWR.n132 0.079539
R1792 VPWR.n128 VPWR.n127 0.079539
R1793 VPWR.n790 VPWR.n789 0.079539
R1794 VPWR.n804 VPWR.n803 0.079539
R1795 VPWR.n818 VPWR.n817 0.079539
R1796 VPWR.n779 VPWR.n778 0.079539
R1797 VPWR.n746 VPWR.n745 0.079539
R1798 VPWR.n772 VPWR.n771 0.079539
R1799 VPWR.n261 VPWR.n260 0.079539
R1800 VPWR.n275 VPWR.n274 0.079539
R1801 VPWR.n707 VPWR.n706 0.079539
R1802 VPWR.n619 VPWR.n618 0.079539
R1803 VPWR.n608 VPWR.n607 0.079539
R1804 VPWR.n634 VPWR.n603 0.079539
R1805 VPWR.n679 VPWR.n678 0.079539
R1806 VPWR.n304 VPWR.n303 0.079539
R1807 VPWR.n318 VPWR.n317 0.079539
R1808 VPWR.n329 VPWR.n328 0.079539
R1809 VPWR.n294 VPWR.n293 0.079539
R1810 VPWR.n375 VPWR.n374 0.079539
R1811 VPWR.n377 VPWR.t118 0.079539
R1812 VPWR.n420 VPWR.n419 0.079539
R1813 VPWR.n559 VPWR.n558 0.079539
R1814 VPWR.n105 VPWR.n104 0.072039
R1815 VPWR.n117 VPWR.n116 0.072039
R1816 VPWR.n866 VPWR.n865 0.072039
R1817 VPWR.n857 VPWR.n856 0.072039
R1818 VPWR.n143 VPWR.n142 0.072039
R1819 VPWR.n134 VPWR.n133 0.072039
R1820 VPWR.n129 VPWR.n128 0.072039
R1821 VPWR.n165 VPWR.n162 0.072039
R1822 VPWR.n791 VPWR.n790 0.072039
R1823 VPWR.n803 VPWR.n802 0.072039
R1824 VPWR.n818 VPWR.n816 0.072039
R1825 VPWR.n780 VPWR.n779 0.072039
R1826 VPWR.n760 VPWR.n759 0.072039
R1827 VPWR.n742 VPWR.n741 0.072039
R1828 VPWR.n262 VPWR.n261 0.072039
R1829 VPWR.n274 VPWR.n273 0.072039
R1830 VPWR.n242 VPWR.n241 0.072039
R1831 VPWR.n618 VPWR.n617 0.072039
R1832 VPWR.n609 VPWR.n608 0.072039
R1833 VPWR.n604 VPWR.n603 0.072039
R1834 VPWR.n641 VPWR.n640 0.072039
R1835 VPWR.n305 VPWR.n304 0.072039
R1836 VPWR.n317 VPWR.n316 0.072039
R1837 VPWR.n329 VPWR.n327 0.072039
R1838 VPWR.n295 VPWR.n294 0.072039
R1839 VPWR.n337 VPWR.n336 0.072039
R1840 VPWR.n284 VPWR.n8 0.41216
R1841 VPWR.n374 VPWR.n373 0.072039
R1842 VPWR.n377 VPWR.n376 0.072039
R1843 VPWR.n401 VPWR.n400 0.072039
R1844 VPWR.n433 VPWR.n432 0.072039
R1845 VPWR.n422 VPWR.n420 0.072039
R1846 VPWR.n418 VPWR.n25 0.241134
R1847 VPWR.n516 VPWR.n514 0.072039
R1848 VPWR.n558 VPWR.n557 0.072039
R1849 VPWR.n457 VPWR.n456 0.072039
R1850 VPWR.n501 VPWR.n500 0.072039
R1851 VPWR.n440 VPWR.n438 0.07175
R1852 VPWR.t1065 VPWR.n45 0.069125
R1853 VPWR.n80 VPWR.n79 0.068289
R1854 VPWR.n951 VPWR.n79 0.068289
R1855 VPWR.n210 VPWR.n208 0.068289
R1856 VPWR.n168 VPWR.n167 0.068289
R1857 VPWR.n761 VPWR.n760 0.068289
R1858 VPWR.n728 VPWR.n726 0.068289
R1859 VPWR.n728 VPWR.n727 0.068289
R1860 VPWR.n650 VPWR.n648 0.068289
R1861 VPWR.n596 VPWR.n595 0.068289
R1862 VPWR.n577 VPWR.n576 0.068289
R1863 VPWR.n673 VPWR.n672 0.068289
R1864 VPWR.n338 VPWR.n337 0.068289
R1865 VPWR.n400 VPWR.n399 0.068289
R1866 VPWR.n411 VPWR.n410 0.068289
R1867 VPWR.n533 VPWR.n410 0.068289
R1868 VPWR.n935 VPWR.n85 0.068
R1869 VPWR.n940 VPWR.n939 0.068
R1870 VPWR.n940 VPWR.n938 0.068
R1871 VPWR.n942 VPWR.n84 0.068
R1872 VPWR.n961 VPWR.n960 0.068
R1873 VPWR.n959 VPWR.n75 0.068
R1874 VPWR.n963 VPWR.n75 0.068
R1875 VPWR.n964 VPWR.n962 0.068
R1876 VPWR.n218 VPWR.n174 0.068
R1877 VPWR.n223 VPWR.n222 0.068
R1878 VPWR.n223 VPWR.n221 0.068
R1879 VPWR.n225 VPWR.n173 0.068
R1880 VPWR.n714 VPWR.n713 0.068
R1881 VPWR.n712 VPWR.n239 0.068
R1882 VPWR.n716 VPWR.n239 0.068
R1883 VPWR.n717 VPWR.n715 0.068
R1884 VPWR.n346 VPWR.n345 0.068
R1885 VPWR.n344 VPWR.n289 0.068
R1886 VPWR.n348 VPWR.n289 0.068
R1887 VPWR.n349 VPWR.n347 0.068
R1888 VPWR.n517 VPWR.n416 0.068
R1889 VPWR.n522 VPWR.n521 0.068
R1890 VPWR.n522 VPWR.n520 0.068
R1891 VPWR.n524 VPWR.n415 0.068
R1892 VPWR.n543 VPWR.n542 0.068
R1893 VPWR.n541 VPWR.n406 0.068
R1894 VPWR.n545 VPWR.n406 0.068
R1895 VPWR.n546 VPWR.n544 0.068
R1896 VPWR.n165 VPWR.n164 0.067039
R1897 VPWR.n210 VPWR.n209 0.067039
R1898 VPWR.n434 VPWR.n433 0.067039
R1899 VPWR.n456 VPWR.n455 0.067039
R1900 VPWR.n114 VPWR.n102 0.065789
R1901 VPWR.n122 VPWR.n121 0.065789
R1902 VPWR.n917 VPWR.n98 0.065789
R1903 VPWR.n871 VPWR.n870 0.065789
R1904 VPWR.n874 VPWR.n854 0.065789
R1905 VPWR.n880 VPWR.n879 0.065789
R1906 VPWR.n148 VPWR.n147 0.065789
R1907 VPWR.n151 VPWR.n131 0.065789
R1908 VPWR.n157 VPWR.n156 0.065789
R1909 VPWR.n159 VPWR.n126 0.065789
R1910 VPWR.n800 VPWR.n788 0.065789
R1911 VPWR.n808 VPWR.n807 0.065789
R1912 VPWR.n814 VPWR.n784 0.065789
R1913 VPWR.n774 VPWR.n737 0.065789
R1914 VPWR.n271 VPWR.n259 0.065789
R1915 VPWR.n279 VPWR.n278 0.065789
R1916 VPWR.n690 VPWR.n255 0.065789
R1917 VPWR.n623 VPWR.n622 0.065789
R1918 VPWR.n626 VPWR.n606 0.065789
R1919 VPWR.n632 VPWR.n631 0.065789
R1920 VPWR.n314 VPWR.n302 0.065789
R1921 VPWR.n322 VPWR.n321 0.065789
R1922 VPWR.n325 VPWR.n300 0.065789
R1923 VPWR.n212 VPWR.n176 0.06425
R1924 VPWR.n778 VPWR.n777 0.06425
R1925 VPWR.n745 VPWR.n744 0.06425
R1926 VPWR.n293 VPWR.n292 0.06425
R1927 VPWR.n435 VPWR.n425 0.06425
R1928 VPWR.n513 VPWR.n512 0.06425
R1929 VPWR.n560 VPWR.n559 0.06425
R1930 VPWR.n708 VPWR.n707 0.063
R1931 VPWR.t71 VPWR.n2 0.169871
R1932 VPWR.n741 VPWR.n740 0.062039
R1933 VPWR.n460 VPWR.n459 0.062039
R1934 VPWR.n499 VPWR.n498 0.062039
R1935 VPWR.n490 VPWR.n489 0.062039
R1936 VPWR.n378 VPWR.t131 0.060789
R1937 VPWR.n167 VPWR.n166 0.0605
R1938 VPWR.t342 VPWR.t318 0.0605
R1939 VPWR.n645 VPWR.n644 0.0605
R1940 VPWR.n648 VPWR.n647 0.0605
R1941 VPWR.n595 VPWR.n594 0.0605
R1942 VPWR.n592 VPWR.n591 0.0605
R1943 VPWR.n581 VPWR.n580 0.0605
R1944 VPWR.n578 VPWR.n577 0.0605
R1945 VPWR.n674 VPWR.n673 0.0605
R1946 VPWR.n677 VPWR.n676 0.0605
R1947 VPWR.t449 VPWR.t450 0.05925
R1948 VPWR.n214 VPWR.n212 0.05675
R1949 VPWR.n437 VPWR.n435 0.05675
R1950 VPWR.n512 VPWR.n24 0.116418
R1951 VPWR.n911 VPWR.n910 0.05506
R1952 VPWR.n970 VPWR.n968 0.05506
R1953 VPWR.n937 VPWR.n935 0.053
R1954 VPWR.n939 VPWR.n85 0.053
R1955 VPWR.n938 VPWR.n84 0.053
R1956 VPWR.n943 VPWR.n942 0.053
R1957 VPWR.n960 VPWR.n76 0.053
R1958 VPWR.n961 VPWR.n959 0.053
R1959 VPWR.n964 VPWR.n963 0.053
R1960 VPWR.n962 VPWR.n74 0.053
R1961 VPWR.n57 VPWR.n187 0.114943
R1962 VPWR.n220 VPWR.n218 0.053
R1963 VPWR.n222 VPWR.n174 0.053
R1964 VPWR.n221 VPWR.n173 0.053
R1965 VPWR.n226 VPWR.n225 0.053
R1966 VPWR.n170 VPWR.n169 0.053
R1967 VPWR.n765 VPWR.n764 0.053
R1968 VPWR.n713 VPWR.n240 0.053
R1969 VPWR.n714 VPWR.n712 0.053
R1970 VPWR.n717 VPWR.n716 0.053
R1971 VPWR.n715 VPWR.n238 0.053
R1972 VPWR.n649 VPWR.n601 0.053
R1973 VPWR.n598 VPWR.n597 0.053
R1974 VPWR.n662 VPWR.n661 0.053
R1975 VPWR.n671 VPWR.n670 0.053
R1976 VPWR.n345 VPWR.n290 0.053
R1977 VPWR.n346 VPWR.n344 0.053
R1978 VPWR.n349 VPWR.n348 0.053
R1979 VPWR.n347 VPWR.n288 0.053
R1980 VPWR.n519 VPWR.n517 0.053
R1981 VPWR.n521 VPWR.n416 0.053
R1982 VPWR.n520 VPWR.n415 0.053
R1983 VPWR.n525 VPWR.n524 0.053
R1984 VPWR.n542 VPWR.n407 0.053
R1985 VPWR.n543 VPWR.n541 0.053
R1986 VPWR.n546 VPWR.n545 0.053
R1987 VPWR.n544 VPWR.n405 0.053
R1988 VPWR.t77 VPWR.t284 0.0513919
R1989 VPWR.n770 VPWR.n769 0.04925
R1990 VPWR.n438 VPWR.n424 0.04925
R1991 VPWR.n498 VPWR.n496 0.0448003
R1992 VPWR.n459 VPWR.n454 0.0448003
R1993 VPWR.n4 VPWR.t386 0.00680486
R1994 VPWR.n977 VPWR.n976 0.0436411
R1995 VPWR.n508 VPWR.n504 0.0436411
R1996 VPWR.n976 VPWR.n64 0.0436411
R1997 VPWR.n969 VPWR.n68 0.0436411
R1998 VPWR.n565 VPWR.n564 0.0436411
R1999 VPWR.n564 VPWR.n563 0.0436411
R2000 VPWR.n505 VPWR.n280 0.04274
R2001 VPWR.n973 VPWR.n66 0.04274
R2002 VPWR.n919 VPWR.n917 0.0423097
R2003 VPWR.n121 VPWR.n101 0.0423097
R2004 VPWR.n115 VPWR.n114 0.0423097
R2005 VPWR.n110 VPWR.n106 0.0423097
R2006 VPWR.n879 VPWR.n853 0.0423097
R2007 VPWR.n875 VPWR.n874 0.0423097
R2008 VPWR.n870 VPWR.n858 0.0423097
R2009 VPWR.n864 VPWR.n863 0.0423097
R2010 VPWR.n160 VPWR.n159 0.0423097
R2011 VPWR.n156 VPWR.n130 0.0423097
R2012 VPWR.n152 VPWR.n151 0.0423097
R2013 VPWR.n147 VPWR.n135 0.0423097
R2014 VPWR.n141 VPWR.n140 0.0423097
R2015 VPWR.n775 VPWR.n774 0.0423097
R2016 VPWR.n820 VPWR.n782 0.0423097
R2017 VPWR.n815 VPWR.n814 0.0423097
R2018 VPWR.n807 VPWR.n787 0.0423097
R2019 VPWR.n801 VPWR.n800 0.0423097
R2020 VPWR.n796 VPWR.n792 0.0423097
R2021 VPWR.n692 VPWR.n690 0.0423097
R2022 VPWR.n278 VPWR.n258 0.0423097
R2023 VPWR.n272 VPWR.n271 0.0423097
R2024 VPWR.n267 VPWR.n263 0.0423097
R2025 VPWR.n638 VPWR.n637 0.0423097
R2026 VPWR.n631 VPWR.n605 0.0423097
R2027 VPWR.n627 VPWR.n626 0.0423097
R2028 VPWR.n622 VPWR.n610 0.0423097
R2029 VPWR.n616 VPWR.n615 0.0423097
R2030 VPWR.n331 VPWR.n297 0.0423097
R2031 VPWR.n326 VPWR.n325 0.0423097
R2032 VPWR.n321 VPWR.n301 0.0423097
R2033 VPWR.n315 VPWR.n314 0.0423097
R2034 VPWR.n310 VPWR.n306 0.0423097
R2035 VPWR.n555 VPWR.n554 0.0423097
R2036 VPWR.n14 VPWR.n442 0.347826
R2037 VPWR.n431 VPWR.n430 0.0423097
R2038 VPWR.n781 VPWR.n780 0.04175
R2039 VPWR.n640 VPWR.n639 0.04175
R2040 VPWR.n296 VPWR.n295 0.04175
R2041 VPWR.n557 VPWR.n556 0.04175
R2042 VPWR.n914 VPWR.n912 0.0405
R2043 VPWR.n908 VPWR.n907 0.0405
R2044 VPWR.n826 VPWR.n825 0.0405
R2045 VPWR.n811 VPWR.n809 0.0405
R2046 VPWR.n687 VPWR.n685 0.0405
R2047 VPWR.n682 VPWR.n681 0.0405
R2048 VPWR.n569 VPWR.n568 0.0405
R2049 VPWR.n353 VPWR.n286 0.03925
R2050 VPWR.n936 VPWR.n86 0.038
R2051 VPWR.n941 VPWR.n83 0.038
R2052 VPWR.n946 VPWR.n945 0.038
R2053 VPWR.n957 VPWR.n77 0.038
R2054 VPWR.n958 VPWR.n956 0.038
R2055 VPWR.n967 VPWR.n966 0.038
R2056 VPWR.n965 VPWR.n73 0.038
R2057 VPWR.n73 VPWR.n72 0.038
R2058 VPWR.n162 VPWR.n161 0.038
R2059 VPWR.n217 VPWR.n215 0.038
R2060 VPWR.n219 VPWR.n175 0.038
R2061 VPWR.n224 VPWR.n172 0.038
R2062 VPWR.n229 VPWR.n228 0.038
R2063 VPWR.n231 VPWR.n171 0.038
R2064 VPWR.n821 VPWR.n783 0.038
R2065 VPWR.n58 VPWR.n756 0.0999426
R2066 VPWR.n33 VPWR.n31 0.0976683
R2067 VPWR.n711 VPWR.n709 0.038
R2068 VPWR.n720 VPWR.n719 0.038
R2069 VPWR.n718 VPWR.n237 0.038
R2070 VPWR.n734 VPWR.n732 0.038
R2071 VPWR.n5 VPWR.n732 0.118705
R2072 VPWR.n635 VPWR.n633 0.038
R2073 VPWR.n651 VPWR.n600 0.038
R2074 VPWR.n658 VPWR.n599 0.038
R2075 VPWR.n665 VPWR.n664 0.038
R2076 VPWR.n668 VPWR.n666 0.038
R2077 VPWR.n332 VPWR.n298 0.038
R2078 VPWR.n342 VPWR.n291 0.038
R2079 VPWR.n343 VPWR.n341 0.038
R2080 VPWR.n352 VPWR.n351 0.038
R2081 VPWR.n350 VPWR.n287 0.038
R2082 VPWR.n518 VPWR.n417 0.038
R2083 VPWR.n523 VPWR.n414 0.038
R2084 VPWR.n528 VPWR.n527 0.038
R2085 VPWR.n539 VPWR.n408 0.038
R2086 VPWR.n540 VPWR.n538 0.038
R2087 VPWR.n549 VPWR.n548 0.038
R2088 VPWR.n547 VPWR.n404 0.038
R2089 VPWR.n552 VPWR.n550 0.038
R2090 VPWR.n163 VPWR.n125 0.03425
R2091 VPWR.n193 VPWR.n192 0.0305
R2092 VPWR.n196 VPWR.n195 0.0305
R2093 VPWR.n199 VPWR.n198 0.0305
R2094 VPWR.n202 VPWR.n201 0.0305
R2095 VPWR.n205 VPWR.n204 0.0305
R2096 VPWR.n208 VPWR.n207 0.0305
R2097 VPWR.n27 VPWR.n772 0.0305
R2098 VPWR.n399 VPWR.n398 0.0305
R2099 VPWR.n396 VPWR.n395 0.0305
R2100 VPWR.n393 VPWR.n392 0.0305
R2101 VPWR.n390 VPWR.n389 0.0305
R2102 VPWR.n387 VPWR.n386 0.0305
R2103 VPWR.n384 VPWR.n383 0.0305
R2104 VPWR.n187 VPWR.n186 0.02925
R2105 VPWR.n944 VPWR.n82 0.023
R2106 VPWR.n949 VPWR.n948 0.023
R2107 VPWR.n954 VPWR.n78 0.023
R2108 VPWR.n955 VPWR.n953 0.023
R2109 VPWR.n216 VPWR.n176 0.023
R2110 VPWR.n227 VPWR.n171 0.023
R2111 VPWR.n723 VPWR.n722 0.023
R2112 VPWR.n721 VPWR.n236 0.023
R2113 VPWR.n731 VPWR.n729 0.023
R2114 VPWR.n733 VPWR.n234 0.023
R2115 VPWR.n655 VPWR.n600 0.023
R2116 VPWR.n654 VPWR.n599 0.023
R2117 VPWR.n665 VPWR.n663 0.023
R2118 VPWR.n668 VPWR.n667 0.023
R2119 VPWR.n355 VPWR.n354 0.023
R2120 VPWR.n526 VPWR.n413 0.023
R2121 VPWR.n531 VPWR.n530 0.023
R2122 VPWR.n536 VPWR.n409 0.023
R2123 VPWR.n537 VPWR.n535 0.023
R2124 VPWR.n910 VPWR.n64 0.0220706
R2125 VPWR.n977 VPWR.n975 0.0220706
R2126 VPWR.n505 VPWR.n504 0.0220706
R2127 VPWR.n509 VPWR.n508 0.0220706
R2128 VPWR.n566 VPWR.n565 0.0220706
R2129 VPWR.n563 VPWR.n562 0.0220706
R2130 VPWR.n68 VPWR.n66 0.0220706
R2131 VPWR.n970 VPWR.n969 0.0220706
R2132 VPWR.n380 VPWR.n379 0.02162
R2133 VPWR.n978 VPWR.n63 0.02162
R2134 VPWR.n40 VPWR.n243 0.0205
R2135 VPWR.n100 VPWR.n99 0.01925
R2136 VPWR.n876 VPWR.n36 0.01925
R2137 VPWR.n153 VPWR.n54 0.01925
R2138 VPWR.n786 VPWR.n785 0.01925
R2139 VPWR.n257 VPWR.n256 0.01925
R2140 VPWR.n628 VPWR.n571 0.01925
R2141 VPWR.n680 VPWR.n679 0.01925
R2142 VPWR.n299 VPWR.n281 0.01925
R2143 VPWR.n439 VPWR.n425 0.01925
R2144 VPWR.n551 VPWR.n404 0.01925
R2145 VPWR.n3 VPWR.t318 0.0186778
R2146 VPWR.n182 VPWR.n181 0.018
R2147 VPWR.n740 VPWR.n739 0.018
R2148 VPWR.n754 VPWR.n753 0.0155
R2149 VPWR.n751 VPWR.n750 0.0155
R2150 VPWR.n748 VPWR.n747 0.0155
R2151 VPWR.n20 VPWR.n434 0.013
R2152 VPWR.n914 VPWR.n913 0.01175
R2153 VPWR.n907 VPWR.n828 0.01175
R2154 VPWR.n825 VPWR.n124 0.01175
R2155 VPWR.n811 VPWR.n810 0.01175
R2156 VPWR.n762 VPWR.n761 0.01175
R2157 VPWR.n764 VPWR.n763 0.01175
R2158 VPWR.n687 VPWR.n686 0.01175
R2159 VPWR.n681 VPWR.n572 0.01175
R2160 VPWR.n568 VPWR.n282 0.01175
R2161 VPWR.n437 VPWR.n436 0.01175
R2162 VPWR.n507 VPWR.n506 0.0115476
R2163 VPWR.n506 VPWR.n503 0.0115476
R2164 VPWR.n972 VPWR.n67 0.0115476
R2165 VPWR.n972 VPWR.n971 0.0115476
R2166 VPWR.n947 VPWR.n81 0.008
R2167 VPWR.n952 VPWR.n950 0.008
R2168 VPWR.n213 VPWR.n177 0.008
R2169 VPWR.n230 VPWR.n170 0.008
R2170 VPWR.n758 VPWR.n757 0.008
R2171 VPWR.n725 VPWR.n724 0.008
R2172 VPWR.n730 VPWR.n235 0.008
R2173 VPWR.n652 VPWR.n601 0.008
R2174 VPWR.n657 VPWR.n598 0.008
R2175 VPWR.n662 VPWR.n660 0.008
R2176 VPWR.n670 VPWR.n669 0.008
R2177 VPWR.n335 VPWR.n334 0.008
R2178 VPWR.n50 VPWR.n402 0.008
R2179 VPWR.n529 VPWR.n412 0.008
R2180 VPWR.n534 VPWR.n532 0.008
R2181 VPWR.n822 VPWR.n820 0.0055
R2182 VPWR.n637 VPWR.n602 0.0055
R2183 VPWR.n333 VPWR.n331 0.0055
R2184 VPWR.n442 VPWR.n424 0.0055
R2185 VPWR.n554 VPWR.n403 0.0055
R2186 VPWR.n364 VPWR.n363 0.00425
R2187 VPWR.n367 VPWR.n366 0.00425
R2188 VPWR.n370 VPWR.n369 0.00425
R2189 VPWR.t28 VPWR.t450 8.50445
R2190 VPWR.t28 VPWR.n26 1.14377
R2191 VPWR.t3 VPWR.n1 0.351713
R2192 VPWR.t400 VPWR.t70 1.04585
R2193 VPWR.t5 VPWR.n736 1.04507
R2194 VGND.n557 VGND.n556 63703.7
R2195 VGND.t40 VGND.n38 6300
R2196 VGND.t40 VGND.n179 6300
R2197 VGND.n24 VGND.n179 6300
R2198 VGND.n614 VGND.n24 6300
R2199 VGND.n118 VGND.n614 6300
R2200 VGND.t156 VGND.n118 6300
R2201 VGND.t156 VGND.n291 6300
R2202 VGND.n556 VGND.n291 6300
R2203 VGND.n35 VGND.n75 5948.99
R2204 VGND.t40 VGND.n75 5785.71
R2205 VGND.t40 VGND.n178 5785.71
R2206 VGND.n617 VGND.n178 5785.71
R2207 VGND.n617 VGND.n616 5785.71
R2208 VGND.n616 VGND.n615 5785.71
R2209 VGND.n615 VGND.t156 5785.71
R2210 VGND.t156 VGND.n289 5785.71
R2211 VGND.n557 VGND.n289 5785.71
R2212 VGND.n35 VGND.n144 14.0759
R2213 VGND.t1419 VGND.n35 183.805
R2214 VGND.t1372 VGND.n35 182.042
R2215 VGND.t865 VGND.n109 91.7683
R2216 VGND.n35 VGND.t1384 183.805
R2217 VGND.n35 VGND.t1394 183.805
R2218 VGND.t1409 VGND.n35 183.806
R2219 VGND.n35 VGND.t1414 183.806
R2220 VGND.n38 VGND.n35 6413.31
R2221 VGND.n731 VGND.t1436 687.192
R2222 VGND.t1437 VGND.n729 687.192
R2223 VGND.t861 VGND.n37 82.2354
R2224 VGND.n144 VGND.t1435 645.394
R2225 VGND.t1438 VGND.n728 642.857
R2226 VGND.n716 VGND.t861 642.857
R2227 VGND.t1439 VGND.n727 598.523
R2228 VGND.n717 VGND.t859 598.523
R2229 VGND.t1440 VGND.n726 554.188
R2230 VGND.n718 VGND.t1449 554.188
R2231 VGND.t1441 VGND.n725 509.853
R2232 VGND.n719 VGND.t1448 509.853
R2233 VGND.t1442 VGND.n724 465.517
R2234 VGND.n720 VGND.t1447 465.517
R2235 VGND.t873 VGND.n142 46.0428
R2236 VGND.n39 VGND.n75 427.132
R2237 VGND.n52 VGND.n178 427.132
R2238 VGND.n22 VGND.n617 427.132
R2239 VGND.n616 VGND.n26 427.132
R2240 VGND.n615 VGND.n71 427.132
R2241 VGND.n12 VGND.n289 427.132
R2242 VGND.n130 VGND.n557 427.132
R2243 VGND.t1443 VGND.n723 421.183
R2244 VGND.n721 VGND.t1446 421.183
R2245 VGND.t1367 VGND.n35 182.042
R2246 VGND.n35 VGND.t1396 182.042
R2247 VGND.n35 VGND.t1421 182.042
R2248 VGND.t1426 VGND.n35 182.042
R2249 VGND.n691 VGND.t148 398.572
R2250 VGND.t149 VGND.n688 398.572
R2251 VGND.t486 VGND.n681 398.572
R2252 VGND.n701 VGND.t856 398.572
R2253 VGND.t1569 VGND.n670 398.572
R2254 VGND.t459 VGND.n621 398.572
R2255 VGND.t36 VGND.n210 398.572
R2256 VGND.n633 VGND.t37 398.572
R2257 VGND.n646 VGND.t846 398.572
R2258 VGND.n648 VGND.t74 398.572
R2259 VGND.t75 VGND.n194 398.572
R2260 VGND.t124 VGND.n187 398.572
R2261 VGND.n656 VGND.t125 398.572
R2262 VGND.n273 VGND.t1546 398.572
R2263 VGND.n287 VGND.t804 398.572
R2264 VGND.n327 VGND.t277 398.572
R2265 VGND.t278 VGND.n326 398.572
R2266 VGND.t411 VGND.n319 398.572
R2267 VGND.n335 VGND.t412 398.572
R2268 VGND.n336 VGND.t577 398.572
R2269 VGND.n343 VGND.t1563 398.572
R2270 VGND.t1564 VGND.n309 398.572
R2271 VGND.n345 VGND.t65 398.572
R2272 VGND.n358 VGND.t779 398.572
R2273 VGND.n580 VGND.t184 398.572
R2274 VGND.t185 VGND.n387 398.572
R2275 VGND.t216 VGND.n375 398.572
R2276 VGND.t97 VGND.n372 398.572
R2277 VGND.n596 VGND.t98 398.572
R2278 VGND.n603 VGND.t257 398.572
R2279 VGND.t258 VGND.n364 398.572
R2280 VGND.t334 VGND.n428 398.572
R2281 VGND.n439 VGND.t1536 398.572
R2282 VGND.t609 VGND.n413 398.572
R2283 VGND.n451 VGND.t317 398.572
R2284 VGND.t643 VGND.n403 398.572
R2285 VGND.t325 VGND.n396 398.572
R2286 VGND.t1501 VGND.n511 398.572
R2287 VGND.t1502 VGND.n510 398.572
R2288 VGND.n533 VGND.t1465 398.572
R2289 VGND.n536 VGND.t1485 398.572
R2290 VGND.t1486 VGND.n495 398.572
R2291 VGND.t717 VGND.n488 398.572
R2292 VGND.n545 VGND.t718 398.572
R2293 VGND.t701 VGND.n486 398.572
R2294 VGND.n554 VGND.t695 398.572
R2295 VGND.n35 VGND.t1350 183.804
R2296 VGND.n35 VGND.t1355 183.805
R2297 VGND.t424 VGND.n222 385.714
R2298 VGND.t361 VGND.t829 385.714
R2299 VGND.t419 VGND.t679 385.714
R2300 VGND.t550 VGND.t814 385.714
R2301 VGND.t518 VGND.n414 385.714
R2302 VGND.t739 VGND.n395 385.714
R2303 VGND.t1470 VGND.n513 385.714
R2304 VGND.n93 VGND.t1532 385.524
R2305 VGND.n613 VGND.t155 381.43
R2306 VGND.t1444 VGND.n722 376.848
R2307 VGND.n722 VGND.t1445 376.848
R2308 VGND.t147 VGND.n690 372.858
R2309 VGND.n693 VGND.t151 372.858
R2310 VGND.n699 VGND.t485 372.858
R2311 VGND.n714 VGND.t869 372.858
R2312 VGND.t458 VGND.n141 375.315
R2313 VGND.n632 VGND.t35 372.858
R2314 VGND.t38 VGND.n209 372.858
R2315 VGND.t845 VGND.n197 372.858
R2316 VGND.n647 VGND.t848 372.858
R2317 VGND.t73 VGND.n104 375.315
R2318 VGND.n649 VGND.t76 372.858
R2319 VGND.n655 VGND.t123 372.858
R2320 VGND.t127 VGND.n112 375.315
R2321 VGND.t690 VGND.n186 372.858
R2322 VGND.n658 VGND.t850 372.858
R2323 VGND.t359 VGND.n94 375.315
R2324 VGND.t828 VGND.n256 372.858
R2325 VGND.n261 VGND.t362 372.858
R2326 VGND.n268 VGND.t418 372.858
R2327 VGND.t680 VGND.n246 372.858
R2328 VGND.t421 VGND.n245 372.858
R2329 VGND.n272 VGND.t1544 372.858
R2330 VGND.t1547 VGND.n242 372.858
R2331 VGND.n279 VGND.t549 372.858
R2332 VGND.t815 VGND.n234 372.858
R2333 VGND.n288 VGND.t807 372.858
R2334 VGND.t625 VGND.n225 372.858
R2335 VGND.t276 VGND.n143 375.315
R2336 VGND.n328 VGND.t279 372.858
R2337 VGND.n334 VGND.t410 372.858
R2338 VGND.n337 VGND.t579 372.858
R2339 VGND.t1562 VGND.n311 372.858
R2340 VGND.n97 VGND.t1565 375.315
R2341 VGND.t64 VGND.n308 372.858
R2342 VGND.n346 VGND.t67 372.858
R2343 VGND.t778 VGND.t810 372.858
R2344 VGND.n359 VGND.t781 372.858
R2345 VGND.n611 VGND.t416 372.858
R2346 VGND.t183 VGND.n389 372.858
R2347 VGND.n582 VGND.t186 372.858
R2348 VGND.t218 VGND.n373 372.858
R2349 VGND.n595 VGND.t96 372.858
R2350 VGND.t99 VGND.n371 372.858
R2351 VGND.t256 VGND.n365 372.858
R2352 VGND.n363 VGND.t632 372.858
R2353 VGND.n429 VGND.t333 372.858
R2354 VGND.n443 VGND.t608 372.858
R2355 VGND.t611 VGND.n412 372.858
R2356 VGND.n452 VGND.t319 372.858
R2357 VGND.t641 VGND.n404 372.858
R2358 VGND.n455 VGND.t644 372.858
R2359 VGND.n461 VGND.t324 372.858
R2360 VGND.n571 VGND.t623 372.858
R2361 VGND.n142 VGND.t870 112.823
R2362 VGND.n535 VGND.t1467 372.858
R2363 VGND.t1484 VGND.n497 372.858
R2364 VGND.n538 VGND.t1487 372.858
R2365 VGND.n546 VGND.t700 372.858
R2366 VGND.t703 VGND.n485 372.858
R2367 VGND.n555 VGND.t697 372.858
R2368 VGND.t635 VGND.n476 372.858
R2369 VGND.t1480 VGND.n560 372.858
R2370 VGND.n559 VGND.t1523 372.858
R2371 VGND.t1431 VGND.n35 185.452
R2372 VGND.t457 VGND.n141 52.5382
R2373 VGND.n143 VGND.t274 52.5382
R2374 VGND.t1235 VGND.n112 13.8941
R2375 VGND.t11 VGND.n97 13.894
R2376 VGND.n99 VGND.t415 52.5394
R2377 VGND.t260 VGND.n108 52.5398
R2378 VGND.n113 VGND.t328 52.5379
R2379 VGND.n104 VGND.t71 52.5375
R2380 VGND.t357 VGND.n94 52.5375
R2381 VGND.t1572 VGND.n44 362.846
R2382 VGND.t808 VGND.n16 362.846
R2383 VGND.t95 VGND.n68 362.846
R2384 VGND.t320 VGND.n8 362.846
R2385 VGND.t1499 VGND.n123 362.846
R2386 VGND.t1468 VGND.n122 362.846
R2387 VGND.n127 VGND.t720 362.846
R2388 VGND.t698 VGND.n120 362.846
R2389 VGND.n622 VGND.t899 360
R2390 VGND.t1452 VGND.n119 362.95
R2391 VGND.n442 VGND.t1522 360
R2392 VGND.n569 VGND.t1526 360
R2393 VGND.n515 VGND.t1451 360
R2394 VGND.t1466 VGND.t1505 360
R2395 VGND.t583 VGND.n667 355.714
R2396 VGND.n258 VGND.t1531 355.714
R2397 VGND.t0 VGND.n374 355.714
R2398 VGND.t744 VGND.n416 355.714
R2399 VGND.n471 VGND.t1528 355.714
R2400 VGND.t152 VGND.n687 347.144
R2401 VGND.t34 VGND.n211 347.144
R2402 VGND.n634 VGND.t39 347.144
R2403 VGND.t849 VGND.n195 347.144
R2404 VGND.t77 VGND.n193 347.144
R2405 VGND.t122 VGND.n188 347.144
R2406 VGND.n259 VGND.t827 347.144
R2407 VGND.t363 VGND.n254 347.144
R2408 VGND.t417 VGND.n248 347.144
R2409 VGND.n270 VGND.t681 347.144
R2410 VGND.n271 VGND.t422 347.144
R2411 VGND.t1542 VGND.n244 347.144
R2412 VGND.t548 VGND.n236 347.144
R2413 VGND.n281 VGND.t816 347.144
R2414 VGND.n286 VGND.t802 347.144
R2415 VGND.t280 VGND.n325 347.144
R2416 VGND.t409 VGND.n320 347.144
R2417 VGND.t580 VGND.n316 347.144
R2418 VGND.t68 VGND.n306 347.144
R2419 VGND.n357 VGND.t777 347.144
R2420 VGND.t782 VGND.n294 347.144
R2421 VGND.t187 VGND.n386 347.144
R2422 VGND.t214 VGND.n376 347.144
R2423 VGND.n597 VGND.t100 347.144
R2424 VGND.n602 VGND.t255 347.144
R2425 VGND.n440 VGND.t1538 347.144
R2426 VGND.n445 VGND.t612 347.144
R2427 VGND.n450 VGND.t314 347.144
R2428 VGND.n453 VGND.t640 347.144
R2429 VGND.t323 VGND.n397 347.144
R2430 VGND.t1488 VGND.n494 347.144
R2431 VGND.t715 VGND.n489 347.144
R2432 VGND.n548 VGND.t704 347.144
R2433 VGND.n553 VGND.t692 347.144
R2434 VGND.t1365 VGND.n35 183.806
R2435 VGND.t1379 VGND.n35 183.804
R2436 VGND.t1389 VGND.n35 183.806
R2437 VGND.t1399 VGND.n35 183.806
R2438 VGND.t1429 VGND.n35 183.806
R2439 VGND.t487 VGND.t853 334.286
R2440 VGND.t854 VGND.t488 334.286
R2441 VGND.t489 VGND.t855 334.286
R2442 VGND.t872 VGND.t1571 334.286
R2443 VGND.t581 VGND.n221 334.286
R2444 VGND.t335 VGND.t722 334.286
R2445 VGND.t723 VGND.t336 334.286
R2446 VGND.t337 VGND.t724 334.286
R2447 VGND.t1533 VGND.t513 334.286
R2448 VGND.t514 VGND.t1534 334.286
R2449 VGND.t1535 VGND.t515 334.286
R2450 VGND.t327 VGND.t356 334.286
R2451 VGND.t740 VGND.n394 334.286
R2452 VGND.n723 VGND.t1444 332.512
R2453 VGND.t1445 VGND.n721 332.512
R2454 VGND.n124 VGND.t1478 329.185
R2455 VGND.t742 VGND.n70 328.56
R2456 VGND.t396 VGND.n66 328.56
R2457 VGND.t898 VGND.n132 328.56
R2458 VGND.n131 VGND.t1479 328.56
R2459 VGND.n698 VGND.t483 321.43
R2460 VGND.n623 VGND.t463 321.43
R2461 VGND.n631 VGND.t33 321.43
R2462 VGND.t441 VGND.n208 321.43
R2463 VGND.t297 VGND.n198 321.43
R2464 VGND.n650 VGND.t78 321.43
R2465 VGND.n654 VGND.t88 321.43
R2466 VGND.n262 VGND.t665 321.43
R2467 VGND.n267 VGND.t842 321.43
R2468 VGND.t538 VGND.n241 321.43
R2469 VGND.n278 VGND.t547 321.43
R2470 VGND.t817 VGND.n233 321.43
R2471 VGND.t826 VGND.n229 321.43
R2472 VGND.n329 VGND.t398 321.43
R2473 VGND.n333 VGND.t408 321.43
R2474 VGND.n338 VGND.t1551 321.43
R2475 VGND.t1560 VGND.n312 321.43
R2476 VGND.t776 VGND.n296 321.43
R2477 VGND.n583 VGND.t188 321.43
R2478 VGND.n591 VGND.t181 321.43
R2479 VGND.t101 VGND.n370 321.43
R2480 VGND.t110 VGND.n366 321.43
R2481 VGND.n431 VGND.t338 321.43
R2482 VGND.n437 VGND.t737 321.43
R2483 VGND.t622 VGND.n407 321.43
R2484 VGND.n456 VGND.t646 321.43
R2485 VGND.n543 VGND.t1498 321.43
R2486 VGND.t714 VGND.n479 321.43
R2487 VGND.n93 VGND.t358 12.2559
R2488 VGND.n44 VGND.t691 319.99
R2489 VGND.n68 VGND.t1539 319.99
R2490 VGND.n4 VGND.t743 319.99
R2491 VGND.t329 VGND.n134 320.613
R2492 VGND.t1424 VGND.n35 183.805
R2493 VGND.t1416 VGND.n35 182.042
R2494 VGND.n35 VGND.t1411 182.042
R2495 VGND.t1406 VGND.n35 182.042
R2496 VGND.n35 VGND.t1401 182.042
R2497 VGND.n35 VGND.t1391 182.042
R2498 VGND.t1386 VGND.n35 182.042
R2499 VGND.n35 VGND.t1381 182.042
R2500 VGND.n35 VGND.t1377 182.024
R2501 VGND.n35 VGND.t1375 183.806
R2502 VGND.t1370 VGND.n35 183.805
R2503 VGND.t1362 VGND.n35 182.042
R2504 VGND.n35 VGND.t1357 182.042
R2505 VGND.t1352 VGND.n35 182.042
R2506 VGND.n35 VGND.t1347 181.875
R2507 VGND.t624 VGND.t154 317.144
R2508 VGND.t867 VGND.n145 320.721
R2509 VGND.n95 VGND.t365 321.541
R2510 VGND.t852 VGND.n185 312.858
R2511 VGND.n148 VGND.t220 320.065
R2512 VGND.t163 VGND.n610 312.858
R2513 VGND.n604 VGND.t1540 312.858
R2514 VGND.t572 VGND.n392 312.858
R2515 VGND.n147 VGND.t870 320.721
R2516 VGND.t1482 VGND.n499 312.858
R2517 VGND.t1471 VGND.n558 312.858
R2518 VGND.t857 VGND.t490 308.572
R2519 VGND.t492 VGND.t858 308.572
R2520 VGND.t874 VGND.t493 308.572
R2521 VGND.t887 VGND.t508 308.572
R2522 VGND.t1567 VGND.t888 308.572
R2523 VGND.t889 VGND.t1568 308.572
R2524 VGND.t450 VGND.t285 308.572
R2525 VGND.t286 VGND.t451 308.572
R2526 VGND.t452 VGND.t287 308.572
R2527 VGND.t288 VGND.t453 308.572
R2528 VGND.t1472 VGND.t1503 308.572
R2529 VGND.t1504 VGND.t1473 308.572
R2530 VGND.t1474 VGND.t1506 308.572
R2531 VGND.t1462 VGND.t1519 308.572
R2532 VGND.t1520 VGND.t1463 308.572
R2533 VGND.t1464 VGND.t1521 308.572
R2534 VGND.t634 VGND.n612 304.286
R2535 VGND.t1570 VGND.t509 300
R2536 VGND.t321 VGND.t326 300
R2537 VGND.t475 VGND.n686 295.714
R2538 VGND.t482 VGND.n683 295.714
R2539 VGND.n703 VGND.t875 295.714
R2540 VGND.t507 VGND.n672 295.714
R2541 VGND.n635 VGND.t442 295.714
R2542 VGND.n638 VGND.t449 295.714
R2543 VGND.n641 VGND.t289 295.714
R2544 VGND.n644 VGND.t296 295.714
R2545 VGND.t79 VGND.n192 295.714
R2546 VGND.t87 VGND.n189 295.714
R2547 VGND.t666 VGND.n253 295.714
R2548 VGND.t841 VGND.n249 295.714
R2549 VGND.n275 VGND.t539 295.714
R2550 VGND.t546 VGND.n237 295.714
R2551 VGND.n282 VGND.t818 295.714
R2552 VGND.n285 VGND.t825 295.714
R2553 VGND.t399 VGND.n324 295.714
R2554 VGND.t407 VGND.n321 295.714
R2555 VGND.t1552 VGND.n315 295.714
R2556 VGND.n341 VGND.t1559 295.714
R2557 VGND.t6 VGND.n305 295.714
R2558 VGND.n356 VGND.t775 295.714
R2559 VGND.n598 VGND.t102 295.714
R2560 VGND.n601 VGND.t109 295.714
R2561 VGND.t339 VGND.n425 295.714
R2562 VGND.t736 VGND.n420 295.714
R2563 VGND.n446 VGND.t614 295.714
R2564 VGND.n449 VGND.t621 295.714
R2565 VGND.t647 VGND.n401 295.714
R2566 VGND.t655 VGND.n398 295.714
R2567 VGND.t1507 VGND.n508 295.714
R2568 VGND.n531 VGND.t1461 295.714
R2569 VGND.t1490 VGND.n493 295.714
R2570 VGND.n549 VGND.t706 295.714
R2571 VGND.n552 VGND.t713 295.714
R2572 VGND.n724 VGND.t1443 288.178
R2573 VGND.t1446 VGND.n720 288.178
R2574 VGND.n712 VGND.t1574 287.144
R2575 VGND.n347 VGND.t1543 287.144
R2576 VGND.t115 VGND.n292 287.144
R2577 VGND.n594 VGND.t663 287.144
R2578 VGND.n441 VGND.t517 287.144
R2579 VGND.t637 VGND.n469 287.144
R2580 VGND.t14 VGND.t60 282.858
R2581 VGND.t61 VGND.t15 282.858
R2582 VGND.t16 VGND.t62 282.858
R2583 VGND.t767 VGND.t17 282.858
R2584 VGND.t18 VGND.t768 282.858
R2585 VGND.n695 VGND.t476 270
R2586 VGND.t876 VGND.n677 270
R2587 VGND.n708 VGND.t506 270
R2588 VGND.t448 VGND.n205 270
R2589 VGND.t290 VGND.n201 270
R2590 VGND.n651 VGND.t80 270
R2591 VGND.n653 VGND.t86 270
R2592 VGND.n263 VGND.t667 270
R2593 VGND.n266 VGND.t840 270
R2594 VGND.n238 VGND.t545 270
R2595 VGND.t819 VGND.n232 270
R2596 VGND.n330 VGND.t400 270
R2597 VGND.n332 VGND.t406 270
R2598 VGND.t1553 VGND.n314 270
R2599 VGND.t1558 VGND.t801 270
R2600 VGND.n348 VGND.t7 270
R2601 VGND.n350 VGND.t13 270
R2602 VGND.t769 VGND.n299 270
R2603 VGND.t774 VGND.n297 270
R2604 VGND.t103 VGND.n369 270
R2605 VGND.t108 VGND.n367 270
R2606 VGND.n432 VGND.t340 270
R2607 VGND.n436 VGND.t735 270
R2608 VGND.t615 VGND.n410 270
R2609 VGND.n459 VGND.t654 270
R2610 VGND.n526 VGND.t1508 270
R2611 VGND.t1460 VGND.n502 270
R2612 VGND.n540 VGND.t1491 270
R2613 VGND.n542 VGND.t1496 270
R2614 VGND.t707 VGND.n482 270
R2615 VGND.t150 VGND.t1323 252.065
R2616 VGND.t1209 VGND.t1235 109.001
R2617 VGND.t11 VGND.t1114 109.001
R2618 VGND.t1060 VGND.t1069 252.065
R2619 VGND.t1060 VGND.t1077 108.999
R2620 VGND.t1060 VGND.t1082 108.999
R2621 VGND.t959 VGND.t315 109.001
R2622 VGND.t994 VGND.t315 108.993
R2623 VGND.t150 VGND.n87 9.63482
R2624 VGND.t1333 VGND.n91 99.5774
R2625 VGND.n82 VGND.t1335 99.5774
R2626 VGND.t1337 VGND.n100 99.5774
R2627 VGND.t150 VGND.n78 9.63482
R2628 VGND.t1341 VGND.n107 99.5774
R2629 VGND.t150 VGND.n76 9.63482
R2630 VGND.t1345 VGND.n117 99.5774
R2631 VGND.t1235 VGND.t1218 108.993
R2632 VGND.t1198 VGND.n103 99.5774
R2633 VGND.t358 VGND.n84 9.63482
R2634 VGND.n111 VGND.t358 9.63482
R2635 VGND.t1204 VGND.t358 108.938
R2636 VGND.t315 VGND.t966 108.993
R2637 VGND.n139 VGND.n138 0.0420737
R2638 VGND.n124 VGND.t940 252.041
R2639 VGND.t930 VGND.n135 252.041
R2640 VGND.t1284 VGND.t150 108.722
R2641 VGND.n179 VGND.t1235 427.5
R2642 VGND.t1216 VGND.n59 251.417
R2643 VGND.t1242 VGND.n62 251.417
R2644 VGND.t1222 VGND.n63 251.417
R2645 VGND.t358 VGND.t1152 108.722
R2646 VGND.n16 VGND.t1196 251.417
R2647 VGND.t11 VGND.t1112 108.722
R2648 VGND.t1124 VGND.n32 251.417
R2649 VGND.t1147 VGND.n33 251.417
R2650 VGND.t1060 VGND.n118 427.5
R2651 VGND.n291 VGND.t315 427.5
R2652 VGND.t986 VGND.n8 251.417
R2653 VGND.t968 VGND.n0 251.417
R2654 VGND.n556 VGND.n140 427.5
R2655 VGND.n122 VGND.t911 251.417
R2656 VGND.n120 VGND.t926 251.417
R2657 VGND.t480 VGND.n684 244.286
R2658 VGND.n704 VGND.t877 244.286
R2659 VGND.t505 VGND.n673 244.286
R2660 VGND.n636 VGND.t444 244.286
R2661 VGND.n637 VGND.t447 244.286
R2662 VGND.n642 VGND.t291 244.286
R2663 VGND.n643 VGND.t294 244.286
R2664 VGND.t81 VGND.n191 244.286
R2665 VGND.t85 VGND.n190 244.286
R2666 VGND.t668 VGND.n252 244.286
R2667 VGND.t839 VGND.n250 244.286
R2668 VGND.n276 VGND.t541 244.286
R2669 VGND.n277 VGND.t544 244.286
R2670 VGND.n283 VGND.t820 244.286
R2671 VGND.n284 VGND.t823 244.286
R2672 VGND.t401 VGND.n323 244.286
R2673 VGND.t405 VGND.n322 244.286
R2674 VGND.n340 VGND.t1557 244.286
R2675 VGND.t8 VGND.n304 244.286
R2676 VGND.t12 VGND.n303 244.286
R2677 VGND.n354 VGND.t770 244.286
R2678 VGND.n355 VGND.t773 244.286
R2679 VGND.n599 VGND.t104 244.286
R2680 VGND.n600 VGND.t107 244.286
R2681 VGND.t341 VGND.n424 244.286
R2682 VGND.t734 VGND.n421 244.286
R2683 VGND.n447 VGND.t616 244.286
R2684 VGND.n448 VGND.t619 244.286
R2685 VGND.t649 VGND.n400 244.286
R2686 VGND.t1509 VGND.n507 244.286
R2687 VGND.n530 VGND.t1459 244.286
R2688 VGND.t1495 VGND.n491 244.286
R2689 VGND.n550 VGND.t708 244.286
R2690 VGND.n551 VGND.t711 244.286
R2691 VGND.n725 VGND.t1442 243.843
R2692 VGND.t1447 VGND.n719 243.843
R2693 VGND.t1285 VGND.t150 109.986
R2694 VGND.t150 VGND.t1287 109.992
R2695 VGND.t1289 VGND.t150 109.992
R2696 VGND.n146 VGND.t1313 100.888
R2697 VGND.t1235 VGND.t1208 109.986
R2698 VGND.t1235 VGND.t1220 109.986
R2699 VGND.t358 VGND.t1158 109.992
R2700 VGND.t1160 VGND.t358 109.992
R2701 VGND.t1113 VGND.t11 109.986
R2702 VGND.t1117 VGND.t11 109.992
R2703 VGND.t1061 VGND.t1060 109.986
R2704 VGND.t1060 VGND.t1068 109.992
R2705 VGND.t1072 VGND.t1060 109.986
R2706 VGND.t1060 VGND.t1074 109.993
R2707 VGND.t1076 VGND.t1060 109.992
R2708 VGND.t1081 VGND.t1060 109.992
R2709 VGND.t315 VGND.t953 109.986
R2710 VGND.t955 VGND.t315 109.992
R2711 VGND.t315 VGND.t957 109.992
R2712 VGND.t315 VGND.t967 109.986
R2713 VGND.t1311 VGND.n116 100.883
R2714 VGND.n77 VGND.t1309 100.883
R2715 VGND.t1305 VGND.n106 100.883
R2716 VGND.n79 VGND.t1303 100.883
R2717 VGND.n101 VGND.t150 9.30721
R2718 VGND.n83 VGND.t1297 100.883
R2719 VGND.n90 VGND.t150 9.30721
R2720 VGND.t1235 VGND.n105 9.30721
R2721 VGND.t358 VGND.n81 9.30721
R2722 VGND.n110 VGND.t358 9.30721
R2723 VGND.n85 VGND.t1174 100.883
R2724 VGND.t1171 VGND.n102 100.883
R2725 VGND.n115 VGND.t1150 100.883
R2726 VGND.t11 VGND.t1122 109.981
R2727 VGND.n133 VGND.t945 243.47
R2728 VGND.t910 VGND.n138 243.47
R2729 VGND.n59 VGND.t1236 242.846
R2730 VGND.t1243 VGND.n54 242.846
R2731 VGND.t1223 VGND.n53 242.846
R2732 VGND.n32 VGND.t1146 242.846
R2733 VGND.t997 VGND.n10 242.846
R2734 VGND.t969 VGND.n11 242.846
R2735 VGND.t113 VGND.n148 101.418
R2736 VGND.t150 VGND.n86 9.14339
R2737 VGND.t638 VGND.n135 239.185
R2738 VGND.n697 VGND.t1327 235.714
R2739 VGND.t1329 VGND.n668 235.714
R2740 VGND.t1293 VGND.n87 242.431
R2741 VGND.n91 VGND.t1295 242.431
R2742 VGND.t1298 VGND.n82 242.431
R2743 VGND.n100 VGND.t1301 242.431
R2744 VGND.t1304 VGND.n78 242.431
R2745 VGND.n107 VGND.t1307 242.431
R2746 VGND.t1310 VGND.n76 242.431
R2747 VGND.n117 VGND.t1312 242.431
R2748 VGND.t1232 VGND.n199 235.714
R2749 VGND.n271 VGND.t1166 235.714
R2750 VGND.t1194 VGND.n228 235.714
R2751 VGND.t1170 VGND.n226 235.714
R2752 VGND.n103 VGND.t1172 242.431
R2753 VGND.t1175 VGND.n84 242.431
R2754 VGND.n111 VGND.t1179 242.431
R2755 VGND.t1141 VGND.n98 238.173
R2756 VGND.n342 VGND.t1143 235.714
R2757 VGND.n612 VGND.t1149 235.714
R2758 VGND.t1087 VGND.n362 235.714
R2759 VGND.t964 VGND.t520 235.714
R2760 VGND.t984 VGND.n406 235.714
R2761 VGND.t990 VGND.n399 235.714
R2762 VGND.t996 VGND.n394 235.714
R2763 VGND.t1469 VGND.t909 235.714
R2764 VGND.t916 VGND.n490 235.714
R2765 VGND.t924 VGND.n478 235.714
R2766 VGND.n470 VGND.t928 235.714
R2767 VGND.n473 VGND.t944 235.714
R2768 VGND.t946 VGND.n466 235.714
R2769 VGND.t464 VGND.t221 231.429
R2770 VGND.t223 VGND.t465 231.429
R2771 VGND.t466 VGND.t224 231.429
R2772 VGND.t30 VGND.t563 231.429
R2773 VGND.t564 VGND.t31 231.429
R2774 VGND.t32 VGND.t565 231.429
R2775 VGND.t189 VGND.t164 231.429
R2776 VGND.t166 VGND.t190 231.429
R2777 VGND.t191 VGND.t167 231.429
R2778 VGND.t178 VGND.t660 231.429
R2779 VGND.t661 VGND.t179 231.429
R2780 VGND.t180 VGND.t662 231.429
R2781 VGND.n692 VGND.t1324 227.143
R2782 VGND.t1326 VGND.n685 227.143
R2783 VGND.t1330 VGND.n86 234.351
R2784 VGND.n90 VGND.t1332 234.188
R2785 VGND.n101 VGND.t1336 234.188
R2786 VGND.n95 VGND.t1241 102.457
R2787 VGND.t1169 VGND.n240 227.143
R2788 VGND.t1195 VGND.n227 227.143
R2789 VGND.n110 VGND.t1201 234.188
R2790 VGND.t1203 VGND.n81 234.188
R2791 VGND.t1142 VGND.n317 227.143
R2792 VGND.n344 VGND.t1144 227.143
R2793 VGND.n581 VGND.t1070 227.143
R2794 VGND.t1111 VGND.n362 227.143
R2795 VGND.t981 VGND.n411 227.143
R2796 VGND.t985 VGND.n405 227.143
R2797 VGND.n457 VGND.t989 227.143
R2798 VGND.n568 VGND.t995 227.143
R2799 VGND.t939 VGND.n512 227.143
R2800 VGND.n537 VGND.t913 227.143
R2801 VGND.t921 VGND.n483 227.143
R2802 VGND.t925 VGND.n477 227.143
R2803 VGND.n134 VGND.t927 243.47
R2804 VGND.n472 VGND.t929 227.143
R2805 VGND.t931 VGND.n467 227.143
R2806 VGND.n561 VGND.t949 227.143
R2807 VGND.t847 VGND.t1234 222.857
R2808 VGND.t682 VGND.n89 231.541
R2809 VGND.t780 VGND.t1145 222.857
R2810 VGND.n592 VGND.t664 222.857
R2811 VGND.t980 VGND.t610 222.857
R2812 VGND.t920 VGND.t702 222.857
R2813 VGND.n145 VGND.t1314 102.709
R2814 VGND.t1221 VGND.n96 15.0018
R2815 VGND.t1191 VGND.n88 15.0018
R2816 VGND.t1084 VGND.t1060 111.022
R2817 VGND.t961 VGND.t315 222.065
R2818 VGND.n147 VGND.n138 8.48859
R2819 VGND.n138 VGND.t933 222.065
R2820 VGND.n119 VGND.t1060 13.4027
R2821 VGND.t11 VGND.t1123 222.041
R2822 VGND.n114 VGND.t1128 102.703
R2823 VGND.n133 VGND.t932 222.041
R2824 VGND.t1237 VGND.n60 221.417
R2825 VGND.n53 VGND.t1244 221.417
R2826 VGND.t1151 VGND.n26 221.417
R2827 VGND.n11 VGND.t998 221.417
R2828 VGND.n131 VGND.t950 221.417
R2829 VGND.n696 VGND.t478 218.571
R2830 VGND.n696 VGND.t479 218.571
R2831 VGND.t878 VGND.n676 218.571
R2832 VGND.n707 VGND.t503 218.571
R2833 VGND.n625 VGND.t467 218.571
R2834 VGND.n629 VGND.t29 218.571
R2835 VGND.t445 VGND.n206 218.571
R2836 VGND.t446 VGND.n206 218.571
R2837 VGND.t292 VGND.n200 218.571
R2838 VGND.t293 VGND.n200 218.571
R2839 VGND.n652 VGND.t83 218.571
R2840 VGND.n652 VGND.t84 218.571
R2841 VGND.n264 VGND.t669 218.571
R2842 VGND.n265 VGND.t838 218.571
R2843 VGND.t542 VGND.n239 218.571
R2844 VGND.t543 VGND.n239 218.571
R2845 VGND.t822 VGND.n231 218.571
R2846 VGND.n331 VGND.t403 218.571
R2847 VGND.n331 VGND.t404 218.571
R2848 VGND.t1556 VGND.n313 218.571
R2849 VGND.n349 VGND.t10 218.571
R2850 VGND.t771 VGND.n298 218.571
R2851 VGND.n585 VGND.t192 218.571
R2852 VGND.n589 VGND.t177 218.571
R2853 VGND.t105 VGND.n368 218.571
R2854 VGND.t106 VGND.n368 218.571
R2855 VGND.n433 VGND.t343 218.571
R2856 VGND.n435 VGND.t733 218.571
R2857 VGND.t618 VGND.n409 218.571
R2858 VGND.n458 VGND.t650 218.571
R2859 VGND.n458 VGND.t651 218.571
R2860 VGND.n527 VGND.t1510 218.571
R2861 VGND.t1458 VGND.n503 218.571
R2862 VGND.n541 VGND.t1494 218.571
R2863 VGND.t710 VGND.n481 218.571
R2864 VGND.t1545 VGND.t1167 214.286
R2865 VGND.t987 VGND.t642 214.286
R2866 VGND.t66 VGND.t1541 210
R2867 VGND.t225 VGND.t468 205.714
R2868 VGND.t469 VGND.t226 205.714
R2869 VGND.t227 VGND.t470 205.714
R2870 VGND.t471 VGND.t22 205.714
R2871 VGND.t24 VGND.t472 205.714
R2872 VGND.t560 VGND.t25 205.714
R2873 VGND.t26 VGND.t561 205.714
R2874 VGND.t562 VGND.t28 205.714
R2875 VGND.t1215 VGND.n207 205.714
R2876 VGND.n105 VGND.t1237 212.76
R2877 VGND.t1244 VGND.n185 205.714
R2878 VGND.t1165 VGND.n257 205.714
R2879 VGND.n114 VGND.t1151 213.578
R2880 VGND.t168 VGND.t193 205.714
R2881 VGND.t194 VGND.t170 205.714
R2882 VGND.t171 VGND.t195 205.714
R2883 VGND.t196 VGND.t172 205.714
R2884 VGND.t173 VGND.t197 205.714
R2885 VGND.t657 VGND.t174 205.714
R2886 VGND.t175 VGND.t658 205.714
R2887 VGND.t659 VGND.t176 205.714
R2888 VGND.t745 VGND.t962 205.714
R2889 VGND.t998 VGND.n392 205.714
R2890 VGND.n147 VGND.t937 102.709
R2891 VGND.n539 VGND.t914 205.714
R2892 VGND.t932 VGND.n466 205.714
R2893 VGND.t950 VGND.n558 205.714
R2894 VGND.n18 VGND.t682 204.274
R2895 VGND.t1292 VGND.t150 109.993
R2896 VGND.n95 VGND.t1235 7.66905
R2897 VGND.t1154 VGND.t358 109.986
R2898 VGND.t1162 VGND.t358 109.993
R2899 VGND.n89 VGND.t1164 102.457
R2900 VGND.t1120 VGND.t11 109.993
R2901 VGND.t1083 VGND.t1060 109.993
R2902 VGND.t315 VGND.n92 86.7547
R2903 VGND.t979 VGND.t315 200.613
R2904 VGND.t908 VGND.n138 109.986
R2905 VGND.t949 VGND.n137 200.613
R2906 VGND.t1332 VGND.n48 199.989
R2907 VGND.n43 VGND.t1334 199.989
R2908 VGND.t1336 VGND.n49 199.989
R2909 VGND.n42 VGND.t1338 199.989
R2910 VGND.t1340 VGND.n50 199.989
R2911 VGND.n41 VGND.t1342 199.989
R2912 VGND.t1344 VGND.n51 199.989
R2913 VGND.n40 VGND.t1346 199.989
R2914 VGND.n54 VGND.t1223 199.989
R2915 VGND.t1197 VGND.n20 199.989
R2916 VGND.n15 VGND.t1199 199.989
R2917 VGND.t1201 VGND.n21 199.989
R2918 VGND.n14 VGND.t1203 199.989
R2919 VGND.t1148 VGND.n149 109.644
R2920 VGND.n70 VGND.t1111 199.989
R2921 VGND.t963 VGND.n4 199.989
R2922 VGND.n10 VGND.t969 199.989
R2923 VGND.t919 VGND.n127 199.989
R2924 VGND.t927 VGND.n129 199.989
R2925 VGND.n136 VGND.t931 199.989
R2926 VGND.n726 VGND.t1441 199.507
R2927 VGND.t1448 VGND.n718 199.507
R2928 VGND.t1110 VGND.t764 197.143
R2929 VGND.t719 VGND.t918 197.143
R2930 VGND.t478 VGND.n685 192.857
R2931 VGND.t479 VGND.n684 192.857
R2932 VGND.n705 VGND.t879 192.857
R2933 VGND.t502 VGND.n674 192.857
R2934 VGND.t467 VGND.n219 192.857
R2935 VGND.t468 VGND.n218 192.857
R2936 VGND.t28 VGND.n214 192.857
R2937 VGND.t29 VGND.n213 192.857
R2938 VGND.n636 VGND.t445 192.857
R2939 VGND.n643 VGND.t293 192.857
R2940 VGND.t83 VGND.n191 192.857
R2941 VGND.t84 VGND.n190 192.857
R2942 VGND.t670 VGND.n251 192.857
R2943 VGND.t837 VGND.n251 192.857
R2944 VGND.n276 VGND.t542 192.857
R2945 VGND.n277 VGND.t543 192.857
R2946 VGND.n283 VGND.t821 192.857
R2947 VGND.n284 VGND.t822 192.857
R2948 VGND.t403 VGND.n323 192.857
R2949 VGND.t404 VGND.n322 192.857
R2950 VGND.n339 VGND.t1555 192.857
R2951 VGND.t9 VGND.n304 192.857
R2952 VGND.n355 VGND.t772 192.857
R2953 VGND.t192 VGND.n384 192.857
R2954 VGND.t193 VGND.n383 192.857
R2955 VGND.t176 VGND.n379 192.857
R2956 VGND.t177 VGND.n378 192.857
R2957 VGND.n599 VGND.t105 192.857
R2958 VGND.n600 VGND.t106 192.857
R2959 VGND.t344 VGND.n423 192.857
R2960 VGND.t732 VGND.n422 192.857
R2961 VGND.n447 VGND.t617 192.857
R2962 VGND.n448 VGND.t618 192.857
R2963 VGND.t650 VGND.n400 192.857
R2964 VGND.t651 VGND.n399 192.857
R2965 VGND.t1511 VGND.n506 192.857
R2966 VGND.n529 VGND.t1457 192.857
R2967 VGND.t1493 VGND.n492 192.857
R2968 VGND.t1494 VGND.n491 192.857
R2969 VGND.n550 VGND.t709 192.857
R2970 VGND.n551 VGND.t710 192.857
R2971 VGND.t1290 VGND.t150 108.999
R2972 VGND.t150 VGND.t1288 109.001
R2973 VGND.t1286 VGND.t150 109.001
R2974 VGND.t1235 VGND.n96 96.0268
R2975 VGND.t1235 VGND.t1213 109.001
R2976 VGND.t1211 VGND.t1235 109.001
R2977 VGND.t1210 VGND.t1235 109.992
R2978 VGND.t1206 VGND.t1235 108.722
R2979 VGND.t1205 VGND.t358 200.714
R2980 VGND.t358 VGND.n88 96.0268
R2981 VGND.t1161 VGND.t358 108.999
R2982 VGND.t358 VGND.t1159 109.001
R2983 VGND.t1157 VGND.t358 109.001
R2984 VGND.t358 VGND.t1155 109.001
R2985 VGND.t1121 VGND.t11 108.965
R2986 VGND.t1118 VGND.t11 108.999
R2987 VGND.t11 VGND.t1116 109.001
R2988 VGND.t11 VGND.t1115 109.992
R2989 VGND.t1060 VGND.t1080 109.001
R2990 VGND.t1060 VGND.t1078 109.993
R2991 VGND.t1060 VGND.t1075 109.001
R2992 VGND.t1073 VGND.t1060 108.999
R2993 VGND.t1060 VGND.t1071 108.962
R2994 VGND.t1066 VGND.t1060 109.001
R2995 VGND.t1060 VGND.t1064 109.001
R2996 VGND.t1062 VGND.t1060 109.001
R2997 VGND.t1060 VGND.t1059 108.722
R2998 VGND.t978 VGND.n92 22.2411
R2999 VGND.t315 VGND.t964 192.042
R3000 VGND.t960 VGND.t315 109.992
R3001 VGND.t956 VGND.t315 109.001
R3002 VGND.t315 VGND.t954 109.001
R3003 VGND.t952 VGND.t315 108.722
R3004 VGND.t738 VGND.t315 16.3379
R3005 VGND.t948 VGND.n137 192.042
R3006 VGND.n139 VGND.t938 108.978
R3007 VGND.n140 VGND.t906 108.722
R3008 VGND.n48 VGND.t1293 191.417
R3009 VGND.t1295 VGND.n43 191.417
R3010 VGND.n49 VGND.t1298 191.417
R3011 VGND.t1301 VGND.n42 191.417
R3012 VGND.n50 VGND.t1304 191.417
R3013 VGND.t1307 VGND.n41 191.417
R3014 VGND.n51 VGND.t1310 191.417
R3015 VGND.t1312 VGND.n40 191.417
R3016 VGND.n60 VGND.t1216 191.417
R3017 VGND.n63 VGND.t1242 191.417
R3018 VGND.n20 VGND.t1170 191.417
R3019 VGND.t1172 VGND.n15 191.417
R3020 VGND.n21 VGND.t1175 191.417
R3021 VGND.t1179 VGND.n14 191.417
R3022 VGND.n33 VGND.t1124 191.417
R3023 VGND.n66 VGND.t1087 191.417
R3024 VGND.n0 VGND.t996 191.417
R3025 VGND.t940 VGND.n123 191.417
R3026 VGND.t944 VGND.n136 191.417
R3027 VGND.n132 VGND.t946 191.417
R3028 VGND.t1573 VGND.n86 101.412
R3029 VGND.t1541 VGND.n307 188.571
R3030 VGND.t1088 VGND.t574 188.571
R3031 VGND.t516 VGND.n417 188.571
R3032 VGND.t943 VGND.t1500 188.571
R3033 VGND.t917 VGND.t716 188.571
R3034 VGND.n472 VGND.t638 188.571
R3035 VGND.t947 VGND.t1525 188.571
R3036 VGND.t1324 VGND.n689 184.286
R3037 VGND.t1328 VGND.n682 184.286
R3038 VGND.n713 VGND.t1330 184.286
R3039 VGND.n90 VGND.t1294 100.883
R3040 VGND.n83 VGND.t1334 234.188
R3041 VGND.n101 VGND.t1299 100.883
R3042 VGND.n79 VGND.t1338 234.188
R3043 VGND.t1340 VGND.n106 234.188
R3044 VGND.n77 VGND.t1342 234.188
R3045 VGND.t1344 VGND.n116 234.188
R3046 VGND.n146 VGND.t1346 234.188
R3047 VGND.n645 VGND.t1233 184.286
R3048 VGND.t1236 VGND.n195 184.286
R3049 VGND.t1217 VGND.n105 100.883
R3050 VGND.n657 VGND.t1243 184.286
R3051 VGND.t1167 VGND.n243 184.286
R3052 VGND.t1193 VGND.n230 184.286
R3053 VGND.t1197 VGND.n102 234.188
R3054 VGND.n85 VGND.t1199 234.188
R3055 VGND.n110 VGND.t1177 100.883
R3056 VGND.t1180 VGND.n81 100.883
R3057 VGND.t1144 VGND.n310 184.286
R3058 VGND.t1146 VGND.n294 184.286
R3059 VGND.n360 VGND.t1126 184.286
R3060 VGND.n115 VGND.t416 45.6164
R3061 VGND.t1070 VGND.n388 184.286
R3062 VGND.n606 VGND.t1088 184.286
R3063 VGND.t1537 VGND.t516 184.286
R3064 VGND.t983 VGND.n408 184.286
R3065 VGND.n454 VGND.t987 184.286
R3066 VGND.n460 VGND.t991 184.286
R3067 VGND.t995 VGND.t738 184.286
R3068 VGND.n570 VGND.t997 184.286
R3069 VGND.n523 VGND.t943 184.286
R3070 VGND.t913 VGND.n496 184.286
R3071 VGND.n544 VGND.t917 184.286
R3072 VGND.t923 VGND.n480 184.286
R3073 VGND.t929 VGND.n468 184.286
R3074 VGND.t945 VGND.n467 184.286
R3075 VGND.n474 VGND.t947 184.286
R3076 VGND.t1524 VGND.t1493 180
R3077 VGND.n694 VGND.t1325 175.714
R3078 VGND.t1331 VGND.n87 99.5774
R3079 VGND.t1339 VGND.n78 99.5774
R3080 VGND.t1343 VGND.n76 99.5774
R3081 VGND.t1234 VGND.n196 175.714
R3082 VGND.n657 VGND.t1222 175.714
R3083 VGND.t1166 VGND.n244 175.714
R3084 VGND.n274 VGND.t1168 175.714
R3085 VGND.t1192 VGND.n231 175.714
R3086 VGND.t1196 VGND.n226 175.714
R3087 VGND.t1200 VGND.n84 99.5774
R3088 VGND.n111 VGND.t1202 99.5774
R3089 VGND.t1145 VGND.n295 175.714
R3090 VGND.n360 VGND.t1147 175.714
R3091 VGND.n610 VGND.t1149 175.714
R3092 VGND.n605 VGND.t1110 175.714
R3093 VGND.t962 VGND.n415 175.714
R3094 VGND.n444 VGND.t980 175.714
R3095 VGND.t982 VGND.n409 175.714
R3096 VGND.n453 VGND.t986 175.714
R3097 VGND.t988 VGND.n402 175.714
R3098 VGND.n570 VGND.t968 175.714
R3099 VGND.n514 VGND.t909 175.714
R3100 VGND.t918 VGND.n487 175.714
R3101 VGND.n547 VGND.t920 175.714
R3102 VGND.t922 VGND.n481 175.714
R3103 VGND.n473 VGND.t930 175.714
R3104 VGND.t1168 VGND.t1548 171.429
R3105 VGND.t805 VGND.t1195 171.429
R3106 VGND.t578 VGND.t1142 171.429
R3107 VGND.t318 VGND.t985 171.429
R3108 VGND.t645 VGND.t988 171.429
R3109 VGND.t696 VGND.t925 171.429
R3110 VGND.n695 VGND.t477 167.143
R3111 VGND.n697 VGND.t480 167.143
R3112 VGND.t880 VGND.n675 167.143
R3113 VGND.n706 VGND.t500 167.143
R3114 VGND.n624 VGND.t466 167.143
R3115 VGND.n626 VGND.t469 167.143
R3116 VGND.n628 VGND.t26 167.143
R3117 VGND.n630 VGND.t30 167.143
R3118 VGND.t444 VGND.n207 167.143
R3119 VGND.t294 VGND.n199 167.143
R3120 VGND.n651 VGND.t81 167.143
R3121 VGND.n653 VGND.t85 167.143
R3122 VGND.n264 VGND.t836 167.143
R3123 VGND.n265 VGND.t672 167.143
R3124 VGND.t541 VGND.n240 167.143
R3125 VGND.t544 VGND.n238 167.143
R3126 VGND.t820 VGND.n232 167.143
R3127 VGND.t823 VGND.n230 167.143
R3128 VGND.n330 VGND.t401 167.143
R3129 VGND.n332 VGND.t405 167.143
R3130 VGND.t1554 VGND.n314 167.143
R3131 VGND.t3 VGND.t1554 167.143
R3132 VGND.t1555 VGND.t1529 167.143
R3133 VGND.t799 VGND.t1556 167.143
R3134 VGND.t1557 VGND.t801 167.143
R3135 VGND.n348 VGND.t8 167.143
R3136 VGND.t773 VGND.n297 167.143
R3137 VGND.n584 VGND.t191 167.143
R3138 VGND.n586 VGND.t194 167.143
R3139 VGND.n588 VGND.t175 167.143
R3140 VGND.n590 VGND.t178 167.143
R3141 VGND.t104 VGND.n369 167.143
R3142 VGND.t107 VGND.n367 167.143
R3143 VGND.n434 VGND.t346 167.143
R3144 VGND.n434 VGND.t731 167.143
R3145 VGND.t616 VGND.n410 167.143
R3146 VGND.t619 VGND.n408 167.143
R3147 VGND.n457 VGND.t649 167.143
R3148 VGND.n459 VGND.t653 167.143
R3149 VGND.n528 VGND.t1512 167.143
R3150 VGND.t1456 VGND.n504 167.143
R3151 VGND.n540 VGND.t1492 167.143
R3152 VGND.n542 VGND.t1495 167.143
R3153 VGND.t708 VGND.n482 167.143
R3154 VGND.t711 VGND.n480 167.143
R3155 VGND.t484 VGND.t1328 162.857
R3156 VGND.t1233 VGND.t844 162.857
R3157 VGND.t607 VGND.t979 162.857
R3158 VGND.t699 VGND.t919 162.857
R3159 VGND.n727 VGND.t1440 155.173
R3160 VGND.t1449 VGND.n717 155.173
R3161 VGND.t57 VGND.t9 154.286
R3162 VGND.t10 VGND.t58 154.286
R3163 VGND.t59 VGND.t12 154.286
R3164 VGND.t770 VGND.t19 154.286
R3165 VGND.t20 VGND.t771 154.286
R3166 VGND.t772 VGND.t21 154.286
R3167 VGND.t664 VGND.t215 150
R3168 VGND.t746 VGND.t963 150
R3169 VGND.t1325 VGND.t474 145.714
R3170 VGND.t582 VGND.t1329 145.714
R3171 VGND.t896 VGND.t939 145.714
R3172 VGND.t1492 VGND.t1481 145.714
R3173 VGND.t928 VGND.t1527 145.714
R3174 VGND.t476 VGND.n686 141.429
R3175 VGND.t481 VGND.n683 141.429
R3176 VGND.t499 VGND.n675 141.429
R3177 VGND.n706 VGND.t881 141.429
R3178 VGND.t465 VGND.n220 141.429
R3179 VGND.t470 VGND.n217 141.429
R3180 VGND.t25 VGND.n215 141.429
R3181 VGND.t31 VGND.n212 141.429
R3182 VGND.n635 VGND.t443 141.429
R3183 VGND.n644 VGND.t295 141.429
R3184 VGND.t80 VGND.n192 141.429
R3185 VGND.t86 VGND.n189 141.429
R3186 VGND.t835 VGND.n252 141.429
R3187 VGND.t673 VGND.n250 141.429
R3188 VGND.n275 VGND.t540 141.429
R3189 VGND.t545 VGND.n237 141.429
R3190 VGND.n282 VGND.t819 141.429
R3191 VGND.n285 VGND.t824 141.429
R3192 VGND.t400 VGND.n324 141.429
R3193 VGND.t406 VGND.n321 141.429
R3194 VGND.n315 VGND.t1553 141.429
R3195 VGND.n341 VGND.t1558 141.429
R3196 VGND.t1123 VGND.t63 141.429
R3197 VGND.t13 VGND.n302 141.429
R3198 VGND.n353 VGND.t769 141.429
R3199 VGND.t190 VGND.n385 141.429
R3200 VGND.t195 VGND.n382 141.429
R3201 VGND.t174 VGND.n380 141.429
R3202 VGND.t179 VGND.n377 141.429
R3203 VGND.n598 VGND.t103 141.429
R3204 VGND.n601 VGND.t108 141.429
R3205 VGND.t331 VGND.t961 141.429
R3206 VGND.t730 VGND.n423 141.429
R3207 VGND.t347 VGND.n422 141.429
R3208 VGND.n446 VGND.t615 141.429
R3209 VGND.n449 VGND.t620 141.429
R3210 VGND.t648 VGND.n401 141.429
R3211 VGND.t654 VGND.n398 141.429
R3212 VGND.n528 VGND.t1455 141.429
R3213 VGND.t1513 VGND.n504 141.429
R3214 VGND.t1491 VGND.n493 141.429
R3215 VGND.t1496 VGND.n490 141.429
R3216 VGND.n549 VGND.t707 141.429
R3217 VGND.n552 VGND.t712 141.429
R3218 VGND.t803 VGND.t1194 137.143
R3219 VGND.t576 VGND.t1141 137.143
R3220 VGND.t316 VGND.t984 137.143
R3221 VGND.t991 VGND.t656 137.143
R3222 VGND.t694 VGND.t924 137.143
R3223 VGND.t494 VGND.t876 128.571
R3224 VGND.t877 VGND.t495 128.571
R3225 VGND.t496 VGND.t878 128.571
R3226 VGND.t879 VGND.t497 128.571
R3227 VGND.t498 VGND.t880 128.571
R3228 VGND.t881 VGND.t499 128.571
R3229 VGND.t500 VGND.t882 128.571
R3230 VGND.t883 VGND.t502 128.571
R3231 VGND.t503 VGND.t884 128.571
R3232 VGND.t885 VGND.t505 128.571
R3233 VGND.t506 VGND.t886 128.571
R3234 VGND.t281 VGND.t446 128.571
R3235 VGND.t447 VGND.t283 128.571
R3236 VGND.t284 VGND.t448 128.571
R3237 VGND.t454 VGND.t290 128.571
R3238 VGND.t291 VGND.t455 128.571
R3239 VGND.t456 VGND.t292 128.571
R3240 VGND.t1205 VGND.t69 128.571
R3241 VGND.t1508 VGND.t1475 128.571
R3242 VGND.t1476 VGND.t1509 128.571
R3243 VGND.t1510 VGND.t1477 128.571
R3244 VGND.t1453 VGND.t1511 128.571
R3245 VGND.t1512 VGND.t1454 128.571
R3246 VGND.t1455 VGND.t1513 128.571
R3247 VGND.t1514 VGND.t1456 128.571
R3248 VGND.t1457 VGND.t1515 128.571
R3249 VGND.t1516 VGND.t1458 128.571
R3250 VGND.t1459 VGND.t1517 128.571
R3251 VGND.t1518 VGND.t1460 128.571
R3252 VGND.t1574 VGND.n667 124.287
R3253 VGND.n258 VGND.t684 124.287
R3254 VGND.n609 VGND.t115 124.287
R3255 VGND.t517 VGND.n416 124.287
R3256 VGND.n471 VGND.t637 124.287
R3257 VGND.n694 VGND.t475 115.715
R3258 VGND.n698 VGND.t482 115.715
R3259 VGND.t875 VGND.n678 115.715
R3260 VGND.n705 VGND.t498 115.715
R3261 VGND.t882 VGND.n674 115.715
R3262 VGND.n709 VGND.t507 115.715
R3263 VGND.n623 VGND.t464 115.715
R3264 VGND.n627 VGND.t471 115.715
R3265 VGND.n627 VGND.t24 115.715
R3266 VGND.n631 VGND.t32 115.715
R3267 VGND.t442 VGND.n208 115.715
R3268 VGND.t449 VGND.n204 115.715
R3269 VGND.t289 VGND.n202 115.715
R3270 VGND.t296 VGND.n198 115.715
R3271 VGND.n650 VGND.t79 115.715
R3272 VGND.n654 VGND.t87 115.715
R3273 VGND.n263 VGND.t834 115.715
R3274 VGND.n266 VGND.t674 115.715
R3275 VGND.t539 VGND.n241 115.715
R3276 VGND.t825 VGND.n229 115.715
R3277 VGND.n329 VGND.t399 115.715
R3278 VGND.n333 VGND.t407 115.715
R3279 VGND.n338 VGND.t1552 115.715
R3280 VGND.t1559 VGND.n312 115.715
R3281 VGND.n351 VGND.t14 115.715
R3282 VGND.t768 VGND.n300 115.715
R3283 VGND.n583 VGND.t189 115.715
R3284 VGND.n587 VGND.t196 115.715
R3285 VGND.n587 VGND.t173 115.715
R3286 VGND.n591 VGND.t180 115.715
R3287 VGND.t102 VGND.n370 115.715
R3288 VGND.t109 VGND.n366 115.715
R3289 VGND.n433 VGND.t729 115.715
R3290 VGND.n435 VGND.t348 115.715
R3291 VGND.t614 VGND.n411 115.715
R3292 VGND.t621 VGND.n407 115.715
R3293 VGND.n456 VGND.t647 115.715
R3294 VGND.n460 VGND.t655 115.715
R3295 VGND.n525 VGND.t1507 115.715
R3296 VGND.t1454 VGND.n506 115.715
R3297 VGND.n529 VGND.t1514 115.715
R3298 VGND.t1461 VGND.n501 115.715
R3299 VGND.t914 VGND.t1489 115.715
R3300 VGND.n539 VGND.t1490 115.715
R3301 VGND.n543 VGND.t1497 115.715
R3302 VGND.t706 VGND.n483 115.715
R3303 VGND.t713 VGND.n479 115.715
R3304 VGND.t1323 VGND.t145 111.43
R3305 VGND.t1143 VGND.t1561 111.43
R3306 VGND.t1069 VGND.t182 111.43
R3307 VGND.t663 VGND.t217 111.43
R3308 VGND.t911 VGND.t1483 111.43
R3309 VGND.t1434 VGND.n144 91.7675
R3310 VGND.n728 VGND.t1439 110.838
R3311 VGND.t859 VGND.n716 110.838
R3312 VGND.t864 VGND.n109 645.394
R3313 VGND.t691 VGND.n668 107.144
R3314 VGND.n93 VGND.t364 77.2375
R3315 VGND.t111 VGND.n305 107.144
R3316 VGND.n613 VGND.t634 107.144
R3317 VGND.t743 VGND.n415 107.144
R3318 VGND.t1530 VGND.t910 107.144
R3319 VGND.n470 VGND.t329 107.144
R3320 VGND.t725 VGND.t339 102.858
R3321 VGND.t340 VGND.t726 102.858
R3322 VGND.t727 VGND.t341 102.858
R3323 VGND.t343 VGND.t728 102.858
R3324 VGND.t729 VGND.t344 102.858
R3325 VGND.t346 VGND.t730 102.858
R3326 VGND.t731 VGND.t347 102.858
R3327 VGND.t348 VGND.t732 102.858
R3328 VGND.t733 VGND.t349 102.858
R3329 VGND.t510 VGND.t734 102.858
R3330 VGND.t735 VGND.t511 102.858
R3331 VGND.t512 VGND.t736 102.858
R3332 VGND.t509 VGND.n669 98.5719
R3333 VGND.n714 VGND.t867 98.5719
R3334 VGND.t365 VGND.n186 98.5719
R3335 VGND.n658 VGND.t852 98.5719
R3336 VGND.t69 VGND.n225 98.5719
R3337 VGND.t220 VGND.n293 98.5719
R3338 VGND.n611 VGND.t163 98.5719
R3339 VGND.n605 VGND.t742 98.5719
R3340 VGND.n606 VGND.t396 98.5719
R3341 VGND.n462 VGND.t321 98.5719
R3342 VGND.n571 VGND.t572 98.5719
R3343 VGND.t1478 VGND.n512 98.5719
R3344 VGND.n534 VGND.t1482 98.5719
R3345 VGND.t1481 VGND.n492 98.5719
R3346 VGND.t1450 VGND.n476 98.5719
R3347 VGND.n474 VGND.t898 98.5719
R3348 VGND.n560 VGND.t1479 98.5719
R3349 VGND.n559 VGND.t1471 98.5719
R3350 VGND.t613 VGND.t981 94.2862
R3351 VGND.t705 VGND.t921 94.2862
R3352 VGND.t474 VGND.n687 90.0005
R3353 VGND.t483 VGND.n682 90.0005
R3354 VGND.n702 VGND.t874 90.0005
R3355 VGND.t497 VGND.n676 90.0005
R3356 VGND.n707 VGND.t883 90.0005
R3357 VGND.t508 VGND.n671 90.0005
R3358 VGND.t463 VGND.n221 90.0005
R3359 VGND.t22 VGND.n217 90.0005
R3360 VGND.t472 VGND.n215 90.0005
R3361 VGND.t33 VGND.n211 90.0005
R3362 VGND.n634 VGND.t441 90.0005
R3363 VGND.n639 VGND.t450 90.0005
R3364 VGND.n640 VGND.t288 90.0005
R3365 VGND.n645 VGND.t297 90.0005
R3366 VGND.t78 VGND.n193 90.0005
R3367 VGND.t88 VGND.n188 90.0005
R3368 VGND.t833 VGND.n253 90.0005
R3369 VGND.t675 VGND.n249 90.0005
R3370 VGND.n274 VGND.t538 90.0005
R3371 VGND.n286 VGND.t826 90.0005
R3372 VGND.t398 VGND.n325 90.0005
R3373 VGND.t408 VGND.n320 90.0005
R3374 VGND.t1551 VGND.n316 90.0005
R3375 VGND.n342 VGND.t1560 90.0005
R3376 VGND.t4 VGND.n306 90.0005
R3377 VGND.t15 VGND.n301 90.0005
R3378 VGND.n352 VGND.t767 90.0005
R3379 VGND.t188 VGND.n386 90.0005
R3380 VGND.t172 VGND.n382 90.0005
R3381 VGND.t197 VGND.n380 90.0005
R3382 VGND.t181 VGND.n376 90.0005
R3383 VGND.n597 VGND.t101 90.0005
R3384 VGND.n602 VGND.t110 90.0005
R3385 VGND.t338 VGND.n426 90.0005
R3386 VGND.t728 VGND.n424 90.0005
R3387 VGND.t349 VGND.n421 90.0005
R3388 VGND.t737 VGND.n419 90.0005
R3389 VGND.n445 VGND.t613 90.0005
R3390 VGND.n450 VGND.t622 90.0005
R3391 VGND.t646 VGND.n402 90.0005
R3392 VGND.t656 VGND.n397 90.0005
R3393 VGND.t1506 VGND.n509 90.0005
R3394 VGND.n527 VGND.t1453 90.0005
R3395 VGND.t1515 VGND.n503 90.0005
R3396 VGND.n532 VGND.t1462 90.0005
R3397 VGND.t1489 VGND.n494 90.0005
R3398 VGND.t1498 VGND.n489 90.0005
R3399 VGND.n548 VGND.t705 90.0005
R3400 VGND.n553 VGND.t714 90.0005
R3401 VGND.t824 VGND.t1193 85.7148
R3402 VGND.t161 VGND.t6 85.7148
R3403 VGND.t620 VGND.t983 85.7148
R3404 VGND.t712 VGND.t923 85.7148
R3405 VGND.t684 VGND.t1165 81.4291
R3406 VGND.n339 VGND.t3 77.1434
R3407 VGND.n356 VGND.t162 77.1434
R3408 VGND.t153 VGND.n119 60.8152
R3409 VGND.n442 VGND.t746 77.1434
R3410 VGND.n569 VGND.t740 77.1434
R3411 VGND.n515 VGND.t1530 77.1434
R3412 VGND.t926 VGND.t1450 77.1434
R3413 VGND.t1540 VGND.t765 72.8576
R3414 VGND.t1531 VGND.n18 71.4177
R3415 VGND.t1435 VGND.n731 66.503
R3416 VGND.n729 VGND.t1438 66.503
R3417 VGND.n36 VGND.t864 82.2354
R3418 VGND.t145 VGND.n690 64.2862
R3419 VGND.n693 VGND.t152 64.2862
R3420 VGND.n699 VGND.t484 64.2862
R3421 VGND.t853 VGND.n680 64.2862
R3422 VGND.n700 VGND.t489 64.2862
R3423 VGND.t490 VGND.n679 64.2862
R3424 VGND.t858 VGND.n679 64.2862
R3425 VGND.n704 VGND.t496 64.2862
R3426 VGND.t884 VGND.n673 64.2862
R3427 VGND.n710 VGND.t1567 64.2862
R3428 VGND.n710 VGND.t889 64.2862
R3429 VGND.n711 VGND.t1572 64.2862
R3430 VGND.n622 VGND.t462 64.2862
R3431 VGND.t221 VGND.n220 64.2862
R3432 VGND.n626 VGND.t227 64.2862
R3433 VGND.n628 VGND.t560 64.2862
R3434 VGND.t565 VGND.n212 64.2862
R3435 VGND.n632 VGND.t34 64.2862
R3436 VGND.t39 VGND.n209 64.2862
R3437 VGND.t443 VGND.t1215 64.2862
R3438 VGND.n637 VGND.t281 64.2862
R3439 VGND.t451 VGND.n203 64.2862
R3440 VGND.t287 VGND.n203 64.2862
R3441 VGND.n642 VGND.t456 64.2862
R3442 VGND.t844 VGND.n197 64.2862
R3443 VGND.n647 VGND.t849 64.2862
R3444 VGND.n649 VGND.t77 64.2862
R3445 VGND.n655 VGND.t122 64.2862
R3446 VGND.t128 VGND.n112 52.5379
R3447 VGND.n262 VGND.t832 64.2862
R3448 VGND.n267 VGND.t676 64.2862
R3449 VGND.t422 VGND.n245 64.2862
R3450 VGND.n272 VGND.t1542 64.2862
R3451 VGND.t1548 VGND.n242 64.2862
R3452 VGND.n278 VGND.t811 64.2862
R3453 VGND.t553 VGND.n233 64.2862
R3454 VGND.t802 VGND.n228 64.2862
R3455 VGND.n288 VGND.t808 64.2862
R3456 VGND.n328 VGND.t280 64.2862
R3457 VGND.n334 VGND.t409 64.2862
R3458 VGND.n99 VGND.t414 375.315
R3459 VGND.t575 VGND.n98 52.5379
R3460 VGND.n337 VGND.t580 64.2862
R3461 VGND.t1561 VGND.n311 64.2862
R3462 VGND.t1566 VGND.n97 52.5375
R3463 VGND.t63 VGND.n308 64.2862
R3464 VGND.n349 VGND.t57 64.2862
R3465 VGND.t62 VGND.n301 64.2862
R3466 VGND.n352 VGND.t16 64.2862
R3467 VGND.t21 VGND.n298 64.2862
R3468 VGND.t162 VGND.t774 64.2862
R3469 VGND.t775 VGND.t721 64.2862
R3470 VGND.t809 VGND.t776 64.2862
R3471 VGND.t777 VGND.t810 64.2862
R3472 VGND.n359 VGND.t782 64.2862
R3473 VGND.t182 VGND.n389 64.2862
R3474 VGND.n582 VGND.t187 64.2862
R3475 VGND.t164 VGND.n385 64.2862
R3476 VGND.n586 VGND.t171 64.2862
R3477 VGND.n588 VGND.t657 64.2862
R3478 VGND.t662 VGND.n377 64.2862
R3479 VGND.n592 VGND.t214 64.2862
R3480 VGND.t219 VGND.n373 64.2862
R3481 VGND.n595 VGND.t95 64.2862
R3482 VGND.t100 VGND.n371 64.2862
R3483 VGND.t255 VGND.n365 64.2862
R3484 VGND.t259 VGND.n108 375.315
R3485 VGND.n429 VGND.t331 64.2862
R3486 VGND.t722 VGND.n427 64.2862
R3487 VGND.n430 VGND.t337 64.2862
R3488 VGND.n432 VGND.t727 64.2862
R3489 VGND.n436 VGND.t510 64.2862
R3490 VGND.n438 VGND.t1533 64.2862
R3491 VGND.t515 VGND.n418 64.2862
R3492 VGND.t1538 VGND.n417 64.2862
R3493 VGND.n443 VGND.t607 64.2862
R3494 VGND.t612 VGND.n412 64.2862
R3495 VGND.t314 VGND.n406 64.2862
R3496 VGND.n452 VGND.t320 64.2862
R3497 VGND.t640 VGND.n404 64.2862
R3498 VGND.n455 VGND.t645 64.2862
R3499 VGND.n461 VGND.t323 64.2862
R3500 VGND.n113 VGND.t356 41.0296
R3501 VGND.n523 VGND.t1499 64.2862
R3502 VGND.n524 VGND.t1472 64.2862
R3503 VGND.n524 VGND.t1504 64.2862
R3504 VGND.t1477 VGND.n507 64.2862
R3505 VGND.n530 VGND.t1516 64.2862
R3506 VGND.t1463 VGND.n500 64.2862
R3507 VGND.t1521 VGND.n500 64.2862
R3508 VGND.n535 VGND.t1468 64.2862
R3509 VGND.t1483 VGND.n497 64.2862
R3510 VGND.n538 VGND.t1488 64.2862
R3511 VGND.n544 VGND.t715 64.2862
R3512 VGND.t720 VGND.n487 64.2862
R3513 VGND.n546 VGND.t699 64.2862
R3514 VGND.t704 VGND.n485 64.2862
R3515 VGND.t692 VGND.n478 64.2862
R3516 VGND.n555 VGND.t698 64.2862
R3517 VGND.t1497 VGND.t916 60.0005
R3518 VGND.n713 VGND.t583 55.7148
R3519 VGND.n346 VGND.t160 55.7148
R3520 VGND.t154 VGND.n293 55.7148
R3521 VGND.n593 VGND.t0 55.7148
R3522 VGND.n440 VGND.t744 55.7148
R3523 VGND.t1528 VGND.n468 55.7148
R3524 VGND.t1525 VGND.n138 54.9227
R3525 VGND.t764 VGND.t1060 54.9217
R3526 VGND.t869 VGND.n39 54.2748
R3527 VGND.n62 VGND.t690 54.2748
R3528 VGND.t850 VGND.n52 54.2748
R3529 VGND.n22 VGND.t625 54.2748
R3530 VGND.t574 VGND.n71 54.2748
R3531 VGND.t623 VGND.n12 54.2748
R3532 VGND.n129 VGND.t635 54.2748
R3533 VGND.t1523 VGND.n130 54.2748
R3534 VGND.t827 VGND.t360 51.4291
R3535 VGND.t830 VGND.t363 51.4291
R3536 VGND.t665 VGND.t831 51.4291
R3537 VGND.t832 VGND.t666 51.4291
R3538 VGND.t667 VGND.t833 51.4291
R3539 VGND.t834 VGND.t668 51.4291
R3540 VGND.t669 VGND.t835 51.4291
R3541 VGND.t836 VGND.t670 51.4291
R3542 VGND.t672 VGND.t837 51.4291
R3543 VGND.t838 VGND.t673 51.4291
R3544 VGND.t674 VGND.t839 51.4291
R3545 VGND.t840 VGND.t675 51.4291
R3546 VGND.t676 VGND.t841 51.4291
R3547 VGND.t842 VGND.t677 51.4291
R3548 VGND.t678 VGND.t417 51.4291
R3549 VGND.t681 VGND.t420 51.4291
R3550 VGND.t811 VGND.t546 51.4291
R3551 VGND.t547 VGND.t812 51.4291
R3552 VGND.t813 VGND.t548 51.4291
R3553 VGND.t816 VGND.t551 51.4291
R3554 VGND.t552 VGND.t817 51.4291
R3555 VGND.t818 VGND.t553 51.4291
R3556 VGND.t1529 VGND.n313 51.4291
R3557 VGND.t721 VGND.n296 51.4291
R3558 VGND.n604 VGND.t1452 51.4291
R3559 VGND.t1522 VGND.n414 51.4291
R3560 VGND.t965 VGND.n92 23.2336
R3561 VGND.t1526 VGND.n395 51.4291
R3562 VGND.t1451 VGND.n513 51.4291
R3563 VGND.t540 VGND.t1169 42.8576
R3564 VGND.t821 VGND.t1192 42.8576
R3565 VGND.t1539 VGND.t219 42.8576
R3566 VGND.t617 VGND.t982 42.8576
R3567 VGND.t989 VGND.t648 42.8576
R3568 VGND.t709 VGND.t922 42.8576
R3569 VGND.n3 VGND.t518 41.4177
R3570 VGND.n691 VGND.t147 38.5719
R3571 VGND.t151 VGND.n688 38.5719
R3572 VGND.t485 VGND.n681 38.5719
R3573 VGND.t488 VGND.n680 38.5719
R3574 VGND.n700 VGND.t854 38.5719
R3575 VGND.n701 VGND.t857 38.5719
R3576 VGND.n702 VGND.t492 38.5719
R3577 VGND.t495 VGND.n677 38.5719
R3578 VGND.n708 VGND.t885 38.5719
R3579 VGND.t888 VGND.n671 38.5719
R3580 VGND.t1568 VGND.n670 38.5719
R3581 VGND.t1571 VGND.n669 38.5719
R3582 VGND.n711 VGND.t872 38.5719
R3583 VGND.n621 VGND.t458 38.5719
R3584 VGND.t461 VGND.n222 38.5719
R3585 VGND.n624 VGND.t223 38.5719
R3586 VGND.t226 VGND.n218 38.5719
R3587 VGND.t561 VGND.n214 38.5719
R3588 VGND.n630 VGND.t564 38.5719
R3589 VGND.t35 VGND.n210 38.5719
R3590 VGND.n633 VGND.t38 38.5719
R3591 VGND.t283 VGND.n205 38.5719
R3592 VGND.n639 VGND.t286 38.5719
R3593 VGND.n640 VGND.t452 38.5719
R3594 VGND.t455 VGND.n201 38.5719
R3595 VGND.n646 VGND.t845 38.5719
R3596 VGND.t848 VGND.n196 38.5719
R3597 VGND.n648 VGND.t73 38.5719
R3598 VGND.t76 VGND.n194 38.5719
R3599 VGND.t123 VGND.n187 38.5719
R3600 VGND.n656 VGND.t127 38.5719
R3601 VGND.n259 VGND.t359 38.5719
R3602 VGND.n260 VGND.t828 38.5719
R3603 VGND.t362 VGND.n255 38.5719
R3604 VGND.t831 VGND.n254 38.5719
R3605 VGND.t677 VGND.n248 38.5719
R3606 VGND.t418 VGND.n247 38.5719
R3607 VGND.n269 VGND.t680 38.5719
R3608 VGND.n270 VGND.t421 38.5719
R3609 VGND.t1544 VGND.n243 38.5719
R3610 VGND.n273 VGND.t1547 38.5719
R3611 VGND.t812 VGND.n236 38.5719
R3612 VGND.t549 VGND.n235 38.5719
R3613 VGND.n280 VGND.t815 38.5719
R3614 VGND.n281 VGND.t552 38.5719
R3615 VGND.n287 VGND.t803 38.5719
R3616 VGND.t807 VGND.n227 38.5719
R3617 VGND.n327 VGND.t276 38.5719
R3618 VGND.t279 VGND.n326 38.5719
R3619 VGND.t410 VGND.n319 38.5719
R3620 VGND.n335 VGND.t414 38.5719
R3621 VGND.n336 VGND.t576 38.5719
R3622 VGND.t579 VGND.n317 38.5719
R3623 VGND.n343 VGND.t1562 38.5719
R3624 VGND.t1565 VGND.n309 38.5719
R3625 VGND.n345 VGND.t64 38.5719
R3626 VGND.t67 VGND.n307 38.5719
R3627 VGND.t58 VGND.n303 38.5719
R3628 VGND.n351 VGND.t61 38.5719
R3629 VGND.t17 VGND.n300 38.5719
R3630 VGND.n354 VGND.t20 38.5719
R3631 VGND.n358 VGND.t778 38.5719
R3632 VGND.t781 VGND.n295 38.5719
R3633 VGND.n609 VGND.t624 38.5719
R3634 VGND.n580 VGND.t183 38.5719
R3635 VGND.t186 VGND.n387 38.5719
R3636 VGND.n584 VGND.t166 38.5719
R3637 VGND.t170 VGND.n383 38.5719
R3638 VGND.t658 VGND.n379 38.5719
R3639 VGND.n590 VGND.t661 38.5719
R3640 VGND.t215 VGND.n375 38.5719
R3641 VGND.t96 VGND.n372 38.5719
R3642 VGND.n596 VGND.t99 38.5719
R3643 VGND.n603 VGND.t256 38.5719
R3644 VGND.t259 VGND.n364 38.5719
R3645 VGND.t632 VGND.t766 38.5719
R3646 VGND.t333 VGND.n428 38.5719
R3647 VGND.t336 VGND.n427 38.5719
R3648 VGND.n430 VGND.t723 38.5719
R3649 VGND.t726 VGND.n425 38.5719
R3650 VGND.t511 VGND.n420 38.5719
R3651 VGND.n438 VGND.t514 38.5719
R3652 VGND.t1534 VGND.n418 38.5719
R3653 VGND.n439 VGND.t1537 38.5719
R3654 VGND.t608 VGND.n413 38.5719
R3655 VGND.n444 VGND.t611 38.5719
R3656 VGND.n451 VGND.t316 38.5719
R3657 VGND.t319 VGND.n405 38.5719
R3658 VGND.n454 VGND.t641 38.5719
R3659 VGND.t644 VGND.n403 38.5719
R3660 VGND.t324 VGND.n396 38.5719
R3661 VGND.n462 VGND.t327 38.5719
R3662 VGND.t1500 VGND.n511 38.5719
R3663 VGND.t1503 VGND.n510 38.5719
R3664 VGND.t1473 VGND.n509 38.5719
R3665 VGND.n526 VGND.t1476 38.5719
R3666 VGND.t1517 VGND.n502 38.5719
R3667 VGND.n532 VGND.t1520 38.5719
R3668 VGND.n533 VGND.t1464 38.5719
R3669 VGND.t1505 VGND.n498 38.5719
R3670 VGND.t1467 VGND.n498 38.5719
R3671 VGND.n536 VGND.t1484 38.5719
R3672 VGND.t1487 VGND.n495 38.5719
R3673 VGND.n541 VGND.t1524 38.5719
R3674 VGND.t716 VGND.n488 38.5719
R3675 VGND.n545 VGND.t719 38.5719
R3676 VGND.t700 VGND.n486 38.5719
R3677 VGND.n547 VGND.t703 38.5719
R3678 VGND.n554 VGND.t694 38.5719
R3679 VGND.t697 VGND.n477 38.5719
R3680 VGND.n561 VGND.t1480 38.5719
R3681 VGND.t1436 VGND.n730 38.3909
R3682 VGND.n730 VGND.t1437 38.3909
R3683 VGND.t862 VGND.n37 35.5278
R3684 VGND.n36 VGND.t863 35.5278
R3685 VGND.t1327 VGND.t481 34.2862
R3686 VGND.t295 VGND.t1232 34.2862
R3687 VGND.t1543 VGND.t4 34.2862
R3688 VGND.t7 VGND.t111 34.2862
R3689 VGND.n712 VGND.t582 30.0005
R3690 VGND.t1240 VGND.n96 12.9737
R3691 VGND.t1163 VGND.n88 12.9737
R3692 VGND.t1532 VGND.n257 30.0005
R3693 VGND.n347 VGND.t161 30.0005
R3694 VGND.t155 VGND.n292 30.0005
R3695 VGND.n594 VGND.t2 30.0005
R3696 VGND.n441 VGND.t745 30.0005
R3697 VGND.t1527 VGND.n469 30.0005
R3698 VGND.t933 VGND.t948 30.0005
R3699 VGND.n46 VGND.t486 28.5605
R3700 VGND.n46 VGND.t487 28.5605
R3701 VGND.t855 VGND.n45 28.5605
R3702 VGND.t856 VGND.n45 28.5605
R3703 VGND.n47 VGND.t1569 28.5605
R3704 VGND.n47 VGND.t1570 28.5605
R3705 VGND.n57 VGND.t460 28.5605
R3706 VGND.n58 VGND.t36 28.5605
R3707 VGND.t37 VGND.n58 28.5605
R3708 VGND.t846 VGND.n56 28.5605
R3709 VGND.n56 VGND.t847 28.5605
R3710 VGND.t74 VGND.n55 28.5605
R3711 VGND.n55 VGND.t75 28.5605
R3712 VGND.n61 VGND.t124 28.5605
R3713 VGND.t125 VGND.n61 28.5605
R3714 VGND.n19 VGND.t1545 28.5605
R3715 VGND.t1546 VGND.n19 28.5605
R3716 VGND.t804 VGND.n17 28.5605
R3717 VGND.n17 VGND.t805 28.5605
R3718 VGND.t277 VGND.n30 28.5605
R3719 VGND.n30 VGND.t278 28.5605
R3720 VGND.n31 VGND.t411 28.5605
R3721 VGND.t412 VGND.n31 28.5605
R3722 VGND.t577 VGND.n29 28.5605
R3723 VGND.n29 VGND.t578 28.5605
R3724 VGND.t65 VGND.n28 28.5605
R3725 VGND.n28 VGND.t66 28.5605
R3726 VGND.t779 VGND.n27 28.5605
R3727 VGND.n27 VGND.t780 28.5605
R3728 VGND.n67 VGND.t97 28.5605
R3729 VGND.t98 VGND.n67 28.5605
R3730 VGND.t257 VGND.n69 28.5605
R3731 VGND.n69 VGND.t258 28.5605
R3732 VGND.n6 VGND.t334 28.5605
R3733 VGND.n6 VGND.t335 28.5605
R3734 VGND.n5 VGND.t1535 28.5605
R3735 VGND.t1536 VGND.n5 28.5605
R3736 VGND.n2 VGND.t609 28.5605
R3737 VGND.t610 VGND.n2 28.5605
R3738 VGND.t317 VGND.n7 28.5605
R3739 VGND.n7 VGND.t318 28.5605
R3740 VGND.t642 VGND.n9 28.5605
R3741 VGND.n9 VGND.t643 28.5605
R3742 VGND.n1 VGND.t325 28.5605
R3743 VGND.t326 VGND.n1 28.5605
R3744 VGND.n125 VGND.t1501 28.5605
R3745 VGND.n125 VGND.t1502 28.5605
R3746 VGND.n126 VGND.t717 28.5605
R3747 VGND.t718 VGND.n126 28.5605
R3748 VGND.n128 VGND.t701 28.5605
R3749 VGND.t702 VGND.n128 28.5605
R3750 VGND.t695 VGND.n121 28.5605
R3751 VGND.n121 VGND.t696 28.5605
R3752 VGND.n340 VGND.t799 25.7148
R3753 VGND.n357 VGND.t809 25.7148
R3754 VGND.t765 VGND.n363 25.7148
R3755 VGND.n568 VGND.t739 25.7148
R3756 VGND.n514 VGND.t1470 25.7148
R3757 VGND.t477 VGND.t1326 17.1434
R3758 VGND.n109 VGND.n35 14.0761
R3759 VGND.n36 VGND.n35 0.879875
R3760 VGND.n37 VGND.n35 0.879875
R3761 VGND.n716 VGND.n35 17.0005
R3762 VGND.n717 VGND.n35 17.0005
R3763 VGND.n718 VGND.n35 17.0005
R3764 VGND.n719 VGND.n35 17.0005
R3765 VGND.n720 VGND.n35 17.0005
R3766 VGND.n721 VGND.n35 17.0005
R3767 VGND.n722 VGND.n35 17.0005
R3768 VGND.n723 VGND.n35 17.0005
R3769 VGND.n724 VGND.n35 17.0005
R3770 VGND.n725 VGND.n35 17.0005
R3771 VGND.n726 VGND.n35 17.0005
R3772 VGND.n727 VGND.n35 17.0005
R3773 VGND.n728 VGND.n35 17.0005
R3774 VGND.n729 VGND.n35 17.0005
R3775 VGND.n731 VGND.n35 17.0005
R3776 VGND.t150 VGND.n714 17.0005
R3777 VGND.t150 VGND.n145 8.48859
R3778 VGND.t150 VGND.n146 9.30762
R3779 VGND.t150 VGND.n117 9.63482
R3780 VGND.t150 VGND.n116 9.30721
R3781 VGND.t150 VGND.n77 9.30721
R3782 VGND.t150 VGND.n107 9.63482
R3783 VGND.t150 VGND.n106 9.30721
R3784 VGND.t150 VGND.n79 9.30721
R3785 VGND.t150 VGND.n100 9.63482
R3786 VGND.t150 VGND.n82 9.63482
R3787 VGND.t150 VGND.n83 9.30721
R3788 VGND.t150 VGND.n91 9.63482
R3789 VGND.t150 VGND.n713 17.0005
R3790 VGND.t150 VGND.n667 17.0005
R3791 VGND.t150 VGND.n712 17.0005
R3792 VGND.t150 VGND.n668 17.0005
R3793 VGND.t150 VGND.n711 17.0005
R3794 VGND.t150 VGND.n669 17.0005
R3795 VGND.t150 VGND.n670 17.0005
R3796 VGND.t150 VGND.n710 17.0005
R3797 VGND.t150 VGND.n671 17.0005
R3798 VGND.t150 VGND.n709 17.0005
R3799 VGND.t150 VGND.n672 17.0005
R3800 VGND.t150 VGND.n708 17.0005
R3801 VGND.t150 VGND.n673 17.0005
R3802 VGND.t150 VGND.n707 17.0005
R3803 VGND.t150 VGND.n674 17.0005
R3804 VGND.t150 VGND.n706 17.0005
R3805 VGND.t150 VGND.n675 17.0005
R3806 VGND.t150 VGND.n705 17.0005
R3807 VGND.t150 VGND.n676 17.0005
R3808 VGND.t150 VGND.n704 17.0005
R3809 VGND.t150 VGND.n677 17.0005
R3810 VGND.t150 VGND.n703 17.0005
R3811 VGND.t150 VGND.n678 17.0005
R3812 VGND.t150 VGND.n702 17.0005
R3813 VGND.t150 VGND.n679 17.0005
R3814 VGND.t150 VGND.n701 17.0005
R3815 VGND.t150 VGND.n700 17.0005
R3816 VGND.t150 VGND.n680 17.0005
R3817 VGND.t150 VGND.n681 17.0005
R3818 VGND.t150 VGND.n699 17.0005
R3819 VGND.t150 VGND.n682 17.0005
R3820 VGND.t150 VGND.n698 17.0005
R3821 VGND.t150 VGND.n683 17.0005
R3822 VGND.t150 VGND.n697 17.0005
R3823 VGND.t150 VGND.n684 17.0005
R3824 VGND.t150 VGND.n696 17.0005
R3825 VGND.t150 VGND.n685 17.0005
R3826 VGND.t150 VGND.n695 17.0005
R3827 VGND.t150 VGND.n686 17.0005
R3828 VGND.t150 VGND.n694 17.0005
R3829 VGND.t150 VGND.n687 17.0005
R3830 VGND.t150 VGND.n693 17.0005
R3831 VGND.t150 VGND.n688 17.0005
R3832 VGND.t150 VGND.n692 17.0005
R3833 VGND.t150 VGND.n689 17.0005
R3834 VGND.t150 VGND.n691 17.0005
R3835 VGND.t150 VGND.n690 17.0005
R3836 VGND.t1235 VGND.n658 17.0005
R3837 VGND.t1235 VGND.n185 17.0005
R3838 VGND.t1235 VGND.n657 17.0005
R3839 VGND.t1235 VGND.n186 17.0005
R3840 VGND.t1235 VGND.n656 17.0005
R3841 VGND.t1235 VGND.n187 17.0005
R3842 VGND.t1235 VGND.n655 17.0005
R3843 VGND.t1235 VGND.n188 17.0005
R3844 VGND.t1235 VGND.n654 17.0005
R3845 VGND.t1235 VGND.n189 17.0005
R3846 VGND.t1235 VGND.n653 17.0005
R3847 VGND.t1235 VGND.n190 17.0005
R3848 VGND.t1235 VGND.n652 17.0005
R3849 VGND.t1235 VGND.n191 17.0005
R3850 VGND.t1235 VGND.n651 17.0005
R3851 VGND.t1235 VGND.n192 17.0005
R3852 VGND.t1235 VGND.n650 17.0005
R3853 VGND.t1235 VGND.n193 17.0005
R3854 VGND.t1235 VGND.n649 17.0005
R3855 VGND.t1235 VGND.n194 17.0005
R3856 VGND.t1235 VGND.n648 17.0005
R3857 VGND.t1235 VGND.n104 13.894
R3858 VGND.t1235 VGND.n195 17.0005
R3859 VGND.t1235 VGND.n647 17.0005
R3860 VGND.t1235 VGND.n196 17.0005
R3861 VGND.t1235 VGND.n646 17.0005
R3862 VGND.t1235 VGND.n197 17.0005
R3863 VGND.t1235 VGND.n645 17.0005
R3864 VGND.t1235 VGND.n198 17.0005
R3865 VGND.t1235 VGND.n644 17.0005
R3866 VGND.t1235 VGND.n199 17.0005
R3867 VGND.t1235 VGND.n643 17.0005
R3868 VGND.t1235 VGND.n200 17.0005
R3869 VGND.t1235 VGND.n642 17.0005
R3870 VGND.t1235 VGND.n201 17.0005
R3871 VGND.t1235 VGND.n641 17.0005
R3872 VGND.t1235 VGND.n202 17.0005
R3873 VGND.t1235 VGND.n640 17.0005
R3874 VGND.t1235 VGND.n203 17.0005
R3875 VGND.t1235 VGND.n639 17.0005
R3876 VGND.t1235 VGND.n204 17.0005
R3877 VGND.t1235 VGND.n638 17.0005
R3878 VGND.t1235 VGND.n205 17.0005
R3879 VGND.t1235 VGND.n637 17.0005
R3880 VGND.t1235 VGND.n206 17.0005
R3881 VGND.t1235 VGND.n636 17.0005
R3882 VGND.t1235 VGND.n207 17.0005
R3883 VGND.t1235 VGND.n635 17.0005
R3884 VGND.t1235 VGND.n208 17.0005
R3885 VGND.t1235 VGND.n634 17.0005
R3886 VGND.t1235 VGND.n209 17.0005
R3887 VGND.t1235 VGND.n633 17.0005
R3888 VGND.t1235 VGND.n210 17.0005
R3889 VGND.t1235 VGND.n632 17.0005
R3890 VGND.t1235 VGND.n211 17.0005
R3891 VGND.t1235 VGND.n631 17.0005
R3892 VGND.t1235 VGND.n212 17.0005
R3893 VGND.t1235 VGND.n630 17.0005
R3894 VGND.t1235 VGND.n213 17.0005
R3895 VGND.t1235 VGND.n629 17.0005
R3896 VGND.t1235 VGND.n214 17.0005
R3897 VGND.t1235 VGND.n628 17.0005
R3898 VGND.t1235 VGND.n215 17.0005
R3899 VGND.t1235 VGND.n627 17.0005
R3900 VGND.t1235 VGND.n217 17.0005
R3901 VGND.t1235 VGND.n626 17.0005
R3902 VGND.t1235 VGND.n218 17.0005
R3903 VGND.t1235 VGND.n625 17.0005
R3904 VGND.t1235 VGND.n219 17.0005
R3905 VGND.t1235 VGND.n624 17.0005
R3906 VGND.t1235 VGND.n220 17.0005
R3907 VGND.t1235 VGND.n623 17.0005
R3908 VGND.t1235 VGND.n221 17.0005
R3909 VGND.t1235 VGND.n622 17.0005
R3910 VGND.t1235 VGND.n222 17.0005
R3911 VGND.t1235 VGND.n621 17.0005
R3912 VGND.t1235 VGND.n141 13.8942
R3913 VGND.t358 VGND.n225 17.0005
R3914 VGND.t358 VGND.n85 9.30721
R3915 VGND.t358 VGND.n103 9.63482
R3916 VGND.t358 VGND.n102 9.30721
R3917 VGND.t358 VGND.n226 17.0005
R3918 VGND.t358 VGND.n288 17.0005
R3919 VGND.t358 VGND.n227 17.0005
R3920 VGND.t358 VGND.n287 17.0005
R3921 VGND.t358 VGND.n228 17.0005
R3922 VGND.t358 VGND.n286 17.0005
R3923 VGND.t358 VGND.n229 17.0005
R3924 VGND.t358 VGND.n285 17.0005
R3925 VGND.t358 VGND.n230 17.0005
R3926 VGND.t358 VGND.n284 17.0005
R3927 VGND.t358 VGND.n231 17.0005
R3928 VGND.t358 VGND.n283 17.0005
R3929 VGND.t358 VGND.n232 17.0005
R3930 VGND.t358 VGND.n282 17.0005
R3931 VGND.t358 VGND.n233 17.0005
R3932 VGND.t358 VGND.n281 17.0005
R3933 VGND.t358 VGND.n234 17.0005
R3934 VGND.t358 VGND.n280 17.0005
R3935 VGND.t358 VGND.n235 17.0005
R3936 VGND.t358 VGND.n279 17.0005
R3937 VGND.t358 VGND.n236 17.0005
R3938 VGND.t358 VGND.n278 17.0005
R3939 VGND.t358 VGND.n237 17.0005
R3940 VGND.t358 VGND.n238 17.0005
R3941 VGND.t358 VGND.n277 17.0005
R3942 VGND.t358 VGND.n239 17.0005
R3943 VGND.t358 VGND.n276 17.0005
R3944 VGND.t358 VGND.n240 17.0005
R3945 VGND.t358 VGND.n275 17.0005
R3946 VGND.t358 VGND.n241 17.0005
R3947 VGND.t358 VGND.n274 17.0005
R3948 VGND.t358 VGND.n242 17.0005
R3949 VGND.t358 VGND.n273 17.0005
R3950 VGND.t358 VGND.n243 17.0005
R3951 VGND.t358 VGND.n272 17.0005
R3952 VGND.t358 VGND.n244 17.0005
R3953 VGND.t358 VGND.n271 17.0005
R3954 VGND.t358 VGND.n245 17.0005
R3955 VGND.t358 VGND.n270 17.0005
R3956 VGND.t358 VGND.n246 17.0005
R3957 VGND.t358 VGND.n269 17.0005
R3958 VGND.t358 VGND.n247 17.0005
R3959 VGND.t358 VGND.n268 17.0005
R3960 VGND.t358 VGND.n248 17.0005
R3961 VGND.t358 VGND.n267 17.0005
R3962 VGND.t358 VGND.n249 17.0005
R3963 VGND.t358 VGND.n266 17.0005
R3964 VGND.t358 VGND.n250 17.0005
R3965 VGND.t358 VGND.n265 17.0005
R3966 VGND.t358 VGND.n251 17.0005
R3967 VGND.t358 VGND.n264 17.0005
R3968 VGND.t358 VGND.n252 17.0005
R3969 VGND.t358 VGND.n263 17.0005
R3970 VGND.t358 VGND.n253 17.0005
R3971 VGND.t358 VGND.n262 17.0005
R3972 VGND.t358 VGND.n254 17.0005
R3973 VGND.t358 VGND.n261 17.0005
R3974 VGND.t358 VGND.n255 17.0005
R3975 VGND.t358 VGND.n260 17.0005
R3976 VGND.t358 VGND.n256 17.0005
R3977 VGND.t358 VGND.n259 17.0005
R3978 VGND.t358 VGND.n94 13.894
R3979 VGND.t358 VGND.n257 17.0005
R3980 VGND.t358 VGND.n258 17.0005
R3981 VGND.t358 VGND.n89 7.66905
R3982 VGND.t11 VGND.n114 8.48812
R3983 VGND.t11 VGND.n115 9.30721
R3984 VGND.t11 VGND.n611 17.0005
R3985 VGND.t11 VGND.n610 17.0005
R3986 VGND.n612 VGND.t11 17.0005
R3987 VGND.t11 VGND.n613 17.0005
R3988 VGND.t11 VGND.n292 17.0005
R3989 VGND.t11 VGND.n609 17.0005
R3990 VGND.t11 VGND.n293 17.0005
R3991 VGND.t11 VGND.n148 9.14381
R3992 VGND.t11 VGND.n360 17.0005
R3993 VGND.t11 VGND.n294 17.0005
R3994 VGND.t11 VGND.n359 17.0005
R3995 VGND.t11 VGND.n295 17.0005
R3996 VGND.t11 VGND.n358 17.0005
R3997 VGND.t11 VGND.t810 17.0005
R3998 VGND.t11 VGND.n357 17.0005
R3999 VGND.t11 VGND.n296 17.0005
R4000 VGND.t11 VGND.n356 17.0005
R4001 VGND.t11 VGND.n297 17.0005
R4002 VGND.t11 VGND.n355 17.0005
R4003 VGND.t11 VGND.n298 17.0005
R4004 VGND.t11 VGND.n354 17.0005
R4005 VGND.t11 VGND.n299 17.0005
R4006 VGND.t11 VGND.n353 17.0005
R4007 VGND.t11 VGND.n300 17.0005
R4008 VGND.t11 VGND.n352 17.0005
R4009 VGND.t11 VGND.n301 17.0005
R4010 VGND.t11 VGND.n351 17.0005
R4011 VGND.t11 VGND.n302 17.0005
R4012 VGND.t11 VGND.n350 17.0005
R4013 VGND.t11 VGND.n303 17.0005
R4014 VGND.t11 VGND.n349 17.0005
R4015 VGND.t11 VGND.n304 17.0005
R4016 VGND.t11 VGND.n348 17.0005
R4017 VGND.t11 VGND.n305 17.0005
R4018 VGND.t11 VGND.n347 17.0005
R4019 VGND.t11 VGND.n306 17.0005
R4020 VGND.t11 VGND.n346 17.0005
R4021 VGND.t11 VGND.n307 17.0005
R4022 VGND.t11 VGND.n345 17.0005
R4023 VGND.t11 VGND.n308 17.0005
R4024 VGND.t11 VGND.n309 17.0005
R4025 VGND.t11 VGND.n344 17.0005
R4026 VGND.t11 VGND.n310 17.0005
R4027 VGND.t11 VGND.n343 17.0005
R4028 VGND.t11 VGND.n311 17.0005
R4029 VGND.t11 VGND.n342 17.0005
R4030 VGND.t11 VGND.n312 17.0005
R4031 VGND.t11 VGND.n341 17.0005
R4032 VGND.t11 VGND.t801 17.0005
R4033 VGND.t11 VGND.n340 17.0005
R4034 VGND.t11 VGND.n313 17.0005
R4035 VGND.t11 VGND.n339 17.0005
R4036 VGND.t11 VGND.n314 17.0005
R4037 VGND.t11 VGND.n315 17.0005
R4038 VGND.t11 VGND.n338 17.0005
R4039 VGND.t11 VGND.n316 17.0005
R4040 VGND.t11 VGND.n337 17.0005
R4041 VGND.t11 VGND.n317 17.0005
R4042 VGND.t11 VGND.n336 17.0005
R4043 VGND.t11 VGND.n99 13.8945
R4044 VGND.t11 VGND.n335 17.0005
R4045 VGND.t11 VGND.n319 17.0005
R4046 VGND.t11 VGND.n334 17.0005
R4047 VGND.t11 VGND.n320 17.0005
R4048 VGND.t11 VGND.n333 17.0005
R4049 VGND.t11 VGND.n321 17.0005
R4050 VGND.t11 VGND.n332 17.0005
R4051 VGND.t11 VGND.n322 17.0005
R4052 VGND.t11 VGND.n331 17.0005
R4053 VGND.t11 VGND.n323 17.0005
R4054 VGND.t11 VGND.n330 17.0005
R4055 VGND.t11 VGND.n324 17.0005
R4056 VGND.t11 VGND.n329 17.0005
R4057 VGND.t11 VGND.n325 17.0005
R4058 VGND.t11 VGND.n328 17.0005
R4059 VGND.t11 VGND.n326 17.0005
R4060 VGND.t11 VGND.n327 17.0005
R4061 VGND.t11 VGND.n143 13.8942
R4062 VGND.t1060 VGND.n606 17.0005
R4063 VGND.t1060 VGND.n362 17.0005
R4064 VGND.t1060 VGND.n605 17.0005
R4065 VGND.t1060 VGND.n363 17.0005
R4066 VGND.t1060 VGND.n604 17.0005
R4067 VGND.t1060 VGND.n108 13.8946
R4068 VGND.t1060 VGND.n364 17.0005
R4069 VGND.t1060 VGND.n603 17.0005
R4070 VGND.t1060 VGND.n365 17.0005
R4071 VGND.t1060 VGND.n602 17.0005
R4072 VGND.t1060 VGND.n366 17.0005
R4073 VGND.t1060 VGND.n601 17.0005
R4074 VGND.t1060 VGND.n367 17.0005
R4075 VGND.t1060 VGND.n600 17.0005
R4076 VGND.t1060 VGND.n368 17.0005
R4077 VGND.t1060 VGND.n599 17.0005
R4078 VGND.t1060 VGND.n369 17.0005
R4079 VGND.t1060 VGND.n598 17.0005
R4080 VGND.t1060 VGND.n370 17.0005
R4081 VGND.t1060 VGND.n597 17.0005
R4082 VGND.t1060 VGND.n371 17.0005
R4083 VGND.t1060 VGND.n596 17.0005
R4084 VGND.t1060 VGND.n372 17.0005
R4085 VGND.t1060 VGND.n595 17.0005
R4086 VGND.t1060 VGND.n373 17.0005
R4087 VGND.t1060 VGND.n594 17.0005
R4088 VGND.t1060 VGND.n374 17.0005
R4089 VGND.t1060 VGND.n593 17.0005
R4090 VGND.t1060 VGND.n375 17.0005
R4091 VGND.t1060 VGND.n592 17.0005
R4092 VGND.t1060 VGND.n376 17.0005
R4093 VGND.t1060 VGND.n591 17.0005
R4094 VGND.t1060 VGND.n377 17.0005
R4095 VGND.t1060 VGND.n590 17.0005
R4096 VGND.t1060 VGND.n378 17.0005
R4097 VGND.t1060 VGND.n589 17.0005
R4098 VGND.t1060 VGND.n379 17.0005
R4099 VGND.t1060 VGND.n588 17.0005
R4100 VGND.t1060 VGND.n380 17.0005
R4101 VGND.t1060 VGND.n587 17.0005
R4102 VGND.t1060 VGND.n382 17.0005
R4103 VGND.t1060 VGND.n586 17.0005
R4104 VGND.t1060 VGND.n383 17.0005
R4105 VGND.t1060 VGND.n585 17.0005
R4106 VGND.t1060 VGND.n384 17.0005
R4107 VGND.t1060 VGND.n584 17.0005
R4108 VGND.t1060 VGND.n385 17.0005
R4109 VGND.t1060 VGND.n583 17.0005
R4110 VGND.t1060 VGND.n386 17.0005
R4111 VGND.t1060 VGND.n582 17.0005
R4112 VGND.t1060 VGND.n387 17.0005
R4113 VGND.t1060 VGND.n581 17.0005
R4114 VGND.t1060 VGND.n388 17.0005
R4115 VGND.t1060 VGND.n580 17.0005
R4116 VGND.t1060 VGND.n389 17.0005
R4117 VGND.t315 VGND.n571 17.0005
R4118 VGND.t315 VGND.n392 17.0005
R4119 VGND.t315 VGND.n570 17.0005
R4120 VGND.t315 VGND.n394 17.0005
R4121 VGND.t315 VGND.n569 17.0005
R4122 VGND.t315 VGND.n395 17.0005
R4123 VGND.t315 VGND.n568 17.0005
R4124 VGND.t315 VGND.n113 13.8941
R4125 VGND.t315 VGND.n462 17.0005
R4126 VGND.t315 VGND.n396 17.0005
R4127 VGND.t315 VGND.n461 17.0005
R4128 VGND.t315 VGND.n397 17.0005
R4129 VGND.t315 VGND.n460 17.0005
R4130 VGND.t315 VGND.n398 17.0005
R4131 VGND.t315 VGND.n459 17.0005
R4132 VGND.t315 VGND.n399 17.0005
R4133 VGND.t315 VGND.n458 17.0005
R4134 VGND.t315 VGND.n400 17.0005
R4135 VGND.t315 VGND.n457 17.0005
R4136 VGND.t315 VGND.n401 17.0005
R4137 VGND.t315 VGND.n456 17.0005
R4138 VGND.t315 VGND.n402 17.0005
R4139 VGND.t315 VGND.n455 17.0005
R4140 VGND.t315 VGND.n403 17.0005
R4141 VGND.t315 VGND.n454 17.0005
R4142 VGND.t315 VGND.n404 17.0005
R4143 VGND.t315 VGND.n453 17.0005
R4144 VGND.t315 VGND.n452 17.0005
R4145 VGND.t315 VGND.n405 17.0005
R4146 VGND.t315 VGND.n451 17.0005
R4147 VGND.t315 VGND.n406 17.0005
R4148 VGND.t315 VGND.n450 17.0005
R4149 VGND.t315 VGND.n407 17.0005
R4150 VGND.t315 VGND.n449 17.0005
R4151 VGND.t315 VGND.n408 17.0005
R4152 VGND.t315 VGND.n448 17.0005
R4153 VGND.t315 VGND.n409 17.0005
R4154 VGND.t315 VGND.n447 17.0005
R4155 VGND.t315 VGND.n410 17.0005
R4156 VGND.t315 VGND.n446 17.0005
R4157 VGND.t315 VGND.n411 17.0005
R4158 VGND.t315 VGND.n445 17.0005
R4159 VGND.t315 VGND.n412 17.0005
R4160 VGND.t315 VGND.n444 17.0005
R4161 VGND.t315 VGND.n413 17.0005
R4162 VGND.t315 VGND.n443 17.0005
R4163 VGND.t315 VGND.n414 17.0005
R4164 VGND.t315 VGND.n442 17.0005
R4165 VGND.t315 VGND.n415 17.0005
R4166 VGND.t315 VGND.n441 17.0005
R4167 VGND.t315 VGND.n416 17.0005
R4168 VGND.t315 VGND.n440 17.0005
R4169 VGND.t315 VGND.n417 17.0005
R4170 VGND.t315 VGND.n439 17.0005
R4171 VGND.t315 VGND.n418 17.0005
R4172 VGND.t315 VGND.n438 17.0005
R4173 VGND.t315 VGND.n419 17.0005
R4174 VGND.t315 VGND.n437 17.0005
R4175 VGND.t315 VGND.n420 17.0005
R4176 VGND.t315 VGND.n436 17.0005
R4177 VGND.t315 VGND.n421 17.0005
R4178 VGND.t315 VGND.n435 17.0005
R4179 VGND.t315 VGND.n422 17.0005
R4180 VGND.t315 VGND.n434 17.0005
R4181 VGND.t315 VGND.n423 17.0005
R4182 VGND.t315 VGND.n433 17.0005
R4183 VGND.t315 VGND.n424 17.0005
R4184 VGND.t315 VGND.n432 17.0005
R4185 VGND.t315 VGND.n425 17.0005
R4186 VGND.t315 VGND.n431 17.0005
R4187 VGND.t315 VGND.n426 17.0005
R4188 VGND.t315 VGND.n430 17.0005
R4189 VGND.t315 VGND.n427 17.0005
R4190 VGND.t315 VGND.n428 17.0005
R4191 VGND.t315 VGND.n429 17.0005
R4192 VGND.n138 VGND.n559 17.0005
R4193 VGND.n138 VGND.n558 17.0005
R4194 VGND.n560 VGND.n138 17.0005
R4195 VGND.n138 VGND.n561 17.0005
R4196 VGND.n138 VGND.n474 17.0005
R4197 VGND.n138 VGND.n466 17.0005
R4198 VGND.n138 VGND.n467 17.0005
R4199 VGND.n138 VGND.n473 17.0005
R4200 VGND.n138 VGND.n472 17.0005
R4201 VGND.n138 VGND.n468 17.0005
R4202 VGND.n138 VGND.n471 17.0005
R4203 VGND.n138 VGND.n469 17.0005
R4204 VGND.n138 VGND.n470 17.0005
R4205 VGND.n138 VGND.n476 17.0005
R4206 VGND.n138 VGND.n555 17.0005
R4207 VGND.n138 VGND.n477 17.0005
R4208 VGND.n138 VGND.n554 17.0005
R4209 VGND.n138 VGND.n478 17.0005
R4210 VGND.n138 VGND.n553 17.0005
R4211 VGND.n138 VGND.n479 17.0005
R4212 VGND.n138 VGND.n552 17.0005
R4213 VGND.n138 VGND.n480 17.0005
R4214 VGND.n138 VGND.n551 17.0005
R4215 VGND.n138 VGND.n481 17.0005
R4216 VGND.n138 VGND.n550 17.0005
R4217 VGND.n138 VGND.n482 17.0005
R4218 VGND.n138 VGND.n549 17.0005
R4219 VGND.n138 VGND.n483 17.0005
R4220 VGND.n138 VGND.n548 17.0005
R4221 VGND.n138 VGND.n485 17.0005
R4222 VGND.n138 VGND.n547 17.0005
R4223 VGND.n138 VGND.n486 17.0005
R4224 VGND.n138 VGND.n546 17.0005
R4225 VGND.n138 VGND.n487 17.0005
R4226 VGND.n138 VGND.n545 17.0005
R4227 VGND.n138 VGND.n488 17.0005
R4228 VGND.n138 VGND.n544 17.0005
R4229 VGND.n138 VGND.n489 17.0005
R4230 VGND.n138 VGND.n543 17.0005
R4231 VGND.n138 VGND.n490 17.0005
R4232 VGND.n138 VGND.n542 17.0005
R4233 VGND.n138 VGND.n491 17.0005
R4234 VGND.n138 VGND.n541 17.0005
R4235 VGND.n138 VGND.n492 17.0005
R4236 VGND.n138 VGND.n540 17.0005
R4237 VGND.n138 VGND.n493 17.0005
R4238 VGND.n138 VGND.n539 17.0005
R4239 VGND.n138 VGND.n494 17.0005
R4240 VGND.n138 VGND.n538 17.0005
R4241 VGND.n138 VGND.n495 17.0005
R4242 VGND.n138 VGND.n537 17.0005
R4243 VGND.n138 VGND.n496 17.0005
R4244 VGND.n138 VGND.n536 17.0005
R4245 VGND.n138 VGND.n497 17.0005
R4246 VGND.n138 VGND.n535 17.0005
R4247 VGND.n138 VGND.n498 17.0005
R4248 VGND.n138 VGND.n534 17.0005
R4249 VGND.n138 VGND.n499 17.0005
R4250 VGND.n138 VGND.n533 17.0005
R4251 VGND.n138 VGND.n500 17.0005
R4252 VGND.n138 VGND.n532 17.0005
R4253 VGND.n138 VGND.n501 17.0005
R4254 VGND.n138 VGND.n531 17.0005
R4255 VGND.n138 VGND.n502 17.0005
R4256 VGND.n138 VGND.n530 17.0005
R4257 VGND.n138 VGND.n503 17.0005
R4258 VGND.n138 VGND.n529 17.0005
R4259 VGND.n138 VGND.n504 17.0005
R4260 VGND.n138 VGND.n528 17.0005
R4261 VGND.n138 VGND.n506 17.0005
R4262 VGND.n138 VGND.n527 17.0005
R4263 VGND.n138 VGND.n507 17.0005
R4264 VGND.n138 VGND.n526 17.0005
R4265 VGND.n138 VGND.n508 17.0005
R4266 VGND.n138 VGND.n525 17.0005
R4267 VGND.n138 VGND.n509 17.0005
R4268 VGND.n138 VGND.n524 17.0005
R4269 VGND.n138 VGND.n510 17.0005
R4270 VGND.n138 VGND.n511 17.0005
R4271 VGND.n138 VGND.n523 17.0005
R4272 VGND.n138 VGND.n512 17.0005
R4273 VGND.n138 VGND.n515 17.0005
R4274 VGND.n138 VGND.n513 17.0005
R4275 VGND.n138 VGND.n514 17.0005
R4276 VGND.t1469 VGND.n138 16.3503
R4277 VGND.n138 VGND.n142 2.10023
R4278 VGND.t766 VGND.t1060 16.3513
R4279 VGND.n57 VGND.t423 15.7034
R4280 VGND.t520 VGND.n3 15.7034
R4281 VGND.t148 VGND.n689 12.8576
R4282 VGND.n692 VGND.t149 12.8576
R4283 VGND.t493 VGND.n678 12.8576
R4284 VGND.n703 VGND.t494 12.8576
R4285 VGND.t886 VGND.n672 12.8576
R4286 VGND.n709 VGND.t887 12.8576
R4287 VGND.t423 VGND.t459 12.8576
R4288 VGND.t460 VGND.t424 12.8576
R4289 VGND.t899 VGND.t461 12.8576
R4290 VGND.t462 VGND.t581 12.8576
R4291 VGND.t224 VGND.n219 12.8576
R4292 VGND.n625 VGND.t225 12.8576
R4293 VGND.n629 VGND.t562 12.8576
R4294 VGND.t563 VGND.n213 12.8576
R4295 VGND.n638 VGND.t284 12.8576
R4296 VGND.t285 VGND.n204 12.8576
R4297 VGND.t453 VGND.n202 12.8576
R4298 VGND.n641 VGND.t454 12.8576
R4299 VGND.t360 VGND.n256 12.8576
R4300 VGND.n260 VGND.t361 12.8576
R4301 VGND.t829 VGND.n255 12.8576
R4302 VGND.n261 VGND.t830 12.8576
R4303 VGND.n268 VGND.t678 12.8576
R4304 VGND.t679 VGND.n247 12.8576
R4305 VGND.n269 VGND.t419 12.8576
R4306 VGND.t420 VGND.n246 12.8576
R4307 VGND.n279 VGND.t813 12.8576
R4308 VGND.t814 VGND.n235 12.8576
R4309 VGND.n280 VGND.t550 12.8576
R4310 VGND.t551 VGND.n234 12.8576
R4311 VGND.t1563 VGND.n310 12.8576
R4312 VGND.n344 VGND.t1564 12.8576
R4313 VGND.n350 VGND.t59 12.8576
R4314 VGND.t60 VGND.n302 12.8576
R4315 VGND.n353 VGND.t18 12.8576
R4316 VGND.t19 VGND.n299 12.8576
R4317 VGND.t184 VGND.n388 12.8576
R4318 VGND.n581 VGND.t185 12.8576
R4319 VGND.t167 VGND.n384 12.8576
R4320 VGND.n585 VGND.t168 12.8576
R4321 VGND.n589 VGND.t659 12.8576
R4322 VGND.t660 VGND.n378 12.8576
R4323 VGND.n593 VGND.t216 12.8576
R4324 VGND.t217 VGND.n374 12.8576
R4325 VGND.t724 VGND.n426 12.8576
R4326 VGND.n431 VGND.t725 12.8576
R4327 VGND.n437 VGND.t512 12.8576
R4328 VGND.t513 VGND.n419 12.8576
R4329 VGND.n525 VGND.t1474 12.8576
R4330 VGND.t1475 VGND.n508 12.8576
R4331 VGND.n531 VGND.t1518 12.8576
R4332 VGND.t1519 VGND.n501 12.8576
R4333 VGND.t1465 VGND.n499 12.8576
R4334 VGND.n534 VGND.t1466 12.8576
R4335 VGND.t1485 VGND.n496 12.8576
R4336 VGND.n537 VGND.t1486 12.8576
R4337 VGND.n734 VGND.n173 9.0005
R4338 VGND.n619 VGND.n173 9.0005
R4339 VGND.n520 VGND.n518 9.0005
R4340 VGND.n522 VGND.n516 9.0005
R4341 VGND.n566 VGND.n463 9.0005
R4342 VGND.n562 VGND.n463 9.0005
R4343 VGND.n182 VGND.n181 9.0005
R4344 VGND.n662 VGND.n661 9.0005
R4345 VGND.t160 VGND.t68 8.57193
R4346 VGND.t2 VGND.t218 8.57193
R4347 VGND.t653 VGND.t990 8.57193
R4348 VGND.n161 VGND.t1432 0.0719145
R4349 VGND.t1430 VGND.n35 8.501
R4350 VGND.n160 VGND.t1427 0.130189
R4351 VGND.t1425 VGND.n35 8.501
R4352 VGND.t1422 VGND.n159 0.130189
R4353 VGND.n158 VGND.t1417 0.215686
R4354 VGND.t1415 VGND.n35 8.501
R4355 VGND.n157 VGND.t1412 0.130189
R4356 VGND.t1410 VGND.n35 8.501
R4357 VGND.n156 VGND.t1407 0.130189
R4358 VGND.t1405 VGND.n35 8.501
R4359 VGND.n155 VGND.t1402 0.130189
R4360 VGND.t1400 VGND.n35 8.501
R4361 VGND.n154 VGND.t1397 0.130189
R4362 VGND.t1395 VGND.n35 8.501
R4363 VGND.n153 VGND.t1392 0.130189
R4364 VGND.t1390 VGND.n35 8.501
R4365 VGND.n152 VGND.t1387 0.130189
R4366 VGND.t1385 VGND.n35 8.501
R4367 VGND.n151 VGND.t1382 0.130189
R4368 VGND.t1380 VGND.n35 8.501
R4369 VGND.n150 VGND.n35 3.33079
R4370 VGND.t1376 VGND.n168 0.238436
R4371 VGND.n167 VGND.t1373 0.130189
R4372 VGND.t1371 VGND.n35 8.501
R4373 VGND.n166 VGND.t1368 0.130189
R4374 VGND.t1366 VGND.n35 8.501
R4375 VGND.n165 VGND.t1363 0.130189
R4376 VGND.t1361 VGND.n35 8.501
R4377 VGND.n164 VGND.t1358 0.130189
R4378 VGND.t1356 VGND.n35 8.501
R4379 VGND.n163 VGND.t1353 0.130189
R4380 VGND.t1351 VGND.n35 8.501
R4381 VGND.n35 VGND.n162 3.33079
R4382 VGND.t116 VGND.n169 0.439794
R4383 VGND.n172 VGND.t934 0.152573
R4384 VGND.t636 VGND.n171 0.633676
R4385 VGND.n170 VGND.n138 1.0909
R4386 VGND.n35 VGND.n161 4.2093
R4387 VGND.n160 VGND.n35 3.33079
R4388 VGND.n35 VGND.n159 3.33079
R4389 VGND.n157 VGND.n35 3.33079
R4390 VGND.n35 VGND.n156 3.33079
R4391 VGND.n155 VGND.n35 3.33079
R4392 VGND.n35 VGND.n154 3.33079
R4393 VGND.n153 VGND.n35 3.33079
R4394 VGND.n35 VGND.n152 3.33079
R4395 VGND.n151 VGND.n35 3.33079
R4396 VGND.n150 VGND.t1378 0.0863258
R4397 VGND.n35 VGND.n167 3.33079
R4398 VGND.n166 VGND.n35 3.33079
R4399 VGND.n35 VGND.n165 3.33079
R4400 VGND.n164 VGND.n35 3.33079
R4401 VGND.n35 VGND.n163 3.33079
R4402 VGND.t1349 VGND.n162 0.0863258
R4403 VGND.t1420 VGND.n715 5.16578
R4404 VGND.t941 VGND.n522 4.61666
R4405 VGND.n562 VGND.t639 4.61666
R4406 VGND.n572 VGND.t332 4.5005
R4407 VGND.n578 VGND.t1004 4.5005
R4408 VGND.t165 VGND.n579 4.5005
R4409 VGND.t275 VGND.n224 4.5005
R4410 VGND.n618 VGND.t358 4.5005
R4411 VGND.t222 VGND.n620 4.5005
R4412 VGND.n733 VGND.t198 4.5005
R4413 VGND.t146 VGND.n175 4.5005
R4414 VGND.t1366 VGND.n732 4.5005
R4415 VGND.t573 VGND.n567 4.5005
R4416 VGND.t1029 VGND.n361 4.5005
R4417 VGND.n607 VGND.t1086 4.5005
R4418 VGND.t1127 VGND.n608 4.5005
R4419 VGND.t1176 VGND.n184 4.5005
R4420 VGND.n659 VGND.t1219 4.5005
R4421 VGND.n665 VGND.t130 4.5005
R4422 VGND.n715 VGND.t1308 4.5005
R4423 VGND.n519 VGND.n390 4.49573
R4424 VGND.n664 VGND.n663 4.49573
R4425 VGND.n737 VGND.n736 4.49046
R4426 VGND.n735 VGND.n173 4.49046
R4427 VGND.n737 VGND.n174 4.49046
R4428 VGND.n517 VGND.n516 4.49046
R4429 VGND.n521 VGND.n520 4.49046
R4430 VGND.n565 VGND.n464 4.49046
R4431 VGND.n564 VGND.n463 4.49046
R4432 VGND.n563 VGND.n464 4.49046
R4433 VGND.n662 VGND.n183 4.49046
R4434 VGND.n660 VGND.n182 4.49046
R4435 VGND.n80 VGND.t1060 0.871819
R4436 VGND.n35 VGND.n158 2.33238
R4437 VGND.n168 VGND.n35 2.31501
R4438 VGND.n138 VGND.n172 2.06295
R4439 VGND.t1028 VGND.n290 2.75379
R4440 VGND.n520 VGND.n463 2.17938
R4441 VGND.n662 VGND.n173 2.17938
R4442 VGND.n23 VGND.t1173 0.291128
R4443 VGND.t11 VGND.t114 1.76601
R4444 VGND.t11 VGND.n169 1.35976
R4445 VGND.n138 VGND.n465 1.4151
R4446 VGND.n170 VGND.t897 0.0854993
R4447 VGND.t41 VGND.t56 1.26877
R4448 VGND.t1235 VGND.t126 1.24547
R4449 VGND.t150 VGND.n73 0.507384
R4450 VGND.t1060 VGND.t1067 1.21971
R4451 VGND.t11 VGND.t1119 1.21971
R4452 VGND.t207 VGND.t41 1.21624
R4453 VGND.t11 VGND.n25 0.903505
R4454 VGND.t315 VGND.t652 1.15703
R4455 VGND.n138 VGND.t907 1.15509
R4456 VGND.n177 VGND.t112 1.14392
R4457 VGND.t1248 VGND.t244 1.10768
R4458 VGND.t1079 VGND.n80 0.00865762
R4459 VGND.n484 VGND.t693 1.09993
R4460 VGND.t866 VGND.n180 1.09461
R4461 VGND.t1235 VGND.n64 0.201956
R4462 VGND.n505 VGND.t942 1.08258
R4463 VGND.t358 VGND.n23 0.596754
R4464 VGND.t504 VGND.t501 1.07761
R4465 VGND.t72 VGND.n65 0.327949
R4466 VGND.t92 VGND.t112 1.06683
R4467 VGND.t402 VGND.n318 1.06341
R4468 VGND.t207 VGND.n176 1.06341
R4469 VGND.t584 VGND.t1296 1.05584
R4470 VGND.t1020 VGND.n575 1.05378
R4471 VGND.n180 VGND.t860 1.0535
R4472 VGND.n574 VGND.t377 1.04408
R4473 VGND.t23 VGND.n216 1.0425
R4474 VGND.t5 VGND.t11 0.387455
R4475 VGND.t915 VGND.t912 1.04047
R4476 VGND.t82 VGND.n65 1.3994
R4477 VGND.t345 VGND.n13 0.423169
R4478 VGND.t1 VGND.n72 0.452173
R4479 VGND.n574 VGND.t350 1.02826
R4480 VGND.t519 VGND.t315 0.410615
R4481 VGND.t169 VGND.n72 1.15065
R4482 VGND.n64 VGND.t282 0.427558
R4483 VGND.t1300 VGND.t1302 1.01465
R4484 VGND.n34 VGND.t800 0.405527
R4485 VGND.t315 VGND.n13 0.175484
R4486 VGND.t169 VGND.n381 1.00953
R4487 VGND.t750 VGND.t350 1.00756
R4488 VGND.n573 VGND.t384 1.00457
R4489 VGND.t11 VGND.n34 0.196847
R4490 VGND.t384 VGND.t750 0.999184
R4491 VGND.t377 VGND.n575 0.990468
R4492 VGND.n391 VGND.t315 0.979464
R4493 VGND.t912 VGND.t942 0.974591
R4494 VGND.t27 VGND.t23 0.968681
R4495 VGND.n74 VGND.t491 0.433959
R4496 VGND.n138 VGND.n475 0.946007
R4497 VGND.n73 VGND.t146 0.0451295
R4498 VGND.t402 VGND.t413 0.920109
R4499 VGND.t1004 VGND.n577 0.915053
R4500 VGND.t1176 VGND.t1178 0.911226
R4501 VGND.t92 VGND.t56 0.910534
R4502 VGND.t342 VGND.t332 0.898162
R4503 VGND.n318 VGND.t275 0.898101
R4504 VGND.t198 VGND.n176 0.898101
R4505 VGND.n484 VGND.t915 0.891224
R4506 VGND.t1308 VGND.n666 0.887897
R4507 VGND.t1308 VGND.t1306 0.873947
R4508 VGND.t633 VGND.t1086 0.870995
R4509 VGND.t330 VGND.t639 0.866232
R4510 VGND.t652 VGND.t322 0.852664
R4511 VGND.t1235 VGND.n223 0.837255
R4512 VGND.t1296 VGND.t1300 0.834398
R4513 VGND.n216 VGND.t222 0.808469
R4514 VGND.n171 VGND.n138 0.683203
R4515 VGND.t504 VGND.t584 0.802429
R4516 VGND.t1029 VGND.n576 0.801572
R4517 VGND.n573 VGND.t1004 0.801326
R4518 VGND.t1306 VGND.t150 0.800627
R4519 VGND.t941 VGND.n505 0.799786
R4520 VGND.t1306 VGND.t1302 0.784895
R4521 VGND.n381 VGND.t165 0.755685
R4522 VGND.n171 VGND.t330 0.0610663
R4523 VGND.t633 VGND.t397 0.734381
R4524 VGND.n475 VGND.t636 0.734171
R4525 VGND.t366 VGND.t1219 0.705589
R4526 VGND.n576 VGND.t157 0.682974
R4527 VGND.t999 VGND.n577 0.669243
R4528 VGND.t897 VGND.t941 0.665917
R4529 VGND.n732 VGND.n175 0.66578
R4530 VGND.n733 VGND.n175 0.66578
R4531 VGND.n620 VGND.n618 0.66578
R4532 VGND.n618 VGND.n224 0.66578
R4533 VGND.n579 VGND.n224 0.66578
R4534 VGND.n579 VGND.n578 0.66578
R4535 VGND.n578 VGND.n572 0.66578
R4536 VGND.n715 VGND.n665 0.66578
R4537 VGND.n659 VGND.n184 0.66578
R4538 VGND.n608 VGND.n184 0.66578
R4539 VGND.n608 VGND.n607 0.66578
R4540 VGND.n607 VGND.n361 0.66578
R4541 VGND.n567 VGND.n361 0.66578
R4542 VGND.t70 VGND.t1178 0.66087
R4543 VGND.n170 VGND.t871 0.534202
R4544 VGND.n576 VGND.n290 0.655078
R4545 VGND.t150 VGND.n39 0.649813
R4546 VGND.t150 VGND.n40 0.649813
R4547 VGND.t150 VGND.n51 0.649813
R4548 VGND.t150 VGND.n41 0.649813
R4549 VGND.t150 VGND.n50 0.649813
R4550 VGND.t150 VGND.n42 0.649813
R4551 VGND.t150 VGND.n49 0.649813
R4552 VGND.t150 VGND.n43 0.649813
R4553 VGND.t150 VGND.n48 0.649813
R4554 VGND.t150 VGND.n44 0.649813
R4555 VGND.t150 VGND.n47 0.649813
R4556 VGND.t150 VGND.n45 0.649813
R4557 VGND.t150 VGND.n46 0.649813
R4558 VGND.t150 VGND.n38 427.5
R4559 VGND.t1235 VGND.n52 0.649813
R4560 VGND.t1235 VGND.n53 0.649813
R4561 VGND.t1235 VGND.n54 0.649813
R4562 VGND.t1235 VGND.n63 0.649813
R4563 VGND.t1235 VGND.n62 0.649813
R4564 VGND.t1235 VGND.n61 0.649813
R4565 VGND.t1235 VGND.n55 0.649813
R4566 VGND.t1235 VGND.n60 0.649813
R4567 VGND.t1235 VGND.n59 0.649813
R4568 VGND.t1235 VGND.n56 0.649813
R4569 VGND.t1235 VGND.n58 0.649813
R4570 VGND.t1235 VGND.n57 0.649813
R4571 VGND.t358 VGND.n22 0.649813
R4572 VGND.t358 VGND.n14 0.649813
R4573 VGND.t358 VGND.n21 0.649813
R4574 VGND.t358 VGND.n15 0.649813
R4575 VGND.t358 VGND.n20 0.649813
R4576 VGND.t358 VGND.n16 0.649813
R4577 VGND.t358 VGND.n17 0.649813
R4578 VGND.t358 VGND.n19 0.649813
R4579 VGND.t358 VGND.n18 0.649813
R4580 VGND.t358 VGND.n24 427.5
R4581 VGND.t11 VGND.n26 0.649813
R4582 VGND.n149 VGND.t1126 243.139
R4583 VGND.t11 VGND.n33 0.649813
R4584 VGND.t11 VGND.n32 0.649813
R4585 VGND.t11 VGND.n27 0.649813
R4586 VGND.t11 VGND.n28 0.649813
R4587 VGND.t11 VGND.n29 0.649813
R4588 VGND.t11 VGND.n31 0.649813
R4589 VGND.t11 VGND.n30 0.649813
R4590 VGND.n614 VGND.t11 427.5
R4591 VGND.t1060 VGND.n71 0.649813
R4592 VGND.t1060 VGND.n66 0.649813
R4593 VGND.t1060 VGND.n70 0.649813
R4594 VGND.t1060 VGND.n69 0.649813
R4595 VGND.t1060 VGND.n67 0.649813
R4596 VGND.t1060 VGND.n68 0.649813
R4597 VGND.t315 VGND.n12 0.649813
R4598 VGND.t315 VGND.n11 0.649813
R4599 VGND.t315 VGND.n10 0.649813
R4600 VGND.t315 VGND.n0 0.649813
R4601 VGND.t315 VGND.n1 0.649813
R4602 VGND.t315 VGND.n9 0.649813
R4603 VGND.t315 VGND.n8 0.649813
R4604 VGND.t315 VGND.n7 0.649813
R4605 VGND.t315 VGND.n2 0.649813
R4606 VGND.t315 VGND.n3 0.649813
R4607 VGND.t315 VGND.n4 0.649813
R4608 VGND.t315 VGND.n5 0.649813
R4609 VGND.t315 VGND.n6 0.649813
R4610 VGND.n138 VGND.n130 0.649813
R4611 VGND.n138 VGND.n131 0.649813
R4612 VGND.n138 VGND.n132 0.649813
R4613 VGND.n138 VGND.n136 0.649813
R4614 VGND.n138 VGND.n134 0.0258175
R4615 VGND.n138 VGND.n129 0.649813
R4616 VGND.n138 VGND.n120 0.649813
R4617 VGND.n138 VGND.n121 0.649813
R4618 VGND.n138 VGND.n128 0.649813
R4619 VGND.n138 VGND.n127 0.649813
R4620 VGND.n138 VGND.n126 0.649813
R4621 VGND.n138 VGND.n122 0.649813
R4622 VGND.n138 VGND.n125 0.649813
R4623 VGND.n138 VGND.n123 0.649813
R4624 VGND.n140 VGND.n138 0.281786
R4625 VGND.t150 VGND.n666 0.635634
R4626 VGND.t1060 VGND.t633 0.632531
R4627 VGND.t150 VGND.t584 0.620732
R4628 VGND.t868 VGND.n666 0.620188
R4629 VGND.t358 VGND.t1178 0.617165
R4630 VGND.t851 VGND.t366 0.611097
R4631 VGND.t1235 VGND.t366 0.608794
R4632 VGND.t150 VGND.t1300 0.604578
R4633 VGND.t82 VGND.t126 0.603967
R4634 VGND.t871 VGND.t907 0.602045
R4635 VGND.t1060 VGND.n381 0.577536
R4636 VGND VGND.n737 0.56194
R4637 VGND.t1235 VGND.n216 0.557338
R4638 VGND.t1129 VGND.n169 0.0899486
R4639 VGND.t750 VGND.n290 0.553856
R4640 VGND.t806 VGND.n23 0.159596
R4641 VGND.n620 VGND.n619 0.52498
R4642 VGND.n661 VGND.n659 0.52498
R4643 VGND.n465 VGND.t934 0.508205
R4644 VGND.t1060 VGND.n72 0.223594
R4645 VGND.n74 VGND.t501 0.18253
R4646 VGND.t1219 VGND.t126 0.504074
R4647 VGND.t1173 VGND.t1176 0.497155
R4648 VGND.n177 VGND.t130 0.495657
R4649 VGND.t114 VGND.t116 0.492708
R4650 VGND.n34 VGND.t413 0.199542
R4651 VGND.n223 VGND.t222 0.488845
R4652 VGND.n138 VGND.n505 0.481929
R4653 VGND.n64 VGND.t27 0.189308
R4654 VGND.n465 VGND.t639 0.466018
R4655 VGND.n573 VGND.n290 0.464458
R4656 VGND.n180 VGND.n35 0.463092
R4657 VGND.n138 VGND.t912 0.454585
R4658 VGND.t244 VGND.n176 0.427478
R4659 VGND.t11 VGND.n318 0.427478
R4660 VGND.n13 VGND.t342 0.179568
R4661 VGND.n572 VGND.n390 0.4229
R4662 VGND.n567 VGND.n566 0.4229
R4663 VGND.n475 VGND.t693 0.417743
R4664 VGND.n577 VGND.n290 0.413575
R4665 VGND.t1129 VGND.t1130 0.397273
R4666 VGND.n138 VGND.n484 0.367819
R4667 VGND.t358 VGND.t1153 0.838794
R4668 VGND.t332 VGND.n391 0.347617
R4669 VGND.n393 VGND.t573 0.344594
R4670 VGND.t244 VGND.t92 0.344014
R4671 VGND.t860 VGND.n168 0.383459
R4672 VGND.t1029 VGND.t1028 0.334655
R4673 VGND.n574 VGND.n290 0.323112
R4674 VGND.n575 VGND.n290 0.316092
R4675 VGND.t1418 VGND.n158 0.0850573
R4676 VGND.n25 VGND.t1127 0.332214
R4677 VGND.t114 VGND.t1127 0.279487
R4678 VGND.t244 VGND.t41 0.252599
R4679 VGND.t1020 VGND.t1028 0.252401
R4680 VGND.t1349 VGND.t1351 0.226736
R4681 VGND.t1356 VGND.t1354 0.226736
R4682 VGND.t1359 VGND.t1361 0.226736
R4683 VGND.t1366 VGND.t1364 0.226736
R4684 VGND.t1369 VGND.t1371 0.226736
R4685 VGND.t1376 VGND.t1374 0.226736
R4686 VGND.t1380 VGND.t1378 0.226736
R4687 VGND.t1383 VGND.t1385 0.226736
R4688 VGND.t1390 VGND.t1388 0.226736
R4689 VGND.t1393 VGND.t1395 0.226736
R4690 VGND.t1400 VGND.t1398 0.226736
R4691 VGND.t1403 VGND.t1405 0.226736
R4692 VGND.t1410 VGND.t1408 0.226736
R4693 VGND.t1413 VGND.t1415 0.226736
R4694 VGND.t1425 VGND.t1423 0.226736
R4695 VGND.t1428 VGND.t1430 0.226736
R4696 VGND.t198 VGND.t1248 0.218652
R4697 VGND.t1348 VGND.n162 0.130189
R4698 VGND.n164 VGND.t1359 0.0863258
R4699 VGND.n166 VGND.t1369 0.0863258
R4700 VGND.n151 VGND.t1383 0.0863258
R4701 VGND.n153 VGND.t1393 0.0863258
R4702 VGND.n155 VGND.t1403 0.0863258
R4703 VGND.n157 VGND.t1413 0.0863258
R4704 VGND.n160 VGND.t1428 0.0863258
R4705 VGND.t1423 VGND.n159 0.0863258
R4706 VGND.t1408 VGND.n156 0.0863258
R4707 VGND.t1398 VGND.n154 0.0863258
R4708 VGND.t1388 VGND.n152 0.0863258
R4709 VGND.n150 VGND.t866 0.130189
R4710 VGND.t1374 VGND.n167 0.0863258
R4711 VGND.t1364 VGND.n165 0.0863258
R4712 VGND.t1354 VGND.n163 0.0863258
R4713 VGND.t951 VGND.n172 0.153437
R4714 VGND.n393 VGND.t322 0.192704
R4715 VGND.t244 VGND.n177 0.179293
R4716 VGND.t1433 VGND.n161 0.0716963
R4717 VGND.t1418 VGND.t1420 0.135506
R4718 VGND.t244 VGND.t40 0.113833
R4719 VGND.t156 VGND.n290 0.113833
R4720 VGND.n73 VGND.t1291 0.0581409
R4721 VGND.t275 VGND.t1119 0.10675
R4722 VGND.t165 VGND.t1067 0.10675
R4723 VGND.t1086 VGND.t1085 0.0939657
R4724 VGND.t1351 VGND.t1353 0.0855
R4725 VGND.t1358 VGND.t1356 0.0855
R4726 VGND.t1361 VGND.t1363 0.0855
R4727 VGND.t1368 VGND.t1366 0.0855
R4728 VGND.t1371 VGND.t1373 0.0855
R4729 VGND.t1382 VGND.t1380 0.0855
R4730 VGND.t1385 VGND.t1387 0.0855
R4731 VGND.t1392 VGND.t1390 0.0855
R4732 VGND.t1395 VGND.t1397 0.0855
R4733 VGND.t1402 VGND.t1400 0.0855
R4734 VGND.t1405 VGND.t1407 0.0855
R4735 VGND.t1412 VGND.t1410 0.0855
R4736 VGND.t1415 VGND.t1417 0.0855
R4737 VGND.t1422 VGND.t1420 0.0855
R4738 VGND.t1427 VGND.t1425 0.0855
R4739 VGND.t1430 VGND.t1432 0.07425
R4740 VGND.n223 VGND.t1207 0.0643825
R4741 VGND.n25 VGND.t1125 0.013847
R4742 VGND.n736 VGND.n735 0.0436411
R4743 VGND.n521 VGND.n517 0.0436411
R4744 VGND.n735 VGND.n174 0.0436411
R4745 VGND.n660 VGND.n183 0.0436411
R4746 VGND.n565 VGND.n564 0.0436411
R4747 VGND.n564 VGND.n563 0.0436411
R4748 VGND.n518 VGND.n390 0.04274
R4749 VGND.n664 VGND.n181 0.04274
R4750 VGND.t1085 VGND.n80 0.0303004
R4751 VGND.t1235 VGND.t1214 109.992
R4752 VGND.t1235 VGND.t1212 109.992
R4753 VGND.t358 VGND.t1156 109.992
R4754 VGND.t11 VGND.n98 13.8941
R4755 VGND.t1060 VGND.t1065 109.992
R4756 VGND.t1060 VGND.t1063 109.992
R4757 VGND.n138 VGND.n137 0.0258175
R4758 VGND.n138 VGND.n133 0.0258175
R4759 VGND.n138 VGND.n135 0.0258175
R4760 VGND.n138 VGND.n124 0.0258175
R4761 VGND.n619 VGND.n174 0.0220706
R4762 VGND.n736 VGND.n734 0.0220706
R4763 VGND.n518 VGND.n517 0.0220706
R4764 VGND.n522 VGND.n521 0.0220706
R4765 VGND.n566 VGND.n565 0.0220706
R4766 VGND.n563 VGND.n562 0.0220706
R4767 VGND.n183 VGND.n181 0.0220706
R4768 VGND.n661 VGND.n660 0.0220706
R4769 VGND.n464 VGND.n463 0.02162
R4770 VGND.n737 VGND.n173 0.02162
R4771 VGND.n732 VGND 0.01986
R4772 VGND.n391 VGND.t958 0.0159033
R4773 VGND.n734 VGND.n733 0.01458
R4774 VGND.n665 VGND.n664 0.01458
R4775 VGND.n520 VGND.n519 0.0115476
R4776 VGND.n519 VGND.n516 0.0115476
R4777 VGND.n663 VGND.n182 0.0115476
R4778 VGND.n663 VGND.n662 0.0115476
R4779 VGND.t1404 VGND.n35 183.805
R4780 VGND.t1360 VGND.n35 183.805
R4781 VGND.n139 VGND.t896 54.9296
R4782 VGND.t315 VGND.n393 1.27714
R4783 VGND.n730 VGND.n35 1.22488
R4784 VGND.t671 VGND.t358 1.16935
R4785 VGND.t1235 VGND.n65 0.390189
R4786 VGND.t1060 VGND.t261 1.09856
R4787 VGND.t11 VGND.n149 1.05563
R4788 VGND.n74 VGND.t150 1.02478
C0 sg13cmos5l_buf_16_1.X a_10318_8434# 0.59066f
C1 sg13cmos5l_buf_1_5.A a_6094_4656# 0.02027f
C2 sg13cmos5l_buf_16_28.X sg13cmos5l_buf_1_6.A 0.08514f
C3 sg13cmos5l_xor2_1_4.X a_13576_9278# 0.05844f
C4 sg13cmos5l_buf_16_14.A a_3694_8434# 0.06953f
C5 a_3668_4620# a_3488_4742# 0.0364f
C6 sg13cmos5l_buf_16_7.X a_6094_4656# 0.57856f
C7 sg13cmos5l_buf_16_33.A sg13cmos5l_and2_2_6.A 0.0808f
C8 sg13cmos5l_buf_16_14.A enable 0.03834f
C9 a_9262_7680# VPWR 2.20407f
C10 sg13cmos5l_buf_16_5.X a_5710_1632# 0.05916f
C11 sg13cmos5l_buf_16_24.X a_6862_9946# 1.37803f
C12 sg13cmos5l_xor2_1_6.X sg13cmos5l_and2_2_5.B 0.0693f
C13 sg13cmos5l_xor2_1_0.B sg13cmos5l_buf_16_39.A 0.34252f
C14 sg13cmos5l_buf_1_15.X sg13cmos5l_buf_16_22.X 0.01525f
C15 sg13cmos5l_buf_16_37.A a_10292_12934# 0.017f
C16 sg13cmos5l_buf_16_8.A sg13cmos5l_buf_16_11.A 0.03043f
C17 a_14344_8468# VPWR 0.264f
C18 a_6094_3898# a_6094_3144# 0.18924f
C19 sg13cmos5l_buf_16_4.X a_8110_6168# 0.0116f
C20 a_4689_6168# VPWR 0.01075f
C21 sg13cmos5l_buf_16_34.X sg13cmos5l_buf_16_14.A 0.38716f
C22 a_15104_8562# VPWR 0.10668f
C23 sg13cmos5l_and2_2_6.B sg13cmos5l_buf_16_25.A 0.08367f
C24 sg13cmos5l_buf_16_31.X a_4721_6526# 0.41648f
C25 sg13cmos5l_and2_2_5.B a_11656_13814# 0.02116f
C26 sg13cmos5l_buf_16_19.A a_6094_10704# 0.0582f
C27 sg13cmos5l_buf_16_4.X VPWR 3.51038f
C28 a_14824_6956# out_xor[3] 0.28955f
C29 a_13581_9988# a_14252_9906# 0.02728f
C30 a_14252_9906# VPWR 0.34791f
C31 sg13cmos5l_xor2_1_0.B sg13cmos5l_buf_16_7.A 0.10267f
C32 sg13cmos5l_buf_1_5.A sg13cmos5l_buf_16_35.A 0.05622f
C33 sg13cmos5l_buf_1_2.A sg13cmos5l_buf_1_2.X 0.01876f
C34 sg13cmos5l_buf_16_39.A VPWR 5.39332f
C35 a_3668_9156# sg13cmos5l_buf_16_13.A 1.35129f
C36 a_1672_14516# sg13cmos5l_and2_2_0.B 0.28943f
C37 sg13cmos5l_and2_2_0.B a_3668_9156# 0.04471f
C38 sg13cmos5l_buf_16_2.A a_13745_8484# 0.09312f
C39 a_7796_12934# VPWR 2.43902f
C40 sg13cmos5l_buf_16_6.X a_10318_8434# 0.04218f
C41 sg13cmos5l_and2_2_6.B sg13cmos5l_buf_1_23.A 0.03433f
C42 sg13cmos5l_buf_16_2.A a_8110_6168# 0.01791f
C43 a_13664_5538# VPWR 0.11893f
C44 sg13cmos5l_buf_1_5.A sg13cmos5l_and2_2_6.A 0.10848f
C45 sg13cmos5l_buf_1_6.A a_4892_6168# 0.11764f
C46 sg13cmos5l_xor2_1_6.X sg13cmos5l_buf_16_27.X 0.25766f
C47 sg13cmos5l_and2_2_6.A a_7629_8028# 0.12029f
C48 a_13667_12956# a_13472_13098# 0.02895f
C49 a_3694_10704# VPWR 2.27185f
C50 a_1480_14610# glitch_en[0] 0.06428f
C51 sg13cmos5l_buf_16_2.A VPWR 4.382f
C52 sg13cmos5l_buf_16_22.X a_13745_8484# 0.42739f
C53 sg13cmos5l_buf_16_7.A VPWR 3.72874f
C54 a_3694_8434# VPWR 2.18947f
C55 a_14444_14442# VPWR 0.28366f
C56 VPWR enable 1.63887f
C57 sg13cmos5l_buf_1_11.X sg13cmos5l_xor2_1_4.X 0.05297f
C58 a_3668_12180# VPWR 2.33005f
C59 sg13cmos5l_xor2_1_5.X a_13745_8484# 0.0583f
C60 sg13cmos5l_buf_16_6.X sg13cmos5l_buf_16_1.X 0.21913f
C61 sg13cmos5l_buf_16_13.A sg13cmos5l_buf_16_34.A 0.18238f
C62 sg13cmos5l_and2_2_6.A sg13cmos5l_buf_16_35.A 0.06609f
C63 sg13cmos5l_and2_2_1.B sg13cmos5l_and2_2_1.X 0.81501f
C64 sg13cmos5l_and2_2_0.B sg13cmos5l_buf_16_34.A 0.25418f
C65 sg13cmos5l_buf_16_23.X a_11272_13728# 0.01933f
C66 a_6548_13692# sg13cmos5l_buf_16_27.X 1.32819f
C67 sg13cmos5l_buf_16_15.X sg13cmos5l_buf_16_15.A 0.09218f
C68 sg13cmos5l_buf_16_7.X a_3668_3108# 0.0908f
C69 sg13cmos5l_xor2_1_0.B a_8564_2680# 0.03711f
C70 sg13cmos5l_buf_16_22.X VPWR 3.43119f
C71 sg13cmos5l_buf_16_34.X VPWR 3.86087f
C72 a_14824_14516# out_xor[7] 0.28827f
C73 sg13cmos5l_xor2_1_6.X glitch_en[4] 0.03033f
C74 sg13cmos5l_buf_16_22.X a_13581_9988# 0.12413f
C75 sg13cmos5l_buf_1_6.A sg13cmos5l_buf_1_5.X 0.04285f
C76 sg13cmos5l_xor2_1_0.B sg13cmos5l_and2_2_0.X 0.06841f
C77 a_11898_13691# VPWR 0.26396f
C78 sg13cmos5l_xor2_1_5.X VPWR 0.68964f
C79 a_4174_13728# VPWR 2.19398f
C80 sg13cmos5l_buf_1_14.X VPWR 0.54135f
C81 a_6862_9946# sg13cmos5l_buf_1_23.A 0.02512f
C82 a_4462_5410# VPWR 2.20754f
C83 VPWR out_xor[2] 0.14045f
C84 sg13cmos5l_buf_16_11.A a_3668_4620# 0.58966f
C85 sg13cmos5l_buf_16_31.X sg13cmos5l_buf_16_28.X 0.07163f
C86 a_8000_1718# VPWR 0.07825f
C87 a_3872_13098# VPWR 0.12088f
C88 sg13cmos5l_buf_1_5.A a_5518_6922# 0.05138f
C89 sg13cmos5l_buf_16_39.A a_8104_1632# 0.012f
C90 sg13cmos5l_and2_2_6.B a_7796_12934# 0.02232f
C91 a_10112_4026# VPWR 0.11854f
C92 sg13cmos5l_xor2_1_0.B sg13cmos5l_buf_1_2.A 0.03393f
C93 sg13cmos5l_xor2_1_6.X out_xor[7] 0.06146f
C94 sg13cmos5l_buf_16_8.A a_3668_4620# 1.37653f
C95 sg13cmos5l_buf_16_18.A sg13cmos5l_buf_16_15.A 0.04534f
C96 a_9344_7050# VPWR 0.06942f
C97 a_8564_2680# VPWR 0.27141f
C98 sg13cmos5l_buf_1_17.X VPWR 1.20091f
C99 sg13cmos5l_buf_16_10.A a_3694_2386# 0.06056f
C100 VPWR out_xor[3] 0.1333f
C101 sg13cmos5l_and2_2_0.X VPWR 0.86625f
C102 a_3020_14442# a_2728_14610# 0.03269f
C103 a_3694_2386# a_5984_2514# 0.0364f
C104 sg13cmos5l_buf_16_35.A a_9617_8484# 0.09184f
C105 sg13cmos5l_buf_1_5.A sg13cmos5l_buf_16_28.X 0.1072f
C106 a_10292_4620# a_10112_4742# 0.0364f
C107 a_4168_10074# VPWR 0.16109f
C108 a_4052_12934# a_3668_12180# 0.12256f
C109 sg13cmos5l_xor2_1_6.X glitch_en[6] 0.04734f
C110 a_3875_5396# sg13cmos5l_xor2_1_0.B 0.12058f
C111 a_3304_14610# glitch_en[1] 0.05864f
C112 sg13cmos5l_buf_1_2.A VPWR 0.38278f
C113 sg13cmos5l_buf_16_2.A a_10318_3898# 0.60196f
C114 sg13cmos5l_and2_2_5.B VPWR 1.7226f
C115 sg13cmos5l_buf_16_0.A sg13cmos5l_buf_16_39.A 0.01412f
C116 a_6161_9550# sg13cmos5l_buf_1_23.A 0.25482f
C117 a_3020_14442# sg13cmos5l_and2_2_1.B 0.28895f
C118 VPWR out_xor[4] 0.25089f
C119 sg13cmos5l_buf_1_6.A a_13768_3932# 0.32815f
C120 a_12232_12216# VPWR 0.32132f
C121 a_9788_8728# sg13cmos5l_xor2_1_5.X 0.12039f
C122 a_14824_9192# sg13cmos5l_buf_1_14.X 0.31638f
C123 a_10292_4620# sg13cmos5l_buf_16_2.X 0.60365f
C124 sg13cmos5l_buf_16_7.X a_3694_3898# 0.04158f
C125 sg13cmos5l_buf_16_31.X a_4892_6168# 0.01885f
C126 a_5024_11586# VPWR 0.07029f
C127 sg13cmos5l_and2_2_4.B a_13667_12956# 0.3457f
C128 a_4174_13728# a_4052_12934# 0.09102f
C129 sg13cmos5l_xor2_1_7.X a_13916_11752# 0.12312f
C130 a_13768_7680# VPWR 0.2893f
C131 a_3694_14482# VPWR 2.16022f
C132 sg13cmos5l_xor2_1_6.X glitch_en[5] 0.31172f
C133 a_4052_12934# a_3872_13098# 0.0364f
C134 sg13cmos5l_buf_16_37.A VPWR 3.59246f
C135 sg13cmos5l_buf_16_30.A VPWR 3.58021f
C136 a_6836_9156# sg13cmos5l_and2_2_6.X 0.63904f
C137 VPWR out_xor[5] 0.17125f
C138 sg13cmos5l_and2_2_0.B sg13cmos5l_and2_2_1.B 0.02272f
C139 a_3875_5396# VPWR 0.53753f
C140 sg13cmos5l_buf_16_33.A a_6094_10704# 0.56942f
C141 a_13745_8484# a_13916_8728# 0.41432f
C142 sg13cmos5l_buf_16_19.A VPWR 1.02704f
C143 sg13cmos5l_and2_2_1.X a_4174_13728# 0.59389f
C144 sg13cmos5l_and2_2_2.B a_6548_13692# 0.01745f
C145 a_10292_4620# VPWR 2.19661f
C146 sg13cmos5l_buf_16_4.A VPWR 1.08341f
C147 a_5204_11422# a_6094_10704# 0.01302f
C148 sg13cmos5l_and2_2_3.B a_13667_12956# 0.03066f
C149 a_4840_11586# a_3694_10704# 0.01121f
C150 a_6161_12574# sg13cmos5l_buf_1_5.A 0.28216f
C151 a_6836_9156# VPWR 2.18576f
C152 sg13cmos5l_buf_16_15.X VPWR 3.80708f
C153 sg13cmos5l_buf_1_17.A a_13667_12956# 0.20977f
C154 sg13cmos5l_buf_16_27.X VPWR 3.24748f
C155 a_13916_8728# VPWR 0.2501f
C156 a_3668_12180# a_4840_11586# 0.0111f
C157 a_9160_7050# a_9344_7050# 0.11523f
C158 sg13cmos5l_buf_16_4.X sg13cmos5l_buf_16_38.A 0.01657f
C159 a_10318_5410# sg13cmos5l_buf_16_2.X 0.06715f
C160 sg13cmos5l_buf_16_10.A enable 0.01798f
C161 VPWR out_xor[6] 0.34181f
C162 a_7520_7766# VPWR 0.06633f
C163 sg13cmos5l_and2_2_3.B sg13cmos5l_and2_2_4.B 1.28156f
C164 sg13cmos5l_xor2_1_0.B a_8494_3144# 0.04705f
C165 a_14824_9192# out_xor[4] 0.2906f
C166 sg13cmos5l_buf_1_2.A a_8104_1632# 0.33391f
C167 a_3694_2386# a_5108_838# 0.01068f
C168 sg13cmos5l_buf_16_33.A sg13cmos5l_buf_16_15.A 0.28557f
C169 sg13cmos5l_buf_16_28.X a_5518_6922# 0.60574f
C170 a_3694_3898# a_3668_3108# 0.11845f
C171 a_5684_6132# VPWR 2.19361f
C172 sg13cmos5l_buf_1_5.A sg13cmos5l_buf_1_5.X 0.07387f
C173 sg13cmos5l_buf_1_23.A a_10318_8434# 0.01068f
C174 sg13cmos5l_buf_16_5.X a_3694_2386# 0.02416f
C175 sg13cmos5l_buf_16_18.A VPWR 3.41183f
C176 sg13cmos5l_buf_1_23.A a_6332_9192# 0.11764f
C177 sg13cmos5l_buf_16_15.A a_5204_11422# 0.08728f
C178 a_10318_5410# VPWR 2.23113f
C179 VPWR glitch_en[4] 0.51908f
C180 a_4721_6526# a_4892_6168# 0.41432f
C181 a_5684_6132# sg13cmos5l_buf_16_28.A 0.57749f
C182 sg13cmos5l_buf_16_24.X sg13cmos5l_buf_16_24.A 0.97297f
C183 sg13cmos5l_buf_1_5.A a_6094_10704# 0.06694f
C184 sg13cmos5l_buf_1_6.A a_8110_6168# 0.08151f
C185 sg13cmos5l_buf_16_2.A sg13cmos5l_buf_16_38.A 0.0609f
C186 sg13cmos5l_buf_16_31.X a_7220_5374# 0.04502f
C187 sg13cmos5l_buf_1_2.A sg13cmos5l_buf_16_5.A 0.02142f
C188 a_10318_8434# a_9262_7680# 0.05296f
C189 sg13cmos5l_and2_2_6.B sg13cmos5l_buf_16_19.A 0.07735f
C190 sg13cmos5l_and2_2_3.B sg13cmos5l_buf_1_17.A 0.15373f
C191 sg13cmos5l_buf_16_34.A a_3488_7766# 0.03873f
C192 a_8494_3144# VPWR 2.36415f
C193 a_7220_5374# a_6094_4656# 0.10281f
C194 a_4436_9910# sg13cmos5l_buf_16_14.A 1.37862f
C195 sg13cmos5l_buf_1_6.A VPWR 1.32349f
C196 sg13cmos5l_and2_2_0.B a_3694_10704# 0.10241f
C197 a_14824_13004# VPWR 0.35238f
C198 a_6094_3144# sg13cmos5l_buf_16_39.A 0.04852f
C199 sg13cmos5l_buf_16_0.A sg13cmos5l_buf_1_2.A 0.01892f
C200 sg13cmos5l_buf_16_13.A a_3694_8434# 0.59328f
C201 sg13cmos5l_buf_1_4.A a_14720_7050# 0.06202f
C202 a_3694_14482# sg13cmos5l_and2_2_1.X 0.04637f
C203 a_3668_9156# sg13cmos5l_buf_16_34.A 0.01721f
C204 sg13cmos5l_and2_2_1.B a_2147_13692# 0.32384f
C205 sg13cmos5l_and2_2_3.X a_13745_11508# 0.41175f
C206 sg13cmos5l_buf_16_3.X VPWR 3.33725f
C207 a_5992_14516# sg13cmos5l_and2_2_2.B 0.28895f
C208 sg13cmos5l_and2_2_0.B a_3694_8434# 0.09911f
C209 sg13cmos5l_and2_2_6.B a_6836_9156# 0.03085f
C210 VPWR out_xor[7] 0.11793f
C211 sg13cmos5l_and2_2_0.B enable 0.03211f
C212 sg13cmos5l_buf_1_6.A sg13cmos5l_buf_16_28.A 0.03007f
C213 sg13cmos5l_and2_2_0.B a_3668_12180# 0.0415f
C214 a_4840_1002# VPWR 0.15897f
C215 sg13cmos5l_and2_2_6.B sg13cmos5l_buf_16_27.X 0.17697f
C216 a_10292_4620# a_10318_3898# 0.10636f
C217 sg13cmos5l_buf_16_1.X a_9262_7680# 0.12317f
C218 sg13cmos5l_buf_1_15.X sg13cmos5l_buf_1_11.X 0.12637f
C219 sg13cmos5l_buf_1_6.A a_13768_5444# 0.03015f
C220 sg13cmos5l_buf_16_23.X a_10292_12934# 1.3557f
C221 sg13cmos5l_buf_16_20.A a_4436_9910# 0.59739f
C222 sg13cmos5l_buf_1_5.A a_7220_5374# 0.08615f
C223 a_9585_8752# VPWR 0.01075f
C224 a_13576_9278# VPWR 0.17901f
C225 sg13cmos5l_buf_16_15.A sg13cmos5l_buf_1_5.A 0.01552f
C226 a_7432_14516# VPWR 0.37103f
C227 sg13cmos5l_buf_16_33.A sg13cmos5l_buf_16_20.A 0.35529f
C228 sg13cmos5l_and2_2_0.B sg13cmos5l_buf_16_34.X 0.36276f
C229 sg13cmos5l_buf_16_34.X sg13cmos5l_buf_16_13.A 0.04031f
C230 a_6094_10704# sg13cmos5l_and2_2_6.A 0.01312f
C231 sg13cmos5l_buf_1_22.X VPWR 0.81402f
C232 a_15016_13814# VPWR 0.17302f
C233 a_9524_6886# a_8110_6168# 0.08261f
C234 sg13cmos5l_and2_2_3.X sg13cmos5l_buf_1_15.X 0.4028f
C235 sg13cmos5l_and2_2_0.B a_4174_13728# 0.02811f
C236 sg13cmos5l_buf_16_15.X sg13cmos5l_and2_2_1.X 0.03362f
C237 a_5992_14516# sg13cmos5l_buf_16_33.A 0.02447f
C238 VPWR glitch_en[6] 0.25899f
C239 a_11272_13728# a_11656_13814# 0.03269f
C240 a_5204_11422# sg13cmos5l_buf_16_20.A 1.35224f
C241 a_4840_11586# a_5024_11586# 0.11523f
C242 sg13cmos5l_buf_16_35.A a_7220_5374# 0.04702f
C243 sg13cmos5l_buf_16_1.X sg13cmos5l_buf_16_4.X 0.01916f
C244 a_9524_6886# VPWR 2.26726f
C245 sg13cmos5l_buf_16_18.A a_4052_12934# 0.58956f
C246 a_1864_13814# VPWR 0.18669f
C247 sg13cmos5l_and2_2_2.B VPWR 0.79676f
C248 a_6862_9946# a_6836_9156# 0.11845f
C249 a_10318_8434# sg13cmos5l_buf_16_2.A 0.01424f
C250 a_5504_1718# VPWR 0.09118f
C251 sg13cmos5l_buf_1_23.A sg13cmos5l_buf_16_6.X 0.01634f
C252 a_3694_7680# sg13cmos5l_buf_16_28.X 0.03692f
C253 sg13cmos5l_buf_16_5.X enable 0.0682f
C254 sg13cmos5l_and2_2_0.B sg13cmos5l_and2_2_0.X 0.02932f
C255 VPWR glitch_en[5] 0.56189f
C256 sg13cmos5l_xor2_1_6.X a_11924_13728# 0.11687f
C257 sg13cmos5l_buf_1_5.A sg13cmos5l_buf_16_14.A 0.01623f
C258 sg13cmos5l_buf_16_37.X a_8948_13692# 0.04878f
C259 a_4436_9910# VPWR 2.20521f
C260 a_5992_14516# glitch_en[2] 0.3193f
C261 sg13cmos5l_buf_16_6.X a_9262_7680# 0.19136f
C262 sg13cmos5l_buf_16_11.A enable 0.18868f
C263 sg13cmos5l_buf_16_22.X a_10318_8434# 1.30038f
C264 sg13cmos5l_buf_16_33.A VPWR 3.82114f
C265 sg13cmos5l_buf_16_24.A sg13cmos5l_buf_1_23.A 0.07703f
C266 sg13cmos5l_buf_1_2.X a_14720_1718# 0.06162f
C267 sg13cmos5l_and2_2_0.B a_4168_10074# 0.01107f
C268 a_10318_8434# sg13cmos5l_xor2_1_5.X 0.09679f
C269 sg13cmos5l_buf_16_1.X sg13cmos5l_buf_16_2.A 0.40813f
C270 sg13cmos5l_buf_1_5.A sg13cmos5l_buf_16_20.A 0.66173f
C271 sg13cmos5l_buf_16_25.A a_6766_8434# 0.59968f
C272 a_7432_14516# sg13cmos5l_and2_2_6.B 0.28895f
C273 a_5204_11422# VPWR 2.2217f
C274 VPWR glitch_en[3] 0.35942f
C275 sg13cmos5l_xor2_1_7.X a_14344_11492# 0.47839f
C276 a_3488_4026# VPWR 0.0906f
C277 sg13cmos5l_buf_1_11.X a_13581_9988# 0.0109f
C278 sg13cmos5l_buf_1_11.X VPWR 0.65656f
C279 a_13576_14516# glitch_en[5] 0.32083f
C280 a_4462_5410# sg13cmos5l_buf_16_11.A 1.38167f
C281 sg13cmos5l_buf_16_6.X sg13cmos5l_buf_16_4.X 0.2306f
C282 sg13cmos5l_buf_16_0.A a_8494_3144# 0.59332f
C283 a_3488_2514# VPWR 0.09599f
C284 sg13cmos5l_buf_16_31.X VPWR 8.3691f
C285 a_6161_9550# a_6836_9156# 0.03775f
C286 sg13cmos5l_and2_2_0.B a_3694_14482# 0.04212f
C287 sg13cmos5l_xor2_1_0.B sg13cmos5l_buf_16_7.X 0.09541f
C288 sg13cmos5l_and2_2_6.A sg13cmos5l_buf_16_14.A 0.82172f
C289 sg13cmos5l_buf_1_5.A sg13cmos5l_buf_16_2.X 0.01226f
C290 a_6765_12564# VPWR 0.55185f
C291 sg13cmos5l_and2_2_3.X VPWR 1.45253f
C292 sg13cmos5l_buf_16_39.A a_8538_2578# 0.13907f
C293 sg13cmos5l_buf_16_1.X sg13cmos5l_xor2_1_5.X 0.08525f
C294 sg13cmos5l_and2_2_3.X a_13581_9988# 0.2067f
C295 a_6094_4656# VPWR 2.2216f
C296 sg13cmos5l_and2_2_2.B sg13cmos5l_and2_2_6.B 0.08834f
C297 sg13cmos5l_buf_16_4.X a_9056_7766# 0.03947f
C298 sg13cmos5l_buf_16_31.X sg13cmos5l_buf_16_28.A 0.71633f
C299 VPWR glitch_en[2] 0.25432f
C300 sg13cmos5l_and2_2_0.B a_3875_5396# 0.35676f
C301 sg13cmos5l_and2_2_6.X a_7629_8028# 0.20614f
C302 sg13cmos5l_buf_1_4.A sg13cmos5l_buf_1_5.X 0.04309f
C303 a_11565_8028# VPWR 0.54864f
C304 sg13cmos5l_buf_16_8.A a_4462_5410# 0.02509f
C305 sg13cmos5l_and2_2_2.B a_4052_12934# 0.02708f
C306 sg13cmos5l_buf_1_5.A a_8110_6168# 0.0235f
C307 a_10292_12934# a_10112_13098# 0.0364f
C308 a_5710_1632# a_8000_1718# 0.0364f
C309 sg13cmos5l_and2_2_0.X sg13cmos5l_buf_16_11.A 0.01203f
C310 sg13cmos5l_buf_16_20.A sg13cmos5l_and2_2_6.A 0.08918f
C311 a_13472_8562# VPWR 0.07246f
C312 sg13cmos5l_buf_16_24.X a_6332_12216# 0.01208f
C313 a_13768_3932# sg13cmos5l_buf_1_1.A 0.28895f
C314 a_5504_6254# VPWR 0.06896f
C315 a_7336_7766# a_7520_7766# 0.11523f
C316 a_6094_3898# enable 0.60196f
C317 sg13cmos5l_and2_2_0.B sg13cmos5l_buf_16_15.X 0.46154f
C318 sg13cmos5l_buf_1_5.A VPWR 1.92919f
C319 sg13cmos5l_and2_2_5.B a_10318_8434# 0.06694f
C320 sg13cmos5l_buf_16_6.X sg13cmos5l_buf_16_2.A 0.51521f
C321 a_7629_8028# VPWR 0.53823f
C322 sg13cmos5l_and2_2_6.X sg13cmos5l_buf_16_35.A 0.25328f
C323 sg13cmos5l_buf_16_6.X enable 0.07018f
C324 sg13cmos5l_buf_16_7.X VPWR 3.98042f
C325 sg13cmos5l_buf_16_35.A a_8110_6168# 0.59238f
C326 VPWR glitch_en[1] 0.27918f
C327 sg13cmos5l_buf_16_24.X sg13cmos5l_buf_1_23.A 0.11536f
C328 sg13cmos5l_buf_16_8.A sg13cmos5l_and2_2_0.X 0.15414f
C329 sg13cmos5l_buf_16_33.A a_4052_12934# 0.10106f
C330 sg13cmos5l_buf_1_5.A sg13cmos5l_buf_16_28.A 0.10816f
C331 a_3488_9278# VPWR 0.0912f
C332 a_1480_14610# VPWR 0.15487f
C333 sg13cmos5l_and2_2_6.B glitch_en[3] 0.02138f
C334 sg13cmos5l_buf_16_30.A a_5108_838# 0.04844f
C335 sg13cmos5l_buf_1_5.A a_13768_5444# 0.32083f
C336 a_11272_13728# VPWR 0.32958f
C337 sg13cmos5l_buf_16_22.X sg13cmos5l_buf_16_6.X 0.01436f
C338 sg13cmos5l_buf_16_35.A VPWR 4.01559f
C339 sg13cmos5l_buf_1_5.X a_14824_5444# 0.32154f
C340 sg13cmos5l_and2_2_6.A sg13cmos5l_and2_2_6.X 0.01088f
C341 sg13cmos5l_buf_16_6.X sg13cmos5l_xor2_1_5.X 0.3132f
C342 sg13cmos5l_and2_2_5.B sg13cmos5l_buf_16_1.X 0.04162f
C343 sg13cmos5l_buf_16_5.X sg13cmos5l_buf_16_30.A 0.96409f
C344 a_14444_14442# sg13cmos5l_and2_2_4.B 0.28855f
C345 sg13cmos5l_buf_16_33.A sg13cmos5l_and2_2_1.X 0.01891f
C346 sg13cmos5l_xor2_1_0.B a_3668_3108# 0.09357f
C347 sg13cmos5l_buf_16_35.A sg13cmos5l_buf_16_28.A 0.07235f
C348 VPWR glitch_en[0] 0.2564f
C349 sg13cmos5l_buf_1_2.A a_5710_1632# 0.01532f
C350 sg13cmos5l_buf_1_6.A sg13cmos5l_buf_16_38.A 0.10554f
C351 sg13cmos5l_and2_2_6.A VPWR 3.53324f
C352 a_4721_6526# VPWR 0.25773f
C353 sg13cmos5l_buf_16_23.X VPWR 3.59721f
C354 sg13cmos5l_buf_1_1.A a_14824_3144# 0.32435f
C355 sg13cmos5l_buf_1_4.A a_14824_6956# 0.32396f
C356 a_3668_9156# a_3694_8434# 0.10636f
C357 a_8538_2578# a_8564_2680# 0.41432f
C358 a_14720_1718# VPWR 0.06899f
C359 sg13cmos5l_xor2_1_6.X a_14824_14516# 0.33574f
C360 a_13713_11776# VPWR 0.01143f
C361 a_8948_13692# a_7796_12934# 0.03601f
C362 sg13cmos5l_buf_16_30.A a_5710_1632# 0.59783f
C363 a_5320_6254# a_4462_5410# 0.0111f
C364 sg13cmos5l_and2_2_6.B sg13cmos5l_buf_1_5.A 0.03659f
C365 sg13cmos5l_and2_2_6.B a_7629_8028# 0.32979f
C366 sg13cmos5l_buf_16_8.A a_3875_5396# 0.02292f
C367 a_6129_9192# VPWR 0.01071f
C368 a_3668_3108# VPWR 2.21642f
C369 sg13cmos5l_buf_16_15.A a_6161_12574# 0.09713f
C370 sg13cmos5l_buf_16_34.X a_3668_9156# 0.12189f
C371 sg13cmos5l_buf_16_1.X sg13cmos5l_buf_16_4.A 0.25221f
C372 a_4462_5410# a_3668_4620# 0.02278f
C373 a_13288_13098# VPWR 0.15298f
C374 a_11924_13728# VPWR 0.25048f
C375 sg13cmos5l_xor2_1_4.X a_13745_8484# 0.27973f
C376 sg13cmos5l_buf_1_23.A sg13cmos5l_buf_16_25.A 0.10518f
C377 a_3680_5538# VPWR 0.06997f
C378 sg13cmos5l_and2_2_3.B sg13cmos5l_buf_16_22.X 0.13461f
C379 sg13cmos5l_and2_2_1.B a_2728_14610# 0.02116f
C380 a_8538_2578# sg13cmos5l_buf_1_2.A 0.25619f
C381 sg13cmos5l_and2_2_5.B sg13cmos5l_buf_16_6.X 0.30118f
C382 sg13cmos5l_buf_16_35.A a_9788_8728# 0.01007f
C383 a_3694_8434# sg13cmos5l_buf_16_34.A 1.38759f
C384 sg13cmos5l_and2_2_6.B sg13cmos5l_buf_16_35.A 0.09173f
C385 sg13cmos5l_buf_1_1.A out_xor[1] 0.02868f
C386 sg13cmos5l_buf_16_34.A enable 0.19787f
C387 a_11656_13814# a_10292_12934# 0.0111f
C388 a_5518_6922# VPWR 2.20951f
C389 sg13cmos5l_buf_16_37.X a_7796_12934# 1.35646f
C390 a_9617_8484# VPWR 0.25689f
C391 sg13cmos5l_buf_1_1.A VPWR 0.63635f
C392 sg13cmos5l_xor2_1_4.X VPWR 0.31551f
C393 a_14720_7050# VPWR 0.06713f
C394 sg13cmos5l_and2_2_0.X a_3668_4620# 0.06562f
C395 sg13cmos5l_buf_16_34.X a_3488_10790# 0.03947f
C396 sg13cmos5l_buf_1_23.A a_13664_7766# 0.06371f
C397 a_15016_2514# VPWR 0.18909f
C398 a_5518_6922# sg13cmos5l_buf_16_28.A 0.04023f
C399 a_3668_3108# a_3488_3230# 0.0364f
C400 sg13cmos5l_and2_2_6.B sg13cmos5l_and2_2_6.A 1.39849f
C401 sg13cmos5l_buf_16_15.X a_3488_14610# 0.03891f
C402 a_5108_838# a_4840_1002# 0.03513f
C403 sg13cmos5l_buf_16_34.X sg13cmos5l_buf_16_34.A 0.22378f
C404 sg13cmos5l_xor2_1_0.B a_3694_3898# 0.09815f
C405 a_14824_10704# out_xor[5] 0.29193f
C406 sg13cmos5l_xor2_1_6.X a_11656_13814# 0.02781f
C407 sg13cmos5l_buf_16_1.X a_10318_5410# 1.308f
C408 sg13cmos5l_buf_16_28.X VPWR 3.31459f
C409 sg13cmos5l_buf_1_17.X sg13cmos5l_buf_1_17.A 0.61222f
C410 a_3304_14610# VPWR 0.12842f
C411 sg13cmos5l_and2_2_0.B a_4436_9910# 0.01317f
C412 sg13cmos5l_buf_1_2.X a_14824_1632# 0.32525f
C413 a_4168_10074# a_3668_9156# 0.01121f
C414 sg13cmos5l_buf_16_6.X sg13cmos5l_buf_16_4.A 0.01449f
C415 a_15016_12302# out_xor[6] 0.01785f
C416 sg13cmos5l_and2_2_0.B sg13cmos5l_buf_16_33.A 0.09218f
C417 sg13cmos5l_buf_16_1.X sg13cmos5l_buf_1_6.A 0.13291f
C418 a_12040_12302# VPWR 0.1589f
C419 sg13cmos5l_buf_16_7.X sg13cmos5l_buf_16_10.A 0.34277f
C420 a_3694_3898# VPWR 2.18239f
C421 sg13cmos5l_and2_2_5.B sg13cmos5l_buf_1_17.A 0.0694f
C422 sg13cmos5l_buf_1_4.A VPWR 0.64538f
C423 a_6164_2350# VPWR 2.3734f
C424 sg13cmos5l_buf_16_22.X a_13768_9192# 0.03276f
C425 sg13cmos5l_buf_1_17.A a_12232_12216# 0.34673f
C426 sg13cmos5l_buf_16_24.A a_6836_9156# 0.07067f
C427 a_3875_5396# a_3668_4620# 0.01996f
C428 a_10112_13098# VPWR 0.08937f
C429 a_9617_8484# a_9788_8728# 0.41432f
C430 sg13cmos5l_buf_16_4.X a_9262_7680# 0.59824f
C431 sg13cmos5l_and2_2_0.B sg13cmos5l_buf_16_31.X 0.03244f
C432 sg13cmos5l_buf_1_5.A a_6161_9550# 0.03072f
C433 a_8872_7766# VPWR 0.14117f
C434 a_3020_14442# glitch_en[1] 0.3294f
C435 sg13cmos5l_buf_16_20.A a_6094_10704# 0.07462f
C436 sg13cmos5l_buf_1_5.A sg13cmos5l_buf_16_38.A 0.06922f
C437 sg13cmos5l_buf_16_1.X a_9524_6886# 0.04593f
C438 a_4892_6168# VPWR 0.25016f
C439 a_6161_12574# VPWR 0.28205f
C440 a_3694_7680# VPWR 2.20181f
C441 sg13cmos5l_buf_16_7.A a_3694_2386# 0.60365f
C442 sg13cmos5l_buf_1_23.A sg13cmos5l_buf_16_2.A 0.56518f
C443 a_2147_13692# a_1864_13814# 0.02801f
C444 a_6836_9156# a_6766_8434# 0.11005f
C445 a_14824_5444# VPWR 0.3443f
C446 sg13cmos5l_buf_16_6.X sg13cmos5l_buf_1_6.A 0.20265f
C447 sg13cmos5l_buf_1_15.X a_13745_11508# 0.0932f
C448 a_8948_13692# sg13cmos5l_buf_16_37.A 1.36525f
C449 sg13cmos5l_buf_16_2.A a_9262_7680# 1.31583f
C450 sg13cmos5l_buf_16_27.X sg13cmos5l_buf_1_17.A 0.01984f
C451 sg13cmos5l_and2_2_0.B glitch_en[1] 0.05412f
C452 sg13cmos5l_buf_16_24.X sg13cmos5l_buf_16_19.A 0.15593f
C453 a_14824_1632# out_xor[0] 0.2906f
C454 sg13cmos5l_buf_16_10.A a_3668_3108# 0.58078f
C455 a_14824_14516# VPWR 0.25132f
C456 sg13cmos5l_buf_16_22.X sg13cmos5l_buf_1_23.A 0.36982f
C457 sg13cmos5l_and2_2_6.A a_6161_9550# 0.41301f
C458 a_10292_12934# VPWR 2.43815f
C459 sg13cmos5l_buf_1_23.A sg13cmos5l_xor2_1_5.X 0.28998f
C460 sg13cmos5l_and2_2_3.X a_13916_11752# 0.0411f
C461 sg13cmos5l_buf_16_15.A sg13cmos5l_buf_16_20.A 0.0248f
C462 sg13cmos5l_buf_1_5.X VPWR 0.49496f
C463 sg13cmos5l_buf_16_37.X sg13cmos5l_buf_16_37.A 0.05825f
C464 a_8948_13692# sg13cmos5l_buf_16_27.X 0.01919f
C465 sg13cmos5l_buf_1_6.A a_5320_6254# 0.03264f
C466 sg13cmos5l_buf_16_31.X sg13cmos5l_buf_16_11.A 0.02473f
C467 a_6094_10704# VPWR 2.28634f
C468 a_14720_14610# glitch_en[6] 0.0593f
C469 a_10318_8434# a_11565_8028# 0.01862f
C470 sg13cmos5l_buf_16_2.A sg13cmos5l_buf_16_4.X 0.15012f
C471 a_3488_8562# VPWR 0.0906f
C472 sg13cmos5l_xor2_1_6.X VPWR 0.37136f
C473 sg13cmos5l_and2_2_0.B sg13cmos5l_and2_2_6.A 0.04362f
C474 a_13768_5444# sg13cmos5l_buf_1_5.X 0.30346f
C475 sg13cmos5l_buf_16_6.X a_9524_6886# 0.02103f
C476 sg13cmos5l_xor2_1_5.X a_14344_8468# 0.32083f
C477 a_3488_12302# VPWR 0.09436f
C478 sg13cmos5l_buf_16_8.A a_3488_4026# 0.03984f
C479 sg13cmos5l_buf_1_14.X a_14344_8468# 0.2906f
C480 a_14824_1632# VPWR 0.28396f
C481 sg13cmos5l_buf_16_31.X a_2147_13692# 0.16214f
C482 sg13cmos5l_buf_16_31.X sg13cmos5l_buf_16_8.A 0.34261f
C483 sg13cmos5l_buf_1_5.A a_6332_9192# 0.01742f
C484 a_8110_6168# a_7220_5374# 0.01174f
C485 sg13cmos5l_buf_16_37.X sg13cmos5l_buf_16_27.X 0.01149f
C486 sg13cmos5l_buf_16_7.X sg13cmos5l_buf_16_5.X 0.11611f
C487 a_8948_13692# glitch_en[4] 0.01359f
C488 sg13cmos5l_and2_2_4.B glitch_en[6] 0.07879f
C489 sg13cmos5l_buf_16_20.A sg13cmos5l_buf_16_14.A 0.05647f
C490 sg13cmos5l_buf_1_5.A sg13cmos5l_buf_16_11.A 0.02504f
C491 a_11656_13814# VPWR 0.14036f
C492 a_6548_13692# VPWR 2.33177f
C493 sg13cmos5l_buf_16_11.A sg13cmos5l_buf_16_7.X 0.16579f
C494 a_7220_5374# VPWR 2.28488f
C495 sg13cmos5l_buf_1_2.X VPWR 1.66681f
C496 sg13cmos5l_buf_16_15.A VPWR 4.69813f
C497 sg13cmos5l_and2_2_5.B sg13cmos5l_buf_1_23.A 0.03442f
C498 a_3668_12180# a_3694_10704# 0.01476f
C499 a_7336_7766# a_5518_6922# 0.01179f
C500 a_3694_8434# enable 0.01901f
C501 sg13cmos5l_buf_1_5.A sg13cmos5l_buf_16_1.X 0.11639f
C502 a_13745_11508# VPWR 0.26202f
C503 sg13cmos5l_buf_16_28.A a_7220_5374# 1.3501f
C504 a_13768_3932# VPWR 0.32923f
C505 a_3694_3898# sg13cmos5l_buf_16_10.A 1.35709f
C506 a_14824_10704# sg13cmos5l_buf_1_11.X 0.32342f
C507 sg13cmos5l_buf_1_23.A a_13768_7680# 0.31647f
C508 sg13cmos5l_buf_16_34.X a_3694_10704# 0.60416f
C509 a_14824_6956# VPWR 0.28083f
C510 a_8990_2704# VPWR 0.01392f
C511 sg13cmos5l_buf_16_22.X sg13cmos5l_buf_16_2.A 0.56045f
C512 a_6836_9156# sg13cmos5l_buf_16_25.A 1.33898f
C513 a_3020_14442# a_3304_14610# 0.01225f
C514 sg13cmos5l_and2_2_6.A a_6332_9192# 0.01857f
C515 sg13cmos5l_buf_16_34.X a_3694_8434# 0.04538f
C516 sg13cmos5l_and2_2_6.B a_6094_10704# 0.03779f
C517 sg13cmos5l_buf_16_34.X enable 0.09967f
C518 sg13cmos5l_xor2_1_5.X sg13cmos5l_buf_16_2.A 0.08672f
C519 sg13cmos5l_buf_16_39.A a_8564_2680# 0.01039f
C520 a_3694_2386# sg13cmos5l_buf_16_30.A 0.01901f
C521 a_6164_2350# a_5984_2514# 0.0364f
C522 a_6094_4656# a_6094_3898# 0.16971f
C523 sg13cmos5l_buf_1_15.X VPWR 0.62456f
C524 sg13cmos5l_buf_1_15.X a_13581_9988# 0.02518f
C525 a_4462_5410# enable 0.03748f
C526 sg13cmos5l_buf_16_14.A VPWR 3.59454f
C527 a_4436_9910# a_3668_9156# 0.08245f
C528 a_13667_12956# sg13cmos5l_and2_2_3.X 0.12024f
C529 sg13cmos5l_buf_16_6.X a_11565_8028# 0.11943f
C530 sg13cmos5l_and2_2_0.B sg13cmos5l_buf_16_28.X 0.02161f
C531 sg13cmos5l_buf_16_2.A a_10112_4026# 0.03947f
C532 sg13cmos5l_buf_1_22.X a_14344_11492# 0.2906f
C533 sg13cmos5l_buf_16_22.X sg13cmos5l_xor2_1_5.X 1.95837f
C534 a_6836_9156# sg13cmos5l_buf_1_23.A 0.05136f
C535 sg13cmos5l_buf_1_6.A a_13664_4026# 0.0605f
C536 a_6129_12216# VPWR 0.01187f
C537 sg13cmos5l_buf_16_39.A sg13cmos5l_buf_1_2.A 0.18425f
C538 sg13cmos5l_buf_16_8.A a_4721_6526# 0.08926f
C539 sg13cmos5l_and2_2_6.B a_6548_13692# 0.06386f
C540 a_14824_3144# out_xor[1] 0.29491f
C541 a_10112_4742# VPWR 0.11914f
C542 a_13288_13098# a_13472_13098# 0.11523f
C543 a_9262_7680# sg13cmos5l_buf_16_4.A 0.02662f
C544 sg13cmos5l_buf_1_5.A sg13cmos5l_buf_16_6.X 0.11541f
C545 sg13cmos5l_buf_16_20.A VPWR 3.46951f
C546 a_13480_7766# VPWR 0.1444f
C547 sg13cmos5l_and2_2_2.B sg13cmos5l_buf_16_24.X 0.48672f
C548 sg13cmos5l_and2_2_4.B sg13cmos5l_and2_2_3.X 0.11636f
C549 a_14824_3144# VPWR 0.35802f
C550 a_5992_14516# VPWR 0.32755f
C551 a_8104_1632# sg13cmos5l_buf_1_2.X 0.29665f
C552 a_4052_12934# sg13cmos5l_buf_16_15.A 1.35289f
C553 a_6094_10704# a_6862_9946# 0.06893f
C554 a_13768_9192# a_13576_9278# 0.01225f
C555 sg13cmos5l_and2_2_3.B sg13cmos5l_buf_1_11.X 0.09285f
C556 sg13cmos5l_xor2_1_0.B VPWR 4.55083f
C557 sg13cmos5l_buf_16_8.A a_3668_3108# 0.06722f
C558 VPWR out_xor[0] 0.24411f
C559 a_13288_8562# a_13472_8562# 0.11523f
C560 sg13cmos5l_buf_1_17.X a_11898_13691# 0.09901f
C561 sg13cmos5l_and2_2_5.B sg13cmos5l_buf_16_2.A 0.08626f
C562 sg13cmos5l_buf_1_5.A sg13cmos5l_buf_16_24.A 0.05088f
C563 sg13cmos5l_buf_16_35.A sg13cmos5l_buf_16_6.X 0.43237f
C564 sg13cmos5l_buf_16_2.X VPWR 3.63173f
C565 sg13cmos5l_buf_16_37.A a_7796_12934# 0.60505f
C566 sg13cmos5l_and2_2_3.B sg13cmos5l_and2_2_3.X 1.72467f
C567 sg13cmos5l_and2_2_0.X a_4462_5410# 0.58554f
C568 sg13cmos5l_buf_16_33.A sg13cmos5l_buf_16_24.X 0.02362f
C569 a_5320_6254# a_5504_6254# 0.11523f
C570 a_13745_8484# VPWR 0.25341f
C571 sg13cmos5l_and2_2_6.X VPWR 1.03785f
C572 a_8110_6168# VPWR 2.27374f
C573 sg13cmos5l_buf_16_34.X a_4168_10074# 0.01072f
C574 sg13cmos5l_buf_16_2.A a_13768_7680# 0.0137f
C575 sg13cmos5l_buf_16_5.A sg13cmos5l_buf_1_2.X 0.01003f
C576 a_9617_8484# sg13cmos5l_buf_16_1.X 0.03865f
C577 a_6094_3144# a_6164_2350# 0.11005f
C578 sg13cmos5l_buf_16_24.X a_5204_11422# 0.09942f
C579 sg13cmos5l_and2_2_5.B sg13cmos5l_buf_16_22.X 0.12068f
C580 a_3668_4620# sg13cmos5l_buf_16_7.X 0.07698f
C581 VPWR out_xor[1] 0.16973f
C582 sg13cmos5l_and2_2_5.B sg13cmos5l_xor2_1_5.X 0.03693f
C583 sg13cmos5l_and2_2_0.B a_3694_7680# 0.10296f
C584 sg13cmos5l_buf_1_14.X out_xor[4] 0.05788f
C585 a_13581_9988# VPWR 0.58194f
C586 sg13cmos5l_buf_1_5.A a_6766_8434# 0.01722f
C587 sg13cmos5l_buf_1_2.A a_8000_1718# 0.06036f
C588 a_6766_8434# a_7629_8028# 0.0173f
C589 sg13cmos5l_buf_16_2.A a_10292_4620# 0.09854f
C590 sg13cmos5l_buf_16_24.X a_6765_12564# 0.16526f
C591 sg13cmos5l_buf_16_28.X a_5224_7050# 0.04023f
C592 a_3668_9156# a_3488_9278# 0.0364f
C593 sg13cmos5l_buf_16_2.A sg13cmos5l_buf_16_4.A 0.06408f
C594 a_1672_14516# a_1480_14610# 0.01225f
C595 sg13cmos5l_buf_16_28.A VPWR 3.44031f
C596 sg13cmos5l_buf_16_5.X a_6164_2350# 0.06996f
C597 a_3694_14482# a_4174_13728# 0.11122f
C598 sg13cmos5l_buf_1_23.A a_13576_9278# 0.01191f
C599 a_13768_5444# VPWR 0.31796f
C600 sg13cmos5l_buf_16_11.A a_3694_3898# 0.06085f
C601 sg13cmos5l_buf_16_2.A a_13916_8728# 0.01007f
C602 sg13cmos5l_buf_1_2.A a_8564_2680# 0.11841f
C603 sg13cmos5l_and2_2_5.B sg13cmos5l_buf_1_17.X 0.03633f
C604 sg13cmos5l_buf_16_15.X a_3668_12180# 1.29121f
C605 a_4721_6526# a_5320_6254# 0.03572f
C606 a_6766_8434# sg13cmos5l_buf_16_35.A 1.32496f
C607 sg13cmos5l_buf_1_17.X a_12232_12216# 0.28827f
C608 a_3875_5396# a_4462_5410# 0.01061f
C609 a_1672_14516# glitch_en[0] 0.32815f
C610 a_3488_3230# VPWR 0.09182f
C611 sg13cmos5l_buf_16_24.X sg13cmos5l_buf_1_5.A 1.15165f
C612 a_13576_14516# VPWR 0.38177f
C613 sg13cmos5l_buf_16_4.X sg13cmos5l_buf_1_6.A 0.02903f
C614 sg13cmos5l_buf_1_11.X a_13768_9192# 0.28895f
C615 sg13cmos5l_and2_2_6.A a_3668_9156# 0.03335f
C616 sg13cmos5l_buf_16_6.X a_5518_6922# 1.29726f
C617 sg13cmos5l_buf_16_8.A a_3694_3898# 0.59597f
C618 sg13cmos5l_buf_16_6.X a_9617_8484# 0.40244f
C619 a_8494_3144# sg13cmos5l_buf_16_39.A 1.31212f
C620 sg13cmos5l_and2_2_3.X sg13cmos5l_xor2_1_7.X 0.25384f
C621 sg13cmos5l_buf_16_22.X a_13916_8728# 0.01748f
C622 sg13cmos5l_and2_2_6.B sg13cmos5l_and2_2_6.X 0.52752f
C623 sg13cmos5l_buf_16_13.A a_3488_8562# 0.03984f
C624 sg13cmos5l_and2_2_6.A a_6766_8434# 0.08192f
C625 a_3304_14610# a_3488_14610# 0.11523f
C626 a_5684_6132# enable 0.03759f
C627 sg13cmos5l_buf_16_27.X a_11898_13691# 0.39734f
C628 a_6164_2350# a_5710_1632# 0.1456f
C629 sg13cmos5l_buf_16_2.X a_10318_3898# 1.35325f
C630 sg13cmos5l_buf_16_2.A a_10318_5410# 0.07019f
C631 a_9262_7680# a_9524_6886# 0.11493f
C632 a_15104_11586# VPWR 0.10628f
C633 a_3875_5396# sg13cmos5l_and2_2_0.X 0.24451f
C634 sg13cmos5l_buf_16_38.A a_7220_5374# 0.60329f
C635 a_9788_8728# VPWR 0.2502f
C636 a_14824_9192# VPWR 0.35601f
C637 sg13cmos5l_and2_2_6.B VPWR 1.30461f
C638 sg13cmos5l_buf_16_2.A a_8494_3144# 0.04102f
C639 a_4052_12934# VPWR 2.25691f
C640 a_8104_1632# VPWR 0.29835f
C641 a_9160_7050# a_8110_6168# 0.01121f
C642 a_3694_7680# a_5224_7050# 0.0111f
C643 sg13cmos5l_buf_16_2.A sg13cmos5l_buf_1_6.A 0.11062f
C644 sg13cmos5l_xor2_1_0.B sg13cmos5l_buf_16_0.A 0.07085f
C645 sg13cmos5l_buf_1_6.A enable 0.08823f
C646 sg13cmos5l_buf_16_27.X sg13cmos5l_buf_1_17.X 0.29224f
C647 a_5684_6132# a_4462_5410# 0.07914f
C648 a_8948_13692# sg13cmos5l_buf_16_23.X 0.60166f
C649 sg13cmos5l_buf_16_8.A a_4892_6168# 0.0119f
C650 a_4174_13728# sg13cmos5l_buf_16_18.A 1.34828f
C651 sg13cmos5l_buf_16_2.A sg13cmos5l_buf_16_3.X 0.63963f
C652 sg13cmos5l_and2_2_0.B sg13cmos5l_buf_16_15.A 0.16747f
C653 sg13cmos5l_buf_16_4.X a_9524_6886# 1.31676f
C654 a_10318_3898# VPWR 2.3717f
C655 a_9160_7050# VPWR 0.14626f
C656 sg13cmos5l_and2_2_1.X VPWR 0.89978f
C657 sg13cmos5l_buf_16_14.A a_6161_9550# 0.09488f
C658 a_6862_9946# sg13cmos5l_and2_2_6.X 0.06867f
C659 sg13cmos5l_and2_2_5.B sg13cmos5l_buf_16_4.A 0.05274f
C660 a_14536_1718# a_14720_1718# 0.11523f
C661 sg13cmos5l_buf_16_5.A VPWR 3.52829f
C662 sg13cmos5l_and2_2_1.B sg13cmos5l_buf_16_31.X 0.34018f
C663 sg13cmos5l_xor2_1_0.B sg13cmos5l_buf_16_10.A 0.07973f
C664 sg13cmos5l_buf_1_5.A sg13cmos5l_buf_16_25.A 0.17975f
C665 sg13cmos5l_buf_1_6.A out_xor[2] 0.01522f
C666 sg13cmos5l_buf_16_0.A VPWR 3.42302f
C667 a_6862_9946# VPWR 2.22069f
C668 a_14444_14442# glitch_en[6] 0.3343f
C669 sg13cmos5l_buf_1_5.A a_6332_12216# 0.13668f
C670 sg13cmos5l_buf_16_22.X a_13576_9278# 0.029f
C671 sg13cmos5l_buf_16_14.A sg13cmos5l_buf_16_13.A 0.04248f
C672 sg13cmos5l_buf_16_2.A a_9524_6886# 0.08504f
C673 sg13cmos5l_buf_16_15.X a_3694_14482# 0.58973f
C674 sg13cmos5l_and2_2_0.B sg13cmos5l_buf_16_14.A 0.05999f
C675 a_3668_4620# a_3694_3898# 0.10636f
C676 a_8872_7766# a_9056_7766# 0.11523f
C677 a_4840_11586# VPWR 0.14257f
C678 sg13cmos5l_buf_1_5.A sg13cmos5l_buf_1_23.A 0.20092f
C679 a_13745_11508# a_13916_11752# 0.41432f
C680 sg13cmos5l_buf_16_27.X sg13cmos5l_buf_16_37.A 0.01837f
C681 sg13cmos5l_buf_16_7.X a_3694_2386# 1.29387f
C682 sg13cmos5l_buf_16_10.A VPWR 3.29346f
C683 sg13cmos5l_and2_2_5.B glitch_en[4] 0.01102f
C684 sg13cmos5l_buf_1_11.X a_14252_9906# 0.01058f
C685 a_3496_5538# a_3680_5538# 0.11523f
C686 a_3694_10704# a_4436_9910# 0.11802f
C687 a_5984_2514# VPWR 0.08893f
C688 sg13cmos5l_buf_1_17.A a_12040_12302# 0.0752f
C689 sg13cmos5l_buf_16_33.A a_3694_10704# 0.0635f
C690 sg13cmos5l_and2_2_6.A sg13cmos5l_buf_16_25.A 0.17432f
C691 a_15104_6254# VPWR 0.07861f
C692 sg13cmos5l_and2_2_3.X a_14252_9906# 0.32803f
C693 sg13cmos5l_and2_2_2.B a_4174_13728# 0.02449f
C694 sg13cmos5l_buf_1_23.A sg13cmos5l_buf_16_35.A 0.05149f
C695 a_3488_4742# VPWR 0.09077f
C696 sg13cmos5l_and2_2_0.B sg13cmos5l_xor2_1_0.B 0.11158f
C697 a_5204_11422# a_3694_10704# 0.0753f
C698 sg13cmos5l_buf_1_15.X a_13916_11752# 0.0104f
C699 sg13cmos5l_and2_2_1.X a_4052_12934# 0.05773f
C700 a_8110_6168# sg13cmos5l_buf_16_38.A 1.37076f
C701 sg13cmos5l_buf_16_33.A a_3668_12180# 0.06578f
C702 a_6161_9550# VPWR 0.24738f
C703 a_3020_14442# VPWR 0.2983f
C704 sg13cmos5l_buf_16_5.A a_8104_1632# 0.01756f
C705 sg13cmos5l_buf_16_35.A a_9262_7680# 0.01786f
C706 sg13cmos5l_buf_16_34.X a_4436_9910# 0.04037f
C707 a_13713_8752# VPWR 0.01071f
C708 a_9524_6886# a_9344_7050# 0.0364f
C709 a_13768_9192# sg13cmos5l_xor2_1_4.X 0.3343f
C710 sg13cmos5l_buf_16_14.A a_6332_9192# 0.01047f
C711 sg13cmos5l_and2_2_6.B a_6862_9946# 0.06015f
C712 sg13cmos5l_and2_2_6.A sg13cmos5l_buf_1_23.A 1.54168f
C713 sg13cmos5l_buf_16_38.A VPWR 3.58741f
C714 a_10318_5410# a_10292_4620# 0.11845f
C715 a_7336_7766# VPWR 0.13993f
C716 sg13cmos5l_buf_16_7.A a_3488_2514# 0.03984f
C717 a_14536_7050# a_14720_7050# 0.11523f
C718 sg13cmos5l_xor2_1_6.X a_14720_14610# 0.06165f
C719 sg13cmos5l_buf_16_33.A a_4174_13728# 0.04993f
C720 sg13cmos5l_buf_16_31.X enable 0.21341f
C721 sg13cmos5l_xor2_1_0.B a_6094_3144# 1.38279f
C722 sg13cmos5l_buf_16_18.A sg13cmos5l_buf_16_27.X 0.02887f
C723 sg13cmos5l_buf_16_28.A sg13cmos5l_buf_16_38.A 0.02729f
C724 sg13cmos5l_buf_16_27.X glitch_en[4] 0.16933f
C725 sg13cmos5l_buf_16_13.A VPWR 3.42331f
C726 sg13cmos5l_and2_2_0.B VPWR 1.81081f
C727 sg13cmos5l_buf_1_11.X sg13cmos5l_buf_16_22.X 0.09605f
C728 a_6094_4656# enable 0.07554f
C729 a_6094_10704# sg13cmos5l_buf_16_24.A 1.34755f
C730 sg13cmos5l_buf_16_2.A a_11565_8028# 0.05627f
C731 sg13cmos5l_buf_16_35.A sg13cmos5l_buf_16_4.X 0.08106f
C732 sg13cmos5l_buf_1_5.A a_13664_5538# 0.0605f
C733 a_3668_3108# a_3694_2386# 0.10636f
C734 a_3968_13814# VPWR 0.09124f
C735 sg13cmos5l_buf_16_4.A sg13cmos5l_buf_1_6.A 0.01133f
C736 sg13cmos5l_buf_16_3.X a_10292_4620# 1.35625f
C737 sg13cmos5l_buf_16_2.A a_13472_8562# 0.03915f
C738 sg13cmos5l_xor2_1_6.X sg13cmos5l_and2_2_4.B 0.07112f
C739 sg13cmos5l_buf_16_31.X a_4462_5410# 0.03294f
C740 sg13cmos5l_xor2_1_0.B sg13cmos5l_buf_16_5.X 0.06102f
C741 sg13cmos5l_buf_1_5.A sg13cmos5l_buf_16_2.A 0.03559f
C742 sg13cmos5l_buf_16_34.A a_3694_7680# 0.59333f
C743 sg13cmos5l_buf_1_5.A enable 0.38651f
C744 a_6094_3144# VPWR 2.21415f
C745 a_14824_13004# out_xor[6] 0.28827f
C746 sg13cmos5l_buf_16_24.X a_6161_12574# 0.4406f
C747 sg13cmos5l_buf_16_7.X sg13cmos5l_buf_16_7.A 0.01656f
C748 a_10292_12934# sg13cmos5l_buf_1_17.A 0.60142f
C749 a_4436_9910# a_4168_10074# 0.03513f
C750 sg13cmos5l_buf_16_7.X enable 0.30626f
C751 sg13cmos5l_buf_1_4.A a_14536_7050# 0.01352f
C752 sg13cmos5l_buf_1_5.A sg13cmos5l_buf_16_34.X 0.06162f
C753 a_5108_838# VPWR 2.21571f
C754 sg13cmos5l_buf_1_6.A a_5684_6132# 0.04843f
C755 sg13cmos5l_xor2_1_6.X sg13cmos5l_and2_2_3.B 0.02572f
C756 a_13916_11752# VPWR 0.25248f
C757 sg13cmos5l_buf_16_31.X sg13cmos5l_and2_2_0.X 0.06722f
C758 a_8948_13692# a_10292_12934# 0.02189f
C759 sg13cmos5l_buf_1_6.A a_10318_5410# 0.01092f
C760 sg13cmos5l_buf_16_30.A a_5504_1718# 0.03802f
C761 sg13cmos5l_and2_2_2.B sg13cmos5l_buf_16_19.A 0.02389f
C762 sg13cmos5l_buf_16_8.A sg13cmos5l_xor2_1_0.B 0.71967f
C763 a_10318_8434# VPWR 2.25886f
C764 sg13cmos5l_buf_1_22.X out_xor[6] 0.11867f
C765 a_6332_9192# VPWR 0.2502f
C766 sg13cmos5l_buf_16_5.X VPWR 3.97753f
C767 sg13cmos5l_buf_16_4.A a_9524_6886# 0.60079f
C768 a_4462_5410# sg13cmos5l_buf_16_7.X 0.07695f
C769 sg13cmos5l_buf_16_3.X a_10318_5410# 0.5778f
C770 a_3694_10704# sg13cmos5l_and2_2_6.A 1.29316f
C771 a_13472_13098# VPWR 0.07435f
C772 sg13cmos5l_xor2_1_4.X a_14344_8468# 0.17071f
C773 a_12350_13728# VPWR 0.01075f
C774 a_3694_14482# sg13cmos5l_buf_16_33.A 1.29313f
C775 sg13cmos5l_buf_16_11.A VPWR 3.31013f
C776 a_5204_11422# a_5024_11586# 0.0364f
C777 sg13cmos5l_buf_16_24.X a_6094_10704# 0.08668f
C778 sg13cmos5l_and2_2_2.B sg13cmos5l_buf_16_27.X 0.03461f
C779 sg13cmos5l_and2_2_0.B a_4052_12934# 0.02996f
C780 a_5224_7050# VPWR 0.18957f
C781 sg13cmos5l_buf_16_1.X VPWR 4.06045f
C782 a_2147_13692# VPWR 0.58381f
C783 sg13cmos5l_and2_2_3.B a_13745_11508# 0.05072f
C784 sg13cmos5l_buf_16_8.A VPWR 3.97299f
C785 sg13cmos5l_and2_2_5.B a_11565_8028# 0.34969f
C786 sg13cmos5l_buf_16_34.X sg13cmos5l_and2_2_6.A 0.11262f
C787 a_5710_1632# VPWR 2.23524f
C788 a_3668_3108# sg13cmos5l_buf_16_7.A 1.35325f
C789 sg13cmos5l_buf_16_19.A a_5204_11422# 0.61423f
C790 sg13cmos5l_and2_2_0.B sg13cmos5l_and2_2_1.X 1.29196f
C791 sg13cmos5l_and2_2_1.X a_3968_13814# 0.03802f
C792 sg13cmos5l_and2_2_2.B sg13cmos5l_buf_16_18.A 0.33148f
C793 sg13cmos5l_xor2_1_0.B a_8538_2578# 0.41585f
C794 sg13cmos5l_buf_1_22.X a_14824_13004# 0.33441f
C795 a_3694_14482# glitch_en[2] 0.04742f
C796 sg13cmos5l_buf_16_20.A sg13cmos5l_buf_16_24.A 0.05491f
C797 a_6765_12564# sg13cmos5l_buf_16_19.A 0.22946f
C798 sg13cmos5l_and2_2_3.X out_xor[5] 0.01429f
C799 a_6161_12574# a_6332_12216# 0.41432f
C800 a_3488_14610# VPWR 0.07233f
C801 sg13cmos5l_buf_16_15.A sg13cmos5l_buf_16_24.X 0.2915f
C802 sg13cmos5l_buf_16_27.X glitch_en[3] 0.07238f
C803 sg13cmos5l_buf_16_14.A a_3668_9156# 0.64891f
C804 sg13cmos5l_buf_1_2.X a_14536_1718# 0.01156f
C805 sg13cmos5l_and2_2_3.B sg13cmos5l_buf_1_15.X 0.52491f
C806 glitch_en[5] glitch_en[4] 0.01599f
C807 a_5518_6922# enable 0.0778f
C808 a_9524_6886# sg13cmos5l_buf_1_6.A 0.03358f
C809 a_11898_13691# a_11924_13728# 0.41432f
C810 a_15016_12302# VPWR 0.17765f
C811 a_11272_13728# sg13cmos5l_and2_2_5.B 0.2906f
C812 a_6548_13692# sg13cmos5l_buf_16_37.X 0.61804f
C813 sg13cmos5l_buf_16_33.A sg13cmos5l_buf_16_18.A 0.27302f
C814 a_6094_3898# VPWR 2.18569f
C815 a_11565_8028# sg13cmos5l_buf_16_4.A 0.23562f
C816 a_14824_10704# VPWR 0.36546f
C817 a_8538_2578# VPWR 0.31462f
C818 sg13cmos5l_buf_16_6.X VPWR 3.62483f
C819 a_14720_14610# VPWR 0.07393f
C820 sg13cmos5l_buf_16_7.X sg13cmos5l_buf_16_30.A 0.02417f
C821 sg13cmos5l_buf_16_0.A a_6094_3144# 0.0535f
C822 sg13cmos5l_buf_16_22.X sg13cmos5l_xor2_1_4.X 0.30347f
C823 sg13cmos5l_xor2_1_0.B a_3668_4620# 0.05748f
C824 sg13cmos5l_buf_16_5.A a_5108_838# 0.60418f
C825 sg13cmos5l_buf_1_5.A a_10292_4620# 0.02645f
C826 sg13cmos5l_buf_16_39.A a_6164_2350# 0.61093f
C827 a_9617_8484# sg13cmos5l_xor2_1_5.X 0.27638f
C828 a_13667_12956# VPWR 0.57944f
C829 sg13cmos5l_xor2_1_4.X sg13cmos5l_xor2_1_5.X 0.11647f
C830 sg13cmos5l_buf_16_28.X enable 0.19046f
C831 sg13cmos5l_xor2_1_4.X sg13cmos5l_buf_1_14.X 0.07575f
C832 sg13cmos5l_buf_16_14.A sg13cmos5l_buf_16_34.A 0.02288f
C833 sg13cmos5l_buf_16_31.X a_5684_6132# 0.10772f
C834 sg13cmos5l_buf_1_17.X a_11924_13728# 0.0146f
C835 sg13cmos5l_buf_1_5.A a_6836_9156# 0.01433f
C836 sg13cmos5l_buf_16_23.X sg13cmos5l_and2_2_5.B 0.15555f
C837 a_13745_11508# sg13cmos5l_xor2_1_7.X 0.31422f
C838 sg13cmos5l_buf_16_5.X sg13cmos5l_buf_16_5.A 0.04292f
C839 a_9056_7766# VPWR 0.07114f
C840 sg13cmos5l_buf_16_24.A VPWR 3.4423f
C841 a_5684_6132# a_6094_4656# 0.01391f
C842 sg13cmos5l_buf_16_15.X glitch_en[1] 0.0108f
C843 a_13288_8562# VPWR 0.14746f
C844 sg13cmos5l_and2_2_4.B VPWR 0.56188f
C845 a_5320_6254# VPWR 0.12411f
C846 a_3694_3898# enable 0.0447f
C847 a_3488_7766# VPWR 0.09155f
C848 sg13cmos5l_buf_16_28.X a_4462_5410# 0.01022f
C849 a_2147_13692# sg13cmos5l_and2_2_1.X 0.20607f
C850 sg13cmos5l_buf_16_24.X sg13cmos5l_buf_16_20.A 0.02488f
C851 sg13cmos5l_and2_2_6.X a_6766_8434# 0.09025f
C852 a_3668_4620# VPWR 2.19054f
C853 sg13cmos5l_buf_16_31.X sg13cmos5l_buf_1_6.A 3.07383f
C854 sg13cmos5l_buf_16_23.X sg13cmos5l_buf_16_37.A 0.05906f
C855 a_5684_6132# a_5504_6254# 0.0364f
C856 sg13cmos5l_buf_1_5.A a_5684_6132# 0.05981f
C857 a_3668_9156# VPWR 2.23415f
C858 a_1672_14516# VPWR 0.29473f
C859 a_7432_14516# glitch_en[3] 0.3298f
C860 a_5710_1632# sg13cmos5l_buf_16_5.A 1.35923f
C861 sg13cmos5l_buf_1_5.A a_10318_5410# 0.08431f
C862 a_6766_8434# VPWR 2.27655f
C863 sg13cmos5l_buf_16_10.A sg13cmos5l_buf_16_5.X 0.07581f
C864 sg13cmos5l_buf_16_15.A a_6332_12216# 0.01075f
C865 sg13cmos5l_and2_2_3.B a_13581_9988# 0.35683f
C866 sg13cmos5l_and2_2_3.B VPWR 0.83061f
C867 sg13cmos5l_and2_2_0.B sg13cmos5l_buf_16_13.A 0.22654f
C868 sg13cmos5l_and2_2_6.A a_6836_9156# 0.0425f
C869 sg13cmos5l_xor2_1_5.X sg13cmos5l_buf_1_4.A 0.02144f
C870 sg13cmos5l_buf_1_17.A VPWR 1.96287f
C871 sg13cmos5l_buf_16_6.X a_9788_8728# 0.0156f
C872 sg13cmos5l_buf_16_33.A sg13cmos5l_and2_2_2.B 0.13567f
C873 a_3694_8434# a_3694_7680# 0.18924f
C874 a_3694_7680# enable 0.08956f
C875 sg13cmos5l_and2_2_6.A a_7520_7766# 0.04565f
C876 sg13cmos5l_buf_1_5.A sg13cmos5l_buf_1_6.A 0.66641f
C877 a_11272_13728# glitch_en[4] 0.33094f
C878 sg13cmos5l_and2_2_3.X sg13cmos5l_buf_1_22.X 0.1233f
C879 a_3488_10790# VPWR 0.09212f
C880 a_3875_5396# a_3680_5538# 0.02895f
C881 sg13cmos5l_buf_1_5.A sg13cmos5l_buf_16_3.X 0.04869f
C882 a_8948_13692# VPWR 2.35913f
C883 a_6161_9550# a_6332_9192# 0.41432f
C884 sg13cmos5l_buf_16_34.A VPWR 3.39664f
C885 sg13cmos5l_and2_2_6.B sg13cmos5l_buf_16_24.A 0.39943f
C886 sg13cmos5l_buf_16_24.X VPWR 3.80931f
C887 a_14536_1718# VPWR 0.14079f
C888 sg13cmos5l_buf_16_34.X a_3694_7680# 1.2948f
C889 a_13576_14516# sg13cmos5l_and2_2_3.B 0.28895f
C890 a_14444_14442# a_14824_14516# 0.07249f
C891 sg13cmos5l_buf_16_35.A sg13cmos5l_buf_1_6.A 0.048f
C892 a_14344_11492# VPWR 0.27112f
C893 sg13cmos5l_and2_2_2.B a_6765_12564# 0.32482f
C894 sg13cmos5l_buf_16_27.X a_11924_13728# 0.01187f
C895 a_6094_3898# sg13cmos5l_buf_16_0.A 1.29491f
C896 sg13cmos5l_buf_16_23.X glitch_en[4] 0.07155f
C897 a_14824_5444# out_xor[2] 0.28895f
C898 sg13cmos5l_buf_16_33.A a_5204_11422# 0.09991f
C899 a_12232_12216# a_12040_12302# 0.01225f
C900 sg13cmos5l_buf_16_37.X VPWR 3.61055f
C901 a_3496_5538# VPWR 0.14367f
C902 a_6164_2350# sg13cmos5l_buf_1_2.A 0.03691f
C903 sg13cmos5l_xor2_1_4.X a_13916_8728# 0.14436f
C904 a_4721_6526# sg13cmos5l_buf_1_6.A 0.25855f
C905 a_14444_14442# sg13cmos5l_xor2_1_6.X 0.01484f
C906 sg13cmos5l_and2_2_6.B a_6766_8434# 0.02917f
C907 sg13cmos5l_xor2_1_7.X VPWR 0.18445f
C908 a_6548_13692# a_7796_12934# 0.02845f
C909 sg13cmos5l_buf_16_39.A sg13cmos5l_buf_1_2.X 0.1683f
C910 a_13768_9192# VPWR 0.30285f
C911 a_13664_4026# VPWR 0.11601f
C912 a_6094_3898# sg13cmos5l_buf_16_10.A 0.0117f
C913 a_13768_7680# sg13cmos5l_buf_1_4.A 0.2906f
C914 a_13480_7766# a_13664_7766# 0.11523f
C915 a_3668_12180# a_3488_12302# 0.0364f
C916 sg13cmos5l_buf_16_24.A a_6862_9946# 0.64114f
C917 sg13cmos5l_buf_1_23.A a_13480_7766# 0.01787f
C918 a_14536_7050# VPWR 0.15149f
C919 sg13cmos5l_buf_16_33.A glitch_en[2] 0.04109f
C920 sg13cmos5l_buf_16_5.X a_6094_3144# 0.60219f
C921 a_5518_6922# a_5684_6132# 0.1301f
C922 sg13cmos5l_and2_2_6.X sg13cmos5l_buf_16_25.A 0.06995f
C923 a_6164_2350# sg13cmos5l_buf_16_30.A 1.30149f
C924 sg13cmos5l_buf_1_5.A a_4436_9910# 0.02951f
C925 sg13cmos5l_and2_2_0.B sg13cmos5l_buf_16_8.A 0.33009f
C926 sg13cmos5l_and2_2_3.X sg13cmos5l_buf_1_11.X 0.72392f
C927 sg13cmos5l_xor2_1_6.X a_11898_13691# 0.25068f
C928 sg13cmos5l_buf_16_37.A a_10112_13098# 0.0395f
C929 sg13cmos5l_buf_1_17.X a_10292_12934# 0.02699f
C930 sg13cmos5l_buf_1_15.X a_14252_9906# 0.29175f
C931 sg13cmos5l_and2_2_6.B sg13cmos5l_buf_16_24.X 0.19178f
C932 sg13cmos5l_buf_16_33.A sg13cmos5l_buf_1_5.A 0.05981f
C933 sg13cmos5l_buf_16_5.X a_5108_838# 1.30812f
C934 sg13cmos5l_buf_16_31.X a_6094_4656# 1.32148f
C935 sg13cmos5l_buf_16_25.A VPWR 3.49809f
C936 sg13cmos5l_buf_16_15.A a_3668_12180# 0.65407f
C937 a_2728_14610# VPWR 0.19157f
C938 sg13cmos5l_buf_16_28.X a_5684_6132# 1.33308f
C939 a_5518_6922# sg13cmos5l_buf_1_6.A 0.03307f
C940 sg13cmos5l_buf_1_5.A a_5204_11422# 0.05441f
C941 sg13cmos5l_and2_2_6.X sg13cmos5l_buf_1_23.A 1.07723f
C942 a_6332_12216# VPWR 0.25565f
C943 a_11898_13691# a_11656_13814# 0.03572f
C944 a_4174_13728# a_6548_13692# 0.03943f
C945 sg13cmos5l_and2_2_6.B sg13cmos5l_buf_16_37.X 0.10099f
C946 a_15016_4742# VPWR 0.17315f
C947 sg13cmos5l_buf_16_31.X sg13cmos5l_buf_1_5.A 0.21786f
C948 sg13cmos5l_and2_2_5.B a_10292_12934# 0.07247f
C949 a_13664_7766# VPWR 0.06268f
C950 a_3694_2386# VPWR 2.5039f
C951 sg13cmos5l_buf_1_5.A a_6765_12564# 0.14745f
C952 sg13cmos5l_buf_1_23.A VPWR 1.06085f
C953 sg13cmos5l_buf_16_31.X sg13cmos5l_buf_16_7.X 0.03114f
C954 sg13cmos5l_and2_2_1.B VPWR 0.55699f
C955 sg13cmos5l_and2_2_6.A a_4436_9910# 0.09428f
C956 a_5710_1632# a_5108_838# 0.03594f
C957 out_xor[0] VGND 0.71386f
C958 out_xor[1] VGND 0.93353f
C959 out_xor[2] VGND 0.96802f
C960 out_xor[3] VGND 0.86148f
C961 out_xor[4] VGND 0.73784f
C962 out_xor[5] VGND 0.90254f
C963 out_xor[6] VGND 0.86015f
C964 out_xor[7] VGND 2.27746f
C965 VPWR VGND 0.3655p
C966 a_4840_1002# VGND 0.13795f ; **FLOATING
C967 a_14720_1718# VGND 0.03807f ; **FLOATING
C968 a_14536_1718# VGND 0.14395f ; **FLOATING
C969 a_14824_1632# VGND 0.84946f
C970 a_8000_1718# VGND 0.04237f ; **FLOATING
C971 a_8104_1632# VGND 1.83087f
C972 a_5504_1718# VGND 0.08397f ; **FLOATING
C973 a_15016_2514# VGND 0.13827f ; **FLOATING
C974 a_8694_2398# VGND 5.25366f
C975 a_8564_2680# VGND 0.13885f
C976 sg13cmos5l_buf_1_2.A VGND 0.11108f
C977 a_5984_2514# VGND 0.04276f ; **FLOATING
C978 a_3488_2514# VGND 0.09056f ; **FLOATING
C979 a_3488_3230# VGND 0.0912f ; **FLOATING
C980 sg13cmos5l_buf_1_1.A VGND 0.74158f
C981 a_13664_4026# VGND 0.06838f ; **FLOATING
C982 a_10112_4026# VGND 0.06173f ; **FLOATING
C983 a_3488_4026# VGND 0.09308f ; **FLOATING
C984 a_15016_4742# VGND 0.14702f ; **FLOATING
C985 a_10112_4742# VGND 0.05947f ; **FLOATING
C986 a_3488_4742# VGND 0.09072f ; **FLOATING
C987 sg13cmos5l_buf_1_5.X VGND 1.05782f
C988 a_13664_5538# VGND 0.06047f ; **FLOATING
C989 a_4105_5452# VGND 1.25593f
C990 a_3680_5538# VGND 0.04608f ; **FLOATING
C991 a_3496_5538# VGND 0.14382f ; **FLOATING
C992 a_15104_6254# VGND 0.12253f ; **FLOATING
C993 a_5504_6254# VGND 0.03689f ; **FLOATING
C994 a_5320_6254# VGND 0.07545f ; **FLOATING
C995 a_4892_6168# VGND 0.1069f
C996 a_8110_6168# VGND 0.0144f
C997 sg13cmos5l_buf_1_6.A VGND 0.22617f
C998 a_14720_7050# VGND 0.03861f ; **FLOATING
C999 a_14536_7050# VGND 0.13546f ; **FLOATING
C1000 a_9344_7050# VGND 0.0377f ; **FLOATING
C1001 a_9160_7050# VGND 0.12043f ; **FLOATING
C1002 a_5224_7050# VGND 0.09794f ; **FLOATING
C1003 sg13cmos5l_buf_1_4.A VGND 0.98718f
C1004 a_13664_7766# VGND 0.04337f ; **FLOATING
C1005 a_13480_7766# VGND 0.13873f ; **FLOATING
C1006 a_13768_7680# VGND 0.09847f
C1007 a_11659_8028# VGND 0.14046f
C1008 a_9056_7766# VGND 0.03882f ; **FLOATING
C1009 a_8872_7766# VGND 0.137f ; **FLOATING
C1010 a_9262_7680# VGND 0.05178f
C1011 a_7723_8028# VGND 0.07363f
C1012 a_7520_7766# VGND 0.03776f ; **FLOATING
C1013 a_7336_7766# VGND 0.11922f ; **FLOATING
C1014 a_3488_7766# VGND 0.09061f ; **FLOATING
C1015 a_15104_8562# VGND 0.09691f ; **FLOATING
C1016 a_14010_8446# VGND 0.01114f
C1017 a_13472_8562# VGND 0.04468f ; **FLOATING
C1018 a_13288_8562# VGND 0.16751f ; **FLOATING
C1019 a_9882_8446# VGND 0.01813f
C1020 a_14344_8468# VGND 0.40391f
C1021 sg13cmos5l_xor2_1_5.X VGND 0.01045f
C1022 a_9788_8728# VGND 2.87425f
C1023 a_3488_8562# VGND 0.08972f ; **FLOATING
C1024 a_14824_9192# VGND 0.29022f
C1025 a_13576_9278# VGND 0.09753f ; **FLOATING
C1026 a_6332_9192# VGND 0.10802f
C1027 a_13768_9192# VGND 0.24246f
C1028 a_6426_9550# VGND 0.09755f
C1029 a_3488_9278# VGND 0.09036f ; **FLOATING
C1030 a_13675_9988# VGND 1.72002f
C1031 a_4168_10074# VGND 0.12664f ; **FLOATING
C1032 a_3488_10790# VGND 0.09068f ; **FLOATING
C1033 a_15104_11586# VGND 0.09598f ; **FLOATING
C1034 a_13713_11776# VGND 0.69434f
C1035 a_13745_11508# VGND 0.06437f
C1036 a_5024_11586# VGND 0.03798f ; **FLOATING
C1037 a_4840_11586# VGND 0.11962f ; **FLOATING
C1038 a_15016_12302# VGND 0.13521f ; **FLOATING
C1039 a_12040_12302# VGND 0.13405f ; **FLOATING
C1040 a_6332_12216# VGND 0.87713f
C1041 a_6129_12216# VGND 1.57687f
C1042 sg13cmos5l_buf_16_19.A VGND 0.08275f
C1043 a_6859_12564# VGND 0.80372f
C1044 a_6426_12574# VGND 1.93234f
C1045 a_3488_12302# VGND 0.0924f ; **FLOATING
C1046 a_13897_13012# VGND 1.40265f
C1047 a_14824_13004# VGND 0.44074f
C1048 sg13cmos5l_buf_1_22.X VGND 0.22284f
C1049 a_13472_13098# VGND 0.04905f ; **FLOATING
C1050 a_13288_13098# VGND 0.16012f ; **FLOATING
C1051 a_10112_13098# VGND 0.04277f ; **FLOATING
C1052 sg13cmos5l_buf_1_17.A VGND 0.46644f
C1053 a_3872_13098# VGND 0.05947f ; **FLOATING
C1054 a_15016_13814# VGND 0.15046f ; **FLOATING
C1055 a_11924_13728# VGND 0.51404f
C1056 a_12054_14086# VGND 4.27277f
C1057 a_11656_13814# VGND 0.09791f ; **FLOATING
C1058 a_3968_13814# VGND 0.09026f ; **FLOATING
C1059 a_2377_14076# VGND 3.80524f
C1060 a_1864_13814# VGND 0.13386f ; **FLOATING
C1061 a_14720_14610# VGND 0.0429f ; **FLOATING
C1062 sg13cmos5l_and2_2_6.B VGND 0.15036f
C1063 a_3488_14610# VGND 0.04249f ; **FLOATING
C1064 a_3304_14610# VGND 0.11243f ; **FLOATING
C1065 a_2728_14610# VGND 0.13045f ; **FLOATING
C1066 sg13cmos5l_buf_16_15.X VGND 0.03191f
C1067 sg13cmos5l_and2_2_0.B VGND 0.11187f
C1068 a_1480_14610# VGND 0.13449f ; **FLOATING
C1069 VGND.t11 VGND 0.13305f
C1070 VGND.t1235 VGND 9.37235f
C1071 VGND.t41 VGND 3.33921f
C1072 VGND.t207 VGND 0.27804f
C1073 VGND.t1349 VGND 10.21919f
C1074 VGND.t1359 VGND 0.70114f
C1075 VGND.t1364 VGND 0.42534f
C1076 VGND.t1369 VGND 0.63388f
C1077 VGND.t1374 VGND 2.56615f
C1078 VGND.t1376 VGND 2.56615f
C1079 VGND.t860 VGND 2.13336f
C1080 VGND.t1378 VGND 0.27168f
C1081 VGND.t1383 VGND 1.80431f
C1082 VGND.t1403 VGND 0.25268f
C1083 VGND.t1413 VGND 0.54355f
C1084 VGND.t1412 VGND 0.54355f
C1085 VGND.t82 VGND 3.54309f
C1086 VGND.t282 VGND 17.26045f
C1087 VGND.t23 VGND 1.09515f
C1088 VGND.t1178 VGND 5.49543f
C1089 VGND.t70 VGND 5.64256f
C1090 VGND.t806 VGND 3.86909f
C1091 VGND.t671 VGND 0.21412f
C1092 VGND.t116 VGND 11.41228f
C1093 VGND.t5 VGND 2.18463f
C1094 VGND.t800 VGND 0.94371f
C1095 VGND.t402 VGND 0.7223f
C1096 VGND.t1119 VGND 0.1123f
C1097 VGND.t633 VGND 0.10564f
C1098 VGND.t1085 VGND 0.62044f
C1099 VGND.t1086 VGND 0.62044f
C1100 VGND.t1079 VGND 1.92109f
C1101 VGND.t1 VGND 5.88178f
C1102 VGND.t1067 VGND 0.1123f
C1103 VGND.t322 VGND 0.01545f
C1104 VGND.t652 VGND 0.95258f
C1105 VGND.t519 VGND 0.82686f
C1106 VGND.t345 VGND 2.00778f
C1107 VGND.t639 VGND 0.03089f
C1108 VGND.t330 VGND 0.06965f
C1109 VGND.t636 VGND 1.28578f
C1110 VGND.t934 VGND 0.61746f
C1111 VGND.t871 VGND 2.57414f
C1112 VGND.t915 VGND 0.45711f
C1113 VGND.t951 VGND 1.44098f
C1114 VGND.t350 VGND 3.08407f
C1115 VGND.t1028 VGND 1.1992f
C1116 VGND.t157 VGND 0.22284f
C1117 VGND.t1029 VGND 3.29672f
C1118 VGND.t1296 VGND 5.59077f
C1119 VGND.t584 VGND 0.11108f
C1120 VGND.t504 VGND 0.06477f
C1121 VGND.t491 VGND 2.19668f
C1122 VGND.t1291 VGND 0.16249f
C1123 VGND.t146 VGND 0.2707f
C1124 VGND.t1433 VGND 0.40972f
C1125 VGND.t1385 VGND 1.257f
C1126 VGND.t1371 VGND 0.63388f
C1127 VPWR.t28 VGND 0.1726f
C1128 VPWR.n1 VGND 0.22471f
C1129 VPWR.t3 VGND 18.6749f
C1130 VPWR.t70 VGND 4.25975f
C1131 VPWR.n6 VGND 0.08249f
C1132 VPWR.n7 VGND 0.13305f
C1133 VPWR.n9 VGND 0.08249f
C1134 VPWR.n10 VGND 0.13298f
C1135 VPWR.n12 VGND 0.08249f
C1136 VPWR.n13 VGND 0.13342f
C1137 VPWR.n15 VGND 0.05976f
C1138 VPWR.n16 VGND 0.08865f
C1139 VPWR.n17 VGND 0.17497f
C1140 VPWR.n20 VGND 0.02831f
C1141 VPWR.n21 VGND 0.04836f
C1142 VPWR.n22 VGND 0.16083f
C1143 VPWR.n24 VGND 0.15365f
C1144 VPWR.n26 VGND 1.10542f
C1145 VPWR.n27 VGND 0.0264f
C1146 VPWR.n28 VGND 0.08249f
C1147 VPWR.n29 VGND 0.1001f
C1148 VPWR.n31 VGND 0.0249f
C1149 VPWR.n32 VGND 0.08249f
C1150 VPWR.n33 VGND 0.06375f
C1151 VPWR.n37 VGND 0.08863f
C1152 VPWR.n38 VGND 0.06725f
C1153 VPWR.n40 VGND 0.01533f
C1154 VPWR.n41 VGND 0.08865f
C1155 VPWR.n42 VGND 0.0523f
C1156 VPWR.n44 VGND 0.08863f
C1157 VPWR.n45 VGND 0.06917f
C1158 VPWR.n47 VGND 0.08865f
C1159 VPWR.n48 VGND 0.06723f
C1160 VPWR.n50 VGND 0.02028f
C1161 VPWR.n51 VGND 0.08865f
C1162 VPWR.n52 VGND 0.06723f
C1163 VPWR.t318 VGND 0.28685f
C1164 VPWR.n59 VGND 0.01451f
C1165 VPWR.n62 VGND 0.04888f
C1166 VPWR.n63 VGND 2.76948f
C1167 VPWR.n64 VGND 0.01329f
C1168 VPWR.t1 VGND 0.25268f
C1169 VPWR.n65 VGND 0.79226f
C1170 VPWR.t6 VGND 0.13584f
C1171 VPWR.t37 VGND 1.12059f
C1172 VPWR.t38 VGND 1.05432f
C1173 VPWR.n66 VGND 0.02659f
C1174 VPWR.n67 VGND 1.32935f
C1175 VPWR.n68 VGND 0.01329f
C1176 VPWR.n69 VGND 0.51049f
C1177 VPWR.t30 VGND 0.52998f
C1178 VPWR.n70 VGND 0.19785f
C1179 VPWR.t1077 VGND 0.64862f
C1180 VPWR.t288 VGND 0.52998f
C1181 VPWR.t880 VGND 0.56702f
C1182 VPWR.t218 VGND 0.02186f
C1183 VPWR.n72 VGND 0.02862f
C1184 VPWR.t802 VGND 0.02389f
C1185 VPWR.n80 VGND 0.02575f
C1186 VPWR.t496 VGND 0.02389f
C1187 VPWR.t778 VGND 0.02389f
C1188 VPWR.n88 VGND 0.0437f
C1189 VPWR.t494 VGND 0.02389f
C1190 VPWR.t279 VGND 0.02389f
C1191 VPWR.n90 VGND 0.0435f
C1192 VPWR.t492 VGND 0.02434f
C1193 VPWR.t277 VGND 0.02389f
C1194 VPWR.n92 VGND 0.04756f
C1195 VPWR.t490 VGND 0.02389f
C1196 VPWR.t275 VGND 2.34863f
C1197 VPWR.n94 VGND 0.04333f
C1198 VPWR.t489 VGND 0.02279f
C1199 VPWR.t274 VGND 0.02186f
C1200 VPWR.n96 VGND 0.05598f
C1201 VPWR.t53 VGND 0.01961f
C1202 VPWR.t1005 VGND 0.01961f
C1203 VPWR.n99 VGND 0.04735f
C1204 VPWR.t455 VGND 0.01961f
C1205 VPWR.t997 VGND 0.01961f
C1206 VPWR.n103 VGND 0.05251f
C1207 VPWR.t454 VGND 0.0196f
C1208 VPWR.t996 VGND 0.0196f
C1209 VPWR.n105 VGND 0.05336f
C1210 VPWR.t451 VGND 0.01961f
C1211 VPWR.t993 VGND 0.01961f
C1212 VPWR.n107 VGND 0.05408f
C1213 VPWR.t452 VGND 0.02105f
C1214 VPWR.n108 VGND 0.08863f
C1215 VPWR.t994 VGND 0.02105f
C1216 VPWR.n109 VGND 0.08865f
C1217 VPWR.n110 VGND 0.07513f
C1218 VPWR.t47 VGND 0.04912f
C1219 VPWR.n112 VGND 0.08863f
C1220 VPWR.t998 VGND 0.52927f
C1221 VPWR.n113 VGND 0.08865f
C1222 VPWR.n114 VGND 0.07184f
C1223 VPWR.t48 VGND 0.04768f
C1224 VPWR.t1000 VGND 0.52782f
C1225 VPWR.n116 VGND 0.05336f
C1226 VPWR.t49 VGND 0.01961f
C1227 VPWR.t1001 VGND 0.01961f
C1228 VPWR.n118 VGND 0.05251f
C1229 VPWR.t50 VGND 0.02105f
C1230 VPWR.n119 VGND 0.08863f
C1231 VPWR.t1002 VGND 5.24041f
C1232 VPWR.n120 VGND 0.08865f
C1233 VPWR.n121 VGND 0.07184f
C1234 VPWR.n123 VGND 0.41875f
C1235 VPWR.t428 VGND 0.09665f
C1236 VPWR.t951 VGND 0.07575f
C1237 VPWR.n124 VGND 0.04797f
C1238 VPWR.t433 VGND 0.01961f
C1239 VPWR.n127 VGND 0.03377f
C1240 VPWR.t432 VGND 0.01994f
C1241 VPWR.t969 VGND 0.8101f
C1242 VPWR.n129 VGND 0.05336f
C1243 VPWR.t586 VGND 0.01961f
C1244 VPWR.t948 VGND 0.01961f
C1245 VPWR.n132 VGND 0.05251f
C1246 VPWR.t585 VGND 0.1319f
C1247 VPWR.t947 VGND 0.07575f
C1248 VPWR.n134 VGND 0.05336f
C1249 VPWR.t578 VGND 0.01961f
C1250 VPWR.t940 VGND 0.01961f
C1251 VPWR.n136 VGND 0.05408f
C1252 VPWR.t579 VGND 0.13335f
C1253 VPWR.n138 VGND 0.08863f
C1254 VPWR.t941 VGND 0.0772f
C1255 VPWR.n139 VGND 0.08865f
C1256 VPWR.n140 VGND 0.07513f
C1257 VPWR.t581 VGND 0.1319f
C1258 VPWR.t943 VGND 0.07575f
C1259 VPWR.n142 VGND 0.05336f
C1260 VPWR.t582 VGND 0.01961f
C1261 VPWR.t944 VGND 0.07576f
C1262 VPWR.n144 VGND 0.05251f
C1263 VPWR.t583 VGND 0.13335f
C1264 VPWR.n145 VGND 0.08863f
C1265 VPWR.t945 VGND 0.13335f
C1266 VPWR.n146 VGND 0.08865f
C1267 VPWR.n147 VGND 0.07184f
C1268 VPWR.t427 VGND 0.0981f
C1269 VPWR.n149 VGND 0.08863f
C1270 VPWR.t949 VGND 0.0772f
C1271 VPWR.n150 VGND 0.08865f
C1272 VPWR.n151 VGND 0.07184f
C1273 VPWR.t429 VGND 0.03006f
C1274 VPWR.t952 VGND 0.01961f
C1275 VPWR.n153 VGND 0.04735f
C1276 VPWR.t430 VGND 0.03184f
C1277 VPWR.n154 VGND 0.08863f
C1278 VPWR.t953 VGND 0.81155f
C1279 VPWR.n155 VGND 0.08865f
C1280 VPWR.n156 VGND 0.07184f
C1281 VPWR.t434 VGND 0.02105f
C1282 VPWR.n158 VGND 0.08863f
C1283 VPWR.t726 VGND 0.0582f
C1284 VPWR.n159 VGND 0.07157f
C1285 VPWR.t436 VGND 0.0196f
C1286 VPWR.t727 VGND 0.08907f
C1287 VPWR.n161 VGND 0.02438f
C1288 VPWR.n162 VGND 0.02644f
C1289 VPWR.t437 VGND 2.25222f
C1290 VPWR.t879 VGND 0.01613f
C1291 VPWR.n163 VGND 0.01964f
C1292 VPWR.n164 VGND 0.02905f
C1293 VPWR.t72 VGND 0.72876f
C1294 VPWR.t837 VGND 0.39127f
C1295 VPWR.t612 VGND 0.02389f
C1296 VPWR.t610 VGND 0.02389f
C1297 VPWR.t1549 VGND 0.02389f
C1298 VPWR.n166 VGND 0.02663f
C1299 VPWR.n167 VGND 0.02319f
C1300 VPWR.t1547 VGND 0.02389f
C1301 VPWR.n169 VGND 0.02446f
C1302 VPWR.t153 VGND 0.02389f
C1303 VPWR.n179 VGND 0.02933f
C1304 VPWR.t152 VGND 0.02389f
C1305 VPWR.t1225 VGND 0.02365f
C1306 VPWR.n181 VGND 0.01638f
C1307 VPWR.n182 VGND 0.02341f
C1308 VPWR.t527 VGND 0.02389f
C1309 VPWR.n184 VGND 0.02903f
C1310 VPWR.t525 VGND 0.07785f
C1311 VPWR.t1227 VGND 0.0207f
C1312 VPWR.n186 VGND 0.02653f
C1313 VPWR.n187 VGND 0.02209f
C1314 VPWR.t438 VGND 2.25145f
C1315 VPWR.n188 VGND 0.05313f
C1316 VPWR.t524 VGND 0.02199f
C1317 VPWR.n189 VGND 0.05943f
C1318 VPWR.t155 VGND 0.02389f
C1319 VPWR.n190 VGND 0.03368f
C1320 VPWR.t1364 VGND 0.02279f
C1321 VPWR.t157 VGND 0.02389f
C1322 VPWR.n192 VGND 0.02573f
C1323 VPWR.n193 VGND 0.02819f
C1324 VPWR.t1365 VGND 0.02389f
C1325 VPWR.t159 VGND 0.02389f
C1326 VPWR.n195 VGND 0.02199f
C1327 VPWR.n196 VGND 0.02344f
C1328 VPWR.t1367 VGND 0.02434f
C1329 VPWR.t161 VGND 0.02389f
C1330 VPWR.n198 VGND 0.0224f
C1331 VPWR.n199 VGND 0.02705f
C1332 VPWR.t1369 VGND 0.02389f
C1333 VPWR.t163 VGND 0.02434f
C1334 VPWR.n201 VGND 0.02705f
C1335 VPWR.n202 VGND 0.0224f
C1336 VPWR.t1371 VGND 0.02389f
C1337 VPWR.t165 VGND 0.02389f
C1338 VPWR.n204 VGND 0.02344f
C1339 VPWR.n205 VGND 0.02199f
C1340 VPWR.t1373 VGND 0.88038f
C1341 VPWR.t167 VGND 0.02279f
C1342 VPWR.n207 VGND 0.02819f
C1343 VPWR.n208 VGND 0.02173f
C1344 VPWR.t975 VGND 3.02587f
C1345 VPWR.n209 VGND 0.0307f
C1346 VPWR.t976 VGND 3.02511f
C1347 VPWR.n211 VGND 0.04836f
C1348 VPWR.n212 VGND 0.02519f
C1349 VPWR.t1375 VGND 0.02389f
C1350 VPWR.n213 VGND 0.02022f
C1351 VPWR.t599 VGND 0.02279f
C1352 VPWR.n215 VGND 0.02438f
C1353 VPWR.t1377 VGND 0.02389f
C1354 VPWR.n216 VGND 0.02022f
C1355 VPWR.t600 VGND 0.02389f
C1356 VPWR.n218 VGND 0.02022f
C1357 VPWR.t720 VGND 0.24632f
C1358 VPWR.n219 VGND 0.02022f
C1359 VPWR.t602 VGND 0.02434f
C1360 VPWR.n221 VGND 0.02438f
C1361 VPWR.t721 VGND 0.46874f
C1362 VPWR.n222 VGND 0.02022f
C1363 VPWR.t604 VGND 0.02389f
C1364 VPWR.n224 VGND 0.02022f
C1365 VPWR.t723 VGND 0.02389f
C1366 VPWR.n225 VGND 0.02015f
C1367 VPWR.t606 VGND 0.02389f
C1368 VPWR.n227 VGND 0.02022f
C1369 VPWR.t725 VGND 0.02186f
C1370 VPWR.n228 VGND 0.02445f
C1371 VPWR.t608 VGND 0.02389f
C1372 VPWR.n230 VGND 0.02022f
C1373 VPWR.t1545 VGND 0.02186f
C1374 VPWR.n231 VGND 0.02445f
C1375 VPWR.n233 VGND 0.41875f
C1376 VPWR.t189 VGND 2.94415f
C1377 VPWR.t82 VGND 0.99212f
C1378 VPWR.n242 VGND 0.02991f
C1379 VPWR.t480 VGND 0.02389f
C1380 VPWR.t704 VGND 0.02389f
C1381 VPWR.n245 VGND 0.0437f
C1382 VPWR.t478 VGND 0.02389f
C1383 VPWR.t703 VGND 0.02389f
C1384 VPWR.n247 VGND 0.0435f
C1385 VPWR.t476 VGND 0.02434f
C1386 VPWR.t1130 VGND 0.02389f
C1387 VPWR.n249 VGND 0.04756f
C1388 VPWR.t474 VGND 0.02389f
C1389 VPWR.t1128 VGND 0.02389f
C1390 VPWR.n251 VGND 0.04333f
C1391 VPWR.t473 VGND 0.02279f
C1392 VPWR.t1127 VGND 0.02186f
C1393 VPWR.n253 VGND 0.05598f
C1394 VPWR.t374 VGND 0.01961f
C1395 VPWR.t1097 VGND 0.01961f
C1396 VPWR.n256 VGND 0.04735f
C1397 VPWR.t366 VGND 0.01961f
C1398 VPWR.t1089 VGND 0.02307f
C1399 VPWR.n260 VGND 0.05251f
C1400 VPWR.t365 VGND 0.11108f
C1401 VPWR.t1088 VGND 0.0196f
C1402 VPWR.n262 VGND 0.05336f
C1403 VPWR.t362 VGND 0.07576f
C1404 VPWR.t1085 VGND 0.02316f
C1405 VPWR.n264 VGND 0.05408f
C1406 VPWR.t363 VGND 0.16868f
C1407 VPWR.n265 VGND 0.08863f
C1408 VPWR.t1086 VGND 0.02461f
C1409 VPWR.n266 VGND 0.08865f
C1410 VPWR.n267 VGND 0.07513f
C1411 VPWR.t367 VGND 0.75937f
C1412 VPWR.n269 VGND 0.08863f
C1413 VPWR.t1090 VGND 2.09963f
C1414 VPWR.n270 VGND 0.08865f
C1415 VPWR.n271 VGND 0.07184f
C1416 VPWR.t369 VGND 0.75793f
C1417 VPWR.t1092 VGND 2.09472f
C1418 VPWR.n273 VGND 0.05336f
C1419 VPWR.t370 VGND 0.01961f
C1420 VPWR.t1093 VGND 0.24999f
C1421 VPWR.n275 VGND 0.05251f
C1422 VPWR.t371 VGND 0.98159f
C1423 VPWR.n276 VGND 0.08863f
C1424 VPWR.t1094 VGND 0.25143f
C1425 VPWR.n277 VGND 0.08865f
C1426 VPWR.n278 VGND 0.07184f
C1427 VPWR.n280 VGND 0.08475f
C1428 VPWR.t15 VGND 0.0196f
C1429 VPWR.t1167 VGND 0.07575f
C1430 VPWR.n282 VGND 0.04797f
C1431 VPWR.t125 VGND 0.61057f
C1432 VPWR.t123 VGND 0.08422f
C1433 VPWR.t113 VGND 0.01961f
C1434 VPWR.t1053 VGND 0.69568f
C1435 VPWR.t1052 VGND 0.69712f
C1436 VPWR.n283 VGND 0.08249f
C1437 VPWR.t112 VGND 0.0196f
C1438 VPWR.n284 VGND 0.03201f
C1439 VPWR.n285 VGND 0.04094f
C1440 VPWR.t111 VGND 0.02105f
C1441 VPWR.t651 VGND 0.02395f
C1442 VPWR.t312 VGND 0.81027f
C1443 VPWR.t311 VGND 0.27681f
C1444 VPWR.t649 VGND 0.0558f
C1445 VPWR.n292 VGND 0.02491f
C1446 VPWR.n293 VGND 0.02792f
C1447 VPWR.t647 VGND 0.02434f
C1448 VPWR.t310 VGND 0.0196f
C1449 VPWR.n295 VGND 0.02662f
C1450 VPWR.n296 VGND 0.02885f
C1451 VPWR.t16 VGND 0.04768f
C1452 VPWR.t1168 VGND 0.01961f
C1453 VPWR.n299 VGND 0.04735f
C1454 VPWR.t106 VGND 1.80999f
C1455 VPWR.t325 VGND 0.07576f
C1456 VPWR.n303 VGND 0.05251f
C1457 VPWR.t105 VGND 0.1319f
C1458 VPWR.t324 VGND 0.07575f
C1459 VPWR.n305 VGND 0.05336f
C1460 VPWR.t102 VGND 0.05152f
C1461 VPWR.t321 VGND 0.07576f
C1462 VPWR.n307 VGND 0.05408f
C1463 VPWR.t103 VGND 0.16526f
C1464 VPWR.n308 VGND 0.08863f
C1465 VPWR.t322 VGND 0.13335f
C1466 VPWR.n309 VGND 0.08865f
C1467 VPWR.n310 VGND 0.07513f
C1468 VPWR.t107 VGND 1.86758f
C1469 VPWR.n312 VGND 0.08863f
C1470 VPWR.t326 VGND 0.0772f
C1471 VPWR.n313 VGND 0.08865f
C1472 VPWR.n314 VGND 0.07184f
C1473 VPWR.t109 VGND 0.07575f
C1474 VPWR.t328 VGND 0.0196f
C1475 VPWR.n316 VGND 0.05336f
C1476 VPWR.t110 VGND 0.01961f
C1477 VPWR.t329 VGND 0.01961f
C1478 VPWR.n318 VGND 0.05251f
C1479 VPWR.t14 VGND 0.02105f
C1480 VPWR.n319 VGND 0.08863f
C1481 VPWR.t330 VGND 0.0772f
C1482 VPWR.n320 VGND 0.08865f
C1483 VPWR.n321 VGND 0.07184f
C1484 VPWR.t17 VGND 0.04912f
C1485 VPWR.n323 VGND 0.08863f
C1486 VPWR.t1169 VGND 0.04912f
C1487 VPWR.n324 VGND 0.08865f
C1488 VPWR.n325 VGND 0.07184f
C1489 VPWR.t992 VGND 0.0196f
C1490 VPWR.t1171 VGND 0.04768f
C1491 VPWR.n327 VGND 0.05336f
C1492 VPWR.t307 VGND 0.34534f
C1493 VPWR.n328 VGND 0.02975f
C1494 VPWR.t645 VGND 1.00716f
C1495 VPWR.t308 VGND 0.34678f
C1496 VPWR.n330 VGND 0.08865f
C1497 VPWR.n331 VGND 0.06181f
C1498 VPWR.t644 VGND 0.02279f
C1499 VPWR.n332 VGND 0.02438f
C1500 VPWR.t653 VGND 0.02389f
C1501 VPWR.n334 VGND 0.02028f
C1502 VPWR.t314 VGND 0.55162f
C1503 VPWR.n336 VGND 0.02991f
C1504 VPWR.t655 VGND 0.02389f
C1505 VPWR.n338 VGND 0.0297f
C1506 VPWR.t657 VGND 0.02389f
C1507 VPWR.n339 VGND 0.02528f
C1508 VPWR.t659 VGND 0.02389f
C1509 VPWR.n341 VGND 0.02022f
C1510 VPWR.t1286 VGND 0.02279f
C1511 VPWR.n342 VGND 0.02438f
C1512 VPWR.t812 VGND 0.02389f
C1513 VPWR.n344 VGND 0.02022f
C1514 VPWR.t1287 VGND 0.02389f
C1515 VPWR.n345 VGND 0.02022f
C1516 VPWR.t814 VGND 0.02389f
C1517 VPWR.n347 VGND 0.02015f
C1518 VPWR.t1289 VGND 0.02434f
C1519 VPWR.n348 VGND 0.02438f
C1520 VPWR.t816 VGND 0.02186f
C1521 VPWR.n350 VGND 0.02445f
C1522 VPWR.t1291 VGND 0.24186f
C1523 VPWR.n351 VGND 0.02022f
C1524 VPWR.t810 VGND 1.59702f
C1525 VPWR.n353 VGND 0.02438f
C1526 VPWR.t1293 VGND 0.02389f
C1527 VPWR.n354 VGND 0.02022f
C1528 VPWR.t1295 VGND 0.02389f
C1529 VPWR.n356 VGND 0.02973f
C1530 VPWR.t817 VGND 0.02365f
C1531 VPWR.t1297 VGND 0.02389f
C1532 VPWR.n358 VGND 0.02878f
C1533 VPWR.n359 VGND 0.02004f
C1534 VPWR.t1299 VGND 0.95322f
C1535 VPWR.n361 VGND 0.02933f
C1536 VPWR.t660 VGND 0.02389f
C1537 VPWR.t1285 VGND 0.01613f
C1538 VPWR.n363 VGND 0.02073f
C1539 VPWR.n364 VGND 0.02274f
C1540 VPWR.t661 VGND 0.02389f
C1541 VPWR.t818 VGND 0.12176f
C1542 VPWR.n366 VGND 0.0212f
C1543 VPWR.n367 VGND 0.02216f
C1544 VPWR.t663 VGND 0.02389f
C1545 VPWR.t819 VGND 0.02434f
C1546 VPWR.n369 VGND 0.02618f
C1547 VPWR.n370 VGND 0.02568f
C1548 VPWR.t665 VGND 0.02186f
C1549 VPWR.t1031 VGND 0.01961f
C1550 VPWR.t1051 VGND 0.01961f
C1551 VPWR.t1054 VGND 0.37053f
C1552 VPWR.t114 VGND 0.0634f
C1553 VPWR.t116 VGND 0.06196f
C1554 VPWR.t1055 VGND 0.63044f
C1555 VPWR.n371 VGND 0.08249f
C1556 VPWR.n372 VGND 0.04094f
C1557 VPWR.n373 VGND 0.02985f
C1558 VPWR.t1056 VGND 0.27807f
C1559 VPWR.t117 VGND 0.01961f
C1560 VPWR.n375 VGND 0.0292f
C1561 VPWR.n376 VGND 0.029f
C1562 VPWR.t1057 VGND 0.53654f
C1563 VPWR.n379 VGND 2.76948f
C1564 VPWR.n380 VGND 1.32935f
C1565 VPWR.n381 VGND 0.65266f
C1566 VPWR.t129 VGND 1.95881f
C1567 VPWR.n382 VGND 0.31095f
C1568 VPWR.t631 VGND 4.58851f
C1569 VPWR.t930 VGND 0.39914f
C1570 VPWR.n383 VGND 0.02825f
C1571 VPWR.n384 VGND 0.29382f
C1572 VPWR.t1259 VGND 0.02389f
C1573 VPWR.t926 VGND 0.02389f
C1574 VPWR.n386 VGND 0.02199f
C1575 VPWR.n387 VGND 0.02337f
C1576 VPWR.t1257 VGND 0.02389f
C1577 VPWR.t924 VGND 0.02389f
C1578 VPWR.n389 VGND 0.0224f
C1579 VPWR.n390 VGND 0.02289f
C1580 VPWR.t1256 VGND 0.02389f
C1581 VPWR.t922 VGND 0.02434f
C1582 VPWR.n392 VGND 0.02705f
C1583 VPWR.n393 VGND 0.0224f
C1584 VPWR.t1500 VGND 0.02389f
C1585 VPWR.t920 VGND 0.02389f
C1586 VPWR.n395 VGND 0.02344f
C1587 VPWR.n396 VGND 0.02199f
C1588 VPWR.t1498 VGND 0.02389f
C1589 VPWR.t919 VGND 0.02279f
C1590 VPWR.n398 VGND 0.02819f
C1591 VPWR.n399 VGND 0.02173f
C1592 VPWR.t1030 VGND 0.07575f
C1593 VPWR.n401 VGND 0.02991f
C1594 VPWR.t1460 VGND 0.02389f
C1595 VPWR.n411 VGND 0.02575f
C1596 VPWR.t226 VGND 0.01961f
C1597 VPWR.t988 VGND 0.0196f
C1598 VPWR.n418 VGND 0.03011f
C1599 VPWR.n419 VGND 0.0292f
C1600 VPWR.t12 VGND 0.02105f
C1601 VPWR.n421 VGND 0.08249f
C1602 VPWR.t1589 VGND 0.0196f
C1603 VPWR.n422 VGND 0.02985f
C1604 VPWR.n423 VGND 0.04094f
C1605 VPWR.t1587 VGND 0.124f
C1606 VPWR.t96 VGND 0.02105f
C1607 VPWR.t982 VGND 0.0335f
C1608 VPWR.t91 VGND 2.06303f
C1609 VPWR.n426 VGND 0.05408f
C1610 VPWR.t983 VGND 0.03494f
C1611 VPWR.n428 VGND 0.08863f
C1612 VPWR.t92 VGND 2.06447f
C1613 VPWR.n429 VGND 0.08865f
C1614 VPWR.n430 VGND 0.07513f
C1615 VPWR.t985 VGND 0.0196f
C1616 VPWR.t94 VGND 0.0196f
C1617 VPWR.n432 VGND 0.05336f
C1618 VPWR.t95 VGND 0.01961f
C1619 VPWR.t986 VGND 0.1319f
C1620 VPWR.n434 VGND 0.02576f
C1621 VPWR.t987 VGND 0.13113f
C1622 VPWR.t1473 VGND 0.02434f
C1623 VPWR.n435 VGND 0.02438f
C1624 VPWR.t98 VGND 0.0196f
C1625 VPWR.n436 VGND 0.03686f
C1626 VPWR.t1455 VGND 0.61015f
C1627 VPWR.n438 VGND 0.01994f
C1628 VPWR.t99 VGND 0.67536f
C1629 VPWR.n439 VGND 0.02459f
C1630 VPWR.t1533 VGND 0.02464f
C1631 VPWR.t9 VGND 0.6768f
C1632 VPWR.n441 VGND 0.08865f
C1633 VPWR.n442 VGND 0.0628f
C1634 VPWR.t1586 VGND 0.12256f
C1635 VPWR.t10 VGND 0.0196f
C1636 VPWR.t11 VGND 0.01961f
C1637 VPWR.t1517 VGND 0.02389f
C1638 VPWR.n444 VGND 0.02933f
C1639 VPWR.t1519 VGND 0.02389f
C1640 VPWR.n446 VGND 0.02912f
C1641 VPWR.t1521 VGND 0.02434f
C1642 VPWR.n448 VGND 0.03319f
C1643 VPWR.t1523 VGND 0.02389f
C1644 VPWR.n450 VGND 0.02903f
C1645 VPWR.t1525 VGND 0.02279f
C1646 VPWR.n452 VGND 0.03738f
C1647 VPWR.t1023 VGND 0.03728f
C1648 VPWR.n455 VGND 0.03398f
C1649 VPWR.t1021 VGND 0.20638f
C1650 VPWR.n457 VGND 0.03389f
C1651 VPWR.t1019 VGND 0.42895f
C1652 VPWR.n458 VGND 0.08865f
C1653 VPWR.n459 VGND 0.05313f
C1654 VPWR.t1020 VGND 0.24073f
C1655 VPWR.n461 VGND 0.0387f
C1656 VPWR.t1486 VGND 0.14023f
C1657 VPWR.n462 VGND 0.03236f
C1658 VPWR.n463 VGND 0.0105f
C1659 VPWR.t1515 VGND 0.02389f
C1660 VPWR.n464 VGND 0.03368f
C1661 VPWR.t1513 VGND 0.02389f
C1662 VPWR.n466 VGND 0.03371f
C1663 VPWR.t1511 VGND 0.02389f
C1664 VPWR.n468 VGND 0.02933f
C1665 VPWR.t1508 VGND 0.02389f
C1666 VPWR.n470 VGND 0.02912f
C1667 VPWR.t1506 VGND 2.25454f
C1668 VPWR.n472 VGND 0.02903f
C1669 VPWR.t1504 VGND 0.02389f
C1670 VPWR.n474 VGND 0.02896f
C1671 VPWR.t1503 VGND 0.02186f
C1672 VPWR.n476 VGND 0.04914f
C1673 VPWR.t1429 VGND 0.15363f
C1674 VPWR.n477 VGND 0.04411f
C1675 VPWR.n478 VGND 0.02156f
C1676 VPWR.t1022 VGND 0.03651f
C1677 VPWR.n479 VGND 0.05314f
C1678 VPWR.n480 VGND 0.04503f
C1679 VPWR.t1485 VGND 0.17385f
C1680 VPWR.n482 VGND 0.02828f
C1681 VPWR.n483 VGND 0.0105f
C1682 VPWR.n484 VGND 0.08865f
C1683 VPWR.t913 VGND 0.07857f
C1684 VPWR.t914 VGND 0.21128f
C1685 VPWR.t1475 VGND 3.30623f
C1686 VPWR.n485 VGND 0.01698f
C1687 VPWR.t384 VGND 8.4311f
C1688 VPWR.t385 VGND 8.42966f
C1689 VPWR.n486 VGND 0.03982f
C1690 VPWR.t1585 VGND 0.28166f
C1691 VPWR.t294 VGND 0.08712f
C1692 VPWR.t1404 VGND 0.13536f
C1693 VPWR.t981 VGND 0.0196f
C1694 VPWR.t980 VGND 0.02042f
C1695 VPWR.n487 VGND 0.03859f
C1696 VPWR.t979 VGND 0.02105f
C1697 VPWR.n488 VGND 0.08865f
C1698 VPWR.n489 VGND 0.0564f
C1699 VPWR.n491 VGND 0.04575f
C1700 VPWR.n492 VGND 0.01575f
C1701 VPWR.n493 VGND 0.04021f
C1702 VPWR.n494 VGND 0.0105f
C1703 VPWR.n495 VGND 0.0387f
C1704 VPWR.t293 VGND 0.35062f
C1705 VPWR.n497 VGND 0.08865f
C1706 VPWR.n498 VGND 0.05313f
C1707 VPWR.n500 VGND 0.03389f
C1708 VPWR.n502 VGND 0.04727f
C1709 VPWR.n503 VGND 1.10779f
C1710 VPWR.n504 VGND 0.01329f
C1711 VPWR.n505 VGND 0.02659f
C1712 VPWR.n507 VGND 2.76948f
C1713 VPWR.n508 VGND 0.01329f
C1714 VPWR.n509 VGND 0.11133f
C1715 VPWR.n510 VGND 0.50043f
C1716 VPWR.t75 VGND 2.81955f
C1717 VPWR.t990 VGND 0.13603f
C1718 VPWR.t989 VGND 0.13527f
C1719 VPWR.n511 VGND 0.04836f
C1720 VPWR.n512 VGND 0.02958f
C1721 VPWR.t76 VGND 2.8181f
C1722 VPWR.n514 VGND 0.02991f
C1723 VPWR.t1263 VGND 0.02279f
C1724 VPWR.n515 VGND 0.02912f
C1725 VPWR.t1264 VGND 0.02389f
C1726 VPWR.n517 VGND 0.02022f
C1727 VPWR.t1476 VGND 0.02186f
C1728 VPWR.n518 VGND 0.02445f
C1729 VPWR.t1266 VGND 0.02434f
C1730 VPWR.n520 VGND 0.02438f
C1731 VPWR.t1477 VGND 0.02389f
C1732 VPWR.n521 VGND 0.02015f
C1733 VPWR.t1268 VGND 0.02389f
C1734 VPWR.n523 VGND 0.02022f
C1735 VPWR.t1479 VGND 0.09461f
C1736 VPWR.n524 VGND 0.02022f
C1737 VPWR.t1270 VGND 0.02389f
C1738 VPWR.n526 VGND 0.02022f
C1739 VPWR.t1457 VGND 0.02389f
C1740 VPWR.n527 VGND 0.02022f
C1741 VPWR.t1272 VGND 0.02389f
C1742 VPWR.n529 VGND 0.02022f
C1743 VPWR.t1458 VGND 0.43615f
C1744 VPWR.n530 VGND 0.02022f
C1745 VPWR.t1462 VGND 0.02389f
C1746 VPWR.n532 VGND 0.02022f
C1747 VPWR.t1274 VGND 0.02389f
C1748 VPWR.n533 VGND 0.02575f
C1749 VPWR.t1464 VGND 0.02389f
C1750 VPWR.n535 VGND 0.02022f
C1751 VPWR.t1276 VGND 0.02389f
C1752 VPWR.n536 VGND 0.02022f
C1753 VPWR.t1466 VGND 0.02389f
C1754 VPWR.n538 VGND 0.02022f
C1755 VPWR.t1278 VGND 2.27178f
C1756 VPWR.n539 VGND 0.02022f
C1757 VPWR.t1468 VGND 0.02434f
C1758 VPWR.n541 VGND 0.02438f
C1759 VPWR.t1536 VGND 0.27918f
C1760 VPWR.n542 VGND 0.02022f
C1761 VPWR.t1470 VGND 0.02389f
C1762 VPWR.n544 VGND 0.02022f
C1763 VPWR.t1538 VGND 0.02389f
C1764 VPWR.n545 VGND 0.02015f
C1765 VPWR.t1472 VGND 0.02279f
C1766 VPWR.n547 VGND 0.02438f
C1767 VPWR.t1540 VGND 0.02186f
C1768 VPWR.n548 VGND 0.02445f
C1769 VPWR.t1487 VGND 0.02279f
C1770 VPWR.n550 VGND 0.02438f
C1771 VPWR.t100 VGND 0.01961f
C1772 VPWR.n551 VGND 0.02459f
C1773 VPWR.t1488 VGND 2.02628f
C1774 VPWR.t101 VGND 0.02105f
C1775 VPWR.n553 VGND 0.08865f
C1776 VPWR.n554 VGND 0.06181f
C1777 VPWR.t1027 VGND 0.0196f
C1778 VPWR.t1490 VGND 0.02434f
C1779 VPWR.n556 VGND 0.02885f
C1780 VPWR.n557 VGND 0.02662f
C1781 VPWR.t1492 VGND 0.02389f
C1782 VPWR.t1028 VGND 0.01961f
C1783 VPWR.n559 VGND 0.02792f
C1784 VPWR.n560 VGND 0.02491f
C1785 VPWR.t1494 VGND 0.02395f
C1786 VPWR.t1029 VGND 0.0772f
C1787 VPWR.t1496 VGND 0.02389f
C1788 VPWR.t928 VGND 0.02389f
C1789 VPWR.t1261 VGND 1.88151f
C1790 VPWR.t297 VGND 1.95881f
C1791 VPWR.t8 VGND 17.4961f
C1792 VPWR.n561 VGND 0.50043f
C1793 VPWR.n562 VGND 0.11133f
C1794 VPWR.n563 VGND 0.01329f
C1795 VPWR.n564 VGND 0.02659f
C1796 VPWR.n565 VGND 0.01329f
C1797 VPWR.n566 VGND 0.08475f
C1798 VPWR.n567 VGND 0.28083f
C1799 VPWR.t13 VGND 17.4961f
C1800 VPWR.n570 VGND 0.28083f
C1801 VPWR.t1173 VGND 0.0196f
C1802 VPWR.t355 VGND 0.0196f
C1803 VPWR.n572 VGND 0.04797f
C1804 VPWR.t357 VGND 0.34045f
C1805 VPWR.t1065 VGND 0.50393f
C1806 VPWR.t588 VGND 0.02389f
C1807 VPWR.t677 VGND 0.02389f
C1808 VPWR.n577 VGND 0.02319f
C1809 VPWR.n578 VGND 0.02428f
C1810 VPWR.t587 VGND 0.02186f
C1811 VPWR.t675 VGND 0.02389f
C1812 VPWR.n580 VGND 0.02345f
C1813 VPWR.n581 VGND 0.02809f
C1814 VPWR.t674 VGND 0.02389f
C1815 VPWR.t521 VGND 0.02186f
C1816 VPWR.n583 VGND 0.04772f
C1817 VPWR.t1435 VGND 0.02389f
C1818 VPWR.t519 VGND 0.13287f
C1819 VPWR.n585 VGND 0.04333f
C1820 VPWR.t1433 VGND 0.02389f
C1821 VPWR.t517 VGND 0.02389f
C1822 VPWR.n587 VGND 0.04333f
C1823 VPWR.t1432 VGND 0.02186f
C1824 VPWR.t472 VGND 1.84865f
C1825 VPWR.n589 VGND 0.04772f
C1826 VPWR.t470 VGND 0.02389f
C1827 VPWR.t836 VGND 0.02279f
C1828 VPWR.n591 VGND 0.02802f
C1829 VPWR.n592 VGND 0.02345f
C1830 VPWR.t468 VGND 0.02389f
C1831 VPWR.t834 VGND 0.02389f
C1832 VPWR.n594 VGND 0.02435f
C1833 VPWR.n595 VGND 0.02319f
C1834 VPWR.t832 VGND 0.02434f
C1835 VPWR.n597 VGND 0.0287f
C1836 VPWR.t1177 VGND 0.07575f
C1837 VPWR.t62 VGND 0.07575f
C1838 VPWR.n604 VGND 0.05336f
C1839 VPWR.t339 VGND 0.01961f
C1840 VPWR.t352 VGND 0.01961f
C1841 VPWR.n607 VGND 0.05251f
C1842 VPWR.t338 VGND 0.0196f
C1843 VPWR.t351 VGND 0.80018f
C1844 VPWR.n609 VGND 0.05336f
C1845 VPWR.t331 VGND 0.01961f
C1846 VPWR.t344 VGND 0.01961f
C1847 VPWR.n611 VGND 0.05408f
C1848 VPWR.t332 VGND 0.02105f
C1849 VPWR.n613 VGND 0.08863f
C1850 VPWR.t345 VGND 0.02105f
C1851 VPWR.n614 VGND 0.08865f
C1852 VPWR.n615 VGND 0.07513f
C1853 VPWR.t334 VGND 0.0196f
C1854 VPWR.t347 VGND 0.0196f
C1855 VPWR.n617 VGND 0.05336f
C1856 VPWR.t335 VGND 0.15998f
C1857 VPWR.t348 VGND 0.01961f
C1858 VPWR.n619 VGND 0.05251f
C1859 VPWR.t336 VGND 0.16142f
C1860 VPWR.n620 VGND 0.08863f
C1861 VPWR.t349 VGND 0.80163f
C1862 VPWR.n621 VGND 0.08865f
C1863 VPWR.n622 VGND 0.07184f
C1864 VPWR.t340 VGND 0.02105f
C1865 VPWR.n624 VGND 0.08863f
C1866 VPWR.t353 VGND 0.02105f
C1867 VPWR.n625 VGND 0.08865f
C1868 VPWR.n626 VGND 0.07184f
C1869 VPWR.t1174 VGND 0.01961f
C1870 VPWR.t356 VGND 0.07576f
C1871 VPWR.n628 VGND 0.04735f
C1872 VPWR.t1175 VGND 0.0772f
C1873 VPWR.n629 VGND 0.08863f
C1874 VPWR.t61 VGND 0.13335f
C1875 VPWR.n630 VGND 0.08865f
C1876 VPWR.n631 VGND 0.07184f
C1877 VPWR.t690 VGND 0.02186f
C1878 VPWR.n633 VGND 0.02445f
C1879 VPWR.t63 VGND 0.01961f
C1880 VPWR.n634 VGND 0.02975f
C1881 VPWR.t691 VGND 0.02395f
C1882 VPWR.t64 VGND 0.04912f
C1883 VPWR.n636 VGND 0.08865f
C1884 VPWR.n637 VGND 0.06174f
C1885 VPWR.t66 VGND 0.04768f
C1886 VPWR.t693 VGND 0.02389f
C1887 VPWR.n639 VGND 0.02469f
C1888 VPWR.n640 VGND 0.02662f
C1889 VPWR.t695 VGND 2.15195f
C1890 VPWR.n642 VGND 0.02912f
C1891 VPWR.t822 VGND 0.02389f
C1892 VPWR.t457 VGND 0.02279f
C1893 VPWR.n644 VGND 0.02802f
C1894 VPWR.n645 VGND 0.02345f
C1895 VPWR.t824 VGND 0.95034f
C1896 VPWR.t458 VGND 0.02389f
C1897 VPWR.n647 VGND 0.02435f
C1898 VPWR.n648 VGND 0.02319f
C1899 VPWR.t460 VGND 0.07883f
C1900 VPWR.n649 VGND 0.0287f
C1901 VPWR.t462 VGND 0.02389f
C1902 VPWR.n651 VGND 0.02022f
C1903 VPWR.t826 VGND 0.02389f
C1904 VPWR.n652 VGND 0.02022f
C1905 VPWR.t464 VGND 0.02389f
C1906 VPWR.n654 VGND 0.02022f
C1907 VPWR.t828 VGND 0.02389f
C1908 VPWR.n655 VGND 0.02022f
C1909 VPWR.t466 VGND 0.02389f
C1910 VPWR.n657 VGND 0.02022f
C1911 VPWR.t830 VGND 0.02389f
C1912 VPWR.n658 VGND 0.02022f
C1913 VPWR.t679 VGND 0.02389f
C1914 VPWR.n660 VGND 0.02022f
C1915 VPWR.t590 VGND 0.02389f
C1916 VPWR.n661 VGND 0.02453f
C1917 VPWR.t681 VGND 0.02389f
C1918 VPWR.n663 VGND 0.02022f
C1919 VPWR.t547 VGND 0.49827f
C1920 VPWR.n664 VGND 0.02022f
C1921 VPWR.t683 VGND 0.02389f
C1922 VPWR.n666 VGND 0.02022f
C1923 VPWR.t548 VGND 0.02389f
C1924 VPWR.n667 VGND 0.02022f
C1925 VPWR.t550 VGND 1.95041f
C1926 VPWR.n669 VGND 0.02022f
C1927 VPWR.t685 VGND 0.02434f
C1928 VPWR.n671 VGND 0.0287f
C1929 VPWR.t687 VGND 0.02389f
C1930 VPWR.t552 VGND 0.02389f
C1931 VPWR.n673 VGND 0.02319f
C1932 VPWR.n674 VGND 0.02435f
C1933 VPWR.t689 VGND 0.02279f
C1934 VPWR.t554 VGND 0.02389f
C1935 VPWR.n676 VGND 0.02345f
C1936 VPWR.n677 VGND 0.02802f
C1937 VPWR.t556 VGND 0.02389f
C1938 VPWR.t1062 VGND 0.01961f
C1939 VPWR.n679 VGND 0.02573f
C1940 VPWR.n680 VGND 0.02465f
C1941 VPWR.t1063 VGND 0.02105f
C1942 VPWR.t558 VGND 0.02444f
C1943 VPWR.t560 VGND 0.02389f
C1944 VPWR.t56 VGND 7.0194f
C1945 VPWR.t55 VGND 17.4959f
C1946 VPWR.n683 VGND 0.41875f
C1947 VPWR.n684 VGND 0.41875f
C1948 VPWR.t373 VGND 0.98015f
C1949 VPWR.t1096 VGND 0.0196f
C1950 VPWR.n686 VGND 0.04797f
C1951 VPWR.t67 VGND 0.02105f
C1952 VPWR.n688 VGND 0.08863f
C1953 VPWR.t1098 VGND 0.02105f
C1954 VPWR.n689 VGND 0.08865f
C1955 VPWR.n690 VGND 0.07184f
C1956 VPWR.t68 VGND 0.0196f
C1957 VPWR.t1606 VGND 0.0196f
C1958 VPWR.n691 VGND 0.05737f
C1959 VPWR.t482 VGND 0.02389f
C1960 VPWR.t706 VGND 0.02389f
C1961 VPWR.n693 VGND 0.04806f
C1962 VPWR.t484 VGND 1.72706f
C1963 VPWR.t708 VGND 0.13794f
C1964 VPWR.n695 VGND 0.04808f
C1965 VPWR.t486 VGND 0.03751f
C1966 VPWR.t710 VGND 0.02389f
C1967 VPWR.n697 VGND 0.0437f
C1968 VPWR.t488 VGND 0.48008f
C1969 VPWR.t712 VGND 0.02389f
C1970 VPWR.n699 VGND 0.0435f
C1971 VPWR.t1202 VGND 0.02389f
C1972 VPWR.t714 VGND 0.02434f
C1973 VPWR.n701 VGND 0.04756f
C1974 VPWR.t1206 VGND 0.93627f
C1975 VPWR.t716 VGND 0.02389f
C1976 VPWR.n703 VGND 0.04333f
C1977 VPWR.t1208 VGND 0.02186f
C1978 VPWR.t718 VGND 0.02279f
C1979 VPWR.n705 VGND 0.05189f
C1980 VPWR.t1205 VGND 0.0207f
C1981 VPWR.t79 VGND 0.01961f
C1982 VPWR.n707 VGND 0.02786f
C1983 VPWR.n708 VGND 0.02906f
C1984 VPWR.t80 VGND 0.99356f
C1985 VPWR.t134 VGND 0.02365f
C1986 VPWR.t228 VGND 0.02279f
C1987 VPWR.n709 VGND 0.02438f
C1988 VPWR.t873 VGND 0.02186f
C1989 VPWR.n710 VGND 0.02918f
C1990 VPWR.t229 VGND 0.02389f
C1991 VPWR.n712 VGND 0.02022f
C1992 VPWR.t874 VGND 0.02389f
C1993 VPWR.n713 VGND 0.02015f
C1994 VPWR.t231 VGND 0.02434f
C1995 VPWR.n715 VGND 0.02438f
C1996 VPWR.t876 VGND 0.02389f
C1997 VPWR.n716 VGND 0.02022f
C1998 VPWR.t233 VGND 0.02389f
C1999 VPWR.n718 VGND 0.02022f
C2000 VPWR.t878 VGND 0.1987f
C2001 VPWR.n719 VGND 0.02022f
C2002 VPWR.t235 VGND 0.02389f
C2003 VPWR.n721 VGND 0.02022f
C2004 VPWR.t1562 VGND 0.02389f
C2005 VPWR.n722 VGND 0.02022f
C2006 VPWR.t1564 VGND 0.02389f
C2007 VPWR.n724 VGND 0.02022f
C2008 VPWR.t237 VGND 0.02389f
C2009 VPWR.n726 VGND 0.02575f
C2010 VPWR.t1566 VGND 0.94026f
C2011 VPWR.n727 VGND 0.02575f
C2012 VPWR.t1568 VGND 0.02389f
C2013 VPWR.n729 VGND 0.02022f
C2014 VPWR.t239 VGND 1.17421f
C2015 VPWR.n730 VGND 0.02022f
C2016 VPWR.t1570 VGND 0.02389f
C2017 VPWR.n732 VGND 0.02199f
C2018 VPWR.t241 VGND 0.37352f
C2019 VPWR.n733 VGND 0.02022f
C2020 VPWR.t243 VGND 0.48937f
C2021 VPWR.t4 VGND 0.53267f
C2022 VPWR.n735 VGND 0.41875f
C2023 VPWR.t149 VGND 0.5331f
C2024 VPWR.t136 VGND 1.84002f
C2025 VPWR.n736 VGND 0.36954f
C2026 VPWR.t195 VGND 0.26386f
C2027 VPWR.t1116 VGND 0.64492f
C2028 VPWR.n738 VGND 0.08249f
C2029 VPWR.t423 VGND 9.89263f
C2030 VPWR.n739 VGND 0.02855f
C2031 VPWR.n740 VGND 0.03158f
C2032 VPWR.t422 VGND 0.24757f
C2033 VPWR.n742 VGND 0.03731f
C2034 VPWR.t84 VGND 0.17654f
C2035 VPWR.t1210 VGND 0.02395f
C2036 VPWR.t83 VGND 0.07576f
C2037 VPWR.t672 VGND 1.81624f
C2038 VPWR.n744 VGND 0.02491f
C2039 VPWR.n745 VGND 0.02792f
C2040 VPWR.t670 VGND 0.1351f
C2041 VPWR.t1337 VGND 1.00262f
C2042 VPWR.n747 VGND 0.02583f
C2043 VPWR.n748 VGND 0.02271f
C2044 VPWR.t668 VGND 0.02389f
C2045 VPWR.t1335 VGND 0.02389f
C2046 VPWR.n750 VGND 0.02216f
C2047 VPWR.n751 VGND 0.02209f
C2048 VPWR.t667 VGND 0.02186f
C2049 VPWR.t1333 VGND 0.02434f
C2050 VPWR.n753 VGND 0.02687f
C2051 VPWR.n754 VGND 0.02589f
C2052 VPWR.t1331 VGND 0.02389f
C2053 VPWR.n756 VGND 0.02834f
C2054 VPWR.t1212 VGND 0.02389f
C2055 VPWR.n757 VGND 0.02028f
C2056 VPWR.t86 VGND 0.11895f
C2057 VPWR.n759 VGND 0.02991f
C2058 VPWR.t87 VGND 0.01961f
C2059 VPWR.t1214 VGND 1.01418f
C2060 VPWR.n761 VGND 0.02081f
C2061 VPWR.n762 VGND 0.03192f
C2062 VPWR.t1216 VGND 0.0795f
C2063 VPWR.t1218 VGND 0.02389f
C2064 VPWR.t88 VGND 0.02105f
C2065 VPWR.t90 VGND 0.0196f
C2066 VPWR.n763 VGND 0.02452f
C2067 VPWR.t1220 VGND 0.02434f
C2068 VPWR.n765 VGND 0.0287f
C2069 VPWR.t1222 VGND 0.02389f
C2070 VPWR.n767 VGND 0.02903f
C2071 VPWR.t1224 VGND 0.91896f
C2072 VPWR.t135 VGND 2.56894f
C2073 VPWR.n769 VGND 0.02292f
C2074 VPWR.n770 VGND 0.02747f
C2075 VPWR.t1338 VGND 0.87607f
C2076 VPWR.t420 VGND 0.94865f
C2077 VPWR.n772 VGND 0.02627f
C2078 VPWR.t1339 VGND 1.42285f
C2079 VPWR.t1115 VGND 0.4899f
C2080 VPWR.t421 VGND 1.17806f
C2081 VPWR.t1118 VGND 0.17329f
C2082 VPWR.t424 VGND 9.89407f
C2083 VPWR.n773 VGND 0.08865f
C2084 VPWR.n774 VGND 0.07169f
C2085 VPWR.t426 VGND 0.0196f
C2086 VPWR.t315 VGND 0.70975f
C2087 VPWR.t201 VGND 0.36792f
C2088 VPWR.t1329 VGND 0.02481f
C2089 VPWR.t419 VGND 0.01883f
C2090 VPWR.n776 VGND 0.05314f
C2091 VPWR.t1323 VGND 0.02395f
C2092 VPWR.t415 VGND 0.07737f
C2093 VPWR.t414 VGND 0.01978f
C2094 VPWR.t598 VGND 0.02389f
C2095 VPWR.n777 VGND 0.02647f
C2096 VPWR.n778 VGND 0.02792f
C2097 VPWR.t596 VGND 1.46168f
C2098 VPWR.t413 VGND 0.04944f
C2099 VPWR.n780 VGND 0.02662f
C2100 VPWR.n781 VGND 0.02469f
C2101 VPWR.t1113 VGND 0.01961f
C2102 VPWR.t406 VGND 0.01961f
C2103 VPWR.n785 VGND 0.04735f
C2104 VPWR.t1105 VGND 0.19442f
C2105 VPWR.t573 VGND 0.01961f
C2106 VPWR.n789 VGND 0.05251f
C2107 VPWR.t1104 VGND 0.07575f
C2108 VPWR.t572 VGND 0.0196f
C2109 VPWR.n791 VGND 0.05336f
C2110 VPWR.t1101 VGND 0.32677f
C2111 VPWR.t569 VGND 0.01961f
C2112 VPWR.n793 VGND 0.05408f
C2113 VPWR.t1102 VGND 0.38436f
C2114 VPWR.n794 VGND 0.08863f
C2115 VPWR.t570 VGND 0.02105f
C2116 VPWR.n795 VGND 0.08865f
C2117 VPWR.n796 VGND 0.07513f
C2118 VPWR.t1106 VGND 0.19586f
C2119 VPWR.n798 VGND 0.08863f
C2120 VPWR.t574 VGND 0.0772f
C2121 VPWR.n799 VGND 0.08865f
C2122 VPWR.n800 VGND 0.07184f
C2123 VPWR.t1108 VGND 0.0196f
C2124 VPWR.t576 VGND 0.07575f
C2125 VPWR.n802 VGND 0.05336f
C2126 VPWR.t1109 VGND 0.06331f
C2127 VPWR.t577 VGND 0.01961f
C2128 VPWR.n804 VGND 0.05251f
C2129 VPWR.t1110 VGND 0.17705f
C2130 VPWR.n805 VGND 0.08863f
C2131 VPWR.t404 VGND 0.02105f
C2132 VPWR.n806 VGND 0.08865f
C2133 VPWR.n807 VGND 0.07184f
C2134 VPWR.t1112 VGND 0.1319f
C2135 VPWR.t405 VGND 0.0196f
C2136 VPWR.n810 VGND 0.04797f
C2137 VPWR.t1114 VGND 3.07587f
C2138 VPWR.n812 VGND 0.08863f
C2139 VPWR.t407 VGND 0.04884f
C2140 VPWR.n813 VGND 0.08865f
C2141 VPWR.n814 VGND 0.07184f
C2142 VPWR.t1608 VGND 3.07443f
C2143 VPWR.t409 VGND 0.04739f
C2144 VPWR.n816 VGND 0.05336f
C2145 VPWR.t410 VGND 0.07576f
C2146 VPWR.n817 VGND 0.02975f
C2147 VPWR.t594 VGND 0.02395f
C2148 VPWR.t411 VGND 0.10704f
C2149 VPWR.n819 VGND 0.08865f
C2150 VPWR.n820 VGND 0.06174f
C2151 VPWR.t593 VGND 0.02186f
C2152 VPWR.n821 VGND 0.02445f
C2153 VPWR.t1325 VGND 0.02389f
C2154 VPWR.t417 VGND 0.07575f
C2155 VPWR.t418 VGND 0.0196f
C2156 VPWR.t1327 VGND 0.02389f
C2157 VPWR.n823 VGND 0.41875f
C2158 VPWR.n824 VGND 0.41875f
C2159 VPWR.n827 VGND 0.41875f
C2160 VPWR.t965 VGND 0.0196f
C2161 VPWR.t44 VGND 0.07575f
C2162 VPWR.n828 VGND 0.04797f
C2163 VPWR.n829 VGND 0.52273f
C2164 VPWR.t745 VGND 0.02412f
C2165 VPWR.t531 VGND 0.02389f
C2166 VPWR.n831 VGND 0.0437f
C2167 VPWR.t744 VGND 0.04081f
C2168 VPWR.t530 VGND 0.02389f
C2169 VPWR.n833 VGND 0.0435f
C2170 VPWR.t868 VGND 0.02389f
C2171 VPWR.t1426 VGND 0.02389f
C2172 VPWR.n835 VGND 0.0434f
C2173 VPWR.t866 VGND 0.02389f
C2174 VPWR.t1424 VGND 1.06028f
C2175 VPWR.n837 VGND 0.04326f
C2176 VPWR.t865 VGND 0.02186f
C2177 VPWR.t1423 VGND 0.02186f
C2178 VPWR.n839 VGND 0.05195f
C2179 VPWR.t864 VGND 0.49354f
C2180 VPWR.t896 VGND 1.02708f
C2181 VPWR.n841 VGND 0.05189f
C2182 VPWR.t862 VGND 0.13973f
C2183 VPWR.t894 VGND 0.02389f
C2184 VPWR.n843 VGND 0.04333f
C2185 VPWR.t860 VGND 0.02811f
C2186 VPWR.t892 VGND 0.02434f
C2187 VPWR.n845 VGND 0.04756f
C2188 VPWR.t775 VGND 0.08181f
C2189 VPWR.t890 VGND 0.02389f
C2190 VPWR.n847 VGND 0.0435f
C2191 VPWR.t773 VGND 0.25973f
C2192 VPWR.t888 VGND 1.10658f
C2193 VPWR.n849 VGND 0.0437f
C2194 VPWR.t771 VGND 0.97238f
C2195 VPWR.t886 VGND 0.02389f
C2196 VPWR.n851 VGND 0.04808f
C2197 VPWR.t962 VGND 0.01961f
C2198 VPWR.t41 VGND 0.01961f
C2199 VPWR.n855 VGND 0.05251f
C2200 VPWR.t961 VGND 0.1319f
C2201 VPWR.t40 VGND 0.1319f
C2202 VPWR.n857 VGND 0.05336f
C2203 VPWR.t954 VGND 0.01961f
C2204 VPWR.t443 VGND 0.01961f
C2205 VPWR.n859 VGND 0.05408f
C2206 VPWR.t955 VGND 0.02105f
C2207 VPWR.n861 VGND 0.08863f
C2208 VPWR.t444 VGND 0.0772f
C2209 VPWR.n862 VGND 0.08865f
C2210 VPWR.n863 VGND 0.07513f
C2211 VPWR.t957 VGND 0.0196f
C2212 VPWR.t446 VGND 0.07575f
C2213 VPWR.n865 VGND 0.05336f
C2214 VPWR.t958 VGND 0.01961f
C2215 VPWR.t447 VGND 0.01961f
C2216 VPWR.n867 VGND 0.05251f
C2217 VPWR.t959 VGND 0.13335f
C2218 VPWR.n868 VGND 0.08863f
C2219 VPWR.t39 VGND 0.13335f
C2220 VPWR.n869 VGND 0.08865f
C2221 VPWR.n870 VGND 0.07184f
C2222 VPWR.t963 VGND 0.02105f
C2223 VPWR.n872 VGND 0.08863f
C2224 VPWR.t42 VGND 0.0772f
C2225 VPWR.n873 VGND 0.08865f
C2226 VPWR.n874 VGND 0.07184f
C2227 VPWR.t966 VGND 0.01961f
C2228 VPWR.t45 VGND 0.04768f
C2229 VPWR.n876 VGND 0.04735f
C2230 VPWR.t967 VGND 0.02105f
C2231 VPWR.n877 VGND 0.08863f
C2232 VPWR.t46 VGND 0.12699f
C2233 VPWR.n878 VGND 0.08865f
C2234 VPWR.n879 VGND 0.07184f
C2235 VPWR.t971 VGND 0.0196f
C2236 VPWR.t1048 VGND 0.09747f
C2237 VPWR.n881 VGND 0.05737f
C2238 VPWR.t760 VGND 0.02279f
C2239 VPWR.t1226 VGND 0.02186f
C2240 VPWR.n883 VGND 0.05598f
C2241 VPWR.t761 VGND 0.02389f
C2242 VPWR.t1228 VGND 0.02494f
C2243 VPWR.n885 VGND 0.04333f
C2244 VPWR.t763 VGND 0.02434f
C2245 VPWR.t1230 VGND 0.02389f
C2246 VPWR.n887 VGND 0.04756f
C2247 VPWR.t765 VGND 0.02389f
C2248 VPWR.t881 VGND 0.02389f
C2249 VPWR.n889 VGND 0.0435f
C2250 VPWR.t767 VGND 0.02389f
C2251 VPWR.t882 VGND 0.02389f
C2252 VPWR.n891 VGND 0.0437f
C2253 VPWR.t769 VGND 0.02389f
C2254 VPWR.t884 VGND 0.02389f
C2255 VPWR.n892 VGND 0.04806f
C2256 VPWR.t747 VGND 1.26717f
C2257 VPWR.t533 VGND 0.02389f
C2258 VPWR.n894 VGND 0.04806f
C2259 VPWR.t749 VGND 0.02389f
C2260 VPWR.t535 VGND 0.02389f
C2261 VPWR.n896 VGND 0.04808f
C2262 VPWR.t751 VGND 0.02389f
C2263 VPWR.t537 VGND 0.02389f
C2264 VPWR.n898 VGND 0.0437f
C2265 VPWR.t753 VGND 0.02389f
C2266 VPWR.t539 VGND 0.02389f
C2267 VPWR.n900 VGND 0.0435f
C2268 VPWR.t755 VGND 0.02434f
C2269 VPWR.t541 VGND 0.02434f
C2270 VPWR.n902 VGND 0.05172f
C2271 VPWR.t757 VGND 0.02389f
C2272 VPWR.t543 VGND 0.02389f
C2273 VPWR.n904 VGND 0.0434f
C2274 VPWR.t759 VGND 0.02279f
C2275 VPWR.t545 VGND 0.02279f
C2276 VPWR.n906 VGND 0.05377f
C2277 VPWR.t1590 VGND 2.0099f
C2278 VPWR.t29 VGND 8.05689f
C2279 VPWR.t381 VGND 14.5673f
C2280 VPWR.n909 VGND 0.41875f
C2281 VPWR.n910 VGND 0.03046f
C2282 VPWR.n911 VGND 0.22654f
C2283 VPWR.t52 VGND 0.0196f
C2284 VPWR.t1004 VGND 5.23897f
C2285 VPWR.n913 VGND 0.04797f
C2286 VPWR.t54 VGND 2.06088f
C2287 VPWR.n915 VGND 0.08863f
C2288 VPWR.t1006 VGND 0.02105f
C2289 VPWR.n916 VGND 0.08865f
C2290 VPWR.n917 VGND 0.07184f
C2291 VPWR.t1050 VGND 2.05944f
C2292 VPWR.t1594 VGND 0.0196f
C2293 VPWR.n918 VGND 0.05737f
C2294 VPWR.t498 VGND 0.02389f
C2295 VPWR.t780 VGND 0.02389f
C2296 VPWR.n920 VGND 0.04806f
C2297 VPWR.t500 VGND 0.02389f
C2298 VPWR.t782 VGND 0.02389f
C2299 VPWR.n922 VGND 0.04808f
C2300 VPWR.t502 VGND 0.02751f
C2301 VPWR.t784 VGND 0.02389f
C2302 VPWR.n924 VGND 0.0437f
C2303 VPWR.t504 VGND 0.02389f
C2304 VPWR.t786 VGND 0.02389f
C2305 VPWR.n926 VGND 0.0435f
C2306 VPWR.t564 VGND 1.97211f
C2307 VPWR.t788 VGND 0.02434f
C2308 VPWR.n928 VGND 0.04756f
C2309 VPWR.t566 VGND 0.02389f
C2310 VPWR.t790 VGND 0.02389f
C2311 VPWR.n930 VGND 0.04333f
C2312 VPWR.t568 VGND 0.02186f
C2313 VPWR.t792 VGND 0.02279f
C2314 VPWR.n932 VGND 0.05189f
C2315 VPWR.t897 VGND 0.02186f
C2316 VPWR.n933 VGND 0.02918f
C2317 VPWR.t898 VGND 0.02389f
C2318 VPWR.n935 VGND 0.02015f
C2319 VPWR.t793 VGND 0.02279f
C2320 VPWR.n936 VGND 0.02438f
C2321 VPWR.t900 VGND 0.02389f
C2322 VPWR.n938 VGND 0.02022f
C2323 VPWR.t794 VGND 0.02389f
C2324 VPWR.n939 VGND 0.02022f
C2325 VPWR.t168 VGND 1.89248f
C2326 VPWR.n941 VGND 0.02022f
C2327 VPWR.t796 VGND 0.05672f
C2328 VPWR.n942 VGND 0.02438f
C2329 VPWR.t169 VGND 0.02389f
C2330 VPWR.n944 VGND 0.02022f
C2331 VPWR.t798 VGND 0.94678f
C2332 VPWR.n945 VGND 0.02022f
C2333 VPWR.t171 VGND 0.02389f
C2334 VPWR.n947 VGND 0.02022f
C2335 VPWR.t800 VGND 0.02389f
C2336 VPWR.n948 VGND 0.02022f
C2337 VPWR.t804 VGND 0.02389f
C2338 VPWR.n950 VGND 0.02022f
C2339 VPWR.t173 VGND 0.02389f
C2340 VPWR.n951 VGND 0.02575f
C2341 VPWR.t806 VGND 0.02389f
C2342 VPWR.n953 VGND 0.02022f
C2343 VPWR.t175 VGND 0.02389f
C2344 VPWR.n954 VGND 0.02022f
C2345 VPWR.t808 VGND 0.02389f
C2346 VPWR.n956 VGND 0.02022f
C2347 VPWR.t177 VGND 0.02389f
C2348 VPWR.n957 VGND 0.02022f
C2349 VPWR.t1578 VGND 0.55653f
C2350 VPWR.n959 VGND 0.02022f
C2351 VPWR.t179 VGND 0.02434f
C2352 VPWR.n960 VGND 0.02438f
C2353 VPWR.t1580 VGND 0.02389f
C2354 VPWR.n962 VGND 0.02015f
C2355 VPWR.t181 VGND 0.02389f
C2356 VPWR.n963 VGND 0.02022f
C2357 VPWR.t1582 VGND 0.02186f
C2358 VPWR.n965 VGND 0.02445f
C2359 VPWR.t183 VGND 0.02279f
C2360 VPWR.n966 VGND 0.02438f
C2361 VPWR.t219 VGND 0.28298f
C2362 VPWR.t32 VGND 0.93662f
C2363 VPWR.t34 VGND 0.38124f
C2364 VPWR.t20 VGND 17.4961f
C2365 VPWR.n968 VGND 0.22654f
C2366 VPWR.n969 VGND 0.01329f
C2367 VPWR.n970 VGND 0.03046f
C2368 VPWR.n971 VGND 2.76948f
C2369 VPWR.n973 VGND 0.50319f
C2370 VPWR.n974 VGND 0.2631f
C2371 VPWR.n975 VGND 0.16562f
C2372 VPWR.n976 VGND 0.02659f
C2373 VPWR.n977 VGND 0.01329f
C2374 VPWR.n978 VGND 0.56719f
.ends
