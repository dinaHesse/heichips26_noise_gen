* PEX produced on Fri Aug  7 15:48:38 CEST 2026 using scripts/sak-pex.sh with m=3 and s=1 (extresist threshold=10000 mOhm, minres=1000 mOhm, mindelay=1 ps)
* NGSPICE file created from config_glitch_pex.ext - technology: ihp-sg13cmos5l

.subckt config_glitch_pex VPWR VGND enable out_xor[0] out_xor[1] out_xor[2]
+ out_xor[3] out_xor[4] out_xor[5] out_xor[6] out_xor[7] glitch_en[0]
+ glitch_en[1] glitch_en[2] glitch_en[3] glitch_en[4] glitch_en[5] glitch_en[6]
X0 a_3668_9156# sg13cmos5l_buf_16_14.A VGND.t66 VGND.t70 sg13_lv_nmos ad=0.1406p pd=1.12u as=0.1406p ps=1.12u w=0.74u l=0.13u
X1 sg13cmos5l_buf_1_14.X a_14344_8468# VGND.t35 VGND.t64 sg13_lv_nmos ad=0.2886p pd=2.26u as=0.14875p ps=1.16u w=0.74u l=0.13u
X2 VGND.t726 VPWR.t16 VGND.t726 VGND.t2 sg13_lv_nmos ad=0.1428p pd=1.52u as=0 ps=0 w=0.42u l=1u
X3 sg13cmos5l_buf_16_37.X a_7796_12934# VGND.t590 VGND.t696 sg13_lv_nmos ad=0.1406p pd=1.12u as=0.1406p ps=1.12u w=0.74u l=0.13u
X4 VGND.t841 VPWR.t1692 VGND.t841 VGND.t928 sg13_lv_nmos ad=0.1428p pd=1.52u as=0 ps=0 w=0.42u l=1u
X5 VPWR.t81 a_13667_12956# sg13cmos5l_buf_1_17.A VPWR.t79 sg13_lv_pmos ad=0.1918p pd=1.5u as=0.2128p ps=1.5u w=1.12u l=0.13u
X6 sg13cmos5l_buf_16_30.A a_6164_2350# VPWR.t1547 VPWR.t67 sg13_lv_pmos ad=0.2128p pd=1.5u as=0.2128p ps=1.5u w=1.12u l=0.13u
X7 VPWR.t904 a_3694_7680# sg13cmos5l_buf_16_34.X VPWR.t58 sg13_lv_pmos ad=0.3976p pd=2.95u as=0.2128p ps=1.5u w=1.12u l=0.13u
X8 a_6836_9156# sg13cmos5l_and2_2_6.X VPWR.t515 VPWR.t5 sg13_lv_pmos ad=0.2128p pd=1.5u as=0.2128p ps=1.5u w=1.12u l=0.13u
X9 VGND.t25 a_6164_2350# sg13cmos5l_buf_16_30.A VGND.t1556 sg13_lv_nmos ad=0.1406p pd=1.12u as=0.1406p ps=1.12u w=0.74u l=0.13u
X10 VGND.t870 a_4174_13728# sg13cmos5l_buf_16_18.A VGND.t1436 sg13_lv_nmos ad=0.1406p pd=1.12u as=0.1406p ps=1.12u w=0.74u l=0.13u
X11 VGND.t891 a_4174_13728# sg13cmos5l_buf_16_18.A VGND.t1448 sg13_lv_nmos ad=0.1406p pd=1.12u as=0.1406p ps=1.12u w=0.74u l=0.13u
X12 VPWR.t216 a_8494_3144# sg13cmos5l_buf_16_39.A VPWR.t67 sg13_lv_pmos ad=0.2128p pd=1.5u as=0.2128p ps=1.5u w=1.12u l=0.13u
X13 VGND.t41 VPWR.t113 VGND.t41 VGND.t40 sg13_lv_nmos ad=0.1428p pd=1.52u as=0 ps=0 w=0.42u l=1u
X14 sg13cmos5l_buf_16_37.A a_8948_13692# VGND.t597 VGND.t656 sg13_lv_nmos ad=0.1406p pd=1.12u as=0.1406p ps=1.12u w=0.74u l=0.13u
X15 VGND.t590 a_10292_12934# sg13cmos5l_buf_16_23.X VGND.t667 sg13_lv_nmos ad=0.1406p pd=1.12u as=0.1406p ps=1.12u w=0.74u l=0.13u
X16 VGND.t1298 VPWR.t63 VGND.t1298 VGND.t1334 sg13_lv_nmos ad=79.8f pd=0.8u as=0 ps=0 w=0.42u l=1u
X17 sg13cmos5l_buf_16_38.A a_8110_6168# VPWR.t61 VPWR.t61 sg13_lv_pmos ad=0.2128p pd=1.5u as=0.2128p ps=1.5u w=1.12u l=0.13u
X18 VGND.t1196 VPWR.t1622 VGND.t1196 VGND.t1199 sg13_lv_nmos ad=79.8f pd=0.8u as=0 ps=0 w=0.42u l=1u
X19 VGND.t1167 VPWR.t62 VGND.t1167 VGND.t1191 sg13_lv_nmos ad=0.1428p pd=1.52u as=0 ps=0 w=0.42u l=1u
X20 VGND.t620 sg13cmos5l_buf_16_24.X a_6161_12574# VGND.t624 sg13_lv_nmos ad=0.15245p pd=1.17u as=0.17462p ps=1.185u w=0.55u l=0.13u
X21 VPWR.t1200 a_3694_10704# sg13cmos5l_and2_2_6.A VPWR.t2 sg13_lv_pmos ad=0.2128p pd=1.5u as=0.2128p ps=1.5u w=1.12u l=0.13u
X22 VGND.t870 a_3694_14482# sg13cmos5l_buf_16_33.A VGND.t878 sg13_lv_nmos ad=0.1406p pd=1.12u as=0.1406p ps=1.12u w=0.74u l=0.13u
X23 VPWR.t1042 VGND.t898 VPWR.t1040 VPWR.t79 sg13_lv_pmos ad=0.19p pd=1.38u as=0 ps=0 w=1u l=1u
X24 VPWR.t81 VGND.t924 VPWR.t81 VPWR.t79 sg13_lv_pmos ad=0.19p pd=1.38u as=0 ps=0 w=1u l=1u
X25 VPWR.t13 VGND.t726 VPWR.t12 VPWR.t8 sg13_lv_pmos ad=0.34p pd=2.68u as=0 ps=0 w=1u l=1u
X26 VPWR.t1287 a_3668_4620# sg13cmos5l_buf_16_8.A VPWR.t64 sg13_lv_pmos ad=0.2128p pd=1.5u as=0.2128p ps=1.5u w=1.12u l=0.13u
X27 sg13cmos5l_buf_16_34.X a_3694_7680# VPWR.t900 VPWR.t58 sg13_lv_pmos ad=0.2128p pd=1.5u as=0.2128p ps=1.5u w=1.12u l=0.13u
X28 sg13cmos5l_buf_16_30.A a_6164_2350# VGND.t25 VGND.t1553 sg13_lv_nmos ad=0.1406p pd=1.12u as=0.1406p ps=1.12u w=0.74u l=0.13u
X29 sg13cmos5l_buf_16_28.X a_5684_6132# VGND.t218 VGND.t224 sg13_lv_nmos ad=0.1406p pd=1.12u as=0.1406p ps=1.12u w=0.74u l=0.13u
X30 VPWR.t1153 a_7796_12934# sg13cmos5l_buf_16_37.X VPWR.t79 sg13_lv_pmos ad=0.2128p pd=1.5u as=0.2128p ps=1.5u w=1.12u l=0.13u
X31 VPWR.t6 VGND.t1061 VPWR.t6 VPWR.t5 sg13_lv_pmos ad=0.19p pd=1.38u as=0 ps=0 w=1u l=1u
X32 sg13cmos5l_buf_1_2.X a_8104_1632# VPWR.t205 VPWR.t55 sg13_lv_pmos ad=0.42p pd=2.99u as=0.2114p ps=1.54u w=1.12u l=0.13u
X33 sg13cmos5l_buf_1_17.X a_12232_12216# VGND.t237 VGND.t417 sg13_lv_nmos ad=0.2886p pd=2.26u as=0.14875p ps=1.16u w=0.74u l=0.13u
X34 VPWR.t61 a_8110_6168# sg13cmos5l_buf_16_38.A VPWR.t61 sg13_lv_pmos ad=0.2128p pd=1.5u as=0.2128p ps=1.5u w=1.12u l=0.13u
X35 sg13cmos5l_buf_16_4.X a_9524_6886# VGND.t210 VGND.t563 sg13_lv_nmos ad=0.1406p pd=1.12u as=0.1406p ps=1.12u w=0.74u l=0.13u
X36 a_6129_12216# sg13cmos5l_buf_16_15.A VPWR.t1168 VPWR.t8 sg13_lv_pmos ad=0.1225p pd=1.245u as=0.36p ps=2.72u w=1u l=0.13u
X37 VGND.t870 sg13cmos5l_and2_2_1.X a_4174_13728# VGND.t1471 sg13_lv_nmos ad=0.1406p pd=1.12u as=0.1406p ps=1.12u w=0.74u l=0.13u
X38 sg13cmos5l_buf_16_8.A a_3668_4620# VPWR.t1283 VPWR.t64 sg13_lv_pmos ad=0.2128p pd=1.5u as=0.2128p ps=1.5u w=1.12u l=0.13u
X39 VGND.t5 VPWR.t1654 VGND.t5 VGND.t1102 sg13_lv_nmos ad=0.1428p pd=1.52u as=0 ps=0 w=0.42u l=1u
X40 VPWR.t86 VGND.t194 VPWR.t86 VPWR.t55 sg13_lv_pmos ad=0.34p pd=2.68u as=0 ps=0 w=1u l=1u
X41 sg13cmos5l_buf_16_35.A a_6766_8434# VGND.t15 VGND.t287 sg13_lv_nmos ad=0.1406p pd=1.12u as=0.1406p ps=1.12u w=0.74u l=0.13u
X42 VGND.t210 a_9524_6886# sg13cmos5l_buf_16_4.X VGND.t560 sg13_lv_nmos ad=0.1406p pd=1.12u as=0.1406p ps=1.12u w=0.74u l=0.13u
X43 VPWR.t58 VGND.t1167 VPWR.t59 VPWR.t58 sg13_lv_pmos ad=0.19p pd=1.38u as=0 ps=0 w=1u l=1u
X44 VGND.t1050 VPWR.t1664 VGND.t1050 VGND.t1051 sg13_lv_nmos ad=79.8f pd=0.8u as=0 ps=0 w=0.42u l=1u
X45 sg13cmos5l_buf_16_38.A a_8110_6168# VPWR.t61 VPWR.t61 sg13_lv_pmos ad=0.2128p pd=1.5u as=0.2128p ps=1.5u w=1.12u l=0.13u
X46 VPWR.t557 sg13cmos5l_buf_16_34.X a_3694_10704# VPWR.t2 sg13_lv_pmos ad=0.2128p pd=1.5u as=0.2128p ps=1.5u w=1.12u l=0.13u
X47 VPWR.t120 VGND.t1298 VPWR.t120 VPWR.t67 sg13_lv_pmos ad=0.19p pd=1.38u as=0 ps=0 w=1u l=1u
X48 VGND.t5 VPWR.t1650 VGND.t5 VGND.t1101 sg13_lv_nmos ad=79.8f pd=0.8u as=0 ps=0 w=0.42u l=1u
X49 VPWR.t1442 sg13cmos5l_buf_16_37.X a_6548_13692# VPWR.t79 sg13_lv_pmos ad=0.3808p pd=2.92u as=0.2128p ps=1.5u w=1.12u l=0.13u
X50 VPWR.t205 VGND.t1375 VPWR.t986 VPWR.t55 sg13_lv_pmos ad=0.19p pd=1.38u as=0 ps=0 w=1u l=1u
X51 VGND.t125 a_6094_3898# sg13cmos5l_buf_16_0.A VGND.t40 sg13_lv_nmos ad=0.1406p pd=1.12u as=0.1406p ps=1.12u w=0.74u l=0.13u
X52 VGND.t61 VPWR.t1646 VGND.t61 VGND.t1109 sg13_lv_nmos ad=0.1428p pd=1.52u as=0 ps=0 w=0.42u l=1u
X53 VPWR.t1149 a_7796_12934# sg13cmos5l_buf_16_37.X VPWR.t79 sg13_lv_pmos ad=0.2128p pd=1.5u as=0.2128p ps=1.5u w=1.12u l=0.13u
X54 VPWR.t1281 a_3668_4620# sg13cmos5l_buf_16_8.A VPWR.t64 sg13_lv_pmos ad=0.2128p pd=1.5u as=0.2128p ps=1.5u w=1.12u l=0.13u
X55 VPWR.t85 VGND.t214 VPWR.t85 VPWR.t61 sg13_lv_pmos ad=0.19p pd=1.38u as=0 ps=0 w=1u l=1u
X56 a_6862_9946# sg13cmos5l_buf_16_24.A VGND.t66 VGND.t153 sg13_lv_nmos ad=0.1406p pd=1.12u as=0.2516p ps=2.16u w=0.74u l=0.13u
X57 sg13cmos5l_buf_16_34.X a_3694_7680# VPWR.t896 VPWR.t58 sg13_lv_pmos ad=0.2128p pd=1.5u as=0.2128p ps=1.5u w=1.12u l=0.13u
X58 VPWR.t1037 VGND.t898 VPWR.t1036 VPWR.t0 sg13_lv_pmos ad=0.34p pd=2.68u as=0 ps=0 w=1u l=1u
X59 VGND.t15 a_6766_8434# sg13cmos5l_buf_16_35.A VGND.t284 sg13_lv_nmos ad=0.1406p pd=1.12u as=0.1406p ps=1.12u w=0.74u l=0.13u
X60 a_3668_9156# sg13cmos5l_buf_16_14.A VGND.t66 VGND.t65 sg13_lv_nmos ad=0.1406p pd=1.12u as=0.1406p ps=1.12u w=0.74u l=0.13u
X61 VGND.t35 sg13cmos5l_buf_1_23.A a_13768_7680# VGND.t34 sg13_lv_nmos ad=0.14875p pd=1.16u as=0.187p ps=1.78u w=0.55u l=0.13u
X62 sg13cmos5l_xor2_1_5.X a_9617_8484# a_9788_8728# VPWR.t5 sg13_lv_pmos ad=0.3808p pd=2.92u as=0.2128p ps=1.5u w=1.12u l=0.13u
X63 sg13cmos5l_buf_16_1.X a_10318_5410# VGND.t86 VGND.t91 sg13_lv_nmos ad=0.1406p pd=1.12u as=0.1406p ps=1.12u w=0.74u l=0.13u
X64 VPWR.t216 VGND.t1286 VPWR.t216 VPWR.t67 sg13_lv_pmos ad=0.34p pd=2.68u as=0 ps=0 w=1u l=1u
X65 VGND.t1292 VPWR.t126 VGND.t1292 VGND.t1328 sg13_lv_nmos ad=79.8f pd=0.8u as=0 ps=0 w=0.42u l=1u
X66 sg13cmos5l_buf_16_25.A a_6836_9156# VPWR.t511 VPWR.t5 sg13_lv_pmos ad=0.2128p pd=1.5u as=0.2128p ps=1.5u w=1.12u l=0.13u
X67 VGND.t214 VPWR.t96 VGND.t214 VGND.t1185 sg13_lv_nmos ad=0.1428p pd=1.52u as=0 ps=0 w=0.42u l=1u
X68 VGND.t1274 VPWR.t1611 VGND.t1274 VGND.t1273 sg13_lv_nmos ad=0.1428p pd=1.52u as=0 ps=0 w=0.42u l=1u
X69 VPWR.t566 a_10292_12934# sg13cmos5l_buf_16_23.X VPWR.t79 sg13_lv_pmos ad=0.2128p pd=1.5u as=0.2128p ps=1.5u w=1.12u l=0.13u
X70 VGND.t1292 VPWR.t117 VGND.t1296 VGND.t1295 sg13_lv_nmos ad=79.8f pd=0.8u as=0 ps=0 w=0.42u l=1u
X71 VPWR.t135 VGND.t3 VPWR.t135 VPWR.t2 sg13_lv_pmos ad=0.34p pd=2.68u as=0 ps=0 w=1u l=1u
X72 a_6766_8434# sg13cmos5l_buf_16_25.A VGND.t61 VGND.t280 sg13_lv_nmos ad=0.1406p pd=1.12u as=0.1406p ps=1.12u w=0.74u l=0.13u
X73 sg13cmos5l_and2_2_6.A a_3694_10704# VGND.t134 VGND.t2 sg13_lv_nmos ad=0.1406p pd=1.12u as=0.1406p ps=1.12u w=0.74u l=0.13u
X74 VGND.t302 a_8494_3144# sg13cmos5l_buf_16_39.A VGND.t40 sg13_lv_nmos ad=0.1406p pd=1.12u as=0.1406p ps=1.12u w=0.74u l=0.13u
X75 VPWR.t1438 sg13cmos5l_buf_16_37.X a_6548_13692# VPWR.t79 sg13_lv_pmos ad=0.2128p pd=1.5u as=0.2128p ps=1.5u w=1.12u l=0.13u
X76 VPWR.t1541 a_3694_3898# sg13cmos5l_buf_16_10.A VPWR.t64 sg13_lv_pmos ad=0.3976p pd=2.95u as=0.2128p ps=1.5u w=1.12u l=0.13u
X77 sg13cmos5l_buf_16_23.X a_10292_12934# VGND.t590 VGND.t670 sg13_lv_nmos ad=0.1406p pd=1.12u as=0.1406p ps=1.12u w=0.74u l=0.13u
X78 a_10292_12934# sg13cmos5l_buf_1_17.A VGND.t237 VGND.t240 sg13_lv_nmos ad=0.1406p pd=1.12u as=0.1406p ps=1.12u w=0.74u l=0.13u
X79 VGND.t86 a_10318_5410# sg13cmos5l_buf_16_1.X VGND.t88 sg13_lv_nmos ad=0.1406p pd=1.12u as=0.1406p ps=1.12u w=0.74u l=0.13u
X80 VGND.t924 VPWR.t81 VGND.t924 VGND.t937 sg13_lv_nmos ad=0.1428p pd=1.52u as=0 ps=0 w=0.42u l=1u
X81 VGND.t260 VPWR.t1661 VGND.t260 VGND.t1056 sg13_lv_nmos ad=0.1428p pd=1.52u as=0 ps=0 w=0.42u l=1u
X82 VGND.t351 sg13cmos5l_buf_16_11.A a_3668_4620# VGND.t1562 sg13_lv_nmos ad=0.1406p pd=1.12u as=0.1406p ps=1.12u w=0.74u l=0.13u
X83 VPWR.t663 a_6766_8434# sg13cmos5l_buf_16_35.A VPWR.t5 sg13_lv_pmos ad=0.2128p pd=1.5u as=0.2128p ps=1.5u w=1.12u l=0.13u
X84 VPWR.t312 sg13cmos5l_buf_16_14.A a_6332_9192# VPWR.t5 sg13_lv_pmos ad=0.2128p pd=1.5u as=0.3808p ps=2.92u w=1.12u l=0.13u
X85 VGND.t1107 VPWR.t1647 VGND.t5 VGND.t1106 sg13_lv_nmos ad=0.1428p pd=1.52u as=0 ps=0 w=0.42u l=1u
X86 VPWR.t1012 a_14444_14442# sg13cmos5l_and2_2_4.B VPWR.t0 sg13_lv_pmos ad=0.2114p pd=1.54u as=0.42p ps=2.99u w=1.12u l=0.13u
X87 VPWR.t165 VGND.t682 VPWR.t164 VPWR.t79 sg13_lv_pmos ad=0.34p pd=2.68u as=0 ps=0 w=1u l=1u
X88 VPWR.t156 VGND.t1274 VPWR.t55 VPWR.t55 sg13_lv_pmos ad=0.34p pd=2.68u as=0 ps=0 w=1u l=1u
X89 VGND.t845 a_5108_838# sg13cmos5l_buf_16_5.X VGND.t1461 sg13_lv_nmos ad=0.1406p pd=1.12u as=0.1406p ps=1.12u w=0.74u l=0.13u
X90 sg13cmos5l_buf_16_10.A a_3694_3898# VPWR.t1537 VPWR.t64 sg13_lv_pmos ad=0.2128p pd=1.5u as=0.2128p ps=1.5u w=1.12u l=0.13u
X91 VGND.t5 a_9262_7680# sg13cmos5l_buf_16_2.A VGND.t111 sg13_lv_nmos ad=0.1406p pd=1.12u as=0.1406p ps=1.12u w=0.74u l=0.13u
X92 VGND.t310 sg13cmos5l_buf_16_8.A a_3694_3898# VGND.t40 sg13_lv_nmos ad=0.1406p pd=1.12u as=0.1406p ps=1.12u w=0.74u l=0.13u
X93 sg13cmos5l_buf_16_1.X a_10318_5410# VGND.t76 VGND.t84 sg13_lv_nmos ad=0.1406p pd=1.12u as=0.1406p ps=1.12u w=0.74u l=0.13u
X94 VGND.t1010 VPWR.t21 VGND.t1010 VGND.t2 sg13_lv_nmos ad=79.8f pd=0.8u as=0 ps=0 w=0.42u l=1u
X95 sg13cmos5l_buf_16_35.A a_6766_8434# VPWR.t659 VPWR.t5 sg13_lv_pmos ad=0.2128p pd=1.5u as=0.2128p ps=1.5u w=1.12u l=0.13u
X96 VPWR.t566 a_10292_12934# sg13cmos5l_buf_16_23.X VPWR.t79 sg13_lv_pmos ad=0.2128p pd=1.5u as=0.2128p ps=1.5u w=1.12u l=0.13u
X97 VPWR.t3 VGND.t1010 VPWR.t3 VPWR.t2 sg13_lv_pmos ad=0.34p pd=2.68u as=0 ps=0 w=1u l=1u
X98 VGND.t1010 VPWR.t3 VGND.t1010 VGND.t2 sg13_lv_nmos ad=79.8f pd=0.8u as=0 ps=0 w=0.42u l=1u
X99 sg13cmos5l_buf_16_13.A a_3668_9156# VPWR.t646 VPWR.t5 sg13_lv_pmos ad=0.2128p pd=1.5u as=0.2128p ps=1.5u w=1.12u l=0.13u
X100 sg13cmos5l_buf_16_5.X a_5108_838# VGND.t845 VGND.t1456 sg13_lv_nmos ad=0.1406p pd=1.12u as=0.1406p ps=1.12u w=0.74u l=0.13u
X101 VPWR.t96 a_10318_5410# sg13cmos5l_buf_16_1.X VPWR.t61 sg13_lv_pmos ad=0.2128p pd=1.5u as=0.2128p ps=1.5u w=1.12u l=0.13u
X102 VGND.t994 VPWR.t1674 VGND.t994 VGND.t2 sg13_lv_nmos ad=0.1428p pd=1.52u as=0 ps=0 w=0.42u l=1u
X103 sg13cmos5l_buf_16_5.X a_5108_838# VPWR.t56 VPWR.t55 sg13_lv_pmos ad=0.2128p pd=1.5u as=0.2128p ps=1.5u w=1.12u l=0.13u
X104 VPWR.t469 sg13cmos5l_buf_16_10.A a_3668_3108# VPWR.t67 sg13_lv_pmos ad=0.2128p pd=1.5u as=0.2128p ps=1.5u w=1.12u l=0.13u
X105 VPWR.t1404 a_6548_13692# sg13cmos5l_buf_16_27.X VPWR.t79 sg13_lv_pmos ad=0.2128p pd=1.5u as=0.2128p ps=1.5u w=1.12u l=0.13u
X106 VGND.t171 a_7220_5374# sg13cmos5l_buf_16_28.A VGND.t333 sg13_lv_nmos ad=0.1406p pd=1.12u as=0.1406p ps=1.12u w=0.74u l=0.13u
X107 sg13cmos5l_buf_16_2.A a_9262_7680# VGND.t5 VGND.t108 sg13_lv_nmos ad=0.1406p pd=1.12u as=0.1406p ps=1.12u w=0.74u l=0.13u
X108 sg13cmos5l_buf_16_20.A a_5204_11422# VPWR.t495 VPWR.t8 sg13_lv_pmos ad=0.2128p pd=1.5u as=0.2128p ps=1.5u w=1.12u l=0.13u
X109 VGND.t237 VPWR.t80 VGND.t513 VGND.t957 sg13_lv_nmos ad=79.8f pd=0.8u as=0 ps=0 w=0.42u l=1u
X110 a_3694_3898# sg13cmos5l_buf_16_8.A VGND.t310 VGND.t40 sg13_lv_nmos ad=0.1406p pd=1.12u as=0.2516p ps=2.16u w=0.74u l=0.13u
X111 VPWR.t77 VGND.t206 VPWR.t78 VPWR.t0 sg13_lv_pmos ad=0.34p pd=2.68u as=0 ps=0 w=1u l=1u
X112 VGND.t125 a_6094_3898# sg13cmos5l_buf_16_0.A VGND.t40 sg13_lv_nmos ad=0.1406p pd=1.12u as=0.1406p ps=1.12u w=0.74u l=0.13u
X113 VPWR.t933 VGND.t994 VPWR.t931 VPWR.t2 sg13_lv_pmos ad=0.19p pd=1.38u as=0 ps=0 w=1u l=1u
X114 sg13cmos5l_buf_16_3.X a_10292_4620# VPWR.t143 VPWR.t64 sg13_lv_pmos ad=0.2128p pd=1.5u as=0.2128p ps=1.5u w=1.12u l=0.13u
X115 VPWR.t101 VGND.t7 VPWR.t100 VPWR.t58 sg13_lv_pmos ad=0.34p pd=2.68u as=0 ps=0 w=1u l=1u
X116 VGND.t597 VPWR.t0 VGND.t597 VGND.t910 sg13_lv_nmos ad=79.8f pd=0.8u as=0 ps=0 w=0.42u l=1u
X117 VGND.t351 a_3668_4620# sg13cmos5l_buf_16_8.A VGND.t830 sg13_lv_nmos ad=0.1406p pd=1.12u as=0.1406p ps=1.12u w=0.74u l=0.13u
X118 VPWR.t1359 a_2147_13692# sg13cmos5l_and2_2_1.X VPWR.t79 sg13_lv_pmos ad=0.1918p pd=1.5u as=0.2128p ps=1.5u w=1.12u l=0.13u
X119 VPWR.t644 a_3668_9156# sg13cmos5l_buf_16_13.A VPWR.t5 sg13_lv_pmos ad=0.2128p pd=1.5u as=0.2128p ps=1.5u w=1.12u l=0.13u
X120 VPWR.t56 VGND.t198 VPWR.t86 VPWR.t55 sg13_lv_pmos ad=0.34p pd=2.68u as=0 ps=0 w=1u l=1u
X121 sg13cmos5l_buf_16_1.X a_10318_5410# VPWR.t85 VPWR.t61 sg13_lv_pmos ad=0.2128p pd=1.5u as=0.2128p ps=1.5u w=1.12u l=0.13u
X122 VGND.t3 VPWR.t135 VGND.t3 VGND.t2 sg13_lv_nmos ad=79.8f pd=0.8u as=0 ps=0 w=0.42u l=1u
X123 VPWR.t56 a_5108_838# sg13cmos5l_buf_16_5.X VPWR.t55 sg13_lv_pmos ad=0.2128p pd=1.5u as=0.2128p ps=1.5u w=1.12u l=0.13u
X124 VPWR.t1024 VGND.t989 VPWR.t1022 VPWR.t8 sg13_lv_pmos ad=0.19p pd=1.38u as=0 ps=0 w=1u l=1u
X125 VPWR.t226 VGND.t1420 VPWR.t226 VPWR.t55 sg13_lv_pmos ad=0.19p pd=1.38u as=0 ps=0 w=1u l=1u
X126 VGND.t66 sg13cmos5l_buf_16_20.A a_4436_9910# VGND.t716 sg13_lv_nmos ad=0.2516p pd=2.16u as=0.1406p ps=1.12u w=0.74u l=0.13u
X127 VGND.t1286 VPWR.t216 VGND.t1286 VGND.t1287 sg13_lv_nmos ad=79.8f pd=0.8u as=0 ps=0 w=0.42u l=1u
X128 VGND.t1393 VPWR.t126 VGND.t1395 VGND.t1394 sg13_lv_nmos ad=79.8f pd=0.8u as=0 ps=0 w=0.42u l=1u
X129 VGND.t125 a_6094_3144# sg13cmos5l_xor2_1_0.B VGND.t40 sg13_lv_nmos ad=0.1406p pd=1.12u as=0.1406p ps=1.12u w=0.74u l=0.13u
X130 VGND.t5 a_9262_7680# sg13cmos5l_buf_16_2.A VGND.t105 sg13_lv_nmos ad=0.1406p pd=1.12u as=0.1406p ps=1.12u w=0.74u l=0.13u
X131 VGND.t942 VPWR.t1682 VGND.t942 VGND.t944 sg13_lv_nmos ad=0.1428p pd=1.52u as=0 ps=0 w=0.42u l=1u
X132 sg13cmos5l_buf_16_6.X a_5518_6922# VPWR.t911 VPWR.t58 sg13_lv_pmos ad=0.2128p pd=1.5u as=0.2128p ps=1.5u w=1.12u l=0.13u
X133 VPWR.t566 a_10292_12934# sg13cmos5l_buf_16_23.X VPWR.t79 sg13_lv_pmos ad=0.2128p pd=1.5u as=0.2128p ps=1.5u w=1.12u l=0.13u
X134 sg13cmos5l_buf_16_10.A a_3694_3898# VPWR.t1533 VPWR.t64 sg13_lv_pmos ad=0.2128p pd=1.5u as=0.2128p ps=1.5u w=1.12u l=0.13u
X135 sg13cmos5l_buf_16_15.X a_3668_12180# VPWR.t814 VPWR.t8 sg13_lv_pmos ad=0.2128p pd=1.5u as=0.2128p ps=1.5u w=1.12u l=0.13u
X136 sg13cmos5l_buf_16_15.X a_3668_12180# VPWR.t826 VPWR.t8 sg13_lv_pmos ad=0.2128p pd=1.5u as=0.2128p ps=1.5u w=1.12u l=0.13u
X137 VPWR.t250 VGND.t1380 VPWR.t250 VPWR.t55 sg13_lv_pmos ad=0.19p pd=1.38u as=0 ps=0 w=1u l=1u
X138 VPWR.t143 a_10292_4620# sg13cmos5l_buf_16_3.X VPWR.t64 sg13_lv_pmos ad=0.2128p pd=1.5u as=0.2128p ps=1.5u w=1.12u l=0.13u
X139 VPWR.t711 a_7220_5374# sg13cmos5l_buf_16_28.A VPWR.t61 sg13_lv_pmos ad=0.2128p pd=1.5u as=0.2128p ps=1.5u w=1.12u l=0.13u
X140 sg13cmos5l_buf_16_6.X a_5518_6922# VGND.t7 VGND.t547 sg13_lv_nmos ad=0.1406p pd=1.12u as=0.1406p ps=1.12u w=0.74u l=0.13u
X141 sg13cmos5l_buf_16_20.A a_5204_11422# VPWR.t491 VPWR.t8 sg13_lv_pmos ad=0.2128p pd=1.5u as=0.2128p ps=1.5u w=1.12u l=0.13u
X142 VPWR.t832 a_6862_9946# sg13cmos5l_buf_16_24.X VPWR.t2 sg13_lv_pmos ad=0.2128p pd=1.5u as=0.2128p ps=1.5u w=1.12u l=0.13u
X143 sg13cmos5l_buf_16_5.X a_5108_838# VPWR.t56 VPWR.t55 sg13_lv_pmos ad=0.2128p pd=1.5u as=0.3976p ps=2.95u w=1.12u l=0.13u
X144 VPWR.t56 sg13cmos5l_buf_16_30.A a_5710_1632# VPWR.t55 sg13_lv_pmos ad=0.2128p pd=1.5u as=0.2128p ps=1.5u w=1.12u l=0.13u
X145 VPWR.t156 VGND.t1346 VPWR.t156 VPWR.t55 sg13_lv_pmos ad=0.19p pd=1.38u as=0 ps=0 w=1u l=1u
X146 VGND.t870 VPWR.t1691 VGND.t870 VGND.t932 sg13_lv_nmos ad=79.8f pd=0.8u as=0 ps=0 w=0.42u l=1u
X147 VPWR.t239 VGND.t843 VPWR.t125 VPWR.t67 sg13_lv_pmos ad=0.34p pd=2.68u as=0 ps=0 w=1u l=1u
X148 sg13cmos5l_buf_16_28.A a_7220_5374# VPWR.t707 VPWR.t61 sg13_lv_pmos ad=0.2128p pd=1.5u as=0.2128p ps=1.5u w=1.12u l=0.13u
X149 VPWR.t146 VGND.t1061 VPWR.t146 VPWR.t5 sg13_lv_pmos ad=0.34p pd=2.68u as=0 ps=0 w=1u l=1u
X150 VPWR.t547 VGND.t942 VPWR.t546 VPWR.t8 sg13_lv_pmos ad=0.34p pd=2.68u as=0 ps=0 w=1u l=1u
X151 VGND.t351 a_4462_5410# sg13cmos5l_buf_16_11.A VGND.t428 sg13_lv_nmos ad=0.1406p pd=1.12u as=0.1406p ps=1.12u w=0.74u l=0.13u
X152 VGND.t726 a_6094_10704# sg13cmos5l_buf_16_24.A VGND.t2 sg13_lv_nmos ad=0.1406p pd=1.12u as=0.1406p ps=1.12u w=0.74u l=0.13u
X153 VPWR.t1475 VGND.t1274 VPWR.t1474 VPWR.t67 sg13_lv_pmos ad=0.34p pd=2.68u as=0 ps=0 w=1u l=1u
X154 VGND.t7 a_5518_6922# sg13cmos5l_buf_16_6.X VGND.t544 sg13_lv_nmos ad=0.1406p pd=1.12u as=0.1406p ps=1.12u w=0.74u l=0.13u
X155 VPWR.t58 VGND.t35 VPWR.t58 VPWR.t58 sg13_lv_pmos ad=0.34p pd=2.68u as=0 ps=0 w=1u l=1u
X156 VGND.t31 sg13cmos5l_buf_16_39.A a_8694_2398# VGND.t33 sg13_lv_nmos ad=0.15245p pd=1.17u as=88.8f ps=0.98u w=0.74u l=0.13u
X157 VPWR.t16 VGND.t726 VPWR.t16 VPWR.t8 sg13_lv_pmos ad=0.19p pd=1.38u as=0 ps=0 w=1u l=1u
X158 VPWR.t0 VGND.t206 VPWR.t75 VPWR.t0 sg13_lv_pmos ad=0.34p pd=2.68u as=0 ps=0 w=1u l=1u
X159 VGND.t260 VPWR.t1660 VGND.t260 VGND.t1058 sg13_lv_nmos ad=0.1428p pd=1.52u as=0 ps=0 w=0.42u l=1u
X160 VGND.t31 VPWR.t986 VGND.t31 VGND.t1319 sg13_lv_nmos ad=0.1428p pd=1.52u as=0 ps=0 w=0.42u l=1u
X161 VPWR.t634 sg13cmos5l_buf_16_24.A a_6862_9946# VPWR.t2 sg13_lv_pmos ad=0.2128p pd=1.5u as=0.2128p ps=1.5u w=1.12u l=0.13u
X162 sg13cmos5l_buf_16_11.A a_4462_5410# VGND.t351 VGND.t425 sg13_lv_nmos ad=0.1406p pd=1.12u as=0.1406p ps=1.12u w=0.74u l=0.13u
X163 VPWR.t1167 sg13cmos5l_buf_16_15.A a_3668_12180# VPWR.t8 sg13_lv_pmos ad=0.3808p pd=2.92u as=0.2128p ps=1.5u w=1.12u l=0.13u
X164 VGND.t310 a_3668_3108# sg13cmos5l_buf_16_7.A VGND.t40 sg13_lv_nmos ad=0.1406p pd=1.12u as=0.1406p ps=1.12u w=0.74u l=0.13u
X165 VPWR.t62 VGND.t1167 VPWR.t62 VPWR.t61 sg13_lv_pmos ad=0.34p pd=2.68u as=0 ps=0 w=1u l=1u
X166 VPWR.t156 VGND.t1274 VPWR.t156 VPWR.t55 sg13_lv_pmos ad=0.34p pd=2.68u as=0 ps=0 w=1u l=1u
X167 VGND.t1286 VPWR.t250 VGND.t1286 VGND.t1324 sg13_lv_nmos ad=79.8f pd=0.8u as=0 ps=0 w=0.42u l=1u
X168 VGND.t302 sg13cmos5l_buf_16_2.A a_10318_3898# VGND.t40 sg13_lv_nmos ad=0.1406p pd=1.12u as=0.1406p ps=1.12u w=0.74u l=0.13u
X169 VGND.t210 VPWR.t61 VGND.t210 VGND.t1181 sg13_lv_nmos ad=0.1428p pd=1.52u as=0 ps=0 w=0.42u l=1u
X170 VPWR.t954 VGND.t444 VPWR.t973 VPWR.t79 sg13_lv_pmos ad=0.19p pd=1.38u as=0 ps=0 w=1u l=1u
X171 VPWR.t63 VGND.t1405 VPWR.t63 VPWR.t55 sg13_lv_pmos ad=0.19p pd=1.38u as=0 ps=0 w=1u l=1u
X172 VPWR.t1362 a_4174_13728# sg13cmos5l_buf_16_18.A VPWR.t79 sg13_lv_pmos ad=0.2128p pd=1.5u as=0.2128p ps=1.5u w=1.12u l=0.13u
X173 VPWR.t1374 a_4174_13728# sg13cmos5l_buf_16_18.A VPWR.t79 sg13_lv_pmos ad=0.2128p pd=1.5u as=0.2128p ps=1.5u w=1.12u l=0.13u
X174 VGND.t206 VPWR.t81 VGND.t924 VGND.t936 sg13_lv_nmos ad=79.8f pd=0.8u as=0 ps=0 w=0.42u l=1u
X175 a_10292_4620# sg13cmos5l_buf_16_2.X VGND.t181 VGND.t182 sg13_lv_nmos ad=0.1406p pd=1.12u as=0.1406p ps=1.12u w=0.74u l=0.13u
X176 out_xor[3] a_14824_6956# VPWR.t905 VPWR.t58 sg13_lv_pmos ad=0.42p pd=2.99u as=0.2114p ps=1.54u w=1.12u l=0.13u
X177 a_3694_2386# sg13cmos5l_buf_16_7.A VPWR.t561 VPWR.t67 sg13_lv_pmos ad=0.2128p pd=1.5u as=0.2128p ps=1.5u w=1.12u l=0.13u
X178 sg13cmos5l_buf_16_37.A a_8948_13692# VPWR.t566 VPWR.t79 sg13_lv_pmos ad=0.2128p pd=1.5u as=0.2128p ps=1.5u w=1.12u l=0.13u
X179 VGND.t198 a_3694_2386# sg13cmos5l_buf_16_7.X VGND.t1570 sg13_lv_nmos ad=0.1406p pd=1.12u as=0.1406p ps=1.12u w=0.74u l=0.13u
X180 VPWR.t91 VGND.t5 VPWR.t91 VPWR.t58 sg13_lv_pmos ad=0.34p pd=2.68u as=0 ps=0 w=1u l=1u
X181 sg13cmos5l_buf_16_5.A a_5710_1632# VGND.t837 VGND.t858 sg13_lv_nmos ad=0.1406p pd=1.12u as=0.1406p ps=1.12u w=0.74u l=0.13u
X182 VGND.t843 VPWR.t226 VGND.t843 VGND.t1335 sg13_lv_nmos ad=0.1428p pd=1.52u as=0 ps=0 w=0.42u l=1u
X183 VGND.t125 a_6094_3144# sg13cmos5l_xor2_1_0.B VGND.t40 sg13_lv_nmos ad=0.1406p pd=1.12u as=0.1406p ps=1.12u w=0.74u l=0.13u
X184 sg13cmos5l_buf_16_7.A a_3668_3108# VGND.t310 VGND.t40 sg13_lv_nmos ad=0.1406p pd=1.12u as=0.2516p ps=2.16u w=0.74u l=0.13u
X185 VPWR.t163 VGND.t682 VPWR.t162 VPWR.t79 sg13_lv_pmos ad=0.19p pd=1.38u as=0 ps=0 w=1u l=1u
X186 VGND.t66 sg13cmos5l_buf_16_20.A a_4436_9910# VGND.t712 sg13_lv_nmos ad=0.1406p pd=1.12u as=0.1406p ps=1.12u w=0.74u l=0.13u
X187 VGND.t1373 VPWR.t205 VGND.t1372 VGND.t1371 sg13_lv_nmos ad=0.1428p pd=1.52u as=0 ps=0 w=0.42u l=1u
X188 VPWR.t143 a_10318_3898# sg13cmos5l_buf_16_2.X VPWR.t64 sg13_lv_pmos ad=0.2128p pd=1.5u as=0.2128p ps=1.5u w=1.12u l=0.13u
X189 sg13cmos5l_buf_16_11.A a_4462_5410# VPWR.t798 VPWR.t61 sg13_lv_pmos ad=0.2128p pd=1.5u as=0.2128p ps=1.5u w=1.12u l=0.13u
X190 VGND.t210 a_8110_6168# sg13cmos5l_buf_16_38.A VGND.t787 sg13_lv_nmos ad=0.1406p pd=1.12u as=0.1406p ps=1.12u w=0.74u l=0.13u
X191 VGND.t86 sg13cmos5l_buf_16_2.X a_10292_4620# VGND.t178 sg13_lv_nmos ad=0.1406p pd=1.12u as=0.1406p ps=1.12u w=0.74u l=0.13u
X192 VPWR.t104 VGND.t7 VPWR.t103 VPWR.t58 sg13_lv_pmos ad=0.34p pd=2.68u as=0 ps=0 w=1u l=1u
X193 sg13cmos5l_buf_16_15.X a_3668_12180# VGND.t454 VGND.t455 sg13_lv_nmos ad=0.1406p pd=1.12u as=0.1406p ps=1.12u w=0.74u l=0.13u
X194 VPWR.t1163 sg13cmos5l_buf_16_15.A a_3668_12180# VPWR.t8 sg13_lv_pmos ad=0.2128p pd=1.5u as=0.2128p ps=1.5u w=1.12u l=0.13u
X195 VPWR.t6 VGND.t1061 VPWR.t6 VPWR.t5 sg13_lv_pmos ad=0.34p pd=2.68u as=0 ps=0 w=1u l=1u
X196 VPWR.t146 VGND.t5 VPWR.t146 VPWR.t5 sg13_lv_pmos ad=0.34p pd=2.68u as=0 ps=0 w=1u l=1u
X197 VGND.t31 VPWR.t216 VGND.t31 VGND.t1283 sg13_lv_nmos ad=0.1428p pd=1.52u as=0 ps=0 w=0.42u l=1u
X198 sg13cmos5l_buf_16_7.X a_3694_2386# VGND.t198 VGND.t1567 sg13_lv_nmos ad=0.1406p pd=1.12u as=0.1406p ps=1.12u w=0.74u l=0.13u
X199 VPWR.t742 a_6094_3898# sg13cmos5l_buf_16_0.A VPWR.t64 sg13_lv_pmos ad=0.2128p pd=1.5u as=0.2128p ps=1.5u w=1.12u l=0.13u
X200 VGND.t1141 VPWR.t1642 VGND.t1141 VGND.t1144 sg13_lv_nmos ad=79.8f pd=0.8u as=0 ps=0 w=0.42u l=1u
X201 VPWR.t28 VGND.t1061 VPWR.t28 VPWR.t2 sg13_lv_pmos ad=0.19p pd=1.38u as=0 ps=0 w=1u l=1u
X202 out_xor[0] a_14824_1632# VPWR.t1060 VPWR.t55 sg13_lv_pmos ad=0.42p pd=2.99u as=0.2114p ps=1.54u w=1.12u l=0.13u
X203 VGND.t7 sg13cmos5l_buf_16_28.A a_5684_6132# VGND.t793 sg13_lv_nmos ad=0.1406p pd=1.12u as=0.1406p ps=1.12u w=0.74u l=0.13u
X204 VPWR.t906 sg13cmos5l_buf_16_28.X a_5518_6922# VPWR.t58 sg13_lv_pmos ad=0.2128p pd=1.5u as=0.2128p ps=1.5u w=1.12u l=0.13u
X205 VPWR.t1397 sg13cmos5l_and2_2_1.X a_4174_13728# VPWR.t79 sg13_lv_pmos ad=0.2128p pd=1.5u as=0.2128p ps=1.5u w=1.12u l=0.13u
X206 a_13675_9988# sg13cmos5l_buf_16_22.X a_13581_9988# VGND.t150 sg13_lv_nmos ad=0.1216p pd=1.02u as=0.2176p ps=1.96u w=0.64u l=0.13u
X207 VPWR.t216 VGND.t1286 VPWR.t216 VPWR.t67 sg13_lv_pmos ad=0.19p pd=1.38u as=0 ps=0 w=1u l=1u
X208 VPWR.t796 a_4462_5410# sg13cmos5l_buf_16_11.A VPWR.t61 sg13_lv_pmos ad=0.2128p pd=1.5u as=0.2128p ps=1.5u w=1.12u l=0.13u
X209 VPWR.t1175 a_4436_9910# sg13cmos5l_buf_16_14.A VPWR.t2 sg13_lv_pmos ad=0.2128p pd=1.5u as=0.2128p ps=1.5u w=1.12u l=0.13u
X210 VGND.t302 sg13cmos5l_buf_16_2.A a_10318_3898# VGND.t40 sg13_lv_nmos ad=0.1406p pd=1.12u as=0.1406p ps=1.12u w=0.74u l=0.13u
X211 sg13cmos5l_xor2_1_0.B a_6094_3144# VPWR.t757 VPWR.t67 sg13_lv_pmos ad=0.2128p pd=1.5u as=0.2128p ps=1.5u w=1.12u l=0.13u
X212 VPWR.t69 VGND.t310 VPWR.t68 VPWR.t67 sg13_lv_pmos ad=0.19p pd=1.38u as=0 ps=0 w=1u l=1u
X213 VPWR.t58 VGND.t1167 VPWR.t58 VPWR.t58 sg13_lv_pmos ad=0.34p pd=2.68u as=0 ps=0 w=1u l=1u
X214 VPWR.t129 VGND.t1010 VPWR.t129 VPWR.t8 sg13_lv_pmos ad=0.19p pd=1.38u as=0 ps=0 w=1u l=1u
X215 VGND.t198 sg13cmos5l_buf_16_7.A a_3694_2386# VGND.t200 sg13_lv_nmos ad=0.1406p pd=1.12u as=0.1406p ps=1.12u w=0.74u l=0.13u
X216 VGND.t1165 VPWR.t59 VGND.t1165 VGND.t1164 sg13_lv_nmos ad=0.1428p pd=1.52u as=0 ps=0 w=0.42u l=1u
X217 sg13cmos5l_buf_16_24.A a_6094_10704# VGND.t726 VGND.t2 sg13_lv_nmos ad=0.1406p pd=1.12u as=0.1406p ps=1.12u w=0.74u l=0.13u
X218 VPWR.t1577 sg13cmos5l_buf_16_11.A a_3668_4620# VPWR.t64 sg13_lv_pmos ad=0.3808p pd=2.92u as=0.2128p ps=1.5u w=1.12u l=0.13u
X219 VPWR.t218 a_6164_2350# sg13cmos5l_buf_16_30.A VPWR.t67 sg13_lv_pmos ad=0.2128p pd=1.5u as=0.2128p ps=1.5u w=1.12u l=0.13u
X220 a_5684_6132# sg13cmos5l_buf_16_28.A VGND.t7 VGND.t790 sg13_lv_nmos ad=0.1406p pd=1.12u as=0.1406p ps=1.12u w=0.74u l=0.13u
X221 VGND.t590 VPWR.t20 VGND.t590 VGND.t976 sg13_lv_nmos ad=0.1428p pd=1.52u as=0 ps=0 w=0.42u l=1u
X222 VPWR.t479 sg13cmos5l_buf_16_5.X a_6094_3144# VPWR.t67 sg13_lv_pmos ad=0.2128p pd=1.5u as=0.2128p ps=1.5u w=1.12u l=0.13u
X223 VPWR.t96 VGND.t214 VPWR.t85 VPWR.t61 sg13_lv_pmos ad=0.34p pd=2.68u as=0 ps=0 w=1u l=1u
X224 VGND.t1061 VPWR.t28 VGND.t1061 VGND.t1066 sg13_lv_nmos ad=79.8f pd=0.8u as=0 ps=0 w=0.42u l=1u
X225 a_8948_13692# sg13cmos5l_buf_16_23.X VGND.t597 VGND.t599 sg13_lv_nmos ad=0.1406p pd=1.12u as=0.1406p ps=1.12u w=0.74u l=0.13u
X226 a_3668_4620# sg13cmos5l_buf_16_11.A VPWR.t1573 VPWR.t64 sg13_lv_pmos ad=0.2128p pd=1.5u as=0.2128p ps=1.5u w=1.12u l=0.13u
X227 VPWR.t1224 a_4436_9910# sg13cmos5l_buf_16_14.A VPWR.t2 sg13_lv_pmos ad=0.2128p pd=1.5u as=0.2128p ps=1.5u w=1.12u l=0.13u
X228 sg13cmos5l_buf_16_30.A a_6164_2350# VPWR.t1553 VPWR.t67 sg13_lv_pmos ad=0.2128p pd=1.5u as=0.2128p ps=1.5u w=1.12u l=0.13u
X229 sg13cmos5l_buf_16_23.X a_10292_12934# VGND.t590 VGND.t664 sg13_lv_nmos ad=0.1406p pd=1.12u as=0.2516p ps=2.16u w=0.74u l=0.13u
X230 VGND.t597 a_8948_13692# sg13cmos5l_buf_16_37.A VGND.t653 sg13_lv_nmos ad=0.1406p pd=1.12u as=0.1406p ps=1.12u w=0.74u l=0.13u
X231 VGND.t1298 VPWR.t117 VGND.t1298 VGND.t1297 sg13_lv_nmos ad=0.1428p pd=1.52u as=0 ps=0 w=0.42u l=1u
X232 VPWR.t3 VGND.t1010 VPWR.t3 VPWR.t2 sg13_lv_pmos ad=0.34p pd=2.68u as=0 ps=0 w=1u l=1u
X233 VPWR.t132 VGND.t37 VPWR.t132 VPWR.t5 sg13_lv_pmos ad=0.19p pd=1.38u as=0 ps=0 w=1u l=1u
X234 VGND.t31 VPWR.t250 VGND.t31 VGND.t1321 sg13_lv_nmos ad=0.1428p pd=1.52u as=0 ps=0 w=0.42u l=1u
X235 sg13cmos5l_and2_2_6.A a_3694_10704# VPWR.t557 VPWR.t2 sg13_lv_pmos ad=0.2128p pd=1.5u as=0.2128p ps=1.5u w=1.12u l=0.13u
X236 sg13cmos5l_buf_16_5.A a_5710_1632# VGND.t837 VGND.t854 sg13_lv_nmos ad=0.1406p pd=1.12u as=0.1406p ps=1.12u w=0.74u l=0.13u
X237 sg13cmos5l_buf_1_2.X a_8104_1632# VGND.t25 VGND.t876 sg13_lv_nmos ad=0.2886p pd=2.26u as=0.14875p ps=1.16u w=0.74u l=0.13u
X238 VGND.t171 sg13cmos5l_buf_16_38.A a_7220_5374# VGND.t172 sg13_lv_nmos ad=0.1406p pd=1.12u as=0.1406p ps=1.12u w=0.74u l=0.13u
X239 VGND.t1224 VPWR.t64 VGND.t76 VGND.t1225 sg13_lv_nmos ad=79.8f pd=0.8u as=0 ps=0 w=0.42u l=1u
X240 sg13cmos5l_buf_16_31.X a_6094_4656# VGND.t351 VGND.t350 sg13_lv_nmos ad=0.1406p pd=1.12u as=0.1406p ps=1.12u w=0.74u l=0.13u
X241 sg13cmos5l_buf_16_33.A a_3694_14482# VPWR.t1337 VPWR.t0 sg13_lv_pmos ad=0.2128p pd=1.5u as=0.2128p ps=1.5u w=1.12u l=0.13u
X242 sg13cmos5l_buf_16_4.X a_9524_6886# VPWR.t335 VPWR.t58 sg13_lv_pmos ad=0.2128p pd=1.5u as=0.2128p ps=1.5u w=1.12u l=0.13u
X243 VGND.t210 VPWR.t85 VGND.t210 VGND.t1183 sg13_lv_nmos ad=0.1428p pd=1.52u as=0 ps=0 w=0.42u l=1u
X244 VGND.t994 VPWR.t1666 VGND.t994 VGND.t2 sg13_lv_nmos ad=79.8f pd=0.8u as=0 ps=0 w=0.42u l=1u
X245 VPWR.t63 VGND.t1410 VPWR.t63 VPWR.t55 sg13_lv_pmos ad=0.19p pd=1.38u as=0 ps=0 w=1u l=1u
X246 VGND.t18 sg13cmos5l_buf_16_13.A a_3694_8434# VGND.t19 sg13_lv_nmos ad=0.1406p pd=1.12u as=0.1406p ps=1.12u w=0.74u l=0.13u
X247 sg13cmos5l_buf_16_37.A a_8948_13692# VGND.t597 VGND.t660 sg13_lv_nmos ad=0.1406p pd=1.12u as=0.1406p ps=1.12u w=0.74u l=0.13u
X248 VPWR.t466 VGND.t1050 VPWR.t464 VPWR.t5 sg13_lv_pmos ad=0.19p pd=1.38u as=0 ps=0 w=1u l=1u
X249 sg13cmos5l_buf_16_28.A a_7220_5374# VGND.t171 VGND.t346 sg13_lv_nmos ad=0.1406p pd=1.12u as=0.1406p ps=1.12u w=0.74u l=0.13u
X250 a_9524_6886# sg13cmos5l_buf_16_4.A VGND.t214 VGND.t215 sg13_lv_nmos ad=0.1406p pd=1.12u as=0.1406p ps=1.12u w=0.74u l=0.13u
X251 VPWR.t923 VGND.t994 VPWR.t922 VPWR.t8 sg13_lv_pmos ad=0.19p pd=1.38u as=0 ps=0 w=1u l=1u
X252 VGND.t3 sg13cmos5l_and2_2_3.X a_13745_11508# VGND.t2 sg13_lv_nmos ad=0.15245p pd=1.17u as=0.17462p ps=1.185u w=0.55u l=0.13u
X253 VPWR.t335 a_9262_7680# sg13cmos5l_buf_16_2.A VPWR.t58 sg13_lv_pmos ad=0.2128p pd=1.5u as=0.2128p ps=1.5u w=1.12u l=0.13u
X254 VGND.t898 VPWR.t1699 VGND.t898 VGND.t897 sg13_lv_nmos ad=0.1428p pd=1.52u as=0 ps=0 w=0.42u l=1u
X255 VGND.t351 sg13cmos5l_buf_16_7.X a_6094_4656# VGND.t434 sg13_lv_nmos ad=0.1406p pd=1.12u as=0.1406p ps=1.12u w=0.74u l=0.13u
X256 VGND.t597 a_8948_13692# sg13cmos5l_buf_16_37.A VGND.t649 sg13_lv_nmos ad=0.1406p pd=1.12u as=0.1406p ps=1.12u w=0.74u l=0.13u
X257 VPWR.t792 a_4462_5410# sg13cmos5l_buf_16_11.A VPWR.t61 sg13_lv_pmos ad=0.2128p pd=1.5u as=0.2128p ps=1.5u w=1.12u l=0.13u
X258 sg13cmos5l_buf_16_8.A a_3668_4620# VPWR.t1289 VPWR.t64 sg13_lv_pmos ad=0.2128p pd=1.5u as=0.2128p ps=1.5u w=1.12u l=0.13u
X259 VPWR.t31 VGND.t682 VPWR.t167 VPWR.t8 sg13_lv_pmos ad=0.34p pd=2.68u as=0 ps=0 w=1u l=1u
X260 VGND.t157 a_6862_9946# sg13cmos5l_buf_16_24.X VGND.t163 sg13_lv_nmos ad=0.1406p pd=1.12u as=0.1406p ps=1.12u w=0.74u l=0.13u
X261 VGND.t96 sg13cmos5l_buf_16_0.A a_8494_3144# VGND.t40 sg13_lv_nmos ad=0.1406p pd=1.12u as=0.1406p ps=1.12u w=0.74u l=0.13u
X262 sg13cmos5l_buf_16_35.A a_6766_8434# VGND.t5 VGND.t293 sg13_lv_nmos ad=0.1406p pd=1.12u as=0.1406p ps=1.12u w=0.74u l=0.13u
X263 VGND.t237 sg13cmos5l_buf_1_17.A a_10292_12934# VGND.t241 sg13_lv_nmos ad=0.1406p pd=1.12u as=0.1406p ps=1.12u w=0.74u l=0.13u
X264 VPWR.t216 VGND.t31 VPWR.t216 VPWR.t67 sg13_lv_pmos ad=0.34p pd=2.68u as=0 ps=0 w=1u l=1u
X265 a_6094_3898# enable VPWR.t1424 VPWR.t64 sg13_lv_pmos ad=0.2128p pd=1.5u as=0.2128p ps=1.5u w=1.12u l=0.13u
X266 VGND.t210 sg13cmos5l_buf_16_4.A a_9524_6886# VGND.t211 sg13_lv_nmos ad=0.1406p pd=1.12u as=0.1406p ps=1.12u w=0.74u l=0.13u
X267 sg13cmos5l_buf_16_33.A a_3694_14482# VPWR.t1333 VPWR.t0 sg13_lv_pmos ad=0.2128p pd=1.5u as=0.2128p ps=1.5u w=1.12u l=0.13u
X268 sg13cmos5l_buf_16_2.A a_9262_7680# VPWR.t335 VPWR.t58 sg13_lv_pmos ad=0.2128p pd=1.5u as=0.2128p ps=1.5u w=1.12u l=0.13u
X269 VPWR.t193 VGND.t134 VPWR.t191 VPWR.t8 sg13_lv_pmos ad=0.19p pd=1.38u as=0 ps=0 w=1u l=1u
X270 a_5710_1632# sg13cmos5l_buf_16_30.A VGND.t837 VGND.t838 sg13_lv_nmos ad=0.1406p pd=1.12u as=0.1406p ps=1.12u w=0.74u l=0.13u
X271 VPWR.t28 VGND.t726 VPWR.t26 VPWR.t2 sg13_lv_pmos ad=0.19p pd=1.38u as=0 ps=0 w=1u l=1u
X272 a_6164_2350# sg13cmos5l_buf_16_39.A VGND.t25 VGND.t27 sg13_lv_nmos ad=0.1406p pd=1.12u as=0.1406p ps=1.12u w=0.74u l=0.13u
X273 a_6094_4656# sg13cmos5l_buf_16_7.X VGND.t351 VGND.t431 sg13_lv_nmos ad=0.1406p pd=1.12u as=0.2516p ps=2.16u w=0.74u l=0.13u
X274 VGND.t726 VPWR.t1665 VGND.t726 VGND.t2 sg13_lv_nmos ad=0.1428p pd=1.52u as=0 ps=0 w=0.42u l=1u
X275 a_4052_12934# sg13cmos5l_buf_16_18.A VPWR.t1091 VPWR.t79 sg13_lv_pmos ad=0.2128p pd=1.5u as=0.2128p ps=1.5u w=1.12u l=0.13u
X276 sg13cmos5l_buf_16_5.X a_5108_838# VGND.t845 VGND.t1462 sg13_lv_nmos ad=0.1406p pd=1.12u as=0.1406p ps=1.12u w=0.74u l=0.13u
X277 VPWR.t283 VGND.t3 VPWR.t131 VPWR.t8 sg13_lv_pmos ad=0.34p pd=2.68u as=0 ps=0 w=1u l=1u
X278 VGND.t1378 VPWR.t250 VGND.t1377 VGND.t1376 sg13_lv_nmos ad=0.1428p pd=1.52u as=0 ps=0 w=0.42u l=1u
X279 VPWR.t475 sg13cmos5l_buf_16_5.X a_6094_3144# VPWR.t67 sg13_lv_pmos ad=0.2128p pd=1.5u as=0.2128p ps=1.5u w=1.12u l=0.13u
X280 a_8494_3144# sg13cmos5l_buf_16_0.A VGND.t93 VGND.t40 sg13_lv_nmos ad=0.1406p pd=1.12u as=0.2516p ps=2.16u w=0.74u l=0.13u
X281 sg13cmos5l_buf_16_24.X a_6862_9946# VGND.t157 VGND.t160 sg13_lv_nmos ad=0.1406p pd=1.12u as=0.1406p ps=1.12u w=0.74u l=0.13u
X282 VGND.t1298 VPWR.t63 VGND.t1298 VGND.t1331 sg13_lv_nmos ad=0.1428p pd=1.52u as=0 ps=0 w=0.42u l=1u
X283 VGND.t457 a_4052_12934# sg13cmos5l_buf_16_15.A VGND.t611 sg13_lv_nmos ad=0.1406p pd=1.12u as=0.1406p ps=1.12u w=0.74u l=0.13u
X284 VPWR.t16 VGND.t590 VPWR.t16 VPWR.t8 sg13_lv_pmos ad=0.34p pd=2.68u as=0 ps=0 w=1u l=1u
X285 VGND.t5 a_6766_8434# sg13cmos5l_buf_16_35.A VGND.t290 sg13_lv_nmos ad=0.1406p pd=1.12u as=0.1406p ps=1.12u w=0.74u l=0.13u
X286 VGND.t1050 VPWR.t1662 VGND.t1050 VGND.t1054 sg13_lv_nmos ad=0.1428p pd=1.52u as=0 ps=0 w=0.42u l=1u
X287 VGND.t845 a_5108_838# sg13cmos5l_buf_16_5.X VGND.t1457 sg13_lv_nmos ad=0.1406p pd=1.12u as=0.1406p ps=1.12u w=0.74u l=0.13u
X288 sg13cmos5l_buf_16_1.X a_10318_5410# VGND.t181 VGND.t182 sg13_lv_nmos ad=0.1406p pd=1.12u as=0.1406p ps=1.12u w=0.74u l=0.13u
X289 a_3694_8434# sg13cmos5l_buf_16_13.A VPWR.t419 VPWR.t5 sg13_lv_pmos ad=0.2128p pd=1.5u as=0.2128p ps=1.5u w=1.12u l=0.13u
X290 VGND.t5 VPWR.t1648 VGND.t5 VGND.t1104 sg13_lv_nmos ad=0.1428p pd=1.52u as=0 ps=0 w=0.42u l=1u
X291 sg13cmos5l_buf_16_35.A a_6766_8434# VPWR.t146 VPWR.t5 sg13_lv_pmos ad=0.2128p pd=1.5u as=0.2128p ps=1.5u w=1.12u l=0.13u
X292 sg13cmos5l_buf_1_6.A a_4721_6526# a_4892_6168# VPWR.t61 sg13_lv_pmos ad=0.3808p pd=2.92u as=0.2128p ps=1.5u w=1.12u l=0.13u
X293 a_3694_14482# sg13cmos5l_buf_16_15.X VPWR.t1328 VPWR.t0 sg13_lv_pmos ad=0.2128p pd=1.5u as=0.2128p ps=1.5u w=1.12u l=0.13u
X294 VGND.t5 sg13cmos5l_buf_16_1.X a_10318_8434# VGND.t1521 sg13_lv_nmos ad=0.1406p pd=1.12u as=0.1406p ps=1.12u w=0.74u l=0.13u
X295 VPWR.t586 a_5684_6132# sg13cmos5l_buf_16_28.X VPWR.t61 sg13_lv_pmos ad=0.2128p pd=1.5u as=0.2128p ps=1.5u w=1.12u l=0.13u
X296 VGND.t597 a_6548_13692# sg13cmos5l_buf_16_27.X VGND.t1490 sg13_lv_nmos ad=0.1406p pd=1.12u as=0.1406p ps=1.12u w=0.74u l=0.13u
X297 VGND.t93 a_6094_3898# sg13cmos5l_buf_16_0.A VGND.t40 sg13_lv_nmos ad=0.2516p pd=2.16u as=0.1406p ps=1.12u w=0.74u l=0.13u
X298 VGND.t86 a_10318_5410# sg13cmos5l_buf_16_1.X VGND.t178 sg13_lv_nmos ad=0.1406p pd=1.12u as=0.1406p ps=1.12u w=0.74u l=0.13u
X299 sg13cmos5l_buf_16_15.A a_4052_12934# VPWR.t1087 VPWR.t79 sg13_lv_pmos ad=0.2128p pd=1.5u as=0.2128p ps=1.5u w=1.12u l=0.13u
X300 sg13cmos5l_buf_16_10.A a_3694_3898# VGND.t122 VGND.t40 sg13_lv_nmos ad=0.1406p pd=1.12u as=0.1406p ps=1.12u w=0.74u l=0.13u
X301 VPWR.t64 VGND.t171 VPWR.t64 VPWR.t64 sg13_lv_pmos ad=0.19p pd=1.38u as=0 ps=0 w=1u l=1u
X302 sg13cmos5l_buf_16_4.X a_9524_6886# VPWR.t335 VPWR.t58 sg13_lv_pmos ad=0.2128p pd=1.5u as=0.2128p ps=1.5u w=1.12u l=0.13u
X303 a_2147_13692# sg13cmos5l_and2_2_1.B VPWR.t1359 VPWR.t79 sg13_lv_pmos ad=0.1596p pd=1.22u as=0.1918p ps=1.5u w=0.84u l=0.13u
X304 VPWR.t146 a_6766_8434# sg13cmos5l_buf_16_35.A VPWR.t5 sg13_lv_pmos ad=0.2128p pd=1.5u as=0.2128p ps=1.5u w=1.12u l=0.13u
X305 VGND.t898 VPWR.t1694 VGND.t898 VGND.t899 sg13_lv_nmos ad=79.8f pd=0.8u as=0 ps=0 w=0.42u l=1u
X306 VGND.t924 VPWR.t81 VGND.t924 VGND.t938 sg13_lv_nmos ad=79.8f pd=0.8u as=0 ps=0 w=0.42u l=1u
X307 sg13cmos5l_and2_2_6.A a_3694_10704# VGND.t139 VGND.t2 sg13_lv_nmos ad=0.1406p pd=1.12u as=0.1406p ps=1.12u w=0.74u l=0.13u
X308 VPWR.t308 sg13cmos5l_buf_16_14.A a_3668_9156# VPWR.t5 sg13_lv_pmos ad=0.2128p pd=1.5u as=0.2128p ps=1.5u w=1.12u l=0.13u
X309 VGND.t1141 VPWR.t1633 VGND.t1141 VGND.t1144 sg13_lv_nmos ad=79.8f pd=0.8u as=0 ps=0 w=0.42u l=1u
X310 VGND.t444 a_4052_12934# sg13cmos5l_buf_16_15.A VGND.t607 sg13_lv_nmos ad=0.1406p pd=1.12u as=0.1406p ps=1.12u w=0.74u l=0.13u
X311 VGND.t1298 VPWR.t120 VGND.t1298 VGND.t1300 sg13_lv_nmos ad=0.1428p pd=1.52u as=0 ps=0 w=0.42u l=1u
X312 VPWR.t1190 a_6094_10704# sg13cmos5l_buf_16_24.A VPWR.t2 sg13_lv_pmos ad=0.2128p pd=1.5u as=0.2128p ps=1.5u w=1.12u l=0.13u
X313 VGND.t682 VPWR.t1684 VGND.t682 VGND.t954 sg13_lv_nmos ad=0.1428p pd=1.52u as=0 ps=0 w=0.42u l=1u
X314 VPWR.t117 VGND.t1298 VPWR.t117 VPWR.t67 sg13_lv_pmos ad=0.34p pd=2.68u as=0 ps=0 w=1u l=1u
X315 sg13cmos5l_buf_16_28.A a_7220_5374# VGND.t171 VGND.t342 sg13_lv_nmos ad=0.1406p pd=1.12u as=0.1406p ps=1.12u w=0.74u l=0.13u
X316 sg13cmos5l_buf_16_20.A a_5204_11422# VGND.t139 VGND.t2 sg13_lv_nmos ad=0.1406p pd=1.12u as=0.1406p ps=1.12u w=0.74u l=0.13u
X317 VGND.t7 a_8110_6168# sg13cmos5l_buf_16_38.A VGND.t775 sg13_lv_nmos ad=0.1406p pd=1.12u as=0.1406p ps=1.12u w=0.74u l=0.13u
X318 VPWR.t165 VGND.t682 VPWR.t166 VPWR.t79 sg13_lv_pmos ad=0.19p pd=1.38u as=0 ps=0 w=1u l=1u
X319 VPWR.t57 VGND.t851 VPWR.t56 VPWR.t55 sg13_lv_pmos ad=0.34p pd=2.68u as=0 ps=0 w=1u l=1u
X320 VGND.t122 a_3694_3898# sg13cmos5l_buf_16_10.A VGND.t40 sg13_lv_nmos ad=0.1406p pd=1.12u as=0.1406p ps=1.12u w=0.74u l=0.13u
X321 VPWR.t335 a_9524_6886# sg13cmos5l_buf_16_4.X VPWR.t58 sg13_lv_pmos ad=0.2128p pd=1.5u as=0.2128p ps=1.5u w=1.12u l=0.13u
X322 sg13cmos5l_buf_16_25.A a_6836_9156# VGND.t157 VGND.t162 sg13_lv_nmos ad=0.1406p pd=1.12u as=0.1406p ps=1.12u w=0.74u l=0.13u
X323 sg13cmos5l_buf_16_35.A a_6766_8434# VPWR.t665 VPWR.t5 sg13_lv_pmos ad=0.2128p pd=1.5u as=0.2128p ps=1.5u w=1.12u l=0.13u
X324 VPWR.t143 sg13cmos5l_buf_16_2.X a_10292_4620# VPWR.t64 sg13_lv_pmos ad=0.2128p pd=1.5u as=0.2128p ps=1.5u w=1.12u l=0.13u
X325 VPWR.t61 VGND.t210 VPWR.t61 VPWR.t61 sg13_lv_pmos ad=0.34p pd=2.68u as=0 ps=0 w=1u l=1u
X326 a_4721_6526# sg13cmos5l_buf_16_8.A VGND.t218 VGND.t308 sg13_lv_nmos ad=0.17462p pd=1.185u as=0.374p ps=2.46u w=0.55u l=0.13u
X327 VPWR.t56 a_5710_1632# sg13cmos5l_buf_16_5.A VPWR.t55 sg13_lv_pmos ad=0.2128p pd=1.5u as=0.2128p ps=1.5u w=1.12u l=0.13u
X328 VPWR.t96 a_10318_5410# sg13cmos5l_buf_16_1.X VPWR.t61 sg13_lv_pmos ad=0.3976p pd=2.95u as=0.2128p ps=1.5u w=1.12u l=0.13u
X329 VGND.t1 a_6548_13692# sg13cmos5l_buf_16_27.X VGND.t1486 sg13_lv_nmos ad=0.1406p pd=1.12u as=0.1406p ps=1.12u w=0.74u l=0.13u
X330 sg13cmos5l_buf_16_5.X a_5108_838# VPWR.t56 VPWR.t55 sg13_lv_pmos ad=0.2128p pd=1.5u as=0.2128p ps=1.5u w=1.12u l=0.13u
X331 VGND.t41 VPWR.t110 VGND.t41 VGND.t40 sg13_lv_nmos ad=0.1428p pd=1.52u as=0 ps=0 w=0.42u l=1u
X332 VPWR.t726 a_6094_4656# sg13cmos5l_buf_16_31.X VPWR.t64 sg13_lv_pmos ad=0.2128p pd=1.5u as=0.2128p ps=1.5u w=1.12u l=0.13u
X333 VPWR.t582 a_5684_6132# sg13cmos5l_buf_16_28.X VPWR.t61 sg13_lv_pmos ad=0.2128p pd=1.5u as=0.2128p ps=1.5u w=1.12u l=0.13u
X334 VPWR.t921 a_5518_6922# sg13cmos5l_buf_16_6.X VPWR.t58 sg13_lv_pmos ad=0.3976p pd=2.95u as=0.2128p ps=1.5u w=1.12u l=0.13u
X335 sg13cmos5l_buf_16_2.A a_9262_7680# VGND.t5 VGND.t114 sg13_lv_nmos ad=0.1406p pd=1.12u as=0.1406p ps=1.12u w=0.74u l=0.13u
X336 VGND.t1286 VPWR.t126 VGND.t1286 VGND.t1325 sg13_lv_nmos ad=0.1428p pd=1.52u as=0 ps=0 w=0.42u l=1u
X337 VGND.t845 a_5108_838# sg13cmos5l_buf_16_5.X VGND.t1463 sg13_lv_nmos ad=0.1406p pd=1.12u as=0.1406p ps=1.12u w=0.74u l=0.13u
X338 VGND.t157 a_6836_9156# sg13cmos5l_buf_16_25.A VGND.t159 sg13_lv_nmos ad=0.1406p pd=1.12u as=0.1406p ps=1.12u w=0.74u l=0.13u
X339 a_13713_11776# sg13cmos5l_buf_1_15.X VPWR.t131 VPWR.t8 sg13_lv_pmos ad=0.1225p pd=1.245u as=0.36p ps=2.72u w=1u l=0.13u
X340 VGND.t597 VPWR.t0 VGND.t601 VGND.t914 sg13_lv_nmos ad=79.8f pd=0.8u as=0 ps=0 w=0.42u l=1u
X341 a_6862_9946# sg13cmos5l_buf_16_24.A VGND.t66 VGND.t155 sg13_lv_nmos ad=0.1406p pd=1.12u as=0.1406p ps=1.12u w=0.74u l=0.13u
X342 VPWR.t305 a_3668_9156# sg13cmos5l_buf_16_13.A VPWR.t5 sg13_lv_pmos ad=0.2128p pd=1.5u as=0.2128p ps=1.5u w=1.12u l=0.13u
X343 sg13cmos5l_buf_16_20.A a_5204_11422# VGND.t134 VGND.t2 sg13_lv_nmos ad=0.1406p pd=1.12u as=0.1406p ps=1.12u w=0.74u l=0.13u
X344 sg13cmos5l_buf_16_5.X a_5108_838# VGND.t845 VGND.t1458 sg13_lv_nmos ad=0.1406p pd=1.12u as=0.1406p ps=1.12u w=0.74u l=0.13u
X345 VPWR.t56 a_5108_838# sg13cmos5l_buf_16_5.X VPWR.t55 sg13_lv_pmos ad=0.2128p pd=1.5u as=0.2128p ps=1.5u w=1.12u l=0.13u
X346 sg13cmos5l_buf_16_1.X a_10318_5410# VPWR.t96 VPWR.t61 sg13_lv_pmos ad=0.2128p pd=1.5u as=0.2128p ps=1.5u w=1.12u l=0.13u
X347 VGND.t1061 VPWR.t6 VGND.t1073 VGND.t1072 sg13_lv_nmos ad=79.8f pd=0.8u as=0 ps=0 w=0.42u l=1u
X348 VPWR.t519 VGND.t1292 VPWR.t126 VPWR.t55 sg13_lv_pmos ad=0.34p pd=2.68u as=0 ps=0 w=1u l=1u
X349 VPWR.t110 VGND.t349 VPWR.t110 VPWR.t64 sg13_lv_pmos ad=0.34p pd=2.68u as=0 ps=0 w=1u l=1u
X350 sg13cmos5l_buf_16_6.X a_5518_6922# VPWR.t917 VPWR.t58 sg13_lv_pmos ad=0.2128p pd=1.5u as=0.2128p ps=1.5u w=1.12u l=0.13u
X351 sg13cmos5l_buf_16_37.X a_7796_12934# VPWR.t1146 VPWR.t79 sg13_lv_pmos ad=0.2128p pd=1.5u as=0.3976p ps=2.95u w=1.12u l=0.13u
X352 VPWR.t717 a_7220_5374# sg13cmos5l_buf_16_28.A VPWR.t61 sg13_lv_pmos ad=0.2128p pd=1.5u as=0.2128p ps=1.5u w=1.12u l=0.13u
X353 VGND.t891 a_6548_13692# sg13cmos5l_buf_16_27.X VGND.t1482 sg13_lv_nmos ad=0.1406p pd=1.12u as=0.1406p ps=1.12u w=0.74u l=0.13u
X354 sg13cmos5l_and2_2_3.B a_13576_14516# VGND.t206 VGND.t1434 sg13_lv_nmos ad=0.2886p pd=2.26u as=0.14875p ps=1.16u w=0.74u l=0.13u
X355 VPWR.t55 VGND.t1274 VPWR.t55 VPWR.t55 sg13_lv_pmos ad=0.34p pd=2.68u as=0 ps=0 w=1u l=1u
X356 VGND.t1196 VPWR.t1622 VGND.t1196 VGND.t1198 sg13_lv_nmos ad=0.1428p pd=1.52u as=0 ps=0 w=0.42u l=1u
X357 VPWR.t56 a_5710_1632# sg13cmos5l_buf_16_5.A VPWR.t55 sg13_lv_pmos ad=0.2128p pd=1.5u as=0.2128p ps=1.5u w=1.12u l=0.13u
X358 VGND.t1292 VPWR.t113 VGND.t1292 VGND.t1291 sg13_lv_nmos ad=0.1428p pd=1.52u as=0 ps=0 w=0.42u l=1u
X359 a_10318_8434# sg13cmos5l_buf_16_1.X VPWR.t440 VPWR.t5 sg13_lv_pmos ad=0.2128p pd=1.5u as=0.2128p ps=1.5u w=1.12u l=0.13u
X360 VGND.t1010 VPWR.t129 VGND.t1010 VGND.t2 sg13_lv_nmos ad=0.1428p pd=1.52u as=0 ps=0 w=0.42u l=1u
X361 VPWR.t216 VGND.t1286 VPWR.t216 VPWR.t67 sg13_lv_pmos ad=0.34p pd=2.68u as=0 ps=0 w=1u l=1u
X362 sg13cmos5l_buf_16_24.A a_6094_10704# VGND.t139 VGND.t2 sg13_lv_nmos ad=0.1406p pd=1.12u as=0.1406p ps=1.12u w=0.74u l=0.13u
X363 VPWR.t216 a_8494_3144# sg13cmos5l_buf_16_39.A VPWR.t67 sg13_lv_pmos ad=0.3976p pd=2.95u as=0.2128p ps=1.5u w=1.12u l=0.13u
X364 VGND.t726 VPWR.t28 VGND.t726 VGND.t2 sg13_lv_nmos ad=79.8f pd=0.8u as=0 ps=0 w=0.42u l=1u
X365 VGND.t198 a_3694_2386# sg13cmos5l_buf_16_7.X VGND.t1580 sg13_lv_nmos ad=0.2516p pd=2.16u as=0.1406p ps=1.12u w=0.74u l=0.13u
X366 sg13cmos5l_buf_16_28.A a_7220_5374# VPWR.t713 VPWR.t61 sg13_lv_pmos ad=0.2128p pd=1.5u as=0.2128p ps=1.5u w=1.12u l=0.13u
X367 VGND.t351 a_4462_5410# sg13cmos5l_buf_16_11.A VGND.t434 sg13_lv_nmos ad=0.1406p pd=1.12u as=0.1406p ps=1.12u w=0.74u l=0.13u
X368 VGND.t93 a_6094_3144# sg13cmos5l_xor2_1_0.B VGND.t40 sg13_lv_nmos ad=0.2516p pd=2.16u as=0.1406p ps=1.12u w=0.74u l=0.13u
X369 VPWR.t21 VGND.t590 VPWR.t21 VPWR.t8 sg13_lv_pmos ad=0.19p pd=1.38u as=0 ps=0 w=1u l=1u
X370 sg13cmos5l_buf_16_7.A a_3668_3108# VGND.t122 VGND.t40 sg13_lv_nmos ad=0.1406p pd=1.12u as=0.1406p ps=1.12u w=0.74u l=0.13u
X371 sg13cmos5l_buf_16_24.A a_6094_10704# VPWR.t1192 VPWR.t2 sg13_lv_pmos ad=0.2128p pd=1.5u as=0.2128p ps=1.5u w=1.12u l=0.13u
X372 VGND.t7 sg13cmos5l_buf_16_35.A a_8110_6168# VGND.t11 sg13_lv_nmos ad=0.1406p pd=1.12u as=0.1406p ps=1.12u w=0.74u l=0.13u
X373 a_6862_9946# sg13cmos5l_buf_16_24.A VPWR.t630 VPWR.t2 sg13_lv_pmos ad=0.2128p pd=1.5u as=0.2128p ps=1.5u w=1.12u l=0.13u
X374 sg13cmos5l_buf_16_2.X a_10318_3898# VGND.t41 VGND.t40 sg13_lv_nmos ad=0.1406p pd=1.12u as=0.1406p ps=1.12u w=0.74u l=0.13u
X375 VPWR.t291 VGND.t260 VPWR.t290 VPWR.t2 sg13_lv_pmos ad=0.34p pd=2.68u as=0 ps=0 w=1u l=1u
X376 VGND.t457 a_3668_12180# sg13cmos5l_buf_16_15.X VGND.t456 sg13_lv_nmos ad=0.1406p pd=1.12u as=0.1406p ps=1.12u w=0.74u l=0.13u
X377 VPWR.t177 VGND.t61 VPWR.t175 VPWR.t5 sg13_lv_pmos ad=0.19p pd=1.38u as=0 ps=0 w=1u l=1u
X378 VPWR.t21 VGND.t726 VPWR.t20 VPWR.t8 sg13_lv_pmos ad=0.34p pd=2.68u as=0 ps=0 w=1u l=1u
X379 VPWR.t146 sg13cmos5l_buf_16_35.A a_9788_8728# VPWR.t5 sg13_lv_pmos ad=0.2128p pd=1.5u as=0.3808p ps=2.92u w=1.12u l=0.13u
X380 sg13cmos5l_buf_16_39.A a_8494_3144# VPWR.t216 VPWR.t67 sg13_lv_pmos ad=0.2128p pd=1.5u as=0.2128p ps=1.5u w=1.12u l=0.13u
X381 sg13cmos5l_buf_16_7.X a_3694_2386# VGND.t198 VGND.t1577 sg13_lv_nmos ad=0.1406p pd=1.12u as=0.1406p ps=1.12u w=0.74u l=0.13u
X382 VPWR.t566 sg13cmos5l_buf_16_37.A a_7796_12934# VPWR.t79 sg13_lv_pmos ad=0.2128p pd=1.5u as=0.2128p ps=1.5u w=1.12u l=0.13u
X383 VPWR.t1583 a_3694_2386# sg13cmos5l_buf_16_7.X VPWR.t67 sg13_lv_pmos ad=0.2128p pd=1.5u as=0.2128p ps=1.5u w=1.12u l=0.13u
X384 sg13cmos5l_buf_16_11.A a_4462_5410# VGND.t351 VGND.t431 sg13_lv_nmos ad=0.1406p pd=1.12u as=0.1406p ps=1.12u w=0.74u l=0.13u
X385 VGND.t843 VPWR.t120 VGND.t843 VGND.t1302 sg13_lv_nmos ad=0.1428p pd=1.52u as=0 ps=0 w=0.42u l=1u
X386 VGND.t25 a_5710_1632# sg13cmos5l_buf_16_5.A VGND.t867 sg13_lv_nmos ad=0.2516p pd=2.16u as=0.1406p ps=1.12u w=0.74u l=0.13u
X387 VGND.t237 VPWR.t131 VGND.t237 VGND.t956 sg13_lv_nmos ad=0.1428p pd=1.52u as=0 ps=0 w=0.42u l=1u
X388 VGND.t122 a_3668_3108# sg13cmos5l_buf_16_7.A VGND.t40 sg13_lv_nmos ad=0.1406p pd=1.12u as=0.1406p ps=1.12u w=0.74u l=0.13u
X389 a_7629_8028# sg13cmos5l_and2_2_6.A VPWR.t789 VPWR.t58 sg13_lv_pmos ad=0.1596p pd=1.22u as=0.2856p ps=2.36u w=0.84u l=0.13u
X390 a_8948_13692# sg13cmos5l_buf_16_23.X VPWR.t566 VPWR.t79 sg13_lv_pmos ad=0.2128p pd=1.5u as=0.2128p ps=1.5u w=1.12u l=0.13u
X391 VPWR.t120 VGND.t1298 VPWR.t120 VPWR.t67 sg13_lv_pmos ad=0.34p pd=2.68u as=0 ps=0 w=1u l=1u
X392 sg13cmos5l_buf_16_37.X a_7796_12934# VGND.t590 VGND.t692 sg13_lv_nmos ad=0.1406p pd=1.12u as=0.1406p ps=1.12u w=0.74u l=0.13u
X393 a_8110_6168# sg13cmos5l_buf_16_35.A VGND.t7 VGND.t6 sg13_lv_nmos ad=0.1406p pd=1.12u as=0.2516p ps=2.16u w=0.74u l=0.13u
X394 VPWR.t213 sg13cmos5l_buf_16_34.A a_3694_7680# VPWR.t58 sg13_lv_pmos ad=0.2128p pd=1.5u as=0.2128p ps=1.5u w=1.12u l=0.13u
X395 VPWR.t1044 VGND.t898 VPWR.t1043 VPWR.t79 sg13_lv_pmos ad=0.34p pd=2.68u as=0 ps=0 w=1u l=1u
X396 VPWR.t81 VGND.t924 VPWR.t81 VPWR.t79 sg13_lv_pmos ad=0.34p pd=2.68u as=0 ps=0 w=1u l=1u
X397 a_9585_8752# sg13cmos5l_buf_16_35.A VPWR.t146 VPWR.t5 sg13_lv_pmos ad=0.1225p pd=1.245u as=0.36p ps=2.72u w=1u l=0.13u
X398 VPWR.t205 VGND.t1372 VPWR.t205 VPWR.t55 sg13_lv_pmos ad=0.34p pd=2.68u as=0 ps=0 w=1u l=1u
X399 VGND.t41 a_10318_3898# sg13cmos5l_buf_16_2.X VGND.t40 sg13_lv_nmos ad=0.1406p pd=1.12u as=0.1406p ps=1.12u w=0.74u l=0.13u
X400 sg13cmos5l_xor2_1_0.B a_6094_3144# VPWR.t767 VPWR.t67 sg13_lv_pmos ad=0.2128p pd=1.5u as=0.2128p ps=1.5u w=1.12u l=0.13u
X401 VPWR.t91 a_11565_8028# sg13cmos5l_buf_16_4.A VPWR.t58 sg13_lv_pmos ad=0.4256p pd=3u as=0.2128p ps=1.5u w=1.12u l=0.13u
X402 VGND.t891 a_4174_13728# sg13cmos5l_buf_16_18.A VGND.t1444 sg13_lv_nmos ad=0.1406p pd=1.12u as=0.1406p ps=1.12u w=0.74u l=0.13u
X403 VPWR.t566 a_8948_13692# sg13cmos5l_buf_16_37.A VPWR.t79 sg13_lv_pmos ad=0.2128p pd=1.5u as=0.2128p ps=1.5u w=1.12u l=0.13u
X404 a_10318_8434# sg13cmos5l_buf_16_1.X VPWR.t146 VPWR.t5 sg13_lv_pmos ad=0.2128p pd=1.5u as=0.3808p ps=2.92u w=1.12u l=0.13u
X405 a_14444_14442# glitch_en[6] VGND.t924 VGND.t1476 sg13_lv_nmos ad=0.187p pd=1.78u as=0.14875p ps=1.16u w=0.55u l=0.13u
X406 sg13cmos5l_buf_16_7.X a_3694_2386# VPWR.t1579 VPWR.t67 sg13_lv_pmos ad=0.2128p pd=1.5u as=0.2128p ps=1.5u w=1.12u l=0.13u
X407 VPWR.t1300 a_3020_14442# sg13cmos5l_and2_2_1.B VPWR.t0 sg13_lv_pmos ad=0.2114p pd=1.54u as=0.42p ps=2.99u w=1.12u l=0.13u
X408 sg13cmos5l_buf_1_14.X a_14344_8468# VPWR.t132 VPWR.t5 sg13_lv_pmos ad=0.42p pd=2.99u as=0.2114p ps=1.54u w=1.12u l=0.13u
X409 VGND.t620 VPWR.t1685 VGND.t682 VGND.t953 sg13_lv_nmos ad=79.8f pd=0.8u as=0 ps=0 w=0.42u l=1u
X410 a_6094_4656# sg13cmos5l_buf_16_7.X VPWR.t1271 VPWR.t64 sg13_lv_pmos ad=0.2128p pd=1.5u as=0.2128p ps=1.5u w=1.12u l=0.13u
X411 a_3694_7680# sg13cmos5l_buf_16_34.A VPWR.t210 VPWR.t58 sg13_lv_pmos ad=0.2128p pd=1.5u as=0.3808p ps=2.92u w=1.12u l=0.13u
X412 VGND.t870 sg13cmos5l_buf_16_15.X a_3694_14482# VGND.t873 sg13_lv_nmos ad=0.1406p pd=1.12u as=0.1406p ps=1.12u w=0.74u l=0.13u
X413 VGND.t444 a_3668_12180# sg13cmos5l_buf_16_15.X VGND.t451 sg13_lv_nmos ad=0.1406p pd=1.12u as=0.1406p ps=1.12u w=0.74u l=0.13u
X414 VGND.t1292 VPWR.t126 VGND.t1292 VGND.t1327 sg13_lv_nmos ad=0.1428p pd=1.52u as=0 ps=0 w=0.42u l=1u
X415 VGND.t1398 VPWR.t126 VGND.t1397 VGND.t1396 sg13_lv_nmos ad=0.1428p pd=1.52u as=0 ps=0 w=0.42u l=1u
X416 sg13cmos5l_buf_16_2.X a_10318_3898# VGND.t41 VGND.t40 sg13_lv_nmos ad=0.1406p pd=1.12u as=0.1406p ps=1.12u w=0.74u l=0.13u
X417 VGND.t870 a_3694_14482# sg13cmos5l_buf_16_33.A VGND.t886 sg13_lv_nmos ad=0.1406p pd=1.12u as=0.1406p ps=1.12u w=0.74u l=0.13u
X418 out_xor[0] a_14824_1632# VGND.t843 VGND.t842 sg13_lv_nmos ad=0.2886p pd=2.26u as=0.14875p ps=1.16u w=0.74u l=0.13u
X419 sg13cmos5l_buf_16_11.A a_4462_5410# VPWR.t804 VPWR.t61 sg13_lv_pmos ad=0.2128p pd=1.5u as=0.2128p ps=1.5u w=1.12u l=0.13u
X420 VPWR.t63 VGND.t1412 VPWR.t63 VPWR.t55 sg13_lv_pmos ad=0.34p pd=2.68u as=0 ps=0 w=1u l=1u
X421 VGND.t532 sg13cmos5l_buf_1_4.A a_14824_6956# VGND.t531 sg13_lv_nmos ad=0.14875p pd=1.16u as=0.187p ps=1.78u w=0.55u l=0.13u
X422 VPWR.t566 a_7796_12934# sg13cmos5l_buf_16_37.X VPWR.t79 sg13_lv_pmos ad=0.2128p pd=1.5u as=0.2128p ps=1.5u w=1.12u l=0.13u
X423 VPWR.t565 sg13cmos5l_buf_16_7.A a_3694_2386# VPWR.t67 sg13_lv_pmos ad=0.2128p pd=1.5u as=0.2128p ps=1.5u w=1.12u l=0.13u
X424 sg13cmos5l_buf_16_37.A a_8948_13692# VPWR.t566 VPWR.t79 sg13_lv_pmos ad=0.2128p pd=1.5u as=0.2128p ps=1.5u w=1.12u l=0.13u
X425 sg13cmos5l_buf_16_7.X a_3694_2386# VGND.t198 VGND.t1573 sg13_lv_nmos ad=0.1406p pd=1.12u as=0.1406p ps=1.12u w=0.74u l=0.13u
X426 VPWR.t748 a_6094_3898# sg13cmos5l_buf_16_0.A VPWR.t64 sg13_lv_pmos ad=0.2128p pd=1.5u as=0.2128p ps=1.5u w=1.12u l=0.13u
X427 sg13cmos5l_buf_16_37.X a_7796_12934# VGND.t590 VGND.t688 sg13_lv_nmos ad=0.1406p pd=1.12u as=0.1406p ps=1.12u w=0.74u l=0.13u
X428 sg13cmos5l_buf_16_14.A a_4436_9910# VPWR.t1224 VPWR.t2 sg13_lv_pmos ad=0.2128p pd=1.5u as=0.2128p ps=1.5u w=1.12u l=0.13u
X429 VPWR.t566 a_8948_13692# sg13cmos5l_buf_16_37.A VPWR.t79 sg13_lv_pmos ad=0.2128p pd=1.5u as=0.2128p ps=1.5u w=1.12u l=0.13u
X430 VPWR.t135 a_14252_9906# sg13cmos5l_buf_1_15.X VPWR.t2 sg13_lv_pmos ad=0.2114p pd=1.54u as=0.42p ps=2.99u w=1.12u l=0.13u
X431 VGND.t260 a_3668_9156# sg13cmos5l_buf_16_13.A VGND.t261 sg13_lv_nmos ad=0.1406p pd=1.12u as=0.1406p ps=1.12u w=0.74u l=0.13u
X432 sg13cmos5l_xor2_1_0.B a_6094_3144# VPWR.t763 VPWR.t67 sg13_lv_pmos ad=0.2128p pd=1.5u as=0.2128p ps=1.5u w=1.12u l=0.13u
X433 sg13cmos5l_buf_16_31.X a_6094_4656# VGND.t171 VGND.t361 sg13_lv_nmos ad=0.1406p pd=1.12u as=0.1406p ps=1.12u w=0.74u l=0.13u
X434 VGND.t1292 VPWR.t117 VGND.t1292 VGND.t1294 sg13_lv_nmos ad=0.1428p pd=1.52u as=0 ps=0 w=0.42u l=1u
X435 sg13cmos5l_buf_16_4.X a_9524_6886# VGND.t7 VGND.t551 sg13_lv_nmos ad=0.1406p pd=1.12u as=0.1406p ps=1.12u w=0.74u l=0.13u
X436 VGND.t3 a_13745_11508# sg13cmos5l_xor2_1_7.X VGND.t2 sg13_lv_nmos ad=0.3108p pd=2.32u as=0.1628p ps=1.18u w=0.74u l=0.13u
X437 VPWR.t113 VGND.t1292 VPWR.t113 VPWR.t67 sg13_lv_pmos ad=0.34p pd=2.68u as=0 ps=0 w=1u l=1u
X438 VGND.t1349 VPWR.t156 VGND.t1348 VGND.t1347 sg13_lv_nmos ad=0.1428p pd=1.52u as=0 ps=0 w=0.42u l=1u
X439 sg13cmos5l_buf_16_14.A a_4436_9910# VPWR.t1220 VPWR.t2 sg13_lv_pmos ad=0.2128p pd=1.5u as=0.2128p ps=1.5u w=1.12u l=0.13u
X440 VPWR.t46 VGND.t597 VPWR.t45 VPWR.t0 sg13_lv_pmos ad=0.34p pd=2.68u as=0 ps=0 w=1u l=1u
X441 VPWR.t91 sg13cmos5l_buf_16_4.A a_9524_6886# VPWR.t58 sg13_lv_pmos ad=0.3808p pd=2.92u as=0.2128p ps=1.5u w=1.12u l=0.13u
X442 VGND.t50 a_3694_7680# sg13cmos5l_buf_16_34.X VGND.t54 sg13_lv_nmos ad=0.1406p pd=1.12u as=0.1406p ps=1.12u w=0.74u l=0.13u
X443 VPWR.t687 sg13cmos5l_buf_16_8.A a_3694_3898# VPWR.t64 sg13_lv_pmos ad=0.2128p pd=1.5u as=0.2128p ps=1.5u w=1.12u l=0.13u
X444 VPWR.t610 VGND.t1141 VPWR.t608 VPWR.t61 sg13_lv_pmos ad=0.19p pd=1.38u as=0 ps=0 w=1u l=1u
X445 a_3694_10704# sg13cmos5l_buf_16_34.X VGND.t134 VGND.t2 sg13_lv_nmos ad=0.1406p pd=1.12u as=0.1406p ps=1.12u w=0.74u l=0.13u
X446 sg13cmos5l_and2_2_6.A a_3694_10704# VGND.t134 VGND.t2 sg13_lv_nmos ad=0.1406p pd=1.12u as=0.1406p ps=1.12u w=0.74u l=0.13u
X447 VGND.t1061 VPWR.t3 VGND.t1061 VGND.t1069 sg13_lv_nmos ad=0.1428p pd=1.52u as=0 ps=0 w=0.42u l=1u
X448 sg13cmos5l_buf_16_5.A a_5710_1632# VGND.t837 VGND.t860 sg13_lv_nmos ad=0.1406p pd=1.12u as=0.1406p ps=1.12u w=0.74u l=0.13u
X449 VPWR.t1416 a_6548_13692# sg13cmos5l_buf_16_27.X VPWR.t79 sg13_lv_pmos ad=0.2128p pd=1.5u as=0.2128p ps=1.5u w=1.12u l=0.13u
X450 out_xor[6] a_14824_13004# VPWR.t81 VPWR.t79 sg13_lv_pmos ad=0.42p pd=2.99u as=0.2114p ps=1.54u w=1.12u l=0.13u
X451 sg13cmos5l_buf_16_31.X a_6094_4656# VGND.t171 VGND.t357 sg13_lv_nmos ad=0.1406p pd=1.12u as=0.1406p ps=1.12u w=0.74u l=0.13u
X452 VGND.t157 sg13cmos5l_and2_2_6.X a_6836_9156# VGND.t477 sg13_lv_nmos ad=0.2516p pd=2.16u as=0.1406p ps=1.12u w=0.74u l=0.13u
X453 sg13cmos5l_buf_16_34.X a_3694_7680# VGND.t50 VGND.t51 sg13_lv_nmos ad=0.1406p pd=1.12u as=0.1406p ps=1.12u w=0.74u l=0.13u
X454 VGND.t597 a_8948_13692# sg13cmos5l_buf_16_37.A VGND.t657 sg13_lv_nmos ad=0.1406p pd=1.12u as=0.1406p ps=1.12u w=0.74u l=0.13u
X455 sg13cmos5l_and2_2_6.A a_3694_10704# VPWR.t1210 VPWR.t2 sg13_lv_pmos ad=0.2128p pd=1.5u as=0.2128p ps=1.5u w=1.12u l=0.13u
X456 VGND.t1061 VPWR.t6 VGND.t1061 VGND.t1068 sg13_lv_nmos ad=79.8f pd=0.8u as=0 ps=0 w=0.42u l=1u
X457 sg13cmos5l_buf_16_33.A a_3694_14482# VGND.t870 VGND.t889 sg13_lv_nmos ad=0.1406p pd=1.12u as=0.1406p ps=1.12u w=0.74u l=0.13u
X458 a_4052_12934# sg13cmos5l_buf_16_18.A VGND.t620 VGND.t644 sg13_lv_nmos ad=0.1406p pd=1.12u as=0.1406p ps=1.12u w=0.74u l=0.13u
X459 VGND.t18 a_3694_8434# sg13cmos5l_buf_16_34.A VGND.t47 sg13_lv_nmos ad=0.1406p pd=1.12u as=0.1406p ps=1.12u w=0.74u l=0.13u
X460 sg13cmos5l_buf_16_22.X a_10318_8434# VGND.t5 VGND.t583 sg13_lv_nmos ad=0.1406p pd=1.12u as=0.1406p ps=1.12u w=0.74u l=0.13u
X461 sg13cmos5l_buf_16_7.A a_3668_3108# VPWR.t846 VPWR.t67 sg13_lv_pmos ad=0.2128p pd=1.5u as=0.2128p ps=1.5u w=1.12u l=0.13u
X462 sg13cmos5l_buf_16_39.A a_8494_3144# VGND.t302 VGND.t40 sg13_lv_nmos ad=0.1406p pd=1.12u as=0.1406p ps=1.12u w=0.74u l=0.13u
X463 VPWR.t1027 VGND.t989 VPWR.t1026 VPWR.t2 sg13_lv_pmos ad=0.34p pd=2.68u as=0 ps=0 w=1u l=1u
X464 VGND.t1050 VPWR.t1664 VGND.t1050 VGND.t1049 sg13_lv_nmos ad=0.1428p pd=1.52u as=0 ps=0 w=0.42u l=1u
X465 sg13cmos5l_buf_16_24.X a_6862_9946# VGND.t157 VGND.t474 sg13_lv_nmos ad=0.1406p pd=1.12u as=0.1406p ps=1.12u w=0.74u l=0.13u
X466 a_3694_3898# sg13cmos5l_buf_16_8.A VPWR.t684 VPWR.t64 sg13_lv_pmos ad=0.2128p pd=1.5u as=0.3808p ps=2.92u w=1.12u l=0.13u
X467 VPWR.t744 a_6094_3898# sg13cmos5l_buf_16_0.A VPWR.t64 sg13_lv_pmos ad=0.2128p pd=1.5u as=0.2128p ps=1.5u w=1.12u l=0.13u
X468 VGND.t5 VPWR.t1650 VGND.t5 VGND.t1100 sg13_lv_nmos ad=0.1428p pd=1.52u as=0 ps=0 w=0.42u l=1u
X469 VPWR.t348 a_9262_7680# sg13cmos5l_buf_16_2.A VPWR.t58 sg13_lv_pmos ad=0.2128p pd=1.5u as=0.2128p ps=1.5u w=1.12u l=0.13u
X470 a_6164_2350# sg13cmos5l_buf_16_39.A VPWR.t219 VPWR.t67 sg13_lv_pmos ad=0.2128p pd=1.5u as=0.2128p ps=1.5u w=1.12u l=0.13u
X471 VGND.t590 VPWR.t16 VGND.t590 VGND.t975 sg13_lv_nmos ad=79.8f pd=0.8u as=0 ps=0 w=0.42u l=1u
X472 a_3694_8434# sg13cmos5l_buf_16_13.A VGND.t18 VGND.t22 sg13_lv_nmos ad=0.1406p pd=1.12u as=0.1406p ps=1.12u w=0.74u l=0.13u
X473 VGND.t5 a_10318_8434# sg13cmos5l_buf_16_22.X VGND.t580 sg13_lv_nmos ad=0.1406p pd=1.12u as=0.1406p ps=1.12u w=0.74u l=0.13u
X474 VPWR.t226 VGND.t1417 VPWR.t226 VPWR.t55 sg13_lv_pmos ad=0.34p pd=2.68u as=0 ps=0 w=1u l=1u
X475 VGND.t96 a_8494_3144# sg13cmos5l_buf_16_39.A VGND.t40 sg13_lv_nmos ad=0.1406p pd=1.12u as=0.1406p ps=1.12u w=0.74u l=0.13u
X476 VGND.t157 a_6862_9946# sg13cmos5l_buf_16_24.X VGND.t169 sg13_lv_nmos ad=0.1406p pd=1.12u as=0.1406p ps=1.12u w=0.74u l=0.13u
X477 VPWR.t1412 a_6548_13692# sg13cmos5l_buf_16_27.X VPWR.t79 sg13_lv_pmos ad=0.2128p pd=1.5u as=0.2128p ps=1.5u w=1.12u l=0.13u
X478 sg13cmos5l_buf_16_19.A a_6765_12564# VPWR.t1172 VPWR.t8 sg13_lv_pmos ad=0.2128p pd=1.5u as=0.1918p ps=1.5u w=1.12u l=0.13u
X479 VPWR.t26 a_6862_9946# sg13cmos5l_buf_16_24.X VPWR.t2 sg13_lv_pmos ad=0.3976p pd=2.95u as=0.2128p ps=1.5u w=1.12u l=0.13u
X480 VPWR.t159 VGND.t194 VPWR.t158 VPWR.t67 sg13_lv_pmos ad=0.19p pd=1.38u as=0 ps=0 w=1u l=1u
X481 VGND.t42 VPWR.t125 VGND.t42 VGND.t40 sg13_lv_nmos ad=79.8f pd=0.8u as=0 ps=0 w=0.42u l=1u
X482 VGND.t139 a_3694_10704# sg13cmos5l_and2_2_6.A VGND.t2 sg13_lv_nmos ad=0.2516p pd=2.16u as=0.1406p ps=1.12u w=0.74u l=0.13u
X483 VPWR.t266 a_3694_8434# sg13cmos5l_buf_16_34.A VPWR.t5 sg13_lv_pmos ad=0.2128p pd=1.5u as=0.2128p ps=1.5u w=1.12u l=0.13u
X484 sg13cmos5l_buf_16_15.A a_4052_12934# VGND.t444 VGND.t608 sg13_lv_nmos ad=0.1406p pd=1.12u as=0.1406p ps=1.12u w=0.74u l=0.13u
X485 VGND.t989 VPWR.t1676 VGND.t989 VGND.t2 sg13_lv_nmos ad=79.8f pd=0.8u as=0 ps=0 w=0.42u l=1u
X486 VGND.t5 sg13cmos5l_buf_16_4.X a_9262_7680# VGND.t771 sg13_lv_nmos ad=0.1406p pd=1.12u as=0.1406p ps=1.12u w=0.74u l=0.13u
X487 a_8694_2398# sg13cmos5l_xor2_1_0.B sg13cmos5l_buf_1_2.A VGND.t805 sg13_lv_nmos ad=88.8f pd=0.98u as=0.1628p ps=1.18u w=0.74u l=0.13u
X488 VGND.t139 sg13cmos5l_buf_16_19.A a_5204_11422# VGND.t2 sg13_lv_nmos ad=0.1406p pd=1.12u as=0.1406p ps=1.12u w=0.74u l=0.13u
X489 a_5684_6132# sg13cmos5l_buf_16_28.A VPWR.t1255 VPWR.t61 sg13_lv_pmos ad=0.2128p pd=1.5u as=0.2128p ps=1.5u w=1.12u l=0.13u
X490 VGND.t210 a_8110_6168# sg13cmos5l_buf_16_38.A VGND.t785 sg13_lv_nmos ad=0.1406p pd=1.12u as=0.1406p ps=1.12u w=0.74u l=0.13u
X491 VGND.t125 a_3694_3898# sg13cmos5l_buf_16_10.A VGND.t40 sg13_lv_nmos ad=0.1406p pd=1.12u as=0.1406p ps=1.12u w=0.74u l=0.13u
X492 VPWR.t1473 VGND.t1147 VPWR.t1472 VPWR.t61 sg13_lv_pmos ad=0.34p pd=2.68u as=0 ps=0 w=1u l=1u
X493 VGND.t989 VPWR.t1669 VGND.t989 VGND.t2 sg13_lv_nmos ad=79.8f pd=0.8u as=0 ps=0 w=0.42u l=1u
X494 sg13cmos5l_buf_16_34.A a_3694_8434# VPWR.t262 VPWR.t5 sg13_lv_pmos ad=0.2128p pd=1.5u as=0.2128p ps=1.5u w=1.12u l=0.13u
X495 VGND.t42 VPWR.t1614 VGND.t1237 VGND.t40 sg13_lv_nmos ad=79.8f pd=0.8u as=0 ps=0 w=0.42u l=1u
X496 sg13cmos5l_buf_16_15.X a_3668_12180# VPWR.t822 VPWR.t8 sg13_lv_pmos ad=0.2128p pd=1.5u as=0.2128p ps=1.5u w=1.12u l=0.13u
X497 VPWR.t519 VGND.t1402 VPWR.t63 VPWR.t55 sg13_lv_pmos ad=0.34p pd=2.68u as=0 ps=0 w=1u l=1u
X498 a_5518_6922# sg13cmos5l_buf_16_28.X VGND.t218 VGND.t631 sg13_lv_nmos ad=0.1406p pd=1.12u as=0.1406p ps=1.12u w=0.74u l=0.13u
X499 VPWR.t1408 a_6548_13692# sg13cmos5l_buf_16_27.X VPWR.t79 sg13_lv_pmos ad=0.2128p pd=1.5u as=0.2128p ps=1.5u w=1.12u l=0.13u
X500 a_6426_12574# sg13cmos5l_buf_16_15.A VGND.t620 VGND.t705 sg13_lv_nmos ad=88.8f pd=0.98u as=0.15245p ps=1.17u w=0.74u l=0.13u
X501 VPWR.t113 VGND.t1292 VPWR.t117 VPWR.t67 sg13_lv_pmos ad=0.34p pd=2.68u as=0 ps=0 w=1u l=1u
X502 sg13cmos5l_buf_16_5.X a_5108_838# VGND.t845 VGND.t1464 sg13_lv_nmos ad=0.1406p pd=1.12u as=0.1406p ps=1.12u w=0.74u l=0.13u
X503 VPWR.t28 VGND.t1061 VPWR.t26 VPWR.t2 sg13_lv_pmos ad=0.34p pd=2.68u as=0 ps=0 w=1u l=1u
X504 sg13cmos5l_buf_16_20.A a_5204_11422# VPWR.t487 VPWR.t8 sg13_lv_pmos ad=0.2128p pd=1.5u as=0.2128p ps=1.5u w=1.12u l=0.13u
X505 VPWR.t592 a_5684_6132# sg13cmos5l_buf_16_28.X VPWR.t61 sg13_lv_pmos ad=0.2128p pd=1.5u as=0.2128p ps=1.5u w=1.12u l=0.13u
X506 sg13cmos5l_buf_16_3.X a_10292_4620# VGND.t76 VGND.t82 sg13_lv_nmos ad=0.1406p pd=1.12u as=0.1406p ps=1.12u w=0.74u l=0.13u
X507 VGND.t134 a_3694_10704# sg13cmos5l_and2_2_6.A VGND.t2 sg13_lv_nmos ad=0.1406p pd=1.12u as=0.1406p ps=1.12u w=0.74u l=0.13u
X508 VGND.t845 a_5108_838# sg13cmos5l_buf_16_5.X VGND.t1459 sg13_lv_nmos ad=0.1406p pd=1.12u as=0.1406p ps=1.12u w=0.74u l=0.13u
X509 a_11924_13728# sg13cmos5l_buf_1_17.X VPWR.t566 VPWR.t79 sg13_lv_pmos ad=0.3808p pd=2.92u as=0.2128p ps=1.5u w=1.12u l=0.13u
X510 sg13cmos5l_buf_16_15.A a_4052_12934# VGND.t444 VGND.t604 sg13_lv_nmos ad=0.1406p pd=1.12u as=0.2516p ps=2.16u w=0.74u l=0.13u
X511 VPWR.t261 sg13cmos5l_buf_16_13.A a_3694_8434# VPWR.t5 sg13_lv_pmos ad=0.2128p pd=1.5u as=0.2128p ps=1.5u w=1.12u l=0.13u
X512 sg13cmos5l_buf_16_34.X a_3694_7680# VGND.t18 VGND.t46 sg13_lv_nmos ad=0.1406p pd=1.12u as=0.1406p ps=1.12u w=0.74u l=0.13u
X513 VGND.t157 sg13cmos5l_and2_2_6.X a_6836_9156# VGND.t473 sg13_lv_nmos ad=0.1406p pd=1.12u as=0.1406p ps=1.12u w=0.74u l=0.13u
X514 sg13cmos5l_buf_16_24.A a_6094_10704# VPWR.t1186 VPWR.t2 sg13_lv_pmos ad=0.2128p pd=1.5u as=0.2128p ps=1.5u w=1.12u l=0.13u
X515 VGND.t137 a_5204_11422# sg13cmos5l_buf_16_20.A VGND.t2 sg13_lv_nmos ad=0.1406p pd=1.12u as=0.1406p ps=1.12u w=0.74u l=0.13u
X516 VGND.t171 VPWR.t64 VGND.t171 VGND.t1221 sg13_lv_nmos ad=0.1428p pd=1.52u as=0 ps=0 w=0.42u l=1u
X517 VPWR.t533 VGND.t942 VPWR.t532 VPWR.t79 sg13_lv_pmos ad=0.34p pd=2.68u as=0 ps=0 w=1u l=1u
X518 VGND.t260 a_4436_9910# sg13cmos5l_buf_16_14.A VGND.t752 sg13_lv_nmos ad=0.1406p pd=1.12u as=0.1406p ps=1.12u w=0.74u l=0.13u
X519 sg13cmos5l_buf_16_5.A a_5710_1632# VPWR.t57 VPWR.t55 sg13_lv_pmos ad=0.2128p pd=1.5u as=0.2128p ps=1.5u w=1.12u l=0.13u
X520 VPWR.t56 sg13cmos5l_buf_16_5.A a_5108_838# VPWR.t55 sg13_lv_pmos ad=0.3808p pd=2.92u as=0.2128p ps=1.5u w=1.12u l=0.13u
X521 VPWR.t143 sg13cmos5l_buf_16_2.A a_10318_3898# VPWR.t64 sg13_lv_pmos ad=0.2128p pd=1.5u as=0.2128p ps=1.5u w=1.12u l=0.13u
X522 VGND.t942 VPWR.t1681 VGND.t942 VGND.t946 sg13_lv_nmos ad=0.1428p pd=1.52u as=0 ps=0 w=0.42u l=1u
X523 VGND.t726 VPWR.t16 VGND.t726 VGND.t2 sg13_lv_nmos ad=79.8f pd=0.8u as=0 ps=0 w=0.42u l=1u
X524 VGND.t1141 VPWR.t1642 VGND.t1141 VGND.t1143 sg13_lv_nmos ad=0.1428p pd=1.52u as=0 ps=0 w=0.42u l=1u
X525 VGND.t682 VPWR.t1684 VGND.t682 VGND.t955 sg13_lv_nmos ad=79.8f pd=0.8u as=0 ps=0 w=0.42u l=1u
X526 VPWR.t376 VGND.t5 VPWR.t374 VPWR.t5 sg13_lv_pmos ad=0.19p pd=1.38u as=0 ps=0 w=1u l=1u
X527 VGND.t122 a_3694_3898# sg13cmos5l_buf_16_10.A VGND.t40 sg13_lv_nmos ad=0.1406p pd=1.12u as=0.1406p ps=1.12u w=0.74u l=0.13u
X528 sg13cmos5l_buf_16_27.X a_6548_13692# VGND.t891 VGND.t1483 sg13_lv_nmos ad=0.1406p pd=1.12u as=0.1406p ps=1.12u w=0.74u l=0.13u
X529 sg13cmos5l_buf_16_25.A a_6836_9156# VGND.t157 VGND.t168 sg13_lv_nmos ad=0.1406p pd=1.12u as=0.1406p ps=1.12u w=0.74u l=0.13u
X530 VPWR.t185 VGND.t61 VPWR.t183 VPWR.t58 sg13_lv_pmos ad=0.19p pd=1.38u as=0 ps=0 w=1u l=1u
X531 VPWR.t131 VGND.t513 VPWR.t131 VPWR.t8 sg13_lv_pmos ad=0.19p pd=1.38u as=0 ps=0 w=1u l=1u
X532 VPWR.t630 sg13cmos5l_buf_16_24.A a_6862_9946# VPWR.t2 sg13_lv_pmos ad=0.2128p pd=1.5u as=0.2128p ps=1.5u w=1.12u l=0.13u
X533 sg13cmos5l_buf_16_14.A a_4436_9910# VGND.t260 VGND.t749 sg13_lv_nmos ad=0.1406p pd=1.12u as=0.2516p ps=2.16u w=0.74u l=0.13u
X534 VGND.t5 a_10318_8434# sg13cmos5l_buf_16_22.X VGND.t576 sg13_lv_nmos ad=0.1406p pd=1.12u as=0.1406p ps=1.12u w=0.74u l=0.13u
X535 VGND.t41 VPWR.t117 VGND.t41 VGND.t40 sg13_lv_nmos ad=79.8f pd=0.8u as=0 ps=0 w=0.42u l=1u
X536 sg13cmos5l_buf_16_20.A a_5204_11422# VPWR.t483 VPWR.t8 sg13_lv_pmos ad=0.2128p pd=1.5u as=0.2128p ps=1.5u w=1.12u l=0.13u
X537 VPWR.t56 a_5710_1632# sg13cmos5l_buf_16_5.A VPWR.t55 sg13_lv_pmos ad=0.2128p pd=1.5u as=0.2128p ps=1.5u w=1.12u l=0.13u
X538 VGND.t532 VPWR.t881 VGND.t532 VGND.t1194 sg13_lv_nmos ad=79.8f pd=0.8u as=0 ps=0 w=0.42u l=1u
X539 VPWR.t732 a_6094_4656# sg13cmos5l_buf_16_31.X VPWR.t64 sg13_lv_pmos ad=0.2128p pd=1.5u as=0.2128p ps=1.5u w=1.12u l=0.13u
X540 VPWR.t80 VGND.t206 VPWR.t80 VPWR.t79 sg13_lv_pmos ad=0.34p pd=2.68u as=0 ps=0 w=1u l=1u
X541 VPWR.t0 VGND.t917 VPWR.t0 VPWR.t0 sg13_lv_pmos ad=0.19p pd=1.38u as=0 ps=0 w=1u l=1u
X542 sg13cmos5l_buf_16_3.X a_10292_4620# VGND.t76 VGND.t78 sg13_lv_nmos ad=0.1406p pd=1.12u as=0.1406p ps=1.12u w=0.74u l=0.13u
X543 VPWR.t1370 a_4174_13728# sg13cmos5l_buf_16_18.A VPWR.t79 sg13_lv_pmos ad=0.2128p pd=1.5u as=0.2128p ps=1.5u w=1.12u l=0.13u
X544 a_7220_5374# sg13cmos5l_buf_16_38.A VPWR.t61 VPWR.t61 sg13_lv_pmos ad=0.2128p pd=1.5u as=0.2128p ps=1.5u w=1.12u l=0.13u
X545 a_14252_9906# sg13cmos5l_and2_2_3.X VGND.t37 VGND.t622 sg13_lv_nmos ad=0.187p pd=1.78u as=0.14875p ps=1.16u w=0.55u l=0.13u
X546 VPWR.t511 a_6836_9156# sg13cmos5l_buf_16_25.A VPWR.t5 sg13_lv_pmos ad=0.2128p pd=1.5u as=0.2128p ps=1.5u w=1.12u l=0.13u
X547 VPWR.t126 VGND.t1387 VPWR.t250 VPWR.t55 sg13_lv_pmos ad=0.34p pd=2.68u as=0 ps=0 w=1u l=1u
X548 VGND.t7 a_8110_6168# sg13cmos5l_buf_16_38.A VGND.t781 sg13_lv_nmos ad=0.1406p pd=1.12u as=0.1406p ps=1.12u w=0.74u l=0.13u
X549 VPWR.t143 sg13cmos5l_buf_16_2.A a_10318_3898# VPWR.t64 sg13_lv_pmos ad=0.2128p pd=1.5u as=0.2128p ps=1.5u w=1.12u l=0.13u
X550 VGND.t1061 VPWR.t146 VGND.t1061 VGND.t1064 sg13_lv_nmos ad=79.8f pd=0.8u as=0 ps=0 w=0.42u l=1u
X551 a_8494_3144# sg13cmos5l_buf_16_0.A VPWR.t330 VPWR.t67 sg13_lv_pmos ad=0.2128p pd=1.5u as=0.2128p ps=1.5u w=1.12u l=0.13u
X552 VGND.t5 VPWR.t1653 VGND.t5 VGND.t1105 sg13_lv_nmos ad=79.8f pd=0.8u as=0 ps=0 w=0.42u l=1u
X553 VPWR.t1593 a_3694_2386# sg13cmos5l_buf_16_7.X VPWR.t67 sg13_lv_pmos ad=0.3976p pd=2.95u as=0.2128p ps=1.5u w=1.12u l=0.13u
X554 VGND.t125 sg13cmos5l_buf_16_10.A a_3668_3108# VGND.t40 sg13_lv_nmos ad=0.1406p pd=1.12u as=0.1406p ps=1.12u w=0.74u l=0.13u
X555 VGND.t837 a_6164_2350# sg13cmos5l_buf_16_30.A VGND.t1547 sg13_lv_nmos ad=0.1406p pd=1.12u as=0.1406p ps=1.12u w=0.74u l=0.13u
X556 sg13cmos5l_buf_16_38.A a_8110_6168# VGND.t7 VGND.t778 sg13_lv_nmos ad=0.1406p pd=1.12u as=0.1406p ps=1.12u w=0.74u l=0.13u
X557 VGND.t218 a_5684_6132# sg13cmos5l_buf_16_28.X VGND.t219 sg13_lv_nmos ad=0.1406p pd=1.12u as=0.1406p ps=1.12u w=0.74u l=0.13u
X558 sg13cmos5l_buf_16_18.A a_4174_13728# VGND.t891 VGND.t1445 sg13_lv_nmos ad=0.1406p pd=1.12u as=0.1406p ps=1.12u w=0.74u l=0.13u
X559 sg13cmos5l_buf_16_22.X a_10318_8434# VPWR.t440 VPWR.t5 sg13_lv_pmos ad=0.2128p pd=1.5u as=0.2128p ps=1.5u w=1.12u l=0.13u
X560 a_13916_11752# sg13cmos5l_and2_2_3.X VPWR.t131 VPWR.t8 sg13_lv_pmos ad=0.2128p pd=1.5u as=0.2128p ps=1.5u w=1.12u l=0.13u
X561 VGND.t1010 VPWR.t129 VGND.t1010 VGND.t2 sg13_lv_nmos ad=79.8f pd=0.8u as=0 ps=0 w=0.42u l=1u
X562 sg13cmos5l_buf_16_7.X a_3694_2386# VPWR.t1589 VPWR.t67 sg13_lv_pmos ad=0.2128p pd=1.5u as=0.2128p ps=1.5u w=1.12u l=0.13u
X563 VPWR.t1279 a_3668_4620# sg13cmos5l_buf_16_8.A VPWR.t64 sg13_lv_pmos ad=0.2128p pd=1.5u as=0.2128p ps=1.5u w=1.12u l=0.13u
X564 sg13cmos5l_buf_16_34.X a_3694_7680# VPWR.t894 VPWR.t58 sg13_lv_pmos ad=0.2128p pd=1.5u as=0.2128p ps=1.5u w=1.12u l=0.13u
X565 VPWR.t440 a_10318_8434# sg13cmos5l_buf_16_22.X VPWR.t5 sg13_lv_pmos ad=0.2128p pd=1.5u as=0.2128p ps=1.5u w=1.12u l=0.13u
X566 sg13cmos5l_buf_16_2.X a_10318_3898# VGND.t41 VGND.t40 sg13_lv_nmos ad=0.1406p pd=1.12u as=0.1406p ps=1.12u w=0.74u l=0.13u
X567 VPWR.t132 VGND.t37 VPWR.t132 VPWR.t5 sg13_lv_pmos ad=0.34p pd=2.68u as=0 ps=0 w=1u l=1u
X568 VPWR.t411 VGND.t42 VPWR.t410 VPWR.t64 sg13_lv_pmos ad=0.34p pd=2.68u as=0 ps=0 w=1u l=1u
X569 VGND.t1224 VPWR.t64 VGND.t171 VGND.t1223 sg13_lv_nmos ad=0.1428p pd=1.52u as=0 ps=0 w=0.42u l=1u
X570 VGND.t590 a_7796_12934# sg13cmos5l_buf_16_37.X VGND.t689 sg13_lv_nmos ad=0.1406p pd=1.12u as=0.1406p ps=1.12u w=0.74u l=0.13u
X571 VPWR.t56 a_5710_1632# sg13cmos5l_buf_16_5.A VPWR.t55 sg13_lv_pmos ad=0.2128p pd=1.5u as=0.2128p ps=1.5u w=1.12u l=0.13u
X572 VGND.t122 a_3668_3108# sg13cmos5l_buf_16_7.A VGND.t40 sg13_lv_nmos ad=0.1406p pd=1.12u as=0.1406p ps=1.12u w=0.74u l=0.13u
X573 VPWR.t728 a_6094_4656# sg13cmos5l_buf_16_31.X VPWR.t64 sg13_lv_pmos ad=0.2128p pd=1.5u as=0.2128p ps=1.5u w=1.12u l=0.13u
X574 sg13cmos5l_buf_16_8.A a_3668_4620# VPWR.t1276 VPWR.t64 sg13_lv_pmos ad=0.2128p pd=1.5u as=0.3976p ps=2.95u w=1.12u l=0.13u
X575 sg13cmos5l_buf_16_18.A a_4174_13728# VGND.t870 VGND.t1441 sg13_lv_nmos ad=0.1406p pd=1.12u as=0.1406p ps=1.12u w=0.74u l=0.13u
X576 VPWR.t892 a_3694_7680# sg13cmos5l_buf_16_34.X VPWR.t58 sg13_lv_pmos ad=0.2128p pd=1.5u as=0.2128p ps=1.5u w=1.12u l=0.13u
X577 VGND.t41 a_10318_3898# sg13cmos5l_buf_16_2.X VGND.t40 sg13_lv_nmos ad=0.1406p pd=1.12u as=0.1406p ps=1.12u w=0.74u l=0.13u
X578 a_6766_8434# sg13cmos5l_buf_16_25.A VGND.t61 VGND.t278 sg13_lv_nmos ad=0.1406p pd=1.12u as=0.1406p ps=1.12u w=0.74u l=0.13u
X579 VGND.t5 VPWR.t1644 VGND.t5 VGND.t1132 sg13_lv_nmos ad=79.8f pd=0.8u as=0 ps=0 w=0.42u l=1u
X580 sg13cmos5l_xor2_1_6.X a_11898_13691# VGND.t204 VGND.t663 sg13_lv_nmos ad=0.1628p pd=1.18u as=0.3108p ps=2.32u w=0.74u l=0.13u
X581 sg13cmos5l_buf_1_23.A sg13cmos5l_and2_2_6.A a_6426_9550# VGND.t419 sg13_lv_nmos ad=0.1628p pd=1.18u as=88.8f ps=0.98u w=0.74u l=0.13u
X582 sg13cmos5l_buf_16_38.A a_8110_6168# VPWR.t153 VPWR.t61 sg13_lv_pmos ad=0.2128p pd=1.5u as=0.2128p ps=1.5u w=1.12u l=0.13u
X583 sg13cmos5l_buf_16_7.X a_3694_2386# VPWR.t1585 VPWR.t67 sg13_lv_pmos ad=0.2128p pd=1.5u as=0.2128p ps=1.5u w=1.12u l=0.13u
X584 VGND.t1418 VPWR.t226 VGND.t1417 VGND.t1416 sg13_lv_nmos ad=0.1428p pd=1.52u as=0 ps=0 w=0.42u l=1u
X585 VGND.t41 VPWR.t120 VGND.t41 VGND.t40 sg13_lv_nmos ad=79.8f pd=0.8u as=0 ps=0 w=0.42u l=1u
X586 a_3694_10704# sg13cmos5l_buf_16_34.X VPWR.t553 VPWR.t2 sg13_lv_pmos ad=0.2128p pd=1.5u as=0.2128p ps=1.5u w=1.12u l=0.13u
X587 sg13cmos5l_and2_2_6.A a_3694_10704# VPWR.t1204 VPWR.t2 sg13_lv_pmos ad=0.2128p pd=1.5u as=0.2128p ps=1.5u w=1.12u l=0.13u
X588 VPWR.t507 a_6836_9156# sg13cmos5l_buf_16_25.A VPWR.t5 sg13_lv_pmos ad=0.2128p pd=1.5u as=0.2128p ps=1.5u w=1.12u l=0.13u
X589 sg13cmos5l_buf_16_37.X a_7796_12934# VPWR.t1113 VPWR.t79 sg13_lv_pmos ad=0.2128p pd=1.5u as=0.2128p ps=1.5u w=1.12u l=0.13u
X590 VGND.t349 sg13cmos5l_buf_1_5.A a_13768_5444# VGND.t710 sg13_lv_nmos ad=0.14875p pd=1.16u as=0.187p ps=1.78u w=0.55u l=0.13u
X591 VPWR.t335 a_9262_7680# sg13cmos5l_buf_16_2.A VPWR.t58 sg13_lv_pmos ad=0.2128p pd=1.5u as=0.2128p ps=1.5u w=1.12u l=0.13u
X592 VPWR.t566 a_8948_13692# sg13cmos5l_buf_16_37.A VPWR.t79 sg13_lv_pmos ad=0.2128p pd=1.5u as=0.2128p ps=1.5u w=1.12u l=0.13u
X593 VGND.t1010 VPWR.t28 VGND.t1010 VGND.t2 sg13_lv_nmos ad=0.1428p pd=1.52u as=0 ps=0 w=0.42u l=1u
X594 VPWR.t430 VGND.t1010 VPWR.t430 VPWR.t2 sg13_lv_pmos ad=0.19p pd=1.38u as=0 ps=0 w=1u l=1u
X595 VGND.t590 a_7796_12934# sg13cmos5l_buf_16_37.X VGND.t685 sg13_lv_nmos ad=0.1406p pd=1.12u as=0.1406p ps=1.12u w=0.74u l=0.13u
X596 VGND.t989 VPWR.t1675 VGND.t994 VGND.t2 sg13_lv_nmos ad=79.8f pd=0.8u as=0 ps=0 w=0.42u l=1u
X597 a_4105_5452# sg13cmos5l_and2_2_0.B VGND.t797 VGND.t1426 sg13_lv_nmos ad=0.1216p pd=1.02u as=0.1331p ps=1.12u w=0.64u l=0.13u
X598 VGND.t5 a_9617_8484# sg13cmos5l_xor2_1_5.X VGND.t1558 sg13_lv_nmos ad=0.3108p pd=2.32u as=0.1628p ps=1.18u w=0.74u l=0.13u
X599 sg13cmos5l_buf_16_1.X a_10318_5410# VGND.t76 VGND.t82 sg13_lv_nmos ad=0.1406p pd=1.12u as=0.1406p ps=1.12u w=0.74u l=0.13u
X600 VPWR.t566 a_10292_12934# sg13cmos5l_buf_16_23.X VPWR.t79 sg13_lv_pmos ad=0.2128p pd=1.5u as=0.2128p ps=1.5u w=1.12u l=0.13u
X601 VGND.t1061 VPWR.t146 VGND.t1061 VGND.t1060 sg13_lv_nmos ad=0.1428p pd=1.52u as=0 ps=0 w=0.42u l=1u
X602 VPWR.t128 VGND.t676 VPWR.t21 VPWR.t8 sg13_lv_pmos ad=0.34p pd=2.68u as=0 ps=0 w=1u l=1u
X603 sg13cmos5l_buf_16_25.A a_6836_9156# VPWR.t503 VPWR.t5 sg13_lv_pmos ad=0.2128p pd=1.5u as=0.2128p ps=1.5u w=1.12u l=0.13u
X604 VGND.t837 a_6164_2350# sg13cmos5l_buf_16_30.A VGND.t1543 sg13_lv_nmos ad=0.1406p pd=1.12u as=0.1406p ps=1.12u w=0.74u l=0.13u
X605 VPWR.t1031 VGND.t989 VPWR.t1030 VPWR.t2 sg13_lv_pmos ad=0.34p pd=2.68u as=0 ps=0 w=1u l=1u
X606 VGND.t597 VPWR.t1695 VGND.t597 VGND.t905 sg13_lv_nmos ad=0.1428p pd=1.52u as=0 ps=0 w=0.42u l=1u
X607 VGND.t31 VPWR.t216 VGND.t31 VGND.t1284 sg13_lv_nmos ad=79.8f pd=0.8u as=0 ps=0 w=0.42u l=1u
X608 a_9262_7680# sg13cmos5l_buf_16_4.X VPWR.t335 VPWR.t58 sg13_lv_pmos ad=0.2128p pd=1.5u as=0.2128p ps=1.5u w=1.12u l=0.13u
X609 VGND.t1141 VPWR.t1633 VGND.t1141 VGND.t1143 sg13_lv_nmos ad=0.1428p pd=1.52u as=0 ps=0 w=0.42u l=1u
X610 VGND.t134 VPWR.t1672 VGND.t134 VGND.t2 sg13_lv_nmos ad=79.8f pd=0.8u as=0 ps=0 w=0.42u l=1u
X611 VGND.t260 a_3668_9156# sg13cmos5l_buf_16_13.A VGND.t267 sg13_lv_nmos ad=0.1406p pd=1.12u as=0.1406p ps=1.12u w=0.74u l=0.13u
X612 VGND.t1107 VPWR.t1652 VGND.t18 VGND.t1108 sg13_lv_nmos ad=79.8f pd=0.8u as=0 ps=0 w=0.42u l=1u
X613 VPWR.t56 VGND.t198 VPWR.t56 VPWR.t55 sg13_lv_pmos ad=0.19p pd=1.38u as=0 ps=0 w=1u l=1u
X614 VPWR.t155 a_7629_8028# sg13cmos5l_and2_2_6.X VPWR.t58 sg13_lv_pmos ad=0.4256p pd=3u as=0.2128p ps=1.5u w=1.12u l=0.13u
X615 VGND.t237 a_10292_12934# sg13cmos5l_buf_16_23.X VGND.t680 sg13_lv_nmos ad=0.1406p pd=1.12u as=0.1406p ps=1.12u w=0.74u l=0.13u
X616 VGND.t590 VPWR.t1678 VGND.t590 VGND.t970 sg13_lv_nmos ad=0.1428p pd=1.52u as=0 ps=0 w=0.42u l=1u
X617 sg13cmos5l_buf_16_30.A a_6164_2350# VGND.t837 VGND.t1540 sg13_lv_nmos ad=0.1406p pd=1.12u as=0.2516p ps=2.16u w=0.74u l=0.13u
X618 VGND.t351 a_3668_4620# sg13cmos5l_buf_16_8.A VGND.t828 sg13_lv_nmos ad=0.1406p pd=1.12u as=0.1406p ps=1.12u w=0.74u l=0.13u
X619 sg13cmos5l_buf_16_34.X a_3694_7680# VGND.t61 VGND.t62 sg13_lv_nmos ad=0.1406p pd=1.12u as=0.1406p ps=1.12u w=0.74u l=0.13u
X620 VPWR.t1212 a_3694_10704# sg13cmos5l_and2_2_6.A VPWR.t2 sg13_lv_pmos ad=0.3976p pd=2.95u as=0.2128p ps=1.5u w=1.12u l=0.13u
X621 VGND.t35 a_13745_8484# sg13cmos5l_xor2_1_4.X VGND.t478 sg13_lv_nmos ad=0.3108p pd=2.32u as=0.1628p ps=1.18u w=0.74u l=0.13u
X622 VGND.t50 a_3694_8434# sg13cmos5l_buf_16_34.A VGND.t58 sg13_lv_nmos ad=0.1406p pd=1.12u as=0.1406p ps=1.12u w=0.74u l=0.13u
X623 VPWR.t335 sg13cmos5l_buf_16_4.X a_9262_7680# VPWR.t58 sg13_lv_pmos ad=0.2128p pd=1.5u as=0.2128p ps=1.5u w=1.12u l=0.13u
X624 sg13cmos5l_buf_16_13.A a_3668_9156# VGND.t260 VGND.t264 sg13_lv_nmos ad=0.1406p pd=1.12u as=0.1406p ps=1.12u w=0.74u l=0.13u
X625 VPWR.t754 a_6094_3898# sg13cmos5l_buf_16_0.A VPWR.t64 sg13_lv_pmos ad=0.3976p pd=2.95u as=0.2128p ps=1.5u w=1.12u l=0.13u
X626 sg13cmos5l_buf_16_10.A a_3694_3898# VPWR.t1531 VPWR.t64 sg13_lv_pmos ad=0.2128p pd=1.5u as=0.2128p ps=1.5u w=1.12u l=0.13u
X627 a_6161_12574# sg13cmos5l_buf_16_15.A VGND.t620 VGND.t704 sg13_lv_nmos ad=0.17462p pd=1.185u as=0.374p ps=2.46u w=0.55u l=0.13u
X628 VPWR.t927 VGND.t994 VPWR.t925 VPWR.t8 sg13_lv_pmos ad=0.19p pd=1.38u as=0 ps=0 w=1u l=1u
X629 sg13cmos5l_buf_16_0.A a_6094_3898# VGND.t125 VGND.t40 sg13_lv_nmos ad=0.1406p pd=1.12u as=0.1406p ps=1.12u w=0.74u l=0.13u
X630 a_10318_5410# sg13cmos5l_buf_16_3.X VGND.t76 VGND.t78 sg13_lv_nmos ad=0.1406p pd=1.12u as=0.1406p ps=1.12u w=0.74u l=0.13u
X631 VPWR.t143 a_10292_4620# sg13cmos5l_buf_16_3.X VPWR.t64 sg13_lv_pmos ad=0.2128p pd=1.5u as=0.2128p ps=1.5u w=1.12u l=0.13u
X632 VGND.t171 a_6094_4656# sg13cmos5l_buf_16_31.X VGND.t364 sg13_lv_nmos ad=0.1406p pd=1.12u as=0.1406p ps=1.12u w=0.74u l=0.13u
X633 out_xor[2] a_14824_5444# VPWR.t882 VPWR.t61 sg13_lv_pmos ad=0.42p pd=2.99u as=0.2114p ps=1.54u w=1.12u l=0.13u
X634 sg13cmos5l_buf_16_8.A a_3668_4620# VGND.t797 VGND.t825 sg13_lv_nmos ad=0.1406p pd=1.12u as=0.1406p ps=1.12u w=0.74u l=0.13u
X635 a_10292_12934# sg13cmos5l_buf_1_17.A VPWR.t566 VPWR.t79 sg13_lv_pmos ad=0.2128p pd=1.5u as=0.2128p ps=1.5u w=1.12u l=0.13u
X636 VGND.t444 VPWR.t1686 VGND.t444 VGND.t951 sg13_lv_nmos ad=0.1428p pd=1.52u as=0 ps=0 w=0.42u l=1u
X637 VPWR.t545 VGND.t942 VPWR.t543 VPWR.t8 sg13_lv_pmos ad=0.19p pd=1.38u as=0 ps=0 w=1u l=1u
X638 VPWR.t131 VGND.t513 VPWR.t131 VPWR.t8 sg13_lv_pmos ad=0.19p pd=1.38u as=0 ps=0 w=1u l=1u
X639 VPWR.t856 a_3668_3108# sg13cmos5l_buf_16_7.A VPWR.t67 sg13_lv_pmos ad=0.2128p pd=1.5u as=0.2128p ps=1.5u w=1.12u l=0.13u
X640 VGND.t1165 VPWR.t62 VGND.t1165 VGND.t1190 sg13_lv_nmos ad=79.8f pd=0.8u as=0 ps=0 w=0.42u l=1u
X641 VPWR.t395 VGND.t5 VPWR.t393 VPWR.t58 sg13_lv_pmos ad=0.19p pd=1.38u as=0 ps=0 w=1u l=1u
X642 VGND.t676 a_10292_12934# sg13cmos5l_buf_16_23.X VGND.t675 sg13_lv_nmos ad=0.1406p pd=1.12u as=0.1406p ps=1.12u w=0.74u l=0.13u
X643 a_3694_14482# sg13cmos5l_buf_16_15.X VPWR.t1325 VPWR.t0 sg13_lv_pmos ad=0.2128p pd=1.5u as=0.3808p ps=2.92u w=1.12u l=0.13u
X644 VGND.t125 enable a_6094_3898# VGND.t40 sg13_lv_nmos ad=0.1406p pd=1.12u as=0.1406p ps=1.12u w=0.74u l=0.13u
X645 VPWR.t1529 a_3694_3898# sg13cmos5l_buf_16_10.A VPWR.t64 sg13_lv_pmos ad=0.2128p pd=1.5u as=0.2128p ps=1.5u w=1.12u l=0.13u
X646 VGND.t1061 VPWR.t6 VGND.t1061 VGND.t1071 sg13_lv_nmos ad=0.1428p pd=1.52u as=0 ps=0 w=0.42u l=1u
X647 VPWR.t276 a_3694_8434# sg13cmos5l_buf_16_34.A VPWR.t5 sg13_lv_pmos ad=0.3976p pd=2.95u as=0.2128p ps=1.5u w=1.12u l=0.13u
X648 VGND.t3 VPWR.t135 VGND.t3 VGND.t2 sg13_lv_nmos ad=0.1428p pd=1.52u as=0 ps=0 w=0.42u l=1u
X649 VPWR.t1208 a_3694_10704# sg13cmos5l_and2_2_6.A VPWR.t2 sg13_lv_pmos ad=0.2128p pd=1.5u as=0.2128p ps=1.5u w=1.12u l=0.13u
X650 VPWR.t0 VGND.t206 VPWR.t0 VPWR.t0 sg13_lv_pmos ad=0.19p pd=1.38u as=0 ps=0 w=1u l=1u
X651 sg13cmos5l_buf_16_15.A a_4052_12934# VPWR.t1083 VPWR.t79 sg13_lv_pmos ad=0.2128p pd=1.5u as=0.2128p ps=1.5u w=1.12u l=0.13u
X652 VGND.t31 VPWR.t250 VGND.t31 VGND.t1322 sg13_lv_nmos ad=79.8f pd=0.8u as=0 ps=0 w=0.42u l=1u
X653 sg13cmos5l_buf_16_7.A a_3668_3108# VPWR.t852 VPWR.t67 sg13_lv_pmos ad=0.2128p pd=1.5u as=0.2128p ps=1.5u w=1.12u l=0.13u
X654 VGND.t1368 VPWR.t57 VGND.t1370 VGND.t1369 sg13_lv_nmos ad=79.8f pd=0.8u as=0 ps=0 w=0.42u l=1u
X655 VGND.t93 VPWR.t64 VGND.t96 VGND.t40 sg13_lv_nmos ad=79.8f pd=0.8u as=0 ps=0 w=0.42u l=1u
X656 a_6094_3898# enable VGND.t125 VGND.t40 sg13_lv_nmos ad=0.1406p pd=1.12u as=0.2516p ps=2.16u w=0.74u l=0.13u
X657 VGND.t845 a_5108_838# sg13cmos5l_buf_16_5.X VGND.t1465 sg13_lv_nmos ad=0.1406p pd=1.12u as=0.1406p ps=1.12u w=0.74u l=0.13u
X658 sg13cmos5l_buf_16_23.X a_10292_12934# VPWR.t566 VPWR.t79 sg13_lv_pmos ad=0.2128p pd=1.5u as=0.2128p ps=1.5u w=1.12u l=0.13u
X659 sg13cmos5l_buf_16_34.A a_3694_8434# VPWR.t272 VPWR.t5 sg13_lv_pmos ad=0.2128p pd=1.5u as=0.2128p ps=1.5u w=1.12u l=0.13u
X660 VGND.t5 VPWR.t1655 VGND.t5 VGND.t1101 sg13_lv_nmos ad=79.8f pd=0.8u as=0 ps=0 w=0.42u l=1u
X661 VPWR.t86 VGND.t194 VPWR.t99 VPWR.t55 sg13_lv_pmos ad=0.19p pd=1.38u as=0 ps=0 w=1u l=1u
X662 VPWR.t881 VGND.t532 VPWR.t882 VPWR.t61 sg13_lv_pmos ad=0.19p pd=1.38u as=0 ps=0 w=1u l=1u
X663 VPWR.t537 VGND.t942 VPWR.t536 VPWR.t79 sg13_lv_pmos ad=0.34p pd=2.68u as=0 ps=0 w=1u l=1u
X664 VPWR.t824 a_3668_12180# sg13cmos5l_buf_16_15.X VPWR.t8 sg13_lv_pmos ad=0.2128p pd=1.5u as=0.2128p ps=1.5u w=1.12u l=0.13u
X665 VGND.t61 VPWR.t1651 VGND.t61 VGND.t1109 sg13_lv_nmos ad=0.1428p pd=1.52u as=0 ps=0 w=0.42u l=1u
X666 VPWR.t143 a_10292_4620# sg13cmos5l_buf_16_3.X VPWR.t64 sg13_lv_pmos ad=0.2128p pd=1.5u as=0.2128p ps=1.5u w=1.12u l=0.13u
X667 VPWR.t3 VGND.t1073 VPWR.t3 VPWR.t2 sg13_lv_pmos ad=0.19p pd=1.38u as=0 ps=0 w=1u l=1u
X668 sg13cmos5l_buf_16_6.X a_5518_6922# VGND.t228 VGND.t539 sg13_lv_nmos ad=0.1406p pd=1.12u as=0.1406p ps=1.12u w=0.74u l=0.13u
X669 sg13cmos5l_buf_16_27.X a_6548_13692# VPWR.t1408 VPWR.t79 sg13_lv_pmos ad=0.2128p pd=1.5u as=0.2128p ps=1.5u w=1.12u l=0.13u
X670 a_3020_14442# glitch_en[1] VGND.t841 VGND.t840 sg13_lv_nmos ad=0.187p pd=1.78u as=0.14875p ps=1.16u w=0.55u l=0.13u
X671 VGND.t590 a_10292_12934# sg13cmos5l_buf_16_23.X VGND.t671 sg13_lv_nmos ad=0.1406p pd=1.12u as=0.1406p ps=1.12u w=0.74u l=0.13u
X672 sg13cmos5l_buf_16_5.X a_5108_838# VGND.t845 VGND.t1460 sg13_lv_nmos ad=0.1406p pd=1.12u as=0.1406p ps=1.12u w=0.74u l=0.13u
X673 VPWR.t61 sg13cmos5l_buf_16_3.X a_10318_5410# VPWR.t61 sg13_lv_pmos ad=0.2128p pd=1.5u as=0.2128p ps=1.5u w=1.12u l=0.13u
X674 sg13cmos5l_buf_16_24.X a_6862_9946# VPWR.t840 VPWR.t2 sg13_lv_pmos ad=0.2128p pd=1.5u as=0.2128p ps=1.5u w=1.12u l=0.13u
X675 VPWR.t850 a_3668_3108# sg13cmos5l_buf_16_7.A VPWR.t67 sg13_lv_pmos ad=0.2128p pd=1.5u as=0.2128p ps=1.5u w=1.12u l=0.13u
X676 VPWR.t623 sg13cmos5l_buf_16_19.A a_5204_11422# VPWR.t8 sg13_lv_pmos ad=0.2128p pd=1.5u as=0.2128p ps=1.5u w=1.12u l=0.13u
X677 sg13cmos5l_buf_16_4.A a_11565_8028# VGND.t5 VGND.t207 sg13_lv_nmos ad=0.1406p pd=1.12u as=0.1331p ps=1.12u w=0.74u l=0.13u
X678 a_4689_6168# sg13cmos5l_buf_16_8.A VPWR.t683 VPWR.t61 sg13_lv_pmos ad=0.1225p pd=1.245u as=0.36p ps=2.72u w=1u l=0.13u
X679 VPWR.t1101 sg13cmos5l_buf_16_28.X a_5518_6922# VPWR.t58 sg13_lv_pmos ad=0.2128p pd=1.5u as=0.2128p ps=1.5u w=1.12u l=0.13u
X680 sg13cmos5l_buf_16_34.X a_3694_7680# VGND.t50 VGND.t57 sg13_lv_nmos ad=0.1406p pd=1.12u as=0.1406p ps=1.12u w=0.74u l=0.13u
X681 VPWR.t1345 a_3694_14482# sg13cmos5l_buf_16_33.A VPWR.t0 sg13_lv_pmos ad=0.2128p pd=1.5u as=0.2128p ps=1.5u w=1.12u l=0.13u
X682 VPWR.t120 VGND.t41 VPWR.t120 VPWR.t67 sg13_lv_pmos ad=0.19p pd=1.38u as=0 ps=0 w=1u l=1u
X683 VPWR.t216 a_8494_3144# sg13cmos5l_buf_16_39.A VPWR.t67 sg13_lv_pmos ad=0.2128p pd=1.5u as=0.2128p ps=1.5u w=1.12u l=0.13u
X684 VGND.t351 sg13cmos5l_and2_2_0.X a_4462_5410# VGND.t803 sg13_lv_nmos ad=0.1406p pd=1.12u as=0.1406p ps=1.12u w=0.74u l=0.13u
X685 VPWR.t216 VGND.t31 VPWR.t216 VPWR.t67 sg13_lv_pmos ad=0.19p pd=1.38u as=0 ps=0 w=1u l=1u
X686 VGND.t797 a_3875_5396# sg13cmos5l_and2_2_0.X VGND.t808 sg13_lv_nmos ad=0.1331p pd=1.12u as=0.1406p ps=1.12u w=0.74u l=0.13u
X687 VPWR.t820 a_3668_12180# sg13cmos5l_buf_16_15.X VPWR.t8 sg13_lv_pmos ad=0.2128p pd=1.5u as=0.2128p ps=1.5u w=1.12u l=0.13u
X688 VPWR.t881 VGND.t637 VPWR.t62 VPWR.t61 sg13_lv_pmos ad=0.19p pd=1.38u as=0 ps=0 w=1u l=1u
X689 VGND.t86 a_10292_4620# sg13cmos5l_buf_16_3.X VGND.t92 sg13_lv_nmos ad=0.1406p pd=1.12u as=0.1406p ps=1.12u w=0.74u l=0.13u
X690 sg13cmos5l_buf_16_8.A a_3668_4620# VGND.t797 VGND.t821 sg13_lv_nmos ad=0.1406p pd=1.12u as=0.1406p ps=1.12u w=0.74u l=0.13u
X691 sg13cmos5l_buf_16_34.A a_3694_8434# VPWR.t268 VPWR.t5 sg13_lv_pmos ad=0.2128p pd=1.5u as=0.2128p ps=1.5u w=1.12u l=0.13u
X692 VGND.t1061 VPWR.t440 VGND.t1061 VGND.t1065 sg13_lv_nmos ad=0.1428p pd=1.52u as=0 ps=0 w=0.42u l=1u
X693 VPWR.t485 a_5204_11422# sg13cmos5l_buf_16_20.A VPWR.t8 sg13_lv_pmos ad=0.2128p pd=1.5u as=0.2128p ps=1.5u w=1.12u l=0.13u
X694 sg13cmos5l_buf_16_24.X a_6862_9946# VPWR.t836 VPWR.t2 sg13_lv_pmos ad=0.2128p pd=1.5u as=0.2128p ps=1.5u w=1.12u l=0.13u
X695 VGND.t1107 VPWR.t1652 VGND.t5 VGND.t1106 sg13_lv_nmos ad=0.1428p pd=1.52u as=0 ps=0 w=0.42u l=1u
X696 sg13cmos5l_buf_16_14.A a_4436_9910# VGND.t66 VGND.t761 sg13_lv_nmos ad=0.1406p pd=1.12u as=0.1406p ps=1.12u w=0.74u l=0.13u
X697 sg13cmos5l_xor2_1_0.B a_6094_3144# VGND.t125 VGND.t40 sg13_lv_nmos ad=0.1406p pd=1.12u as=0.1406p ps=1.12u w=0.74u l=0.13u
X698 VPWR.t235 VGND.t891 VPWR.t234 VPWR.t0 sg13_lv_pmos ad=0.34p pd=2.68u as=0 ps=0 w=1u l=1u
X699 sg13cmos5l_buf_16_2.X a_10318_3898# VPWR.t143 VPWR.t64 sg13_lv_pmos ad=0.2128p pd=1.5u as=0.2128p ps=1.5u w=1.12u l=0.13u
X700 VGND.t682 VPWR.t1679 VGND.t590 VGND.t969 sg13_lv_nmos ad=79.8f pd=0.8u as=0 ps=0 w=0.42u l=1u
X701 sg13cmos5l_buf_16_3.X a_10292_4620# VGND.t86 VGND.t89 sg13_lv_nmos ad=0.1406p pd=1.12u as=0.1406p ps=1.12u w=0.74u l=0.13u
X702 VPWR.t1501 VGND.t1196 VPWR.t1499 VPWR.t61 sg13_lv_pmos ad=0.19p pd=1.38u as=0 ps=0 w=1u l=1u
X703 sg13cmos5l_buf_16_18.A a_4174_13728# VPWR.t1370 VPWR.t79 sg13_lv_pmos ad=0.2128p pd=1.5u as=0.2128p ps=1.5u w=1.12u l=0.13u
X704 sg13cmos5l_buf_16_24.A a_6094_10704# VGND.t139 VGND.t2 sg13_lv_nmos ad=0.1406p pd=1.12u as=0.1406p ps=1.12u w=0.74u l=0.13u
X705 VGND.t198 sg13cmos5l_buf_16_7.A a_3694_2386# VGND.t197 sg13_lv_nmos ad=0.1406p pd=1.12u as=0.1406p ps=1.12u w=0.74u l=0.13u
X706 VPWR.t64 VGND.t96 VPWR.t64 VPWR.t64 sg13_lv_pmos ad=0.19p pd=1.38u as=0 ps=0 w=1u l=1u
X707 VGND.t202 VPWR.t0 VGND.t917 VGND.t916 sg13_lv_nmos ad=79.8f pd=0.8u as=0 ps=0 w=0.42u l=1u
X708 VGND.t942 VPWR.t1690 VGND.t942 VGND.t941 sg13_lv_nmos ad=0.1428p pd=1.52u as=0 ps=0 w=0.42u l=1u
X709 VPWR.t62 VGND.t1162 VPWR.t96 VPWR.t61 sg13_lv_pmos ad=0.19p pd=1.38u as=0 ps=0 w=1u l=1u
X710 VGND.t66 a_4436_9910# sg13cmos5l_buf_16_14.A VGND.t758 sg13_lv_nmos ad=0.1406p pd=1.12u as=0.1406p ps=1.12u w=0.74u l=0.13u
X711 VGND.t125 sg13cmos5l_buf_16_5.X a_6094_3144# VGND.t40 sg13_lv_nmos ad=0.1406p pd=1.12u as=0.1406p ps=1.12u w=0.74u l=0.13u
X712 VPWR.t110 sg13cmos5l_buf_1_6.A a_13768_3932# VPWR.t64 sg13_lv_pmos ad=0.2114p pd=1.54u as=0.2856p ps=2.36u w=0.84u l=0.13u
X713 VGND.t1167 VPWR.t62 VGND.t532 VGND.t1192 sg13_lv_nmos ad=79.8f pd=0.8u as=0 ps=0 w=0.42u l=1u
X714 VPWR.t143 a_10318_3898# sg13cmos5l_buf_16_2.X VPWR.t64 sg13_lv_pmos ad=0.2128p pd=1.5u as=0.2128p ps=1.5u w=1.12u l=0.13u
X715 VPWR.t250 VGND.t31 VPWR.t986 VPWR.t55 sg13_lv_pmos ad=0.19p pd=1.38u as=0 ps=0 w=1u l=1u
X716 VPWR.t1036 VGND.t898 VPWR.t1038 VPWR.t0 sg13_lv_pmos ad=0.19p pd=1.38u as=0 ps=0 w=1u l=1u
X717 VGND.t1010 VPWR.t21 VGND.t726 VGND.t2 sg13_lv_nmos ad=0.1428p pd=1.52u as=0 ps=0 w=0.42u l=1u
X718 a_3694_2386# sg13cmos5l_buf_16_7.A VGND.t194 VGND.t193 sg13_lv_nmos ad=0.1406p pd=1.12u as=0.2516p ps=2.16u w=0.74u l=0.13u
X719 VPWR.t3 VGND.t1010 VPWR.t3 VPWR.t2 sg13_lv_pmos ad=0.19p pd=1.38u as=0 ps=0 w=1u l=1u
X720 VGND.t171 VPWR.t1624 VGND.t351 VGND.t1204 sg13_lv_nmos ad=0.1428p pd=1.52u as=0 ps=0 w=0.42u l=1u
X721 sg13cmos5l_buf_16_14.A a_4436_9910# VGND.t260 VGND.t755 sg13_lv_nmos ad=0.1406p pd=1.12u as=0.1406p ps=1.12u w=0.74u l=0.13u
X722 VPWR.t116 VGND.t41 VPWR.t113 VPWR.t67 sg13_lv_pmos ad=0.19p pd=1.38u as=0 ps=0 w=1u l=1u
X723 a_6094_3144# sg13cmos5l_buf_16_5.X VGND.t125 VGND.t40 sg13_lv_nmos ad=0.1406p pd=1.12u as=0.2516p ps=2.16u w=0.74u l=0.13u
X724 VGND.t231 a_5684_6132# sg13cmos5l_buf_16_28.X VGND.t230 sg13_lv_nmos ad=0.1406p pd=1.12u as=0.1406p ps=1.12u w=0.74u l=0.13u
X725 a_6836_9156# sg13cmos5l_and2_2_6.X VPWR.t146 VPWR.t5 sg13_lv_pmos ad=0.2128p pd=1.5u as=0.2128p ps=1.5u w=1.12u l=0.13u
X726 sg13cmos5l_buf_16_2.X a_10318_3898# VPWR.t143 VPWR.t64 sg13_lv_pmos ad=0.2128p pd=1.5u as=0.2128p ps=1.5u w=1.12u l=0.13u
X727 sg13cmos5l_buf_16_18.A a_4174_13728# VPWR.t1366 VPWR.t79 sg13_lv_pmos ad=0.2128p pd=1.5u as=0.2128p ps=1.5u w=1.12u l=0.13u
X728 VPWR.t457 VGND.t1050 VPWR.t455 VPWR.t2 sg13_lv_pmos ad=0.19p pd=1.38u as=0 ps=0 w=1u l=1u
X729 a_6094_10704# sg13cmos5l_buf_16_33.A VGND.t139 VGND.t2 sg13_lv_nmos ad=0.1406p pd=1.12u as=0.1406p ps=1.12u w=0.74u l=0.13u
X730 VPWR.t216 a_8494_3144# sg13cmos5l_buf_16_39.A VPWR.t67 sg13_lv_pmos ad=0.2128p pd=1.5u as=0.2128p ps=1.5u w=1.12u l=0.13u
X731 VGND.t1208 VPWR.t62 VGND.t1208 VGND.t1210 sg13_lv_nmos ad=0.1428p pd=1.52u as=0 ps=0 w=0.42u l=1u
X732 VGND.t989 VPWR.t1668 VGND.t989 VGND.t2 sg13_lv_nmos ad=0.1428p pd=1.52u as=0 ps=0 w=0.42u l=1u
X733 VGND.t214 VPWR.t96 VGND.t214 VGND.t1186 sg13_lv_nmos ad=79.8f pd=0.8u as=0 ps=0 w=0.42u l=1u
X734 VGND.t218 sg13cmos5l_buf_16_28.X a_5518_6922# VGND.t634 sg13_lv_nmos ad=0.1406p pd=1.12u as=0.1406p ps=1.12u w=0.74u l=0.13u
X735 VPWR.t135 VGND.t3 VPWR.t135 VPWR.t2 sg13_lv_pmos ad=0.19p pd=1.38u as=0 ps=0 w=1u l=1u
X736 VGND.t1019 VPWR.t3 VGND.t1019 VGND.t2 sg13_lv_nmos ad=0.1428p pd=1.52u as=0 ps=0 w=0.42u l=1u
X737 VPWR.t1549 a_6164_2350# sg13cmos5l_buf_16_30.A VPWR.t67 sg13_lv_pmos ad=0.2128p pd=1.5u as=0.2128p ps=1.5u w=1.12u l=0.13u
X738 a_6164_2350# sg13cmos5l_buf_16_39.A VGND.t25 VGND.t24 sg13_lv_nmos ad=0.1406p pd=1.12u as=0.1406p ps=1.12u w=0.74u l=0.13u
X739 VGND.t444 a_3668_12180# sg13cmos5l_buf_16_15.X VGND.t447 sg13_lv_nmos ad=0.1406p pd=1.12u as=0.1406p ps=1.12u w=0.74u l=0.13u
X740 VGND.t457 a_3668_12180# sg13cmos5l_buf_16_15.X VGND.t461 sg13_lv_nmos ad=0.1406p pd=1.12u as=0.1406p ps=1.12u w=0.74u l=0.13u
X741 VPWR.t6 a_10318_8434# sg13cmos5l_buf_16_22.X VPWR.t5 sg13_lv_pmos ad=0.2128p pd=1.5u as=0.2128p ps=1.5u w=1.12u l=0.13u
X742 sg13cmos5l_buf_16_39.A a_8494_3144# VPWR.t216 VPWR.t67 sg13_lv_pmos ad=0.2128p pd=1.5u as=0.2128p ps=1.5u w=1.12u l=0.13u
X743 VPWR.t1113 a_7796_12934# sg13cmos5l_buf_16_37.X VPWR.t79 sg13_lv_pmos ad=0.2128p pd=1.5u as=0.2128p ps=1.5u w=1.12u l=0.13u
X744 VGND.t513 a_13667_12956# sg13cmos5l_buf_1_17.A VGND.t514 sg13_lv_nmos ad=0.1331p pd=1.12u as=0.1406p ps=1.12u w=0.74u l=0.13u
X745 VPWR.t738 a_6094_4656# sg13cmos5l_buf_16_31.X VPWR.t64 sg13_lv_pmos ad=0.3976p pd=2.95u as=0.2128p ps=1.5u w=1.12u l=0.13u
X746 a_6094_10704# sg13cmos5l_buf_16_33.A VGND.t139 VGND.t2 sg13_lv_nmos ad=0.1406p pd=1.12u as=0.2516p ps=2.16u w=0.74u l=0.13u
X747 sg13cmos5l_buf_16_8.A a_3668_4620# VPWR.t1287 VPWR.t64 sg13_lv_pmos ad=0.2128p pd=1.5u as=0.2128p ps=1.5u w=1.12u l=0.13u
X748 VGND.t218 a_5684_6132# sg13cmos5l_buf_16_28.X VGND.t225 sg13_lv_nmos ad=0.1406p pd=1.12u as=0.1406p ps=1.12u w=0.74u l=0.13u
X749 VPWR.t902 a_3694_7680# sg13cmos5l_buf_16_34.X VPWR.t58 sg13_lv_pmos ad=0.2128p pd=1.5u as=0.2128p ps=1.5u w=1.12u l=0.13u
X750 a_4436_9910# sg13cmos5l_buf_16_20.A VPWR.t1178 VPWR.t2 sg13_lv_pmos ad=0.2128p pd=1.5u as=0.2128p ps=1.5u w=1.12u l=0.13u
X751 VPWR.t387 VGND.t5 VPWR.t385 VPWR.t58 sg13_lv_pmos ad=0.19p pd=1.38u as=0 ps=0 w=1u l=1u
X752 sg13cmos5l_buf_1_11.X a_13768_9192# VPWR.t132 VPWR.t5 sg13_lv_pmos ad=0.42p pd=2.99u as=0.2114p ps=1.54u w=1.12u l=0.13u
X753 VPWR.t179 VGND.t61 VPWR.t178 VPWR.t58 sg13_lv_pmos ad=0.34p pd=2.68u as=0 ps=0 w=1u l=1u
X754 sg13cmos5l_buf_16_38.A a_8110_6168# VPWR.t61 VPWR.t61 sg13_lv_pmos ad=0.2128p pd=1.5u as=0.2128p ps=1.5u w=1.12u l=0.13u
X755 a_14444_14442# glitch_en[6] VPWR.t1012 VPWR.t0 sg13_lv_pmos ad=0.2856p pd=2.36u as=0.2114p ps=1.54u w=0.84u l=0.13u
X756 VGND.t1061 VPWR.t6 VGND.t1061 VGND.t1067 sg13_lv_nmos ad=0.1428p pd=1.52u as=0 ps=0 w=0.42u l=1u
X757 VPWR.t16 VGND.t590 VPWR.t16 VPWR.t8 sg13_lv_pmos ad=0.19p pd=1.38u as=0 ps=0 w=1u l=1u
X758 sg13cmos5l_buf_1_5.A a_6161_12574# a_6332_12216# VPWR.t8 sg13_lv_pmos ad=0.3808p pd=2.92u as=0.2128p ps=1.5u w=1.12u l=0.13u
X759 a_4462_5410# sg13cmos5l_and2_2_0.X VPWR.t1261 VPWR.t61 sg13_lv_pmos ad=0.2128p pd=1.5u as=0.2128p ps=1.5u w=1.12u l=0.13u
X760 VPWR.t1285 a_3668_4620# sg13cmos5l_buf_16_8.A VPWR.t64 sg13_lv_pmos ad=0.2128p pd=1.5u as=0.2128p ps=1.5u w=1.12u l=0.13u
X761 VPWR.t0 VGND.t204 VPWR.t0 VPWR.t0 sg13_lv_pmos ad=0.34p pd=2.68u as=0 ps=0 w=1u l=1u
X762 VGND.t15 a_6766_8434# sg13cmos5l_buf_16_35.A VGND.t288 sg13_lv_nmos ad=0.1406p pd=1.12u as=0.1406p ps=1.12u w=0.74u l=0.13u
X763 VGND.t1388 VPWR.t126 VGND.t1390 VGND.t1389 sg13_lv_nmos ad=79.8f pd=0.8u as=0 ps=0 w=0.42u l=1u
X764 sg13cmos5l_buf_16_4.X a_9524_6886# VGND.t210 VGND.t561 sg13_lv_nmos ad=0.1406p pd=1.12u as=0.1406p ps=1.12u w=0.74u l=0.13u
X765 VPWR.t62 VGND.t1165 VPWR.t62 VPWR.t61 sg13_lv_pmos ad=0.19p pd=1.38u as=0 ps=0 w=1u l=1u
X766 sg13cmos5l_buf_16_14.A a_4436_9910# VPWR.t1216 VPWR.t2 sg13_lv_pmos ad=0.2128p pd=1.5u as=0.2128p ps=1.5u w=1.12u l=0.13u
X767 a_4436_9910# sg13cmos5l_buf_16_20.A VPWR.t1175 VPWR.t2 sg13_lv_pmos ad=0.2128p pd=1.5u as=0.2128p ps=1.5u w=1.12u l=0.13u
X768 VGND.t637 VPWR.t62 VGND.t637 VGND.t1212 sg13_lv_nmos ad=79.8f pd=0.8u as=0 ps=0 w=0.42u l=1u
X769 VPWR.t682 sg13cmos5l_buf_16_8.A a_4892_6168# VPWR.t61 sg13_lv_pmos ad=0.2128p pd=1.5u as=0.3808p ps=2.92u w=1.12u l=0.13u
X770 VPWR.t898 a_3694_7680# sg13cmos5l_buf_16_34.X VPWR.t58 sg13_lv_pmos ad=0.2128p pd=1.5u as=0.2128p ps=1.5u w=1.12u l=0.13u
X771 VGND.t206 VPWR.t80 VGND.t206 VGND.t933 sg13_lv_nmos ad=0.1428p pd=1.52u as=0 ps=0 w=0.42u l=1u
X772 VGND.t66 sg13cmos5l_buf_16_24.A a_6862_9946# VGND.t154 sg13_lv_nmos ad=0.1406p pd=1.12u as=0.1406p ps=1.12u w=0.74u l=0.13u
X773 sg13cmos5l_buf_16_35.A a_6766_8434# VGND.t15 VGND.t285 sg13_lv_nmos ad=0.1406p pd=1.12u as=0.1406p ps=1.12u w=0.74u l=0.13u
X774 sg13cmos5l_buf_1_5.A sg13cmos5l_buf_16_24.X a_6426_12574# VGND.t625 sg13_lv_nmos ad=0.1628p pd=1.18u as=88.8f ps=0.98u w=0.74u l=0.13u
X775 VGND.t726 a_6094_10704# sg13cmos5l_buf_16_24.A VGND.t2 sg13_lv_nmos ad=0.1406p pd=1.12u as=0.1406p ps=1.12u w=0.74u l=0.13u
X776 VGND.t66 sg13cmos5l_buf_16_14.A a_3668_9156# VGND.t67 sg13_lv_nmos ad=0.1406p pd=1.12u as=0.1406p ps=1.12u w=0.74u l=0.13u
X777 VPWR.t170 VGND.t5 VPWR.t396 VPWR.t58 sg13_lv_pmos ad=0.34p pd=2.68u as=0 ps=0 w=1u l=1u
X778 VGND.t86 a_10318_5410# sg13cmos5l_buf_16_1.X VGND.t92 sg13_lv_nmos ad=0.1406p pd=1.12u as=0.1406p ps=1.12u w=0.74u l=0.13u
X779 VGND.t843 VPWR.t120 VGND.t843 VGND.t1303 sg13_lv_nmos ad=79.8f pd=0.8u as=0 ps=0 w=0.42u l=1u
X780 sg13cmos5l_and2_2_6.A a_3694_10704# VGND.t134 VGND.t2 sg13_lv_nmos ad=0.1406p pd=1.12u as=0.1406p ps=1.12u w=0.74u l=0.13u
X781 VPWR.t1545 a_6164_2350# sg13cmos5l_buf_16_30.A VPWR.t67 sg13_lv_pmos ad=0.2128p pd=1.5u as=0.2128p ps=1.5u w=1.12u l=0.13u
X782 VPWR.t513 a_6836_9156# sg13cmos5l_buf_16_25.A VPWR.t5 sg13_lv_pmos ad=0.2128p pd=1.5u as=0.2128p ps=1.5u w=1.12u l=0.13u
X783 VPWR.t143 VGND.t302 VPWR.t64 VPWR.t64 sg13_lv_pmos ad=0.34p pd=2.68u as=0 ps=0 w=1u l=1u
X784 VPWR.t101 VGND.t7 VPWR.t102 VPWR.t58 sg13_lv_pmos ad=0.19p pd=1.38u as=0 ps=0 w=1u l=1u
X785 VGND.t1196 VPWR.t1627 VGND.t1196 VGND.t1199 sg13_lv_nmos ad=79.8f pd=0.8u as=0 ps=0 w=0.42u l=1u
X786 VGND.t42 VPWR.t1614 VGND.t42 VGND.t40 sg13_lv_nmos ad=0.1428p pd=1.52u as=0 ps=0 w=0.42u l=1u
X787 a_3668_12180# sg13cmos5l_buf_16_15.A VGND.t457 VGND.t700 sg13_lv_nmos ad=0.1406p pd=1.12u as=0.1406p ps=1.12u w=0.74u l=0.13u
X788 VGND.t1286 VPWR.t250 VGND.t1286 VGND.t1323 sg13_lv_nmos ad=0.1428p pd=1.52u as=0 ps=0 w=0.42u l=1u
X789 sg13cmos5l_buf_16_39.A a_8494_3144# VGND.t302 VGND.t40 sg13_lv_nmos ad=0.1406p pd=1.12u as=0.1406p ps=1.12u w=0.74u l=0.13u
X790 a_4052_12934# sg13cmos5l_buf_16_18.A VGND.t620 VGND.t640 sg13_lv_nmos ad=0.1406p pd=1.12u as=0.1406p ps=1.12u w=0.74u l=0.13u
X791 sg13cmos5l_buf_16_14.A a_4436_9910# VPWR.t1213 VPWR.t2 sg13_lv_pmos ad=0.2128p pd=1.5u as=0.3976p ps=2.95u w=1.12u l=0.13u
X792 sg13cmos5l_buf_16_0.A a_6094_3898# VGND.t125 VGND.t40 sg13_lv_nmos ad=0.1406p pd=1.12u as=0.1406p ps=1.12u w=0.74u l=0.13u
X793 sg13cmos5l_buf_16_1.X a_10318_5410# VGND.t86 VGND.t89 sg13_lv_nmos ad=0.1406p pd=1.12u as=0.1406p ps=1.12u w=0.74u l=0.13u
X794 VGND.t1339 VPWR.t55 VGND.t1341 VGND.t1340 sg13_lv_nmos ad=79.8f pd=0.8u as=0 ps=0 w=0.42u l=1u
X795 sg13cmos5l_buf_1_11.X a_13768_9192# VGND.t39 VGND.t38 sg13_lv_nmos ad=0.2886p pd=2.26u as=0.14875p ps=1.16u w=0.74u l=0.13u
X796 sg13cmos5l_buf_16_30.A a_6164_2350# VPWR.t1542 VPWR.t67 sg13_lv_pmos ad=0.2128p pd=1.5u as=0.3976p ps=2.95u w=1.12u l=0.13u
X797 VGND.t42 VPWR.t125 VGND.t41 VGND.t40 sg13_lv_nmos ad=0.1428p pd=1.52u as=0 ps=0 w=0.42u l=1u
X798 a_3668_4620# sg13cmos5l_buf_16_11.A VGND.t351 VGND.t1563 sg13_lv_nmos ad=0.1406p pd=1.12u as=0.1406p ps=1.12u w=0.74u l=0.13u
X799 sg13cmos5l_buf_16_35.A a_6766_8434# VPWR.t663 VPWR.t5 sg13_lv_pmos ad=0.2128p pd=1.5u as=0.2128p ps=1.5u w=1.12u l=0.13u
X800 VGND.t1550 a_6164_2350# sg13cmos5l_buf_16_30.A VGND.t1549 sg13_lv_nmos ad=0.1406p pd=1.12u as=0.1406p ps=1.12u w=0.74u l=0.13u
X801 a_6332_9192# sg13cmos5l_and2_2_6.A VPWR.t312 VPWR.t5 sg13_lv_pmos ad=0.2128p pd=1.5u as=0.2128p ps=1.5u w=1.12u l=0.13u
X802 VPWR.t473 sg13cmos5l_buf_16_10.A a_3668_3108# VPWR.t67 sg13_lv_pmos ad=0.3808p pd=2.92u as=0.2128p ps=1.5u w=1.12u l=0.13u
X803 VGND.t171 a_7220_5374# sg13cmos5l_buf_16_28.A VGND.t337 sg13_lv_nmos ad=0.1406p pd=1.12u as=0.1406p ps=1.12u w=0.74u l=0.13u
X804 VPWR.t1326 sg13cmos5l_buf_16_15.X a_3694_14482# VPWR.t0 sg13_lv_pmos ad=0.2128p pd=1.5u as=0.2128p ps=1.5u w=1.12u l=0.13u
X805 VPWR.t1539 a_3694_3898# sg13cmos5l_buf_16_10.A VPWR.t64 sg13_lv_pmos ad=0.2128p pd=1.5u as=0.2128p ps=1.5u w=1.12u l=0.13u
X806 VPWR.t580 a_5684_6132# sg13cmos5l_buf_16_28.X VPWR.t61 sg13_lv_pmos ad=0.2128p pd=1.5u as=0.2128p ps=1.5u w=1.12u l=0.13u
X807 VGND.t845 sg13cmos5l_buf_16_5.A a_5108_838# VGND.t848 sg13_lv_nmos ad=0.1406p pd=1.12u as=0.1406p ps=1.12u w=0.74u l=0.13u
X808 VPWR.t430 VGND.t1061 VPWR.t430 VPWR.t2 sg13_lv_pmos ad=0.34p pd=2.68u as=0 ps=0 w=1u l=1u
X809 VPWR.t1085 a_4052_12934# sg13cmos5l_buf_16_15.A VPWR.t79 sg13_lv_pmos ad=0.2128p pd=1.5u as=0.2128p ps=1.5u w=1.12u l=0.13u
X810 VPWR.t1112 sg13cmos5l_buf_16_18.A a_4052_12934# VPWR.t79 sg13_lv_pmos ad=0.3808p pd=2.92u as=0.2128p ps=1.5u w=1.12u l=0.13u
X811 VPWR.t661 a_6766_8434# sg13cmos5l_buf_16_35.A VPWR.t5 sg13_lv_pmos ad=0.2128p pd=1.5u as=0.2128p ps=1.5u w=1.12u l=0.13u
X812 VPWR.t63 VGND.t1298 VPWR.t63 VPWR.t55 sg13_lv_pmos ad=0.19p pd=1.38u as=0 ps=0 w=1u l=1u
X813 sg13cmos5l_buf_16_3.X a_10292_4620# VPWR.t143 VPWR.t64 sg13_lv_pmos ad=0.2128p pd=1.5u as=0.2128p ps=1.5u w=1.12u l=0.13u
X814 VPWR.t648 a_3668_9156# sg13cmos5l_buf_16_13.A VPWR.t5 sg13_lv_pmos ad=0.2128p pd=1.5u as=0.2128p ps=1.5u w=1.12u l=0.13u
X815 sg13cmos5l_buf_16_5.X a_5108_838# VGND.t845 VGND.t1466 sg13_lv_nmos ad=0.1406p pd=1.12u as=0.1406p ps=1.12u w=0.74u l=0.13u
X816 VPWR.t56 a_5108_838# sg13cmos5l_buf_16_5.X VPWR.t55 sg13_lv_pmos ad=0.2128p pd=1.5u as=0.2128p ps=1.5u w=1.12u l=0.13u
X817 a_3668_3108# sg13cmos5l_buf_16_10.A VPWR.t469 VPWR.t67 sg13_lv_pmos ad=0.2128p pd=1.5u as=0.2128p ps=1.5u w=1.12u l=0.13u
X818 sg13cmos5l_buf_16_1.X a_10318_5410# VPWR.t96 VPWR.t61 sg13_lv_pmos ad=0.2128p pd=1.5u as=0.2128p ps=1.5u w=1.12u l=0.13u
X819 sg13cmos5l_buf_16_15.A a_4052_12934# VGND.t457 VGND.t616 sg13_lv_nmos ad=0.1406p pd=1.12u as=0.1406p ps=1.12u w=0.74u l=0.13u
X820 sg13cmos5l_buf_16_28.A a_7220_5374# VGND.t171 VGND.t334 sg13_lv_nmos ad=0.1406p pd=1.12u as=0.1406p ps=1.12u w=0.74u l=0.13u
X821 sg13cmos5l_buf_16_4.X a_9524_6886# VGND.t210 VGND.t557 sg13_lv_nmos ad=0.1406p pd=1.12u as=0.1406p ps=1.12u w=0.74u l=0.13u
X822 VGND.t204 VPWR.t0 VGND.t206 VGND.t919 sg13_lv_nmos ad=79.8f pd=0.8u as=0 ps=0 w=0.42u l=1u
X823 VGND.t1368 VPWR.t57 VGND.t851 VGND.t1367 sg13_lv_nmos ad=0.1428p pd=1.52u as=0 ps=0 w=0.42u l=1u
X824 VPWR.t61 a_8110_6168# sg13cmos5l_buf_16_38.A VPWR.t61 sg13_lv_pmos ad=0.2128p pd=1.5u as=0.2128p ps=1.5u w=1.12u l=0.13u
X825 VGND.t41 VPWR.t117 VGND.t41 VGND.t40 sg13_lv_nmos ad=0.1428p pd=1.52u as=0 ps=0 w=0.42u l=1u
X826 sg13cmos5l_buf_16_28.X a_5684_6132# VPWR.t577 VPWR.t61 sg13_lv_pmos ad=0.2128p pd=1.5u as=0.3976p ps=2.95u w=1.12u l=0.13u
X827 VGND.t5 a_9262_7680# sg13cmos5l_buf_16_2.A VGND.t109 sg13_lv_nmos ad=0.1406p pd=1.12u as=0.1406p ps=1.12u w=0.74u l=0.13u
X828 VPWR.t131 VGND.t1018 VPWR.t131 VPWR.t8 sg13_lv_pmos ad=0.34p pd=2.68u as=0 ps=0 w=1u l=1u
X829 VGND.t139 a_5204_11422# sg13cmos5l_buf_16_20.A VGND.t2 sg13_lv_nmos ad=0.1406p pd=1.12u as=0.1406p ps=1.12u w=0.74u l=0.13u
X830 VGND.t843 VPWR.t226 VGND.t843 VGND.t1336 sg13_lv_nmos ad=79.8f pd=0.8u as=0 ps=0 w=0.42u l=1u
X831 sg13cmos5l_buf_16_0.A a_6094_3898# VGND.t125 VGND.t40 sg13_lv_nmos ad=0.1406p pd=1.12u as=0.1406p ps=1.12u w=0.74u l=0.13u
X832 VGND.t1196 VPWR.t1621 VGND.t1196 VGND.t1201 sg13_lv_nmos ad=79.8f pd=0.8u as=0 ps=0 w=0.42u l=1u
X833 VGND.t532 VPWR.t881 VGND.t532 VGND.t1193 sg13_lv_nmos ad=0.1428p pd=1.52u as=0 ps=0 w=0.42u l=1u
X834 sg13cmos5l_buf_16_25.A a_6836_9156# VGND.t66 VGND.t153 sg13_lv_nmos ad=0.1406p pd=1.12u as=0.2516p ps=2.16u w=0.74u l=0.13u
X835 VPWR.t143 a_10292_4620# sg13cmos5l_buf_16_3.X VPWR.t64 sg13_lv_pmos ad=0.2128p pd=1.5u as=0.2128p ps=1.5u w=1.12u l=0.13u
X836 sg13cmos5l_buf_16_13.A a_3668_9156# VPWR.t644 VPWR.t5 sg13_lv_pmos ad=0.2128p pd=1.5u as=0.2128p ps=1.5u w=1.12u l=0.13u
X837 sg13cmos5l_buf_16_5.X a_5108_838# VPWR.t56 VPWR.t55 sg13_lv_pmos ad=0.2128p pd=1.5u as=0.2128p ps=1.5u w=1.12u l=0.13u
X838 VPWR.t85 a_10318_5410# sg13cmos5l_buf_16_1.X VPWR.t61 sg13_lv_pmos ad=0.2128p pd=1.5u as=0.2128p ps=1.5u w=1.12u l=0.13u
X839 VGND.t210 a_9524_6886# sg13cmos5l_buf_16_4.X VGND.t554 sg13_lv_nmos ad=0.1406p pd=1.12u as=0.1406p ps=1.12u w=0.74u l=0.13u
X840 VGND.t5 VPWR.t146 VGND.t5 VGND.t1111 sg13_lv_nmos ad=0.1428p pd=1.52u as=0 ps=0 w=0.42u l=1u
X841 a_6548_13692# sg13cmos5l_buf_16_37.X VGND.t597 VGND.t1514 sg13_lv_nmos ad=0.1406p pd=1.12u as=0.1406p ps=1.12u w=0.74u l=0.13u
X842 VPWR.t913 a_5518_6922# sg13cmos5l_buf_16_6.X VPWR.t58 sg13_lv_pmos ad=0.2128p pd=1.5u as=0.2128p ps=1.5u w=1.12u l=0.13u
X843 VPWR.t1081 a_4052_12934# sg13cmos5l_buf_16_15.A VPWR.t79 sg13_lv_pmos ad=0.2128p pd=1.5u as=0.2128p ps=1.5u w=1.12u l=0.13u
X844 VGND.t1339 VPWR.t55 VGND.t1338 VGND.t1337 sg13_lv_nmos ad=0.1428p pd=1.52u as=0 ps=0 w=0.42u l=1u
X845 VPWR.t62 VGND.t532 VPWR.t62 VPWR.t61 sg13_lv_pmos ad=0.19p pd=1.38u as=0 ps=0 w=1u l=1u
X846 VPWR.t1535 a_3694_3898# sg13cmos5l_buf_16_10.A VPWR.t64 sg13_lv_pmos ad=0.2128p pd=1.5u as=0.2128p ps=1.5u w=1.12u l=0.13u
X847 sg13cmos5l_buf_16_3.X a_10292_4620# VPWR.t143 VPWR.t64 sg13_lv_pmos ad=0.2128p pd=1.5u as=0.2128p ps=1.5u w=1.12u l=0.13u
X848 sg13cmos5l_buf_16_28.A a_7220_5374# VPWR.t711 VPWR.t61 sg13_lv_pmos ad=0.2128p pd=1.5u as=0.2128p ps=1.5u w=1.12u l=0.13u
X849 VPWR.t289 VGND.t260 VPWR.t288 VPWR.t2 sg13_lv_pmos ad=0.19p pd=1.38u as=0 ps=0 w=1u l=1u
X850 VPWR.t86 VGND.t1361 VPWR.t86 VPWR.t55 sg13_lv_pmos ad=0.19p pd=1.38u as=0 ps=0 w=1u l=1u
X851 VPWR.t10 VGND.t726 VPWR.t11 VPWR.t8 sg13_lv_pmos ad=0.19p pd=1.38u as=0 ps=0 w=1u l=1u
X852 VGND.t7 a_5518_6922# sg13cmos5l_buf_16_6.X VGND.t548 sg13_lv_nmos ad=0.2516p pd=2.16u as=0.1406p ps=1.12u w=0.74u l=0.13u
X853 sg13cmos5l_buf_16_24.A a_6094_10704# VPWR.t1182 VPWR.t2 sg13_lv_pmos ad=0.2128p pd=1.5u as=0.2128p ps=1.5u w=1.12u l=0.13u
X854 VGND.t139 a_5204_11422# sg13cmos5l_buf_16_20.A VGND.t2 sg13_lv_nmos ad=0.1406p pd=1.12u as=0.1406p ps=1.12u w=0.74u l=0.13u
X855 a_5710_1632# sg13cmos5l_buf_16_30.A VPWR.t56 VPWR.t55 sg13_lv_pmos ad=0.2128p pd=1.5u as=0.2128p ps=1.5u w=1.12u l=0.13u
X856 sg13cmos5l_buf_16_39.A a_8494_3144# VGND.t302 VGND.t40 sg13_lv_nmos ad=0.1406p pd=1.12u as=0.1406p ps=1.12u w=0.74u l=0.13u
X857 sg13cmos5l_buf_16_7.A a_3668_3108# VPWR.t858 VPWR.t67 sg13_lv_pmos ad=0.2128p pd=1.5u as=0.2128p ps=1.5u w=1.12u l=0.13u
X858 VPWR.t125 VGND.t843 VPWR.t120 VPWR.t67 sg13_lv_pmos ad=0.19p pd=1.38u as=0 ps=0 w=1u l=1u
X859 a_3668_4620# sg13cmos5l_buf_16_11.A VGND.t351 VGND.t1559 sg13_lv_nmos ad=0.1406p pd=1.12u as=0.1406p ps=1.12u w=0.74u l=0.13u
X860 a_2147_13692# sg13cmos5l_buf_16_31.X a_2377_14076# VGND.t1509 sg13_lv_nmos ad=0.2176p pd=1.96u as=0.1216p ps=1.02u w=0.64u l=0.13u
X861 VPWR.t709 a_7220_5374# sg13cmos5l_buf_16_28.A VPWR.t61 sg13_lv_pmos ad=0.2128p pd=1.5u as=0.2128p ps=1.5u w=1.12u l=0.13u
X862 sg13cmos5l_and2_2_0.B a_1672_14516# VGND.t895 VGND.t1494 sg13_lv_nmos ad=0.2886p pd=2.26u as=0.14875p ps=1.16u w=0.74u l=0.13u
X863 sg13cmos5l_buf_16_11.A a_4462_5410# VGND.t351 VGND.t429 sg13_lv_nmos ad=0.1406p pd=1.12u as=0.1406p ps=1.12u w=0.74u l=0.13u
X864 sg13cmos5l_xor2_1_0.B a_6094_3144# VGND.t125 VGND.t40 sg13_lv_nmos ad=0.1406p pd=1.12u as=0.1406p ps=1.12u w=0.74u l=0.13u
X865 sg13cmos5l_buf_16_6.X a_5518_6922# VGND.t7 VGND.t545 sg13_lv_nmos ad=0.1406p pd=1.12u as=0.1406p ps=1.12u w=0.74u l=0.13u
X866 sg13cmos5l_buf_16_27.X a_6548_13692# VGND.t891 VGND.t1479 sg13_lv_nmos ad=0.1406p pd=1.12u as=0.1406p ps=1.12u w=0.74u l=0.13u
X867 sg13cmos5l_buf_16_37.X a_7796_12934# VGND.t682 VGND.t681 sg13_lv_nmos ad=0.1406p pd=1.12u as=0.2516p ps=2.16u w=0.74u l=0.13u
X868 VPWR.t126 VGND.t1290 VPWR.t126 VPWR.t55 sg13_lv_pmos ad=0.19p pd=1.38u as=0 ps=0 w=1u l=1u
X869 VPWR.t96 VGND.t214 VPWR.t96 VPWR.t61 sg13_lv_pmos ad=0.19p pd=1.38u as=0 ps=0 w=1u l=1u
X870 VPWR.t1077 a_4052_12934# sg13cmos5l_buf_16_15.A VPWR.t79 sg13_lv_pmos ad=0.2128p pd=1.5u as=0.2128p ps=1.5u w=1.12u l=0.13u
X871 sg13cmos5l_buf_16_33.A a_3694_14482# VPWR.t1341 VPWR.t0 sg13_lv_pmos ad=0.2128p pd=1.5u as=0.2128p ps=1.5u w=1.12u l=0.13u
X872 VPWR.t236 VGND.t931 VPWR.t304 VPWR.t79 sg13_lv_pmos ad=0.34p pd=2.68u as=0 ps=0 w=1u l=1u
X873 VPWR.t187 VGND.t134 VPWR.t186 VPWR.t8 sg13_lv_pmos ad=0.34p pd=2.68u as=0 ps=0 w=1u l=1u
X874 VPWR.t656 sg13cmos5l_buf_16_25.A a_6766_8434# VPWR.t5 sg13_lv_pmos ad=0.2128p pd=1.5u as=0.2128p ps=1.5u w=1.12u l=0.13u
X875 VPWR.t23 VGND.t726 VPWR.t22 VPWR.t2 sg13_lv_pmos ad=0.34p pd=2.68u as=0 ps=0 w=1u l=1u
X876 a_6094_10704# sg13cmos5l_buf_16_33.A VPWR.t1356 VPWR.t2 sg13_lv_pmos ad=0.2128p pd=1.5u as=0.2128p ps=1.5u w=1.12u l=0.13u
X877 VGND.t5 VPWR.t1653 VGND.t5 VGND.t1104 sg13_lv_nmos ad=0.1428p pd=1.52u as=0 ps=0 w=0.42u l=1u
X878 VGND.t1292 VPWR.t519 VGND.t1296 VGND.t1330 sg13_lv_nmos ad=79.8f pd=0.8u as=0 ps=0 w=0.42u l=1u
X879 VGND.t351 a_4462_5410# sg13cmos5l_buf_16_11.A VGND.t426 sg13_lv_nmos ad=0.1406p pd=1.12u as=0.1406p ps=1.12u w=0.74u l=0.13u
X880 VGND.t214 VPWR.t96 VGND.t214 VGND.t1187 sg13_lv_nmos ad=0.1428p pd=1.52u as=0 ps=0 w=0.42u l=1u
X881 VPWR.t58 VGND.t532 VPWR.t58 VPWR.t58 sg13_lv_pmos ad=0.19p pd=1.38u as=0 ps=0 w=1u l=1u
X882 VGND.t682 a_6765_12564# sg13cmos5l_buf_16_19.A VGND.t709 sg13_lv_nmos ad=0.2812p pd=2.24u as=0.1406p ps=1.12u w=0.74u l=0.13u
X883 VPWR.t113 VGND.t41 VPWR.t113 VPWR.t67 sg13_lv_pmos ad=0.19p pd=1.38u as=0 ps=0 w=1u l=1u
X884 sg13cmos5l_and2_2_5.B a_11272_13728# VPWR.t566 VPWR.t79 sg13_lv_pmos ad=0.42p pd=2.99u as=0.2114p ps=1.54u w=1.12u l=0.13u
X885 sg13cmos5l_buf_16_2.X a_10318_3898# VGND.t302 VGND.t40 sg13_lv_nmos ad=0.1406p pd=1.12u as=0.1406p ps=1.12u w=0.74u l=0.13u
X886 VGND.t206 glitch_en[5] a_13576_14516# VGND.t1493 sg13_lv_nmos ad=0.14875p pd=1.16u as=0.187p ps=1.78u w=0.55u l=0.13u
X887 VGND.t1113 VPWR.t6 VGND.t1115 VGND.t1114 sg13_lv_nmos ad=79.8f pd=0.8u as=0 ps=0 w=0.42u l=1u
X888 VPWR.t63 VGND.t1298 VPWR.t63 VPWR.t55 sg13_lv_pmos ad=0.19p pd=1.38u as=0 ps=0 w=1u l=1u
X889 VGND.t1344 VPWR.t156 VGND.t1346 VGND.t1345 sg13_lv_nmos ad=79.8f pd=0.8u as=0 ps=0 w=0.42u l=1u
X890 VGND.t181 sg13cmos5l_buf_16_2.X a_10292_4620# VGND.t183 sg13_lv_nmos ad=0.2516p pd=2.16u as=0.1406p ps=1.12u w=0.74u l=0.13u
X891 VPWR.t1514 VGND.t1196 VPWR.t1512 VPWR.t64 sg13_lv_pmos ad=0.19p pd=1.38u as=0 ps=0 w=1u l=1u
X892 sg13cmos5l_buf_16_13.A a_3668_9156# VPWR.t640 VPWR.t5 sg13_lv_pmos ad=0.2128p pd=1.5u as=0.2128p ps=1.5u w=1.12u l=0.13u
X893 VPWR.t563 sg13cmos5l_buf_16_7.A a_3694_2386# VPWR.t67 sg13_lv_pmos ad=0.2128p pd=1.5u as=0.2128p ps=1.5u w=1.12u l=0.13u
X894 sg13cmos5l_buf_16_7.X a_3694_2386# VGND.t198 VGND.t1571 sg13_lv_nmos ad=0.1406p pd=1.12u as=0.1406p ps=1.12u w=0.74u l=0.13u
X895 VPWR.t85 a_10318_5410# sg13cmos5l_buf_16_1.X VPWR.t61 sg13_lv_pmos ad=0.2128p pd=1.5u as=0.2128p ps=1.5u w=1.12u l=0.13u
X896 VGND.t5 VPWR.t1644 VGND.t5 VGND.t1131 sg13_lv_nmos ad=0.1428p pd=1.52u as=0 ps=0 w=0.42u l=1u
X897 VGND.t898 VPWR.t1699 VGND.t898 VGND.t899 sg13_lv_nmos ad=79.8f pd=0.8u as=0 ps=0 w=0.42u l=1u
X898 a_4436_9910# sg13cmos5l_buf_16_20.A VGND.t66 VGND.t713 sg13_lv_nmos ad=0.1406p pd=1.12u as=0.1406p ps=1.12u w=0.74u l=0.13u
X899 sg13cmos5l_xor2_1_0.B a_6094_3144# VGND.t125 VGND.t40 sg13_lv_nmos ad=0.1406p pd=1.12u as=0.1406p ps=1.12u w=0.74u l=0.13u
X900 VPWR.t909 a_5518_6922# sg13cmos5l_buf_16_6.X VPWR.t58 sg13_lv_pmos ad=0.2128p pd=1.5u as=0.2128p ps=1.5u w=1.12u l=0.13u
X901 sg13cmos5l_buf_16_2.A a_9262_7680# VGND.t5 VGND.t101 sg13_lv_nmos ad=0.1406p pd=1.12u as=0.1406p ps=1.12u w=0.74u l=0.13u
X902 a_14252_9906# sg13cmos5l_and2_2_3.X VPWR.t135 VPWR.t2 sg13_lv_pmos ad=0.2856p pd=2.36u as=0.2114p ps=1.54u w=0.84u l=0.13u
X903 sg13cmos5l_buf_16_2.X a_10318_3898# VPWR.t143 VPWR.t64 sg13_lv_pmos ad=0.2128p pd=1.5u as=0.2128p ps=1.5u w=1.12u l=0.13u
X904 VGND.t590 sg13cmos5l_buf_16_37.A a_7796_12934# VGND.t593 sg13_lv_nmos ad=0.1406p pd=1.12u as=0.1406p ps=1.12u w=0.74u l=0.13u
X905 VGND.t797 VPWR.t1620 VGND.t797 VGND.t1203 sg13_lv_nmos ad=79.8f pd=0.8u as=0 ps=0 w=0.42u l=1u
X906 VPWR.t800 a_4462_5410# sg13cmos5l_buf_16_11.A VPWR.t61 sg13_lv_pmos ad=0.2128p pd=1.5u as=0.2128p ps=1.5u w=1.12u l=0.13u
X907 sg13cmos5l_buf_16_38.A a_8110_6168# VGND.t210 VGND.t788 sg13_lv_nmos ad=0.1406p pd=1.12u as=0.1406p ps=1.12u w=0.74u l=0.13u
X908 a_6094_10704# sg13cmos5l_buf_16_33.A VPWR.t1353 VPWR.t2 sg13_lv_pmos ad=0.2128p pd=1.5u as=0.3808p ps=2.92u w=1.12u l=0.13u
X909 VPWR.t430 VGND.t1061 VPWR.t28 VPWR.t2 sg13_lv_pmos ad=0.19p pd=1.38u as=0 ps=0 w=1u l=1u
X910 a_10292_4620# sg13cmos5l_buf_16_2.X VGND.t86 VGND.t179 sg13_lv_nmos ad=0.1406p pd=1.12u as=0.1406p ps=1.12u w=0.74u l=0.13u
X911 VGND.t1147 VPWR.t1639 VGND.t1147 VGND.t1151 sg13_lv_nmos ad=79.8f pd=0.8u as=0 ps=0 w=0.42u l=1u
X912 VPWR.t389 VGND.t5 VPWR.t388 VPWR.t58 sg13_lv_pmos ad=0.34p pd=2.68u as=0 ps=0 w=1u l=1u
X913 VPWR.t91 VGND.t214 VPWR.t91 VPWR.t58 sg13_lv_pmos ad=0.19p pd=1.38u as=0 ps=0 w=1u l=1u
X914 a_3694_2386# sg13cmos5l_buf_16_7.A VPWR.t560 VPWR.t67 sg13_lv_pmos ad=0.2128p pd=1.5u as=0.3808p ps=2.92u w=1.12u l=0.13u
X915 VGND.t198 a_3694_2386# sg13cmos5l_buf_16_7.X VGND.t1568 sg13_lv_nmos ad=0.1406p pd=1.12u as=0.1406p ps=1.12u w=0.74u l=0.13u
X916 VPWR.t117 VGND.t1296 VPWR.t117 VPWR.t67 sg13_lv_pmos ad=0.19p pd=1.38u as=0 ps=0 w=1u l=1u
X917 sg13cmos5l_buf_16_6.X a_5518_6922# VPWR.t906 VPWR.t58 sg13_lv_pmos ad=0.2128p pd=1.5u as=0.2128p ps=1.5u w=1.12u l=0.13u
X918 VPWR.t143 a_10318_3898# sg13cmos5l_buf_16_2.X VPWR.t64 sg13_lv_pmos ad=0.2128p pd=1.5u as=0.2128p ps=1.5u w=1.12u l=0.13u
X919 a_5684_6132# sg13cmos5l_buf_16_28.A VGND.t7 VGND.t794 sg13_lv_nmos ad=0.1406p pd=1.12u as=0.1406p ps=1.12u w=0.74u l=0.13u
X920 a_10318_3898# sg13cmos5l_buf_16_2.A VGND.t302 VGND.t40 sg13_lv_nmos ad=0.1406p pd=1.12u as=0.1406p ps=1.12u w=0.74u l=0.13u
X921 sg13cmos5l_buf_16_33.A a_3694_14482# VGND.t870 VGND.t883 sg13_lv_nmos ad=0.1406p pd=1.12u as=0.1406p ps=1.12u w=0.74u l=0.13u
X922 VPWR.t120 VGND.t41 VPWR.t117 VPWR.t67 sg13_lv_pmos ad=0.34p pd=2.68u as=0 ps=0 w=1u l=1u
X923 VPWR.t905 sg13cmos5l_buf_1_4.A a_14824_6956# VPWR.t58 sg13_lv_pmos ad=0.2114p pd=1.54u as=0.2856p ps=2.36u w=0.84u l=0.13u
X924 VPWR.t759 a_6094_3144# sg13cmos5l_xor2_1_0.B VPWR.t67 sg13_lv_pmos ad=0.2128p pd=1.5u as=0.2128p ps=1.5u w=1.12u l=0.13u
X925 sg13cmos5l_and2_2_6.B a_7432_14516# VGND.t1 VGND.t1451 sg13_lv_nmos ad=0.2886p pd=2.26u as=0.14875p ps=1.16u w=0.74u l=0.13u
X926 VPWR.t56 VGND.t1366 VPWR.t56 VPWR.t55 sg13_lv_pmos ad=0.19p pd=1.38u as=0 ps=0 w=1u l=1u
X927 VGND.t3 VPWR.t283 VGND.t3 VGND.t2 sg13_lv_nmos ad=0.1428p pd=1.52u as=0 ps=0 w=0.42u l=1u
X928 sg13cmos5l_and2_2_3.X a_13581_9988# VPWR.t135 VPWR.t2 sg13_lv_pmos ad=0.2128p pd=1.5u as=0.1918p ps=1.5u w=1.12u l=0.13u
X929 VGND.t590 a_7796_12934# sg13cmos5l_buf_16_37.X VGND.t697 sg13_lv_nmos ad=0.1406p pd=1.12u as=0.1406p ps=1.12u w=0.74u l=0.13u
X930 VGND.t139 sg13cmos5l_buf_16_33.A a_6094_10704# VGND.t2 sg13_lv_nmos ad=0.1406p pd=1.12u as=0.1406p ps=1.12u w=0.74u l=0.13u
X931 VGND.t1061 VPWR.t3 VGND.t1073 VGND.t1072 sg13_lv_nmos ad=79.8f pd=0.8u as=0 ps=0 w=0.42u l=1u
X932 a_6426_9550# sg13cmos5l_buf_16_14.A VGND.t66 VGND.t73 sg13_lv_nmos ad=88.8f pd=0.98u as=0.15245p ps=1.17u w=0.74u l=0.13u
X933 a_6164_2350# sg13cmos5l_buf_16_39.A VPWR.t218 VPWR.t67 sg13_lv_pmos ad=0.2128p pd=1.5u as=0.2128p ps=1.5u w=1.12u l=0.13u
X934 VGND.t7 sg13cmos5l_buf_16_28.A a_5684_6132# VGND.t791 sg13_lv_nmos ad=0.1406p pd=1.12u as=0.1406p ps=1.12u w=0.74u l=0.13u
X935 sg13cmos5l_buf_16_18.A a_4174_13728# VGND.t870 VGND.t1437 sg13_lv_nmos ad=0.1406p pd=1.12u as=0.1406p ps=1.12u w=0.74u l=0.13u
X936 sg13cmos5l_buf_16_18.A a_4174_13728# VGND.t891 VGND.t1449 sg13_lv_nmos ad=0.1406p pd=1.12u as=0.1406p ps=1.12u w=0.74u l=0.13u
X937 VGND.t351 a_4462_5410# sg13cmos5l_buf_16_11.A VGND.t422 sg13_lv_nmos ad=0.1406p pd=1.12u as=0.1406p ps=1.12u w=0.74u l=0.13u
X938 VPWR.t1194 a_6094_10704# sg13cmos5l_buf_16_24.A VPWR.t2 sg13_lv_pmos ad=0.2128p pd=1.5u as=0.2128p ps=1.5u w=1.12u l=0.13u
X939 a_3875_5396# sg13cmos5l_and2_2_0.B VPWR.t1269 VPWR.t61 sg13_lv_pmos ad=0.1596p pd=1.22u as=0.1918p ps=1.5u w=0.84u l=0.13u
X940 VPWR.t126 VGND.t1292 VPWR.t126 VPWR.t55 sg13_lv_pmos ad=0.19p pd=1.38u as=0 ps=0 w=1u l=1u
X941 sg13cmos5l_and2_2_6.A a_3694_10704# VPWR.t1200 VPWR.t2 sg13_lv_pmos ad=0.2128p pd=1.5u as=0.2128p ps=1.5u w=1.12u l=0.13u
X942 VPWR.t1575 sg13cmos5l_buf_16_11.A a_3668_4620# VPWR.t64 sg13_lv_pmos ad=0.2128p pd=1.5u as=0.2128p ps=1.5u w=1.12u l=0.13u
X943 sg13cmos5l_buf_16_33.A a_3694_14482# VGND.t870 VGND.t879 sg13_lv_nmos ad=0.1406p pd=1.12u as=0.1406p ps=1.12u w=0.74u l=0.13u
X944 VPWR.t28 VGND.t1061 VPWR.t28 VPWR.t2 sg13_lv_pmos ad=0.34p pd=2.68u as=0 ps=0 w=1u l=1u
X945 VPWR.t156 VGND.t1351 VPWR.t156 VPWR.t55 sg13_lv_pmos ad=0.19p pd=1.38u as=0 ps=0 w=1u l=1u
X946 sg13cmos5l_buf_16_37.X a_7796_12934# VPWR.t1153 VPWR.t79 sg13_lv_pmos ad=0.2128p pd=1.5u as=0.2128p ps=1.5u w=1.12u l=0.13u
X947 VGND.t837 a_5710_1632# sg13cmos5l_buf_16_5.A VGND.t855 sg13_lv_nmos ad=0.1406p pd=1.12u as=0.1406p ps=1.12u w=0.74u l=0.13u
X948 VGND.t1196 VPWR.t1623 VGND.t1196 VGND.t1197 sg13_lv_nmos ad=79.8f pd=0.8u as=0 ps=0 w=0.42u l=1u
X949 VGND.t1165 VPWR.t62 VGND.t1162 VGND.t1189 sg13_lv_nmos ad=0.1428p pd=1.52u as=0 ps=0 w=0.42u l=1u
X950 VGND.t204 VPWR.t0 VGND.t204 VGND.t918 sg13_lv_nmos ad=0.1428p pd=1.52u as=0 ps=0 w=0.42u l=1u
X951 VPWR.t335 a_9262_7680# sg13cmos5l_buf_16_2.A VPWR.t58 sg13_lv_pmos ad=0.2128p pd=1.5u as=0.2128p ps=1.5u w=1.12u l=0.13u
X952 VPWR.t1176 sg13cmos5l_buf_16_20.A a_4436_9910# VPWR.t2 sg13_lv_pmos ad=0.2128p pd=1.5u as=0.2128p ps=1.5u w=1.12u l=0.13u
X953 VGND.t351 a_6094_4656# sg13cmos5l_buf_16_31.X VGND.t352 sg13_lv_nmos ad=0.1406p pd=1.12u as=0.1406p ps=1.12u w=0.74u l=0.13u
X954 a_4174_13728# sg13cmos5l_and2_2_1.X VGND.t870 VGND.t1472 sg13_lv_nmos ad=0.1406p pd=1.12u as=0.1406p ps=1.12u w=0.74u l=0.13u
X955 VPWR.t1018 VGND.t989 VPWR.t1017 VPWR.t8 sg13_lv_pmos ad=0.34p pd=2.68u as=0 ps=0 w=1u l=1u
X956 VGND.t444 VPWR.t1680 VGND.t948 VGND.t949 sg13_lv_nmos ad=0.1428p pd=1.52u as=0 ps=0 w=0.42u l=1u
X957 VGND.t726 VPWR.t16 VGND.t726 VGND.t2 sg13_lv_nmos ad=79.8f pd=0.8u as=0 ps=0 w=0.42u l=1u
X958 a_3694_8434# sg13cmos5l_buf_16_13.A VGND.t18 VGND.t20 sg13_lv_nmos ad=0.1406p pd=1.12u as=0.1406p ps=1.12u w=0.74u l=0.13u
X959 VPWR.t28 VGND.t726 VPWR.t28 VPWR.t2 sg13_lv_pmos ad=0.19p pd=1.38u as=0 ps=0 w=1u l=1u
X960 sg13cmos5l_buf_16_35.A a_6766_8434# VGND.t5 VGND.t297 sg13_lv_nmos ad=0.1406p pd=1.12u as=0.1406p ps=1.12u w=0.74u l=0.13u
X961 sg13cmos5l_buf_16_0.A a_6094_3898# VPWR.t739 VPWR.t64 sg13_lv_pmos ad=0.2128p pd=1.5u as=0.2128p ps=1.5u w=1.12u l=0.13u
X962 VGND.t214 sg13cmos5l_buf_16_4.A a_9524_6886# VGND.t216 sg13_lv_nmos ad=0.2516p pd=2.16u as=0.1406p ps=1.12u w=0.74u l=0.13u
X963 sg13cmos5l_buf_16_2.A a_9262_7680# VPWR.t335 VPWR.t58 sg13_lv_pmos ad=0.2128p pd=1.5u as=0.2128p ps=1.5u w=1.12u l=0.13u
X964 VGND.t134 a_3694_10704# sg13cmos5l_and2_2_6.A VGND.t2 sg13_lv_nmos ad=0.1406p pd=1.12u as=0.1406p ps=1.12u w=0.74u l=0.13u
X965 VPWR.t113 VGND.t302 VPWR.t216 VPWR.t67 sg13_lv_pmos ad=0.34p pd=2.68u as=0 ps=0 w=1u l=1u
X966 a_6094_4656# sg13cmos5l_buf_16_7.X VGND.t351 VGND.t435 sg13_lv_nmos ad=0.1406p pd=1.12u as=0.1406p ps=1.12u w=0.74u l=0.13u
X967 a_3694_14482# sg13cmos5l_buf_16_15.X VGND.t870 VGND.t874 sg13_lv_nmos ad=0.1406p pd=1.12u as=0.1406p ps=1.12u w=0.74u l=0.13u
X968 VPWR.t20 VGND.t590 VPWR.t16 VPWR.t8 sg13_lv_pmos ad=0.34p pd=2.68u as=0 ps=0 w=1u l=1u
X969 sg13cmos5l_buf_16_37.X a_7796_12934# VPWR.t1149 VPWR.t79 sg13_lv_pmos ad=0.2128p pd=1.5u as=0.2128p ps=1.5u w=1.12u l=0.13u
X970 VGND.t1408 VPWR.t63 VGND.t1410 VGND.t1409 sg13_lv_nmos ad=79.8f pd=0.8u as=0 ps=0 w=0.42u l=1u
X971 VPWR.t1291 a_3668_4620# sg13cmos5l_buf_16_8.A VPWR.t64 sg13_lv_pmos ad=0.2128p pd=1.5u as=0.2128p ps=1.5u w=1.12u l=0.13u
X972 sg13cmos5l_buf_16_11.A a_4462_5410# VPWR.t792 VPWR.t61 sg13_lv_pmos ad=0.2128p pd=1.5u as=0.2128p ps=1.5u w=1.12u l=0.13u
X973 sg13cmos5l_buf_16_24.X a_6862_9946# VGND.t157 VGND.t164 sg13_lv_nmos ad=0.1406p pd=1.12u as=0.1406p ps=1.12u w=0.74u l=0.13u
X974 a_8494_3144# sg13cmos5l_buf_16_0.A VGND.t96 VGND.t40 sg13_lv_nmos ad=0.1406p pd=1.12u as=0.1406p ps=1.12u w=0.74u l=0.13u
X975 VPWR.t62 sg13cmos5l_buf_1_5.A a_13768_5444# VPWR.t61 sg13_lv_pmos ad=0.2114p pd=1.54u as=0.2856p ps=2.36u w=0.84u l=0.13u
X976 VGND.t1147 VPWR.t1638 VGND.t218 VGND.t1153 sg13_lv_nmos ad=79.8f pd=0.8u as=0 ps=0 w=0.42u l=1u
X977 VPWR.t393 VGND.t5 VPWR.t392 VPWR.t58 sg13_lv_pmos ad=0.34p pd=2.68u as=0 ps=0 w=1u l=1u
X978 VGND.t5 a_6766_8434# sg13cmos5l_buf_16_35.A VGND.t294 sg13_lv_nmos ad=0.1406p pd=1.12u as=0.1406p ps=1.12u w=0.74u l=0.13u
X979 VPWR.t1426 enable a_6094_3898# VPWR.t64 sg13_lv_pmos ad=0.2128p pd=1.5u as=0.2128p ps=1.5u w=1.12u l=0.13u
X980 sg13cmos5l_and2_2_2.B a_5992_14516# VGND.t891 VGND.t1495 sg13_lv_nmos ad=0.2886p pd=2.26u as=0.14875p ps=1.16u w=0.74u l=0.13u
X981 VPWR.t131 VGND.t513 VPWR.t131 VPWR.t8 sg13_lv_pmos ad=0.34p pd=2.68u as=0 ps=0 w=1u l=1u
X982 VPWR.t335 a_9262_7680# sg13cmos5l_buf_16_2.A VPWR.t58 sg13_lv_pmos ad=0.2128p pd=1.5u as=0.2128p ps=1.5u w=1.12u l=0.13u
X983 a_4174_13728# sg13cmos5l_and2_2_1.X VGND.t870 VGND.t1468 sg13_lv_nmos ad=0.1406p pd=1.12u as=0.2516p ps=2.16u w=0.74u l=0.13u
X984 VGND.t837 sg13cmos5l_buf_16_30.A a_5710_1632# VGND.t839 sg13_lv_nmos ad=0.1406p pd=1.12u as=0.1406p ps=1.12u w=0.74u l=0.13u
X985 VGND.t25 sg13cmos5l_buf_16_39.A a_6164_2350# VGND.t28 sg13_lv_nmos ad=0.1406p pd=1.12u as=0.1406p ps=1.12u w=0.74u l=0.13u
X986 VGND.t797 VPWR.t1620 VGND.t1196 VGND.t1202 sg13_lv_nmos ad=0.1428p pd=1.52u as=0 ps=0 w=0.42u l=1u
X987 VGND.t7 a_5684_6132# sg13cmos5l_buf_16_28.X VGND.t233 sg13_lv_nmos ad=0.1406p pd=1.12u as=0.1406p ps=1.12u w=0.74u l=0.13u
X988 a_5108_838# sg13cmos5l_buf_16_5.A VGND.t845 VGND.t849 sg13_lv_nmos ad=0.1406p pd=1.12u as=0.1406p ps=1.12u w=0.74u l=0.13u
X989 a_10292_12934# sg13cmos5l_buf_1_17.A VPWR.t566 VPWR.t79 sg13_lv_pmos ad=0.2128p pd=1.5u as=0.2128p ps=1.5u w=1.12u l=0.13u
X990 a_6094_3144# sg13cmos5l_buf_16_5.X VPWR.t475 VPWR.t67 sg13_lv_pmos ad=0.2128p pd=1.5u as=0.2128p ps=1.5u w=1.12u l=0.13u
X991 sg13cmos5l_buf_16_35.A a_6766_8434# VGND.t5 VGND.t291 sg13_lv_nmos ad=0.1406p pd=1.12u as=0.1406p ps=1.12u w=0.74u l=0.13u
X992 VGND.t134 a_3694_10704# sg13cmos5l_and2_2_6.A VGND.t2 sg13_lv_nmos ad=0.1406p pd=1.12u as=0.1406p ps=1.12u w=0.74u l=0.13u
X993 a_6094_3898# enable VPWR.t1423 VPWR.t64 sg13_lv_pmos ad=0.2128p pd=1.5u as=0.3808p ps=2.92u w=1.12u l=0.13u
X994 VGND.t845 a_5108_838# sg13cmos5l_buf_16_5.X VGND.t1467 sg13_lv_nmos ad=0.1406p pd=1.12u as=0.1406p ps=1.12u w=0.74u l=0.13u
X995 a_6548_13692# sg13cmos5l_buf_16_37.X VPWR.t1438 VPWR.t79 sg13_lv_pmos ad=0.2128p pd=1.5u as=0.2128p ps=1.5u w=1.12u l=0.13u
X996 VGND.t181 a_10318_5410# sg13cmos5l_buf_16_1.X VGND.t183 sg13_lv_nmos ad=0.2516p pd=2.16u as=0.1406p ps=1.12u w=0.74u l=0.13u
X997 VPWR.t421 sg13cmos5l_buf_16_13.A a_3694_8434# VPWR.t5 sg13_lv_pmos ad=0.2128p pd=1.5u as=0.2128p ps=1.5u w=1.12u l=0.13u
X998 VGND.t637 sg13cmos5l_buf_1_5.X a_14824_5444# VGND.t636 sg13_lv_nmos ad=0.14875p pd=1.16u as=0.187p ps=1.78u w=0.55u l=0.13u
X999 VPWR.t881 VGND.t532 VPWR.t62 VPWR.t61 sg13_lv_pmos ad=0.34p pd=2.68u as=0 ps=0 w=1u l=1u
X1000 VPWR.t1551 a_6164_2350# sg13cmos5l_buf_16_30.A VPWR.t67 sg13_lv_pmos ad=0.2128p pd=1.5u as=0.2128p ps=1.5u w=1.12u l=0.13u
X1001 VGND.t1141 VPWR.t1641 VGND.t1147 VGND.t1146 sg13_lv_nmos ad=79.8f pd=0.8u as=0 ps=0 w=0.42u l=1u
X1002 VPWR.t146 a_6766_8434# sg13cmos5l_buf_16_35.A VPWR.t5 sg13_lv_pmos ad=0.3976p pd=2.95u as=0.2128p ps=1.5u w=1.12u l=0.13u
X1003 sg13cmos5l_buf_16_28.X a_5684_6132# VPWR.t586 VPWR.t61 sg13_lv_pmos ad=0.2128p pd=1.5u as=0.2128p ps=1.5u w=1.12u l=0.13u
X1004 VGND.t35 sg13cmos5l_xor2_1_5.X a_14344_8468# VGND.t765 sg13_lv_nmos ad=0.14875p pd=1.16u as=0.187p ps=1.78u w=0.55u l=0.13u
X1005 VGND.t1147 VPWR.t1630 VGND.t1147 VGND.t1151 sg13_lv_nmos ad=79.8f pd=0.8u as=0 ps=0 w=0.42u l=1u
X1006 sg13cmos5l_buf_16_1.X a_10318_5410# VGND.t86 VGND.t179 sg13_lv_nmos ad=0.1406p pd=1.12u as=0.1406p ps=1.12u w=0.74u l=0.13u
X1007 a_3694_8434# sg13cmos5l_buf_16_13.A VPWR.t418 VPWR.t5 sg13_lv_pmos ad=0.2128p pd=1.5u as=0.3808p ps=2.92u w=1.12u l=0.13u
X1008 VGND.t122 a_3694_3898# sg13cmos5l_buf_16_10.A VGND.t40 sg13_lv_nmos ad=0.1406p pd=1.12u as=0.1406p ps=1.12u w=0.74u l=0.13u
X1009 VPWR.t335 a_9524_6886# sg13cmos5l_buf_16_4.X VPWR.t58 sg13_lv_pmos ad=0.2128p pd=1.5u as=0.2128p ps=1.5u w=1.12u l=0.13u
X1010 VGND.t18 sg13cmos5l_buf_16_34.A a_3694_7680# VGND.t19 sg13_lv_nmos ad=0.1406p pd=1.12u as=0.1406p ps=1.12u w=0.74u l=0.13u
X1011 sg13cmos5l_buf_16_23.X a_10292_12934# VPWR.t566 VPWR.t79 sg13_lv_pmos ad=0.2128p pd=1.5u as=0.2128p ps=1.5u w=1.12u l=0.13u
X1012 a_3668_9156# sg13cmos5l_buf_16_14.A VPWR.t308 VPWR.t5 sg13_lv_pmos ad=0.2128p pd=1.5u as=0.2128p ps=1.5u w=1.12u l=0.13u
X1013 sg13cmos5l_buf_16_35.A a_6766_8434# VPWR.t146 VPWR.t5 sg13_lv_pmos ad=0.2128p pd=1.5u as=0.2128p ps=1.5u w=1.12u l=0.13u
X1014 VGND.t237 sg13cmos5l_buf_1_17.A a_12232_12216# VGND.t236 sg13_lv_nmos ad=0.14875p pd=1.16u as=0.187p ps=1.78u w=0.55u l=0.13u
X1015 a_5108_838# sg13cmos5l_buf_16_5.A VPWR.t56 VPWR.t55 sg13_lv_pmos ad=0.2128p pd=1.5u as=0.2128p ps=1.5u w=1.12u l=0.13u
X1016 sg13cmos5l_buf_16_27.X a_6548_13692# VPWR.t1404 VPWR.t79 sg13_lv_pmos ad=0.2128p pd=1.5u as=0.2128p ps=1.5u w=1.12u l=0.13u
X1017 VGND.t171 a_7220_5374# sg13cmos5l_buf_16_28.A VGND.t343 sg13_lv_nmos ad=0.1406p pd=1.12u as=0.1406p ps=1.12u w=0.74u l=0.13u
X1018 VGND.t218 sg13cmos5l_buf_16_31.X a_4721_6526# VGND.t1510 sg13_lv_nmos ad=0.15245p pd=1.17u as=0.17462p ps=1.185u w=0.55u l=0.13u
X1019 VPWR.t96 VGND.t214 VPWR.t96 VPWR.t61 sg13_lv_pmos ad=0.34p pd=2.68u as=0 ps=0 w=1u l=1u
X1020 VPWR.t497 a_5204_11422# sg13cmos5l_buf_16_20.A VPWR.t8 sg13_lv_pmos ad=0.2128p pd=1.5u as=0.2128p ps=1.5u w=1.12u l=0.13u
X1021 VGND.t125 a_6094_3898# sg13cmos5l_buf_16_0.A VGND.t40 sg13_lv_nmos ad=0.1406p pd=1.12u as=0.1406p ps=1.12u w=0.74u l=0.13u
X1022 VPWR.t62 VGND.t637 VPWR.t62 VPWR.t61 sg13_lv_pmos ad=0.34p pd=2.68u as=0 ps=0 w=1u l=1u
X1023 VGND.t1061 VPWR.t146 VGND.t1061 VGND.t1062 sg13_lv_nmos ad=79.8f pd=0.8u as=0 ps=0 w=0.42u l=1u
X1024 sg13cmos5l_buf_16_10.A a_3694_3898# VGND.t122 VGND.t40 sg13_lv_nmos ad=0.1406p pd=1.12u as=0.1406p ps=1.12u w=0.74u l=0.13u
X1025 VGND.t157 a_6836_9156# sg13cmos5l_buf_16_25.A VGND.t163 sg13_lv_nmos ad=0.1406p pd=1.12u as=0.1406p ps=1.12u w=0.74u l=0.13u
X1026 VPWR.t986 VGND.t31 VPWR.t986 VPWR.t55 sg13_lv_pmos ad=0.34p pd=2.68u as=0 ps=0 w=1u l=1u
X1027 sg13cmos5l_buf_16_4.X a_9524_6886# VPWR.t335 VPWR.t58 sg13_lv_pmos ad=0.2128p pd=1.5u as=0.2128p ps=1.5u w=1.12u l=0.13u
X1028 a_10292_4620# sg13cmos5l_buf_16_2.X VPWR.t143 VPWR.t64 sg13_lv_pmos ad=0.2128p pd=1.5u as=0.2128p ps=1.5u w=1.12u l=0.13u
X1029 a_10318_8434# sg13cmos5l_buf_16_1.X VGND.t5 VGND.t1522 sg13_lv_nmos ad=0.1406p pd=1.12u as=0.1406p ps=1.12u w=0.74u l=0.13u
X1030 VPWR.t980 VGND.t895 VPWR.t199 VPWR.t0 sg13_lv_pmos ad=0.34p pd=2.68u as=0 ps=0 w=1u l=1u
X1031 sg13cmos5l_buf_16_5.A a_5710_1632# VPWR.t56 VPWR.t55 sg13_lv_pmos ad=0.2128p pd=1.5u as=0.2128p ps=1.5u w=1.12u l=0.13u
X1032 VPWR.t126 VGND.t1286 VPWR.t250 VPWR.t55 sg13_lv_pmos ad=0.19p pd=1.38u as=0 ps=0 w=1u l=1u
X1033 VPWR.t56 a_5108_838# sg13cmos5l_buf_16_5.X VPWR.t55 sg13_lv_pmos ad=0.2128p pd=1.5u as=0.2128p ps=1.5u w=1.12u l=0.13u
X1034 sg13cmos5l_buf_16_28.A a_7220_5374# VGND.t171 VGND.t340 sg13_lv_nmos ad=0.1406p pd=1.12u as=0.1406p ps=1.12u w=0.74u l=0.13u
X1035 sg13cmos5l_buf_16_28.X a_5684_6132# VPWR.t582 VPWR.t61 sg13_lv_pmos ad=0.2128p pd=1.5u as=0.2128p ps=1.5u w=1.12u l=0.13u
X1036 VGND.t5 a_9262_7680# sg13cmos5l_buf_16_2.A VGND.t115 sg13_lv_nmos ad=0.2516p pd=2.16u as=0.1406p ps=1.12u w=0.74u l=0.13u
X1037 VGND.t1393 VPWR.t126 VGND.t1392 VGND.t1391 sg13_lv_nmos ad=0.1428p pd=1.52u as=0 ps=0 w=0.42u l=1u
X1038 VPWR.t113 VGND.t41 VPWR.t113 VPWR.t67 sg13_lv_pmos ad=0.34p pd=2.68u as=0 ps=0 w=1u l=1u
X1039 sg13cmos5l_buf_16_23.X a_10292_12934# VPWR.t566 VPWR.t79 sg13_lv_pmos ad=0.2128p pd=1.5u as=0.2128p ps=1.5u w=1.12u l=0.13u
X1040 VGND.t851 sg13cmos5l_buf_16_5.A a_5108_838# VGND.t850 sg13_lv_nmos ad=0.2516p pd=2.16u as=0.1406p ps=1.12u w=0.74u l=0.13u
X1041 VPWR.t816 a_3668_12180# sg13cmos5l_buf_16_15.X VPWR.t8 sg13_lv_pmos ad=0.2128p pd=1.5u as=0.2128p ps=1.5u w=1.12u l=0.13u
X1042 VPWR.t828 a_3668_12180# sg13cmos5l_buf_16_15.X VPWR.t8 sg13_lv_pmos ad=0.2128p pd=1.5u as=0.2128p ps=1.5u w=1.12u l=0.13u
X1043 sg13cmos5l_buf_16_25.A a_6836_9156# VGND.t157 VGND.t160 sg13_lv_nmos ad=0.1406p pd=1.12u as=0.1406p ps=1.12u w=0.74u l=0.13u
X1044 VPWR.t143 sg13cmos5l_buf_16_2.X a_10292_4620# VPWR.t64 sg13_lv_pmos ad=0.2128p pd=1.5u as=0.2128p ps=1.5u w=1.12u l=0.13u
X1045 VPWR.t226 VGND.t843 VPWR.t63 VPWR.t55 sg13_lv_pmos ad=0.34p pd=2.68u as=0 ps=0 w=1u l=1u
X1046 VPWR.t61 a_7220_5374# sg13cmos5l_buf_16_28.A VPWR.t61 sg13_lv_pmos ad=0.2128p pd=1.5u as=0.2128p ps=1.5u w=1.12u l=0.13u
X1047 VGND.t676 VPWR.t128 VGND.t237 VGND.t981 sg13_lv_nmos ad=79.8f pd=0.8u as=0 ps=0 w=0.42u l=1u
X1048 VGND.t157 sg13cmos5l_buf_16_24.A a_6862_9946# VGND.t156 sg13_lv_nmos ad=0.1406p pd=1.12u as=0.1406p ps=1.12u w=0.74u l=0.13u
X1049 a_3020_14442# glitch_en[1] VPWR.t1300 VPWR.t0 sg13_lv_pmos ad=0.2856p pd=2.36u as=0.2114p ps=1.54u w=0.84u l=0.13u
X1050 VPWR.t493 a_5204_11422# sg13cmos5l_buf_16_20.A VPWR.t8 sg13_lv_pmos ad=0.2128p pd=1.5u as=0.2128p ps=1.5u w=1.12u l=0.13u
X1051 sg13cmos5l_buf_16_24.X a_6862_9946# VPWR.t832 VPWR.t2 sg13_lv_pmos ad=0.2128p pd=1.5u as=0.2128p ps=1.5u w=1.12u l=0.13u
X1052 VGND.t1061 VPWR.t430 VGND.t1061 VGND.t1068 sg13_lv_nmos ad=79.8f pd=0.8u as=0 ps=0 w=0.42u l=1u
X1053 a_5108_838# sg13cmos5l_buf_16_5.A VGND.t845 VGND.t844 sg13_lv_nmos ad=0.1406p pd=1.12u as=0.1406p ps=1.12u w=0.74u l=0.13u
X1054 sg13cmos5l_buf_16_5.X a_5108_838# VPWR.t56 VPWR.t55 sg13_lv_pmos ad=0.2128p pd=1.5u as=0.2128p ps=1.5u w=1.12u l=0.13u
X1055 sg13cmos5l_buf_16_38.A a_8110_6168# VGND.t7 VGND.t776 sg13_lv_nmos ad=0.1406p pd=1.12u as=0.1406p ps=1.12u w=0.74u l=0.13u
X1056 VPWR.t299 VGND.t260 VPWR.t298 VPWR.t5 sg13_lv_pmos ad=0.19p pd=1.38u as=0 ps=0 w=1u l=1u
X1057 VGND.t41 sg13cmos5l_buf_1_6.A a_13768_3932# VGND.t40 sg13_lv_nmos ad=0.14875p pd=1.16u as=0.187p ps=1.78u w=0.55u l=0.13u
X1058 VGND.t5 VPWR.t1655 VGND.t5 VGND.t1100 sg13_lv_nmos ad=0.1428p pd=1.52u as=0 ps=0 w=0.42u l=1u
X1059 sg13cmos5l_buf_16_28.A a_7220_5374# VPWR.t717 VPWR.t61 sg13_lv_pmos ad=0.2128p pd=1.5u as=0.2128p ps=1.5u w=1.12u l=0.13u
X1060 sg13cmos5l_buf_16_20.A a_5204_11422# VGND.t139 VGND.t2 sg13_lv_nmos ad=0.1406p pd=1.12u as=0.1406p ps=1.12u w=0.74u l=0.13u
X1061 VPWR.t91 VGND.t214 VPWR.t93 VPWR.t58 sg13_lv_pmos ad=0.34p pd=2.68u as=0 ps=0 w=1u l=1u
X1062 a_10318_8434# sg13cmos5l_buf_16_1.X VGND.t103 VGND.t1518 sg13_lv_nmos ad=0.1406p pd=1.12u as=0.2516p ps=2.16u w=0.74u l=0.13u
X1063 VGND.t1413 VPWR.t63 VGND.t1415 VGND.t1414 sg13_lv_nmos ad=79.8f pd=0.8u as=0 ps=0 w=0.42u l=1u
X1064 VGND.t66 sg13cmos5l_and2_2_6.A a_6161_9550# VGND.t418 sg13_lv_nmos ad=0.15245p pd=1.17u as=0.17462p ps=1.185u w=0.55u l=0.13u
X1065 VPWR.t55 VGND.t1341 VPWR.t55 VPWR.t55 sg13_lv_pmos ad=0.19p pd=1.38u as=0 ps=0 w=1u l=1u
X1066 VPWR.t440 sg13cmos5l_buf_16_1.X a_10318_8434# VPWR.t5 sg13_lv_pmos ad=0.2128p pd=1.5u as=0.2128p ps=1.5u w=1.12u l=0.13u
X1067 VGND.t1388 VPWR.t126 VGND.t1387 VGND.t1386 sg13_lv_nmos ad=0.1428p pd=1.52u as=0 ps=0 w=0.42u l=1u
X1068 VPWR.t239 sg13cmos5l_buf_1_1.A a_14824_3144# VPWR.t67 sg13_lv_pmos ad=0.2114p pd=1.54u as=0.2856p ps=2.36u w=0.84u l=0.13u
X1069 VGND.t1147 VPWR.t1640 VGND.t1147 VGND.t1149 sg13_lv_nmos ad=79.8f pd=0.8u as=0 ps=0 w=0.42u l=1u
X1070 a_3668_9156# sg13cmos5l_buf_16_14.A VPWR.t305 VPWR.t5 sg13_lv_pmos ad=0.2128p pd=1.5u as=0.2128p ps=1.5u w=1.12u l=0.13u
X1071 VPWR.t715 a_7220_5374# sg13cmos5l_buf_16_28.A VPWR.t61 sg13_lv_pmos ad=0.2128p pd=1.5u as=0.2128p ps=1.5u w=1.12u l=0.13u
X1072 sg13cmos5l_buf_16_24.X a_6862_9946# VPWR.t634 VPWR.t2 sg13_lv_pmos ad=0.2128p pd=1.5u as=0.2128p ps=1.5u w=1.12u l=0.13u
X1073 sg13cmos5l_buf_16_11.A a_4462_5410# VGND.t351 VGND.t435 sg13_lv_nmos ad=0.1406p pd=1.12u as=0.1406p ps=1.12u w=0.74u l=0.13u
X1074 VGND.t206 VPWR.t75 VGND.t206 VGND.t920 sg13_lv_nmos ad=0.1428p pd=1.52u as=0 ps=0 w=0.42u l=1u
X1075 VGND.t122 a_3668_3108# sg13cmos5l_buf_16_7.A VGND.t40 sg13_lv_nmos ad=0.1406p pd=1.12u as=0.1406p ps=1.12u w=0.74u l=0.13u
X1076 a_8110_6168# sg13cmos5l_buf_16_35.A VGND.t7 VGND.t12 sg13_lv_nmos ad=0.1406p pd=1.12u as=0.1406p ps=1.12u w=0.74u l=0.13u
X1077 VPWR.t216 sg13cmos5l_buf_16_39.A a_8990_2704# VPWR.t67 sg13_lv_pmos ad=0.36p pd=2.72u as=0.1225p ps=1.245u w=1u l=0.13u
X1078 VGND.t41 a_10318_3898# sg13cmos5l_buf_16_2.X VGND.t40 sg13_lv_nmos ad=0.1406p pd=1.12u as=0.1406p ps=1.12u w=0.74u l=0.13u
X1079 VPWR.t1354 sg13cmos5l_buf_16_33.A a_6094_10704# VPWR.t2 sg13_lv_pmos ad=0.2128p pd=1.5u as=0.2128p ps=1.5u w=1.12u l=0.13u
X1080 VGND.t42 VPWR.t411 VGND.t42 VGND.t40 sg13_lv_nmos ad=0.1428p pd=1.52u as=0 ps=0 w=0.42u l=1u
X1081 sg13cmos5l_buf_16_10.A a_3694_3898# VGND.t310 VGND.t40 sg13_lv_nmos ad=0.1406p pd=1.12u as=0.1406p ps=1.12u w=0.74u l=0.13u
X1082 sg13cmos5l_buf_16_18.A a_4174_13728# VPWR.t1362 VPWR.t79 sg13_lv_pmos ad=0.2128p pd=1.5u as=0.2128p ps=1.5u w=1.12u l=0.13u
X1083 sg13cmos5l_buf_16_18.A a_4174_13728# VPWR.t1374 VPWR.t79 sg13_lv_pmos ad=0.2128p pd=1.5u as=0.2128p ps=1.5u w=1.12u l=0.13u
X1084 a_9788_8728# sg13cmos5l_buf_16_6.X VPWR.t146 VPWR.t5 sg13_lv_pmos ad=0.2128p pd=1.5u as=0.2128p ps=1.5u w=1.12u l=0.13u
X1085 VGND.t198 a_3694_2386# sg13cmos5l_buf_16_7.X VGND.t1578 sg13_lv_nmos ad=0.1406p pd=1.12u as=0.1406p ps=1.12u w=0.74u l=0.13u
X1086 VPWR.t216 a_8494_3144# sg13cmos5l_buf_16_39.A VPWR.t67 sg13_lv_pmos ad=0.2128p pd=1.5u as=0.2128p ps=1.5u w=1.12u l=0.13u
X1087 sg13cmos5l_buf_16_7.X a_3694_2386# VPWR.t1583 VPWR.t67 sg13_lv_pmos ad=0.2128p pd=1.5u as=0.2128p ps=1.5u w=1.12u l=0.13u
X1088 sg13cmos5l_buf_16_5.A a_5710_1632# VPWR.t56 VPWR.t55 sg13_lv_pmos ad=0.2128p pd=1.5u as=0.2128p ps=1.5u w=1.12u l=0.13u
X1089 VGND.t125 a_6094_3144# sg13cmos5l_xor2_1_0.B VGND.t40 sg13_lv_nmos ad=0.1406p pd=1.12u as=0.1406p ps=1.12u w=0.74u l=0.13u
X1090 VPWR.t154 sg13cmos5l_and2_2_6.B a_7629_8028# VPWR.t58 sg13_lv_pmos ad=0.1918p pd=1.5u as=0.1596p ps=1.22u w=0.84u l=0.13u
X1091 VGND.t1274 VPWR.t156 VGND.t1274 VGND.t1277 sg13_lv_nmos ad=79.8f pd=0.8u as=0 ps=0 w=0.42u l=1u
X1092 sg13cmos5l_buf_16_7.A a_3668_3108# VGND.t122 VGND.t40 sg13_lv_nmos ad=0.1406p pd=1.12u as=0.1406p ps=1.12u w=0.74u l=0.13u
X1093 sg13cmos5l_buf_16_31.X a_6094_4656# VPWR.t723 VPWR.t64 sg13_lv_pmos ad=0.2128p pd=1.5u as=0.2128p ps=1.5u w=1.12u l=0.13u
X1094 VGND.t1364 VPWR.t56 VGND.t1366 VGND.t1365 sg13_lv_nmos ad=79.8f pd=0.8u as=0 ps=0 w=0.42u l=1u
X1095 VPWR.t62 VGND.t1162 VPWR.t62 VPWR.t61 sg13_lv_pmos ad=0.34p pd=2.68u as=0 ps=0 w=1u l=1u
X1096 VGND.t7 sg13cmos5l_buf_16_35.A a_8110_6168# VGND.t9 sg13_lv_nmos ad=0.1406p pd=1.12u as=0.1406p ps=1.12u w=0.74u l=0.13u
X1097 sg13cmos5l_buf_16_2.X a_10318_3898# VGND.t41 VGND.t40 sg13_lv_nmos ad=0.1406p pd=1.12u as=0.1406p ps=1.12u w=0.74u l=0.13u
X1098 VPWR.t1029 VGND.t989 VPWR.t1027 VPWR.t2 sg13_lv_pmos ad=0.19p pd=1.38u as=0 ps=0 w=1u l=1u
X1099 sg13cmos5l_buf_16_25.A a_6836_9156# VGND.t66 VGND.t155 sg13_lv_nmos ad=0.1406p pd=1.12u as=0.1406p ps=1.12u w=0.74u l=0.13u
X1100 VGND.t1073 VPWR.t6 VGND.t1073 VGND.t1074 sg13_lv_nmos ad=0.1428p pd=1.52u as=0 ps=0 w=0.42u l=1u
X1101 VPWR.t440 sg13cmos5l_buf_16_1.X a_10318_8434# VPWR.t5 sg13_lv_pmos ad=0.2128p pd=1.5u as=0.2128p ps=1.5u w=1.12u l=0.13u
X1102 VPWR.t99 VGND.t1353 VPWR.t99 VPWR.t55 sg13_lv_pmos ad=0.34p pd=2.68u as=0 ps=0 w=1u l=1u
X1103 a_3668_12180# sg13cmos5l_buf_16_15.A VPWR.t1163 VPWR.t8 sg13_lv_pmos ad=0.2128p pd=1.5u as=0.2128p ps=1.5u w=1.12u l=0.13u
X1104 VPWR.t1581 a_3694_2386# sg13cmos5l_buf_16_7.X VPWR.t67 sg13_lv_pmos ad=0.2128p pd=1.5u as=0.2128p ps=1.5u w=1.12u l=0.13u
X1105 VGND.t1298 VPWR.t63 VGND.t1298 VGND.t1333 sg13_lv_nmos ad=0.1428p pd=1.52u as=0 ps=0 w=0.42u l=1u
X1106 VGND.t1141 VPWR.t1632 VGND.t1147 VGND.t1146 sg13_lv_nmos ad=79.8f pd=0.8u as=0 ps=0 w=0.42u l=1u
X1107 VPWR.t1273 sg13cmos5l_buf_16_7.X a_6094_4656# VPWR.t64 sg13_lv_pmos ad=0.2128p pd=1.5u as=0.2128p ps=1.5u w=1.12u l=0.13u
X1108 VPWR.t915 a_5518_6922# sg13cmos5l_buf_16_6.X VPWR.t58 sg13_lv_pmos ad=0.2128p pd=1.5u as=0.2128p ps=1.5u w=1.12u l=0.13u
X1109 VGND.t891 a_4174_13728# sg13cmos5l_buf_16_18.A VGND.t1450 sg13_lv_nmos ad=0.2516p pd=2.16u as=0.1406p ps=1.12u w=0.74u l=0.13u
X1110 a_4174_13728# sg13cmos5l_and2_2_1.X VPWR.t1397 VPWR.t79 sg13_lv_pmos ad=0.2128p pd=1.5u as=0.2128p ps=1.5u w=1.12u l=0.13u
X1111 VPWR.t806 a_4462_5410# sg13cmos5l_buf_16_11.A VPWR.t61 sg13_lv_pmos ad=0.3976p pd=2.95u as=0.2128p ps=1.5u w=1.12u l=0.13u
X1112 VGND.t444 VPWR.t1687 VGND.t444 VGND.t950 sg13_lv_nmos ad=79.8f pd=0.8u as=0 ps=0 w=0.42u l=1u
X1113 VGND.t989 VPWR.t1667 VGND.t989 VGND.t2 sg13_lv_nmos ad=0.1428p pd=1.52u as=0 ps=0 w=0.42u l=1u
X1114 VGND.t1196 VPWR.t1627 VGND.t1196 VGND.t1198 sg13_lv_nmos ad=0.1428p pd=1.52u as=0 ps=0 w=0.42u l=1u
X1115 VGND.t198 a_3694_2386# sg13cmos5l_buf_16_7.X VGND.t1574 sg13_lv_nmos ad=0.1406p pd=1.12u as=0.1406p ps=1.12u w=0.74u l=0.13u
X1116 VPWR.t600 VGND.t1141 VPWR.t598 VPWR.t58 sg13_lv_pmos ad=0.19p pd=1.38u as=0 ps=0 w=1u l=1u
X1117 VPWR.t1202 a_3694_10704# sg13cmos5l_and2_2_6.A VPWR.t2 sg13_lv_pmos ad=0.2128p pd=1.5u as=0.2128p ps=1.5u w=1.12u l=0.13u
X1118 a_5710_1632# sg13cmos5l_buf_16_30.A VPWR.t56 VPWR.t55 sg13_lv_pmos ad=0.2128p pd=1.5u as=0.2128p ps=1.5u w=1.12u l=0.13u
X1119 VGND.t42 sg13cmos5l_buf_1_1.A a_14824_3144# VGND.t40 sg13_lv_nmos ad=0.14875p pd=1.16u as=0.187p ps=1.78u w=0.55u l=0.13u
X1120 VGND.t1141 VPWR.t1643 VGND.t1141 VGND.t1142 sg13_lv_nmos ad=79.8f pd=0.8u as=0 ps=0 w=0.42u l=1u
X1121 VPWR.t1022 VGND.t989 VPWR.t1021 VPWR.t8 sg13_lv_pmos ad=0.34p pd=2.68u as=0 ps=0 w=1u l=1u
X1122 a_6094_4656# sg13cmos5l_buf_16_7.X VPWR.t1270 VPWR.t64 sg13_lv_pmos ad=0.2128p pd=1.5u as=0.3808p ps=2.92u w=1.12u l=0.13u
X1123 VGND.t726 VPWR.t1670 VGND.t726 VGND.t2 sg13_lv_nmos ad=0.1428p pd=1.52u as=0 ps=0 w=0.42u l=1u
X1124 VGND.t637 VPWR.t62 VGND.t637 VGND.t1211 sg13_lv_nmos ad=0.1428p pd=1.52u as=0 ps=0 w=0.42u l=1u
X1125 VPWR.t64 VGND.t76 VPWR.t64 VPWR.t64 sg13_lv_pmos ad=0.19p pd=1.38u as=0 ps=0 w=1u l=1u
X1126 sg13cmos5l_buf_16_13.A a_3668_9156# VGND.t260 VGND.t262 sg13_lv_nmos ad=0.1406p pd=1.12u as=0.1406p ps=1.12u w=0.74u l=0.13u
X1127 VPWR.t765 a_6094_3144# sg13cmos5l_xor2_1_0.B VPWR.t67 sg13_lv_pmos ad=0.2128p pd=1.5u as=0.2128p ps=1.5u w=1.12u l=0.13u
X1128 VPWR.t131 VGND.t237 VPWR.t129 VPWR.t8 sg13_lv_pmos ad=0.34p pd=2.68u as=0 ps=0 w=1u l=1u
X1129 sg13cmos5l_buf_16_37.X a_7796_12934# VGND.t590 VGND.t694 sg13_lv_nmos ad=0.1406p pd=1.12u as=0.1406p ps=1.12u w=0.74u l=0.13u
X1130 VPWR.t59 VGND.t1165 VPWR.t59 VPWR.t58 sg13_lv_pmos ad=0.34p pd=2.68u as=0 ps=0 w=1u l=1u
X1131 VGND.t171 a_6094_4656# sg13cmos5l_buf_16_31.X VGND.t362 sg13_lv_nmos ad=0.1406p pd=1.12u as=0.1406p ps=1.12u w=0.74u l=0.13u
X1132 VGND.t601 sg13cmos5l_buf_16_23.X a_8948_13692# VGND.t600 sg13_lv_nmos ad=0.1406p pd=1.12u as=0.1406p ps=1.12u w=0.74u l=0.13u
X1133 a_4174_13728# sg13cmos5l_and2_2_1.X VPWR.t1394 VPWR.t79 sg13_lv_pmos ad=0.2128p pd=1.5u as=0.3808p ps=2.92u w=1.12u l=0.13u
X1134 VGND.t590 a_10292_12934# sg13cmos5l_buf_16_23.X VGND.t665 sg13_lv_nmos ad=0.1406p pd=1.12u as=0.1406p ps=1.12u w=0.74u l=0.13u
X1135 VPWR.t0 VGND.t597 VPWR.t0 VPWR.t0 sg13_lv_pmos ad=0.34p pd=2.68u as=0 ps=0 w=1u l=1u
X1136 VGND.t870 VPWR.t1691 VGND.t931 VGND.t930 sg13_lv_nmos ad=0.1428p pd=1.52u as=0 ps=0 w=0.42u l=1u
X1137 sg13cmos5l_buf_16_37.A a_8948_13692# VGND.t597 VGND.t654 sg13_lv_nmos ad=0.1406p pd=1.12u as=0.1406p ps=1.12u w=0.74u l=0.13u
X1138 sg13cmos5l_buf_1_22.X a_14344_11492# VPWR.t131 VPWR.t8 sg13_lv_pmos ad=0.42p pd=2.99u as=0.2114p ps=1.54u w=1.12u l=0.13u
X1139 VPWR.t85 VGND.t210 VPWR.t85 VPWR.t61 sg13_lv_pmos ad=0.34p pd=2.68u as=0 ps=0 w=1u l=1u
X1140 sg13cmos5l_buf_16_0.A a_6094_3898# VPWR.t748 VPWR.t64 sg13_lv_pmos ad=0.2128p pd=1.5u as=0.2128p ps=1.5u w=1.12u l=0.13u
X1141 VGND.t1061 VPWR.t28 VGND.t1061 VGND.t1064 sg13_lv_nmos ad=79.8f pd=0.8u as=0 ps=0 w=0.42u l=1u
X1142 VPWR.t1198 a_3694_10704# sg13cmos5l_and2_2_6.A VPWR.t2 sg13_lv_pmos ad=0.2128p pd=1.5u as=0.2128p ps=1.5u w=1.12u l=0.13u
X1143 sg13cmos5l_buf_16_5.A a_5710_1632# VGND.t25 VGND.t864 sg13_lv_nmos ad=0.1406p pd=1.12u as=0.1406p ps=1.12u w=0.74u l=0.13u
X1144 sg13cmos5l_buf_16_7.A a_3668_3108# VGND.t310 VGND.t40 sg13_lv_nmos ad=0.1406p pd=1.12u as=0.1406p ps=1.12u w=0.74u l=0.13u
X1145 VPWR.t1339 a_3694_14482# sg13cmos5l_buf_16_33.A VPWR.t0 sg13_lv_pmos ad=0.2128p pd=1.5u as=0.2128p ps=1.5u w=1.12u l=0.13u
X1146 VPWR.t1471 VGND.t1147 VPWR.t1469 VPWR.t61 sg13_lv_pmos ad=0.19p pd=1.38u as=0 ps=0 w=1u l=1u
X1147 a_11565_8028# sg13cmos5l_buf_16_6.X VPWR.t91 VPWR.t58 sg13_lv_pmos ad=0.1596p pd=1.22u as=0.2856p ps=2.36u w=0.84u l=0.13u
X1148 VPWR.t385 VGND.t5 VPWR.t384 VPWR.t58 sg13_lv_pmos ad=0.34p pd=2.68u as=0 ps=0 w=1u l=1u
X1149 VPWR.t535 VGND.t942 VPWR.t533 VPWR.t79 sg13_lv_pmos ad=0.19p pd=1.38u as=0 ps=0 w=1u l=1u
X1150 VGND.t1147 VPWR.t1640 VGND.t1147 VGND.t1148 sg13_lv_nmos ad=0.1428p pd=1.52u as=0 ps=0 w=0.42u l=1u
X1151 VGND.t3 sg13cmos5l_xor2_1_7.X a_14344_11492# VGND.t2 sg13_lv_nmos ad=0.14875p pd=1.16u as=0.187p ps=1.78u w=0.55u l=0.13u
X1152 VGND.t50 a_3694_8434# sg13cmos5l_buf_16_34.A VGND.t52 sg13_lv_nmos ad=0.1406p pd=1.12u as=0.1406p ps=1.12u w=0.74u l=0.13u
X1153 VGND.t597 a_8948_13692# sg13cmos5l_buf_16_37.A VGND.t661 sg13_lv_nmos ad=0.1406p pd=1.12u as=0.1406p ps=1.12u w=0.74u l=0.13u
X1154 VGND.t870 sg13cmos5l_and2_2_1.X a_4174_13728# VGND.t1469 sg13_lv_nmos ad=0.1406p pd=1.12u as=0.1406p ps=1.12u w=0.74u l=0.13u
X1155 VGND.t25 a_5710_1632# sg13cmos5l_buf_16_5.A VGND.t861 sg13_lv_nmos ad=0.1406p pd=1.12u as=0.1406p ps=1.12u w=0.74u l=0.13u
X1156 VGND.t171 a_6094_4656# sg13cmos5l_buf_16_31.X VGND.t358 sg13_lv_nmos ad=0.1406p pd=1.12u as=0.1406p ps=1.12u w=0.74u l=0.13u
X1157 sg13cmos5l_buf_16_37.A a_8948_13692# VGND.t597 VGND.t650 sg13_lv_nmos ad=0.1406p pd=1.12u as=0.1406p ps=1.12u w=0.74u l=0.13u
X1158 VPWR.t802 a_4462_5410# sg13cmos5l_buf_16_11.A VPWR.t61 sg13_lv_pmos ad=0.2128p pd=1.5u as=0.2128p ps=1.5u w=1.12u l=0.13u
X1159 VPWR.t848 a_3668_3108# sg13cmos5l_buf_16_7.A VPWR.t67 sg13_lv_pmos ad=0.2128p pd=1.5u as=0.2128p ps=1.5u w=1.12u l=0.13u
X1160 VGND.t157 a_6862_9946# sg13cmos5l_buf_16_24.X VGND.t475 sg13_lv_nmos ad=0.1406p pd=1.12u as=0.1406p ps=1.12u w=0.74u l=0.13u
X1161 sg13cmos5l_buf_16_34.A a_3694_8434# VGND.t18 VGND.t48 sg13_lv_nmos ad=0.1406p pd=1.12u as=0.1406p ps=1.12u w=0.74u l=0.13u
X1162 VPWR.t86 VGND.t1358 VPWR.t86 VPWR.t55 sg13_lv_pmos ad=0.34p pd=2.68u as=0 ps=0 w=1u l=1u
X1163 VGND.t302 a_8494_3144# sg13cmos5l_buf_16_39.A VGND.t40 sg13_lv_nmos ad=0.1406p pd=1.12u as=0.1406p ps=1.12u w=0.74u l=0.13u
X1164 a_10292_12934# sg13cmos5l_buf_1_17.A VGND.t237 VGND.t242 sg13_lv_nmos ad=0.1406p pd=1.12u as=0.1406p ps=1.12u w=0.74u l=0.13u
X1165 VPWR.t462 VGND.t1050 VPWR.t460 VPWR.t5 sg13_lv_pmos ad=0.19p pd=1.38u as=0 ps=0 w=1u l=1u
X1166 sg13cmos5l_buf_16_0.A a_6094_3898# VPWR.t744 VPWR.t64 sg13_lv_pmos ad=0.2128p pd=1.5u as=0.2128p ps=1.5u w=1.12u l=0.13u
X1167 VGND.t1196 VPWR.t1621 VGND.t1196 VGND.t1200 sg13_lv_nmos ad=0.1428p pd=1.52u as=0 ps=0 w=0.42u l=1u
X1168 VGND.t1147 VPWR.t1631 VGND.t1147 VGND.t1149 sg13_lv_nmos ad=79.8f pd=0.8u as=0 ps=0 w=0.42u l=1u
X1169 sg13cmos5l_buf_16_2.A a_9262_7680# VPWR.t348 VPWR.t58 sg13_lv_pmos ad=0.2128p pd=1.5u as=0.2128p ps=1.5u w=1.12u l=0.13u
X1170 VPWR.t1335 a_3694_14482# sg13cmos5l_buf_16_33.A VPWR.t0 sg13_lv_pmos ad=0.2128p pd=1.5u as=0.2128p ps=1.5u w=1.12u l=0.13u
X1171 VPWR.t221 sg13cmos5l_buf_16_39.A a_6164_2350# VPWR.t67 sg13_lv_pmos ad=0.2128p pd=1.5u as=0.2128p ps=1.5u w=1.12u l=0.13u
X1172 VGND.t1061 VPWR.t146 VGND.t1061 VGND.t1063 sg13_lv_nmos ad=0.1428p pd=1.52u as=0 ps=0 w=0.42u l=1u
X1173 sg13cmos5l_buf_16_31.X a_6094_4656# VGND.t171 VGND.t355 sg13_lv_nmos ad=0.1406p pd=1.12u as=0.1406p ps=1.12u w=0.74u l=0.13u
X1174 VPWR.t1108 sg13cmos5l_buf_16_18.A a_4052_12934# VPWR.t79 sg13_lv_pmos ad=0.2128p pd=1.5u as=0.2128p ps=1.5u w=1.12u l=0.13u
X1175 VGND.t18 sg13cmos5l_buf_16_13.A a_3694_8434# VGND.t23 sg13_lv_nmos ad=0.1406p pd=1.12u as=0.1406p ps=1.12u w=0.74u l=0.13u
X1176 sg13cmos5l_buf_16_7.A a_3668_3108# VPWR.t845 VPWR.t67 sg13_lv_pmos ad=0.2128p pd=1.5u as=0.3976p ps=2.95u w=1.12u l=0.13u
X1177 sg13cmos5l_buf_16_24.X a_6862_9946# VGND.t157 VGND.t472 sg13_lv_nmos ad=0.1406p pd=1.12u as=0.1406p ps=1.12u w=0.74u l=0.13u
X1178 VPWR.t761 a_6094_3144# sg13cmos5l_xor2_1_0.B VPWR.t67 sg13_lv_pmos ad=0.2128p pd=1.5u as=0.2128p ps=1.5u w=1.12u l=0.13u
X1179 sg13cmos5l_buf_16_39.A a_8494_3144# VGND.t96 VGND.t40 sg13_lv_nmos ad=0.1406p pd=1.12u as=0.1406p ps=1.12u w=0.74u l=0.13u
X1180 VPWR.t132 VGND.t1117 VPWR.t132 VPWR.t5 sg13_lv_pmos ad=0.34p pd=2.68u as=0 ps=0 w=1u l=1u
X1181 sg13cmos5l_buf_16_15.A a_4052_12934# VGND.t457 VGND.t612 sg13_lv_nmos ad=0.1406p pd=1.12u as=0.1406p ps=1.12u w=0.74u l=0.13u
X1182 VGND.t1019 VPWR.t131 VGND.t1018 VGND.t2 sg13_lv_nmos ad=0.1428p pd=1.52u as=0 ps=0 w=0.42u l=1u
X1183 VGND.t1208 VPWR.t108 VGND.t1208 VGND.t1209 sg13_lv_nmos ad=79.8f pd=0.8u as=0 ps=0 w=0.42u l=1u
X1184 VPWR.t126 VGND.t1286 VPWR.t126 VPWR.t55 sg13_lv_pmos ad=0.34p pd=2.68u as=0 ps=0 w=1u l=1u
X1185 VGND.t1344 VPWR.t156 VGND.t1343 VGND.t1342 sg13_lv_nmos ad=0.1428p pd=1.52u as=0 ps=0 w=0.42u l=1u
X1186 VPWR.t61 a_8110_6168# sg13cmos5l_buf_16_38.A VPWR.t61 sg13_lv_pmos ad=0.2128p pd=1.5u as=0.2128p ps=1.5u w=1.12u l=0.13u
X1187 sg13cmos5l_buf_16_34.A a_3694_8434# VPWR.t266 VPWR.t5 sg13_lv_pmos ad=0.2128p pd=1.5u as=0.2128p ps=1.5u w=1.12u l=0.13u
X1188 sg13cmos5l_buf_16_2.A a_9262_7680# VGND.t5 VGND.t99 sg13_lv_nmos ad=0.1406p pd=1.12u as=0.1406p ps=1.12u w=0.74u l=0.13u
X1189 sg13cmos5l_buf_16_23.X a_10292_12934# VGND.t590 VGND.t668 sg13_lv_nmos ad=0.1406p pd=1.12u as=0.1406p ps=1.12u w=0.74u l=0.13u
X1190 VPWR.t1330 sg13cmos5l_buf_16_15.X a_3694_14482# VPWR.t0 sg13_lv_pmos ad=0.2128p pd=1.5u as=0.2128p ps=1.5u w=1.12u l=0.13u
X1191 VPWR.t1257 sg13cmos5l_buf_16_28.A a_5684_6132# VPWR.t61 sg13_lv_pmos ad=0.2128p pd=1.5u as=0.2128p ps=1.5u w=1.12u l=0.13u
X1192 sg13cmos5l_buf_16_27.X a_6548_13692# VGND.t597 VGND.t1491 sg13_lv_nmos ad=0.1406p pd=1.12u as=0.1406p ps=1.12u w=0.74u l=0.13u
X1193 sg13cmos5l_buf_16_10.A a_3694_3898# VGND.t125 VGND.t40 sg13_lv_nmos ad=0.1406p pd=1.12u as=0.1406p ps=1.12u w=0.74u l=0.13u
X1194 VGND.t797 a_3668_4620# sg13cmos5l_buf_16_8.A VGND.t816 sg13_lv_nmos ad=0.1406p pd=1.12u as=0.1406p ps=1.12u w=0.74u l=0.13u
X1195 VPWR.t1089 a_4052_12934# sg13cmos5l_buf_16_15.A VPWR.t79 sg13_lv_pmos ad=0.2128p pd=1.5u as=0.2128p ps=1.5u w=1.12u l=0.13u
X1196 VPWR.t120 VGND.t843 VPWR.t120 VPWR.t67 sg13_lv_pmos ad=0.34p pd=2.68u as=0 ps=0 w=1u l=1u
X1197 VGND.t1061 VPWR.t28 VGND.t1061 VGND.t1060 sg13_lv_nmos ad=0.1428p pd=1.52u as=0 ps=0 w=0.42u l=1u
X1198 VPWR.t301 VGND.t260 VPWR.t300 VPWR.t5 sg13_lv_pmos ad=0.34p pd=2.68u as=0 ps=0 w=1u l=1u
X1199 VPWR.t264 a_3694_8434# sg13cmos5l_buf_16_34.A VPWR.t5 sg13_lv_pmos ad=0.2128p pd=1.5u as=0.2128p ps=1.5u w=1.12u l=0.13u
X1200 a_9524_6886# sg13cmos5l_buf_16_4.A VPWR.t348 VPWR.t58 sg13_lv_pmos ad=0.2128p pd=1.5u as=0.2128p ps=1.5u w=1.12u l=0.13u
X1201 VGND.t726 VPWR.t1671 VGND.t726 VGND.t2 sg13_lv_nmos ad=79.8f pd=0.8u as=0 ps=0 w=0.42u l=1u
X1202 VGND.t1113 VPWR.t6 VGND.t5 VGND.t1112 sg13_lv_nmos ad=0.1428p pd=1.52u as=0 ps=0 w=0.42u l=1u
X1203 VPWR.t1435 sg13cmos5l_buf_16_31.X a_2147_13692# VPWR.t79 sg13_lv_pmos ad=0.2856p pd=2.36u as=0.1596p ps=1.22u w=0.84u l=0.13u
X1204 VGND.t218 sg13cmos5l_buf_16_28.X a_5518_6922# VGND.t632 sg13_lv_nmos ad=0.1406p pd=1.12u as=0.1406p ps=1.12u w=0.74u l=0.13u
X1205 VPWR.t28 VGND.t1010 VPWR.t28 VPWR.t2 sg13_lv_pmos ad=0.34p pd=2.68u as=0 ps=0 w=1u l=1u
X1206 a_7220_5374# sg13cmos5l_buf_16_38.A VGND.t171 VGND.t175 sg13_lv_nmos ad=0.1406p pd=1.12u as=0.1406p ps=1.12u w=0.74u l=0.13u
X1207 a_5684_6132# sg13cmos5l_buf_16_28.A VPWR.t592 VPWR.t61 sg13_lv_pmos ad=0.2128p pd=1.5u as=0.2128p ps=1.5u w=1.12u l=0.13u
X1208 VGND.t895 VPWR.t1698 VGND.t895 VGND.t900 sg13_lv_nmos ad=0.1428p pd=1.52u as=0 ps=0 w=0.42u l=1u
X1209 VPWR.t566 a_10292_12934# sg13cmos5l_buf_16_23.X VPWR.t79 sg13_lv_pmos ad=0.2128p pd=1.5u as=0.2128p ps=1.5u w=1.12u l=0.13u
X1210 VGND.t139 a_5204_11422# sg13cmos5l_buf_16_20.A VGND.t2 sg13_lv_nmos ad=0.1406p pd=1.12u as=0.1406p ps=1.12u w=0.74u l=0.13u
X1211 VPWR.t156 VGND.t1343 VPWR.t55 VPWR.t55 sg13_lv_pmos ad=0.34p pd=2.68u as=0 ps=0 w=1u l=1u
X1212 sg13cmos5l_buf_1_4.A a_13768_7680# VPWR.t58 VPWR.t58 sg13_lv_pmos ad=0.42p pd=2.99u as=0.2114p ps=1.54u w=1.12u l=0.13u
X1213 VPWR.t16 VGND.t590 VPWR.t16 VPWR.t8 sg13_lv_pmos ad=0.19p pd=1.38u as=0 ps=0 w=1u l=1u
X1214 VGND.t845 sg13cmos5l_buf_16_5.A a_5108_838# VGND.t846 sg13_lv_nmos ad=0.1406p pd=1.12u as=0.1406p ps=1.12u w=0.74u l=0.13u
X1215 a_6836_9156# sg13cmos5l_and2_2_6.X VGND.t157 VGND.t474 sg13_lv_nmos ad=0.1406p pd=1.12u as=0.1406p ps=1.12u w=0.74u l=0.13u
X1216 VPWR.t348 a_9524_6886# sg13cmos5l_buf_16_4.X VPWR.t58 sg13_lv_pmos ad=0.2128p pd=1.5u as=0.2128p ps=1.5u w=1.12u l=0.13u
X1217 VGND.t18 a_3694_7680# sg13cmos5l_buf_16_34.X VGND.t47 sg13_lv_nmos ad=0.1406p pd=1.12u as=0.1406p ps=1.12u w=0.74u l=0.13u
X1218 VGND.t1141 VPWR.t1634 VGND.t1141 VGND.t1142 sg13_lv_nmos ad=79.8f pd=0.8u as=0 ps=0 w=0.42u l=1u
X1219 VGND.t1147 VPWR.t1639 VGND.t1147 VGND.t1150 sg13_lv_nmos ad=0.1428p pd=1.52u as=0 ps=0 w=0.42u l=1u
X1220 sg13cmos5l_buf_16_14.A a_4436_9910# VGND.t260 VGND.t753 sg13_lv_nmos ad=0.1406p pd=1.12u as=0.1406p ps=1.12u w=0.74u l=0.13u
X1221 VPWR.t205 a_5710_1632# sg13cmos5l_buf_16_5.A VPWR.t55 sg13_lv_pmos ad=0.3976p pd=2.95u as=0.2128p ps=1.5u w=1.12u l=0.13u
X1222 sg13cmos5l_buf_16_27.X a_6548_13692# VGND.t1 VGND.t1487 sg13_lv_nmos ad=0.1406p pd=1.12u as=0.1406p ps=1.12u w=0.74u l=0.13u
X1223 sg13cmos5l_buf_16_2.X a_10318_3898# VPWR.t143 VPWR.t64 sg13_lv_pmos ad=0.2128p pd=1.5u as=0.2128p ps=1.5u w=1.12u l=0.13u
X1224 VGND.t134 VPWR.t1673 VGND.t134 VGND.t2 sg13_lv_nmos ad=0.1428p pd=1.52u as=0 ps=0 w=0.42u l=1u
X1225 a_3694_7680# sg13cmos5l_buf_16_34.A VGND.t18 VGND.t22 sg13_lv_nmos ad=0.1406p pd=1.12u as=0.1406p ps=1.12u w=0.74u l=0.13u
X1226 VGND.t157 a_6836_9156# sg13cmos5l_buf_16_25.A VGND.t169 sg13_lv_nmos ad=0.1406p pd=1.12u as=0.1406p ps=1.12u w=0.74u l=0.13u
X1227 VPWR.t293 VGND.t260 VPWR.t291 VPWR.t2 sg13_lv_pmos ad=0.19p pd=1.38u as=0 ps=0 w=1u l=1u
X1228 sg13cmos5l_buf_16_22.X a_10318_8434# VGND.t5 VGND.t577 sg13_lv_nmos ad=0.1406p pd=1.12u as=0.1406p ps=1.12u w=0.74u l=0.13u
X1229 VGND.t260 a_4436_9910# sg13cmos5l_buf_16_14.A VGND.t750 sg13_lv_nmos ad=0.1406p pd=1.12u as=0.1406p ps=1.12u w=0.74u l=0.13u
X1230 sg13cmos5l_buf_16_24.X a_6862_9946# VGND.t157 VGND.t166 sg13_lv_nmos ad=0.1406p pd=1.12u as=0.1406p ps=1.12u w=0.74u l=0.13u
X1231 sg13cmos5l_buf_16_39.A a_8494_3144# VGND.t96 VGND.t40 sg13_lv_nmos ad=0.1406p pd=1.12u as=0.1406p ps=1.12u w=0.74u l=0.13u
X1232 VPWR.t56 VGND.t1363 VPWR.t86 VPWR.t55 sg13_lv_pmos ad=0.34p pd=2.68u as=0 ps=0 w=1u l=1u
X1233 VGND.t1423 VPWR.t1060 VGND.t1422 VGND.t1421 sg13_lv_nmos ad=0.1428p pd=1.52u as=0 ps=0 w=0.42u l=1u
X1234 VPWR.t56 sg13cmos5l_buf_16_5.A a_5108_838# VPWR.t55 sg13_lv_pmos ad=0.2128p pd=1.5u as=0.2128p ps=1.5u w=1.12u l=0.13u
X1235 VGND.t42 VPWR.t110 VGND.t42 VGND.t40 sg13_lv_nmos ad=79.8f pd=0.8u as=0 ps=0 w=0.42u l=1u
X1236 VPWR.t199 VGND.t841 VPWR.t198 VPWR.t0 sg13_lv_pmos ad=0.19p pd=1.38u as=0 ps=0 w=1u l=1u
X1237 VPWR.t1463 VGND.t1147 VPWR.t612 VPWR.t61 sg13_lv_pmos ad=0.19p pd=1.38u as=0 ps=0 w=1u l=1u
X1238 VPWR.t1147 a_7796_12934# sg13cmos5l_buf_16_37.X VPWR.t79 sg13_lv_pmos ad=0.2128p pd=1.5u as=0.2128p ps=1.5u w=1.12u l=0.13u
X1239 VGND.t1061 VPWR.t3 VGND.t1061 VGND.t1071 sg13_lv_nmos ad=0.1428p pd=1.52u as=0 ps=0 w=0.42u l=1u
X1240 VGND.t76 a_10292_4620# sg13cmos5l_buf_16_3.X VGND.t79 sg13_lv_nmos ad=0.1406p pd=1.12u as=0.1406p ps=1.12u w=0.74u l=0.13u
X1241 VPWR.t830 a_6862_9946# sg13cmos5l_buf_16_24.X VPWR.t2 sg13_lv_pmos ad=0.2128p pd=1.5u as=0.2128p ps=1.5u w=1.12u l=0.13u
X1242 sg13cmos5l_buf_16_20.A a_5204_11422# VPWR.t489 VPWR.t8 sg13_lv_pmos ad=0.2128p pd=1.5u as=0.2128p ps=1.5u w=1.12u l=0.13u
X1243 VPWR.t61 sg13cmos5l_buf_16_38.A a_7220_5374# VPWR.t61 sg13_lv_pmos ad=0.3808p pd=2.92u as=0.2128p ps=1.5u w=1.12u l=0.13u
X1244 VGND.t5 a_10318_8434# sg13cmos5l_buf_16_22.X VGND.t574 sg13_lv_nmos ad=0.1406p pd=1.12u as=0.1406p ps=1.12u w=0.74u l=0.13u
X1245 a_9262_7680# sg13cmos5l_buf_16_4.X VGND.t5 VGND.t768 sg13_lv_nmos ad=0.1406p pd=1.12u as=0.1406p ps=1.12u w=0.74u l=0.13u
X1246 VGND.t1061 VPWR.t6 VGND.t1061 VGND.t1070 sg13_lv_nmos ad=79.8f pd=0.8u as=0 ps=0 w=0.42u l=1u
X1247 sg13cmos5l_buf_16_38.A a_8110_6168# VGND.t7 VGND.t782 sg13_lv_nmos ad=0.1406p pd=1.12u as=0.1406p ps=1.12u w=0.74u l=0.13u
X1248 VGND.t1208 VPWR.t110 VGND.t349 VGND.t1230 sg13_lv_nmos ad=79.8f pd=0.8u as=0 ps=0 w=0.42u l=1u
X1249 VGND.t1147 VPWR.t1631 VGND.t1147 VGND.t1148 sg13_lv_nmos ad=0.1428p pd=1.52u as=0 ps=0 w=0.42u l=1u
X1250 VPWR.t126 VGND.t1292 VPWR.t126 VPWR.t55 sg13_lv_pmos ad=0.34p pd=2.68u as=0 ps=0 w=1u l=1u
X1251 a_10318_3898# sg13cmos5l_buf_16_2.A VPWR.t143 VPWR.t64 sg13_lv_pmos ad=0.2128p pd=1.5u as=0.2128p ps=1.5u w=1.12u l=0.13u
X1252 sg13cmos5l_buf_16_10.A a_3694_3898# VGND.t122 VGND.t40 sg13_lv_nmos ad=0.1406p pd=1.12u as=0.1406p ps=1.12u w=0.74u l=0.13u
X1253 VGND.t42 VPWR.t1618 VGND.t1237 VGND.t40 sg13_lv_nmos ad=79.8f pd=0.8u as=0 ps=0 w=0.42u l=1u
X1254 VPWR.t1376 a_4174_13728# sg13cmos5l_buf_16_18.A VPWR.t79 sg13_lv_pmos ad=0.3976p pd=2.95u as=0.2128p ps=1.5u w=1.12u l=0.13u
X1255 sg13cmos5l_buf_16_22.X a_10318_8434# VPWR.t6 VPWR.t5 sg13_lv_pmos ad=0.2128p pd=1.5u as=0.2128p ps=1.5u w=1.12u l=0.13u
X1256 VPWR.t216 sg13cmos5l_buf_16_0.A a_8494_3144# VPWR.t67 sg13_lv_pmos ad=0.2128p pd=1.5u as=0.2128p ps=1.5u w=1.12u l=0.13u
X1257 VGND.t139 a_6094_10704# sg13cmos5l_buf_16_24.A VGND.t2 sg13_lv_nmos ad=0.1406p pd=1.12u as=0.1406p ps=1.12u w=0.74u l=0.13u
X1258 a_7220_5374# sg13cmos5l_buf_16_38.A VPWR.t61 VPWR.t61 sg13_lv_pmos ad=0.2128p pd=1.5u as=0.2128p ps=1.5u w=1.12u l=0.13u
X1259 sg13cmos5l_and2_2_3.X a_13581_9988# VGND.t39 VGND.t565 sg13_lv_nmos ad=0.1406p pd=1.12u as=0.1331p ps=1.12u w=0.74u l=0.13u
X1260 a_3668_3108# sg13cmos5l_buf_16_10.A VGND.t125 VGND.t40 sg13_lv_nmos ad=0.1406p pd=1.12u as=0.1406p ps=1.12u w=0.74u l=0.13u
X1261 sg13cmos5l_buf_16_31.X a_6094_4656# VPWR.t732 VPWR.t64 sg13_lv_pmos ad=0.2128p pd=1.5u as=0.2128p ps=1.5u w=1.12u l=0.13u
X1262 VPWR.t551 VGND.t942 VPWR.t550 VPWR.t8 sg13_lv_pmos ad=0.34p pd=2.68u as=0 ps=0 w=1u l=1u
X1263 VPWR.t410 VGND.t637 VPWR.t110 VPWR.t64 sg13_lv_pmos ad=0.34p pd=2.68u as=0 ps=0 w=1u l=1u
X1264 VGND.t7 a_8110_6168# sg13cmos5l_buf_16_38.A VGND.t779 sg13_lv_nmos ad=0.1406p pd=1.12u as=0.1406p ps=1.12u w=0.74u l=0.13u
X1265 sg13cmos5l_buf_16_28.X a_5684_6132# VGND.t218 VGND.t220 sg13_lv_nmos ad=0.1406p pd=1.12u as=0.1406p ps=1.12u w=0.74u l=0.13u
X1266 VPWR.t78 glitch_en[5] a_13576_14516# VPWR.t0 sg13_lv_pmos ad=0.2114p pd=1.54u as=0.2856p ps=2.36u w=0.84u l=0.13u
X1267 VPWR.t632 sg13cmos5l_buf_16_24.A a_6862_9946# VPWR.t2 sg13_lv_pmos ad=0.2128p pd=1.5u as=0.2128p ps=1.5u w=1.12u l=0.13u
X1268 VPWR.t6 a_10318_8434# sg13cmos5l_buf_16_22.X VPWR.t5 sg13_lv_pmos ad=0.2128p pd=1.5u as=0.2128p ps=1.5u w=1.12u l=0.13u
X1269 VGND.t31 sg13cmos5l_buf_16_39.A a_8538_2578# VGND.t32 sg13_lv_nmos ad=0.374p pd=2.46u as=0.17462p ps=1.185u w=0.55u l=0.13u
X1270 a_8494_3144# sg13cmos5l_buf_16_0.A VPWR.t329 VPWR.t67 sg13_lv_pmos ad=0.2128p pd=1.5u as=0.3808p ps=2.92u w=1.12u l=0.13u
X1271 sg13cmos5l_buf_16_15.X a_3668_12180# VGND.t457 VGND.t458 sg13_lv_nmos ad=0.1406p pd=1.12u as=0.1406p ps=1.12u w=0.74u l=0.13u
X1272 VPWR.t1591 a_3694_2386# sg13cmos5l_buf_16_7.X VPWR.t67 sg13_lv_pmos ad=0.2128p pd=1.5u as=0.2128p ps=1.5u w=1.12u l=0.13u
X1273 a_7796_12934# sg13cmos5l_buf_16_37.A VPWR.t566 VPWR.t79 sg13_lv_pmos ad=0.2128p pd=1.5u as=0.2128p ps=1.5u w=1.12u l=0.13u
X1274 sg13cmos5l_buf_1_1.A a_13768_3932# VPWR.t110 VPWR.t64 sg13_lv_pmos ad=0.42p pd=2.99u as=0.2114p ps=1.54u w=1.12u l=0.13u
X1275 VPWR.t400 VGND.t5 VPWR.t398 VPWR.t58 sg13_lv_pmos ad=0.19p pd=1.38u as=0 ps=0 w=1u l=1u
X1276 VPWR.t566 sg13cmos5l_buf_16_23.X a_8948_13692# VPWR.t79 sg13_lv_pmos ad=0.2128p pd=1.5u as=0.2128p ps=1.5u w=1.12u l=0.13u
X1277 VPWR.t896 a_3694_7680# sg13cmos5l_buf_16_34.X VPWR.t58 sg13_lv_pmos ad=0.2128p pd=1.5u as=0.2128p ps=1.5u w=1.12u l=0.13u
X1278 VGND.t590 a_7796_12934# sg13cmos5l_buf_16_37.X VGND.t693 sg13_lv_nmos ad=0.1406p pd=1.12u as=0.1406p ps=1.12u w=0.74u l=0.13u
X1279 VPWR.t156 VGND.t1348 VPWR.t156 VPWR.t55 sg13_lv_pmos ad=0.34p pd=2.68u as=0 ps=0 w=1u l=1u
X1280 VGND.t41 a_10318_3898# sg13cmos5l_buf_16_2.X VGND.t40 sg13_lv_nmos ad=0.2516p pd=2.16u as=0.1406p ps=1.12u w=0.74u l=0.13u
X1281 sg13cmos5l_buf_16_22.X a_10318_8434# VPWR.t440 VPWR.t5 sg13_lv_pmos ad=0.2128p pd=1.5u as=0.2128p ps=1.5u w=1.12u l=0.13u
X1282 sg13cmos5l_buf_16_37.A a_8948_13692# VPWR.t566 VPWR.t79 sg13_lv_pmos ad=0.2128p pd=1.5u as=0.2128p ps=1.5u w=1.12u l=0.13u
X1283 VPWR.t110 VGND.t42 VPWR.t110 VPWR.t64 sg13_lv_pmos ad=0.19p pd=1.38u as=0 ps=0 w=1u l=1u
X1284 VGND.t1237 VPWR.t1613 VGND.t1237 VGND.t40 sg13_lv_nmos ad=79.8f pd=0.8u as=0 ps=0 w=0.42u l=1u
X1285 VGND.t1147 VPWR.t1638 VGND.t1147 VGND.t1152 sg13_lv_nmos ad=0.1428p pd=1.52u as=0 ps=0 w=0.42u l=1u
X1286 VGND.t1061 VPWR.t28 VGND.t1061 VGND.t1065 sg13_lv_nmos ad=0.1428p pd=1.52u as=0 ps=0 w=0.42u l=1u
X1287 sg13cmos5l_buf_16_5.A a_5710_1632# VPWR.t56 VPWR.t55 sg13_lv_pmos ad=0.2128p pd=1.5u as=0.2128p ps=1.5u w=1.12u l=0.13u
X1288 VPWR.t45 VGND.t597 VPWR.t47 VPWR.t0 sg13_lv_pmos ad=0.19p pd=1.38u as=0 ps=0 w=1u l=1u
X1289 sg13cmos5l_buf_16_31.X a_6094_4656# VPWR.t728 VPWR.t64 sg13_lv_pmos ad=0.2128p pd=1.5u as=0.2128p ps=1.5u w=1.12u l=0.13u
X1290 sg13cmos5l_buf_16_34.X a_3694_7680# VPWR.t892 VPWR.t58 sg13_lv_pmos ad=0.2128p pd=1.5u as=0.2128p ps=1.5u w=1.12u l=0.13u
X1291 sg13cmos5l_buf_16_15.X a_3668_12180# VGND.t444 VGND.t452 sg13_lv_nmos ad=0.1406p pd=1.12u as=0.1406p ps=1.12u w=0.74u l=0.13u
X1292 sg13cmos5l_buf_16_2.X a_10318_3898# VGND.t41 VGND.t40 sg13_lv_nmos ad=0.1406p pd=1.12u as=0.1406p ps=1.12u w=0.74u l=0.13u
X1293 VGND.t302 VPWR.t143 VGND.t302 VGND.t40 sg13_lv_nmos ad=0.1428p pd=1.52u as=0 ps=0 w=0.42u l=1u
X1294 a_7796_12934# sg13cmos5l_buf_16_37.A VPWR.t566 VPWR.t79 sg13_lv_pmos ad=0.2128p pd=1.5u as=0.2128p ps=1.5u w=1.12u l=0.13u
X1295 VPWR.t1587 a_3694_2386# sg13cmos5l_buf_16_7.X VPWR.t67 sg13_lv_pmos ad=0.2128p pd=1.5u as=0.2128p ps=1.5u w=1.12u l=0.13u
X1296 VPWR.t61 a_8110_6168# sg13cmos5l_buf_16_38.A VPWR.t61 sg13_lv_pmos ad=0.2128p pd=1.5u as=0.2128p ps=1.5u w=1.12u l=0.13u
X1297 VPWR.t566 a_8948_13692# sg13cmos5l_buf_16_37.A VPWR.t79 sg13_lv_pmos ad=0.2128p pd=1.5u as=0.2128p ps=1.5u w=1.12u l=0.13u
X1298 VPWR.t355 VGND.t1237 VPWR.t354 VPWR.t64 sg13_lv_pmos ad=0.19p pd=1.38u as=0 ps=0 w=1u l=1u
X1299 VPWR.t1395 sg13cmos5l_and2_2_1.X a_4174_13728# VPWR.t79 sg13_lv_pmos ad=0.2128p pd=1.5u as=0.2128p ps=1.5u w=1.12u l=0.13u
X1300 sg13cmos5l_buf_16_25.A a_6836_9156# VPWR.t507 VPWR.t5 sg13_lv_pmos ad=0.2128p pd=1.5u as=0.2128p ps=1.5u w=1.12u l=0.13u
X1301 VPWR.t1226 a_4436_9910# sg13cmos5l_buf_16_14.A VPWR.t2 sg13_lv_pmos ad=0.2128p pd=1.5u as=0.2128p ps=1.5u w=1.12u l=0.13u
X1302 VGND.t989 VPWR.t1677 VGND.t989 VGND.t2 sg13_lv_nmos ad=0.1428p pd=1.52u as=0 ps=0 w=0.42u l=1u
X1303 sg13cmos5l_buf_16_37.A a_8948_13692# VPWR.t566 VPWR.t79 sg13_lv_pmos ad=0.2128p pd=1.5u as=0.2128p ps=1.5u w=1.12u l=0.13u
X1304 a_13581_9988# sg13cmos5l_buf_16_22.X VPWR.t135 VPWR.t2 sg13_lv_pmos ad=0.1596p pd=1.22u as=0.2856p ps=2.36u w=0.84u l=0.13u
X1305 VGND.t260 a_3668_9156# sg13cmos5l_buf_16_13.A VGND.t271 sg13_lv_nmos ad=0.1406p pd=1.12u as=0.1406p ps=1.12u w=0.74u l=0.13u
X1306 VPWR.t380 VGND.t5 VPWR.t378 VPWR.t5 sg13_lv_pmos ad=0.19p pd=1.38u as=0 ps=0 w=1u l=1u
X1307 VGND.t597 VPWR.t0 VGND.t597 VGND.t913 sg13_lv_nmos ad=0.1428p pd=1.52u as=0 ps=0 w=0.42u l=1u
X1308 sg13cmos5l_buf_16_24.A a_6094_10704# VGND.t726 VGND.t2 sg13_lv_nmos ad=0.1406p pd=1.12u as=0.1406p ps=1.12u w=0.74u l=0.13u
X1309 a_3668_3108# sg13cmos5l_buf_16_10.A VGND.t122 VGND.t40 sg13_lv_nmos ad=0.1406p pd=1.12u as=0.1406p ps=1.12u w=0.74u l=0.13u
X1310 VPWR.t464 VGND.t1050 VPWR.t463 VPWR.t5 sg13_lv_pmos ad=0.34p pd=2.68u as=0 ps=0 w=1u l=1u
X1311 VPWR.t129 VGND.t1010 VPWR.t131 VPWR.t8 sg13_lv_pmos ad=0.19p pd=1.38u as=0 ps=0 w=1u l=1u
X1312 VPWR.t505 a_6836_9156# sg13cmos5l_buf_16_25.A VPWR.t5 sg13_lv_pmos ad=0.2128p pd=1.5u as=0.2128p ps=1.5u w=1.12u l=0.13u
X1313 sg13cmos5l_buf_16_30.A a_6164_2350# VGND.t837 VGND.t1544 sg13_lv_nmos ad=0.1406p pd=1.12u as=0.1406p ps=1.12u w=0.74u l=0.13u
X1314 sg13cmos5l_buf_16_15.X a_3668_12180# VGND.t444 VGND.t448 sg13_lv_nmos ad=0.1406p pd=1.12u as=0.1406p ps=1.12u w=0.74u l=0.13u
X1315 VGND.t1147 VPWR.t1630 VGND.t1147 VGND.t1150 sg13_lv_nmos ad=0.1428p pd=1.52u as=0 ps=0 w=0.42u l=1u
X1316 a_3694_14482# sg13cmos5l_buf_16_15.X VGND.t870 VGND.t869 sg13_lv_nmos ad=0.1406p pd=1.12u as=0.2516p ps=2.16u w=0.74u l=0.13u
X1317 VGND.t942 VPWR.t1682 VGND.t942 VGND.t945 sg13_lv_nmos ad=79.8f pd=0.8u as=0 ps=0 w=0.42u l=1u
X1318 VGND.t61 a_3694_8434# sg13cmos5l_buf_16_34.A VGND.t63 sg13_lv_nmos ad=0.2516p pd=2.16u as=0.1406p ps=1.12u w=0.74u l=0.13u
X1319 VPWR.t335 sg13cmos5l_buf_16_4.X a_9262_7680# VPWR.t58 sg13_lv_pmos ad=0.2128p pd=1.5u as=0.2128p ps=1.5u w=1.12u l=0.13u
X1320 a_8948_13692# sg13cmos5l_buf_16_23.X VGND.t597 VGND.t596 sg13_lv_nmos ad=0.1406p pd=1.12u as=0.1406p ps=1.12u w=0.74u l=0.13u
X1321 sg13cmos5l_buf_16_13.A a_3668_9156# VGND.t260 VGND.t268 sg13_lv_nmos ad=0.1406p pd=1.12u as=0.1406p ps=1.12u w=0.74u l=0.13u
X1322 VPWR.t1222 a_4436_9910# sg13cmos5l_buf_16_14.A VPWR.t2 sg13_lv_pmos ad=0.2128p pd=1.5u as=0.2128p ps=1.5u w=1.12u l=0.13u
X1323 VGND.t837 a_6164_2350# sg13cmos5l_buf_16_30.A VGND.t1541 sg13_lv_nmos ad=0.1406p pd=1.12u as=0.1406p ps=1.12u w=0.74u l=0.13u
X1324 VGND.t1141 VPWR.t1641 VGND.t1141 VGND.t1145 sg13_lv_nmos ad=0.1428p pd=1.52u as=0 ps=0 w=0.42u l=1u
X1325 sg13cmos5l_buf_16_34.A a_3694_8434# VGND.t50 VGND.t59 sg13_lv_nmos ad=0.1406p pd=1.12u as=0.1406p ps=1.12u w=0.74u l=0.13u
X1326 sg13cmos5l_buf_1_17.X a_12232_12216# VPWR.t129 VPWR.t8 sg13_lv_pmos ad=0.42p pd=2.99u as=0.2114p ps=1.54u w=1.12u l=0.13u
X1327 VGND.t1196 VPWR.t1623 VGND.t1196 VGND.t1195 sg13_lv_nmos ad=0.1428p pd=1.52u as=0 ps=0 w=0.42u l=1u
X1328 VPWR.t3 VGND.t1019 VPWR.t3 VPWR.t2 sg13_lv_pmos ad=0.34p pd=2.68u as=0 ps=0 w=1u l=1u
X1329 VGND.t260 a_3668_9156# sg13cmos5l_buf_16_13.A VGND.t265 sg13_lv_nmos ad=0.1406p pd=1.12u as=0.1406p ps=1.12u w=0.74u l=0.13u
X1330 VGND.t134 sg13cmos5l_buf_16_34.X a_3694_10704# VGND.t2 sg13_lv_nmos ad=0.1406p pd=1.12u as=0.1406p ps=1.12u w=0.74u l=0.13u
X1331 VGND.t134 a_3694_10704# sg13cmos5l_and2_2_6.A VGND.t2 sg13_lv_nmos ad=0.1406p pd=1.12u as=0.1406p ps=1.12u w=0.74u l=0.13u
X1332 VGND.t125 a_6094_3898# sg13cmos5l_buf_16_0.A VGND.t40 sg13_lv_nmos ad=0.1406p pd=1.12u as=0.1406p ps=1.12u w=0.74u l=0.13u
X1333 VPWR.t1533 a_3694_3898# sg13cmos5l_buf_16_10.A VPWR.t64 sg13_lv_pmos ad=0.2128p pd=1.5u as=0.2128p ps=1.5u w=1.12u l=0.13u
X1334 VGND.t76 sg13cmos5l_buf_16_3.X a_10318_5410# VGND.t79 sg13_lv_nmos ad=0.1406p pd=1.12u as=0.1406p ps=1.12u w=0.74u l=0.13u
X1335 sg13cmos5l_buf_16_3.X a_10292_4620# VPWR.t143 VPWR.t64 sg13_lv_pmos ad=0.2128p pd=1.5u as=0.2128p ps=1.5u w=1.12u l=0.13u
X1336 sg13cmos5l_buf_16_31.X a_6094_4656# VGND.t171 VGND.t365 sg13_lv_nmos ad=0.1406p pd=1.12u as=0.1406p ps=1.12u w=0.74u l=0.13u
X1337 sg13cmos5l_buf_16_27.X a_6548_13692# VPWR.t1416 VPWR.t79 sg13_lv_pmos ad=0.2128p pd=1.5u as=0.2128p ps=1.5u w=1.12u l=0.13u
X1338 VGND.t1413 VPWR.t63 VGND.t1412 VGND.t1411 sg13_lv_nmos ad=0.1428p pd=1.52u as=0 ps=0 w=0.42u l=1u
X1339 sg13cmos5l_buf_16_34.X a_3694_7680# VPWR.t215 VPWR.t58 sg13_lv_pmos ad=0.2128p pd=1.5u as=0.2128p ps=1.5u w=1.12u l=0.13u
X1340 VGND.t942 VPWR.t1690 VGND.t942 VGND.t943 sg13_lv_nmos ad=79.8f pd=0.8u as=0 ps=0 w=0.42u l=1u
X1341 sg13cmos5l_buf_16_37.A a_8948_13692# VGND.t597 VGND.t658 sg13_lv_nmos ad=0.1406p pd=1.12u as=0.1406p ps=1.12u w=0.74u l=0.13u
X1342 VPWR.t771 a_6094_3144# sg13cmos5l_xor2_1_0.B VPWR.t67 sg13_lv_pmos ad=0.3976p pd=2.95u as=0.2128p ps=1.5u w=1.12u l=0.13u
X1343 VGND.t457 a_4052_12934# sg13cmos5l_buf_16_15.A VGND.t613 sg13_lv_nmos ad=0.1406p pd=1.12u as=0.1406p ps=1.12u w=0.74u l=0.13u
X1344 sg13cmos5l_buf_16_7.A a_3668_3108# VPWR.t856 VPWR.t67 sg13_lv_pmos ad=0.2128p pd=1.5u as=0.2128p ps=1.5u w=1.12u l=0.13u
X1345 VGND.t891 a_3694_14482# sg13cmos5l_buf_16_33.A VGND.t890 sg13_lv_nmos ad=0.1406p pd=1.12u as=0.1406p ps=1.12u w=0.74u l=0.13u
X1346 VGND.t620 sg13cmos5l_buf_16_18.A a_4052_12934# VGND.t645 sg13_lv_nmos ad=0.2516p pd=2.16u as=0.1406p ps=1.12u w=0.74u l=0.13u
X1347 VPWR.t752 a_6094_3898# sg13cmos5l_buf_16_0.A VPWR.t64 sg13_lv_pmos ad=0.2128p pd=1.5u as=0.2128p ps=1.5u w=1.12u l=0.13u
X1348 VPWR.t151 sg13cmos5l_buf_16_35.A a_8110_6168# VPWR.t61 sg13_lv_pmos ad=0.2128p pd=1.5u as=0.2128p ps=1.5u w=1.12u l=0.13u
X1349 VPWR.t606 VGND.t1141 VPWR.t604 VPWR.t61 sg13_lv_pmos ad=0.19p pd=1.38u as=0 ps=0 w=1u l=1u
X1350 VPWR.t335 a_9524_6886# sg13cmos5l_buf_16_4.X VPWR.t58 sg13_lv_pmos ad=0.2128p pd=1.5u as=0.2128p ps=1.5u w=1.12u l=0.13u
X1351 VGND.t1237 VPWR.t1612 VGND.t310 VGND.t40 sg13_lv_nmos ad=79.8f pd=0.8u as=0 ps=0 w=0.42u l=1u
X1352 sg13cmos5l_buf_16_10.A a_3694_3898# VPWR.t1529 VPWR.t64 sg13_lv_pmos ad=0.2128p pd=1.5u as=0.2128p ps=1.5u w=1.12u l=0.13u
X1353 VGND.t597 a_8948_13692# sg13cmos5l_buf_16_37.A VGND.t647 sg13_lv_nmos ad=0.1406p pd=1.12u as=0.1406p ps=1.12u w=0.74u l=0.13u
X1354 VGND.t1061 VPWR.t430 VGND.t1061 VGND.t1067 sg13_lv_nmos ad=0.1428p pd=1.52u as=0 ps=0 w=0.42u l=1u
X1355 a_6094_3898# enable VGND.t125 VGND.t40 sg13_lv_nmos ad=0.1406p pd=1.12u as=0.1406p ps=1.12u w=0.74u l=0.13u
X1356 VPWR.t64 VGND.t171 VPWR.t240 VPWR.t64 sg13_lv_pmos ad=0.34p pd=2.68u as=0 ps=0 w=1u l=1u
X1357 sg13cmos5l_buf_16_33.A a_3694_14482# VPWR.t1330 VPWR.t0 sg13_lv_pmos ad=0.2128p pd=1.5u as=0.2128p ps=1.5u w=1.12u l=0.13u
X1358 sg13cmos5l_buf_16_34.A a_3694_8434# VGND.t50 VGND.t55 sg13_lv_nmos ad=0.1406p pd=1.12u as=0.1406p ps=1.12u w=0.74u l=0.13u
X1359 VPWR.t854 a_3668_3108# sg13cmos5l_buf_16_7.A VPWR.t67 sg13_lv_pmos ad=0.2128p pd=1.5u as=0.2128p ps=1.5u w=1.12u l=0.13u
X1360 a_8110_6168# sg13cmos5l_buf_16_35.A VPWR.t148 VPWR.t61 sg13_lv_pmos ad=0.2128p pd=1.5u as=0.3808p ps=2.92u w=1.12u l=0.13u
X1361 sg13cmos5l_buf_16_4.X a_9524_6886# VPWR.t335 VPWR.t58 sg13_lv_pmos ad=0.2128p pd=1.5u as=0.3976p ps=2.95u w=1.12u l=0.13u
X1362 sg13cmos5l_buf_16_27.X a_6548_13692# VPWR.t1412 VPWR.t79 sg13_lv_pmos ad=0.2128p pd=1.5u as=0.2128p ps=1.5u w=1.12u l=0.13u
X1363 VPWR.t1173 a_6765_12564# sg13cmos5l_buf_16_19.A VPWR.t8 sg13_lv_pmos ad=0.4256p pd=3u as=0.2128p ps=1.5u w=1.12u l=0.13u
X1364 VPWR.t34 VGND.t590 VPWR.t33 VPWR.t8 sg13_lv_pmos ad=0.34p pd=2.68u as=0 ps=0 w=1u l=1u
X1365 sg13cmos5l_buf_16_15.A a_4052_12934# VPWR.t1089 VPWR.t79 sg13_lv_pmos ad=0.2128p pd=1.5u as=0.2128p ps=1.5u w=1.12u l=0.13u
X1366 VPWR.t274 a_3694_8434# sg13cmos5l_buf_16_34.A VPWR.t5 sg13_lv_pmos ad=0.2128p pd=1.5u as=0.2128p ps=1.5u w=1.12u l=0.13u
X1367 VPWR.t882 sg13cmos5l_buf_1_5.X a_14824_5444# VPWR.t61 sg13_lv_pmos ad=0.2114p pd=1.54u as=0.2856p ps=2.36u w=0.84u l=0.13u
X1368 VPWR.t6 VGND.t1073 VPWR.t6 VPWR.t5 sg13_lv_pmos ad=0.34p pd=2.68u as=0 ps=0 w=1u l=1u
X1369 sg13cmos5l_buf_16_3.X a_10292_4620# VPWR.t143 VPWR.t64 sg13_lv_pmos ad=0.2128p pd=1.5u as=0.2128p ps=1.5u w=1.12u l=0.13u
X1370 VGND.t231 a_5518_6922# sg13cmos5l_buf_16_6.X VGND.t540 sg13_lv_nmos ad=0.1406p pd=1.12u as=0.1406p ps=1.12u w=0.74u l=0.13u
X1371 a_7723_8028# sg13cmos5l_and2_2_6.A a_7629_8028# VGND.t420 sg13_lv_nmos ad=0.1216p pd=1.02u as=0.2176p ps=1.96u w=0.64u l=0.13u
X1372 VGND.t454 a_4052_12934# sg13cmos5l_buf_16_15.A VGND.t609 sg13_lv_nmos ad=0.1406p pd=1.12u as=0.1406p ps=1.12u w=0.74u l=0.13u
X1373 VGND.t726 VPWR.t26 VGND.t726 VGND.t2 sg13_lv_nmos ad=0.1428p pd=1.52u as=0 ps=0 w=0.42u l=1u
X1374 VGND.t1364 VPWR.t56 VGND.t1363 VGND.t1362 sg13_lv_nmos ad=0.1428p pd=1.52u as=0 ps=0 w=0.42u l=1u
X1375 a_5108_838# sg13cmos5l_buf_16_5.A VGND.t845 VGND.t847 sg13_lv_nmos ad=0.1406p pd=1.12u as=0.1406p ps=1.12u w=0.74u l=0.13u
X1376 a_5204_11422# sg13cmos5l_buf_16_19.A VGND.t139 VGND.t2 sg13_lv_nmos ad=0.1406p pd=1.12u as=0.1406p ps=1.12u w=0.74u l=0.13u
X1377 VGND.t5 a_11565_8028# sg13cmos5l_buf_16_4.A VGND.t208 sg13_lv_nmos ad=0.2812p pd=2.24u as=0.1406p ps=1.12u w=0.74u l=0.13u
X1378 VPWR.t132 sg13cmos5l_xor2_1_5.X a_14344_8468# VPWR.t5 sg13_lv_pmos ad=0.2114p pd=1.54u as=0.2856p ps=2.36u w=0.84u l=0.13u
X1379 VPWR.t298 VGND.t1050 VPWR.t467 VPWR.t5 sg13_lv_pmos ad=0.34p pd=2.68u as=0 ps=0 w=1u l=1u
X1380 a_6766_8434# sg13cmos5l_buf_16_25.A VPWR.t651 VPWR.t5 sg13_lv_pmos ad=0.2128p pd=1.5u as=0.3808p ps=2.92u w=1.12u l=0.13u
X1381 VPWR.t1465 VGND.t1147 VPWR.t1464 VPWR.t61 sg13_lv_pmos ad=0.34p pd=2.68u as=0 ps=0 w=1u l=1u
X1382 VGND.t50 a_3694_7680# sg13cmos5l_buf_16_34.X VGND.t58 sg13_lv_nmos ad=0.1406p pd=1.12u as=0.1406p ps=1.12u w=0.74u l=0.13u
X1383 VGND.t513 VPWR.t131 VGND.t513 VGND.t988 sg13_lv_nmos ad=0.1428p pd=1.52u as=0 ps=0 w=0.42u l=1u
X1384 VGND.t1 a_6548_13692# sg13cmos5l_buf_16_27.X VGND.t1488 sg13_lv_nmos ad=0.1406p pd=1.12u as=0.1406p ps=1.12u w=0.74u l=0.13u
X1385 sg13cmos5l_buf_16_15.A a_4052_12934# VPWR.t1085 VPWR.t79 sg13_lv_pmos ad=0.2128p pd=1.5u as=0.2128p ps=1.5u w=1.12u l=0.13u
X1386 VPWR.t489 a_5204_11422# sg13cmos5l_buf_16_20.A VPWR.t8 sg13_lv_pmos ad=0.2128p pd=1.5u as=0.2128p ps=1.5u w=1.12u l=0.13u
X1387 VGND.t1274 VPWR.t156 VGND.t1274 VGND.t1276 sg13_lv_nmos ad=0.1428p pd=1.52u as=0 ps=0 w=0.42u l=1u
X1388 a_10292_4620# sg13cmos5l_buf_16_2.X VGND.t86 VGND.t177 sg13_lv_nmos ad=0.1406p pd=1.12u as=0.1406p ps=1.12u w=0.74u l=0.13u
X1389 sg13cmos5l_and2_2_6.A a_3694_10704# VGND.t134 VGND.t2 sg13_lv_nmos ad=0.1406p pd=1.12u as=0.1406p ps=1.12u w=0.74u l=0.13u
X1390 VGND.t797 a_3668_4620# sg13cmos5l_buf_16_8.A VGND.t822 sg13_lv_nmos ad=0.1406p pd=1.12u as=0.1406p ps=1.12u w=0.74u l=0.13u
X1391 VGND.t444 a_4052_12934# sg13cmos5l_buf_16_15.A VGND.t605 sg13_lv_nmos ad=0.1406p pd=1.12u as=0.1406p ps=1.12u w=0.74u l=0.13u
X1392 VPWR.t636 a_3668_9156# sg13cmos5l_buf_16_13.A VPWR.t5 sg13_lv_pmos ad=0.2128p pd=1.5u as=0.2128p ps=1.5u w=1.12u l=0.13u
X1393 VPWR.t270 a_3694_8434# sg13cmos5l_buf_16_34.A VPWR.t5 sg13_lv_pmos ad=0.2128p pd=1.5u as=0.2128p ps=1.5u w=1.12u l=0.13u
X1394 VGND.t42 VPWR.t1615 VGND.t42 VGND.t40 sg13_lv_nmos ad=79.8f pd=0.8u as=0 ps=0 w=0.42u l=1u
X1395 a_10318_5410# sg13cmos5l_buf_16_3.X VPWR.t61 VPWR.t61 sg13_lv_pmos ad=0.2128p pd=1.5u as=0.2128p ps=1.5u w=1.12u l=0.13u
X1396 VPWR.t1188 a_6094_10704# sg13cmos5l_buf_16_24.A VPWR.t2 sg13_lv_pmos ad=0.2128p pd=1.5u as=0.2128p ps=1.5u w=1.12u l=0.13u
X1397 sg13cmos5l_buf_1_4.A a_13768_7680# VGND.t35 VGND.t772 sg13_lv_nmos ad=0.2886p pd=2.26u as=0.14875p ps=1.16u w=0.74u l=0.13u
X1398 sg13cmos5l_buf_16_20.A a_5204_11422# VGND.t137 VGND.t2 sg13_lv_nmos ad=0.1406p pd=1.12u as=0.1406p ps=1.12u w=0.74u l=0.13u
X1399 VPWR.t135 VGND.t37 VPWR.t135 VPWR.t2 sg13_lv_pmos ad=0.34p pd=2.68u as=0 ps=0 w=1u l=1u
X1400 VGND.t125 a_6094_3144# sg13cmos5l_xor2_1_0.B VGND.t40 sg13_lv_nmos ad=0.1406p pd=1.12u as=0.1406p ps=1.12u w=0.74u l=0.13u
X1401 VGND.t66 a_4436_9910# sg13cmos5l_buf_16_14.A VGND.t762 sg13_lv_nmos ad=0.1406p pd=1.12u as=0.1406p ps=1.12u w=0.74u l=0.13u
X1402 a_5518_6922# sg13cmos5l_buf_16_28.X VPWR.t1101 VPWR.t58 sg13_lv_pmos ad=0.2128p pd=1.5u as=0.2128p ps=1.5u w=1.12u l=0.13u
X1403 VGND.t895 glitch_en[0] a_1672_14516# VGND.t894 sg13_lv_nmos ad=0.14875p pd=1.16u as=0.187p ps=1.78u w=0.55u l=0.13u
X1404 VPWR.t143 a_10318_3898# sg13cmos5l_buf_16_2.X VPWR.t64 sg13_lv_pmos ad=0.2128p pd=1.5u as=0.2128p ps=1.5u w=1.12u l=0.13u
X1405 VGND.t940 sg13cmos5l_xor2_1_6.X a_14824_14516# VGND.t1496 sg13_lv_nmos ad=0.14875p pd=1.16u as=0.187p ps=1.78u w=0.55u l=0.13u
X1406 a_6859_12564# sg13cmos5l_buf_16_24.X a_6765_12564# VGND.t626 sg13_lv_nmos ad=0.1216p pd=1.02u as=0.2176p ps=1.96u w=0.64u l=0.13u
X1407 sg13cmos5l_buf_16_10.A a_3694_3898# VPWR.t689 VPWR.t64 sg13_lv_pmos ad=0.2128p pd=1.5u as=0.2128p ps=1.5u w=1.12u l=0.13u
X1408 out_xor[4] a_14824_9192# VPWR.t132 VPWR.t5 sg13_lv_pmos ad=0.42p pd=2.99u as=0.2114p ps=1.54u w=1.12u l=0.13u
X1409 VGND.t86 a_10292_4620# sg13cmos5l_buf_16_3.X VGND.t90 sg13_lv_nmos ad=0.1406p pd=1.12u as=0.1406p ps=1.12u w=0.74u l=0.13u
X1410 VGND.t895 VPWR.t1698 VGND.t841 VGND.t901 sg13_lv_nmos ad=79.8f pd=0.8u as=0 ps=0 w=0.42u l=1u
X1411 sg13cmos5l_buf_16_8.A a_3668_4620# VGND.t797 VGND.t819 sg13_lv_nmos ad=0.1406p pd=1.12u as=0.1406p ps=1.12u w=0.74u l=0.13u
X1412 VGND.t1 a_6548_13692# sg13cmos5l_buf_16_27.X VGND.t1484 sg13_lv_nmos ad=0.1406p pd=1.12u as=0.1406p ps=1.12u w=0.74u l=0.13u
X1413 VGND.t5 a_10318_8434# sg13cmos5l_buf_16_22.X VGND.t586 sg13_lv_nmos ad=0.1406p pd=1.12u as=0.1406p ps=1.12u w=0.74u l=0.13u
X1414 a_6094_3144# sg13cmos5l_buf_16_5.X VGND.t125 VGND.t40 sg13_lv_nmos ad=0.1406p pd=1.12u as=0.1406p ps=1.12u w=0.74u l=0.13u
X1415 sg13cmos5l_buf_16_14.A a_4436_9910# VGND.t66 VGND.t759 sg13_lv_nmos ad=0.1406p pd=1.12u as=0.1406p ps=1.12u w=0.74u l=0.13u
X1416 sg13cmos5l_buf_16_2.X a_10318_3898# VPWR.t143 VPWR.t64 sg13_lv_pmos ad=0.2128p pd=1.5u as=0.2128p ps=1.5u w=1.12u l=0.13u
X1417 VPWR.t3 VGND.t1018 VPWR.t3 VPWR.t2 sg13_lv_pmos ad=0.19p pd=1.38u as=0 ps=0 w=1u l=1u
X1418 VPWR.t28 VGND.t1061 VPWR.t28 VPWR.t2 sg13_lv_pmos ad=0.19p pd=1.38u as=0 ps=0 w=1u l=1u
X1419 VPWR.t372 VGND.t5 VPWR.t370 VPWR.t5 sg13_lv_pmos ad=0.19p pd=1.38u as=0 ps=0 w=1u l=1u
X1420 sg13cmos5l_buf_16_20.A a_5204_11422# VGND.t134 VGND.t2 sg13_lv_nmos ad=0.1406p pd=1.12u as=0.2516p ps=2.16u w=0.74u l=0.13u
X1421 VGND.t218 a_5518_6922# sg13cmos5l_buf_16_6.X VGND.t536 sg13_lv_nmos ad=0.1406p pd=1.12u as=0.1406p ps=1.12u w=0.74u l=0.13u
X1422 VPWR.t175 VGND.t61 VPWR.t174 VPWR.t5 sg13_lv_pmos ad=0.34p pd=2.68u as=0 ps=0 w=1u l=1u
X1423 VPWR.t64 VGND.t171 VPWR.t64 VPWR.t64 sg13_lv_pmos ad=0.34p pd=2.68u as=0 ps=0 w=1u l=1u
X1424 a_10318_5410# sg13cmos5l_buf_16_3.X VPWR.t61 VPWR.t61 sg13_lv_pmos ad=0.2128p pd=1.5u as=0.3808p ps=2.92u w=1.12u l=0.13u
X1425 VGND.t1141 VPWR.t1632 VGND.t1141 VGND.t1145 sg13_lv_nmos ad=0.1428p pd=1.52u as=0 ps=0 w=0.42u l=1u
X1426 VGND.t1237 VPWR.t1612 VGND.t1237 VGND.t40 sg13_lv_nmos ad=0.1428p pd=1.52u as=0 ps=0 w=0.42u l=1u
X1427 sg13cmos5l_buf_16_28.X a_5684_6132# VGND.t231 VGND.t232 sg13_lv_nmos ad=0.1406p pd=1.12u as=0.1406p ps=1.12u w=0.74u l=0.13u
X1428 VPWR.t146 sg13cmos5l_and2_2_6.X a_6836_9156# VPWR.t5 sg13_lv_pmos ad=0.3808p pd=2.92u as=0.2128p ps=1.5u w=1.12u l=0.13u
X1429 VGND.t37 VPWR.t132 VGND.t37 VGND.t1099 sg13_lv_nmos ad=79.8f pd=0.8u as=0 ps=0 w=0.42u l=1u
X1430 a_5518_6922# sg13cmos5l_buf_16_28.X VPWR.t1098 VPWR.t58 sg13_lv_pmos ad=0.2128p pd=1.5u as=0.3808p ps=2.92u w=1.12u l=0.13u
X1431 sg13cmos5l_buf_16_39.A a_8494_3144# VPWR.t216 VPWR.t67 sg13_lv_pmos ad=0.2128p pd=1.5u as=0.2128p ps=1.5u w=1.12u l=0.13u
X1432 a_4462_5410# sg13cmos5l_and2_2_0.X VGND.t797 VGND.t799 sg13_lv_nmos ad=0.1406p pd=1.12u as=0.1406p ps=1.12u w=0.74u l=0.13u
X1433 VGND.t942 VPWR.t1681 VGND.t948 VGND.t947 sg13_lv_nmos ad=79.8f pd=0.8u as=0 ps=0 w=0.42u l=1u
X1434 sg13cmos5l_buf_16_6.X a_5518_6922# VGND.t218 VGND.t533 sg13_lv_nmos ad=0.1406p pd=1.12u as=0.1406p ps=1.12u w=0.74u l=0.13u
X1435 VPWR.t55 VGND.t1338 VPWR.t55 VPWR.t55 sg13_lv_pmos ad=0.34p pd=2.68u as=0 ps=0 w=1u l=1u
X1436 VPWR.t32 VGND.t590 VPWR.t31 VPWR.t8 sg13_lv_pmos ad=0.19p pd=1.38u as=0 ps=0 w=1u l=1u
X1437 VGND.t25 sg13cmos5l_buf_16_39.A a_6164_2350# VGND.t26 sg13_lv_nmos ad=0.1406p pd=1.12u as=0.1406p ps=1.12u w=0.74u l=0.13u
X1438 VGND.t1050 VPWR.t1658 VGND.t1050 VGND.t1053 sg13_lv_nmos ad=79.8f pd=0.8u as=0 ps=0 w=0.42u l=1u
X1439 VGND.t96 VPWR.t64 VGND.t302 VGND.t40 sg13_lv_nmos ad=79.8f pd=0.8u as=0 ps=0 w=0.42u l=1u
X1440 VGND.t891 a_4174_13728# sg13cmos5l_buf_16_18.A VGND.t1446 sg13_lv_nmos ad=0.1406p pd=1.12u as=0.1406p ps=1.12u w=0.74u l=0.13u
X1441 VPWR.t1469 VGND.t1147 VPWR.t1468 VPWR.t61 sg13_lv_pmos ad=0.34p pd=2.68u as=0 ps=0 w=1u l=1u
X1442 sg13cmos5l_xor2_1_7.X a_13745_11508# a_13916_11752# VPWR.t8 sg13_lv_pmos ad=0.3808p pd=2.92u as=0.2128p ps=1.5u w=1.12u l=0.13u
X1443 sg13cmos5l_buf_16_22.X a_10318_8434# VPWR.t6 VPWR.t5 sg13_lv_pmos ad=0.2128p pd=1.5u as=0.2128p ps=1.5u w=1.12u l=0.13u
X1444 VPWR.t216 a_8494_3144# sg13cmos5l_buf_16_39.A VPWR.t67 sg13_lv_pmos ad=0.2128p pd=1.5u as=0.2128p ps=1.5u w=1.12u l=0.13u
X1445 out_xor[4] a_14824_9192# VGND.t37 VGND.t45 sg13_lv_nmos ad=0.2886p pd=2.26u as=0.14875p ps=1.16u w=0.74u l=0.13u
X1446 VPWR.t217 sg13cmos5l_xor2_1_0.B a_8564_2680# VPWR.t67 sg13_lv_pmos ad=0.2128p pd=1.5u as=0.2128p ps=1.5u w=1.12u l=0.13u
X1447 VPWR.t171 VGND.t18 VPWR.t170 VPWR.t58 sg13_lv_pmos ad=0.19p pd=1.38u as=0 ps=0 w=1u l=1u
X1448 sg13cmos5l_buf_16_24.A a_6094_10704# VPWR.t1190 VPWR.t2 sg13_lv_pmos ad=0.2128p pd=1.5u as=0.2128p ps=1.5u w=1.12u l=0.13u
X1449 VPWR.t168 VGND.t5 VPWR.t381 VPWR.t5 sg13_lv_pmos ad=0.34p pd=2.68u as=0 ps=0 w=1u l=1u
X1450 VGND.t1 glitch_en[3] a_7432_14516# VGND.t0 sg13_lv_nmos ad=0.14875p pd=1.16u as=0.187p ps=1.78u w=0.55u l=0.13u
X1451 VPWR.t1289 a_3668_4620# sg13cmos5l_buf_16_8.A VPWR.t64 sg13_lv_pmos ad=0.2128p pd=1.5u as=0.2128p ps=1.5u w=1.12u l=0.13u
X1452 sg13cmos5l_buf_16_34.X a_3694_7680# VPWR.t902 VPWR.t58 sg13_lv_pmos ad=0.2128p pd=1.5u as=0.2128p ps=1.5u w=1.12u l=0.13u
X1453 VGND.t206 VPWR.t78 VGND.t206 VGND.t922 sg13_lv_nmos ad=0.1428p pd=1.52u as=0 ps=0 w=0.42u l=1u
X1454 VPWR.t232 VGND.t891 VPWR.t231 VPWR.t0 sg13_lv_pmos ad=0.34p pd=2.68u as=0 ps=0 w=1u l=1u
X1455 VGND.t86 a_10292_4620# sg13cmos5l_buf_16_3.X VGND.t85 sg13_lv_nmos ad=0.1406p pd=1.12u as=0.1406p ps=1.12u w=0.74u l=0.13u
X1456 VPWR.t6 a_10318_8434# sg13cmos5l_buf_16_22.X VPWR.t5 sg13_lv_pmos ad=0.2128p pd=1.5u as=0.2128p ps=1.5u w=1.12u l=0.13u
X1457 VGND.t597 VPWR.t1695 VGND.t597 VGND.t906 sg13_lv_nmos ad=79.8f pd=0.8u as=0 ps=0 w=0.42u l=1u
X1458 VPWR.t566 sg13cmos5l_buf_16_37.A a_7796_12934# VPWR.t79 sg13_lv_pmos ad=0.2128p pd=1.5u as=0.2128p ps=1.5u w=1.12u l=0.13u
X1459 VPWR.t295 VGND.t260 VPWR.t294 VPWR.t2 sg13_lv_pmos ad=0.34p pd=2.68u as=0 ps=0 w=1u l=1u
X1460 VPWR.t61 a_8110_6168# sg13cmos5l_buf_16_38.A VPWR.t61 sg13_lv_pmos ad=0.2128p pd=1.5u as=0.2128p ps=1.5u w=1.12u l=0.13u
X1461 a_8948_13692# sg13cmos5l_buf_16_23.X VPWR.t566 VPWR.t79 sg13_lv_pmos ad=0.2128p pd=1.5u as=0.2128p ps=1.5u w=1.12u l=0.13u
X1462 VPWR.t16 VGND.t726 VPWR.t15 VPWR.t8 sg13_lv_pmos ad=0.34p pd=2.68u as=0 ps=0 w=1u l=1u
X1463 VPWR.t239 VGND.t42 VPWR.t125 VPWR.t67 sg13_lv_pmos ad=0.19p pd=1.38u as=0 ps=0 w=1u l=1u
X1464 VGND.t837 sg13cmos5l_buf_16_30.A a_5710_1632# VGND.t836 sg13_lv_nmos ad=0.1406p pd=1.12u as=0.1406p ps=1.12u w=0.74u l=0.13u
X1465 sg13cmos5l_buf_16_37.X a_7796_12934# VGND.t590 VGND.t690 sg13_lv_nmos ad=0.1406p pd=1.12u as=0.1406p ps=1.12u w=0.74u l=0.13u
X1466 VPWR.t736 a_6094_4656# sg13cmos5l_buf_16_31.X VPWR.t64 sg13_lv_pmos ad=0.2128p pd=1.5u as=0.2128p ps=1.5u w=1.12u l=0.13u
X1467 VGND.t513 VPWR.t131 VGND.t513 VGND.t984 sg13_lv_nmos ad=0.1428p pd=1.52u as=0 ps=0 w=0.42u l=1u
X1468 sg13cmos5l_buf_16_8.A a_3668_4620# VPWR.t1285 VPWR.t64 sg13_lv_pmos ad=0.2128p pd=1.5u as=0.2128p ps=1.5u w=1.12u l=0.13u
X1469 VPWR.t1263 sg13cmos5l_and2_2_0.X a_4462_5410# VPWR.t61 sg13_lv_pmos ad=0.2128p pd=1.5u as=0.2128p ps=1.5u w=1.12u l=0.13u
X1470 VGND.t1113 VPWR.t59 VGND.t1113 VGND.t1135 sg13_lv_nmos ad=0.1428p pd=1.52u as=0 ps=0 w=0.42u l=1u
X1471 VGND.t870 a_4174_13728# sg13cmos5l_buf_16_18.A VGND.t1442 sg13_lv_nmos ad=0.1406p pd=1.12u as=0.1406p ps=1.12u w=0.74u l=0.13u
X1472 VPWR.t135 sg13cmos5l_and2_2_3.B a_13581_9988# VPWR.t2 sg13_lv_pmos ad=0.1918p pd=1.5u as=0.1596p ps=1.22u w=0.84u l=0.13u
X1473 sg13cmos5l_buf_16_35.A a_6766_8434# VGND.t15 VGND.t289 sg13_lv_nmos ad=0.1406p pd=1.12u as=0.1406p ps=1.12u w=0.74u l=0.13u
X1474 VGND.t66 sg13cmos5l_buf_16_14.A a_3668_9156# VGND.t71 sg13_lv_nmos ad=0.2516p pd=2.16u as=0.1406p ps=1.12u w=0.74u l=0.13u
X1475 a_13897_13012# sg13cmos5l_and2_2_4.B VGND.t513 VGND.t1475 sg13_lv_nmos ad=0.1216p pd=1.02u as=0.1331p ps=1.12u w=0.64u l=0.13u
X1476 a_5710_1632# sg13cmos5l_buf_16_30.A VGND.t198 VGND.t833 sg13_lv_nmos ad=0.1406p pd=1.12u as=0.2516p ps=2.16u w=0.74u l=0.13u
X1477 VGND.t1208 VPWR.t108 VGND.t181 VGND.t1207 sg13_lv_nmos ad=0.1428p pd=1.52u as=0 ps=0 w=0.42u l=1u
X1478 VPWR.t555 sg13cmos5l_buf_16_34.X a_3694_10704# VPWR.t2 sg13_lv_pmos ad=0.2128p pd=1.5u as=0.2128p ps=1.5u w=1.12u l=0.13u
X1479 VPWR.t1206 a_3694_10704# sg13cmos5l_and2_2_6.A VPWR.t2 sg13_lv_pmos ad=0.2128p pd=1.5u as=0.2128p ps=1.5u w=1.12u l=0.13u
X1480 VPWR.t362 VGND.t1237 VPWR.t361 VPWR.t67 sg13_lv_pmos ad=0.19p pd=1.38u as=0 ps=0 w=1u l=1u
X1481 sg13cmos5l_buf_16_28.X a_5684_6132# VGND.t218 VGND.t226 sg13_lv_nmos ad=0.1406p pd=1.12u as=0.1406p ps=1.12u w=0.74u l=0.13u
X1482 VGND.t870 sg13cmos5l_buf_16_15.X a_3694_14482# VGND.t871 sg13_lv_nmos ad=0.1406p pd=1.12u as=0.1406p ps=1.12u w=0.74u l=0.13u
X1483 VPWR.t146 sg13cmos5l_and2_2_6.X a_6836_9156# VPWR.t5 sg13_lv_pmos ad=0.2128p pd=1.5u as=0.2128p ps=1.5u w=1.12u l=0.13u
X1484 a_4462_5410# sg13cmos5l_and2_2_0.X VPWR.t1260 VPWR.t61 sg13_lv_pmos ad=0.2128p pd=1.5u as=0.3808p ps=2.92u w=1.12u l=0.13u
X1485 VGND.t1383 VPWR.t250 VGND.t1385 VGND.t1384 sg13_lv_nmos ad=79.8f pd=0.8u as=0 ps=0 w=0.42u l=1u
X1486 VGND.t214 VPWR.t91 VGND.t214 VGND.t1159 sg13_lv_nmos ad=0.1428p pd=1.52u as=0 ps=0 w=0.42u l=1u
X1487 VPWR.t1113 a_7796_12934# sg13cmos5l_buf_16_37.X VPWR.t79 sg13_lv_pmos ad=0.2128p pd=1.5u as=0.2128p ps=1.5u w=1.12u l=0.13u
X1488 VGND.t843 VPWR.t239 VGND.t843 VGND.t1304 sg13_lv_nmos ad=0.1428p pd=1.52u as=0 ps=0 w=0.42u l=1u
X1489 VGND.t15 a_6766_8434# sg13cmos5l_buf_16_35.A VGND.t286 sg13_lv_nmos ad=0.1406p pd=1.12u as=0.1406p ps=1.12u w=0.74u l=0.13u
X1490 sg13cmos5l_buf_16_37.A a_8948_13692# VPWR.t566 VPWR.t79 sg13_lv_pmos ad=0.2128p pd=1.5u as=0.2128p ps=1.5u w=1.12u l=0.13u
X1491 a_3668_9156# sg13cmos5l_buf_16_14.A VGND.t66 VGND.t68 sg13_lv_nmos ad=0.1406p pd=1.12u as=0.1406p ps=1.12u w=0.74u l=0.13u
X1492 VPWR.t1505 VGND.t1196 VPWR.t1503 VPWR.t61 sg13_lv_pmos ad=0.19p pd=1.38u as=0 ps=0 w=1u l=1u
X1493 sg13cmos5l_buf_16_37.X a_7796_12934# VGND.t590 VGND.t686 sg13_lv_nmos ad=0.1406p pd=1.12u as=0.1406p ps=1.12u w=0.74u l=0.13u
X1494 sg13cmos5l_buf_16_1.X a_10318_5410# VGND.t86 VGND.t177 sg13_lv_nmos ad=0.1406p pd=1.12u as=0.1406p ps=1.12u w=0.74u l=0.13u
X1495 VPWR.t608 VGND.t1141 VPWR.t607 VPWR.t61 sg13_lv_pmos ad=0.34p pd=2.68u as=0 ps=0 w=1u l=1u
X1496 sg13cmos5l_buf_16_23.X a_10292_12934# VPWR.t566 VPWR.t79 sg13_lv_pmos ad=0.2128p pd=1.5u as=0.2128p ps=1.5u w=1.12u l=0.13u
X1497 VGND.t1141 VPWR.t1643 VGND.t1141 VGND.t1140 sg13_lv_nmos ad=0.1428p pd=1.52u as=0 ps=0 w=0.42u l=1u
X1498 VGND.t870 a_4174_13728# sg13cmos5l_buf_16_18.A VGND.t1438 sg13_lv_nmos ad=0.1406p pd=1.12u as=0.1406p ps=1.12u w=0.74u l=0.13u
X1499 VPWR.t1113 a_8948_13692# sg13cmos5l_buf_16_37.A VPWR.t79 sg13_lv_pmos ad=0.2128p pd=1.5u as=0.2128p ps=1.5u w=1.12u l=0.13u
X1500 sg13cmos5l_buf_16_30.A a_6164_2350# VPWR.t1545 VPWR.t67 sg13_lv_pmos ad=0.2128p pd=1.5u as=0.2128p ps=1.5u w=1.12u l=0.13u
X1501 sg13cmos5l_buf_16_25.A a_6836_9156# VPWR.t513 VPWR.t5 sg13_lv_pmos ad=0.2128p pd=1.5u as=0.2128p ps=1.5u w=1.12u l=0.13u
X1502 VGND.t25 a_6164_2350# sg13cmos5l_buf_16_30.A VGND.t1554 sg13_lv_nmos ad=0.1406p pd=1.12u as=0.1406p ps=1.12u w=0.74u l=0.13u
X1503 sg13cmos5l_buf_16_37.A a_8948_13692# VGND.t597 VGND.t646 sg13_lv_nmos ad=0.1406p pd=1.12u as=0.2516p ps=2.16u w=0.74u l=0.13u
X1504 VPWR.t250 VGND.t31 VPWR.t250 VPWR.t55 sg13_lv_pmos ad=0.19p pd=1.38u as=0 ps=0 w=1u l=1u
X1505 sg13cmos5l_xor2_1_4.X sg13cmos5l_buf_16_22.X a_14010_8446# VGND.t152 sg13_lv_nmos ad=0.1628p pd=1.18u as=88.8f ps=0.98u w=0.74u l=0.13u
X1506 VGND.t125 a_6094_3898# sg13cmos5l_buf_16_0.A VGND.t40 sg13_lv_nmos ad=0.1406p pd=1.12u as=0.1406p ps=1.12u w=0.74u l=0.13u
X1507 VGND.t86 a_10318_5410# sg13cmos5l_buf_16_1.X VGND.t90 sg13_lv_nmos ad=0.1406p pd=1.12u as=0.1406p ps=1.12u w=0.74u l=0.13u
X1508 a_10292_12934# sg13cmos5l_buf_1_17.A VGND.t237 VGND.t238 sg13_lv_nmos ad=0.1406p pd=1.12u as=0.1406p ps=1.12u w=0.74u l=0.13u
X1509 VPWR.t1543 a_6164_2350# sg13cmos5l_buf_16_30.A VPWR.t67 sg13_lv_pmos ad=0.2128p pd=1.5u as=0.2128p ps=1.5u w=1.12u l=0.13u
X1510 VPWR.t1060 sg13cmos5l_buf_1_2.X a_14824_1632# VPWR.t55 sg13_lv_pmos ad=0.2114p pd=1.54u as=0.2856p ps=2.36u w=0.84u l=0.13u
X1511 sg13cmos5l_buf_16_34.X a_3694_7680# VPWR.t898 VPWR.t58 sg13_lv_pmos ad=0.2128p pd=1.5u as=0.2128p ps=1.5u w=1.12u l=0.13u
X1512 VGND.t891 glitch_en[2] a_5992_14516# VGND.t1425 sg13_lv_nmos ad=0.14875p pd=1.16u as=0.187p ps=1.78u w=0.55u l=0.13u
X1513 sg13cmos5l_buf_1_23.A a_6161_9550# a_6332_9192# VPWR.t5 sg13_lv_pmos ad=0.3808p pd=2.92u as=0.2128p ps=1.5u w=1.12u l=0.13u
X1514 sg13cmos5l_buf_16_30.A a_6164_2350# VGND.t1550 VGND.t1551 sg13_lv_nmos ad=0.1406p pd=1.12u as=0.1406p ps=1.12u w=0.74u l=0.13u
X1515 VPWR.t117 VGND.t41 VPWR.t117 VPWR.t67 sg13_lv_pmos ad=0.19p pd=1.38u as=0 ps=0 w=1u l=1u
X1516 sg13cmos5l_buf_16_28.X a_5684_6132# VGND.t218 VGND.t222 sg13_lv_nmos ad=0.1406p pd=1.12u as=0.1406p ps=1.12u w=0.74u l=0.13u
X1517 out_xor[7] a_14824_14516# VGND.t940 VGND.t1508 sg13_lv_nmos ad=0.2886p pd=2.26u as=0.14875p ps=1.16u w=0.74u l=0.13u
X1518 sg13cmos5l_buf_16_28.A a_7220_5374# VGND.t171 VGND.t338 sg13_lv_nmos ad=0.1406p pd=1.12u as=0.1406p ps=1.12u w=0.74u l=0.13u
X1519 VPWR.t61 a_8110_6168# sg13cmos5l_buf_16_38.A VPWR.t61 sg13_lv_pmos ad=0.2128p pd=1.5u as=0.2128p ps=1.5u w=1.12u l=0.13u
X1520 VPWR.t64 VGND.t302 VPWR.t64 VPWR.t64 sg13_lv_pmos ad=0.19p pd=1.38u as=0 ps=0 w=1u l=1u
X1521 sg13cmos5l_buf_1_6.A sg13cmos5l_buf_16_31.X a_4986_6526# VGND.t1511 sg13_lv_nmos ad=0.1628p pd=1.18u as=88.8f ps=0.98u w=0.74u l=0.13u
X1522 sg13cmos5l_buf_16_13.A a_3668_9156# VGND.t260 VGND.t274 sg13_lv_nmos ad=0.1406p pd=1.12u as=0.1406p ps=1.12u w=0.74u l=0.13u
X1523 sg13cmos5l_buf_16_10.A a_3694_3898# VPWR.t1539 VPWR.t64 sg13_lv_pmos ad=0.2128p pd=1.5u as=0.2128p ps=1.5u w=1.12u l=0.13u
X1524 VPWR.t143 a_10292_4620# sg13cmos5l_buf_16_3.X VPWR.t64 sg13_lv_pmos ad=0.2128p pd=1.5u as=0.2128p ps=1.5u w=1.12u l=0.13u
X1525 sg13cmos5l_buf_16_8.A a_3668_4620# VPWR.t1281 VPWR.t64 sg13_lv_pmos ad=0.2128p pd=1.5u as=0.2128p ps=1.5u w=1.12u l=0.13u
X1526 VPWR.t47 VGND.t597 VPWR.t47 VPWR.t0 sg13_lv_pmos ad=0.34p pd=2.68u as=0 ps=0 w=1u l=1u
X1527 VPWR.t1012 VGND.t924 VPWR.t1012 VPWR.t0 sg13_lv_pmos ad=0.34p pd=2.68u as=0 ps=0 w=1u l=1u
X1528 a_13916_8728# sg13cmos5l_buf_16_22.X VPWR.t132 VPWR.t5 sg13_lv_pmos ad=0.2128p pd=1.5u as=0.2128p ps=1.5u w=1.12u l=0.13u
X1529 VPWR.t566 sg13cmos5l_buf_1_17.A a_10292_12934# VPWR.t79 sg13_lv_pmos ad=0.3808p pd=2.92u as=0.2128p ps=1.5u w=1.12u l=0.13u
X1530 sg13cmos5l_buf_16_5.X a_5108_838# VPWR.t56 VPWR.t55 sg13_lv_pmos ad=0.2128p pd=1.5u as=0.2128p ps=1.5u w=1.12u l=0.13u
X1531 VPWR.t471 sg13cmos5l_buf_16_10.A a_3668_3108# VPWR.t67 sg13_lv_pmos ad=0.2128p pd=1.5u as=0.2128p ps=1.5u w=1.12u l=0.13u
X1532 VGND.t171 a_7220_5374# sg13cmos5l_buf_16_28.A VGND.t335 sg13_lv_nmos ad=0.1406p pd=1.12u as=0.1406p ps=1.12u w=0.74u l=0.13u
X1533 sg13cmos5l_buf_16_38.A a_8110_6168# VPWR.t61 VPWR.t61 sg13_lv_pmos ad=0.2128p pd=1.5u as=0.2128p ps=1.5u w=1.12u l=0.13u
X1534 VGND.t210 a_9524_6886# sg13cmos5l_buf_16_4.X VGND.t558 sg13_lv_nmos ad=0.1406p pd=1.12u as=0.1406p ps=1.12u w=0.74u l=0.13u
X1535 VPWR.t1414 a_6548_13692# sg13cmos5l_buf_16_27.X VPWR.t79 sg13_lv_pmos ad=0.2128p pd=1.5u as=0.2128p ps=1.5u w=1.12u l=0.13u
X1536 VPWR.t578 a_5684_6132# sg13cmos5l_buf_16_28.X VPWR.t61 sg13_lv_pmos ad=0.2128p pd=1.5u as=0.2128p ps=1.5u w=1.12u l=0.13u
X1537 sg13cmos5l_buf_16_2.A a_9262_7680# VGND.t5 VGND.t110 sg13_lv_nmos ad=0.1406p pd=1.12u as=0.1406p ps=1.12u w=0.74u l=0.13u
X1538 sg13cmos5l_buf_16_23.X a_10292_12934# VGND.t676 VGND.t677 sg13_lv_nmos ad=0.1406p pd=1.12u as=0.1406p ps=1.12u w=0.74u l=0.13u
X1539 VGND.t66 a_6836_9156# sg13cmos5l_buf_16_25.A VGND.t154 sg13_lv_nmos ad=0.1406p pd=1.12u as=0.1406p ps=1.12u w=0.74u l=0.13u
X1540 VPWR.t6 VGND.t1061 VPWR.t6 VPWR.t5 sg13_lv_pmos ad=0.34p pd=2.68u as=0 ps=0 w=1u l=1u
X1541 VGND.t125 a_6094_3898# sg13cmos5l_buf_16_0.A VGND.t40 sg13_lv_nmos ad=0.1406p pd=1.12u as=0.1406p ps=1.12u w=0.74u l=0.13u
X1542 VGND.t1010 VPWR.t3 VGND.t1018 VGND.t2 sg13_lv_nmos ad=79.8f pd=0.8u as=0 ps=0 w=0.42u l=1u
X1543 sg13cmos5l_buf_16_3.X a_10292_4620# VPWR.t143 VPWR.t64 sg13_lv_pmos ad=0.2128p pd=1.5u as=0.2128p ps=1.5u w=1.12u l=0.13u
X1544 sg13cmos5l_and2_2_6.A a_3694_10704# VPWR.t1208 VPWR.t2 sg13_lv_pmos ad=0.2128p pd=1.5u as=0.2128p ps=1.5u w=1.12u l=0.13u
X1545 sg13cmos5l_buf_16_33.A a_3694_14482# VGND.t870 VGND.t887 sg13_lv_nmos ad=0.1406p pd=1.12u as=0.1406p ps=1.12u w=0.74u l=0.13u
X1546 VGND.t61 sg13cmos5l_buf_16_25.A a_6766_8434# VGND.t281 sg13_lv_nmos ad=0.1406p pd=1.12u as=0.1406p ps=1.12u w=0.74u l=0.13u
X1547 VPWR.t56 a_5108_838# sg13cmos5l_buf_16_5.X VPWR.t55 sg13_lv_pmos ad=0.2128p pd=1.5u as=0.2128p ps=1.5u w=1.12u l=0.13u
X1548 sg13cmos5l_buf_16_4.X a_9524_6886# VGND.t210 VGND.t555 sg13_lv_nmos ad=0.1406p pd=1.12u as=0.1406p ps=1.12u w=0.74u l=0.13u
X1549 VPWR.t81 VGND.t513 VPWR.t81 VPWR.t79 sg13_lv_pmos ad=0.34p pd=2.68u as=0 ps=0 w=1u l=1u
X1550 VPWR.t460 VGND.t1050 VPWR.t459 VPWR.t5 sg13_lv_pmos ad=0.34p pd=2.68u as=0 ps=0 w=1u l=1u
X1551 VPWR.t21 VGND.t1010 VPWR.t21 VPWR.t8 sg13_lv_pmos ad=0.19p pd=1.38u as=0 ps=0 w=1u l=1u
X1552 VGND.t994 VPWR.t1666 VGND.t994 VGND.t2 sg13_lv_nmos ad=0.1428p pd=1.52u as=0 ps=0 w=0.42u l=1u
X1553 VPWR.t451 VGND.t1050 VPWR.t450 VPWR.t2 sg13_lv_pmos ad=0.34p pd=2.68u as=0 ps=0 w=1u l=1u
X1554 sg13cmos5l_buf_16_0.A a_6094_3898# VGND.t125 VGND.t40 sg13_lv_nmos ad=0.1406p pd=1.12u as=0.1406p ps=1.12u w=0.74u l=0.13u
X1555 VGND.t1208 VPWR.t110 VGND.t1208 VGND.t1229 sg13_lv_nmos ad=0.1428p pd=1.52u as=0 ps=0 w=0.42u l=1u
X1556 VPWR.t566 a_10292_12934# sg13cmos5l_buf_16_23.X VPWR.t79 sg13_lv_pmos ad=0.2128p pd=1.5u as=0.2128p ps=1.5u w=1.12u l=0.13u
X1557 VPWR.t566 sg13cmos5l_buf_1_17.A a_10292_12934# VPWR.t79 sg13_lv_pmos ad=0.2128p pd=1.5u as=0.2128p ps=1.5u w=1.12u l=0.13u
X1558 VGND.t42 VPWR.t1618 VGND.t42 VGND.t40 sg13_lv_nmos ad=0.1428p pd=1.52u as=0 ps=0 w=0.42u l=1u
X1559 VPWR.t713 a_7220_5374# sg13cmos5l_buf_16_28.A VPWR.t61 sg13_lv_pmos ad=0.2128p pd=1.5u as=0.2128p ps=1.5u w=1.12u l=0.13u
X1560 sg13cmos5l_buf_16_15.X a_3668_12180# VPWR.t824 VPWR.t8 sg13_lv_pmos ad=0.2128p pd=1.5u as=0.2128p ps=1.5u w=1.12u l=0.13u
X1561 VGND.t237 VPWR.t131 VGND.t513 VGND.t957 sg13_lv_nmos ad=79.8f pd=0.8u as=0 ps=0 w=0.42u l=1u
X1562 VPWR.t1410 a_6548_13692# sg13cmos5l_buf_16_27.X VPWR.t79 sg13_lv_pmos ad=0.2128p pd=1.5u as=0.2128p ps=1.5u w=1.12u l=0.13u
X1563 sg13cmos5l_buf_16_23.X a_10292_12934# VGND.t590 VGND.t672 sg13_lv_nmos ad=0.1406p pd=1.12u as=0.1406p ps=1.12u w=0.74u l=0.13u
X1564 VPWR.t468 a_3668_3108# sg13cmos5l_buf_16_7.A VPWR.t67 sg13_lv_pmos ad=0.2128p pd=1.5u as=0.2128p ps=1.5u w=1.12u l=0.13u
X1565 VGND.t302 a_8494_3144# sg13cmos5l_buf_16_39.A VGND.t40 sg13_lv_nmos ad=0.1406p pd=1.12u as=0.1406p ps=1.12u w=0.74u l=0.13u
X1566 VGND.t42 VPWR.t110 VGND.t41 VGND.t40 sg13_lv_nmos ad=0.1428p pd=1.52u as=0 ps=0 w=0.42u l=1u
X1567 a_5204_11422# sg13cmos5l_buf_16_19.A VPWR.t623 VPWR.t8 sg13_lv_pmos ad=0.2128p pd=1.5u as=0.2128p ps=1.5u w=1.12u l=0.13u
X1568 a_13745_11508# sg13cmos5l_buf_1_15.X VGND.t3 VGND.t2 sg13_lv_nmos ad=0.17462p pd=1.185u as=0.374p ps=2.46u w=0.55u l=0.13u
X1569 VPWR.t842 a_6862_9946# sg13cmos5l_buf_16_24.X VPWR.t2 sg13_lv_pmos ad=0.2128p pd=1.5u as=0.2128p ps=1.5u w=1.12u l=0.13u
X1570 VGND.t86 a_10318_5410# sg13cmos5l_buf_16_1.X VGND.t85 sg13_lv_nmos ad=0.1406p pd=1.12u as=0.1406p ps=1.12u w=0.74u l=0.13u
X1571 VPWR.t612 VGND.t1141 VPWR.t611 VPWR.t61 sg13_lv_pmos ad=0.34p pd=2.68u as=0 ps=0 w=1u l=1u
X1572 sg13cmos5l_and2_2_3.B a_13576_14516# VPWR.t78 VPWR.t0 sg13_lv_pmos ad=0.42p pd=2.99u as=0.2114p ps=1.54u w=1.12u l=0.13u
X1573 VGND.t351 sg13cmos5l_buf_16_11.A a_3668_4620# VGND.t1560 sg13_lv_nmos ad=0.1406p pd=1.12u as=0.1406p ps=1.12u w=0.74u l=0.13u
X1574 sg13cmos5l_buf_16_28.A a_7220_5374# VPWR.t709 VPWR.t61 sg13_lv_pmos ad=0.2128p pd=1.5u as=0.2128p ps=1.5u w=1.12u l=0.13u
X1575 sg13cmos5l_buf_16_33.A a_3694_14482# VPWR.t1345 VPWR.t0 sg13_lv_pmos ad=0.2128p pd=1.5u as=0.2128p ps=1.5u w=1.12u l=0.13u
X1576 VPWR.t374 VGND.t5 VPWR.t373 VPWR.t5 sg13_lv_pmos ad=0.34p pd=2.68u as=0 ps=0 w=1u l=1u
X1577 VGND.t351 a_4462_5410# sg13cmos5l_buf_16_11.A VGND.t430 sg13_lv_nmos ad=0.1406p pd=1.12u as=0.1406p ps=1.12u w=0.74u l=0.13u
X1578 VGND.t125 a_6094_3144# sg13cmos5l_xor2_1_0.B VGND.t40 sg13_lv_nmos ad=0.1406p pd=1.12u as=0.1406p ps=1.12u w=0.74u l=0.13u
X1579 VPWR.t430 VGND.t1010 VPWR.t430 VPWR.t2 sg13_lv_pmos ad=0.34p pd=2.68u as=0 ps=0 w=1u l=1u
X1580 sg13cmos5l_buf_16_10.A a_3694_3898# VPWR.t1535 VPWR.t64 sg13_lv_pmos ad=0.2128p pd=1.5u as=0.2128p ps=1.5u w=1.12u l=0.13u
X1581 VGND.t310 sg13cmos5l_buf_16_8.A a_3694_3898# VGND.t40 sg13_lv_nmos ad=0.1406p pd=1.12u as=0.1406p ps=1.12u w=0.74u l=0.13u
X1582 sg13cmos5l_buf_16_15.X a_3668_12180# VPWR.t820 VPWR.t8 sg13_lv_pmos ad=0.2128p pd=1.5u as=0.2128p ps=1.5u w=1.12u l=0.13u
X1583 sg13cmos5l_buf_16_35.A a_6766_8434# VPWR.t656 VPWR.t5 sg13_lv_pmos ad=0.2128p pd=1.5u as=0.2128p ps=1.5u w=1.12u l=0.13u
X1584 VPWR.t120 VGND.t41 VPWR.t120 VPWR.t67 sg13_lv_pmos ad=0.19p pd=1.38u as=0 ps=0 w=1u l=1u
X1585 VGND.t942 VPWR.t1689 VGND.t942 VGND.t944 sg13_lv_nmos ad=0.1428p pd=1.52u as=0 ps=0 w=0.42u l=1u
X1586 sg13cmos5l_buf_16_20.A a_5204_11422# VPWR.t485 VPWR.t8 sg13_lv_pmos ad=0.2128p pd=1.5u as=0.2128p ps=1.5u w=1.12u l=0.13u
X1587 VPWR.t838 a_6862_9946# sg13cmos5l_buf_16_24.X VPWR.t2 sg13_lv_pmos ad=0.2128p pd=1.5u as=0.2128p ps=1.5u w=1.12u l=0.13u
X1588 VGND.t1196 VPWR.t1626 VGND.t1196 VGND.t1201 sg13_lv_nmos ad=79.8f pd=0.8u as=0 ps=0 w=0.42u l=1u
X1589 sg13cmos5l_buf_16_2.A a_9262_7680# VGND.t5 VGND.t106 sg13_lv_nmos ad=0.1406p pd=1.12u as=0.1406p ps=1.12u w=0.74u l=0.13u
X1590 a_14010_8446# sg13cmos5l_buf_16_2.A VGND.t35 VGND.t299 sg13_lv_nmos ad=88.8f pd=0.98u as=0.15245p ps=1.17u w=0.74u l=0.13u
X1591 VPWR.t1020 VGND.t989 VPWR.t1018 VPWR.t8 sg13_lv_pmos ad=0.19p pd=1.38u as=0 ps=0 w=1u l=1u
X1592 VPWR.t654 sg13cmos5l_buf_16_25.A a_6766_8434# VPWR.t5 sg13_lv_pmos ad=0.2128p pd=1.5u as=0.2128p ps=1.5u w=1.12u l=0.13u
X1593 VPWR.t1372 a_4174_13728# sg13cmos5l_buf_16_18.A VPWR.t79 sg13_lv_pmos ad=0.2128p pd=1.5u as=0.2128p ps=1.5u w=1.12u l=0.13u
X1594 VPWR.t3 VGND.t1073 VPWR.t3 VPWR.t2 sg13_lv_pmos ad=0.34p pd=2.68u as=0 ps=0 w=1u l=1u
X1595 VPWR.t642 a_3668_9156# sg13cmos5l_buf_16_13.A VPWR.t5 sg13_lv_pmos ad=0.2128p pd=1.5u as=0.2128p ps=1.5u w=1.12u l=0.13u
X1596 sg13cmos5l_buf_16_1.X a_10318_5410# VPWR.t85 VPWR.t61 sg13_lv_pmos ad=0.2128p pd=1.5u as=0.2128p ps=1.5u w=1.12u l=0.13u
X1597 VGND.t1141 VPWR.t1634 VGND.t1141 VGND.t1140 sg13_lv_nmos ad=0.1428p pd=1.52u as=0 ps=0 w=0.42u l=1u
X1598 VGND.t139 a_6094_10704# sg13cmos5l_buf_16_24.A VGND.t2 sg13_lv_nmos ad=0.1406p pd=1.12u as=0.1406p ps=1.12u w=0.74u l=0.13u
X1599 VGND.t198 a_3694_2386# sg13cmos5l_buf_16_7.X VGND.t1572 sg13_lv_nmos ad=0.1406p pd=1.12u as=0.1406p ps=1.12u w=0.74u l=0.13u
X1600 VPWR.t56 a_5108_838# sg13cmos5l_buf_16_5.X VPWR.t55 sg13_lv_pmos ad=0.2128p pd=1.5u as=0.2128p ps=1.5u w=1.12u l=0.13u
X1601 VGND.t66 sg13cmos5l_buf_16_20.A a_4436_9910# VGND.t714 sg13_lv_nmos ad=0.1406p pd=1.12u as=0.1406p ps=1.12u w=0.74u l=0.13u
X1602 VGND.t125 a_6094_3144# sg13cmos5l_xor2_1_0.B VGND.t40 sg13_lv_nmos ad=0.1406p pd=1.12u as=0.1406p ps=1.12u w=0.74u l=0.13u
X1603 VGND.t103 a_9262_7680# sg13cmos5l_buf_16_2.A VGND.t102 sg13_lv_nmos ad=0.1406p pd=1.12u as=0.1406p ps=1.12u w=0.74u l=0.13u
X1604 sg13cmos5l_buf_16_15.X a_3668_12180# VPWR.t816 VPWR.t8 sg13_lv_pmos ad=0.2128p pd=1.5u as=0.2128p ps=1.5u w=1.12u l=0.13u
X1605 VGND.t1403 VPWR.t63 VGND.t1405 VGND.t1404 sg13_lv_nmos ad=79.8f pd=0.8u as=0 ps=0 w=0.42u l=1u
X1606 sg13cmos5l_buf_16_6.X a_5518_6922# VPWR.t909 VPWR.t58 sg13_lv_pmos ad=0.2128p pd=1.5u as=0.2128p ps=1.5u w=1.12u l=0.13u
X1607 VPWR.t143 a_10318_3898# sg13cmos5l_buf_16_2.X VPWR.t64 sg13_lv_pmos ad=0.3976p pd=2.95u as=0.2128p ps=1.5u w=1.12u l=0.13u
X1608 VGND.t210 a_8110_6168# sg13cmos5l_buf_16_38.A VGND.t789 sg13_lv_nmos ad=0.2516p pd=2.16u as=0.1406p ps=1.12u w=0.74u l=0.13u
X1609 a_4986_6526# sg13cmos5l_buf_16_8.A VGND.t218 VGND.t309 sg13_lv_nmos ad=88.8f pd=0.98u as=0.15245p ps=1.17u w=0.74u l=0.13u
X1610 VGND.t1061 VPWR.t28 VGND.t1061 VGND.t1062 sg13_lv_nmos ad=79.8f pd=0.8u as=0 ps=0 w=0.42u l=1u
X1611 VPWR.t1497 VGND.t1196 VPWR.t1495 VPWR.t61 sg13_lv_pmos ad=0.19p pd=1.38u as=0 ps=0 w=1u l=1u
X1612 VPWR.t0 VGND.t597 VPWR.t0 VPWR.t0 sg13_lv_pmos ad=0.19p pd=1.38u as=0 ps=0 w=1u l=1u
X1613 sg13cmos5l_buf_16_20.A a_5204_11422# VPWR.t482 VPWR.t8 sg13_lv_pmos ad=0.2128p pd=1.5u as=0.3976p ps=2.95u w=1.12u l=0.13u
X1614 VPWR.t205 sg13cmos5l_buf_1_2.A a_8104_1632# VPWR.t55 sg13_lv_pmos ad=0.2114p pd=1.54u as=0.2856p ps=2.36u w=0.84u l=0.13u
X1615 VPWR.t110 VGND.t41 VPWR.t110 VPWR.t64 sg13_lv_pmos ad=0.34p pd=2.68u as=0 ps=0 w=1u l=1u
X1616 VGND.t5 a_7629_8028# sg13cmos5l_and2_2_6.X VGND.t16 sg13_lv_nmos ad=0.2812p pd=2.24u as=0.1406p ps=1.12u w=0.74u l=0.13u
X1617 sg13cmos5l_buf_16_13.A a_3668_9156# VPWR.t638 VPWR.t5 sg13_lv_pmos ad=0.2128p pd=1.5u as=0.2128p ps=1.5u w=1.12u l=0.13u
X1618 VPWR.t85 a_10318_5410# sg13cmos5l_buf_16_1.X VPWR.t61 sg13_lv_pmos ad=0.2128p pd=1.5u as=0.2128p ps=1.5u w=1.12u l=0.13u
X1619 a_12054_14086# sg13cmos5l_buf_16_27.X sg13cmos5l_xor2_1_6.X VGND.t638 sg13_lv_nmos ad=88.8f pd=0.98u as=0.1628p ps=1.18u w=0.74u l=0.13u
X1620 out_xor[5] a_14824_10704# VPWR.t135 VPWR.t2 sg13_lv_pmos ad=0.42p pd=2.99u as=0.2114p ps=1.54u w=1.12u l=0.13u
X1621 sg13cmos5l_buf_16_7.X a_3694_2386# VGND.t198 VGND.t1569 sg13_lv_nmos ad=0.1406p pd=1.12u as=0.1406p ps=1.12u w=0.74u l=0.13u
X1622 VGND.t1237 VPWR.t1613 VGND.t1237 VGND.t40 sg13_lv_nmos ad=0.1428p pd=1.52u as=0 ps=0 w=0.42u l=1u
X1623 a_4436_9910# sg13cmos5l_buf_16_20.A VGND.t66 VGND.t711 sg13_lv_nmos ad=0.1406p pd=1.12u as=0.1406p ps=1.12u w=0.74u l=0.13u
X1624 sg13cmos5l_xor2_1_0.B a_6094_3144# VGND.t125 VGND.t40 sg13_lv_nmos ad=0.1406p pd=1.12u as=0.1406p ps=1.12u w=0.74u l=0.13u
X1625 VGND.t7 sg13cmos5l_buf_16_28.A a_5684_6132# VGND.t795 sg13_lv_nmos ad=0.2516p pd=2.16u as=0.1406p ps=1.12u w=0.74u l=0.13u
X1626 VPWR.t907 a_5518_6922# sg13cmos5l_buf_16_6.X VPWR.t58 sg13_lv_pmos ad=0.2128p pd=1.5u as=0.2128p ps=1.5u w=1.12u l=0.13u
X1627 sg13cmos5l_buf_16_2.X a_10318_3898# VPWR.t143 VPWR.t64 sg13_lv_pmos ad=0.2128p pd=1.5u as=0.2128p ps=1.5u w=1.12u l=0.13u
X1628 VGND.t302 sg13cmos5l_buf_16_2.A a_10318_3898# VGND.t40 sg13_lv_nmos ad=0.1406p pd=1.12u as=0.1406p ps=1.12u w=0.74u l=0.13u
X1629 VGND.t637 VPWR.t110 VGND.t349 VGND.t1231 sg13_lv_nmos ad=0.1428p pd=1.52u as=0 ps=0 w=0.42u l=1u
X1630 VPWR.t1368 a_4174_13728# sg13cmos5l_buf_16_18.A VPWR.t79 sg13_lv_pmos ad=0.2128p pd=1.5u as=0.2128p ps=1.5u w=1.12u l=0.13u
X1631 sg13cmos5l_buf_16_28.A a_7220_5374# VPWR.t706 VPWR.t61 sg13_lv_pmos ad=0.2128p pd=1.5u as=0.3976p ps=2.95u w=1.12u l=0.13u
X1632 VPWR.t80 VGND.t237 VPWR.t80 VPWR.t79 sg13_lv_pmos ad=0.34p pd=2.68u as=0 ps=0 w=1u l=1u
X1633 VGND.t139 sg13cmos5l_buf_16_33.A a_6094_10704# VGND.t2 sg13_lv_nmos ad=0.1406p pd=1.12u as=0.1406p ps=1.12u w=0.74u l=0.13u
X1634 VPWR.t81 VGND.t206 VPWR.t81 VPWR.t79 sg13_lv_pmos ad=0.34p pd=2.68u as=0 ps=0 w=1u l=1u
X1635 VGND.t37 VPWR.t135 VGND.t37 VGND.t1076 sg13_lv_nmos ad=79.8f pd=0.8u as=0 ps=0 w=0.42u l=1u
X1636 VGND.t7 a_5518_6922# sg13cmos5l_buf_16_6.X VGND.t542 sg13_lv_nmos ad=0.1406p pd=1.12u as=0.1406p ps=1.12u w=0.74u l=0.13u
X1637 VPWR.t219 sg13cmos5l_buf_16_39.A a_6164_2350# VPWR.t67 sg13_lv_pmos ad=0.2128p pd=1.5u as=0.2128p ps=1.5u w=1.12u l=0.13u
X1638 VPWR.t3 VGND.t1061 VPWR.t3 VPWR.t2 sg13_lv_pmos ad=0.34p pd=2.68u as=0 ps=0 w=1u l=1u
X1639 sg13cmos5l_buf_16_11.A a_4462_5410# VGND.t351 VGND.t423 sg13_lv_nmos ad=0.1406p pd=1.12u as=0.1406p ps=1.12u w=0.74u l=0.13u
X1640 VGND.t891 VPWR.t1697 VGND.t891 VGND.t902 sg13_lv_nmos ad=0.1428p pd=1.52u as=0 ps=0 w=0.42u l=1u
X1641 VPWR.t378 VGND.t5 VPWR.t377 VPWR.t5 sg13_lv_pmos ad=0.34p pd=2.68u as=0 ps=0 w=1u l=1u
X1642 VGND.t310 a_3668_3108# sg13cmos5l_buf_16_7.A VGND.t40 sg13_lv_nmos ad=0.1406p pd=1.12u as=0.1406p ps=1.12u w=0.74u l=0.13u
X1643 VPWR.t243 VGND.t1196 VPWR.t1506 VPWR.t61 sg13_lv_pmos ad=0.34p pd=2.68u as=0 ps=0 w=1u l=1u
X1644 VGND.t590 VPWR.t21 VGND.t590 VGND.t978 sg13_lv_nmos ad=0.1428p pd=1.52u as=0 ps=0 w=0.42u l=1u
X1645 a_3668_4620# sg13cmos5l_buf_16_11.A VPWR.t1575 VPWR.t64 sg13_lv_pmos ad=0.2128p pd=1.5u as=0.2128p ps=1.5u w=1.12u l=0.13u
X1646 sg13cmos5l_buf_1_5.X a_13768_5444# VGND.t349 VGND.t348 sg13_lv_nmos ad=0.2886p pd=2.26u as=0.14875p ps=1.16u w=0.74u l=0.13u
X1647 VPWR.t1364 a_4174_13728# sg13cmos5l_buf_16_18.A VPWR.t79 sg13_lv_pmos ad=0.2128p pd=1.5u as=0.2128p ps=1.5u w=1.12u l=0.13u
X1648 VPWR.t1180 sg13cmos5l_buf_16_20.A a_4436_9910# VPWR.t2 sg13_lv_pmos ad=0.3808p pd=2.92u as=0.2128p ps=1.5u w=1.12u l=0.13u
X1649 sg13cmos5l_buf_16_37.A a_8948_13692# VPWR.t1113 VPWR.t79 sg13_lv_pmos ad=0.2128p pd=1.5u as=0.3976p ps=2.95u w=1.12u l=0.13u
X1650 VPWR.t6 VGND.t1115 VPWR.t6 VPWR.t5 sg13_lv_pmos ad=0.19p pd=1.38u as=0 ps=0 w=1u l=1u
X1651 VPWR.t250 VGND.t1286 VPWR.t250 VPWR.t55 sg13_lv_pmos ad=0.34p pd=2.68u as=0 ps=0 w=1u l=1u
X1652 sg13cmos5l_buf_16_5.A a_5710_1632# VGND.t837 VGND.t856 sg13_lv_nmos ad=0.1406p pd=1.12u as=0.1406p ps=1.12u w=0.74u l=0.13u
X1653 VGND.t1010 VPWR.t129 VGND.t1010 VGND.t2 sg13_lv_nmos ad=79.8f pd=0.8u as=0 ps=0 w=0.42u l=1u
X1654 sg13cmos5l_buf_16_31.X a_6094_4656# VGND.t351 VGND.t353 sg13_lv_nmos ad=0.1406p pd=1.12u as=0.1406p ps=1.12u w=0.74u l=0.13u
X1655 VGND.t797 VPWR.t1625 VGND.t797 VGND.t1203 sg13_lv_nmos ad=79.8f pd=0.8u as=0 ps=0 w=0.42u l=1u
X1656 VGND.t39 sg13cmos5l_and2_2_3.B a_13675_9988# VGND.t1504 sg13_lv_nmos ad=0.1331p pd=1.12u as=0.1216p ps=1.02u w=0.64u l=0.13u
X1657 sg13cmos5l_buf_16_11.A a_4462_5410# VPWR.t796 VPWR.t61 sg13_lv_pmos ad=0.2128p pd=1.5u as=0.2128p ps=1.5u w=1.12u l=0.13u
X1658 sg13cmos5l_buf_16_15.X a_3668_12180# VGND.t444 VGND.t443 sg13_lv_nmos ad=0.1406p pd=1.12u as=0.2516p ps=2.16u w=0.74u l=0.13u
X1659 VGND.t18 sg13cmos5l_buf_16_13.A a_3694_8434# VGND.t21 sg13_lv_nmos ad=0.1406p pd=1.12u as=0.1406p ps=1.12u w=0.74u l=0.13u
X1660 a_11924_13728# a_11898_13691# sg13cmos5l_xor2_1_6.X VPWR.t79 sg13_lv_pmos ad=0.2128p pd=1.5u as=0.3808p ps=2.92u w=1.12u l=0.13u
X1661 VGND.t5 a_6766_8434# sg13cmos5l_buf_16_35.A VGND.t298 sg13_lv_nmos ad=0.2516p pd=2.16u as=0.1406p ps=1.12u w=0.74u l=0.13u
X1662 sg13cmos5l_buf_16_7.X a_3694_2386# VGND.t198 VGND.t1565 sg13_lv_nmos ad=0.1406p pd=1.12u as=0.1406p ps=1.12u w=0.74u l=0.13u
X1663 VPWR.t740 a_6094_3898# sg13cmos5l_buf_16_0.A VPWR.t64 sg13_lv_pmos ad=0.2128p pd=1.5u as=0.2128p ps=1.5u w=1.12u l=0.13u
X1664 VPWR.t335 a_9262_7680# sg13cmos5l_buf_16_2.A VPWR.t58 sg13_lv_pmos ad=0.2128p pd=1.5u as=0.2128p ps=1.5u w=1.12u l=0.13u
X1665 VGND.t351 sg13cmos5l_buf_16_7.X a_6094_4656# VGND.t436 sg13_lv_nmos ad=0.1406p pd=1.12u as=0.1406p ps=1.12u w=0.74u l=0.13u
X1666 VPWR.t1218 a_4436_9910# sg13cmos5l_buf_16_14.A VPWR.t2 sg13_lv_pmos ad=0.2128p pd=1.5u as=0.2128p ps=1.5u w=1.12u l=0.13u
X1667 VGND.t1274 VPWR.t1610 VGND.t1274 VGND.t1277 sg13_lv_nmos ad=79.8f pd=0.8u as=0 ps=0 w=0.42u l=1u
X1668 VPWR.t794 a_4462_5410# sg13cmos5l_buf_16_11.A VPWR.t61 sg13_lv_pmos ad=0.2128p pd=1.5u as=0.2128p ps=1.5u w=1.12u l=0.13u
X1669 a_3694_8434# sg13cmos5l_buf_16_13.A VGND.t18 VGND.t17 sg13_lv_nmos ad=0.1406p pd=1.12u as=0.2516p ps=2.16u w=0.74u l=0.13u
X1670 sg13cmos5l_xor2_1_0.B a_6094_3144# VPWR.t479 VPWR.t67 sg13_lv_pmos ad=0.2128p pd=1.5u as=0.2128p ps=1.5u w=1.12u l=0.13u
X1671 VGND.t96 sg13cmos5l_buf_16_0.A a_8494_3144# VGND.t40 sg13_lv_nmos ad=0.1406p pd=1.12u as=0.1406p ps=1.12u w=0.74u l=0.13u
X1672 VGND.t157 a_6862_9946# sg13cmos5l_buf_16_24.X VGND.t165 sg13_lv_nmos ad=0.1406p pd=1.12u as=0.1406p ps=1.12u w=0.74u l=0.13u
X1673 VPWR.t203 VGND.t841 VPWR.t201 VPWR.t79 sg13_lv_pmos ad=0.19p pd=1.38u as=0 ps=0 w=1u l=1u
X1674 sg13cmos5l_buf_16_35.A a_6766_8434# VGND.t5 VGND.t295 sg13_lv_nmos ad=0.1406p pd=1.12u as=0.1406p ps=1.12u w=0.74u l=0.13u
X1675 sg13cmos5l_buf_16_24.A a_6094_10704# VGND.t726 VGND.t2 sg13_lv_nmos ad=0.1406p pd=1.12u as=0.1406p ps=1.12u w=0.74u l=0.13u
X1676 a_6094_3898# enable VPWR.t1426 VPWR.t64 sg13_lv_pmos ad=0.2128p pd=1.5u as=0.2128p ps=1.5u w=1.12u l=0.13u
X1677 VPWR.t1518 VGND.t1196 VPWR.t1516 VPWR.t64 sg13_lv_pmos ad=0.19p pd=1.38u as=0 ps=0 w=1u l=1u
X1678 sg13cmos5l_buf_16_5.A a_5710_1632# VGND.t837 VGND.t852 sg13_lv_nmos ad=0.1406p pd=1.12u as=0.1406p ps=1.12u w=0.74u l=0.13u
X1679 a_13745_8484# sg13cmos5l_buf_16_22.X a_13713_8752# VPWR.t5 sg13_lv_pmos ad=0.34p pd=2.68u as=0.1225p ps=1.245u w=1u l=0.13u
X1680 a_6164_2350# sg13cmos5l_buf_16_39.A VGND.t25 VGND.t29 sg13_lv_nmos ad=0.1406p pd=1.12u as=0.1406p ps=1.12u w=0.74u l=0.13u
X1681 sg13cmos5l_buf_16_28.X a_5684_6132# VGND.t7 VGND.t234 sg13_lv_nmos ad=0.1406p pd=1.12u as=0.1406p ps=1.12u w=0.74u l=0.13u
X1682 VPWR.t131 VGND.t1019 VPWR.t131 VPWR.t8 sg13_lv_pmos ad=0.19p pd=1.38u as=0 ps=0 w=1u l=1u
X1683 VPWR.t1555 a_6164_2350# sg13cmos5l_buf_16_30.A VPWR.t67 sg13_lv_pmos ad=0.2128p pd=1.5u as=0.2128p ps=1.5u w=1.12u l=0.13u
X1684 sg13cmos5l_buf_16_11.A a_4462_5410# VPWR.t791 VPWR.t61 sg13_lv_pmos ad=0.2128p pd=1.5u as=0.2128p ps=1.5u w=1.12u l=0.13u
X1685 VPWR.t477 sg13cmos5l_buf_16_5.X a_6094_3144# VPWR.t67 sg13_lv_pmos ad=0.2128p pd=1.5u as=0.2128p ps=1.5u w=1.12u l=0.13u
X1686 VGND.t620 sg13cmos5l_buf_16_15.A a_3668_12180# VGND.t701 sg13_lv_nmos ad=0.1406p pd=1.12u as=0.1406p ps=1.12u w=0.74u l=0.13u
X1687 VGND.t620 sg13cmos5l_buf_16_18.A a_4052_12934# VGND.t641 sg13_lv_nmos ad=0.1406p pd=1.12u as=0.1406p ps=1.12u w=0.74u l=0.13u
X1688 VGND.t1010 VPWR.t430 VGND.t1010 VGND.t2 sg13_lv_nmos ad=0.1428p pd=1.52u as=0 ps=0 w=0.42u l=1u
X1689 VPWR.t1214 a_4436_9910# sg13cmos5l_buf_16_14.A VPWR.t2 sg13_lv_pmos ad=0.2128p pd=1.5u as=0.2128p ps=1.5u w=1.12u l=0.13u
X1690 VGND.t994 VPWR.t1674 VGND.t994 VGND.t2 sg13_lv_nmos ad=79.8f pd=0.8u as=0 ps=0 w=0.42u l=1u
X1691 sg13cmos5l_buf_16_30.A a_6164_2350# VPWR.t1551 VPWR.t67 sg13_lv_pmos ad=0.2128p pd=1.5u as=0.2128p ps=1.5u w=1.12u l=0.13u
X1692 a_3668_4620# sg13cmos5l_buf_16_11.A VPWR.t1291 VPWR.t64 sg13_lv_pmos ad=0.2128p pd=1.5u as=0.2128p ps=1.5u w=1.12u l=0.13u
X1693 VPWR.t335 a_9524_6886# sg13cmos5l_buf_16_4.X VPWR.t58 sg13_lv_pmos ad=0.2128p pd=1.5u as=0.2128p ps=1.5u w=1.12u l=0.13u
X1694 out_xor[3] a_14824_6956# VGND.t532 VGND.t773 sg13_lv_nmos ad=0.2886p pd=2.26u as=0.14875p ps=1.16u w=0.74u l=0.13u
X1695 VPWR.t958 VGND.t948 VPWR.t957 VPWR.t8 sg13_lv_pmos ad=0.34p pd=2.68u as=0 ps=0 w=1u l=1u
X1696 VGND.t843 sg13cmos5l_buf_1_2.X a_14824_1632# VGND.t868 sg13_lv_nmos ad=0.14875p pd=1.16u as=0.187p ps=1.78u w=0.55u l=0.13u
X1697 VGND.t1196 VPWR.t1628 VGND.t1196 VGND.t1197 sg13_lv_nmos ad=79.8f pd=0.8u as=0 ps=0 w=0.42u l=1u
X1698 VPWR.t928 VGND.t989 VPWR.t1034 VPWR.t2 sg13_lv_pmos ad=0.34p pd=2.68u as=0 ps=0 w=1u l=1u
X1699 VPWR.t455 VGND.t1050 VPWR.t454 VPWR.t2 sg13_lv_pmos ad=0.34p pd=2.68u as=0 ps=0 w=1u l=1u
X1700 VPWR.t226 VGND.t843 VPWR.t226 VPWR.t55 sg13_lv_pmos ad=0.19p pd=1.38u as=0 ps=0 w=1u l=1u
X1701 a_6094_3144# sg13cmos5l_buf_16_5.X VPWR.t474 VPWR.t67 sg13_lv_pmos ad=0.2128p pd=1.5u as=0.3808p ps=2.92u w=1.12u l=0.13u
X1702 VGND.t597 VPWR.t47 VGND.t597 VGND.t907 sg13_lv_nmos ad=0.1428p pd=1.52u as=0 ps=0 w=0.42u l=1u
X1703 VPWR.t588 a_5684_6132# sg13cmos5l_buf_16_28.X VPWR.t61 sg13_lv_pmos ad=0.2128p pd=1.5u as=0.2128p ps=1.5u w=1.12u l=0.13u
X1704 VPWR.t80 VGND.t206 VPWR.t81 VPWR.t79 sg13_lv_pmos ad=0.19p pd=1.38u as=0 ps=0 w=1u l=1u
X1705 VGND.t171 a_7220_5374# sg13cmos5l_buf_16_28.A VGND.t347 sg13_lv_nmos ad=0.1406p pd=1.12u as=0.1406p ps=1.12u w=0.74u l=0.13u
X1706 a_3694_14482# sg13cmos5l_buf_16_15.X VPWR.t1326 VPWR.t0 sg13_lv_pmos ad=0.2128p pd=1.5u as=0.2128p ps=1.5u w=1.12u l=0.13u
X1707 sg13cmos5l_buf_16_33.A a_3694_14482# VPWR.t1339 VPWR.t0 sg13_lv_pmos ad=0.2128p pd=1.5u as=0.2128p ps=1.5u w=1.12u l=0.13u
X1708 VGND.t61 VPWR.t1645 VGND.t61 VGND.t1130 sg13_lv_nmos ad=79.8f pd=0.8u as=0 ps=0 w=0.42u l=1u
X1709 VGND.t93 VPWR.t64 VGND.t93 VGND.t40 sg13_lv_nmos ad=0.1428p pd=1.52u as=0 ps=0 w=0.42u l=1u
X1710 sg13cmos5l_buf_16_4.X a_9524_6886# VPWR.t335 VPWR.t58 sg13_lv_pmos ad=0.2128p pd=1.5u as=0.2128p ps=1.5u w=1.12u l=0.13u
X1711 a_3694_7680# sg13cmos5l_buf_16_34.A VGND.t18 VGND.t20 sg13_lv_nmos ad=0.1406p pd=1.12u as=0.1406p ps=1.12u w=0.74u l=0.13u
X1712 VPWR.t146 a_6766_8434# sg13cmos5l_buf_16_35.A VPWR.t5 sg13_lv_pmos ad=0.2128p pd=1.5u as=0.2128p ps=1.5u w=1.12u l=0.13u
X1713 VGND.t457 a_4052_12934# sg13cmos5l_buf_16_15.A VGND.t617 sg13_lv_nmos ad=0.1406p pd=1.12u as=0.1406p ps=1.12u w=0.74u l=0.13u
X1714 VPWR.t56 sg13cmos5l_buf_16_5.A a_5108_838# VPWR.t55 sg13_lv_pmos ad=0.2128p pd=1.5u as=0.2128p ps=1.5u w=1.12u l=0.13u
X1715 a_9524_6886# sg13cmos5l_buf_16_4.A VGND.t210 VGND.t212 sg13_lv_nmos ad=0.1406p pd=1.12u as=0.1406p ps=1.12u w=0.74u l=0.13u
X1716 VGND.t1359 VPWR.t86 VGND.t1361 VGND.t1360 sg13_lv_nmos ad=79.8f pd=0.8u as=0 ps=0 w=0.42u l=1u
X1717 sg13cmos5l_buf_16_28.A a_7220_5374# VGND.t171 VGND.t344 sg13_lv_nmos ad=0.1406p pd=1.12u as=0.1406p ps=1.12u w=0.74u l=0.13u
X1718 a_5204_11422# sg13cmos5l_buf_16_19.A VGND.t139 VGND.t2 sg13_lv_nmos ad=0.1406p pd=1.12u as=0.1406p ps=1.12u w=0.74u l=0.13u
X1719 sg13cmos5l_buf_16_0.A a_6094_3898# VGND.t125 VGND.t40 sg13_lv_nmos ad=0.1406p pd=1.12u as=0.1406p ps=1.12u w=0.74u l=0.13u
X1720 VGND.t351 sg13cmos5l_buf_16_7.X a_6094_4656# VGND.t432 sg13_lv_nmos ad=0.1406p pd=1.12u as=0.1406p ps=1.12u w=0.74u l=0.13u
X1721 VPWR.t335 a_9524_6886# sg13cmos5l_buf_16_4.X VPWR.t58 sg13_lv_pmos ad=0.2128p pd=1.5u as=0.2128p ps=1.5u w=1.12u l=0.13u
X1722 sg13cmos5l_buf_16_25.A a_6836_9156# VGND.t157 VGND.t164 sg13_lv_nmos ad=0.1406p pd=1.12u as=0.1406p ps=1.12u w=0.74u l=0.13u
X1723 VPWR.t519 VGND.t1296 VPWR.t63 VPWR.t55 sg13_lv_pmos ad=0.19p pd=1.38u as=0 ps=0 w=1u l=1u
X1724 a_14010_11470# sg13cmos5l_buf_1_15.X VGND.t3 VGND.t2 sg13_lv_nmos ad=88.8f pd=0.98u as=0.15245p ps=1.17u w=0.74u l=0.13u
X1725 VPWR.t143 sg13cmos5l_buf_16_2.X a_10292_4620# VPWR.t64 sg13_lv_pmos ad=0.3808p pd=2.92u as=0.2128p ps=1.5u w=1.12u l=0.13u
X1726 VGND.t5 sg13cmos5l_buf_16_1.X a_10318_8434# VGND.t1523 sg13_lv_nmos ad=0.1406p pd=1.12u as=0.1406p ps=1.12u w=0.74u l=0.13u
X1727 VGND.t590 a_10292_12934# sg13cmos5l_buf_16_23.X VGND.t673 sg13_lv_nmos ad=0.1406p pd=1.12u as=0.1406p ps=1.12u w=0.74u l=0.13u
X1728 VGND.t157 a_6862_9946# sg13cmos5l_buf_16_24.X VGND.t161 sg13_lv_nmos ad=0.1406p pd=1.12u as=0.1406p ps=1.12u w=0.74u l=0.13u
X1729 VPWR.t120 VGND.t41 VPWR.t120 VPWR.t67 sg13_lv_pmos ad=0.34p pd=2.68u as=0 ps=0 w=1u l=1u
X1730 VGND.t93 sg13cmos5l_buf_16_0.A a_8494_3144# VGND.t40 sg13_lv_nmos ad=0.1406p pd=1.12u as=0.1406p ps=1.12u w=0.74u l=0.13u
X1731 sg13cmos5l_buf_16_5.X a_5108_838# VPWR.t56 VPWR.t55 sg13_lv_pmos ad=0.2128p pd=1.5u as=0.2128p ps=1.5u w=1.12u l=0.13u
X1732 VGND.t171 a_7220_5374# sg13cmos5l_buf_16_28.A VGND.t341 sg13_lv_nmos ad=0.1406p pd=1.12u as=0.1406p ps=1.12u w=0.74u l=0.13u
X1733 VPWR.t604 VGND.t1141 VPWR.t603 VPWR.t61 sg13_lv_pmos ad=0.34p pd=2.68u as=0 ps=0 w=1u l=1u
X1734 VGND.t210 a_9524_6886# sg13cmos5l_buf_16_4.X VGND.t564 sg13_lv_nmos ad=0.1406p pd=1.12u as=0.1406p ps=1.12u w=0.74u l=0.13u
X1735 VGND.t797 VPWR.t1625 VGND.t1196 VGND.t1202 sg13_lv_nmos ad=0.1428p pd=1.52u as=0 ps=0 w=0.42u l=1u
X1736 sg13cmos5l_buf_16_2.A a_9262_7680# VPWR.t335 VPWR.t58 sg13_lv_pmos ad=0.2128p pd=1.5u as=0.2128p ps=1.5u w=1.12u l=0.13u
X1737 VGND.t597 sg13cmos5l_buf_16_37.X a_6548_13692# VGND.t1515 sg13_lv_nmos ad=0.1406p pd=1.12u as=0.1406p ps=1.12u w=0.74u l=0.13u
X1738 VPWR.t584 a_5684_6132# sg13cmos5l_buf_16_28.X VPWR.t61 sg13_lv_pmos ad=0.2128p pd=1.5u as=0.2128p ps=1.5u w=1.12u l=0.13u
X1739 sg13cmos5l_buf_16_15.A a_4052_12934# VPWR.t1081 VPWR.t79 sg13_lv_pmos ad=0.2128p pd=1.5u as=0.2128p ps=1.5u w=1.12u l=0.13u
X1740 a_10292_4620# sg13cmos5l_buf_16_2.X VPWR.t143 VPWR.t64 sg13_lv_pmos ad=0.2128p pd=1.5u as=0.2128p ps=1.5u w=1.12u l=0.13u
X1741 VPWR.t1347 a_3694_14482# sg13cmos5l_buf_16_33.A VPWR.t0 sg13_lv_pmos ad=0.3976p pd=2.95u as=0.2128p ps=1.5u w=1.12u l=0.13u
X1742 a_7220_5374# sg13cmos5l_buf_16_38.A VPWR.t61 VPWR.t61 sg13_lv_pmos ad=0.2128p pd=1.5u as=0.2128p ps=1.5u w=1.12u l=0.13u
X1743 VPWR.t1481 VGND.t1274 VPWR.t1479 VPWR.t67 sg13_lv_pmos ad=0.19p pd=1.38u as=0 ps=0 w=1u l=1u
X1744 a_6862_9946# sg13cmos5l_buf_16_24.A VGND.t157 VGND.t158 sg13_lv_nmos ad=0.1406p pd=1.12u as=0.1406p ps=1.12u w=0.74u l=0.13u
X1745 VPWR.t1184 a_6094_10704# sg13cmos5l_buf_16_24.A VPWR.t2 sg13_lv_pmos ad=0.2128p pd=1.5u as=0.2128p ps=1.5u w=1.12u l=0.13u
X1746 VGND.t513 VPWR.t81 VGND.t513 VGND.t958 sg13_lv_nmos ad=0.1428p pd=1.52u as=0 ps=0 w=0.42u l=1u
X1747 sg13cmos5l_buf_16_20.A a_5204_11422# VGND.t139 VGND.t2 sg13_lv_nmos ad=0.1406p pd=1.12u as=0.1406p ps=1.12u w=0.74u l=0.13u
X1748 VGND.t1354 VPWR.t99 VGND.t1356 VGND.t1355 sg13_lv_nmos ad=79.8f pd=0.8u as=0 ps=0 w=0.42u l=1u
X1749 a_4721_6526# sg13cmos5l_buf_16_31.X a_4689_6168# VPWR.t61 sg13_lv_pmos ad=0.34p pd=2.68u as=0.1225p ps=1.245u w=1u l=0.13u
X1750 VGND.t1061 VPWR.t28 VGND.t1061 VGND.t1063 sg13_lv_nmos ad=0.1428p pd=1.52u as=0 ps=0 w=0.42u l=1u
X1751 VGND.t1050 VPWR.t1658 VGND.t1050 VGND.t1052 sg13_lv_nmos ad=0.1428p pd=1.52u as=0 ps=0 w=0.42u l=1u
X1752 VPWR.t86 VGND.t1356 VPWR.t99 VPWR.t55 sg13_lv_pmos ad=0.19p pd=1.38u as=0 ps=0 w=1u l=1u
X1753 VPWR.t719 a_7220_5374# sg13cmos5l_buf_16_28.A VPWR.t61 sg13_lv_pmos ad=0.2128p pd=1.5u as=0.2128p ps=1.5u w=1.12u l=0.13u
X1754 VPWR.t1499 VGND.t1196 VPWR.t1498 VPWR.t61 sg13_lv_pmos ad=0.34p pd=2.68u as=0 ps=0 w=1u l=1u
X1755 VGND.t1147 VPWR.t1629 VGND.t1147 VGND.t1180 sg13_lv_nmos ad=0.1428p pd=1.52u as=0 ps=0 w=0.42u l=1u
X1756 VPWR.t541 VGND.t942 VPWR.t540 VPWR.t79 sg13_lv_pmos ad=0.34p pd=2.68u as=0 ps=0 w=1u l=1u
X1757 VGND.t891 a_6548_13692# sg13cmos5l_buf_16_27.X VGND.t1480 sg13_lv_nmos ad=0.1406p pd=1.12u as=0.1406p ps=1.12u w=0.74u l=0.13u
X1758 VGND.t597 a_6548_13692# sg13cmos5l_buf_16_27.X VGND.t1492 sg13_lv_nmos ad=0.1406p pd=1.12u as=0.1406p ps=1.12u w=0.74u l=0.13u
X1759 VGND.t5 sg13cmos5l_buf_16_1.X a_10318_8434# VGND.t1519 sg13_lv_nmos ad=0.1406p pd=1.12u as=0.1406p ps=1.12u w=0.74u l=0.13u
X1760 VPWR.t64 VGND.t93 VPWR.t247 VPWR.t64 sg13_lv_pmos ad=0.34p pd=2.68u as=0 ps=0 w=1u l=1u
X1761 sg13cmos5l_buf_16_15.A a_4052_12934# VPWR.t1077 VPWR.t79 sg13_lv_pmos ad=0.2128p pd=1.5u as=0.2128p ps=1.5u w=1.12u l=0.13u
X1762 VGND.t590 a_7796_12934# sg13cmos5l_buf_16_37.X VGND.t683 sg13_lv_nmos ad=0.1406p pd=1.12u as=0.1406p ps=1.12u w=0.74u l=0.13u
X1763 VGND.t37 VPWR.t132 VGND.t37 VGND.t1098 sg13_lv_nmos ad=0.1428p pd=1.52u as=0 ps=0 w=0.42u l=1u
X1764 VPWR.t1343 a_3694_14482# sg13cmos5l_buf_16_33.A VPWR.t0 sg13_lv_pmos ad=0.2128p pd=1.5u as=0.2128p ps=1.5u w=1.12u l=0.13u
X1765 sg13cmos5l_buf_16_22.X a_10318_8434# VPWR.t440 VPWR.t5 sg13_lv_pmos ad=0.2128p pd=1.5u as=0.2128p ps=1.5u w=1.12u l=0.13u
X1766 VPWR.t667 a_6766_8434# sg13cmos5l_buf_16_35.A VPWR.t5 sg13_lv_pmos ad=0.2128p pd=1.5u as=0.2128p ps=1.5u w=1.12u l=0.13u
X1767 VGND.t924 a_14444_14442# sg13cmos5l_and2_2_4.B VGND.t1505 sg13_lv_nmos ad=0.14875p pd=1.16u as=0.2886p ps=2.26u w=0.74u l=0.13u
X1768 VPWR.t306 sg13cmos5l_buf_16_14.A a_3668_9156# VPWR.t5 sg13_lv_pmos ad=0.2128p pd=1.5u as=0.2128p ps=1.5u w=1.12u l=0.13u
X1769 VGND.t206 sg13cmos5l_buf_1_17.X a_11898_13691# VGND.t205 sg13_lv_nmos ad=0.374p pd=2.46u as=0.17462p ps=1.185u w=0.55u l=0.13u
X1770 VPWR.t1181 sg13cmos5l_buf_16_33.A a_6094_10704# VPWR.t2 sg13_lv_pmos ad=0.2128p pd=1.5u as=0.2128p ps=1.5u w=1.12u l=0.13u
X1771 VGND.t351 a_4462_5410# sg13cmos5l_buf_16_11.A VGND.t436 sg13_lv_nmos ad=0.2516p pd=2.16u as=0.1406p ps=1.12u w=0.74u l=0.13u
X1772 VPWR.t1348 glitch_en[0] a_1672_14516# VPWR.t0 sg13_lv_pmos ad=0.2114p pd=1.54u as=0.2856p ps=2.36u w=0.84u l=0.13u
X1773 VPWR.t1422 sg13cmos5l_xor2_1_6.X a_14824_14516# VPWR.t0 sg13_lv_pmos ad=0.2114p pd=1.54u as=0.2856p ps=2.36u w=0.84u l=0.13u
X1774 VGND.t7 sg13cmos5l_buf_16_35.A a_8110_6168# VGND.t13 sg13_lv_nmos ad=0.1406p pd=1.12u as=0.1406p ps=1.12u w=0.74u l=0.13u
X1775 sg13cmos5l_and2_2_1.X a_2147_13692# VGND.t895 VGND.t1506 sg13_lv_nmos ad=0.1406p pd=1.12u as=0.2812p ps=2.24u w=0.74u l=0.13u
X1776 VGND.t1010 VPWR.t28 VGND.t1010 VGND.t2 sg13_lv_nmos ad=79.8f pd=0.8u as=0 ps=0 w=0.42u l=1u
X1777 sg13cmos5l_buf_16_2.X a_10318_3898# VGND.t41 VGND.t40 sg13_lv_nmos ad=0.1406p pd=1.12u as=0.1406p ps=1.12u w=0.74u l=0.13u
X1778 VGND.t310 a_3694_3898# sg13cmos5l_buf_16_10.A VGND.t40 sg13_lv_nmos ad=0.1406p pd=1.12u as=0.1406p ps=1.12u w=0.74u l=0.13u
X1779 VGND.t96 VPWR.t64 VGND.t96 VGND.t40 sg13_lv_nmos ad=0.1428p pd=1.52u as=0 ps=0 w=0.42u l=1u
X1780 sg13cmos5l_buf_16_24.X a_6862_9946# VPWR.t834 VPWR.t2 sg13_lv_pmos ad=0.2128p pd=1.5u as=0.2128p ps=1.5u w=1.12u l=0.13u
X1781 VGND.t194 VPWR.t86 VGND.t198 VGND.t1314 sg13_lv_nmos ad=79.8f pd=0.8u as=0 ps=0 w=0.42u l=1u
X1782 sg13cmos5l_buf_16_39.A a_8494_3144# VPWR.t216 VPWR.t67 sg13_lv_pmos ad=0.2128p pd=1.5u as=0.2128p ps=1.5u w=1.12u l=0.13u
X1783 VGND.t42 VPWR.t1615 VGND.t42 VGND.t40 sg13_lv_nmos ad=0.1428p pd=1.52u as=0 ps=0 w=0.42u l=1u
X1784 VPWR.t129 VGND.t237 VPWR.t128 VPWR.t8 sg13_lv_pmos ad=0.19p pd=1.38u as=0 ps=0 w=1u l=1u
X1785 VPWR.t1585 a_3694_2386# sg13cmos5l_buf_16_7.X VPWR.t67 sg13_lv_pmos ad=0.2128p pd=1.5u as=0.2128p ps=1.5u w=1.12u l=0.13u
X1786 sg13cmos5l_buf_16_7.X a_3694_2386# VGND.t198 VGND.t1579 sg13_lv_nmos ad=0.1406p pd=1.12u as=0.1406p ps=1.12u w=0.74u l=0.13u
X1787 VPWR.t56 a_5710_1632# sg13cmos5l_buf_16_5.A VPWR.t55 sg13_lv_pmos ad=0.2128p pd=1.5u as=0.2128p ps=1.5u w=1.12u l=0.13u
X1788 VPWR.t96 a_10318_5410# sg13cmos5l_buf_16_1.X VPWR.t61 sg13_lv_pmos ad=0.2128p pd=1.5u as=0.2128p ps=1.5u w=1.12u l=0.13u
X1789 sg13cmos5l_xor2_1_0.B a_6094_3144# VGND.t125 VGND.t40 sg13_lv_nmos ad=0.1406p pd=1.12u as=0.1406p ps=1.12u w=0.74u l=0.13u
X1790 VGND.t597 VPWR.t0 VGND.t597 VGND.t912 sg13_lv_nmos ad=79.8f pd=0.8u as=0 ps=0 w=0.42u l=1u
X1791 VPWR.t724 a_6094_4656# sg13cmos5l_buf_16_31.X VPWR.t64 sg13_lv_pmos ad=0.2128p pd=1.5u as=0.2128p ps=1.5u w=1.12u l=0.13u
X1792 a_8110_6168# sg13cmos5l_buf_16_35.A VGND.t7 VGND.t10 sg13_lv_nmos ad=0.1406p pd=1.12u as=0.1406p ps=1.12u w=0.74u l=0.13u
X1793 sg13cmos5l_buf_16_2.A a_9262_7680# VGND.t5 VGND.t112 sg13_lv_nmos ad=0.1406p pd=1.12u as=0.1406p ps=1.12u w=0.74u l=0.13u
X1794 VPWR.t21 VGND.t1010 VPWR.t21 VPWR.t8 sg13_lv_pmos ad=0.34p pd=2.68u as=0 ps=0 w=1u l=1u
X1795 VPWR.t919 a_5518_6922# sg13cmos5l_buf_16_6.X VPWR.t58 sg13_lv_pmos ad=0.2128p pd=1.5u as=0.2128p ps=1.5u w=1.12u l=0.13u
X1796 VGND.t895 VPWR.t1693 VGND.t898 VGND.t927 sg13_lv_nmos ad=0.1428p pd=1.52u as=0 ps=0 w=0.42u l=1u
X1797 VGND.t940 VPWR.t81 VGND.t924 VGND.t939 sg13_lv_nmos ad=0.1428p pd=1.52u as=0 ps=0 w=0.42u l=1u
X1798 a_6161_9550# sg13cmos5l_and2_2_6.A a_6129_9192# VPWR.t5 sg13_lv_pmos ad=0.34p pd=2.68u as=0.1225p ps=1.245u w=1u l=0.13u
X1799 VGND.t41 a_10318_3898# sg13cmos5l_buf_16_2.X VGND.t40 sg13_lv_nmos ad=0.1406p pd=1.12u as=0.1406p ps=1.12u w=0.74u l=0.13u
X1800 a_3694_3898# sg13cmos5l_buf_16_8.A VGND.t310 VGND.t40 sg13_lv_nmos ad=0.1406p pd=1.12u as=0.1406p ps=1.12u w=0.74u l=0.13u
X1801 a_7796_12934# sg13cmos5l_buf_16_37.A VGND.t590 VGND.t594 sg13_lv_nmos ad=0.1406p pd=1.12u as=0.1406p ps=1.12u w=0.74u l=0.13u
X1802 VGND.t157 a_6836_9156# sg13cmos5l_buf_16_25.A VGND.t156 sg13_lv_nmos ad=0.1406p pd=1.12u as=0.1406p ps=1.12u w=0.74u l=0.13u
X1803 sg13cmos5l_buf_16_24.A a_6094_10704# VGND.t139 VGND.t2 sg13_lv_nmos ad=0.1406p pd=1.12u as=0.1406p ps=1.12u w=0.74u l=0.13u
X1804 a_10318_8434# sg13cmos5l_buf_16_1.X VPWR.t440 VPWR.t5 sg13_lv_pmos ad=0.2128p pd=1.5u as=0.2128p ps=1.5u w=1.12u l=0.13u
X1805 sg13cmos5l_xor2_1_5.X sg13cmos5l_buf_16_6.X a_9882_8446# VGND.t191 sg13_lv_nmos ad=0.1628p pd=1.18u as=88.8f ps=0.98u w=0.74u l=0.13u
X1806 VPWR.t1510 VGND.t1196 VPWR.t1508 VPWR.t64 sg13_lv_pmos ad=0.19p pd=1.38u as=0 ps=0 w=1u l=1u
X1807 VGND.t590 VPWR.t1678 VGND.t590 VGND.t971 sg13_lv_nmos ad=79.8f pd=0.8u as=0 ps=0 w=0.42u l=1u
X1808 sg13cmos5l_buf_16_7.X a_3694_2386# VPWR.t1581 VPWR.t67 sg13_lv_pmos ad=0.2128p pd=1.5u as=0.2128p ps=1.5u w=1.12u l=0.13u
X1809 VPWR.t125 VGND.t41 VPWR.t120 VPWR.t67 sg13_lv_pmos ad=0.34p pd=2.68u as=0 ps=0 w=1u l=1u
X1810 VGND.t25 sg13cmos5l_buf_1_2.A a_8104_1632# VGND.t832 sg13_lv_nmos ad=0.14875p pd=1.16u as=0.187p ps=1.78u w=0.55u l=0.13u
X1811 a_6094_4656# sg13cmos5l_buf_16_7.X VPWR.t1273 VPWR.t64 sg13_lv_pmos ad=0.2128p pd=1.5u as=0.2128p ps=1.5u w=1.12u l=0.13u
X1812 VGND.t1118 VPWR.t905 VGND.t1118 VGND.t1139 sg13_lv_nmos ad=0.1428p pd=1.52u as=0 ps=0 w=0.42u l=1u
X1813 sg13cmos5l_buf_16_6.X a_5518_6922# VPWR.t915 VPWR.t58 sg13_lv_pmos ad=0.2128p pd=1.5u as=0.2128p ps=1.5u w=1.12u l=0.13u
X1814 VPWR.t1460 VGND.t1147 VPWR.t1458 VPWR.t58 sg13_lv_pmos ad=0.19p pd=1.38u as=0 ps=0 w=1u l=1u
X1815 VGND.t870 a_3694_14482# sg13cmos5l_buf_16_33.A VGND.t884 sg13_lv_nmos ad=0.1406p pd=1.12u as=0.1406p ps=1.12u w=0.74u l=0.13u
X1816 VPWR.t370 VGND.t5 VPWR.t369 VPWR.t5 sg13_lv_pmos ad=0.34p pd=2.68u as=0 ps=0 w=1u l=1u
X1817 VGND.t726 VPWR.t16 VGND.t726 VGND.t2 sg13_lv_nmos ad=0.1428p pd=1.52u as=0 ps=0 w=0.42u l=1u
X1818 VGND.t637 VPWR.t410 VGND.t637 VGND.t1233 sg13_lv_nmos ad=0.1428p pd=1.52u as=0 ps=0 w=0.42u l=1u
X1819 sg13cmos5l_and2_2_6.X a_7629_8028# VPWR.t154 VPWR.t58 sg13_lv_pmos ad=0.2128p pd=1.5u as=0.1918p ps=1.5u w=1.12u l=0.13u
X1820 sg13cmos5l_buf_16_25.A a_6836_9156# VPWR.t500 VPWR.t5 sg13_lv_pmos ad=0.2128p pd=1.5u as=0.3976p ps=2.95u w=1.12u l=0.13u
X1821 a_13667_12956# sg13cmos5l_and2_2_4.B VPWR.t81 VPWR.t79 sg13_lv_pmos ad=0.1596p pd=1.22u as=0.1918p ps=1.5u w=0.84u l=0.13u
X1822 VGND.t726 VPWR.t28 VGND.t726 VGND.t2 sg13_lv_nmos ad=0.1428p pd=1.52u as=0 ps=0 w=0.42u l=1u
X1823 VPWR.t135 a_13581_9988# sg13cmos5l_and2_2_3.X VPWR.t2 sg13_lv_pmos ad=0.4256p pd=3u as=0.2128p ps=1.5u w=1.12u l=0.13u
X1824 VPWR.t56 sg13cmos5l_buf_16_30.A a_5710_1632# VPWR.t55 sg13_lv_pmos ad=0.2128p pd=1.5u as=0.2128p ps=1.5u w=1.12u l=0.13u
X1825 VGND.t1118 VPWR.t132 VGND.t1117 VGND.t1116 sg13_lv_nmos ad=0.1428p pd=1.52u as=0 ps=0 w=0.42u l=1u
X1826 a_7796_12934# sg13cmos5l_buf_16_37.A VGND.t590 VGND.t589 sg13_lv_nmos ad=0.1406p pd=1.12u as=0.1406p ps=1.12u w=0.74u l=0.13u
X1827 a_6094_10704# sg13cmos5l_buf_16_33.A VGND.t139 VGND.t2 sg13_lv_nmos ad=0.1406p pd=1.12u as=0.1406p ps=1.12u w=0.74u l=0.13u
X1828 VPWR.t116 VGND.t41 VPWR.t117 VPWR.t67 sg13_lv_pmos ad=0.34p pd=2.68u as=0 ps=0 w=1u l=1u
X1829 VGND.t237 VPWR.t80 VGND.t237 VGND.t956 sg13_lv_nmos ad=0.1428p pd=1.52u as=0 ps=0 w=0.42u l=1u
X1830 VGND.t260 a_3668_9156# sg13cmos5l_buf_16_13.A VGND.t263 sg13_lv_nmos ad=0.1406p pd=1.12u as=0.1406p ps=1.12u w=0.74u l=0.13u
X1831 VPWR.t1503 VGND.t1196 VPWR.t1502 VPWR.t61 sg13_lv_pmos ad=0.34p pd=2.68u as=0 ps=0 w=1u l=1u
X1832 VGND.t351 a_4462_5410# sg13cmos5l_buf_16_11.A VGND.t432 sg13_lv_nmos ad=0.1406p pd=1.12u as=0.1406p ps=1.12u w=0.74u l=0.13u
X1833 sg13cmos5l_buf_16_24.A a_6094_10704# VPWR.t1194 VPWR.t2 sg13_lv_pmos ad=0.2128p pd=1.5u as=0.2128p ps=1.5u w=1.12u l=0.13u
X1834 VGND.t37 a_14252_9906# sg13cmos5l_buf_1_15.X VGND.t628 sg13_lv_nmos ad=0.14875p pd=1.16u as=0.2886p ps=2.26u w=0.74u l=0.13u
X1835 sg13cmos5l_buf_16_31.X a_6094_4656# VGND.t171 VGND.t363 sg13_lv_nmos ad=0.1406p pd=1.12u as=0.1406p ps=1.12u w=0.74u l=0.13u
X1836 VPWR.t64 VGND.t96 VPWR.t64 VPWR.t64 sg13_lv_pmos ad=0.34p pd=2.68u as=0 ps=0 w=1u l=1u
X1837 VPWR.t245 VGND.t1196 VPWR.t1519 VPWR.t64 sg13_lv_pmos ad=0.34p pd=2.68u as=0 ps=0 w=1u l=1u
X1838 VGND.t1061 VPWR.t3 VGND.t1061 VGND.t1070 sg13_lv_nmos ad=79.8f pd=0.8u as=0 ps=0 w=0.42u l=1u
X1839 VPWR.t1 glitch_en[3] a_7432_14516# VPWR.t0 sg13_lv_pmos ad=0.2114p pd=1.54u as=0.2856p ps=2.36u w=0.84u l=0.13u
X1840 VGND.t444 a_3668_12180# sg13cmos5l_buf_16_15.X VGND.t445 sg13_lv_nmos ad=0.1406p pd=1.12u as=0.1406p ps=1.12u w=0.74u l=0.13u
X1841 VGND.t870 a_3694_14482# sg13cmos5l_buf_16_33.A VGND.t880 sg13_lv_nmos ad=0.1406p pd=1.12u as=0.1406p ps=1.12u w=0.74u l=0.13u
X1842 VPWR.t250 VGND.t31 VPWR.t250 VPWR.t55 sg13_lv_pmos ad=0.34p pd=2.68u as=0 ps=0 w=1u l=1u
X1843 VPWR.t62 VGND.t1208 VPWR.t62 VPWR.t61 sg13_lv_pmos ad=0.19p pd=1.38u as=0 ps=0 w=1u l=1u
X1844 VPWR.t1155 a_7796_12934# sg13cmos5l_buf_16_37.X VPWR.t79 sg13_lv_pmos ad=0.2128p pd=1.5u as=0.2128p ps=1.5u w=1.12u l=0.13u
X1845 VGND.t66 a_6161_9550# sg13cmos5l_buf_1_23.A VGND.t74 sg13_lv_nmos ad=0.3108p pd=2.32u as=0.1628p ps=1.18u w=0.74u l=0.13u
X1846 sg13cmos5l_buf_16_39.A a_8494_3144# VPWR.t216 VPWR.t67 sg13_lv_pmos ad=0.2128p pd=1.5u as=0.2128p ps=1.5u w=1.12u l=0.13u
X1847 sg13cmos5l_buf_16_13.A a_3668_9156# VGND.t260 VGND.t259 sg13_lv_nmos ad=0.1406p pd=1.12u as=0.2516p ps=2.16u w=0.74u l=0.13u
X1848 sg13cmos5l_buf_16_7.X a_3694_2386# VGND.t198 VGND.t1575 sg13_lv_nmos ad=0.1406p pd=1.12u as=0.1406p ps=1.12u w=0.74u l=0.13u
X1849 VPWR.t750 a_6094_3898# sg13cmos5l_buf_16_0.A VPWR.t64 sg13_lv_pmos ad=0.2128p pd=1.5u as=0.2128p ps=1.5u w=1.12u l=0.13u
X1850 a_9617_8484# sg13cmos5l_buf_16_35.A VGND.t5 VGND.t8 sg13_lv_nmos ad=0.17462p pd=1.185u as=0.374p ps=2.46u w=0.55u l=0.13u
X1851 VGND.t25 a_5710_1632# sg13cmos5l_buf_16_5.A VGND.t865 sg13_lv_nmos ad=0.1406p pd=1.12u as=0.1406p ps=1.12u w=0.74u l=0.13u
X1852 a_4436_9910# sg13cmos5l_buf_16_20.A VPWR.t1176 VPWR.t2 sg13_lv_pmos ad=0.2128p pd=1.5u as=0.2128p ps=1.5u w=1.12u l=0.13u
X1853 VGND.t310 a_3668_3108# sg13cmos5l_buf_16_7.A VGND.t40 sg13_lv_nmos ad=0.1406p pd=1.12u as=0.1406p ps=1.12u w=0.74u l=0.13u
X1854 VPWR.t211 sg13cmos5l_buf_16_34.A a_3694_7680# VPWR.t58 sg13_lv_pmos ad=0.2128p pd=1.5u as=0.2128p ps=1.5u w=1.12u l=0.13u
X1855 VGND.t870 sg13cmos5l_and2_2_1.X a_4174_13728# VGND.t1473 sg13_lv_nmos ad=0.1406p pd=1.12u as=0.1406p ps=1.12u w=0.74u l=0.13u
X1856 VPWR.t566 glitch_en[4] a_11272_13728# VPWR.t79 sg13_lv_pmos ad=0.2114p pd=1.54u as=0.2856p ps=2.36u w=0.84u l=0.13u
X1857 VGND.t41 a_10318_3898# sg13cmos5l_buf_16_2.X VGND.t40 sg13_lv_nmos ad=0.1406p pd=1.12u as=0.1406p ps=1.12u w=0.74u l=0.13u
X1858 sg13cmos5l_xor2_1_0.B a_6094_3144# VPWR.t765 VPWR.t67 sg13_lv_pmos ad=0.2128p pd=1.5u as=0.2128p ps=1.5u w=1.12u l=0.13u
X1859 VPWR.t91 sg13cmos5l_and2_2_5.B a_11565_8028# VPWR.t58 sg13_lv_pmos ad=0.1918p pd=1.5u as=0.1596p ps=1.22u w=0.84u l=0.13u
X1860 sg13cmos5l_buf_16_34.A a_3694_8434# VGND.t50 VGND.t53 sg13_lv_nmos ad=0.1406p pd=1.12u as=0.1406p ps=1.12u w=0.74u l=0.13u
X1861 VGND.t198 VPWR.t56 VGND.t198 VGND.t1316 sg13_lv_nmos ad=79.8f pd=0.8u as=0 ps=0 w=0.42u l=1u
X1862 VGND.t726 a_6094_10704# sg13cmos5l_buf_16_24.A VGND.t2 sg13_lv_nmos ad=0.2516p pd=2.16u as=0.1406p ps=1.12u w=0.74u l=0.13u
X1863 sg13cmos5l_buf_16_7.X a_3694_2386# VPWR.t565 VPWR.t67 sg13_lv_pmos ad=0.2128p pd=1.5u as=0.2128p ps=1.5u w=1.12u l=0.13u
X1864 sg13cmos5l_buf_16_5.A a_5710_1632# VGND.t25 VGND.t862 sg13_lv_nmos ad=0.1406p pd=1.12u as=0.1406p ps=1.12u w=0.74u l=0.13u
X1865 VPWR.t1095 sg13cmos5l_buf_16_15.A a_6332_12216# VPWR.t8 sg13_lv_pmos ad=0.2128p pd=1.5u as=0.3808p ps=2.92u w=1.12u l=0.13u
X1866 sg13cmos5l_buf_16_7.A a_3668_3108# VGND.t310 VGND.t40 sg13_lv_nmos ad=0.1406p pd=1.12u as=0.1406p ps=1.12u w=0.74u l=0.13u
X1867 sg13cmos5l_and2_2_6.A a_3694_10704# VGND.t134 VGND.t2 sg13_lv_nmos ad=0.1406p pd=1.12u as=0.1406p ps=1.12u w=0.74u l=0.13u
X1868 VGND.t870 sg13cmos5l_buf_16_15.X a_3694_14482# VGND.t875 sg13_lv_nmos ad=0.1406p pd=1.12u as=0.1406p ps=1.12u w=0.74u l=0.13u
X1869 sg13cmos5l_buf_16_31.X a_6094_4656# VGND.t171 VGND.t359 sg13_lv_nmos ad=0.1406p pd=1.12u as=0.1406p ps=1.12u w=0.74u l=0.13u
X1870 VPWR.t303 VGND.t260 VPWR.t301 VPWR.t5 sg13_lv_pmos ad=0.19p pd=1.38u as=0 ps=0 w=1u l=1u
X1871 VGND.t7 VPWR.t1635 VGND.t7 VGND.t1158 sg13_lv_nmos ad=79.8f pd=0.8u as=0 ps=0 w=0.42u l=1u
X1872 VPWR.t1151 a_7796_12934# sg13cmos5l_buf_16_37.X VPWR.t79 sg13_lv_pmos ad=0.2128p pd=1.5u as=0.2128p ps=1.5u w=1.12u l=0.13u
X1873 sg13cmos5l_buf_16_11.A a_4462_5410# VPWR.t802 VPWR.t61 sg13_lv_pmos ad=0.2128p pd=1.5u as=0.2128p ps=1.5u w=1.12u l=0.13u
X1874 VGND.t601 sg13cmos5l_buf_16_23.X a_8948_13692# VGND.t603 sg13_lv_nmos ad=0.2516p pd=2.16u as=0.1406p ps=1.12u w=0.74u l=0.13u
X1875 VGND.t50 a_3694_8434# sg13cmos5l_buf_16_34.A VGND.t49 sg13_lv_nmos ad=0.1406p pd=1.12u as=0.1406p ps=1.12u w=0.74u l=0.13u
X1876 sg13cmos5l_buf_16_39.A a_8494_3144# VGND.t302 VGND.t40 sg13_lv_nmos ad=0.1406p pd=1.12u as=0.1406p ps=1.12u w=0.74u l=0.13u
X1877 sg13cmos5l_buf_16_24.X a_6862_9946# VGND.t157 VGND.t476 sg13_lv_nmos ad=0.1406p pd=1.12u as=0.1406p ps=1.12u w=0.74u l=0.13u
X1878 sg13cmos5l_buf_16_14.A a_4436_9910# VPWR.t1214 VPWR.t2 sg13_lv_pmos ad=0.2128p pd=1.5u as=0.2128p ps=1.5u w=1.12u l=0.13u
X1879 VPWR.t746 a_6094_3898# sg13cmos5l_buf_16_0.A VPWR.t64 sg13_lv_pmos ad=0.2128p pd=1.5u as=0.2128p ps=1.5u w=1.12u l=0.13u
X1880 VPWR.t348 a_9262_7680# sg13cmos5l_buf_16_2.A VPWR.t58 sg13_lv_pmos ad=0.3976p pd=2.95u as=0.2128p ps=1.5u w=1.12u l=0.13u
X1881 a_6164_2350# sg13cmos5l_buf_16_39.A VPWR.t221 VPWR.t67 sg13_lv_pmos ad=0.2128p pd=1.5u as=0.2128p ps=1.5u w=1.12u l=0.13u
X1882 VGND.t1274 VPWR.t156 VGND.t1274 VGND.t1279 sg13_lv_nmos ad=79.8f pd=0.8u as=0 ps=0 w=0.42u l=1u
X1883 VGND.t210 a_9524_6886# sg13cmos5l_buf_16_4.X VGND.t552 sg13_lv_nmos ad=0.1406p pd=1.12u as=0.1406p ps=1.12u w=0.74u l=0.13u
X1884 VPWR.t63 VGND.t1298 VPWR.t63 VPWR.t55 sg13_lv_pmos ad=0.34p pd=2.68u as=0 ps=0 w=1u l=1u
X1885 VPWR.t71 VGND.t218 VPWR.t70 VPWR.t58 sg13_lv_pmos ad=0.19p pd=1.38u as=0 ps=0 w=1u l=1u
X1886 sg13cmos5l_xor2_1_0.B a_6094_3144# VPWR.t761 VPWR.t67 sg13_lv_pmos ad=0.2128p pd=1.5u as=0.2128p ps=1.5u w=1.12u l=0.13u
X1887 VGND.t206 VPWR.t81 VGND.t206 VGND.t935 sg13_lv_nmos ad=0.1428p pd=1.52u as=0 ps=0 w=0.42u l=1u
X1888 sg13cmos5l_and2_2_6.A a_3694_10704# VGND.t134 VGND.t2 sg13_lv_nmos ad=0.1406p pd=1.12u as=0.1406p ps=1.12u w=0.74u l=0.13u
X1889 sg13cmos5l_buf_16_0.A a_6094_3898# VPWR.t742 VPWR.t64 sg13_lv_pmos ad=0.2128p pd=1.5u as=0.2128p ps=1.5u w=1.12u l=0.13u
X1890 a_6765_12564# sg13cmos5l_buf_16_24.X VPWR.t1096 VPWR.t8 sg13_lv_pmos ad=0.1596p pd=1.22u as=0.2856p ps=2.36u w=0.84u l=0.13u
X1891 sg13cmos5l_buf_16_38.A a_8110_6168# VPWR.t61 VPWR.t61 sg13_lv_pmos ad=0.2128p pd=1.5u as=0.2128p ps=1.5u w=1.12u l=0.13u
X1892 VPWR.t1440 sg13cmos5l_buf_16_37.X a_6548_13692# VPWR.t79 sg13_lv_pmos ad=0.2128p pd=1.5u as=0.2128p ps=1.5u w=1.12u l=0.13u
X1893 VPWR.t268 a_3694_8434# sg13cmos5l_buf_16_34.A VPWR.t5 sg13_lv_pmos ad=0.2128p pd=1.5u as=0.2128p ps=1.5u w=1.12u l=0.13u
X1894 VPWR.t1351 glitch_en[2] a_5992_14516# VPWR.t0 sg13_lv_pmos ad=0.2114p pd=1.54u as=0.2856p ps=2.36u w=0.84u l=0.13u
X1895 sg13cmos5l_buf_16_4.X a_9524_6886# VGND.t7 VGND.t549 sg13_lv_nmos ad=0.1406p pd=1.12u as=0.2516p ps=2.16u w=0.74u l=0.13u
X1896 VPWR.t162 VGND.t620 VPWR.t197 VPWR.t79 sg13_lv_pmos ad=0.34p pd=2.68u as=0 ps=0 w=1u l=1u
X1897 a_3668_12180# sg13cmos5l_buf_16_15.A VGND.t457 VGND.t698 sg13_lv_nmos ad=0.1406p pd=1.12u as=0.1406p ps=1.12u w=0.74u l=0.13u
X1898 VGND.t1403 VPWR.t63 VGND.t1402 VGND.t1401 sg13_lv_nmos ad=0.1428p pd=1.52u as=0 ps=0 w=0.42u l=1u
X1899 sg13cmos5l_buf_16_15.A a_4052_12934# VGND.t457 VGND.t618 sg13_lv_nmos ad=0.1406p pd=1.12u as=0.1406p ps=1.12u w=0.74u l=0.13u
X1900 VGND.t1010 VPWR.t21 VGND.t1010 VGND.t2 sg13_lv_nmos ad=79.8f pd=0.8u as=0 ps=0 w=0.42u l=1u
X1901 a_8990_2704# sg13cmos5l_xor2_1_0.B a_8538_2578# VPWR.t67 sg13_lv_pmos ad=0.1225p pd=1.245u as=0.34p ps=2.68u w=1u l=0.13u
X1902 a_5684_6132# sg13cmos5l_buf_16_28.A VPWR.t1257 VPWR.t61 sg13_lv_pmos ad=0.2128p pd=1.5u as=0.2128p ps=1.5u w=1.12u l=0.13u
X1903 VPWR.t73 VGND.t218 VPWR.t72 VPWR.t58 sg13_lv_pmos ad=0.34p pd=2.68u as=0 ps=0 w=1u l=1u
X1904 VGND.t61 VPWR.t1646 VGND.t61 VGND.t1110 sg13_lv_nmos ad=79.8f pd=0.8u as=0 ps=0 w=0.42u l=1u
X1905 sg13cmos5l_buf_16_8.A a_3668_4620# VGND.t797 VGND.t817 sg13_lv_nmos ad=0.1406p pd=1.12u as=0.1406p ps=1.12u w=0.74u l=0.13u
X1906 sg13cmos5l_buf_16_34.A a_3694_8434# VPWR.t264 VPWR.t5 sg13_lv_pmos ad=0.2128p pd=1.5u as=0.2128p ps=1.5u w=1.12u l=0.13u
X1907 VPWR.t91 sg13cmos5l_buf_16_4.A a_9524_6886# VPWR.t58 sg13_lv_pmos ad=0.2128p pd=1.5u as=0.2128p ps=1.5u w=1.12u l=0.13u
X1908 VPWR.t1452 VGND.t1147 VPWR.t602 VPWR.t58 sg13_lv_pmos ad=0.19p pd=1.38u as=0 ps=0 w=1u l=1u
X1909 VGND.t50 a_3694_7680# sg13cmos5l_buf_16_34.X VGND.t52 sg13_lv_nmos ad=0.1406p pd=1.12u as=0.1406p ps=1.12u w=0.74u l=0.13u
X1910 VPWR.t0 VGND.t597 VPWR.t0 VPWR.t0 sg13_lv_pmos ad=0.34p pd=2.68u as=0 ps=0 w=1u l=1u
X1911 VPWR.t566 a_10292_12934# sg13cmos5l_buf_16_23.X VPWR.t79 sg13_lv_pmos ad=0.2128p pd=1.5u as=0.2128p ps=1.5u w=1.12u l=0.13u
X1912 a_3694_10704# sg13cmos5l_buf_16_34.X VGND.t134 VGND.t2 sg13_lv_nmos ad=0.1406p pd=1.12u as=0.1406p ps=1.12u w=0.74u l=0.13u
X1913 VPWR.t1406 a_6548_13692# sg13cmos5l_buf_16_27.X VPWR.t79 sg13_lv_pmos ad=0.2128p pd=1.5u as=0.2128p ps=1.5u w=1.12u l=0.13u
X1914 VPWR.t1418 a_6548_13692# sg13cmos5l_buf_16_27.X VPWR.t79 sg13_lv_pmos ad=0.2128p pd=1.5u as=0.2128p ps=1.5u w=1.12u l=0.13u
X1915 VPWR.t685 sg13cmos5l_buf_16_8.A a_3694_3898# VPWR.t64 sg13_lv_pmos ad=0.2128p pd=1.5u as=0.2128p ps=1.5u w=1.12u l=0.13u
X1916 VGND.t76 sg13cmos5l_buf_16_38.A a_7220_5374# VGND.t176 sg13_lv_nmos ad=0.2516p pd=2.16u as=0.1406p ps=1.12u w=0.74u l=0.13u
X1917 VPWR.t1255 sg13cmos5l_buf_16_28.A a_5684_6132# VPWR.t61 sg13_lv_pmos ad=0.2128p pd=1.5u as=0.2128p ps=1.5u w=1.12u l=0.13u
X1918 VGND.t989 VPWR.t1668 VGND.t989 VGND.t2 sg13_lv_nmos ad=79.8f pd=0.8u as=0 ps=0 w=0.42u l=1u
X1919 a_5204_11422# sg13cmos5l_buf_16_19.A VPWR.t497 VPWR.t8 sg13_lv_pmos ad=0.2128p pd=1.5u as=0.2128p ps=1.5u w=1.12u l=0.13u
X1920 VGND.t1019 VPWR.t3 VGND.t3 VGND.t2 sg13_lv_nmos ad=79.8f pd=0.8u as=0 ps=0 w=0.42u l=1u
X1921 a_9524_6886# sg13cmos5l_buf_16_4.A VPWR.t348 VPWR.t58 sg13_lv_pmos ad=0.2128p pd=1.5u as=0.2128p ps=1.5u w=1.12u l=0.13u
X1922 sg13cmos5l_buf_16_34.X a_3694_7680# VGND.t18 VGND.t48 sg13_lv_nmos ad=0.1406p pd=1.12u as=0.1406p ps=1.12u w=0.74u l=0.13u
X1923 VGND.t157 sg13cmos5l_and2_2_6.X a_6836_9156# VGND.t475 sg13_lv_nmos ad=0.1406p pd=1.12u as=0.1406p ps=1.12u w=0.74u l=0.13u
X1924 sg13cmos5l_buf_16_15.A a_4052_12934# VGND.t457 VGND.t614 sg13_lv_nmos ad=0.1406p pd=1.12u as=0.1406p ps=1.12u w=0.74u l=0.13u
X1925 VGND.t260 a_4436_9910# sg13cmos5l_buf_16_14.A VGND.t754 sg13_lv_nmos ad=0.1406p pd=1.12u as=0.1406p ps=1.12u w=0.74u l=0.13u
X1926 sg13cmos5l_buf_16_22.X a_10318_8434# VGND.t5 VGND.t581 sg13_lv_nmos ad=0.1406p pd=1.12u as=0.1406p ps=1.12u w=0.74u l=0.13u
X1927 VGND.t1196 VPWR.t1626 VGND.t1196 VGND.t1200 sg13_lv_nmos ad=0.1428p pd=1.52u as=0 ps=0 w=0.42u l=1u
X1928 VGND.t139 a_5204_11422# sg13cmos5l_buf_16_20.A VGND.t2 sg13_lv_nmos ad=0.1406p pd=1.12u as=0.1406p ps=1.12u w=0.74u l=0.13u
X1929 a_7220_5374# sg13cmos5l_buf_16_38.A VGND.t171 VGND.t173 sg13_lv_nmos ad=0.1406p pd=1.12u as=0.1406p ps=1.12u w=0.74u l=0.13u
X1930 VPWR.t135 sg13cmos5l_buf_1_11.X a_14824_10704# VPWR.t2 sg13_lv_pmos ad=0.2114p pd=1.54u as=0.2856p ps=2.36u w=0.84u l=0.13u
X1931 a_6836_9156# sg13cmos5l_and2_2_6.X VGND.t157 VGND.t472 sg13_lv_nmos ad=0.1406p pd=1.12u as=0.1406p ps=1.12u w=0.74u l=0.13u
X1932 a_5518_6922# sg13cmos5l_buf_16_28.X VGND.t218 VGND.t633 sg13_lv_nmos ad=0.1406p pd=1.12u as=0.1406p ps=1.12u w=0.74u l=0.13u
X1933 VGND.t18 sg13cmos5l_buf_16_34.A a_3694_7680# VGND.t23 sg13_lv_nmos ad=0.1406p pd=1.12u as=0.1406p ps=1.12u w=0.74u l=0.13u
X1934 VGND.t1208 VPWR.t62 VGND.t1208 VGND.t1209 sg13_lv_nmos ad=79.8f pd=0.8u as=0 ps=0 w=0.42u l=1u
X1935 a_6548_13692# sg13cmos5l_buf_16_37.X VGND.t597 VGND.t1512 sg13_lv_nmos ad=0.1406p pd=1.12u as=0.1406p ps=1.12u w=0.74u l=0.13u
X1936 VGND.t5 a_10318_8434# sg13cmos5l_buf_16_22.X VGND.t578 sg13_lv_nmos ad=0.1406p pd=1.12u as=0.1406p ps=1.12u w=0.74u l=0.13u
X1937 VPWR.t156 VGND.t1274 VPWR.t156 VPWR.t55 sg13_lv_pmos ad=0.19p pd=1.38u as=0 ps=0 w=1u l=1u
X1938 VGND.t96 a_8494_3144# sg13cmos5l_buf_16_39.A VGND.t40 sg13_lv_nmos ad=0.1406p pd=1.12u as=0.1406p ps=1.12u w=0.74u l=0.13u
X1939 sg13cmos5l_and2_2_5.B a_11272_13728# VGND.t202 VGND.t201 sg13_lv_nmos ad=0.2886p pd=2.26u as=0.14875p ps=1.16u w=0.74u l=0.13u
X1940 VGND.t157 a_6862_9946# sg13cmos5l_buf_16_24.X VGND.t167 sg13_lv_nmos ad=0.1406p pd=1.12u as=0.1406p ps=1.12u w=0.74u l=0.13u
X1941 VGND.t841 VPWR.t1692 VGND.t841 VGND.t929 sg13_lv_nmos ad=79.8f pd=0.8u as=0 ps=0 w=0.42u l=1u
X1942 sg13cmos5l_buf_16_20.A a_5204_11422# VPWR.t493 VPWR.t8 sg13_lv_pmos ad=0.2128p pd=1.5u as=0.2128p ps=1.5u w=1.12u l=0.13u
X1943 VPWR.t834 a_6862_9946# sg13cmos5l_buf_16_24.X VPWR.t2 sg13_lv_pmos ad=0.2128p pd=1.5u as=0.2128p ps=1.5u w=1.12u l=0.13u
X1944 VGND.t37 VPWR.t135 VGND.t37 VGND.t1075 sg13_lv_nmos ad=0.1428p pd=1.52u as=0 ps=0 w=0.42u l=1u
X1945 a_5108_838# sg13cmos5l_buf_16_5.A VPWR.t56 VPWR.t55 sg13_lv_pmos ad=0.2128p pd=1.5u as=0.2128p ps=1.5u w=1.12u l=0.13u
X1946 sg13cmos5l_buf_16_38.A a_8110_6168# VGND.t210 VGND.t786 sg13_lv_nmos ad=0.1406p pd=1.12u as=0.1406p ps=1.12u w=0.74u l=0.13u
X1947 VGND.t989 VPWR.t1677 VGND.t989 VGND.t2 sg13_lv_nmos ad=79.8f pd=0.8u as=0 ps=0 w=0.42u l=1u
X1948 VPWR.t905 VGND.t1118 VPWR.t58 VPWR.t58 sg13_lv_pmos ad=0.34p pd=2.68u as=0 ps=0 w=1u l=1u
X1949 sg13cmos5l_buf_16_24.A a_6094_10704# VPWR.t1181 VPWR.t2 sg13_lv_pmos ad=0.2128p pd=1.5u as=0.2128p ps=1.5u w=1.12u l=0.13u
X1950 VGND.t1281 VPWR.t99 VGND.t194 VGND.t1282 sg13_lv_nmos ad=79.8f pd=0.8u as=0 ps=0 w=0.42u l=1u
X1951 VGND.t139 a_5204_11422# sg13cmos5l_buf_16_20.A VGND.t2 sg13_lv_nmos ad=0.1406p pd=1.12u as=0.1406p ps=1.12u w=0.74u l=0.13u
X1952 VPWR.t63 VGND.t1298 VPWR.t63 VPWR.t55 sg13_lv_pmos ad=0.34p pd=2.68u as=0 ps=0 w=1u l=1u
X1953 VPWR.t1512 VGND.t1196 VPWR.t1511 VPWR.t64 sg13_lv_pmos ad=0.34p pd=2.68u as=0 ps=0 w=1u l=1u
X1954 VGND.t5 sg13cmos5l_buf_16_4.X a_9262_7680# VGND.t769 sg13_lv_nmos ad=0.1406p pd=1.12u as=0.1406p ps=1.12u w=0.74u l=0.13u
X1955 sg13cmos5l_buf_16_22.X a_10318_8434# VGND.t5 VGND.t575 sg13_lv_nmos ad=0.1406p pd=1.12u as=0.1406p ps=1.12u w=0.74u l=0.13u
X1956 VPWR.t13 VGND.t726 VPWR.t14 VPWR.t8 sg13_lv_pmos ad=0.19p pd=1.38u as=0 ps=0 w=1u l=1u
X1957 VGND.t7 a_8110_6168# sg13cmos5l_buf_16_38.A VGND.t783 sg13_lv_nmos ad=0.1406p pd=1.12u as=0.1406p ps=1.12u w=0.74u l=0.13u
X1958 VPWR.t143 sg13cmos5l_buf_16_2.A a_10318_3898# VPWR.t64 sg13_lv_pmos ad=0.2128p pd=1.5u as=0.2128p ps=1.5u w=1.12u l=0.13u
X1959 VGND.t122 a_3694_3898# sg13cmos5l_buf_16_10.A VGND.t40 sg13_lv_nmos ad=0.1406p pd=1.12u as=0.1406p ps=1.12u w=0.74u l=0.13u
X1960 sg13cmos5l_buf_16_15.X a_3668_12180# VPWR.t813 VPWR.t8 sg13_lv_pmos ad=0.2128p pd=1.5u as=0.3976p ps=2.95u w=1.12u l=0.13u
X1961 VPWR.t6 a_10318_8434# sg13cmos5l_buf_16_22.X VPWR.t5 sg13_lv_pmos ad=0.2128p pd=1.5u as=0.2128p ps=1.5u w=1.12u l=0.13u
X1962 a_8494_3144# sg13cmos5l_buf_16_0.A VPWR.t216 VPWR.t67 sg13_lv_pmos ad=0.2128p pd=1.5u as=0.2128p ps=1.5u w=1.12u l=0.13u
X1963 sg13cmos5l_buf_16_34.A a_3694_8434# VPWR.t261 VPWR.t5 sg13_lv_pmos ad=0.2128p pd=1.5u as=0.2128p ps=1.5u w=1.12u l=0.13u
X1964 VPWR.t61 sg13cmos5l_buf_16_38.A a_7220_5374# VPWR.t61 sg13_lv_pmos ad=0.2128p pd=1.5u as=0.2128p ps=1.5u w=1.12u l=0.13u
X1965 a_5518_6922# sg13cmos5l_buf_16_28.X VGND.t218 VGND.t629 sg13_lv_nmos ad=0.1406p pd=1.12u as=0.2516p ps=2.16u w=0.74u l=0.13u
X1966 VGND.t942 VPWR.t1688 VGND.t942 VGND.t946 sg13_lv_nmos ad=0.1428p pd=1.52u as=0 ps=0 w=0.42u l=1u
X1967 VPWR.t6 VGND.t5 VPWR.t6 VPWR.t5 sg13_lv_pmos ad=0.34p pd=2.68u as=0 ps=0 w=1u l=1u
X1968 a_9262_7680# sg13cmos5l_buf_16_4.X VGND.t5 VGND.t766 sg13_lv_nmos ad=0.1406p pd=1.12u as=0.2516p ps=2.16u w=0.74u l=0.13u
X1969 VGND.t39 a_13581_9988# sg13cmos5l_and2_2_3.X VGND.t566 sg13_lv_nmos ad=0.2812p pd=2.24u as=0.1406p ps=1.12u w=0.74u l=0.13u
X1970 VPWR.t734 a_6094_4656# sg13cmos5l_buf_16_31.X VPWR.t64 sg13_lv_pmos ad=0.2128p pd=1.5u as=0.2128p ps=1.5u w=1.12u l=0.13u
X1971 VPWR.t590 a_5684_6132# sg13cmos5l_buf_16_28.X VPWR.t61 sg13_lv_pmos ad=0.2128p pd=1.5u as=0.2128p ps=1.5u w=1.12u l=0.13u
X1972 sg13cmos5l_buf_16_38.A a_8110_6168# VGND.t7 VGND.t780 sg13_lv_nmos ad=0.1406p pd=1.12u as=0.1406p ps=1.12u w=0.74u l=0.13u
X1973 VGND.t206 VPWR.t80 VGND.t206 VGND.t934 sg13_lv_nmos ad=79.8f pd=0.8u as=0 ps=0 w=0.42u l=1u
X1974 out_xor[6] a_14824_13004# VGND.t513 VGND.t706 sg13_lv_nmos ad=0.2886p pd=2.26u as=0.14875p ps=1.16u w=0.74u l=0.13u
X1975 sg13cmos5l_buf_16_3.X a_10292_4620# VGND.t76 VGND.t80 sg13_lv_nmos ad=0.1406p pd=1.12u as=0.1406p ps=1.12u w=0.74u l=0.13u
X1976 a_6094_10704# sg13cmos5l_buf_16_33.A VPWR.t1354 VPWR.t2 sg13_lv_pmos ad=0.2128p pd=1.5u as=0.2128p ps=1.5u w=1.12u l=0.13u
X1977 sg13cmos5l_buf_16_22.X a_10318_8434# VPWR.t6 VPWR.t5 sg13_lv_pmos ad=0.2128p pd=1.5u as=0.2128p ps=1.5u w=1.12u l=0.13u
X1978 VPWR.t191 VGND.t134 VPWR.t190 VPWR.t8 sg13_lv_pmos ad=0.34p pd=2.68u as=0 ps=0 w=1u l=1u
X1979 VGND.t1162 VPWR.t93 VGND.t1162 VGND.t1163 sg13_lv_nmos ad=79.8f pd=0.8u as=0 ps=0 w=0.42u l=1u
X1980 sg13cmos5l_buf_16_7.X a_3694_2386# VPWR.t1591 VPWR.t67 sg13_lv_pmos ad=0.2128p pd=1.5u as=0.2128p ps=1.5u w=1.12u l=0.13u
X1981 VPWR.t26 VGND.t726 VPWR.t26 VPWR.t2 sg13_lv_pmos ad=0.34p pd=2.68u as=0 ps=0 w=1u l=1u
X1982 sg13cmos5l_buf_16_5.A a_5710_1632# VPWR.t56 VPWR.t55 sg13_lv_pmos ad=0.2128p pd=1.5u as=0.2128p ps=1.5u w=1.12u l=0.13u
X1983 VGND.t198 VPWR.t56 VGND.t198 VGND.t1317 sg13_lv_nmos ad=0.1428p pd=1.52u as=0 ps=0 w=0.42u l=1u
X1984 VGND.t1408 VPWR.t63 VGND.t1407 VGND.t1406 sg13_lv_nmos ad=0.1428p pd=1.52u as=0 ps=0 w=0.42u l=1u
X1985 VGND.t1274 VPWR.t1610 VGND.t1274 VGND.t1276 sg13_lv_nmos ad=0.1428p pd=1.52u as=0 ps=0 w=0.42u l=1u
X1986 sg13cmos5l_buf_16_25.A a_6836_9156# VGND.t157 VGND.t166 sg13_lv_nmos ad=0.1406p pd=1.12u as=0.1406p ps=1.12u w=0.74u l=0.13u
X1987 VPWR.t1165 sg13cmos5l_buf_16_15.A a_3668_12180# VPWR.t8 sg13_lv_pmos ad=0.2128p pd=1.5u as=0.2128p ps=1.5u w=1.12u l=0.13u
X1988 VPWR.t56 a_5710_1632# sg13cmos5l_buf_16_5.A VPWR.t55 sg13_lv_pmos ad=0.2128p pd=1.5u as=0.2128p ps=1.5u w=1.12u l=0.13u
X1989 VGND.t1274 VPWR.t55 VGND.t1274 VGND.t1275 sg13_lv_nmos ad=79.8f pd=0.8u as=0 ps=0 w=0.42u l=1u
X1990 VGND.t590 sg13cmos5l_buf_16_37.A a_7796_12934# VGND.t591 sg13_lv_nmos ad=0.1406p pd=1.12u as=0.1406p ps=1.12u w=0.74u l=0.13u
X1991 VPWR.t730 a_6094_4656# sg13cmos5l_buf_16_31.X VPWR.t64 sg13_lv_pmos ad=0.2128p pd=1.5u as=0.2128p ps=1.5u w=1.12u l=0.13u
X1992 VPWR.t1361 sg13cmos5l_and2_2_1.X a_4174_13728# VPWR.t79 sg13_lv_pmos ad=0.2128p pd=1.5u as=0.2128p ps=1.5u w=1.12u l=0.13u
X1993 sg13cmos5l_buf_16_3.X a_10292_4620# VGND.t76 VGND.t75 sg13_lv_nmos ad=0.1406p pd=1.12u as=0.2516p ps=2.16u w=0.74u l=0.13u
X1994 VPWR.t1495 VGND.t1196 VPWR.t1494 VPWR.t61 sg13_lv_pmos ad=0.34p pd=2.68u as=0 ps=0 w=1u l=1u
X1995 VGND.t513 sg13cmos5l_buf_1_22.X a_14824_13004# VGND.t707 sg13_lv_nmos ad=0.14875p pd=1.16u as=0.187p ps=1.78u w=0.55u l=0.13u
X1996 VPWR.t81 VGND.t924 VPWR.t81 VPWR.t79 sg13_lv_pmos ad=0.34p pd=2.68u as=0 ps=0 w=1u l=1u
X1997 VPWR.t3 VGND.t1061 VPWR.t430 VPWR.t2 sg13_lv_pmos ad=0.19p pd=1.38u as=0 ps=0 w=1u l=1u
X1998 sg13cmos5l_and2_2_0.X a_3875_5396# VPWR.t1268 VPWR.t61 sg13_lv_pmos ad=0.2128p pd=1.5u as=0.4256p ps=3u w=1.12u l=0.13u
X1999 VPWR.t1196 a_6094_10704# sg13cmos5l_buf_16_24.A VPWR.t2 sg13_lv_pmos ad=0.3976p pd=2.95u as=0.2128p ps=1.5u w=1.12u l=0.13u
X2000 VPWR.t509 a_6836_9156# sg13cmos5l_buf_16_25.A VPWR.t5 sg13_lv_pmos ad=0.2128p pd=1.5u as=0.2128p ps=1.5u w=1.12u l=0.13u
X2001 sg13cmos5l_buf_16_30.A a_6164_2350# VGND.t837 VGND.t1548 sg13_lv_nmos ad=0.1406p pd=1.12u as=0.1406p ps=1.12u w=0.74u l=0.13u
X2002 sg13cmos5l_and2_2_6.A a_3694_10704# VPWR.t1202 VPWR.t2 sg13_lv_pmos ad=0.2128p pd=1.5u as=0.2128p ps=1.5u w=1.12u l=0.13u
X2003 sg13cmos5l_buf_16_31.X a_6094_4656# VPWR.t726 VPWR.t64 sg13_lv_pmos ad=0.2128p pd=1.5u as=0.2128p ps=1.5u w=1.12u l=0.13u
X2004 VGND.t1359 VPWR.t86 VGND.t1358 VGND.t1357 sg13_lv_nmos ad=0.1428p pd=1.52u as=0 ps=0 w=0.42u l=1u
X2005 VPWR.t566 sg13cmos5l_buf_16_23.X a_8948_13692# VPWR.t79 sg13_lv_pmos ad=0.3808p pd=2.92u as=0.2128p ps=1.5u w=1.12u l=0.13u
X2006 sg13cmos5l_buf_16_13.A a_3668_9156# VGND.t260 VGND.t272 sg13_lv_nmos ad=0.1406p pd=1.12u as=0.1406p ps=1.12u w=0.74u l=0.13u
X2007 VPWR.t1516 VGND.t1196 VPWR.t1515 VPWR.t64 sg13_lv_pmos ad=0.34p pd=2.68u as=0 ps=0 w=1u l=1u
X2008 VGND.t35 sg13cmos5l_buf_16_22.X a_13745_8484# VGND.t151 sg13_lv_nmos ad=0.15245p pd=1.17u as=0.17462p ps=1.185u w=0.55u l=0.13u
X2009 VGND.t590 a_7796_12934# sg13cmos5l_buf_16_37.X VGND.t695 sg13_lv_nmos ad=0.1406p pd=1.12u as=0.1406p ps=1.12u w=0.74u l=0.13u
X2010 VGND.t122 sg13cmos5l_buf_16_10.A a_3668_3108# VGND.t40 sg13_lv_nmos ad=0.1406p pd=1.12u as=0.1406p ps=1.12u w=0.74u l=0.13u
X2011 sg13cmos5l_buf_1_17.A a_13667_12956# VPWR.t81 VPWR.t79 sg13_lv_pmos ad=0.2128p pd=1.5u as=0.4256p ps=3u w=1.12u l=0.13u
X2012 sg13cmos5l_buf_16_25.A a_6836_9156# VPWR.t505 VPWR.t5 sg13_lv_pmos ad=0.2128p pd=1.5u as=0.2128p ps=1.5u w=1.12u l=0.13u
X2013 VPWR.t596 VGND.t1141 VPWR.t594 VPWR.t58 sg13_lv_pmos ad=0.19p pd=1.38u as=0 ps=0 w=1u l=1u
X2014 sg13cmos5l_buf_16_18.A a_4174_13728# VGND.t870 VGND.t1435 sg13_lv_nmos ad=0.1406p pd=1.12u as=0.1406p ps=1.12u w=0.74u l=0.13u
X2015 a_8948_13692# sg13cmos5l_buf_16_23.X VGND.t601 VGND.t602 sg13_lv_nmos ad=0.1406p pd=1.12u as=0.1406p ps=1.12u w=0.74u l=0.13u
X2016 VGND.t837 a_6164_2350# sg13cmos5l_buf_16_30.A VGND.t1545 sg13_lv_nmos ad=0.1406p pd=1.12u as=0.1406p ps=1.12u w=0.74u l=0.13u
X2017 VPWR.t6 VGND.t1073 VPWR.t6 VPWR.t5 sg13_lv_pmos ad=0.19p pd=1.38u as=0 ps=0 w=1u l=1u
X2018 VGND.t1281 VPWR.t99 VGND.t1274 VGND.t1280 sg13_lv_nmos ad=0.1428p pd=1.52u as=0 ps=0 w=0.42u l=1u
X2019 VGND.t597 a_8948_13692# sg13cmos5l_buf_16_37.A VGND.t655 sg13_lv_nmos ad=0.1406p pd=1.12u as=0.1406p ps=1.12u w=0.74u l=0.13u
X2020 sg13cmos5l_buf_16_23.X a_10292_12934# VGND.t590 VGND.t666 sg13_lv_nmos ad=0.1406p pd=1.12u as=0.1406p ps=1.12u w=0.74u l=0.13u
X2021 VPWR.t108 VGND.t1208 VPWR.t110 VPWR.t64 sg13_lv_pmos ad=0.19p pd=1.38u as=0 ps=0 w=1u l=1u
X2022 sg13cmos5l_buf_16_38.A a_8110_6168# VPWR.t61 VPWR.t61 sg13_lv_pmos ad=0.2128p pd=1.5u as=0.2128p ps=1.5u w=1.12u l=0.13u
X2023 sg13cmos5l_buf_16_2.A a_9262_7680# VPWR.t335 VPWR.t58 sg13_lv_pmos ad=0.2128p pd=1.5u as=0.2128p ps=1.5u w=1.12u l=0.13u
X2024 sg13cmos5l_buf_16_7.X a_3694_2386# VPWR.t1587 VPWR.t67 sg13_lv_pmos ad=0.2128p pd=1.5u as=0.2128p ps=1.5u w=1.12u l=0.13u
X2025 VGND.t35 VPWR.t58 VGND.t1117 VGND.t1138 sg13_lv_nmos ad=79.8f pd=0.8u as=0 ps=0 w=0.42u l=1u
X2026 VGND.t260 a_3668_9156# sg13cmos5l_buf_16_13.A VGND.t269 sg13_lv_nmos ad=0.1406p pd=1.12u as=0.1406p ps=1.12u w=0.74u l=0.13u
X2027 sg13cmos5l_and2_2_6.A a_3694_10704# VPWR.t1198 VPWR.t2 sg13_lv_pmos ad=0.2128p pd=1.5u as=0.2128p ps=1.5u w=1.12u l=0.13u
X2028 sg13cmos5l_buf_16_33.A a_3694_14482# VGND.t870 VGND.t877 sg13_lv_nmos ad=0.1406p pd=1.12u as=0.1406p ps=1.12u w=0.74u l=0.13u
X2029 VGND.t989 VPWR.t1667 VGND.t994 VGND.t2 sg13_lv_nmos ad=79.8f pd=0.8u as=0 ps=0 w=0.42u l=1u
X2030 sg13cmos5l_buf_16_30.A a_6164_2350# VGND.t837 VGND.t1542 sg13_lv_nmos ad=0.1406p pd=1.12u as=0.1406p ps=1.12u w=0.74u l=0.13u
X2031 VPWR.t1277 a_3668_4620# sg13cmos5l_buf_16_8.A VPWR.t64 sg13_lv_pmos ad=0.2128p pd=1.5u as=0.2128p ps=1.5u w=1.12u l=0.13u
X2032 VGND.t1 VPWR.t1696 VGND.t891 VGND.t904 sg13_lv_nmos ad=0.1428p pd=1.52u as=0 ps=0 w=0.42u l=1u
X2033 VGND.t637 VPWR.t110 VGND.t637 VGND.t1232 sg13_lv_nmos ad=79.8f pd=0.8u as=0 ps=0 w=0.42u l=1u
X2034 VGND.t61 a_3694_8434# sg13cmos5l_buf_16_34.A VGND.t60 sg13_lv_nmos ad=0.1406p pd=1.12u as=0.1406p ps=1.12u w=0.74u l=0.13u
X2035 VGND.t1237 VPWR.t1617 VGND.t1237 VGND.t40 sg13_lv_nmos ad=79.8f pd=0.8u as=0 ps=0 w=0.42u l=1u
X2036 VGND.t1165 VPWR.t59 VGND.t1167 VGND.t1166 sg13_lv_nmos ad=79.8f pd=0.8u as=0 ps=0 w=0.42u l=1u
X2037 VGND.t1050 VPWR.t1663 VGND.t1050 VGND.t1053 sg13_lv_nmos ad=79.8f pd=0.8u as=0 ps=0 w=0.42u l=1u
X2038 VGND.t590 VPWR.t16 VGND.t590 VGND.t972 sg13_lv_nmos ad=0.1428p pd=1.52u as=0 ps=0 w=0.42u l=1u
X2039 sg13cmos5l_buf_16_0.A a_6094_3898# VGND.t125 VGND.t40 sg13_lv_nmos ad=0.1406p pd=1.12u as=0.1406p ps=1.12u w=0.74u l=0.13u
X2040 VGND.t5 VPWR.t1649 VGND.t5 VGND.t1103 sg13_lv_nmos ad=79.8f pd=0.8u as=0 ps=0 w=0.42u l=1u
X2041 a_4174_13728# sg13cmos5l_and2_2_1.X VGND.t870 VGND.t1470 sg13_lv_nmos ad=0.1406p pd=1.12u as=0.1406p ps=1.12u w=0.74u l=0.13u
X2042 VGND.t61 VPWR.t1645 VGND.t61 VGND.t1129 sg13_lv_nmos ad=0.1428p pd=1.52u as=0 ps=0 w=0.42u l=1u
X2043 VGND.t597 a_8948_13692# sg13cmos5l_buf_16_37.A VGND.t651 sg13_lv_nmos ad=0.1406p pd=1.12u as=0.1406p ps=1.12u w=0.74u l=0.13u
X2044 VPWR.t566 sg13cmos5l_buf_1_17.X a_12350_13728# VPWR.t79 sg13_lv_pmos ad=0.36p pd=2.72u as=0.1225p ps=1.245u w=1u l=0.13u
X2045 VPWR.t1467 VGND.t1147 VPWR.t1465 VPWR.t61 sg13_lv_pmos ad=0.19p pd=1.38u as=0 ps=0 w=1u l=1u
X2046 VPWR.t890 a_3694_7680# sg13cmos5l_buf_16_34.X VPWR.t58 sg13_lv_pmos ad=0.2128p pd=1.5u as=0.2128p ps=1.5u w=1.12u l=0.13u
X2047 VGND.t841 a_3020_14442# sg13cmos5l_and2_2_1.B VGND.t896 sg13_lv_nmos ad=0.14875p pd=1.16u as=0.2886p ps=2.26u w=0.74u l=0.13u
X2048 a_6766_8434# sg13cmos5l_buf_16_25.A VGND.t61 VGND.t276 sg13_lv_nmos ad=0.1406p pd=1.12u as=0.2516p ps=2.16u w=0.74u l=0.13u
X2049 VPWR.t1454 VGND.t1147 VPWR.t1453 VPWR.t58 sg13_lv_pmos ad=0.34p pd=2.68u as=0 ps=0 w=1u l=1u
X2050 VPWR.t189 VGND.t134 VPWR.t187 VPWR.t8 sg13_lv_pmos ad=0.19p pd=1.38u as=0 ps=0 w=1u l=1u
X2051 VPWR.t858 a_3668_3108# sg13cmos5l_buf_16_7.A VPWR.t67 sg13_lv_pmos ad=0.2128p pd=1.5u as=0.2128p ps=1.5u w=1.12u l=0.13u
X2052 VPWR.t237 VGND.t870 VPWR.t236 VPWR.t79 sg13_lv_pmos ad=0.19p pd=1.38u as=0 ps=0 w=1u l=1u
X2053 a_3694_10704# sg13cmos5l_buf_16_34.X VPWR.t555 VPWR.t2 sg13_lv_pmos ad=0.2128p pd=1.5u as=0.2128p ps=1.5u w=1.12u l=0.13u
X2054 a_3875_5396# sg13cmos5l_xor2_1_0.B a_4105_5452# VGND.t804 sg13_lv_nmos ad=0.2176p pd=1.96u as=0.1216p ps=1.02u w=0.64u l=0.13u
X2055 a_8110_6168# sg13cmos5l_buf_16_35.A VPWR.t151 VPWR.t61 sg13_lv_pmos ad=0.2128p pd=1.5u as=0.2128p ps=1.5u w=1.12u l=0.13u
X2056 sg13cmos5l_buf_16_0.A a_6094_3898# VPWR.t752 VPWR.t64 sg13_lv_pmos ad=0.2128p pd=1.5u as=0.2128p ps=1.5u w=1.12u l=0.13u
X2057 sg13cmos5l_buf_16_4.X a_9524_6886# VPWR.t335 VPWR.t58 sg13_lv_pmos ad=0.2128p pd=1.5u as=0.2128p ps=1.5u w=1.12u l=0.13u
X2058 VGND.t237 sg13cmos5l_buf_1_17.A a_10292_12934# VGND.t243 sg13_lv_nmos ad=0.2516p pd=2.16u as=0.1406p ps=1.12u w=0.74u l=0.13u
X2059 VGND.t125 enable a_6094_3898# VGND.t40 sg13_lv_nmos ad=0.1406p pd=1.12u as=0.1406p ps=1.12u w=0.74u l=0.13u
X2060 sg13cmos5l_buf_16_37.X a_7796_12934# VPWR.t1147 VPWR.t79 sg13_lv_pmos ad=0.2128p pd=1.5u as=0.2128p ps=1.5u w=1.12u l=0.13u
X2061 sg13cmos5l_buf_16_33.A a_3694_14482# VPWR.t1335 VPWR.t0 sg13_lv_pmos ad=0.2128p pd=1.5u as=0.2128p ps=1.5u w=1.12u l=0.13u
X2062 a_3694_7680# sg13cmos5l_buf_16_34.A VPWR.t213 VPWR.t58 sg13_lv_pmos ad=0.2128p pd=1.5u as=0.2128p ps=1.5u w=1.12u l=0.13u
X2063 VPWR.t549 VGND.t942 VPWR.t547 VPWR.t8 sg13_lv_pmos ad=0.19p pd=1.38u as=0 ps=0 w=1u l=1u
X2064 VPWR.t16 VGND.t590 VPWR.t37 VPWR.t8 sg13_lv_pmos ad=0.34p pd=2.68u as=0 ps=0 w=1u l=1u
X2065 a_4052_12934# sg13cmos5l_buf_16_18.A VPWR.t1108 VPWR.t79 sg13_lv_pmos ad=0.2128p pd=1.5u as=0.2128p ps=1.5u w=1.12u l=0.13u
X2066 VPWR.t769 a_6094_3144# sg13cmos5l_xor2_1_0.B VPWR.t67 sg13_lv_pmos ad=0.2128p pd=1.5u as=0.2128p ps=1.5u w=1.12u l=0.13u
X2067 sg13cmos5l_buf_16_7.A a_3668_3108# VPWR.t854 VPWR.t67 sg13_lv_pmos ad=0.2128p pd=1.5u as=0.2128p ps=1.5u w=1.12u l=0.13u
X2068 VPWR.t440 VGND.t1061 VPWR.t440 VPWR.t5 sg13_lv_pmos ad=0.19p pd=1.38u as=0 ps=0 w=1u l=1u
X2069 VGND.t50 a_3694_8434# sg13cmos5l_buf_16_34.A VGND.t56 sg13_lv_nmos ad=0.1406p pd=1.12u as=0.1406p ps=1.12u w=0.74u l=0.13u
X2070 a_10318_5410# sg13cmos5l_buf_16_3.X VGND.t76 VGND.t80 sg13_lv_nmos ad=0.1406p pd=1.12u as=0.1406p ps=1.12u w=0.74u l=0.13u
X2071 VPWR.t149 sg13cmos5l_buf_16_35.A a_8110_6168# VPWR.t61 sg13_lv_pmos ad=0.2128p pd=1.5u as=0.2128p ps=1.5u w=1.12u l=0.13u
X2072 VPWR.t335 a_9524_6886# sg13cmos5l_buf_16_4.X VPWR.t58 sg13_lv_pmos ad=0.2128p pd=1.5u as=0.2128p ps=1.5u w=1.12u l=0.13u
X2073 VPWR.t77 VGND.t206 VPWR.t75 VPWR.t0 sg13_lv_pmos ad=0.19p pd=1.38u as=0 ps=0 w=1u l=1u
X2074 sg13cmos5l_buf_16_25.A a_6836_9156# VPWR.t501 VPWR.t5 sg13_lv_pmos ad=0.2128p pd=1.5u as=0.2128p ps=1.5u w=1.12u l=0.13u
X2075 VGND.t5 VPWR.t91 VGND.t5 VGND.t1134 sg13_lv_nmos ad=79.8f pd=0.8u as=0 ps=0 w=0.42u l=1u
X2076 VGND.t61 a_3694_7680# sg13cmos5l_buf_16_34.X VGND.t63 sg13_lv_nmos ad=0.2516p pd=2.16u as=0.1406p ps=1.12u w=0.74u l=0.13u
X2077 sg13cmos5l_buf_16_34.A a_3694_8434# VPWR.t274 VPWR.t5 sg13_lv_pmos ad=0.2128p pd=1.5u as=0.2128p ps=1.5u w=1.12u l=0.13u
X2078 sg13cmos5l_buf_16_23.X a_10292_12934# VPWR.t566 VPWR.t79 sg13_lv_pmos ad=0.2128p pd=1.5u as=0.2128p ps=1.5u w=1.12u l=0.13u
X2079 VPWR.t143 a_10292_4620# sg13cmos5l_buf_16_3.X VPWR.t64 sg13_lv_pmos ad=0.2128p pd=1.5u as=0.2128p ps=1.5u w=1.12u l=0.13u
X2080 a_9262_7680# sg13cmos5l_buf_16_4.X VPWR.t335 VPWR.t58 sg13_lv_pmos ad=0.2128p pd=1.5u as=0.2128p ps=1.5u w=1.12u l=0.13u
X2081 VGND.t15 sg13cmos5l_and2_2_6.B a_7723_8028# VGND.t1503 sg13_lv_nmos ad=0.1331p pd=1.12u as=0.1216p ps=1.02u w=0.64u l=0.13u
X2082 a_6548_13692# sg13cmos5l_buf_16_37.X VPWR.t1418 VPWR.t79 sg13_lv_pmos ad=0.2128p pd=1.5u as=0.2128p ps=1.5u w=1.12u l=0.13u
X2083 VGND.t590 a_10292_12934# sg13cmos5l_buf_16_23.X VGND.t669 sg13_lv_nmos ad=0.1406p pd=1.12u as=0.1406p ps=1.12u w=0.74u l=0.13u
X2084 sg13cmos5l_and2_2_0.B a_1672_14516# VPWR.t1348 VPWR.t0 sg13_lv_pmos ad=0.42p pd=2.99u as=0.2114p ps=1.54u w=1.12u l=0.13u
X2085 VGND.t237 sg13cmos5l_buf_1_17.A a_10292_12934# VGND.t239 sg13_lv_nmos ad=0.1406p pd=1.12u as=0.1406p ps=1.12u w=0.74u l=0.13u
X2086 VPWR.t652 sg13cmos5l_buf_16_25.A a_6766_8434# VPWR.t5 sg13_lv_pmos ad=0.2128p pd=1.5u as=0.2128p ps=1.5u w=1.12u l=0.13u
X2087 VGND.t801 a_3668_4620# sg13cmos5l_buf_16_8.A VGND.t826 sg13_lv_nmos ad=0.1406p pd=1.12u as=0.1406p ps=1.12u w=0.74u l=0.13u
X2088 sg13cmos5l_buf_16_34.X a_3694_7680# VGND.t50 VGND.t59 sg13_lv_nmos ad=0.1406p pd=1.12u as=0.1406p ps=1.12u w=0.74u l=0.13u
X2089 VPWR.t359 VGND.t1237 VPWR.t357 VPWR.t64 sg13_lv_pmos ad=0.19p pd=1.38u as=0 ps=0 w=1u l=1u
X2090 VGND.t620 VPWR.t1685 VGND.t620 VGND.t952 sg13_lv_nmos ad=0.1428p pd=1.52u as=0 ps=0 w=0.42u l=1u
X2091 VGND.t1196 VPWR.t1628 VGND.t1196 VGND.t1195 sg13_lv_nmos ad=0.1428p pd=1.52u as=0 ps=0 w=0.42u l=1u
X2092 VGND.t194 VPWR.t86 VGND.t194 VGND.t1313 sg13_lv_nmos ad=0.1428p pd=1.52u as=0 ps=0 w=0.42u l=1u
X2093 VPWR.t110 VGND.t349 VPWR.t110 VPWR.t64 sg13_lv_pmos ad=0.19p pd=1.38u as=0 ps=0 w=1u l=1u
X2094 a_10318_5410# sg13cmos5l_buf_16_3.X VGND.t76 VGND.t75 sg13_lv_nmos ad=0.1406p pd=1.12u as=0.2516p ps=2.16u w=0.74u l=0.13u
X2095 VPWR.t196 VGND.t351 VPWR.t195 VPWR.t61 sg13_lv_pmos ad=0.34p pd=2.68u as=0 ps=0 w=1u l=1u
X2096 sg13cmos5l_buf_16_23.X a_10292_12934# VPWR.t566 VPWR.t79 sg13_lv_pmos ad=0.2128p pd=1.5u as=0.2128p ps=1.5u w=1.12u l=0.13u
X2097 sg13cmos5l_buf_16_8.A a_3668_4620# VGND.t797 VGND.t823 sg13_lv_nmos ad=0.1406p pd=1.12u as=0.1406p ps=1.12u w=0.74u l=0.13u
X2098 VGND.t7 VPWR.t1636 VGND.t7 VGND.t1155 sg13_lv_nmos ad=0.1428p pd=1.52u as=0 ps=0 w=0.42u l=1u
X2099 sg13cmos5l_buf_16_13.A a_3668_9156# VPWR.t636 VPWR.t5 sg13_lv_pmos ad=0.2128p pd=1.5u as=0.2128p ps=1.5u w=1.12u l=0.13u
X2100 VGND.t76 VPWR.t61 VGND.t76 VGND.t1206 sg13_lv_nmos ad=79.8f pd=0.8u as=0 ps=0 w=0.42u l=1u
X2101 VPWR.t61 sg13cmos5l_buf_16_3.X a_10318_5410# VPWR.t61 sg13_lv_pmos ad=0.2128p pd=1.5u as=0.2128p ps=1.5u w=1.12u l=0.13u
X2102 VGND.t1237 VPWR.t1616 VGND.t310 VGND.t40 sg13_lv_nmos ad=79.8f pd=0.8u as=0 ps=0 w=0.42u l=1u
X2103 VPWR.t495 a_5204_11422# sg13cmos5l_buf_16_20.A VPWR.t8 sg13_lv_pmos ad=0.2128p pd=1.5u as=0.2128p ps=1.5u w=1.12u l=0.13u
X2104 sg13cmos5l_buf_16_14.A a_4436_9910# VGND.t66 VGND.t763 sg13_lv_nmos ad=0.1406p pd=1.12u as=0.1406p ps=1.12u w=0.74u l=0.13u
X2105 sg13cmos5l_xor2_1_0.B a_6094_3144# VGND.t125 VGND.t40 sg13_lv_nmos ad=0.1406p pd=1.12u as=0.1406p ps=1.12u w=0.74u l=0.13u
X2106 VPWR.t62 VGND.t1208 VPWR.t62 VPWR.t61 sg13_lv_pmos ad=0.34p pd=2.68u as=0 ps=0 w=1u l=1u
X2107 VGND.t1286 VPWR.t216 VGND.t1290 VGND.t1289 sg13_lv_nmos ad=79.8f pd=0.8u as=0 ps=0 w=0.42u l=1u
X2108 sg13cmos5l_buf_1_2.A a_8538_2578# VGND.t31 VGND.t416 sg13_lv_nmos ad=0.1628p pd=1.18u as=0.3108p ps=2.32u w=0.74u l=0.13u
X2109 sg13cmos5l_buf_16_2.X a_10318_3898# VPWR.t143 VPWR.t64 sg13_lv_pmos ad=0.2128p pd=1.5u as=0.2128p ps=1.5u w=1.12u l=0.13u
X2110 VPWR.t1527 a_3694_3898# sg13cmos5l_buf_16_10.A VPWR.t64 sg13_lv_pmos ad=0.2128p pd=1.5u as=0.2128p ps=1.5u w=1.12u l=0.13u
X2111 VGND.t125 enable a_6094_3898# VGND.t40 sg13_lv_nmos ad=0.1406p pd=1.12u as=0.1406p ps=1.12u w=0.74u l=0.13u
X2112 a_9882_8446# sg13cmos5l_buf_16_35.A VGND.t5 VGND.t4 sg13_lv_nmos ad=88.8f pd=0.98u as=0.15245p ps=1.17u w=0.74u l=0.13u
X2113 VGND.t797 a_3668_4620# sg13cmos5l_buf_16_8.A VGND.t820 sg13_lv_nmos ad=0.1406p pd=1.12u as=0.1406p ps=1.12u w=0.74u l=0.13u
X2114 sg13cmos5l_and2_2_1.X a_2147_13692# VPWR.t1432 VPWR.t79 sg13_lv_pmos ad=0.2128p pd=1.5u as=0.4256p ps=3u w=1.12u l=0.13u
X2115 sg13cmos5l_buf_16_34.X a_3694_7680# VGND.t50 VGND.t55 sg13_lv_nmos ad=0.1406p pd=1.12u as=0.1406p ps=1.12u w=0.74u l=0.13u
X2116 VPWR.t1458 VGND.t1147 VPWR.t1457 VPWR.t58 sg13_lv_pmos ad=0.34p pd=2.68u as=0 ps=0 w=1u l=1u
X2117 VPWR.t3 VGND.t1061 VPWR.t3 VPWR.t2 sg13_lv_pmos ad=0.19p pd=1.38u as=0 ps=0 w=1u l=1u
X2118 sg13cmos5l_buf_16_7.A a_3668_3108# VPWR.t850 VPWR.t67 sg13_lv_pmos ad=0.2128p pd=1.5u as=0.2128p ps=1.5u w=1.12u l=0.13u
X2119 VGND.t66 a_4436_9910# sg13cmos5l_buf_16_14.A VGND.t760 sg13_lv_nmos ad=0.1406p pd=1.12u as=0.1406p ps=1.12u w=0.74u l=0.13u
X2120 sg13cmos5l_buf_16_22.X a_10318_8434# VGND.t5 VGND.t587 sg13_lv_nmos ad=0.1406p pd=1.12u as=0.1406p ps=1.12u w=0.74u l=0.13u
X2121 VGND.t125 sg13cmos5l_buf_16_5.X a_6094_3144# VGND.t40 sg13_lv_nmos ad=0.1406p pd=1.12u as=0.1406p ps=1.12u w=0.74u l=0.13u
X2122 VPWR.t169 VGND.t18 VPWR.t168 VPWR.t5 sg13_lv_pmos ad=0.19p pd=1.38u as=0 ps=0 w=1u l=1u
X2123 VGND.t590 VPWR.t20 VGND.t590 VGND.t977 sg13_lv_nmos ad=79.8f pd=0.8u as=0 ps=0 w=0.42u l=1u
X2124 VPWR.t143 a_10318_3898# sg13cmos5l_buf_16_2.X VPWR.t64 sg13_lv_pmos ad=0.2128p pd=1.5u as=0.2128p ps=1.5u w=1.12u l=0.13u
X2125 a_3694_3898# sg13cmos5l_buf_16_8.A VPWR.t687 VPWR.t64 sg13_lv_pmos ad=0.2128p pd=1.5u as=0.2128p ps=1.5u w=1.12u l=0.13u
X2126 VPWR.t814 a_3668_12180# sg13cmos5l_buf_16_15.X VPWR.t8 sg13_lv_pmos ad=0.2128p pd=1.5u as=0.2128p ps=1.5u w=1.12u l=0.13u
X2127 sg13cmos5l_buf_16_34.A a_3694_8434# VPWR.t270 VPWR.t5 sg13_lv_pmos ad=0.2128p pd=1.5u as=0.2128p ps=1.5u w=1.12u l=0.13u
X2128 sg13cmos5l_buf_16_6.X a_5518_6922# VGND.t218 VGND.t537 sg13_lv_nmos ad=0.1406p pd=1.12u as=0.1406p ps=1.12u w=0.74u l=0.13u
X2129 VPWR.t491 a_5204_11422# sg13cmos5l_buf_16_20.A VPWR.t8 sg13_lv_pmos ad=0.2128p pd=1.5u as=0.2128p ps=1.5u w=1.12u l=0.13u
X2130 sg13cmos5l_buf_16_24.X a_6862_9946# VPWR.t830 VPWR.t2 sg13_lv_pmos ad=0.2128p pd=1.5u as=0.2128p ps=1.5u w=1.12u l=0.13u
X2131 VGND.t5 a_10318_8434# sg13cmos5l_buf_16_22.X VGND.t584 sg13_lv_nmos ad=0.1406p pd=1.12u as=0.1406p ps=1.12u w=0.74u l=0.13u
X2132 VPWR.t61 sg13cmos5l_buf_16_3.X a_10318_5410# VPWR.t61 sg13_lv_pmos ad=0.2128p pd=1.5u as=0.2128p ps=1.5u w=1.12u l=0.13u
X2133 VGND.t1010 VPWR.t21 VGND.t1010 VGND.t2 sg13_lv_nmos ad=0.1428p pd=1.52u as=0 ps=0 w=0.42u l=1u
X2134 VPWR.t6 VGND.t1061 VPWR.t6 VPWR.t5 sg13_lv_pmos ad=0.19p pd=1.38u as=0 ps=0 w=1u l=1u
X2135 VPWR.t205 VGND.t1370 VPWR.t57 VPWR.t55 sg13_lv_pmos ad=0.19p pd=1.38u as=0 ps=0 w=1u l=1u
X2136 a_11659_8028# sg13cmos5l_buf_16_6.X a_11565_8028# VGND.t192 sg13_lv_nmos ad=0.1216p pd=1.02u as=0.2176p ps=1.96u w=0.64u l=0.13u
X2137 sg13cmos5l_and2_2_6.B a_7432_14516# VPWR.t1 VPWR.t0 sg13_lv_pmos ad=0.42p pd=2.99u as=0.2114p ps=1.54u w=1.12u l=0.13u
X2138 VGND.t942 VPWR.t1683 VGND.t942 VGND.t941 sg13_lv_nmos ad=0.1428p pd=1.52u as=0 ps=0 w=0.42u l=1u
X2139 VGND.t620 a_6161_12574# sg13cmos5l_buf_1_5.A VGND.t627 sg13_lv_nmos ad=0.3108p pd=2.32u as=0.1628p ps=1.18u w=0.74u l=0.13u
X2140 VPWR.t1099 sg13cmos5l_buf_16_28.X a_5518_6922# VPWR.t58 sg13_lv_pmos ad=0.2128p pd=1.5u as=0.2128p ps=1.5u w=1.12u l=0.13u
X2141 VGND.t1113 VPWR.t59 VGND.t1115 VGND.t1136 sg13_lv_nmos ad=79.8f pd=0.8u as=0 ps=0 w=0.42u l=1u
X2142 VPWR.t216 a_8494_3144# sg13cmos5l_buf_16_39.A VPWR.t67 sg13_lv_pmos ad=0.2128p pd=1.5u as=0.2128p ps=1.5u w=1.12u l=0.13u
X2143 VGND.t801 sg13cmos5l_and2_2_0.X a_4462_5410# VGND.t800 sg13_lv_nmos ad=0.1406p pd=1.12u as=0.1406p ps=1.12u w=0.74u l=0.13u
X2144 VGND.t218 a_5518_6922# sg13cmos5l_buf_16_6.X VGND.t534 sg13_lv_nmos ad=0.1406p pd=1.12u as=0.1406p ps=1.12u w=0.74u l=0.13u
X2145 VPWR.t21 VGND.t590 VPWR.t20 VPWR.t8 sg13_lv_pmos ad=0.19p pd=1.38u as=0 ps=0 w=1u l=1u
X2146 sg13cmos5l_buf_16_24.A a_6094_10704# VGND.t139 VGND.t2 sg13_lv_nmos ad=0.1406p pd=1.12u as=0.1406p ps=1.12u w=0.74u l=0.13u
X2147 VPWR.t62 VGND.t181 VPWR.t96 VPWR.t61 sg13_lv_pmos ad=0.34p pd=2.68u as=0 ps=0 w=1u l=1u
X2148 VGND.t1378 VPWR.t250 VGND.t1380 VGND.t1379 sg13_lv_nmos ad=79.8f pd=0.8u as=0 ps=0 w=0.42u l=1u
X2149 VGND.t1286 VPWR.t126 VGND.t1290 VGND.t1326 sg13_lv_nmos ad=79.8f pd=0.8u as=0 ps=0 w=0.42u l=1u
X2150 VPWR.t931 VGND.t994 VPWR.t930 VPWR.t2 sg13_lv_pmos ad=0.34p pd=2.68u as=0 ps=0 w=1u l=1u
X2151 VGND.t42 VPWR.t1619 VGND.t42 VGND.t40 sg13_lv_nmos ad=79.8f pd=0.8u as=0 ps=0 w=0.42u l=1u
X2152 VGND.t3 VPWR.t135 VGND.t3 VGND.t2 sg13_lv_nmos ad=0.1428p pd=1.52u as=0 ps=0 w=0.42u l=1u
X2153 a_6862_9946# sg13cmos5l_buf_16_24.A VPWR.t632 VPWR.t2 sg13_lv_pmos ad=0.2128p pd=1.5u as=0.2128p ps=1.5u w=1.12u l=0.13u
X2154 VPWR.t6 a_10318_8434# sg13cmos5l_buf_16_22.X VPWR.t5 sg13_lv_pmos ad=0.3976p pd=2.95u as=0.2128p ps=1.5u w=1.12u l=0.13u
X2155 sg13cmos5l_buf_16_39.A a_8494_3144# VPWR.t216 VPWR.t67 sg13_lv_pmos ad=0.2128p pd=1.5u as=0.2128p ps=1.5u w=1.12u l=0.13u
X2156 a_4462_5410# sg13cmos5l_and2_2_0.X VGND.t797 VGND.t796 sg13_lv_nmos ad=0.1406p pd=1.12u as=0.2516p ps=2.16u w=0.74u l=0.13u
X2157 VPWR.t59 VGND.t1113 VPWR.t59 VPWR.t58 sg13_lv_pmos ad=0.34p pd=2.68u as=0 ps=0 w=1u l=1u
X2158 VGND.t457 a_3668_12180# sg13cmos5l_buf_16_15.X VGND.t459 sg13_lv_nmos ad=0.1406p pd=1.12u as=0.1406p ps=1.12u w=0.74u l=0.13u
X2159 a_8564_2680# sg13cmos5l_buf_16_39.A VPWR.t217 VPWR.t67 sg13_lv_pmos ad=0.3808p pd=2.92u as=0.2128p ps=1.5u w=1.12u l=0.13u
X2160 VGND.t198 VPWR.t56 VGND.t198 VGND.t1315 sg13_lv_nmos ad=0.1428p pd=1.52u as=0 ps=0 w=0.42u l=1u
X2161 VGND.t204 sg13cmos5l_buf_1_17.X a_12054_14086# VGND.t203 sg13_lv_nmos ad=0.15245p pd=1.17u as=88.8f ps=0.98u w=0.74u l=0.13u
X2162 VPWR.t975 VGND.t444 VPWR.t974 VPWR.t79 sg13_lv_pmos ad=0.34p pd=2.68u as=0 ps=0 w=1u l=1u
X2163 VPWR.t566 sg13cmos5l_buf_16_37.A a_7796_12934# VPWR.t79 sg13_lv_pmos ad=0.3808p pd=2.92u as=0.2128p ps=1.5u w=1.12u l=0.13u
X2164 VPWR.t598 VGND.t1141 VPWR.t597 VPWR.t58 sg13_lv_pmos ad=0.34p pd=2.68u as=0 ps=0 w=1u l=1u
X2165 sg13cmos5l_buf_16_18.A a_4174_13728# VPWR.t1361 VPWR.t79 sg13_lv_pmos ad=0.2128p pd=1.5u as=0.2128p ps=1.5u w=1.12u l=0.13u
X2166 a_8948_13692# sg13cmos5l_buf_16_23.X VPWR.t566 VPWR.t79 sg13_lv_pmos ad=0.2128p pd=1.5u as=0.2128p ps=1.5u w=1.12u l=0.13u
X2167 VPWR.t129 VGND.t1010 VPWR.t128 VPWR.t8 sg13_lv_pmos ad=0.34p pd=2.68u as=0 ps=0 w=1u l=1u
X2168 sg13cmos5l_buf_16_3.X a_10292_4620# VGND.t86 VGND.t87 sg13_lv_nmos ad=0.1406p pd=1.12u as=0.1406p ps=1.12u w=0.74u l=0.13u
X2169 sg13cmos5l_buf_16_24.A a_6094_10704# VGND.t139 VGND.t2 sg13_lv_nmos ad=0.1406p pd=1.12u as=0.1406p ps=1.12u w=0.74u l=0.13u
X2170 VGND.t7 VPWR.t1635 VGND.t7 VGND.t1157 sg13_lv_nmos ad=0.1428p pd=1.52u as=0 ps=0 w=0.42u l=1u
X2171 sg13cmos5l_buf_16_22.X a_10318_8434# VPWR.t6 VPWR.t5 sg13_lv_pmos ad=0.2128p pd=1.5u as=0.2128p ps=1.5u w=1.12u l=0.13u
X2172 VPWR.t566 a_8948_13692# sg13cmos5l_buf_16_37.A VPWR.t79 sg13_lv_pmos ad=0.2128p pd=1.5u as=0.2128p ps=1.5u w=1.12u l=0.13u
X2173 VGND.t194 sg13cmos5l_buf_16_7.A a_3694_2386# VGND.t195 sg13_lv_nmos ad=0.1406p pd=1.12u as=0.1406p ps=1.12u w=0.74u l=0.13u
X2174 VGND.t66 a_4436_9910# sg13cmos5l_buf_16_14.A VGND.t756 sg13_lv_nmos ad=0.1406p pd=1.12u as=0.1406p ps=1.12u w=0.74u l=0.13u
X2175 VGND.t125 sg13cmos5l_buf_16_5.X a_6094_3144# VGND.t40 sg13_lv_nmos ad=0.1406p pd=1.12u as=0.1406p ps=1.12u w=0.74u l=0.13u
X2176 VGND.t726 VPWR.t1665 VGND.t726 VGND.t2 sg13_lv_nmos ad=79.8f pd=0.8u as=0 ps=0 w=0.42u l=1u
X2177 VGND.t1292 VPWR.t113 VGND.t1292 VGND.t1293 sg13_lv_nmos ad=79.8f pd=0.8u as=0 ps=0 w=0.42u l=1u
X2178 VPWR.t143 a_10318_3898# sg13cmos5l_buf_16_2.X VPWR.t64 sg13_lv_pmos ad=0.2128p pd=1.5u as=0.2128p ps=1.5u w=1.12u l=0.13u
X2179 sg13cmos5l_buf_16_31.X a_6094_4656# VPWR.t736 VPWR.t64 sg13_lv_pmos ad=0.2128p pd=1.5u as=0.2128p ps=1.5u w=1.12u l=0.13u
X2180 VGND.t989 VPWR.t1676 VGND.t989 VGND.t2 sg13_lv_nmos ad=0.1428p pd=1.52u as=0 ps=0 w=0.42u l=1u
X2181 VPWR.t113 VGND.t1290 VPWR.t216 VPWR.t67 sg13_lv_pmos ad=0.19p pd=1.38u as=0 ps=0 w=1u l=1u
X2182 a_4462_5410# sg13cmos5l_and2_2_0.X VPWR.t1263 VPWR.t61 sg13_lv_pmos ad=0.2128p pd=1.5u as=0.2128p ps=1.5u w=1.12u l=0.13u
X2183 VGND.t76 a_10292_4620# sg13cmos5l_buf_16_3.X VGND.t83 sg13_lv_nmos ad=0.1406p pd=1.12u as=0.1406p ps=1.12u w=0.74u l=0.13u
X2184 VPWR.t956 VGND.t948 VPWR.t551 VPWR.t8 sg13_lv_pmos ad=0.19p pd=1.38u as=0 ps=0 w=1u l=1u
X2185 VGND.t454 a_3668_12180# sg13cmos5l_buf_16_15.X VGND.t453 sg13_lv_nmos ad=0.1406p pd=1.12u as=0.1406p ps=1.12u w=0.74u l=0.13u
X2186 a_3668_12180# sg13cmos5l_buf_16_15.A VPWR.t828 VPWR.t8 sg13_lv_pmos ad=0.2128p pd=1.5u as=0.2128p ps=1.5u w=1.12u l=0.13u
X2187 VPWR.t1508 VGND.t1196 VPWR.t1507 VPWR.t64 sg13_lv_pmos ad=0.34p pd=2.68u as=0 ps=0 w=1u l=1u
X2188 VPWR.t453 VGND.t1050 VPWR.t451 VPWR.t2 sg13_lv_pmos ad=0.19p pd=1.38u as=0 ps=0 w=1u l=1u
X2189 VGND.t1237 VPWR.t1616 VGND.t1237 VGND.t40 sg13_lv_nmos ad=0.1428p pd=1.52u as=0 ps=0 w=0.42u l=1u
X2190 VGND.t1167 VPWR.t58 VGND.t1167 VGND.t1168 sg13_lv_nmos ad=0.1428p pd=1.52u as=0 ps=0 w=0.42u l=1u
X2191 VPWR.t70 VGND.t1147 VPWR.t1461 VPWR.t58 sg13_lv_pmos ad=0.34p pd=2.68u as=0 ps=0 w=1u l=1u
X2192 VGND.t198 sg13cmos5l_buf_16_30.A a_5710_1632# VGND.t834 sg13_lv_nmos ad=0.1406p pd=1.12u as=0.1406p ps=1.12u w=0.74u l=0.13u
X2193 sg13cmos5l_buf_16_30.A a_6164_2350# VPWR.t1549 VPWR.t67 sg13_lv_pmos ad=0.2128p pd=1.5u as=0.2128p ps=1.5u w=1.12u l=0.13u
X2194 VGND.t228 a_5684_6132# sg13cmos5l_buf_16_28.X VGND.t227 sg13_lv_nmos ad=0.1406p pd=1.12u as=0.1406p ps=1.12u w=0.74u l=0.13u
X2195 a_4174_13728# sg13cmos5l_and2_2_1.X VPWR.t1395 VPWR.t79 sg13_lv_pmos ad=0.2128p pd=1.5u as=0.2128p ps=1.5u w=1.12u l=0.13u
X2196 a_6836_9156# sg13cmos5l_and2_2_6.X VPWR.t146 VPWR.t5 sg13_lv_pmos ad=0.2128p pd=1.5u as=0.2128p ps=1.5u w=1.12u l=0.13u
X2197 sg13cmos5l_and2_2_2.B a_5992_14516# VPWR.t1351 VPWR.t0 sg13_lv_pmos ad=0.42p pd=2.99u as=0.2114p ps=1.54u w=1.12u l=0.13u
X2198 VPWR.t1261 sg13cmos5l_and2_2_0.X a_4462_5410# VPWR.t61 sg13_lv_pmos ad=0.2128p pd=1.5u as=0.2128p ps=1.5u w=1.12u l=0.13u
X2199 sg13cmos5l_buf_16_14.A a_4436_9910# VPWR.t1226 VPWR.t2 sg13_lv_pmos ad=0.2128p pd=1.5u as=0.2128p ps=1.5u w=1.12u l=0.13u
X2200 VPWR.t566 a_8948_13692# sg13cmos5l_buf_16_37.A VPWR.t79 sg13_lv_pmos ad=0.2128p pd=1.5u as=0.2128p ps=1.5u w=1.12u l=0.13u
X2201 VGND.t66 sg13cmos5l_buf_16_14.A a_3668_9156# VGND.t69 sg13_lv_nmos ad=0.1406p pd=1.12u as=0.1406p ps=1.12u w=0.74u l=0.13u
X2202 VGND.t726 a_6094_10704# sg13cmos5l_buf_16_24.A VGND.t2 sg13_lv_nmos ad=0.1406p pd=1.12u as=0.1406p ps=1.12u w=0.74u l=0.13u
X2203 VPWR.t407 VGND.t42 VPWR.t405 VPWR.t64 sg13_lv_pmos ad=0.19p pd=1.38u as=0 ps=0 w=1u l=1u
X2204 VPWR.t1547 a_6164_2350# sg13cmos5l_buf_16_30.A VPWR.t67 sg13_lv_pmos ad=0.2128p pd=1.5u as=0.2128p ps=1.5u w=1.12u l=0.13u
X2205 VPWR.t954 VGND.t948 VPWR.t953 VPWR.t79 sg13_lv_pmos ad=0.34p pd=2.68u as=0 ps=0 w=1u l=1u
X2206 VPWR.t515 a_6836_9156# sg13cmos5l_buf_16_25.A VPWR.t5 sg13_lv_pmos ad=0.2128p pd=1.5u as=0.2128p ps=1.5u w=1.12u l=0.13u
X2207 sg13cmos5l_buf_16_30.A a_6164_2350# VGND.t25 VGND.t1555 sg13_lv_nmos ad=0.1406p pd=1.12u as=0.1406p ps=1.12u w=0.74u l=0.13u
X2208 VGND.t444 a_3668_12180# sg13cmos5l_buf_16_15.X VGND.t449 sg13_lv_nmos ad=0.1406p pd=1.12u as=0.1406p ps=1.12u w=0.74u l=0.13u
X2209 VGND.t1274 VPWR.t156 VGND.t1274 VGND.t1278 sg13_lv_nmos ad=0.1428p pd=1.52u as=0 ps=0 w=0.42u l=1u
X2210 VPWR.t922 VGND.t989 VPWR.t1025 VPWR.t8 sg13_lv_pmos ad=0.34p pd=2.68u as=0 ps=0 w=1u l=1u
X2211 a_9617_8484# sg13cmos5l_buf_16_6.X a_9585_8752# VPWR.t5 sg13_lv_pmos ad=0.34p pd=2.68u as=0.1225p ps=1.245u w=1u l=0.13u
X2212 sg13cmos5l_buf_16_39.A a_8494_3144# VPWR.t216 VPWR.t67 sg13_lv_pmos ad=0.2128p pd=1.5u as=0.2128p ps=1.5u w=1.12u l=0.13u
X2213 VGND.t597 sg13cmos5l_buf_16_23.X a_8948_13692# VGND.t598 sg13_lv_nmos ad=0.1406p pd=1.12u as=0.1406p ps=1.12u w=0.74u l=0.13u
X2214 sg13cmos5l_buf_16_0.A a_6094_3898# VGND.t125 VGND.t40 sg13_lv_nmos ad=0.1406p pd=1.12u as=0.1406p ps=1.12u w=0.74u l=0.13u
X2215 VPWR.t131 VGND.t513 VPWR.t131 VPWR.t8 sg13_lv_pmos ad=0.34p pd=2.68u as=0 ps=0 w=1u l=1u
X2216 sg13cmos5l_buf_16_14.A a_4436_9910# VPWR.t1222 VPWR.t2 sg13_lv_pmos ad=0.2128p pd=1.5u as=0.2128p ps=1.5u w=1.12u l=0.13u
X2217 sg13cmos5l_buf_16_30.A a_6164_2350# VPWR.t1543 VPWR.t67 sg13_lv_pmos ad=0.2128p pd=1.5u as=0.2128p ps=1.5u w=1.12u l=0.13u
X2218 sg13cmos5l_buf_16_37.A a_8948_13692# VGND.t597 VGND.t652 sg13_lv_nmos ad=0.1406p pd=1.12u as=0.1406p ps=1.12u w=0.74u l=0.13u
X2219 VGND.t25 a_6164_2350# sg13cmos5l_buf_16_30.A VGND.t1552 sg13_lv_nmos ad=0.1406p pd=1.12u as=0.1406p ps=1.12u w=0.74u l=0.13u
X2220 VPWR.t900 a_3694_7680# sg13cmos5l_buf_16_34.X VPWR.t58 sg13_lv_pmos ad=0.2128p pd=1.5u as=0.2128p ps=1.5u w=1.12u l=0.13u
X2221 VGND.t218 a_5684_6132# sg13cmos5l_buf_16_28.X VGND.t223 sg13_lv_nmos ad=0.1406p pd=1.12u as=0.1406p ps=1.12u w=0.74u l=0.13u
X2222 VPWR.t63 VGND.t1415 VPWR.t226 VPWR.t55 sg13_lv_pmos ad=0.19p pd=1.38u as=0 ps=0 w=1u l=1u
X2223 VGND.t171 a_7220_5374# sg13cmos5l_buf_16_28.A VGND.t339 sg13_lv_nmos ad=0.1406p pd=1.12u as=0.1406p ps=1.12u w=0.74u l=0.13u
X2224 VGND.t210 a_9524_6886# sg13cmos5l_buf_16_4.X VGND.t562 sg13_lv_nmos ad=0.1406p pd=1.12u as=0.1406p ps=1.12u w=0.74u l=0.13u
X2225 sg13cmos5l_buf_16_38.A a_8110_6168# VPWR.t61 VPWR.t61 sg13_lv_pmos ad=0.2128p pd=1.5u as=0.2128p ps=1.5u w=1.12u l=0.13u
X2226 VPWR.t0 VGND.t601 VPWR.t0 VPWR.t0 sg13_lv_pmos ad=0.34p pd=2.68u as=0 ps=0 w=1u l=1u
X2227 VGND.t66 a_3668_9156# sg13cmos5l_buf_16_13.A VGND.t275 sg13_lv_nmos ad=0.1406p pd=1.12u as=0.1406p ps=1.12u w=0.74u l=0.13u
X2228 VPWR.t440 VGND.t1061 VPWR.t146 VPWR.t5 sg13_lv_pmos ad=0.19p pd=1.38u as=0 ps=0 w=1u l=1u
X2229 VPWR.t1337 a_3694_14482# sg13cmos5l_buf_16_33.A VPWR.t0 sg13_lv_pmos ad=0.2128p pd=1.5u as=0.2128p ps=1.5u w=1.12u l=0.13u
X2230 a_10292_4620# sg13cmos5l_buf_16_2.X VPWR.t143 VPWR.t64 sg13_lv_pmos ad=0.2128p pd=1.5u as=0.2128p ps=1.5u w=1.12u l=0.13u
X2231 VPWR.t1283 a_3668_4620# sg13cmos5l_buf_16_8.A VPWR.t64 sg13_lv_pmos ad=0.2128p pd=1.5u as=0.2128p ps=1.5u w=1.12u l=0.13u
X2232 VPWR.t602 VGND.t1141 VPWR.t601 VPWR.t58 sg13_lv_pmos ad=0.34p pd=2.68u as=0 ps=0 w=1u l=1u
X2233 VPWR.t65 VGND.t1237 VPWR.t360 VPWR.t64 sg13_lv_pmos ad=0.34p pd=2.68u as=0 ps=0 w=1u l=1u
X2234 VPWR.t1110 sg13cmos5l_buf_16_18.A a_4052_12934# VPWR.t79 sg13_lv_pmos ad=0.2128p pd=1.5u as=0.2128p ps=1.5u w=1.12u l=0.13u
X2235 sg13cmos5l_xor2_1_4.X a_13745_8484# a_13916_8728# VPWR.t5 sg13_lv_pmos ad=0.3808p pd=2.92u as=0.2128p ps=1.5u w=1.12u l=0.13u
X2236 a_3668_3108# sg13cmos5l_buf_16_10.A VPWR.t471 VPWR.t67 sg13_lv_pmos ad=0.2128p pd=1.5u as=0.2128p ps=1.5u w=1.12u l=0.13u
X2237 VGND.t597 a_8948_13692# sg13cmos5l_buf_16_37.A VGND.t659 sg13_lv_nmos ad=0.1406p pd=1.12u as=0.1406p ps=1.12u w=0.74u l=0.13u
X2238 VGND.t1050 VPWR.t1657 VGND.t260 VGND.t1055 sg13_lv_nmos ad=79.8f pd=0.8u as=0 ps=0 w=0.42u l=1u
X2239 VGND.t1208 VPWR.t62 VGND.t181 VGND.t1207 sg13_lv_nmos ad=0.1428p pd=1.52u as=0 ps=0 w=0.42u l=1u
X2240 sg13cmos5l_buf_16_28.A a_7220_5374# VGND.t171 VGND.t336 sg13_lv_nmos ad=0.1406p pd=1.12u as=0.1406p ps=1.12u w=0.74u l=0.13u
X2241 VPWR.t61 a_8110_6168# sg13cmos5l_buf_16_38.A VPWR.t61 sg13_lv_pmos ad=0.2128p pd=1.5u as=0.2128p ps=1.5u w=1.12u l=0.13u
X2242 sg13cmos5l_buf_16_4.X a_9524_6886# VGND.t210 VGND.t559 sg13_lv_nmos ad=0.1406p pd=1.12u as=0.1406p ps=1.12u w=0.74u l=0.13u
X2243 VPWR.t3 VGND.t1061 VPWR.t3 VPWR.t2 sg13_lv_pmos ad=0.34p pd=2.68u as=0 ps=0 w=1u l=1u
X2244 sg13cmos5l_buf_16_33.A a_3694_14482# VGND.t891 VGND.t892 sg13_lv_nmos ad=0.1406p pd=1.12u as=0.1406p ps=1.12u w=0.74u l=0.13u
X2245 sg13cmos5l_buf_16_14.A a_4436_9910# VPWR.t1218 VPWR.t2 sg13_lv_pmos ad=0.2128p pd=1.5u as=0.2128p ps=1.5u w=1.12u l=0.13u
X2246 sg13cmos5l_buf_16_28.X a_5684_6132# VPWR.t578 VPWR.t61 sg13_lv_pmos ad=0.2128p pd=1.5u as=0.2128p ps=1.5u w=1.12u l=0.13u
X2247 sg13cmos5l_buf_16_37.A a_8948_13692# VGND.t597 VGND.t648 sg13_lv_nmos ad=0.1406p pd=1.12u as=0.1406p ps=1.12u w=0.74u l=0.13u
X2248 sg13cmos5l_buf_16_0.A a_6094_3898# VGND.t125 VGND.t40 sg13_lv_nmos ad=0.1406p pd=1.12u as=0.1406p ps=1.12u w=0.74u l=0.13u
X2249 VPWR.t143 a_10292_4620# sg13cmos5l_buf_16_3.X VPWR.t64 sg13_lv_pmos ad=0.2128p pd=1.5u as=0.2128p ps=1.5u w=1.12u l=0.13u
X2250 VPWR.t113 VGND.t1292 VPWR.t113 VPWR.t67 sg13_lv_pmos ad=0.19p pd=1.38u as=0 ps=0 w=1u l=1u
X2251 sg13cmos5l_buf_16_8.A a_3668_4620# VPWR.t1279 VPWR.t64 sg13_lv_pmos ad=0.2128p pd=1.5u as=0.2128p ps=1.5u w=1.12u l=0.13u
X2252 VGND.t206 VPWR.t75 VGND.t206 VGND.t921 sg13_lv_nmos ad=79.8f pd=0.8u as=0 ps=0 w=0.42u l=1u
X2253 sg13cmos5l_buf_16_35.A a_6766_8434# VGND.t61 VGND.t283 sg13_lv_nmos ad=0.1406p pd=1.12u as=0.1406p ps=1.12u w=0.74u l=0.13u
X2254 VGND.t302 a_8494_3144# sg13cmos5l_buf_16_39.A VGND.t40 sg13_lv_nmos ad=0.2516p pd=2.16u as=0.1406p ps=1.12u w=0.74u l=0.13u
X2255 VGND.t210 a_9524_6886# sg13cmos5l_buf_16_4.X VGND.t556 sg13_lv_nmos ad=0.1406p pd=1.12u as=0.1406p ps=1.12u w=0.74u l=0.13u
X2256 VPWR.t1333 a_3694_14482# sg13cmos5l_buf_16_33.A VPWR.t0 sg13_lv_pmos ad=0.2128p pd=1.5u as=0.2128p ps=1.5u w=1.12u l=0.13u
X2257 a_3694_10704# sg13cmos5l_buf_16_34.X VGND.t134 VGND.t2 sg13_lv_nmos ad=0.1406p pd=1.12u as=0.2516p ps=2.16u w=0.74u l=0.13u
X2258 VGND.t351 sg13cmos5l_buf_16_11.A a_3668_4620# VGND.t1564 sg13_lv_nmos ad=0.2516p pd=2.16u as=0.1406p ps=1.12u w=0.74u l=0.13u
X2259 VPWR.t1091 a_4052_12934# sg13cmos5l_buf_16_15.A VPWR.t79 sg13_lv_pmos ad=0.2128p pd=1.5u as=0.2128p ps=1.5u w=1.12u l=0.13u
X2260 sg13cmos5l_buf_16_15.A a_4052_12934# VGND.t454 VGND.t610 sg13_lv_nmos ad=0.1406p pd=1.12u as=0.1406p ps=1.12u w=0.74u l=0.13u
X2261 VGND.t61 sg13cmos5l_buf_16_25.A a_6766_8434# VGND.t279 sg13_lv_nmos ad=0.1406p pd=1.12u as=0.1406p ps=1.12u w=0.74u l=0.13u
X2262 sg13cmos5l_buf_16_39.A a_8494_3144# VGND.t302 VGND.t40 sg13_lv_nmos ad=0.1406p pd=1.12u as=0.1406p ps=1.12u w=0.74u l=0.13u
X2263 VPWR.t126 VGND.t1400 VPWR.t519 VPWR.t55 sg13_lv_pmos ad=0.19p pd=1.38u as=0 ps=0 w=1u l=1u
X2264 sg13cmos5l_buf_16_1.X a_10318_5410# VGND.t86 VGND.t87 sg13_lv_nmos ad=0.1406p pd=1.12u as=0.1406p ps=1.12u w=0.74u l=0.13u
X2265 VGND.t139 sg13cmos5l_buf_16_19.A a_5204_11422# VGND.t2 sg13_lv_nmos ad=0.2516p pd=2.16u as=0.1406p ps=1.12u w=0.74u l=0.13u
X2266 a_3668_4620# sg13cmos5l_buf_16_11.A VGND.t351 VGND.t1561 sg13_lv_nmos ad=0.1406p pd=1.12u as=0.1406p ps=1.12u w=0.74u l=0.13u
X2267 sg13cmos5l_buf_16_35.A a_6766_8434# VPWR.t661 VPWR.t5 sg13_lv_pmos ad=0.2128p pd=1.5u as=0.2128p ps=1.5u w=1.12u l=0.13u
X2268 VPWR.t366 VGND.t1237 VPWR.t364 VPWR.t67 sg13_lv_pmos ad=0.19p pd=1.38u as=0 ps=0 w=1u l=1u
X2269 sg13cmos5l_xor2_1_0.B a_6094_3144# VGND.t125 VGND.t40 sg13_lv_nmos ad=0.1406p pd=1.12u as=0.1406p ps=1.12u w=0.74u l=0.13u
X2270 VGND.t1162 VPWR.t93 VGND.t214 VGND.t1161 sg13_lv_nmos ad=0.1428p pd=1.52u as=0 ps=0 w=0.42u l=1u
X2271 VPWR.t1537 a_3694_3898# sg13cmos5l_buf_16_10.A VPWR.t64 sg13_lv_pmos ad=0.2128p pd=1.5u as=0.2128p ps=1.5u w=1.12u l=0.13u
X2272 sg13cmos5l_buf_16_27.X a_6548_13692# VGND.t1 VGND.t1489 sg13_lv_nmos ad=0.1406p pd=1.12u as=0.1406p ps=1.12u w=0.74u l=0.13u
X2273 VGND.t76 a_10318_5410# sg13cmos5l_buf_16_1.X VGND.t83 sg13_lv_nmos ad=0.1406p pd=1.12u as=0.1406p ps=1.12u w=0.74u l=0.13u
X2274 VPWR.t1087 a_4052_12934# sg13cmos5l_buf_16_15.A VPWR.t79 sg13_lv_pmos ad=0.2128p pd=1.5u as=0.2128p ps=1.5u w=1.12u l=0.13u
X2275 a_3694_3898# sg13cmos5l_buf_16_8.A VGND.t310 VGND.t40 sg13_lv_nmos ad=0.1406p pd=1.12u as=0.1406p ps=1.12u w=0.74u l=0.13u
X2276 VPWR.t659 a_6766_8434# sg13cmos5l_buf_16_35.A VPWR.t5 sg13_lv_pmos ad=0.2128p pd=1.5u as=0.2128p ps=1.5u w=1.12u l=0.13u
X2277 VPWR.t129 VGND.t1010 VPWR.t129 VPWR.t8 sg13_lv_pmos ad=0.34p pd=2.68u as=0 ps=0 w=1u l=1u
X2278 VGND.t139 a_3694_10704# sg13cmos5l_and2_2_6.A VGND.t2 sg13_lv_nmos ad=0.1406p pd=1.12u as=0.1406p ps=1.12u w=0.74u l=0.13u
X2279 VPWR.t1040 VGND.t898 VPWR.t1039 VPWR.t79 sg13_lv_pmos ad=0.34p pd=2.68u as=0 ps=0 w=1u l=1u
X2280 sg13cmos5l_buf_16_15.A a_4052_12934# VGND.t444 VGND.t606 sg13_lv_nmos ad=0.1406p pd=1.12u as=0.1406p ps=1.12u w=0.74u l=0.13u
X2281 VPWR.t646 a_3668_9156# sg13cmos5l_buf_16_13.A VPWR.t5 sg13_lv_pmos ad=0.2128p pd=1.5u as=0.2128p ps=1.5u w=1.12u l=0.13u
X2282 sg13cmos5l_buf_16_1.X a_10318_5410# VPWR.t85 VPWR.t61 sg13_lv_pmos ad=0.2128p pd=1.5u as=0.2128p ps=1.5u w=1.12u l=0.13u
X2283 VGND.t726 VPWR.t1670 VGND.t726 VGND.t2 sg13_lv_nmos ad=79.8f pd=0.8u as=0 ps=0 w=0.42u l=1u
X2284 sg13cmos5l_buf_16_24.A a_6094_10704# VPWR.t1188 VPWR.t2 sg13_lv_pmos ad=0.2128p pd=1.5u as=0.2128p ps=1.5u w=1.12u l=0.13u
X2285 a_3668_3108# sg13cmos5l_buf_16_10.A VPWR.t468 VPWR.t67 sg13_lv_pmos ad=0.2128p pd=1.5u as=0.2128p ps=1.5u w=1.12u l=0.13u
X2286 VGND.t139 a_5204_11422# sg13cmos5l_buf_16_20.A VGND.t2 sg13_lv_nmos ad=0.1406p pd=1.12u as=0.1406p ps=1.12u w=0.74u l=0.13u
X2287 out_xor[2] a_14824_5444# VGND.t637 VGND.t831 sg13_lv_nmos ad=0.2886p pd=2.26u as=0.14875p ps=1.16u w=0.74u l=0.13u
X2288 sg13cmos5l_buf_16_28.A a_7220_5374# VGND.t171 VGND.t332 sg13_lv_nmos ad=0.1406p pd=1.12u as=0.2516p ps=2.16u w=0.74u l=0.13u
X2289 VPWR.t129 sg13cmos5l_buf_1_17.A a_12232_12216# VPWR.t8 sg13_lv_pmos ad=0.2114p pd=1.54u as=0.2856p ps=2.36u w=0.84u l=0.13u
X2290 sg13cmos5l_buf_16_6.X a_5518_6922# VPWR.t913 VPWR.t58 sg13_lv_pmos ad=0.2128p pd=1.5u as=0.2128p ps=1.5u w=1.12u l=0.13u
X2291 VGND.t5 a_9262_7680# sg13cmos5l_buf_16_2.A VGND.t107 sg13_lv_nmos ad=0.1406p pd=1.12u as=0.1406p ps=1.12u w=0.74u l=0.13u
X2292 VGND.t682 sg13cmos5l_and2_2_2.B a_6859_12564# VGND.t1424 sg13_lv_nmos ad=0.1331p pd=1.12u as=0.1216p ps=1.02u w=0.64u l=0.13u
X2293 VGND.t726 VPWR.t26 VGND.t726 VGND.t2 sg13_lv_nmos ad=79.8f pd=0.8u as=0 ps=0 w=0.42u l=1u
X2294 VPWR.t131 VGND.t513 VPWR.t131 VPWR.t8 sg13_lv_pmos ad=0.19p pd=1.38u as=0 ps=0 w=1u l=1u
X2295 a_6766_8434# sg13cmos5l_buf_16_25.A VPWR.t654 VPWR.t5 sg13_lv_pmos ad=0.2128p pd=1.5u as=0.2128p ps=1.5u w=1.12u l=0.13u
X2296 VPWR.t143 a_10292_4620# sg13cmos5l_buf_16_3.X VPWR.t64 sg13_lv_pmos ad=0.2128p pd=1.5u as=0.2128p ps=1.5u w=1.12u l=0.13u
X2297 sg13cmos5l_buf_16_8.A a_3668_4620# VGND.t351 VGND.t829 sg13_lv_nmos ad=0.1406p pd=1.12u as=0.1406p ps=1.12u w=0.74u l=0.13u
X2298 sg13cmos5l_buf_16_13.A a_3668_9156# VPWR.t642 VPWR.t5 sg13_lv_pmos ad=0.2128p pd=1.5u as=0.2128p ps=1.5u w=1.12u l=0.13u
X2299 sg13cmos5l_buf_16_5.X a_5108_838# VPWR.t56 VPWR.t55 sg13_lv_pmos ad=0.2128p pd=1.5u as=0.2128p ps=1.5u w=1.12u l=0.13u
X2300 VPWR.t85 a_10318_5410# sg13cmos5l_buf_16_1.X VPWR.t61 sg13_lv_pmos ad=0.2128p pd=1.5u as=0.2128p ps=1.5u w=1.12u l=0.13u
X2301 sg13cmos5l_buf_16_27.X a_6548_13692# VGND.t1 VGND.t1485 sg13_lv_nmos ad=0.1406p pd=1.12u as=0.1406p ps=1.12u w=0.74u l=0.13u
X2302 VGND.t260 VPWR.t1656 VGND.t260 VGND.t1057 sg13_lv_nmos ad=79.8f pd=0.8u as=0 ps=0 w=0.42u l=1u
X2303 VPWR.t56 sg13cmos5l_buf_16_30.A a_5710_1632# VPWR.t55 sg13_lv_pmos ad=0.2128p pd=1.5u as=0.2128p ps=1.5u w=1.12u l=0.13u
X2304 sg13cmos5l_xor2_1_0.B a_6094_3144# VGND.t125 VGND.t40 sg13_lv_nmos ad=0.1406p pd=1.12u as=0.1406p ps=1.12u w=0.74u l=0.13u
X2305 VPWR.t244 VGND.t797 VPWR.t243 VPWR.t61 sg13_lv_pmos ad=0.19p pd=1.38u as=0 ps=0 w=1u l=1u
X2306 a_4436_9910# sg13cmos5l_buf_16_20.A VGND.t66 VGND.t715 sg13_lv_nmos ad=0.1406p pd=1.12u as=0.1406p ps=1.12u w=0.74u l=0.13u
X2307 VPWR.t1060 VGND.t1422 VPWR.t226 VPWR.t55 sg13_lv_pmos ad=0.34p pd=2.68u as=0 ps=0 w=1u l=1u
X2308 VPWR.t911 a_5518_6922# sg13cmos5l_buf_16_6.X VPWR.t58 sg13_lv_pmos ad=0.2128p pd=1.5u as=0.2128p ps=1.5u w=1.12u l=0.13u
X2309 sg13cmos5l_buf_16_2.A a_9262_7680# VGND.t103 VGND.t104 sg13_lv_nmos ad=0.1406p pd=1.12u as=0.1406p ps=1.12u w=0.74u l=0.13u
X2310 VPWR.t0 VGND.t601 VPWR.t0 VPWR.t0 sg13_lv_pmos ad=0.19p pd=1.38u as=0 ps=0 w=1u l=1u
X2311 VGND.t134 VPWR.t1672 VGND.t134 VGND.t2 sg13_lv_nmos ad=0.1428p pd=1.52u as=0 ps=0 w=0.42u l=1u
X2312 sg13cmos5l_buf_16_24.A a_6094_10704# VPWR.t1184 VPWR.t2 sg13_lv_pmos ad=0.2128p pd=1.5u as=0.2128p ps=1.5u w=1.12u l=0.13u
X2313 VPWR.t640 a_3668_9156# sg13cmos5l_buf_16_13.A VPWR.t5 sg13_lv_pmos ad=0.2128p pd=1.5u as=0.2128p ps=1.5u w=1.12u l=0.13u
X2314 VPWR.t132 sg13cmos5l_xor2_1_4.X a_13768_9192# VPWR.t5 sg13_lv_pmos ad=0.2114p pd=1.54u as=0.2856p ps=2.36u w=0.84u l=0.13u
X2315 VGND.t7 a_5518_6922# sg13cmos5l_buf_16_6.X VGND.t546 sg13_lv_nmos ad=0.1406p pd=1.12u as=0.1406p ps=1.12u w=0.74u l=0.13u
X2316 VGND.t134 a_5204_11422# sg13cmos5l_buf_16_20.A VGND.t2 sg13_lv_nmos ad=0.1406p pd=1.12u as=0.1406p ps=1.12u w=0.74u l=0.13u
X2317 sg13cmos5l_buf_16_1.X a_10318_5410# VPWR.t85 VPWR.t61 sg13_lv_pmos ad=0.2128p pd=1.5u as=0.2128p ps=1.5u w=1.12u l=0.13u
X2318 a_5710_1632# sg13cmos5l_buf_16_30.A VPWR.t56 VPWR.t55 sg13_lv_pmos ad=0.2128p pd=1.5u as=0.3808p ps=2.92u w=1.12u l=0.13u
X2319 sg13cmos5l_buf_16_6.X a_5518_6922# VPWR.t907 VPWR.t58 sg13_lv_pmos ad=0.2128p pd=1.5u as=0.2128p ps=1.5u w=1.12u l=0.13u
X2320 VPWR.t398 VGND.t5 VPWR.t397 VPWR.t58 sg13_lv_pmos ad=0.34p pd=2.68u as=0 ps=0 w=1u l=1u
X2321 VPWR.t707 a_7220_5374# sg13cmos5l_buf_16_28.A VPWR.t61 sg13_lv_pmos ad=0.2128p pd=1.5u as=0.2128p ps=1.5u w=1.12u l=0.13u
X2322 VGND.t171 VPWR.t64 VGND.t171 VGND.t1222 sg13_lv_nmos ad=79.8f pd=0.8u as=0 ps=0 w=0.42u l=1u
X2323 sg13cmos5l_buf_16_11.A a_4462_5410# VGND.t351 VGND.t427 sg13_lv_nmos ad=0.1406p pd=1.12u as=0.1406p ps=1.12u w=0.74u l=0.13u
X2324 sg13cmos5l_buf_16_6.X a_5518_6922# VGND.t7 VGND.t543 sg13_lv_nmos ad=0.1406p pd=1.12u as=0.1406p ps=1.12u w=0.74u l=0.13u
X2325 VPWR.t108 VGND.t181 VPWR.t64 VPWR.t64 sg13_lv_pmos ad=0.34p pd=2.68u as=0 ps=0 w=1u l=1u
X2326 VGND.t139 a_6094_10704# sg13cmos5l_buf_16_24.A VGND.t2 sg13_lv_nmos ad=0.1406p pd=1.12u as=0.1406p ps=1.12u w=0.74u l=0.13u
X2327 VPWR.t61 VGND.t76 VPWR.t61 VPWR.t61 sg13_lv_pmos ad=0.34p pd=2.68u as=0 ps=0 w=1u l=1u
X2328 VPWR.t143 VGND.t76 VPWR.t64 VPWR.t64 sg13_lv_pmos ad=0.34p pd=2.68u as=0 ps=0 w=1u l=1u
X2329 sg13cmos5l_buf_16_18.A a_4174_13728# VGND.t891 VGND.t1447 sg13_lv_nmos ad=0.1406p pd=1.12u as=0.1406p ps=1.12u w=0.74u l=0.13u
X2330 VGND.t351 a_4462_5410# sg13cmos5l_buf_16_11.A VGND.t424 sg13_lv_nmos ad=0.1406p pd=1.12u as=0.1406p ps=1.12u w=0.74u l=0.13u
X2331 VGND.t1050 VPWR.t1663 VGND.t1050 VGND.t1052 sg13_lv_nmos ad=0.1428p pd=1.52u as=0 ps=0 w=0.42u l=1u
X2332 sg13cmos5l_buf_16_7.A a_3668_3108# VGND.t310 VGND.t40 sg13_lv_nmos ad=0.1406p pd=1.12u as=0.1406p ps=1.12u w=0.74u l=0.13u
X2333 VPWR.t0 VGND.t597 VPWR.t0 VPWR.t0 sg13_lv_pmos ad=0.34p pd=2.68u as=0 ps=0 w=1u l=1u
X2334 VPWR.t1192 a_6094_10704# sg13cmos5l_buf_16_24.A VPWR.t2 sg13_lv_pmos ad=0.2128p pd=1.5u as=0.2128p ps=1.5u w=1.12u l=0.13u
X2335 VPWR.t354 VGND.t42 VPWR.t408 VPWR.t64 sg13_lv_pmos ad=0.34p pd=2.68u as=0 ps=0 w=1u l=1u
X2336 VGND.t5 VPWR.t1649 VGND.t5 VGND.t1102 sg13_lv_nmos ad=0.1428p pd=1.52u as=0 ps=0 w=0.42u l=1u
X2337 a_10318_3898# sg13cmos5l_buf_16_2.A VGND.t302 VGND.t40 sg13_lv_nmos ad=0.1406p pd=1.12u as=0.1406p ps=1.12u w=0.74u l=0.13u
X2338 VPWR.t250 VGND.t1377 VPWR.t986 VPWR.t55 sg13_lv_pmos ad=0.34p pd=2.68u as=0 ps=0 w=1u l=1u
X2339 VGND.t1050 VPWR.t1659 VGND.t1050 VGND.t1051 sg13_lv_nmos ad=79.8f pd=0.8u as=0 ps=0 w=0.42u l=1u
X2340 VGND.t1398 VPWR.t126 VGND.t1400 VGND.t1399 sg13_lv_nmos ad=79.8f pd=0.8u as=0 ps=0 w=0.42u l=1u
X2341 VGND.t181 sg13cmos5l_buf_16_2.X a_10292_4620# VGND.t180 sg13_lv_nmos ad=0.1406p pd=1.12u as=0.1406p ps=1.12u w=0.74u l=0.13u
X2342 a_11898_13691# sg13cmos5l_buf_16_27.X VGND.t204 VGND.t639 sg13_lv_nmos ad=0.17462p pd=1.185u as=0.15245p ps=1.17u w=0.55u l=0.13u
X2343 VPWR.t561 sg13cmos5l_buf_16_7.A a_3694_2386# VPWR.t67 sg13_lv_pmos ad=0.2128p pd=1.5u as=0.2128p ps=1.5u w=1.12u l=0.13u
X2344 VGND.t35 VPWR.t58 VGND.t35 VGND.t1137 sg13_lv_nmos ad=0.1428p pd=1.52u as=0 ps=0 w=0.42u l=1u
X2345 a_7796_12934# sg13cmos5l_buf_16_37.A VPWR.t566 VPWR.t79 sg13_lv_pmos ad=0.2128p pd=1.5u as=0.2128p ps=1.5u w=1.12u l=0.13u
X2346 sg13cmos5l_buf_16_11.A a_4462_5410# VGND.t351 VGND.t421 sg13_lv_nmos ad=0.1406p pd=1.12u as=0.1406p ps=1.12u w=0.74u l=0.13u
X2347 VGND.t837 a_5710_1632# sg13cmos5l_buf_16_5.A VGND.t857 sg13_lv_nmos ad=0.1406p pd=1.12u as=0.1406p ps=1.12u w=0.74u l=0.13u
X2348 VPWR.t126 VGND.t1390 VPWR.t126 VPWR.t55 sg13_lv_pmos ad=0.19p pd=1.38u as=0 ps=0 w=1u l=1u
X2349 VPWR.t566 sg13cmos5l_buf_16_23.X a_8948_13692# VPWR.t79 sg13_lv_pmos ad=0.2128p pd=1.5u as=0.2128p ps=1.5u w=1.12u l=0.13u
X2350 VGND.t171 a_6094_4656# sg13cmos5l_buf_16_31.X VGND.t354 sg13_lv_nmos ad=0.1406p pd=1.12u as=0.1406p ps=1.12u w=0.74u l=0.13u
X2351 VGND.t590 a_7796_12934# sg13cmos5l_buf_16_37.X VGND.t691 sg13_lv_nmos ad=0.1406p pd=1.12u as=0.1406p ps=1.12u w=0.74u l=0.13u
X2352 VGND.t39 sg13cmos5l_xor2_1_4.X a_13768_9192# VGND.t282 sg13_lv_nmos ad=0.14875p pd=1.16u as=0.187p ps=1.78u w=0.55u l=0.13u
X2353 sg13cmos5l_buf_16_37.A a_8948_13692# VPWR.t566 VPWR.t79 sg13_lv_pmos ad=0.2128p pd=1.5u as=0.2128p ps=1.5u w=1.12u l=0.13u
X2354 VGND.t1292 VPWR.t519 VGND.t1292 VGND.t1329 sg13_lv_nmos ad=0.1428p pd=1.52u as=0 ps=0 w=0.42u l=1u
X2355 VPWR.t798 a_4462_5410# sg13cmos5l_buf_16_11.A VPWR.t61 sg13_lv_pmos ad=0.2128p pd=1.5u as=0.2128p ps=1.5u w=1.12u l=0.13u
X2356 sg13cmos5l_buf_16_18.A a_4174_13728# VGND.t870 VGND.t1443 sg13_lv_nmos ad=0.1406p pd=1.12u as=0.1406p ps=1.12u w=0.74u l=0.13u
X2357 a_6161_12574# sg13cmos5l_buf_16_24.X a_6129_12216# VPWR.t8 sg13_lv_pmos ad=0.34p pd=2.68u as=0.1225p ps=1.245u w=1u l=0.13u
X2358 VGND.t1237 VPWR.t1617 VGND.t1237 VGND.t40 sg13_lv_nmos ad=0.1428p pd=1.52u as=0 ps=0 w=0.42u l=1u
X2359 VPWR.t81 sg13cmos5l_buf_1_22.X a_14824_13004# VPWR.t79 sg13_lv_pmos ad=0.2114p pd=1.54u as=0.2856p ps=2.36u w=0.84u l=0.13u
X2360 VGND.t198 a_3694_2386# sg13cmos5l_buf_16_7.X VGND.t1566 sg13_lv_nmos ad=0.1406p pd=1.12u as=0.1406p ps=1.12u w=0.74u l=0.13u
X2361 sg13cmos5l_buf_16_0.A a_6094_3898# VPWR.t740 VPWR.t64 sg13_lv_pmos ad=0.2128p pd=1.5u as=0.2128p ps=1.5u w=1.12u l=0.13u
X2362 sg13cmos5l_buf_16_2.A a_9262_7680# VPWR.t335 VPWR.t58 sg13_lv_pmos ad=0.2128p pd=1.5u as=0.2128p ps=1.5u w=1.12u l=0.13u
X2363 VPWR.t440 VGND.t1061 VPWR.t440 VPWR.t5 sg13_lv_pmos ad=0.34p pd=2.68u as=0 ps=0 w=1u l=1u
X2364 VGND.t1274 VPWR.t55 VGND.t1274 VGND.t1273 sg13_lv_nmos ad=0.1428p pd=1.52u as=0 ps=0 w=0.42u l=1u
X2365 a_13667_12956# sg13cmos5l_and2_2_3.X a_13897_13012# VGND.t621 sg13_lv_nmos ad=0.2176p pd=1.96u as=0.1216p ps=1.02u w=0.64u l=0.13u
X2366 sg13cmos5l_buf_16_15.X a_3668_12180# VGND.t444 VGND.t450 sg13_lv_nmos ad=0.1406p pd=1.12u as=0.1406p ps=1.12u w=0.74u l=0.13u
X2367 a_5684_6132# sg13cmos5l_buf_16_28.A VGND.t7 VGND.t792 sg13_lv_nmos ad=0.1406p pd=1.12u as=0.1406p ps=1.12u w=0.74u l=0.13u
X2368 a_3694_14482# sg13cmos5l_buf_16_15.X VGND.t870 VGND.t872 sg13_lv_nmos ad=0.1406p pd=1.12u as=0.1406p ps=1.12u w=0.74u l=0.13u
X2369 sg13cmos5l_buf_16_33.A a_3694_14482# VGND.t870 VGND.t885 sg13_lv_nmos ad=0.1406p pd=1.12u as=0.1406p ps=1.12u w=0.74u l=0.13u
X2370 VPWR.t28 VGND.t1010 VPWR.t28 VPWR.t2 sg13_lv_pmos ad=0.19p pd=1.38u as=0 ps=0 w=1u l=1u
X2371 VGND.t41 VPWR.t108 VGND.t41 VGND.t40 sg13_lv_nmos ad=79.8f pd=0.8u as=0 ps=0 w=0.42u l=1u
X2372 a_10318_3898# sg13cmos5l_buf_16_2.A VGND.t302 VGND.t40 sg13_lv_nmos ad=0.1406p pd=1.12u as=0.2516p ps=2.16u w=0.74u l=0.13u
X2373 sg13cmos5l_buf_16_11.A a_4462_5410# VPWR.t794 VPWR.t61 sg13_lv_pmos ad=0.2128p pd=1.5u as=0.2128p ps=1.5u w=1.12u l=0.13u
X2374 VGND.t5 VPWR.t91 VGND.t5 VGND.t1133 sg13_lv_nmos ad=0.1428p pd=1.52u as=0 ps=0 w=0.42u l=1u
X2375 sg13cmos5l_buf_16_37.X a_7796_12934# VPWR.t1113 VPWR.t79 sg13_lv_pmos ad=0.2128p pd=1.5u as=0.2128p ps=1.5u w=1.12u l=0.13u
X2376 VPWR.t757 a_6094_3144# sg13cmos5l_xor2_1_0.B VPWR.t67 sg13_lv_pmos ad=0.2128p pd=1.5u as=0.2128p ps=1.5u w=1.12u l=0.13u
X2377 VGND.t5 a_6766_8434# sg13cmos5l_buf_16_35.A VGND.t296 sg13_lv_nmos ad=0.1406p pd=1.12u as=0.1406p ps=1.12u w=0.74u l=0.13u
X2378 VPWR.t566 a_8948_13692# sg13cmos5l_buf_16_37.A VPWR.t79 sg13_lv_pmos ad=0.2128p pd=1.5u as=0.2128p ps=1.5u w=1.12u l=0.13u
X2379 VPWR.t21 VGND.t590 VPWR.t21 VPWR.t8 sg13_lv_pmos ad=0.34p pd=2.68u as=0 ps=0 w=1u l=1u
X2380 a_3694_2386# sg13cmos5l_buf_16_7.A VGND.t198 VGND.t199 sg13_lv_nmos ad=0.1406p pd=1.12u as=0.1406p ps=1.12u w=0.74u l=0.13u
X2381 VGND.t1349 VPWR.t156 VGND.t1351 VGND.t1350 sg13_lv_nmos ad=79.8f pd=0.8u as=0 ps=0 w=0.42u l=1u
X2382 VPWR.t739 enable a_6094_3898# VPWR.t64 sg13_lv_pmos ad=0.2128p pd=1.5u as=0.2128p ps=1.5u w=1.12u l=0.13u
X2383 VPWR.t1266 sg13cmos5l_xor2_1_0.B a_3875_5396# VPWR.t61 sg13_lv_pmos ad=0.2856p pd=2.36u as=0.1596p ps=1.22u w=0.84u l=0.13u
X2384 VGND.t590 a_7796_12934# sg13cmos5l_buf_16_37.X VGND.t687 sg13_lv_nmos ad=0.1406p pd=1.12u as=0.1406p ps=1.12u w=0.74u l=0.13u
X2385 VGND.t260 VPWR.t1656 VGND.t260 VGND.t1056 sg13_lv_nmos ad=0.1428p pd=1.52u as=0 ps=0 w=0.42u l=1u
X2386 VPWR.t566 a_10292_12934# sg13cmos5l_buf_16_23.X VPWR.t79 sg13_lv_pmos ad=0.2128p pd=1.5u as=0.2128p ps=1.5u w=1.12u l=0.13u
X2387 VGND.t31 sg13cmos5l_buf_16_39.A a_6164_2350# VGND.t30 sg13_lv_nmos ad=0.2516p pd=2.16u as=0.1406p ps=1.12u w=0.74u l=0.13u
X2388 VGND.t837 a_5710_1632# sg13cmos5l_buf_16_5.A VGND.t853 sg13_lv_nmos ad=0.1406p pd=1.12u as=0.1406p ps=1.12u w=0.74u l=0.13u
X2389 VPWR.t415 VGND.t42 VPWR.t413 VPWR.t67 sg13_lv_pmos ad=0.19p pd=1.38u as=0 ps=0 w=1u l=1u
X2390 sg13cmos5l_buf_16_18.A a_4174_13728# VGND.t870 VGND.t1439 sg13_lv_nmos ad=0.1406p pd=1.12u as=0.1406p ps=1.12u w=0.74u l=0.13u
X2391 sg13cmos5l_buf_16_37.A a_8948_13692# VPWR.t1113 VPWR.t79 sg13_lv_pmos ad=0.2128p pd=1.5u as=0.2128p ps=1.5u w=1.12u l=0.13u
X2392 sg13cmos5l_buf_16_30.A a_6164_2350# VPWR.t1555 VPWR.t67 sg13_lv_pmos ad=0.2128p pd=1.5u as=0.2128p ps=1.5u w=1.12u l=0.13u
X2393 VGND.t7 a_5684_6132# sg13cmos5l_buf_16_28.X VGND.t235 sg13_lv_nmos ad=0.1406p pd=1.12u as=0.1406p ps=1.12u w=0.74u l=0.13u
X2394 VPWR.t91 VGND.t214 VPWR.t91 VPWR.t58 sg13_lv_pmos ad=0.34p pd=2.68u as=0 ps=0 w=1u l=1u
X2395 VGND.t1010 VPWR.t3 VGND.t1010 VGND.t2 sg13_lv_nmos ad=0.1428p pd=1.52u as=0 ps=0 w=0.42u l=1u
X2396 VGND.t218 VPWR.t1637 VGND.t218 VGND.t1154 sg13_lv_nmos ad=0.1428p pd=1.52u as=0 ps=0 w=0.42u l=1u
X2397 VGND.t134 VPWR.t1673 VGND.t134 VGND.t2 sg13_lv_nmos ad=79.8f pd=0.8u as=0 ps=0 w=0.42u l=1u
X2398 a_6094_3144# sg13cmos5l_buf_16_5.X VPWR.t477 VPWR.t67 sg13_lv_pmos ad=0.2128p pd=1.5u as=0.2128p ps=1.5u w=1.12u l=0.13u
X2399 VGND.t682 VPWR.t1679 VGND.t682 VGND.t968 sg13_lv_nmos ad=0.1428p pd=1.52u as=0 ps=0 w=0.42u l=1u
X2400 VPWR.t110 VGND.t1208 VPWR.t110 VPWR.t64 sg13_lv_pmos ad=0.34p pd=2.68u as=0 ps=0 w=1u l=1u
X2401 a_3694_10704# sg13cmos5l_buf_16_34.X VPWR.t552 VPWR.t2 sg13_lv_pmos ad=0.2128p pd=1.5u as=0.3808p ps=2.92u w=1.12u l=0.13u
X2402 VPWR.t594 VGND.t1141 VPWR.t593 VPWR.t58 sg13_lv_pmos ad=0.34p pd=2.68u as=0 ps=0 w=1u l=1u
X2403 VGND.t444 VPWR.t1687 VGND.t948 VGND.t949 sg13_lv_nmos ad=0.1428p pd=1.52u as=0 ps=0 w=0.42u l=1u
X2404 VPWR.t1573 sg13cmos5l_buf_16_11.A a_3668_4620# VPWR.t64 sg13_lv_pmos ad=0.2128p pd=1.5u as=0.2128p ps=1.5u w=1.12u l=0.13u
X2405 sg13cmos5l_buf_16_4.X a_9524_6886# VPWR.t335 VPWR.t58 sg13_lv_pmos ad=0.2128p pd=1.5u as=0.2128p ps=1.5u w=1.12u l=0.13u
X2406 VGND.t202 VPWR.t0 VGND.t601 VGND.t915 sg13_lv_nmos ad=0.1428p pd=1.52u as=0 ps=0 w=0.42u l=1u
X2407 VPWR.t1553 a_6164_2350# sg13cmos5l_buf_16_30.A VPWR.t67 sg13_lv_pmos ad=0.2128p pd=1.5u as=0.2128p ps=1.5u w=1.12u l=0.13u
X2408 VGND.t891 a_3694_14482# sg13cmos5l_buf_16_33.A VGND.t893 sg13_lv_nmos ad=0.2516p pd=2.16u as=0.1406p ps=1.12u w=0.74u l=0.13u
X2409 VPWR.t1220 a_4436_9910# sg13cmos5l_buf_16_14.A VPWR.t2 sg13_lv_pmos ad=0.2128p pd=1.5u as=0.2128p ps=1.5u w=1.12u l=0.13u
X2410 a_7220_5374# sg13cmos5l_buf_16_38.A VGND.t171 VGND.t170 sg13_lv_nmos ad=0.1406p pd=1.12u as=0.1406p ps=1.12u w=0.74u l=0.13u
X2411 sg13cmos5l_buf_16_28.X a_5684_6132# VPWR.t588 VPWR.t61 sg13_lv_pmos ad=0.2128p pd=1.5u as=0.2128p ps=1.5u w=1.12u l=0.13u
X2412 VGND.t590 VPWR.t16 VGND.t590 VGND.t974 sg13_lv_nmos ad=0.1428p pd=1.52u as=0 ps=0 w=0.42u l=1u
X2413 VGND.t1286 VPWR.t216 VGND.t1286 VGND.t1288 sg13_lv_nmos ad=0.1428p pd=1.52u as=0 ps=0 w=0.42u l=1u
X2414 VPWR.t28 VGND.t726 VPWR.t28 VPWR.t2 sg13_lv_pmos ad=0.34p pd=2.68u as=0 ps=0 w=1u l=1u
X2415 VPWR.t357 VGND.t1237 VPWR.t356 VPWR.t64 sg13_lv_pmos ad=0.34p pd=2.68u as=0 ps=0 w=1u l=1u
X2416 VPWR.t335 a_9524_6886# sg13cmos5l_buf_16_4.X VPWR.t58 sg13_lv_pmos ad=0.2128p pd=1.5u as=0.2128p ps=1.5u w=1.12u l=0.13u
X2417 VGND.t18 sg13cmos5l_buf_16_34.A a_3694_7680# VGND.t21 sg13_lv_nmos ad=0.1406p pd=1.12u as=0.1406p ps=1.12u w=0.74u l=0.13u
X2418 VPWR.t250 VGND.t1382 VPWR.t250 VPWR.t55 sg13_lv_pmos ad=0.34p pd=2.68u as=0 ps=0 w=1u l=1u
X2419 VPWR.t68 VGND.t1237 VPWR.t367 VPWR.t67 sg13_lv_pmos ad=0.34p pd=2.68u as=0 ps=0 w=1u l=1u
X2420 a_5108_838# sg13cmos5l_buf_16_5.A VPWR.t56 VPWR.t55 sg13_lv_pmos ad=0.2128p pd=1.5u as=0.2128p ps=1.5u w=1.12u l=0.13u
X2421 VGND.t134 sg13cmos5l_buf_16_34.X a_3694_10704# VGND.t2 sg13_lv_nmos ad=0.1406p pd=1.12u as=0.1406p ps=1.12u w=0.74u l=0.13u
X2422 VGND.t171 a_7220_5374# sg13cmos5l_buf_16_28.A VGND.t345 sg13_lv_nmos ad=0.1406p pd=1.12u as=0.1406p ps=1.12u w=0.74u l=0.13u
X2423 VGND.t214 sg13cmos5l_buf_16_4.A a_9524_6886# VGND.t213 sg13_lv_nmos ad=0.1406p pd=1.12u as=0.1406p ps=1.12u w=0.74u l=0.13u
X2424 VPWR.t126 VGND.t1395 VPWR.t126 VPWR.t55 sg13_lv_pmos ad=0.19p pd=1.38u as=0 ps=0 w=1u l=1u
X2425 VPWR.t110 VGND.t41 VPWR.t108 VPWR.t64 sg13_lv_pmos ad=0.19p pd=1.38u as=0 ps=0 w=1u l=1u
X2426 sg13cmos5l_buf_16_2.A a_9262_7680# VPWR.t335 VPWR.t58 sg13_lv_pmos ad=0.2128p pd=1.5u as=0.2128p ps=1.5u w=1.12u l=0.13u
X2427 sg13cmos5l_buf_16_27.X a_6548_13692# VPWR.t1414 VPWR.t79 sg13_lv_pmos ad=0.2128p pd=1.5u as=0.2128p ps=1.5u w=1.12u l=0.13u
X2428 VGND.t676 a_10292_12934# sg13cmos5l_buf_16_23.X VGND.t678 sg13_lv_nmos ad=0.1406p pd=1.12u as=0.1406p ps=1.12u w=0.74u l=0.13u
X2429 a_6094_4656# sg13cmos5l_buf_16_7.X VGND.t351 VGND.t433 sg13_lv_nmos ad=0.1406p pd=1.12u as=0.1406p ps=1.12u w=0.74u l=0.13u
X2430 VGND.t157 a_6836_9156# sg13cmos5l_buf_16_25.A VGND.t165 sg13_lv_nmos ad=0.1406p pd=1.12u as=0.1406p ps=1.12u w=0.74u l=0.13u
X2431 a_3694_7680# sg13cmos5l_buf_16_34.A VGND.t18 VGND.t17 sg13_lv_nmos ad=0.1406p pd=1.12u as=0.2516p ps=2.16u w=0.74u l=0.13u
X2432 VGND.t76 VPWR.t61 VGND.t76 VGND.t1205 sg13_lv_nmos ad=0.1428p pd=1.52u as=0 ps=0 w=0.42u l=1u
X2433 VPWR.t1210 a_3694_10704# sg13cmos5l_and2_2_6.A VPWR.t2 sg13_lv_pmos ad=0.2128p pd=1.5u as=0.2128p ps=1.5u w=1.12u l=0.13u
X2434 VGND.t870 a_3694_14482# sg13cmos5l_buf_16_33.A VGND.t888 sg13_lv_nmos ad=0.1406p pd=1.12u as=0.1406p ps=1.12u w=0.74u l=0.13u
X2435 sg13cmos5l_buf_16_22.X a_10318_8434# VGND.t5 VGND.t573 sg13_lv_nmos ad=0.1406p pd=1.12u as=0.1406p ps=1.12u w=0.74u l=0.13u
X2436 a_8494_3144# sg13cmos5l_buf_16_0.A VGND.t93 VGND.t40 sg13_lv_nmos ad=0.1406p pd=1.12u as=0.1406p ps=1.12u w=0.74u l=0.13u
X2437 sg13cmos5l_buf_16_24.X a_6862_9946# VGND.t157 VGND.t162 sg13_lv_nmos ad=0.1406p pd=1.12u as=0.1406p ps=1.12u w=0.74u l=0.13u
X2438 VGND.t5 a_6766_8434# sg13cmos5l_buf_16_35.A VGND.t292 sg13_lv_nmos ad=0.1406p pd=1.12u as=0.1406p ps=1.12u w=0.74u l=0.13u
X2439 VPWR.t56 a_5108_838# sg13cmos5l_buf_16_5.X VPWR.t55 sg13_lv_pmos ad=0.2128p pd=1.5u as=0.2128p ps=1.5u w=1.12u l=0.13u
X2440 VPWR.t1424 enable a_6094_3898# VPWR.t64 sg13_lv_pmos ad=0.2128p pd=1.5u as=0.2128p ps=1.5u w=1.12u l=0.13u
X2441 a_9524_6886# sg13cmos5l_buf_16_4.A VGND.t210 VGND.t209 sg13_lv_nmos ad=0.1406p pd=1.12u as=0.1406p ps=1.12u w=0.74u l=0.13u
X2442 VPWR.t335 a_9262_7680# sg13cmos5l_buf_16_2.A VPWR.t58 sg13_lv_pmos ad=0.2128p pd=1.5u as=0.2128p ps=1.5u w=1.12u l=0.13u
X2443 VPWR.t6 VGND.t1061 VPWR.t440 VPWR.t5 sg13_lv_pmos ad=0.34p pd=2.68u as=0 ps=0 w=1u l=1u
X2444 sg13cmos5l_buf_16_23.X a_10292_12934# VPWR.t566 VPWR.t79 sg13_lv_pmos ad=0.2128p pd=1.5u as=0.2128p ps=1.5u w=1.12u l=0.13u
X2445 a_10292_12934# sg13cmos5l_buf_1_17.A VPWR.t566 VPWR.t79 sg13_lv_pmos ad=0.2128p pd=1.5u as=0.2128p ps=1.5u w=1.12u l=0.13u
X2446 sg13cmos5l_buf_16_5.X a_5108_838# VGND.t845 VGND.t1452 sg13_lv_nmos ad=0.1406p pd=1.12u as=0.2516p ps=2.16u w=0.74u l=0.13u
X2447 VPWR.t61 sg13cmos5l_buf_16_38.A a_7220_5374# VPWR.t61 sg13_lv_pmos ad=0.2128p pd=1.5u as=0.2128p ps=1.5u w=1.12u l=0.13u
X2448 VPWR.t826 a_3668_12180# sg13cmos5l_buf_16_15.X VPWR.t8 sg13_lv_pmos ad=0.2128p pd=1.5u as=0.2128p ps=1.5u w=1.12u l=0.13u
X2449 VGND.t157 sg13cmos5l_buf_16_24.A a_6862_9946# VGND.t159 sg13_lv_nmos ad=0.1406p pd=1.12u as=0.1406p ps=1.12u w=0.74u l=0.13u
X2450 sg13cmos5l_buf_16_27.X a_6548_13692# VPWR.t1410 VPWR.t79 sg13_lv_pmos ad=0.2128p pd=1.5u as=0.2128p ps=1.5u w=1.12u l=0.13u
X2451 VPWR.t625 sg13cmos5l_buf_16_19.A a_5204_11422# VPWR.t8 sg13_lv_pmos ad=0.3808p pd=2.92u as=0.2128p ps=1.5u w=1.12u l=0.13u
X2452 sg13cmos5l_buf_16_24.X a_6862_9946# VPWR.t842 VPWR.t2 sg13_lv_pmos ad=0.2128p pd=1.5u as=0.2128p ps=1.5u w=1.12u l=0.13u
X2453 VGND.t181 a_10318_5410# sg13cmos5l_buf_16_1.X VGND.t180 sg13_lv_nmos ad=0.1406p pd=1.12u as=0.1406p ps=1.12u w=0.74u l=0.13u
X2454 VPWR.t419 sg13cmos5l_buf_16_13.A a_3694_8434# VPWR.t5 sg13_lv_pmos ad=0.2128p pd=1.5u as=0.2128p ps=1.5u w=1.12u l=0.13u
X2455 VPWR.t310 sg13cmos5l_buf_16_14.A a_3668_9156# VPWR.t5 sg13_lv_pmos ad=0.3808p pd=2.92u as=0.2128p ps=1.5u w=1.12u l=0.13u
X2456 VPWR.t63 VGND.t1407 VPWR.t63 VPWR.t55 sg13_lv_pmos ad=0.34p pd=2.68u as=0 ps=0 w=1u l=1u
X2457 sg13cmos5l_buf_16_28.A a_7220_5374# VPWR.t719 VPWR.t61 sg13_lv_pmos ad=0.2128p pd=1.5u as=0.2128p ps=1.5u w=1.12u l=0.13u
X2458 a_4892_6168# sg13cmos5l_buf_16_31.X VPWR.t682 VPWR.t61 sg13_lv_pmos ad=0.2128p pd=1.5u as=0.2128p ps=1.5u w=1.12u l=0.13u
X2459 VGND.t1274 VPWR.t1609 VGND.t1274 VGND.t1279 sg13_lv_nmos ad=79.8f pd=0.8u as=0 ps=0 w=0.42u l=1u
X2460 a_5204_11422# sg13cmos5l_buf_16_19.A VGND.t139 VGND.t2 sg13_lv_nmos ad=0.1406p pd=1.12u as=0.1406p ps=1.12u w=0.74u l=0.13u
X2461 a_10318_8434# sg13cmos5l_buf_16_1.X VGND.t5 VGND.t1520 sg13_lv_nmos ad=0.1406p pd=1.12u as=0.1406p ps=1.12u w=0.74u l=0.13u
X2462 a_8538_2578# sg13cmos5l_xor2_1_0.B VGND.t31 VGND.t806 sg13_lv_nmos ad=0.17462p pd=1.185u as=0.15245p ps=1.17u w=0.55u l=0.13u
X2463 sg13cmos5l_buf_16_28.X a_5684_6132# VPWR.t584 VPWR.t61 sg13_lv_pmos ad=0.2128p pd=1.5u as=0.2128p ps=1.5u w=1.12u l=0.13u
X2464 VGND.t122 a_3694_3898# sg13cmos5l_buf_16_10.A VGND.t40 sg13_lv_nmos ad=0.1406p pd=1.12u as=0.1406p ps=1.12u w=0.74u l=0.13u
X2465 VPWR.t822 a_3668_12180# sg13cmos5l_buf_16_15.X VPWR.t8 sg13_lv_pmos ad=0.2128p pd=1.5u as=0.2128p ps=1.5u w=1.12u l=0.13u
X2466 VPWR.t81 VGND.t513 VPWR.t81 VPWR.t79 sg13_lv_pmos ad=0.19p pd=1.38u as=0 ps=0 w=1u l=1u
X2467 a_3668_9156# sg13cmos5l_buf_16_14.A VPWR.t306 VPWR.t5 sg13_lv_pmos ad=0.2128p pd=1.5u as=0.2128p ps=1.5u w=1.12u l=0.13u
X2468 sg13cmos5l_buf_16_35.A a_6766_8434# VPWR.t667 VPWR.t5 sg13_lv_pmos ad=0.2128p pd=1.5u as=0.2128p ps=1.5u w=1.12u l=0.13u
X2469 VPWR.t487 a_5204_11422# sg13cmos5l_buf_16_20.A VPWR.t8 sg13_lv_pmos ad=0.2128p pd=1.5u as=0.2128p ps=1.5u w=1.12u l=0.13u
X2470 sg13cmos5l_buf_16_24.X a_6862_9946# VPWR.t838 VPWR.t2 sg13_lv_pmos ad=0.2128p pd=1.5u as=0.2128p ps=1.5u w=1.12u l=0.13u
X2471 sg13cmos5l_buf_16_38.A a_8110_6168# VGND.t7 VGND.t774 sg13_lv_nmos ad=0.1406p pd=1.12u as=0.1406p ps=1.12u w=0.74u l=0.13u
X2472 sg13cmos5l_and2_2_6.A a_3694_10704# VGND.t134 VGND.t2 sg13_lv_nmos ad=0.1406p pd=1.12u as=0.1406p ps=1.12u w=0.74u l=0.13u
X2473 VPWR.t566 sg13cmos5l_buf_16_27.X a_11924_13728# VPWR.t79 sg13_lv_pmos ad=0.2128p pd=1.5u as=0.2128p ps=1.5u w=1.12u l=0.13u
X2474 VGND.t61 VPWR.t1651 VGND.t61 VGND.t1110 sg13_lv_nmos ad=79.8f pd=0.8u as=0 ps=0 w=0.42u l=1u
X2475 sg13cmos5l_buf_16_10.A a_3694_3898# VGND.t310 VGND.t40 sg13_lv_nmos ad=0.1406p pd=1.12u as=0.1406p ps=1.12u w=0.74u l=0.13u
X2476 VPWR.t1186 a_6094_10704# sg13cmos5l_buf_16_24.A VPWR.t2 sg13_lv_pmos ad=0.2128p pd=1.5u as=0.2128p ps=1.5u w=1.12u l=0.13u
X2477 VGND.t157 a_6836_9156# sg13cmos5l_buf_16_25.A VGND.t161 sg13_lv_nmos ad=0.1406p pd=1.12u as=0.1406p ps=1.12u w=0.74u l=0.13u
X2478 VPWR.t665 a_6766_8434# sg13cmos5l_buf_16_35.A VPWR.t5 sg13_lv_pmos ad=0.2128p pd=1.5u as=0.2128p ps=1.5u w=1.12u l=0.13u
X2479 sg13cmos5l_buf_16_18.A a_4174_13728# VPWR.t1372 VPWR.t79 sg13_lv_pmos ad=0.2128p pd=1.5u as=0.2128p ps=1.5u w=1.12u l=0.13u
X2480 sg13cmos5l_buf_16_5.A a_5710_1632# VPWR.t56 VPWR.t55 sg13_lv_pmos ad=0.2128p pd=1.5u as=0.2128p ps=1.5u w=1.12u l=0.13u
X2481 VPWR.t56 a_5108_838# sg13cmos5l_buf_16_5.X VPWR.t55 sg13_lv_pmos ad=0.2128p pd=1.5u as=0.2128p ps=1.5u w=1.12u l=0.13u
X2482 sg13cmos5l_buf_16_1.X a_10318_5410# VPWR.t96 VPWR.t61 sg13_lv_pmos ad=0.2128p pd=1.5u as=0.2128p ps=1.5u w=1.12u l=0.13u
X2483 out_xor[5] a_14824_10704# VGND.t3 VGND.t2 sg13_lv_nmos ad=0.2886p pd=2.26u as=0.14875p ps=1.16u w=0.74u l=0.13u
X2484 sg13cmos5l_buf_16_31.X a_6094_4656# VPWR.t724 VPWR.t64 sg13_lv_pmos ad=0.2128p pd=1.5u as=0.2128p ps=1.5u w=1.12u l=0.13u
X2485 VPWR.t246 VGND.t797 VPWR.t245 VPWR.t64 sg13_lv_pmos ad=0.19p pd=1.38u as=0 ps=0 w=1u l=1u
X2486 VGND.t590 VPWR.t21 VGND.t590 VGND.t979 sg13_lv_nmos ad=79.8f pd=0.8u as=0 ps=0 w=0.42u l=1u
X2487 sg13cmos5l_buf_16_28.X a_5684_6132# VPWR.t580 VPWR.t61 sg13_lv_pmos ad=0.2128p pd=1.5u as=0.2128p ps=1.5u w=1.12u l=0.13u
X2488 sg13cmos5l_buf_16_6.X a_5518_6922# VPWR.t919 VPWR.t58 sg13_lv_pmos ad=0.2128p pd=1.5u as=0.2128p ps=1.5u w=1.12u l=0.13u
X2489 VGND.t5 a_9262_7680# sg13cmos5l_buf_16_2.A VGND.t113 sg13_lv_nmos ad=0.1406p pd=1.12u as=0.1406p ps=1.12u w=0.74u l=0.13u
X2490 VPWR.t818 a_3668_12180# sg13cmos5l_buf_16_15.X VPWR.t8 sg13_lv_pmos ad=0.2128p pd=1.5u as=0.2128p ps=1.5u w=1.12u l=0.13u
X2491 VGND.t845 a_5108_838# sg13cmos5l_buf_16_5.X VGND.t1453 sg13_lv_nmos ad=0.1406p pd=1.12u as=0.1406p ps=1.12u w=0.74u l=0.13u
X2492 VGND.t310 sg13cmos5l_buf_16_8.A a_3694_3898# VGND.t40 sg13_lv_nmos ad=0.1406p pd=1.12u as=0.1406p ps=1.12u w=0.74u l=0.13u
X2493 sg13cmos5l_buf_16_25.A a_6836_9156# VGND.t157 VGND.t158 sg13_lv_nmos ad=0.1406p pd=1.12u as=0.1406p ps=1.12u w=0.74u l=0.13u
X2494 VPWR.t440 sg13cmos5l_buf_16_1.X a_10318_8434# VPWR.t5 sg13_lv_pmos ad=0.2128p pd=1.5u as=0.2128p ps=1.5u w=1.12u l=0.13u
X2495 VPWR.t483 a_5204_11422# sg13cmos5l_buf_16_20.A VPWR.t8 sg13_lv_pmos ad=0.2128p pd=1.5u as=0.2128p ps=1.5u w=1.12u l=0.13u
X2496 a_6862_9946# sg13cmos5l_buf_16_24.A VPWR.t629 VPWR.t2 sg13_lv_pmos ad=0.2128p pd=1.5u as=0.3808p ps=2.92u w=1.12u l=0.13u
X2497 sg13cmos5l_buf_16_13.A a_3668_9156# VPWR.t648 VPWR.t5 sg13_lv_pmos ad=0.2128p pd=1.5u as=0.2128p ps=1.5u w=1.12u l=0.13u
X2498 VPWR.t96 a_10318_5410# sg13cmos5l_buf_16_1.X VPWR.t61 sg13_lv_pmos ad=0.2128p pd=1.5u as=0.2128p ps=1.5u w=1.12u l=0.13u
X2499 VPWR.t126 VGND.t1392 VPWR.t126 VPWR.t55 sg13_lv_pmos ad=0.34p pd=2.68u as=0 ps=0 w=1u l=1u
X2500 VPWR.t1033 VGND.t989 VPWR.t1031 VPWR.t2 sg13_lv_pmos ad=0.19p pd=1.38u as=0 ps=0 w=1u l=1u
X2501 VPWR.t723 sg13cmos5l_buf_16_7.X a_6094_4656# VPWR.t64 sg13_lv_pmos ad=0.2128p pd=1.5u as=0.2128p ps=1.5u w=1.12u l=0.13u
X2502 VPWR.t917 a_5518_6922# sg13cmos5l_buf_16_6.X VPWR.t58 sg13_lv_pmos ad=0.2128p pd=1.5u as=0.2128p ps=1.5u w=1.12u l=0.13u
X2503 VGND.t1061 VPWR.t440 VGND.t1061 VGND.t1066 sg13_lv_nmos ad=79.8f pd=0.8u as=0 ps=0 w=0.42u l=1u
X2504 sg13cmos5l_buf_16_18.A a_4174_13728# VPWR.t1368 VPWR.t79 sg13_lv_pmos ad=0.2128p pd=1.5u as=0.2128p ps=1.5u w=1.12u l=0.13u
X2505 VGND.t1010 VPWR.t3 VGND.t1010 VGND.t2 sg13_lv_nmos ad=0.1428p pd=1.52u as=0 ps=0 w=0.42u l=1u
X2506 VPWR.t135 VGND.t3 VPWR.t3 VPWR.t2 sg13_lv_pmos ad=0.19p pd=1.38u as=0 ps=0 w=1u l=1u
X2507 a_6161_9550# sg13cmos5l_buf_16_14.A VGND.t66 VGND.t72 sg13_lv_nmos ad=0.17462p pd=1.185u as=0.374p ps=2.46u w=0.55u l=0.13u
X2508 sg13cmos5l_buf_16_28.A a_7220_5374# VPWR.t715 VPWR.t61 sg13_lv_pmos ad=0.2128p pd=1.5u as=0.2128p ps=1.5u w=1.12u l=0.13u
X2509 VGND.t1383 VPWR.t250 VGND.t1382 VGND.t1381 sg13_lv_nmos ad=0.1428p pd=1.52u as=0 ps=0 w=0.42u l=1u
X2510 VPWR.t501 a_6836_9156# sg13cmos5l_buf_16_25.A VPWR.t5 sg13_lv_pmos ad=0.2128p pd=1.5u as=0.2128p ps=1.5u w=1.12u l=0.13u
X2511 sg13cmos5l_buf_16_5.A a_5710_1632# VPWR.t56 VPWR.t55 sg13_lv_pmos ad=0.2128p pd=1.5u as=0.2128p ps=1.5u w=1.12u l=0.13u
X2512 VGND.t597 VPWR.t0 VGND.t597 VGND.t911 sg13_lv_nmos ad=0.1428p pd=1.52u as=0 ps=0 w=0.42u l=1u
X2513 sg13cmos5l_buf_16_11.A a_4462_5410# VGND.t351 VGND.t433 sg13_lv_nmos ad=0.1406p pd=1.12u as=0.1406p ps=1.12u w=0.74u l=0.13u
X2514 VGND.t1281 VPWR.t1608 VGND.t194 VGND.t1282 sg13_lv_nmos ad=79.8f pd=0.8u as=0 ps=0 w=0.42u l=1u
X2515 VGND.t444 VPWR.t1680 VGND.t444 VGND.t950 sg13_lv_nmos ad=79.8f pd=0.8u as=0 ps=0 w=0.42u l=1u
X2516 VPWR.t1485 VGND.t1274 VPWR.t1483 VPWR.t67 sg13_lv_pmos ad=0.19p pd=1.38u as=0 ps=0 w=1u l=1u
X2517 VGND.t122 a_3668_3108# sg13cmos5l_buf_16_7.A VGND.t40 sg13_lv_nmos ad=0.1406p pd=1.12u as=0.1406p ps=1.12u w=0.74u l=0.13u
X2518 VGND.t5 sg13cmos5l_buf_16_6.X a_9617_8484# VGND.t190 sg13_lv_nmos ad=0.15245p pd=1.17u as=0.17462p ps=1.185u w=0.55u l=0.13u
X2519 VPWR.t361 VGND.t42 VPWR.t416 VPWR.t67 sg13_lv_pmos ad=0.34p pd=2.68u as=0 ps=0 w=1u l=1u
X2520 sg13cmos5l_buf_16_18.A a_4174_13728# VPWR.t1364 VPWR.t79 sg13_lv_pmos ad=0.2128p pd=1.5u as=0.2128p ps=1.5u w=1.12u l=0.13u
X2521 VGND.t42 VPWR.t1619 VGND.t42 VGND.t40 sg13_lv_nmos ad=0.1428p pd=1.52u as=0 ps=0 w=0.42u l=1u
X2522 VPWR.t36 VGND.t590 VPWR.t34 VPWR.t8 sg13_lv_pmos ad=0.19p pd=1.38u as=0 ps=0 w=1u l=1u
X2523 VGND.t198 a_3694_2386# sg13cmos5l_buf_16_7.X VGND.t1576 sg13_lv_nmos ad=0.1406p pd=1.12u as=0.1406p ps=1.12u w=0.74u l=0.13u
X2524 VPWR.t216 a_8494_3144# sg13cmos5l_buf_16_39.A VPWR.t67 sg13_lv_pmos ad=0.2128p pd=1.5u as=0.2128p ps=1.5u w=1.12u l=0.13u
X2525 VGND.t898 VPWR.t1694 VGND.t898 VGND.t897 sg13_lv_nmos ad=0.1428p pd=1.52u as=0 ps=0 w=0.42u l=1u
X2526 sg13cmos5l_buf_16_0.A a_6094_3898# VPWR.t750 VPWR.t64 sg13_lv_pmos ad=0.2128p pd=1.5u as=0.2128p ps=1.5u w=1.12u l=0.13u
X2527 sg13cmos5l_buf_16_5.A a_5710_1632# VGND.t25 VGND.t866 sg13_lv_nmos ad=0.1406p pd=1.12u as=0.1406p ps=1.12u w=0.74u l=0.13u
X2528 VGND.t1418 VPWR.t226 VGND.t1420 VGND.t1419 sg13_lv_nmos ad=79.8f pd=0.8u as=0 ps=0 w=0.42u l=1u
X2529 sg13cmos5l_buf_16_7.A a_3668_3108# VGND.t310 VGND.t40 sg13_lv_nmos ad=0.1406p pd=1.12u as=0.1406p ps=1.12u w=0.74u l=0.13u
X2530 VPWR.t10 VGND.t726 VPWR.t9 VPWR.t8 sg13_lv_pmos ad=0.34p pd=2.68u as=0 ps=0 w=1u l=1u
X2531 a_3694_7680# sg13cmos5l_buf_16_34.A VPWR.t211 VPWR.t58 sg13_lv_pmos ad=0.2128p pd=1.5u as=0.2128p ps=1.5u w=1.12u l=0.13u
X2532 VGND.t989 VPWR.t1675 VGND.t989 VGND.t2 sg13_lv_nmos ad=0.1428p pd=1.52u as=0 ps=0 w=0.42u l=1u
X2533 sg13cmos5l_buf_16_2.X a_10318_3898# VGND.t41 VGND.t40 sg13_lv_nmos ad=0.1406p pd=1.12u as=0.1406p ps=1.12u w=0.74u l=0.13u
X2534 sg13cmos5l_buf_16_4.A a_11565_8028# VPWR.t91 VPWR.t58 sg13_lv_pmos ad=0.2128p pd=1.5u as=0.1918p ps=1.5u w=1.12u l=0.13u
X2535 VPWR.t767 a_6094_3144# sg13cmos5l_xor2_1_0.B VPWR.t67 sg13_lv_pmos ad=0.2128p pd=1.5u as=0.2128p ps=1.5u w=1.12u l=0.13u
X2536 VPWR.t977 VGND.t444 VPWR.t958 VPWR.t8 sg13_lv_pmos ad=0.19p pd=1.38u as=0 ps=0 w=1u l=1u
X2537 VGND.t50 a_3694_8434# sg13cmos5l_buf_16_34.A VGND.t54 sg13_lv_nmos ad=0.1406p pd=1.12u as=0.1406p ps=1.12u w=0.74u l=0.13u
X2538 VPWR.t1579 a_3694_2386# sg13cmos5l_buf_16_7.X VPWR.t67 sg13_lv_pmos ad=0.2128p pd=1.5u as=0.2128p ps=1.5u w=1.12u l=0.13u
X2539 VGND.t41 VPWR.t120 VGND.t41 VGND.t40 sg13_lv_nmos ad=79.8f pd=0.8u as=0 ps=0 w=0.42u l=1u
X2540 VGND.t25 a_5710_1632# sg13cmos5l_buf_16_5.A VGND.t863 sg13_lv_nmos ad=0.1406p pd=1.12u as=0.1406p ps=1.12u w=0.74u l=0.13u
X2541 VGND.t870 a_4174_13728# sg13cmos5l_buf_16_18.A VGND.t1440 sg13_lv_nmos ad=0.1406p pd=1.12u as=0.1406p ps=1.12u w=0.74u l=0.13u
X2542 VPWR.t539 VGND.t942 VPWR.t537 VPWR.t79 sg13_lv_pmos ad=0.19p pd=1.38u as=0 ps=0 w=1u l=1u
X2543 VGND.t310 a_3668_3108# sg13cmos5l_buf_16_7.A VGND.t40 sg13_lv_nmos ad=0.1406p pd=1.12u as=0.1406p ps=1.12u w=0.74u l=0.13u
X2544 VPWR.t1271 sg13cmos5l_buf_16_7.X a_6094_4656# VPWR.t64 sg13_lv_pmos ad=0.2128p pd=1.5u as=0.2128p ps=1.5u w=1.12u l=0.13u
X2545 VPWR.t16 VGND.t726 VPWR.t16 VPWR.t8 sg13_lv_pmos ad=0.34p pd=2.68u as=0 ps=0 w=1u l=1u
X2546 VGND.t171 a_6094_4656# sg13cmos5l_buf_16_31.X VGND.t360 sg13_lv_nmos ad=0.1406p pd=1.12u as=0.1406p ps=1.12u w=0.74u l=0.13u
X2547 VGND.t41 a_10318_3898# sg13cmos5l_buf_16_2.X VGND.t40 sg13_lv_nmos ad=0.1406p pd=1.12u as=0.1406p ps=1.12u w=0.74u l=0.13u
X2548 VPWR.t804 a_4462_5410# sg13cmos5l_buf_16_11.A VPWR.t61 sg13_lv_pmos ad=0.2128p pd=1.5u as=0.2128p ps=1.5u w=1.12u l=0.13u
X2549 VGND.t513 VPWR.t131 VGND.t513 VGND.t986 sg13_lv_nmos ad=0.1428p pd=1.52u as=0 ps=0 w=0.42u l=1u
X2550 sg13cmos5l_buf_16_34.A a_3694_8434# VGND.t50 VGND.t51 sg13_lv_nmos ad=0.1406p pd=1.12u as=0.1406p ps=1.12u w=0.74u l=0.13u
X2551 VGND.t157 a_6862_9946# sg13cmos5l_buf_16_24.X VGND.t477 sg13_lv_nmos ad=0.2516p pd=2.16u as=0.1406p ps=1.12u w=0.74u l=0.13u
X2552 VGND.t1050 VPWR.t1657 VGND.t1050 VGND.t1054 sg13_lv_nmos ad=0.1428p pd=1.52u as=0 ps=0 w=0.42u l=1u
X2553 VGND.t302 a_8494_3144# sg13cmos5l_buf_16_39.A VGND.t40 sg13_lv_nmos ad=0.1406p pd=1.12u as=0.1406p ps=1.12u w=0.74u l=0.13u
X2554 a_3694_2386# sg13cmos5l_buf_16_7.A VPWR.t563 VPWR.t67 sg13_lv_pmos ad=0.2128p pd=1.5u as=0.2128p ps=1.5u w=1.12u l=0.13u
X2555 VPWR.t553 sg13cmos5l_buf_16_34.X a_3694_10704# VPWR.t2 sg13_lv_pmos ad=0.2128p pd=1.5u as=0.2128p ps=1.5u w=1.12u l=0.13u
X2556 sg13cmos5l_buf_16_0.A a_6094_3898# VPWR.t746 VPWR.t64 sg13_lv_pmos ad=0.2128p pd=1.5u as=0.2128p ps=1.5u w=1.12u l=0.13u
X2557 VPWR.t223 sg13cmos5l_buf_16_39.A a_6164_2350# VPWR.t67 sg13_lv_pmos ad=0.3808p pd=2.92u as=0.2128p ps=1.5u w=1.12u l=0.13u
X2558 VPWR.t126 VGND.t1397 VPWR.t126 VPWR.t55 sg13_lv_pmos ad=0.34p pd=2.68u as=0 ps=0 w=1u l=1u
X2559 VPWR.t135 VGND.t37 VPWR.t135 VPWR.t2 sg13_lv_pmos ad=0.19p pd=1.38u as=0 ps=0 w=1u l=1u
X2560 VGND.t1274 VPWR.t1611 VGND.t1274 VGND.t1275 sg13_lv_nmos ad=79.8f pd=0.8u as=0 ps=0 w=0.42u l=1u
X2561 VPWR.t181 VGND.t61 VPWR.t179 VPWR.t58 sg13_lv_pmos ad=0.19p pd=1.38u as=0 ps=0 w=1u l=1u
X2562 sg13cmos5l_buf_16_11.A a_4462_5410# VPWR.t800 VPWR.t61 sg13_lv_pmos ad=0.2128p pd=1.5u as=0.2128p ps=1.5u w=1.12u l=0.13u
X2563 sg13cmos5l_buf_16_4.X a_9524_6886# VGND.t210 VGND.t553 sg13_lv_nmos ad=0.1406p pd=1.12u as=0.1406p ps=1.12u w=0.74u l=0.13u
X2564 VGND.t41 VPWR.t113 VGND.t41 VGND.t40 sg13_lv_nmos ad=79.8f pd=0.8u as=0 ps=0 w=0.42u l=1u
X2565 sg13cmos5l_buf_16_37.X a_7796_12934# VGND.t590 VGND.t684 sg13_lv_nmos ad=0.1406p pd=1.12u as=0.1406p ps=1.12u w=0.74u l=0.13u
X2566 VPWR.t763 a_6094_3144# sg13cmos5l_xor2_1_0.B VPWR.t67 sg13_lv_pmos ad=0.2128p pd=1.5u as=0.2128p ps=1.5u w=1.12u l=0.13u
X2567 sg13cmos5l_buf_16_23.X a_10292_12934# VPWR.t566 VPWR.t79 sg13_lv_pmos ad=0.2128p pd=1.5u as=0.3976p ps=2.95u w=1.12u l=0.13u
X2568 a_3668_12180# sg13cmos5l_buf_16_15.A VGND.t620 VGND.t702 sg13_lv_nmos ad=0.1406p pd=1.12u as=0.1406p ps=1.12u w=0.74u l=0.13u
X2569 VPWR.t405 VGND.t42 VPWR.t404 VPWR.t64 sg13_lv_pmos ad=0.34p pd=2.68u as=0 ps=0 w=1u l=1u
X2570 VPWR.t61 a_8110_6168# sg13cmos5l_buf_16_38.A VPWR.t61 sg13_lv_pmos ad=0.3976p pd=2.95u as=0.2128p ps=1.5u w=1.12u l=0.13u
X2571 a_4052_12934# sg13cmos5l_buf_16_18.A VGND.t620 VGND.t642 sg13_lv_nmos ad=0.1406p pd=1.12u as=0.1406p ps=1.12u w=0.74u l=0.13u
X2572 VPWR.t131 VGND.t513 VPWR.t131 VPWR.t8 sg13_lv_pmos ad=0.34p pd=2.68u as=0 ps=0 w=1u l=1u
X2573 VGND.t7 a_9524_6886# sg13cmos5l_buf_16_4.X VGND.t550 sg13_lv_nmos ad=0.1406p pd=1.12u as=0.1406p ps=1.12u w=0.74u l=0.13u
X2574 sg13cmos5l_xor2_1_0.B a_6094_3144# VPWR.t759 VPWR.t67 sg13_lv_pmos ad=0.2128p pd=1.5u as=0.2128p ps=1.5u w=1.12u l=0.13u
X2575 VPWR.t28 VGND.t1061 VPWR.t28 VPWR.t2 sg13_lv_pmos ad=0.34p pd=2.68u as=0 ps=0 w=1u l=1u
X2576 sg13cmos5l_buf_16_23.X a_10292_12934# VGND.t676 VGND.t679 sg13_lv_nmos ad=0.1406p pd=1.12u as=0.1406p ps=1.12u w=0.74u l=0.13u
X2577 VPWR.t1259 sg13cmos5l_buf_16_28.A a_5684_6132# VPWR.t61 sg13_lv_pmos ad=0.3808p pd=2.92u as=0.2128p ps=1.5u w=1.12u l=0.13u
X2578 VPWR.t1328 sg13cmos5l_buf_16_15.X a_3694_14482# VPWR.t0 sg13_lv_pmos ad=0.2128p pd=1.5u as=0.2128p ps=1.5u w=1.12u l=0.13u
X2579 VGND.t1073 VPWR.t3 VGND.t1073 VGND.t1074 sg13_lv_nmos ad=0.1428p pd=1.52u as=0 ps=0 w=0.42u l=1u
X2580 VPWR.t1341 a_3694_14482# sg13cmos5l_buf_16_33.A VPWR.t0 sg13_lv_pmos ad=0.2128p pd=1.5u as=0.2128p ps=1.5u w=1.12u l=0.13u
X2581 VGND.t797 a_3668_4620# sg13cmos5l_buf_16_8.A VGND.t818 sg13_lv_nmos ad=0.1406p pd=1.12u as=0.1406p ps=1.12u w=0.74u l=0.13u
X2582 VPWR.t364 VGND.t1237 VPWR.t363 VPWR.t67 sg13_lv_pmos ad=0.34p pd=2.68u as=0 ps=0 w=1u l=1u
X2583 a_9524_6886# sg13cmos5l_buf_16_4.A VPWR.t91 VPWR.t58 sg13_lv_pmos ad=0.2128p pd=1.5u as=0.2128p ps=1.5u w=1.12u l=0.13u
X2584 sg13cmos5l_buf_16_34.X a_3694_7680# VGND.t50 VGND.t53 sg13_lv_nmos ad=0.1406p pd=1.12u as=0.1406p ps=1.12u w=0.74u l=0.13u
X2585 VGND.t1281 VPWR.t1608 VGND.t1274 VGND.t1280 sg13_lv_nmos ad=0.1428p pd=1.52u as=0 ps=0 w=0.42u l=1u
X2586 a_12350_13728# sg13cmos5l_buf_16_27.X a_11898_13691# VPWR.t79 sg13_lv_pmos ad=0.1225p pd=1.245u as=0.34p ps=2.68u w=1u l=0.13u
X2587 a_3694_3898# sg13cmos5l_buf_16_8.A VPWR.t685 VPWR.t64 sg13_lv_pmos ad=0.2128p pd=1.5u as=0.2128p ps=1.5u w=1.12u l=0.13u
X2588 VGND.t837 a_5710_1632# sg13cmos5l_buf_16_5.A VGND.t859 sg13_lv_nmos ad=0.1406p pd=1.12u as=0.1406p ps=1.12u w=0.74u l=0.13u
X2589 VGND.t139 sg13cmos5l_buf_16_19.A a_5204_11422# VGND.t2 sg13_lv_nmos ad=0.1406p pd=1.12u as=0.1406p ps=1.12u w=0.74u l=0.13u
X2590 VGND.t171 a_6094_4656# sg13cmos5l_buf_16_31.X VGND.t356 sg13_lv_nmos ad=0.1406p pd=1.12u as=0.1406p ps=1.12u w=0.74u l=0.13u
X2591 sg13cmos5l_buf_16_8.A a_3668_4620# VGND.t797 VGND.t815 sg13_lv_nmos ad=0.1406p pd=1.12u as=0.2516p ps=2.16u w=0.74u l=0.13u
X2592 VPWR.t566 sg13cmos5l_buf_1_17.A a_10292_12934# VPWR.t79 sg13_lv_pmos ad=0.2128p pd=1.5u as=0.2128p ps=1.5u w=1.12u l=0.13u
X2593 VPWR.t348 sg13cmos5l_buf_16_4.A a_9524_6886# VPWR.t58 sg13_lv_pmos ad=0.2128p pd=1.5u as=0.2128p ps=1.5u w=1.12u l=0.13u
X2594 VGND.t50 a_3694_7680# sg13cmos5l_buf_16_34.X VGND.t49 sg13_lv_nmos ad=0.1406p pd=1.12u as=0.1406p ps=1.12u w=0.74u l=0.13u
X2595 a_6836_9156# sg13cmos5l_and2_2_6.X VGND.t157 VGND.t476 sg13_lv_nmos ad=0.1406p pd=1.12u as=0.1406p ps=1.12u w=0.74u l=0.13u
X2596 VGND.t5 a_10318_8434# sg13cmos5l_buf_16_22.X VGND.t582 sg13_lv_nmos ad=0.1406p pd=1.12u as=0.1406p ps=1.12u w=0.74u l=0.13u
X2597 VPWR.t846 a_3668_3108# sg13cmos5l_buf_16_7.A VPWR.t67 sg13_lv_pmos ad=0.2128p pd=1.5u as=0.2128p ps=1.5u w=1.12u l=0.13u
X2598 sg13cmos5l_buf_16_23.X a_10292_12934# VGND.t590 VGND.t674 sg13_lv_nmos ad=0.1406p pd=1.12u as=0.1406p ps=1.12u w=0.74u l=0.13u
X2599 VGND.t157 a_6862_9946# sg13cmos5l_buf_16_24.X VGND.t473 sg13_lv_nmos ad=0.1406p pd=1.12u as=0.1406p ps=1.12u w=0.74u l=0.13u
X2600 sg13cmos5l_buf_16_34.A a_3694_8434# VGND.t18 VGND.t46 sg13_lv_nmos ad=0.1406p pd=1.12u as=0.1406p ps=1.12u w=0.74u l=0.13u
X2601 VGND.t302 a_8494_3144# sg13cmos5l_buf_16_39.A VGND.t40 sg13_lv_nmos ad=0.1406p pd=1.12u as=0.1406p ps=1.12u w=0.74u l=0.13u
X2602 VGND.t171 sg13cmos5l_buf_16_38.A a_7220_5374# VGND.t174 sg13_lv_nmos ad=0.1406p pd=1.12u as=0.1406p ps=1.12u w=0.74u l=0.13u
X2603 sg13cmos5l_buf_16_2.A a_9262_7680# VPWR.t335 VPWR.t58 sg13_lv_pmos ad=0.2128p pd=1.5u as=0.2128p ps=1.5u w=1.12u l=0.13u
X2604 a_6548_13692# sg13cmos5l_buf_16_37.X VGND.t597 VGND.t1516 sg13_lv_nmos ad=0.1406p pd=1.12u as=0.1406p ps=1.12u w=0.74u l=0.13u
X2605 VPWR.t1083 a_4052_12934# sg13cmos5l_buf_16_15.A VPWR.t79 sg13_lv_pmos ad=0.2128p pd=1.5u as=0.2128p ps=1.5u w=1.12u l=0.13u
X2606 VGND.t1010 VPWR.t129 VGND.t1010 VGND.t2 sg13_lv_nmos ad=0.1428p pd=1.52u as=0 ps=0 w=0.42u l=1u
X2607 VPWR.t929 VGND.t994 VPWR.t928 VPWR.t2 sg13_lv_pmos ad=0.19p pd=1.38u as=0 ps=0 w=1u l=1u
X2608 sg13cmos5l_and2_2_6.A a_3694_10704# VPWR.t1206 VPWR.t2 sg13_lv_pmos ad=0.2128p pd=1.5u as=0.2128p ps=1.5u w=1.12u l=0.13u
X2609 VGND.t5 VPWR.t1654 VGND.t5 VGND.t1103 sg13_lv_nmos ad=79.8f pd=0.8u as=0 ps=0 w=0.42u l=1u
X2610 VPWR.t86 VGND.t198 VPWR.t86 VPWR.t55 sg13_lv_pmos ad=0.19p pd=1.38u as=0 ps=0 w=1u l=1u
X2611 out_xor[1] a_14824_3144# VPWR.t239 VPWR.t67 sg13_lv_pmos ad=0.42p pd=2.99u as=0.2114p ps=1.54u w=1.12u l=0.13u
X2612 sg13cmos5l_buf_16_22.X a_10318_8434# VGND.t5 VGND.t579 sg13_lv_nmos ad=0.1406p pd=1.12u as=0.1406p ps=1.12u w=0.74u l=0.13u
X2613 VGND.t5 a_9262_7680# sg13cmos5l_buf_16_2.A VGND.t100 sg13_lv_nmos ad=0.1406p pd=1.12u as=0.1406p ps=1.12u w=0.74u l=0.13u
X2614 sg13cmos5l_buf_16_24.X a_6862_9946# VGND.t157 VGND.t168 sg13_lv_nmos ad=0.1406p pd=1.12u as=0.1406p ps=1.12u w=0.74u l=0.13u
X2615 sg13cmos5l_buf_16_39.A a_8494_3144# VGND.t96 VGND.t40 sg13_lv_nmos ad=0.1406p pd=1.12u as=0.1406p ps=1.12u w=0.74u l=0.13u
X2616 VPWR.t231 VGND.t891 VPWR.t233 VPWR.t0 sg13_lv_pmos ad=0.19p pd=1.38u as=0 ps=0 w=1u l=1u
X2617 VGND.t198 VPWR.t56 VGND.t198 VGND.t1318 sg13_lv_nmos ad=79.8f pd=0.8u as=0 ps=0 w=0.42u l=1u
X2618 VGND.t1354 VPWR.t99 VGND.t1353 VGND.t1352 sg13_lv_nmos ad=0.1428p pd=1.52u as=0 ps=0 w=0.42u l=1u
X2619 VGND.t125 a_3694_3898# sg13cmos5l_buf_16_10.A VGND.t40 sg13_lv_nmos ad=0.2516p pd=2.16u as=0.1406p ps=1.12u w=0.74u l=0.13u
X2620 VPWR.t297 VGND.t260 VPWR.t295 VPWR.t2 sg13_lv_pmos ad=0.19p pd=1.38u as=0 ps=0 w=1u l=1u
X2621 VPWR.t21 VGND.t1010 VPWR.t21 VPWR.t8 sg13_lv_pmos ad=0.19p pd=1.38u as=0 ps=0 w=1u l=1u
X2622 a_9262_7680# sg13cmos5l_buf_16_4.X VGND.t5 VGND.t770 sg13_lv_nmos ad=0.1406p pd=1.12u as=0.1406p ps=1.12u w=0.74u l=0.13u
X2623 a_5204_11422# sg13cmos5l_buf_16_19.A VPWR.t621 VPWR.t8 sg13_lv_pmos ad=0.2128p pd=1.5u as=0.2128p ps=1.5u w=1.12u l=0.13u
X2624 VPWR.t840 a_6862_9946# sg13cmos5l_buf_16_24.X VPWR.t2 sg13_lv_pmos ad=0.2128p pd=1.5u as=0.2128p ps=1.5u w=1.12u l=0.13u
X2625 VPWR.t1477 VGND.t1274 VPWR.t1475 VPWR.t67 sg13_lv_pmos ad=0.19p pd=1.38u as=0 ps=0 w=1u l=1u
X2626 VGND.t513 VPWR.t131 VGND.t513 VGND.t985 sg13_lv_nmos ad=79.8f pd=0.8u as=0 ps=0 w=0.42u l=1u
X2627 VPWR.t925 VGND.t994 VPWR.t924 VPWR.t8 sg13_lv_pmos ad=0.34p pd=2.68u as=0 ps=0 w=1u l=1u
X2628 VPWR.t201 VGND.t841 VPWR.t200 VPWR.t79 sg13_lv_pmos ad=0.34p pd=2.68u as=0 ps=0 w=1u l=1u
X2629 sg13cmos5l_buf_16_27.X a_6548_13692# VGND.t891 VGND.t1481 sg13_lv_nmos ad=0.1406p pd=1.12u as=0.1406p ps=1.12u w=0.74u l=0.13u
X2630 sg13cmos5l_buf_16_38.A a_8110_6168# VGND.t7 VGND.t784 sg13_lv_nmos ad=0.1406p pd=1.12u as=0.1406p ps=1.12u w=0.74u l=0.13u
X2631 VPWR.t1079 a_4052_12934# sg13cmos5l_buf_16_15.A VPWR.t79 sg13_lv_pmos ad=0.2128p pd=1.5u as=0.2128p ps=1.5u w=1.12u l=0.13u
X2632 sg13cmos5l_buf_16_10.A a_3694_3898# VGND.t122 VGND.t40 sg13_lv_nmos ad=0.1406p pd=1.12u as=0.1406p ps=1.12u w=0.74u l=0.13u
X2633 sg13cmos5l_buf_16_33.A a_3694_14482# VPWR.t1343 VPWR.t0 sg13_lv_pmos ad=0.2128p pd=1.5u as=0.2128p ps=1.5u w=1.12u l=0.13u
X2634 VPWR.t262 a_3694_8434# sg13cmos5l_buf_16_34.A VPWR.t5 sg13_lv_pmos ad=0.2128p pd=1.5u as=0.2128p ps=1.5u w=1.12u l=0.13u
X2635 sg13cmos5l_buf_16_22.X a_10318_8434# VPWR.t6 VPWR.t5 sg13_lv_pmos ad=0.2128p pd=1.5u as=0.2128p ps=1.5u w=1.12u l=0.13u
X2636 VPWR.t216 sg13cmos5l_buf_16_0.A a_8494_3144# VPWR.t67 sg13_lv_pmos ad=0.2128p pd=1.5u as=0.2128p ps=1.5u w=1.12u l=0.13u
X2637 sg13cmos5l_buf_16_5.X a_5108_838# VGND.t845 VGND.t1454 sg13_lv_nmos ad=0.1406p pd=1.12u as=0.1406p ps=1.12u w=0.74u l=0.13u
X2638 VGND.t218 sg13cmos5l_buf_16_28.X a_5518_6922# VGND.t630 sg13_lv_nmos ad=0.1406p pd=1.12u as=0.1406p ps=1.12u w=0.74u l=0.13u
X2639 VGND.t5 sg13cmos5l_buf_16_4.X a_9262_7680# VGND.t767 sg13_lv_nmos ad=0.1406p pd=1.12u as=0.1406p ps=1.12u w=0.74u l=0.13u
X2640 sg13cmos5l_buf_16_31.X a_6094_4656# VPWR.t734 VPWR.t64 sg13_lv_pmos ad=0.2128p pd=1.5u as=0.2128p ps=1.5u w=1.12u l=0.13u
X2641 sg13cmos5l_buf_16_28.X a_5684_6132# VPWR.t590 VPWR.t61 sg13_lv_pmos ad=0.2128p pd=1.5u as=0.2128p ps=1.5u w=1.12u l=0.13u
X2642 sg13cmos5l_buf_16_15.X a_3668_12180# VPWR.t818 VPWR.t8 sg13_lv_pmos ad=0.2128p pd=1.5u as=0.2128p ps=1.5u w=1.12u l=0.13u
X2643 VGND.t76 a_10292_4620# sg13cmos5l_buf_16_3.X VGND.t81 sg13_lv_nmos ad=0.1406p pd=1.12u as=0.1406p ps=1.12u w=0.74u l=0.13u
X2644 VGND.t895 a_2147_13692# sg13cmos5l_and2_2_1.X VGND.t1507 sg13_lv_nmos ad=0.1331p pd=1.12u as=0.1406p ps=1.12u w=0.74u l=0.13u
X2645 VGND.t513 VPWR.t81 VGND.t513 VGND.t959 sg13_lv_nmos ad=79.8f pd=0.8u as=0 ps=0 w=0.42u l=1u
X2646 sg13cmos5l_xor2_1_7.X sg13cmos5l_and2_2_3.X a_14010_11470# VGND.t2 sg13_lv_nmos ad=0.1628p pd=1.18u as=88.8f ps=0.98u w=0.74u l=0.13u
X2647 a_3694_8434# sg13cmos5l_buf_16_13.A VPWR.t421 VPWR.t5 sg13_lv_pmos ad=0.2128p pd=1.5u as=0.2128p ps=1.5u w=1.12u l=0.13u
X2648 VPWR.t6 a_10318_8434# sg13cmos5l_buf_16_22.X VPWR.t5 sg13_lv_pmos ad=0.2128p pd=1.5u as=0.2128p ps=1.5u w=1.12u l=0.13u
X2649 VPWR.t836 a_6862_9946# sg13cmos5l_buf_16_24.X VPWR.t2 sg13_lv_pmos ad=0.2128p pd=1.5u as=0.2128p ps=1.5u w=1.12u l=0.13u
X2650 sg13cmos5l_buf_16_27.X a_6548_13692# VGND.t891 VGND.t1477 sg13_lv_nmos ad=0.1406p pd=1.12u as=0.2516p ps=2.16u w=0.74u l=0.13u
X2651 sg13cmos5l_buf_16_14.A a_4436_9910# VGND.t260 VGND.t751 sg13_lv_nmos ad=0.1406p pd=1.12u as=0.1406p ps=1.12u w=0.74u l=0.13u
X2652 VPWR.t57 a_5710_1632# sg13cmos5l_buf_16_5.A VPWR.t55 sg13_lv_pmos ad=0.2128p pd=1.5u as=0.2128p ps=1.5u w=1.12u l=0.13u
X2653 out_xor[1] a_14824_3144# VGND.t42 VGND.t40 sg13_lv_nmos ad=0.2886p pd=2.26u as=0.14875p ps=1.16u w=0.74u l=0.13u
X2654 a_10318_3898# sg13cmos5l_buf_16_2.A VPWR.t143 VPWR.t64 sg13_lv_pmos ad=0.2128p pd=1.5u as=0.2128p ps=1.5u w=1.12u l=0.13u
X2655 VPWR.t158 VGND.t1274 VPWR.t1486 VPWR.t67 sg13_lv_pmos ad=0.34p pd=2.68u as=0 ps=0 w=1u l=1u
X2656 VPWR.t952 VGND.t948 VPWR.t541 VPWR.t79 sg13_lv_pmos ad=0.19p pd=1.38u as=0 ps=0 w=1u l=1u
X2657 sg13cmos5l_buf_16_10.A a_3694_3898# VGND.t122 VGND.t40 sg13_lv_nmos ad=0.1406p pd=1.12u as=0.1406p ps=1.12u w=0.74u l=0.13u
X2658 VGND.t590 sg13cmos5l_buf_16_37.A a_7796_12934# VGND.t595 sg13_lv_nmos ad=0.2516p pd=2.16u as=0.1406p ps=1.12u w=0.74u l=0.13u
X2659 VGND.t157 a_6836_9156# sg13cmos5l_buf_16_25.A VGND.t167 sg13_lv_nmos ad=0.1406p pd=1.12u as=0.1406p ps=1.12u w=0.74u l=0.13u
X2660 VGND.t41 VPWR.t108 VGND.t41 VGND.t40 sg13_lv_nmos ad=0.1428p pd=1.52u as=0 ps=0 w=0.42u l=1u
X2661 VGND.t139 a_6094_10704# sg13cmos5l_buf_16_24.A VGND.t2 sg13_lv_nmos ad=0.1406p pd=1.12u as=0.1406p ps=1.12u w=0.74u l=0.13u
X2662 sg13cmos5l_buf_16_5.A a_5710_1632# VPWR.t56 VPWR.t55 sg13_lv_pmos ad=0.2128p pd=1.5u as=0.2128p ps=1.5u w=1.12u l=0.13u
X2663 sg13cmos5l_buf_16_31.X a_6094_4656# VPWR.t730 VPWR.t64 sg13_lv_pmos ad=0.2128p pd=1.5u as=0.2128p ps=1.5u w=1.12u l=0.13u
X2664 VPWR.t110 VGND.t41 VPWR.t110 VPWR.t64 sg13_lv_pmos ad=0.34p pd=2.68u as=0 ps=0 w=1u l=1u
X2665 VPWR.t56 VGND.t198 VPWR.t56 VPWR.t55 sg13_lv_pmos ad=0.19p pd=1.38u as=0 ps=0 w=1u l=1u
X2666 VGND.t76 a_10292_4620# sg13cmos5l_buf_16_3.X VGND.t77 sg13_lv_nmos ad=0.1406p pd=1.12u as=0.1406p ps=1.12u w=0.74u l=0.13u
X2667 VGND.t214 VPWR.t96 VGND.t1162 VGND.t1188 sg13_lv_nmos ad=79.8f pd=0.8u as=0 ps=0 w=0.42u l=1u
X2668 VPWR.t146 VGND.t1061 VPWR.t146 VPWR.t5 sg13_lv_pmos ad=0.19p pd=1.38u as=0 ps=0 w=1u l=1u
X2669 VPWR.t1269 a_3875_5396# sg13cmos5l_and2_2_0.X VPWR.t61 sg13_lv_pmos ad=0.1918p pd=1.5u as=0.2128p ps=1.5u w=1.12u l=0.13u
X2670 VGND.t125 sg13cmos5l_buf_16_10.A a_3668_3108# VGND.t40 sg13_lv_nmos ad=0.2516p pd=2.16u as=0.1406p ps=1.12u w=0.74u l=0.13u
X2671 VPWR.t47 VGND.t597 VPWR.t0 VPWR.t0 sg13_lv_pmos ad=0.19p pd=1.38u as=0 ps=0 w=1u l=1u
X2672 sg13cmos5l_buf_16_25.A a_6836_9156# VPWR.t509 VPWR.t5 sg13_lv_pmos ad=0.2128p pd=1.5u as=0.2128p ps=1.5u w=1.12u l=0.13u
X2673 VPWR.t58 VGND.t1117 VPWR.t58 VPWR.t58 sg13_lv_pmos ad=0.19p pd=1.38u as=0 ps=0 w=1u l=1u
X2674 VPWR.t1366 a_4174_13728# sg13cmos5l_buf_16_18.A VPWR.t79 sg13_lv_pmos ad=0.2128p pd=1.5u as=0.2128p ps=1.5u w=1.12u l=0.13u
X2675 a_10318_3898# sg13cmos5l_buf_16_2.A VPWR.t143 VPWR.t64 sg13_lv_pmos ad=0.2128p pd=1.5u as=0.3808p ps=2.92u w=1.12u l=0.13u
X2676 VGND.t218 a_5684_6132# sg13cmos5l_buf_16_28.X VGND.t221 sg13_lv_nmos ad=0.1406p pd=1.12u as=0.1406p ps=1.12u w=0.74u l=0.13u
X2677 VPWR.t81 sg13cmos5l_and2_2_3.X a_13667_12956# VPWR.t79 sg13_lv_pmos ad=0.2856p pd=2.36u as=0.1596p ps=1.22u w=0.84u l=0.13u
X2678 VPWR.t132 sg13cmos5l_buf_1_14.X a_14824_9192# VPWR.t5 sg13_lv_pmos ad=0.2114p pd=1.54u as=0.2856p ps=2.36u w=0.84u l=0.13u
X2679 VGND.t139 sg13cmos5l_buf_16_33.A a_6094_10704# VGND.t2 sg13_lv_nmos ad=0.1406p pd=1.12u as=0.1406p ps=1.12u w=0.74u l=0.13u
X2680 VPWR.t330 sg13cmos5l_buf_16_0.A a_8494_3144# VPWR.t67 sg13_lv_pmos ad=0.2128p pd=1.5u as=0.2128p ps=1.5u w=1.12u l=0.13u
X2681 VPWR.t1456 VGND.t1147 VPWR.t1454 VPWR.t58 sg13_lv_pmos ad=0.19p pd=1.38u as=0 ps=0 w=1u l=1u
X2682 VGND.t260 a_3668_9156# sg13cmos5l_buf_16_13.A VGND.t273 sg13_lv_nmos ad=0.1406p pd=1.12u as=0.1406p ps=1.12u w=0.74u l=0.13u
X2683 a_3668_3108# sg13cmos5l_buf_16_10.A VGND.t122 VGND.t40 sg13_lv_nmos ad=0.1406p pd=1.12u as=0.1406p ps=1.12u w=0.74u l=0.13u
X2684 VGND.t7 a_8110_6168# sg13cmos5l_buf_16_38.A VGND.t777 sg13_lv_nmos ad=0.1406p pd=1.12u as=0.1406p ps=1.12u w=0.74u l=0.13u
X2685 sg13cmos5l_buf_16_30.A a_6164_2350# VGND.t837 VGND.t1546 sg13_lv_nmos ad=0.1406p pd=1.12u as=0.1406p ps=1.12u w=0.74u l=0.13u
X2686 VPWR.t156 VGND.t1274 VPWR.t156 VPWR.t55 sg13_lv_pmos ad=0.19p pd=1.38u as=0 ps=0 w=1u l=1u
X2687 sg13cmos5l_buf_16_28.X a_5684_6132# VGND.t218 VGND.t217 sg13_lv_nmos ad=0.1406p pd=1.12u as=0.2516p ps=2.16u w=0.74u l=0.13u
X2688 VPWR.t391 VGND.t5 VPWR.t389 VPWR.t58 sg13_lv_pmos ad=0.19p pd=1.38u as=0 ps=0 w=1u l=1u
X2689 a_13745_8484# sg13cmos5l_buf_16_2.A VGND.t301 VGND.t300 sg13_lv_nmos ad=0.17462p pd=1.185u as=0.374p ps=2.46u w=0.55u l=0.13u
X2690 VPWR.t132 sg13cmos5l_buf_16_2.A a_13916_8728# VPWR.t5 sg13_lv_pmos ad=0.2128p pd=1.5u as=0.3808p ps=2.92u w=1.12u l=0.13u
X2691 sg13cmos5l_buf_16_15.X a_3668_12180# VGND.t444 VGND.t446 sg13_lv_nmos ad=0.1406p pd=1.12u as=0.1406p ps=1.12u w=0.74u l=0.13u
X2692 sg13cmos5l_buf_16_15.X a_3668_12180# VGND.t457 VGND.t460 sg13_lv_nmos ad=0.1406p pd=1.12u as=0.1406p ps=1.12u w=0.74u l=0.13u
X2693 VPWR.t440 a_10318_8434# sg13cmos5l_buf_16_22.X VPWR.t5 sg13_lv_pmos ad=0.2128p pd=1.5u as=0.2128p ps=1.5u w=1.12u l=0.13u
X2694 VPWR.t183 VGND.t61 VPWR.t182 VPWR.t58 sg13_lv_pmos ad=0.34p pd=2.68u as=0 ps=0 w=1u l=1u
X2695 sg13cmos5l_buf_16_33.A a_3694_14482# VGND.t870 VGND.t881 sg13_lv_nmos ad=0.1406p pd=1.12u as=0.1406p ps=1.12u w=0.74u l=0.13u
X2696 sg13cmos5l_buf_1_17.A a_13667_12956# VGND.t513 VGND.t512 sg13_lv_nmos ad=0.1406p pd=1.12u as=0.2812p ps=2.24u w=0.74u l=0.13u
X2697 VGND.t989 VPWR.t1669 VGND.t989 VGND.t2 sg13_lv_nmos ad=0.1428p pd=1.52u as=0 ps=0 w=0.42u l=1u
X2698 VPWR.t1589 a_3694_2386# sg13cmos5l_buf_16_7.X VPWR.t67 sg13_lv_pmos ad=0.2128p pd=1.5u as=0.2128p ps=1.5u w=1.12u l=0.13u
X2699 out_xor[7] a_14824_14516# VPWR.t1422 VPWR.t0 sg13_lv_pmos ad=0.42p pd=2.99u as=0.2114p ps=1.54u w=1.12u l=0.13u
X2700 sg13cmos5l_buf_16_37.X a_7796_12934# VPWR.t1155 VPWR.t79 sg13_lv_pmos ad=0.2128p pd=1.5u as=0.2128p ps=1.5u w=1.12u l=0.13u
X2701 VGND.t1061 VPWR.t6 VGND.t1061 VGND.t1069 sg13_lv_nmos ad=0.1428p pd=1.52u as=0 ps=0 w=0.42u l=1u
X2702 sg13cmos5l_buf_16_13.A a_3668_9156# VGND.t260 VGND.t270 sg13_lv_nmos ad=0.1406p pd=1.12u as=0.1406p ps=1.12u w=0.74u l=0.13u
X2703 a_13713_8752# sg13cmos5l_buf_16_2.A VPWR.t6 VPWR.t5 sg13_lv_pmos ad=0.1225p pd=1.245u as=0.36p ps=2.72u w=1u l=0.13u
X2704 VGND.t260 VPWR.t1660 VGND.t260 VGND.t1059 sg13_lv_nmos ad=79.8f pd=0.8u as=0 ps=0 w=0.42u l=1u
X2705 VPWR.t108 VGND.t41 VPWR.t64 VPWR.t64 sg13_lv_pmos ad=0.34p pd=2.68u as=0 ps=0 w=1u l=1u
X2706 sg13cmos5l_buf_16_8.A a_3668_4620# VPWR.t1277 VPWR.t64 sg13_lv_pmos ad=0.2128p pd=1.5u as=0.2128p ps=1.5u w=1.12u l=0.13u
X2707 VGND.t676 VPWR.t128 VGND.t676 VGND.t980 sg13_lv_nmos ad=0.1428p pd=1.52u as=0 ps=0 w=0.42u l=1u
X2708 VPWR.t1178 sg13cmos5l_buf_16_20.A a_4436_9910# VPWR.t2 sg13_lv_pmos ad=0.2128p pd=1.5u as=0.2128p ps=1.5u w=1.12u l=0.13u
X2709 VPWR.t894 a_3694_7680# sg13cmos5l_buf_16_34.X VPWR.t58 sg13_lv_pmos ad=0.2128p pd=1.5u as=0.2128p ps=1.5u w=1.12u l=0.13u
X2710 VGND.t31 VPWR.t986 VGND.t31 VGND.t1320 sg13_lv_nmos ad=79.8f pd=0.8u as=0 ps=0 w=0.42u l=1u
X2711 VGND.t41 a_10318_3898# sg13cmos5l_buf_16_2.X VGND.t40 sg13_lv_nmos ad=0.1406p pd=1.12u as=0.1406p ps=1.12u w=0.74u l=0.13u
X2712 VGND.t1050 VPWR.t1659 VGND.t1050 VGND.t1049 sg13_lv_nmos ad=0.1428p pd=1.52u as=0 ps=0 w=0.42u l=1u
X2713 sg13cmos5l_buf_16_34.A a_3694_8434# VGND.t61 VGND.t62 sg13_lv_nmos ad=0.1406p pd=1.12u as=0.1406p ps=1.12u w=0.74u l=0.13u
X2714 VGND.t125 a_6094_3898# sg13cmos5l_buf_16_0.A VGND.t40 sg13_lv_nmos ad=0.1406p pd=1.12u as=0.1406p ps=1.12u w=0.74u l=0.13u
X2715 VGND.t210 VPWR.t61 VGND.t210 VGND.t1182 sg13_lv_nmos ad=79.8f pd=0.8u as=0 ps=0 w=0.42u l=1u
X2716 a_6332_12216# sg13cmos5l_buf_16_24.X VPWR.t1095 VPWR.t8 sg13_lv_pmos ad=0.2128p pd=1.5u as=0.2128p ps=1.5u w=1.12u l=0.13u
X2717 VGND.t134 a_3694_10704# sg13cmos5l_and2_2_6.A VGND.t2 sg13_lv_nmos ad=0.1406p pd=1.12u as=0.1406p ps=1.12u w=0.74u l=0.13u
X2718 sg13cmos5l_buf_16_7.A a_3668_3108# VGND.t122 VGND.t40 sg13_lv_nmos ad=0.1406p pd=1.12u as=0.1406p ps=1.12u w=0.74u l=0.13u
X2719 VGND.t1019 VPWR.t131 VGND.t1019 VGND.t2 sg13_lv_nmos ad=79.8f pd=0.8u as=0 ps=0 w=0.42u l=1u
X2720 sg13cmos5l_buf_16_34.X a_3694_7680# VPWR.t890 VPWR.t58 sg13_lv_pmos ad=0.2128p pd=1.5u as=0.2128p ps=1.5u w=1.12u l=0.13u
X2721 VGND.t61 sg13cmos5l_buf_16_25.A a_6766_8434# VGND.t277 sg13_lv_nmos ad=0.1406p pd=1.12u as=0.1406p ps=1.12u w=0.74u l=0.13u
X2722 VPWR.t61 VGND.t76 VPWR.t61 VPWR.t61 sg13_lv_pmos ad=0.19p pd=1.38u as=0 ps=0 w=1u l=1u
X2723 sg13cmos5l_buf_16_37.X a_7796_12934# VPWR.t1151 VPWR.t79 sg13_lv_pmos ad=0.2128p pd=1.5u as=0.2128p ps=1.5u w=1.12u l=0.13u
X2724 VPWR.t135 VGND.t3 VPWR.t135 VPWR.t2 sg13_lv_pmos ad=0.34p pd=2.68u as=0 ps=0 w=1u l=1u
X2725 VPWR.t91 VGND.t5 VPWR.t91 VPWR.t58 sg13_lv_pmos ad=0.19p pd=1.38u as=0 ps=0 w=1u l=1u
X2726 VGND.t620 sg13cmos5l_buf_16_15.A a_3668_12180# VGND.t703 sg13_lv_nmos ad=0.2516p pd=2.16u as=0.1406p ps=1.12u w=0.74u l=0.13u
X2727 VGND.t37 sg13cmos5l_buf_1_14.X a_14824_9192# VGND.t36 sg13_lv_nmos ad=0.14875p pd=1.16u as=0.187p ps=1.78u w=0.55u l=0.13u
X2728 VPWR.t153 sg13cmos5l_buf_16_35.A a_8110_6168# VPWR.t61 sg13_lv_pmos ad=0.2128p pd=1.5u as=0.2128p ps=1.5u w=1.12u l=0.13u
X2729 VGND.t620 sg13cmos5l_buf_16_18.A a_4052_12934# VGND.t643 sg13_lv_nmos ad=0.1406p pd=1.12u as=0.1406p ps=1.12u w=0.74u l=0.13u
X2730 VPWR.t1216 a_4436_9910# sg13cmos5l_buf_16_14.A VPWR.t2 sg13_lv_pmos ad=0.2128p pd=1.5u as=0.2128p ps=1.5u w=1.12u l=0.13u
X2731 VGND.t942 VPWR.t1689 VGND.t942 VGND.t945 sg13_lv_nmos ad=79.8f pd=0.8u as=0 ps=0 w=0.42u l=1u
X2732 VPWR.t106 VGND.t7 VPWR.t104 VPWR.t58 sg13_lv_pmos ad=0.19p pd=1.38u as=0 ps=0 w=1u l=1u
X2733 VGND.t41 VPWR.t113 VGND.t41 VGND.t40 sg13_lv_nmos ad=79.8f pd=0.8u as=0 ps=0 w=0.42u l=1u
X2734 VGND.t7 VPWR.t1636 VGND.t7 VGND.t1156 sg13_lv_nmos ad=79.8f pd=0.8u as=0 ps=0 w=0.42u l=1u
X2735 VPWR.t58 sg13cmos5l_buf_1_23.A a_13768_7680# VPWR.t58 sg13_lv_pmos ad=0.2114p pd=1.54u as=0.2856p ps=2.36u w=0.84u l=0.13u
X2736 VPWR.t215 sg13cmos5l_buf_16_34.A a_3694_7680# VPWR.t58 sg13_lv_pmos ad=0.2128p pd=1.5u as=0.2128p ps=1.5u w=1.12u l=0.13u
X2737 VPWR.t16 VGND.t726 VPWR.t16 VPWR.t8 sg13_lv_pmos ad=0.19p pd=1.38u as=0 ps=0 w=1u l=1u
X2738 sg13cmos5l_xor2_1_0.B a_6094_3144# VPWR.t769 VPWR.t67 sg13_lv_pmos ad=0.2128p pd=1.5u as=0.2128p ps=1.5u w=1.12u l=0.13u
X2739 VGND.t218 a_4721_6526# sg13cmos5l_buf_1_6.A VGND.t479 sg13_lv_nmos ad=0.3108p pd=2.32u as=0.1628p ps=1.18u w=0.74u l=0.13u
X2740 VGND.t76 sg13cmos5l_buf_16_3.X a_10318_5410# VGND.t81 sg13_lv_nmos ad=0.1406p pd=1.12u as=0.1406p ps=1.12u w=0.74u l=0.13u
X2741 VGND.t942 VPWR.t1683 VGND.t942 VGND.t943 sg13_lv_nmos ad=79.8f pd=0.8u as=0 ps=0 w=0.42u l=1u
X2742 VGND.t513 VPWR.t131 VGND.t513 VGND.t987 sg13_lv_nmos ad=79.8f pd=0.8u as=0 ps=0 w=0.42u l=1u
X2743 a_8110_6168# sg13cmos5l_buf_16_35.A VPWR.t149 VPWR.t61 sg13_lv_pmos ad=0.2128p pd=1.5u as=0.2128p ps=1.5u w=1.12u l=0.13u
X2744 sg13cmos5l_buf_16_4.X a_9524_6886# VPWR.t335 VPWR.t58 sg13_lv_pmos ad=0.2128p pd=1.5u as=0.2128p ps=1.5u w=1.12u l=0.13u
X2745 VGND.t134 a_3694_10704# sg13cmos5l_and2_2_6.A VGND.t2 sg13_lv_nmos ad=0.1406p pd=1.12u as=0.1406p ps=1.12u w=0.74u l=0.13u
X2746 VPWR.t1172 sg13cmos5l_and2_2_2.B a_6765_12564# VPWR.t8 sg13_lv_pmos ad=0.1918p pd=1.5u as=0.1596p ps=1.22u w=0.84u l=0.13u
X2747 VPWR.t25 VGND.t726 VPWR.t23 VPWR.t2 sg13_lv_pmos ad=0.19p pd=1.38u as=0 ps=0 w=1u l=1u
X2748 VPWR.t503 a_6836_9156# sg13cmos5l_buf_16_25.A VPWR.t5 sg13_lv_pmos ad=0.2128p pd=1.5u as=0.2128p ps=1.5u w=1.12u l=0.13u
X2749 VPWR.t413 VGND.t42 VPWR.t412 VPWR.t67 sg13_lv_pmos ad=0.34p pd=2.68u as=0 ps=0 w=1u l=1u
X2750 a_6548_13692# sg13cmos5l_buf_16_37.X VPWR.t1440 VPWR.t79 sg13_lv_pmos ad=0.2128p pd=1.5u as=0.2128p ps=1.5u w=1.12u l=0.13u
X2751 VPWR.t335 sg13cmos5l_buf_16_4.X a_9262_7680# VPWR.t58 sg13_lv_pmos ad=0.2128p pd=1.5u as=0.2128p ps=1.5u w=1.12u l=0.13u
X2752 VGND.t620 a_4052_12934# sg13cmos5l_buf_16_15.A VGND.t619 sg13_lv_nmos ad=0.1406p pd=1.12u as=0.1406p ps=1.12u w=0.74u l=0.13u
X2753 VGND.t457 sg13cmos5l_buf_16_15.A a_3668_12180# VGND.t699 sg13_lv_nmos ad=0.1406p pd=1.12u as=0.1406p ps=1.12u w=0.74u l=0.13u
X2754 sg13cmos5l_buf_1_1.A a_13768_3932# VGND.t41 VGND.t40 sg13_lv_nmos ad=0.2886p pd=2.26u as=0.14875p ps=1.16u w=0.74u l=0.13u
X2755 sg13cmos5l_buf_16_13.A a_3668_9156# VGND.t260 VGND.t266 sg13_lv_nmos ad=0.1406p pd=1.12u as=0.1406p ps=1.12u w=0.74u l=0.13u
X2756 a_6766_8434# sg13cmos5l_buf_16_25.A VPWR.t652 VPWR.t5 sg13_lv_pmos ad=0.2128p pd=1.5u as=0.2128p ps=1.5u w=1.12u l=0.13u
X2757 VGND.t171 a_6094_4656# sg13cmos5l_buf_16_31.X VGND.t366 sg13_lv_nmos ad=0.2516p pd=2.16u as=0.1406p ps=1.12u w=0.74u l=0.13u
X2758 sg13cmos5l_buf_1_22.X a_14344_11492# VGND.t3 VGND.t2 sg13_lv_nmos ad=0.2886p pd=2.26u as=0.14875p ps=1.16u w=0.74u l=0.13u
X2759 sg13cmos5l_buf_16_8.A a_3668_4620# VGND.t801 VGND.t827 sg13_lv_nmos ad=0.1406p pd=1.12u as=0.1406p ps=1.12u w=0.74u l=0.13u
X2760 VGND.t61 a_3694_7680# sg13cmos5l_buf_16_34.X VGND.t60 sg13_lv_nmos ad=0.1406p pd=1.12u as=0.1406p ps=1.12u w=0.74u l=0.13u
X2761 sg13cmos5l_buf_16_34.A a_3694_8434# VGND.t50 VGND.t57 sg13_lv_nmos ad=0.1406p pd=1.12u as=0.1406p ps=1.12u w=0.74u l=0.13u
X2762 VGND.t1274 VPWR.t1609 VGND.t1274 VGND.t1278 sg13_lv_nmos ad=0.1428p pd=1.52u as=0 ps=0 w=0.42u l=1u
X2763 a_9262_7680# sg13cmos5l_buf_16_4.X VPWR.t1230 VPWR.t58 sg13_lv_pmos ad=0.2128p pd=1.5u as=0.3808p ps=2.92u w=1.12u l=0.13u
X2764 VGND.t134 sg13cmos5l_buf_16_34.X a_3694_10704# VGND.t2 sg13_lv_nmos ad=0.1406p pd=1.12u as=0.1406p ps=1.12u w=0.74u l=0.13u
X2765 VPWR.t1479 VGND.t1274 VPWR.t1478 VPWR.t67 sg13_lv_pmos ad=0.34p pd=2.68u as=0 ps=0 w=1u l=1u
X2766 VGND.t41 VPWR.t120 VGND.t41 VGND.t40 sg13_lv_nmos ad=0.1428p pd=1.52u as=0 ps=0 w=0.42u l=1u
X2767 VPWR.t288 VGND.t1050 VPWR.t458 VPWR.t2 sg13_lv_pmos ad=0.34p pd=2.68u as=0 ps=0 w=1u l=1u
X2768 VGND.t597 VPWR.t0 VGND.t597 VGND.t909 sg13_lv_nmos ad=0.1428p pd=1.52u as=0 ps=0 w=0.42u l=1u
X2769 VGND.t597 sg13cmos5l_buf_16_37.X a_6548_13692# VGND.t1517 sg13_lv_nmos ad=0.2516p pd=2.16u as=0.1406p ps=1.12u w=0.74u l=0.13u
X2770 sg13cmos5l_buf_16_27.X a_6548_13692# VPWR.t1406 VPWR.t79 sg13_lv_pmos ad=0.2128p pd=1.5u as=0.2128p ps=1.5u w=1.12u l=0.13u
X2771 VPWR.t1531 a_3694_3898# sg13cmos5l_buf_16_10.A VPWR.t64 sg13_lv_pmos ad=0.2128p pd=1.5u as=0.2128p ps=1.5u w=1.12u l=0.13u
X2772 VPWR.t81 VGND.t924 VPWR.t81 VPWR.t79 sg13_lv_pmos ad=0.19p pd=1.38u as=0 ps=0 w=1u l=1u
X2773 VPWR.t81 VGND.t513 VPWR.t80 VPWR.t79 sg13_lv_pmos ad=0.19p pd=1.38u as=0 ps=0 w=1u l=1u
X2774 sg13cmos5l_buf_16_3.X a_10292_4620# VPWR.t143 VPWR.t64 sg13_lv_pmos ad=0.2128p pd=1.5u as=0.2128p ps=1.5u w=1.12u l=0.13u
X2775 VGND.t76 sg13cmos5l_buf_16_3.X a_10318_5410# VGND.t77 sg13_lv_nmos ad=0.1406p pd=1.12u as=0.1406p ps=1.12u w=0.74u l=0.13u
X2776 a_4052_12934# sg13cmos5l_buf_16_18.A VPWR.t1110 VPWR.t79 sg13_lv_pmos ad=0.2128p pd=1.5u as=0.2128p ps=1.5u w=1.12u l=0.13u
X2777 VPWR.t621 sg13cmos5l_buf_16_19.A a_5204_11422# VPWR.t8 sg13_lv_pmos ad=0.2128p pd=1.5u as=0.2128p ps=1.5u w=1.12u l=0.13u
X2778 VGND.t3 sg13cmos5l_buf_1_11.X a_14824_10704# VGND.t2 sg13_lv_nmos ad=0.14875p pd=1.16u as=0.187p ps=1.78u w=0.55u l=0.13u
X2779 VGND.t797 a_3668_4620# sg13cmos5l_buf_16_8.A VGND.t824 sg13_lv_nmos ad=0.1406p pd=1.12u as=0.1406p ps=1.12u w=0.74u l=0.13u
X2780 sg13cmos5l_and2_2_6.X a_7629_8028# VGND.t15 VGND.t14 sg13_lv_nmos ad=0.1406p pd=1.12u as=0.1331p ps=1.12u w=0.74u l=0.13u
X2781 VPWR.t638 a_3668_9156# sg13cmos5l_buf_16_13.A VPWR.t5 sg13_lv_pmos ad=0.2128p pd=1.5u as=0.2128p ps=1.5u w=1.12u l=0.13u
X2782 VGND.t1298 VPWR.t117 VGND.t1298 VGND.t1299 sg13_lv_nmos ad=79.8f pd=0.8u as=0 ps=0 w=0.42u l=1u
X2783 sg13cmos5l_buf_16_1.X a_10318_5410# VPWR.t61 VPWR.t61 sg13_lv_pmos ad=0.2128p pd=1.5u as=0.2128p ps=1.5u w=1.12u l=0.13u
X2784 VGND.t457 a_4052_12934# sg13cmos5l_buf_16_15.A VGND.t615 sg13_lv_nmos ad=0.1406p pd=1.12u as=0.1406p ps=1.12u w=0.74u l=0.13u
X2785 VGND.t125 a_6094_3144# sg13cmos5l_xor2_1_0.B VGND.t40 sg13_lv_nmos ad=0.1406p pd=1.12u as=0.1406p ps=1.12u w=0.74u l=0.13u
X2786 VGND.t66 a_4436_9910# sg13cmos5l_buf_16_14.A VGND.t764 sg13_lv_nmos ad=0.1406p pd=1.12u as=0.1406p ps=1.12u w=0.74u l=0.13u
X2787 sg13cmos5l_buf_16_20.A a_5204_11422# VGND.t139 VGND.t2 sg13_lv_nmos ad=0.1406p pd=1.12u as=0.1406p ps=1.12u w=0.74u l=0.13u
X2788 a_6094_3898# enable VGND.t125 VGND.t40 sg13_lv_nmos ad=0.1406p pd=1.12u as=0.1406p ps=1.12u w=0.74u l=0.13u
X2789 sg13cmos5l_buf_16_10.A a_3694_3898# VPWR.t1527 VPWR.t64 sg13_lv_pmos ad=0.2128p pd=1.5u as=0.2128p ps=1.5u w=1.12u l=0.13u
X2790 VGND.t210 VPWR.t85 VGND.t214 VGND.t1184 sg13_lv_nmos ad=79.8f pd=0.8u as=0 ps=0 w=0.42u l=1u
X2791 VGND.t891 VPWR.t1697 VGND.t891 VGND.t903 sg13_lv_nmos ad=79.8f pd=0.8u as=0 ps=0 w=0.42u l=1u
X2792 sg13cmos5l_buf_16_13.A a_3668_9156# VPWR.t635 VPWR.t5 sg13_lv_pmos ad=0.2128p pd=1.5u as=0.3976p ps=2.95u w=1.12u l=0.13u
X2793 sg13cmos5l_buf_16_6.X a_5518_6922# VGND.t231 VGND.t541 sg13_lv_nmos ad=0.1406p pd=1.12u as=0.1406p ps=1.12u w=0.74u l=0.13u
X2794 VGND.t50 a_3694_7680# sg13cmos5l_buf_16_34.X VGND.t56 sg13_lv_nmos ad=0.1406p pd=1.12u as=0.1406p ps=1.12u w=0.74u l=0.13u
X2795 VPWR.t59 VGND.t1115 VPWR.t59 VPWR.t58 sg13_lv_pmos ad=0.19p pd=1.38u as=0 ps=0 w=1u l=1u
X2796 VGND.t597 sg13cmos5l_buf_16_37.X a_6548_13692# VGND.t1513 sg13_lv_nmos ad=0.1406p pd=1.12u as=0.1406p ps=1.12u w=0.74u l=0.13u
X2797 sg13cmos5l_buf_16_27.X a_6548_13692# VPWR.t1403 VPWR.t79 sg13_lv_pmos ad=0.2128p pd=1.5u as=0.3976p ps=2.95u w=1.12u l=0.13u
X2798 VGND.t5 a_10318_8434# sg13cmos5l_buf_16_22.X VGND.t588 sg13_lv_nmos ad=0.2516p pd=2.16u as=0.1406p ps=1.12u w=0.74u l=0.13u
X2799 VPWR.t852 a_3668_3108# sg13cmos5l_buf_16_7.A VPWR.t67 sg13_lv_pmos ad=0.2128p pd=1.5u as=0.2128p ps=1.5u w=1.12u l=0.13u
X2800 VPWR.t0 VGND.t597 VPWR.t0 VPWR.t0 sg13_lv_pmos ad=0.19p pd=1.38u as=0 ps=0 w=1u l=1u
X2801 sg13cmos5l_buf_16_15.A a_4052_12934# VPWR.t1079 VPWR.t79 sg13_lv_pmos ad=0.2128p pd=1.5u as=0.2128p ps=1.5u w=1.12u l=0.13u
X2802 VPWR.t689 sg13cmos5l_buf_16_8.A a_3694_3898# VPWR.t64 sg13_lv_pmos ad=0.2128p pd=1.5u as=0.2128p ps=1.5u w=1.12u l=0.13u
X2803 VGND.t1167 VPWR.t58 VGND.t532 VGND.t1169 sg13_lv_nmos ad=79.8f pd=0.8u as=0 ps=0 w=0.42u l=1u
X2804 VGND.t1050 VPWR.t1662 VGND.t260 VGND.t1055 sg13_lv_nmos ad=79.8f pd=0.8u as=0 ps=0 w=0.42u l=1u
X2805 VGND.t845 a_5108_838# sg13cmos5l_buf_16_5.X VGND.t1455 sg13_lv_nmos ad=0.1406p pd=1.12u as=0.1406p ps=1.12u w=0.74u l=0.13u
X2806 VPWR.t272 a_3694_8434# sg13cmos5l_buf_16_34.A VPWR.t5 sg13_lv_pmos ad=0.2128p pd=1.5u as=0.2128p ps=1.5u w=1.12u l=0.13u
X2807 VGND.t5 VPWR.t1648 VGND.t5 VGND.t1105 sg13_lv_nmos ad=79.8f pd=0.8u as=0 ps=0 w=0.42u l=1u
X2808 VPWR.t250 VGND.t1385 VPWR.t250 VPWR.t55 sg13_lv_pmos ad=0.19p pd=1.38u as=0 ps=0 w=1u l=1u
X2809 sg13cmos5l_buf_16_3.X a_10292_4620# VPWR.t143 VPWR.t64 sg13_lv_pmos ad=0.2128p pd=1.5u as=0.3976p ps=2.95u w=1.12u l=0.13u
X2810 VGND.t228 a_5518_6922# sg13cmos5l_buf_16_6.X VGND.t538 sg13_lv_nmos ad=0.1406p pd=1.12u as=0.1406p ps=1.12u w=0.74u l=0.13u
X2811 VPWR.t1182 a_6094_10704# sg13cmos5l_buf_16_24.A VPWR.t2 sg13_lv_pmos ad=0.2128p pd=1.5u as=0.2128p ps=1.5u w=1.12u l=0.13u
X2812 sg13cmos5l_buf_16_20.A a_5204_11422# VGND.t139 VGND.t2 sg13_lv_nmos ad=0.1406p pd=1.12u as=0.1406p ps=1.12u w=0.74u l=0.13u
X2813 a_10318_5410# sg13cmos5l_buf_16_3.X VPWR.t61 VPWR.t61 sg13_lv_pmos ad=0.2128p pd=1.5u as=0.2128p ps=1.5u w=1.12u l=0.13u
X2814 sg13cmos5l_buf_16_22.X a_10318_8434# VGND.t5 VGND.t585 sg13_lv_nmos ad=0.1406p pd=1.12u as=0.1406p ps=1.12u w=0.74u l=0.13u
X2815 VPWR.t55 VGND.t1274 VPWR.t55 VPWR.t55 sg13_lv_pmos ad=0.19p pd=1.38u as=0 ps=0 w=1u l=1u
X2816 sg13cmos5l_buf_16_7.A a_3668_3108# VPWR.t848 VPWR.t67 sg13_lv_pmos ad=0.2128p pd=1.5u as=0.2128p ps=1.5u w=1.12u l=0.13u
X2817 VGND.t5 sg13cmos5l_and2_2_5.B a_11659_8028# VGND.t662 sg13_lv_nmos ad=0.1331p pd=1.12u as=0.1216p ps=1.02u w=0.64u l=0.13u
X2818 a_5518_6922# sg13cmos5l_buf_16_28.X VPWR.t1099 VPWR.t58 sg13_lv_pmos ad=0.2128p pd=1.5u as=0.2128p ps=1.5u w=1.12u l=0.13u
X2819 a_2377_14076# sg13cmos5l_and2_2_1.B VGND.t895 VGND.t1433 sg13_lv_nmos ad=0.1216p pd=1.02u as=0.1331p ps=1.12u w=0.64u l=0.13u
X2820 VGND.t41 VPWR.t113 VGND.t302 VGND.t40 sg13_lv_nmos ad=0.1428p pd=1.52u as=0 ps=0 w=0.42u l=1u
X2821 VPWR.t56 VGND.t198 VPWR.t56 VPWR.t55 sg13_lv_pmos ad=0.34p pd=2.68u as=0 ps=0 w=1u l=1u
X2822 VGND.t1298 VPWR.t63 VGND.t1298 VGND.t1332 sg13_lv_nmos ad=79.8f pd=0.8u as=0 ps=0 w=0.42u l=1u
X2823 sg13cmos5l_buf_16_39.A a_8494_3144# VPWR.t216 VPWR.t67 sg13_lv_pmos ad=0.2128p pd=1.5u as=0.2128p ps=1.5u w=1.12u l=0.13u
X2824 a_4462_5410# sg13cmos5l_and2_2_0.X VGND.t801 VGND.t802 sg13_lv_nmos ad=0.1406p pd=1.12u as=0.1406p ps=1.12u w=0.74u l=0.13u
X2825 VPWR.t131 sg13cmos5l_xor2_1_7.X a_14344_11492# VPWR.t8 sg13_lv_pmos ad=0.2114p pd=1.54u as=0.2856p ps=2.36u w=0.84u l=0.13u
X2826 sg13cmos5l_buf_16_6.X a_5518_6922# VGND.t218 VGND.t535 sg13_lv_nmos ad=0.1406p pd=1.12u as=0.1406p ps=1.12u w=0.74u l=0.13u
X2827 VGND.t891 a_6548_13692# sg13cmos5l_buf_16_27.X VGND.t1478 sg13_lv_nmos ad=0.1406p pd=1.12u as=0.1406p ps=1.12u w=0.74u l=0.13u
X2828 VPWR.t146 VGND.t1061 VPWR.t146 VPWR.t5 sg13_lv_pmos ad=0.34p pd=2.68u as=0 ps=0 w=1u l=1u
X2829 sg13cmos5l_buf_16_15.A a_4052_12934# VPWR.t1076 VPWR.t79 sg13_lv_pmos ad=0.2128p pd=1.5u as=0.3976p ps=2.95u w=1.12u l=0.13u
X2830 sg13cmos5l_and2_2_0.X a_3875_5396# VGND.t797 VGND.t807 sg13_lv_nmos ad=0.1406p pd=1.12u as=0.2812p ps=2.24u w=0.74u l=0.13u
X2831 sg13cmos5l_buf_16_3.X a_10292_4620# VGND.t86 VGND.t91 sg13_lv_nmos ad=0.1406p pd=1.12u as=0.1406p ps=1.12u w=0.74u l=0.13u
X2832 VPWR.t1356 sg13cmos5l_buf_16_33.A a_6094_10704# VPWR.t2 sg13_lv_pmos ad=0.2128p pd=1.5u as=0.2128p ps=1.5u w=1.12u l=0.13u
X2833 VGND.t924 VPWR.t1012 VGND.t924 VGND.t923 sg13_lv_nmos ad=0.1428p pd=1.52u as=0 ps=0 w=0.42u l=1u
X2834 sg13cmos5l_buf_1_5.X a_13768_5444# VPWR.t62 VPWR.t61 sg13_lv_pmos ad=0.42p pd=2.99u as=0.2114p ps=1.54u w=1.12u l=0.13u
X2835 VGND.t797 sg13cmos5l_and2_2_0.X a_4462_5410# VGND.t798 sg13_lv_nmos ad=0.1406p pd=1.12u as=0.1406p ps=1.12u w=0.74u l=0.13u
X2836 VPWR.t131 sg13cmos5l_buf_1_15.X a_13916_11752# VPWR.t8 sg13_lv_pmos ad=0.2128p pd=1.5u as=0.3808p ps=2.92u w=1.12u l=0.13u
X2837 sg13cmos5l_buf_16_19.A a_6765_12564# VGND.t682 VGND.t708 sg13_lv_nmos ad=0.1406p pd=1.12u as=0.1331p ps=1.12u w=0.74u l=0.13u
X2838 VPWR.t1483 VGND.t1274 VPWR.t1482 VPWR.t67 sg13_lv_pmos ad=0.34p pd=2.68u as=0 ps=0 w=1u l=1u
X2839 VGND.t41 VPWR.t120 VGND.t41 VGND.t40 sg13_lv_nmos ad=0.1428p pd=1.52u as=0 ps=0 w=0.42u l=1u
X2840 a_6129_9192# sg13cmos5l_buf_16_14.A VPWR.t311 VPWR.t5 sg13_lv_pmos ad=0.1225p pd=1.245u as=0.36p ps=2.72u w=1u l=0.13u
X2841 VPWR.t99 VGND.t1274 VPWR.t99 VPWR.t55 sg13_lv_pmos ad=0.34p pd=2.68u as=0 ps=0 w=1u l=1u
X2842 VGND.t86 a_10292_4620# sg13cmos5l_buf_16_3.X VGND.t88 sg13_lv_nmos ad=0.1406p pd=1.12u as=0.1406p ps=1.12u w=0.74u l=0.13u
X2843 VGND.t1010 VPWR.t430 VGND.t1010 VGND.t2 sg13_lv_nmos ad=79.8f pd=0.8u as=0 ps=0 w=0.42u l=1u
X2844 VGND.t214 VPWR.t91 VGND.t214 VGND.t1160 sg13_lv_nmos ad=79.8f pd=0.8u as=0 ps=0 w=0.42u l=1u
X2845 VPWR.t59 VGND.t1162 VPWR.t93 VPWR.t58 sg13_lv_pmos ad=0.19p pd=1.38u as=0 ps=0 w=1u l=1u
X2846 a_3694_2386# sg13cmos5l_buf_16_7.A VGND.t194 VGND.t196 sg13_lv_nmos ad=0.1406p pd=1.12u as=0.1406p ps=1.12u w=0.74u l=0.13u
X2847 VGND.t1298 VPWR.t120 VGND.t1298 VGND.t1301 sg13_lv_nmos ad=79.8f pd=0.8u as=0 ps=0 w=0.42u l=1u
X2848 VPWR.t120 VGND.t1298 VPWR.t117 VPWR.t67 sg13_lv_pmos ad=0.19p pd=1.38u as=0 ps=0 w=1u l=1u
X2849 a_8564_2680# a_8538_2578# sg13cmos5l_buf_1_2.A VPWR.t67 sg13_lv_pmos ad=0.2128p pd=1.5u as=0.3808p ps=2.92u w=1.12u l=0.13u
X2850 a_6094_3144# sg13cmos5l_buf_16_5.X VGND.t125 VGND.t40 sg13_lv_nmos ad=0.1406p pd=1.12u as=0.1406p ps=1.12u w=0.74u l=0.13u
X2851 a_3668_12180# sg13cmos5l_buf_16_15.A VPWR.t1165 VPWR.t8 sg13_lv_pmos ad=0.2128p pd=1.5u as=0.2128p ps=1.5u w=1.12u l=0.13u
X2852 sg13cmos5l_buf_16_14.A a_4436_9910# VGND.t66 VGND.t757 sg13_lv_nmos ad=0.1406p pd=1.12u as=0.1406p ps=1.12u w=0.74u l=0.13u
X2853 VPWR.t543 VGND.t942 VPWR.t542 VPWR.t8 sg13_lv_pmos ad=0.34p pd=2.68u as=0 ps=0 w=1u l=1u
X2854 sg13cmos5l_buf_16_2.X a_10318_3898# VPWR.t143 VPWR.t64 sg13_lv_pmos ad=0.2128p pd=1.5u as=0.2128p ps=1.5u w=1.12u l=0.13u
X2855 VPWR.t110 VGND.t637 VPWR.t110 VPWR.t64 sg13_lv_pmos ad=0.19p pd=1.38u as=0 ps=0 w=1u l=1u
X2856 VPWR.t791 sg13cmos5l_and2_2_0.X a_4462_5410# VPWR.t61 sg13_lv_pmos ad=0.2128p pd=1.5u as=0.2128p ps=1.5u w=1.12u l=0.13u
X2857 VGND.t942 VPWR.t1688 VGND.t948 VGND.t947 sg13_lv_nmos ad=79.8f pd=0.8u as=0 ps=0 w=0.42u l=1u
X2858 a_7796_12934# sg13cmos5l_buf_16_37.A VGND.t590 VGND.t592 sg13_lv_nmos ad=0.1406p pd=1.12u as=0.1406p ps=1.12u w=0.74u l=0.13u
X2859 VPWR.t61 VGND.t210 VPWR.t61 VPWR.t61 sg13_lv_pmos ad=0.19p pd=1.38u as=0 ps=0 w=1u l=1u
X2860 VGND.t597 VPWR.t47 VGND.t597 VGND.t908 sg13_lv_nmos ad=79.8f pd=0.8u as=0 ps=0 w=0.42u l=1u
X2861 sg13cmos5l_buf_16_3.X a_10292_4620# VGND.t76 VGND.t84 sg13_lv_nmos ad=0.1406p pd=1.12u as=0.1406p ps=1.12u w=0.74u l=0.13u
X2862 VGND.t1286 VPWR.t216 VGND.t1286 VGND.t1285 sg13_lv_nmos ad=0.1428p pd=1.52u as=0 ps=0 w=0.42u l=1u
X2863 VGND.t726 VPWR.t1671 VGND.t726 VGND.t2 sg13_lv_nmos ad=0.1428p pd=1.52u as=0 ps=0 w=0.42u l=1u
X2864 a_5710_1632# sg13cmos5l_buf_16_30.A VGND.t198 VGND.t835 sg13_lv_nmos ad=0.1406p pd=1.12u as=0.1406p ps=1.12u w=0.74u l=0.13u
X2865 VGND.t202 glitch_en[4] a_11272_13728# VGND.t1474 sg13_lv_nmos ad=0.14875p pd=1.16u as=0.187p ps=1.78u w=0.55u l=0.13u
X2866 VGND.t590 VPWR.t16 VGND.t590 VGND.t973 sg13_lv_nmos ad=79.8f pd=0.8u as=0 ps=0 w=0.42u l=1u
X2867 a_13745_11508# sg13cmos5l_and2_2_3.X a_13713_11776# VPWR.t8 sg13_lv_pmos ad=0.34p pd=2.68u as=0.1225p ps=1.245u w=1u l=0.13u
X2868 VPWR.t143 a_10318_3898# sg13cmos5l_buf_16_2.X VPWR.t64 sg13_lv_pmos ad=0.2128p pd=1.5u as=0.2128p ps=1.5u w=1.12u l=0.13u
X2869 sg13cmos5l_buf_16_28.X a_5684_6132# VGND.t228 VGND.t229 sg13_lv_nmos ad=0.1406p pd=1.12u as=0.1406p ps=1.12u w=0.74u l=0.13u
X2870 VPWR.t146 sg13cmos5l_and2_2_6.X a_6836_9156# VPWR.t5 sg13_lv_pmos ad=0.2128p pd=1.5u as=0.2128p ps=1.5u w=1.12u l=0.13u
X2871 VGND.t1373 VPWR.t205 VGND.t1375 VGND.t1374 sg13_lv_nmos ad=79.8f pd=0.8u as=0 ps=0 w=0.42u l=1u
X2872 VGND.t76 VPWR.t143 VGND.t76 VGND.t1226 sg13_lv_nmos ad=0.1428p pd=1.52u as=0 ps=0 w=0.42u l=1u
X2873 VPWR.t1204 a_3694_10704# sg13cmos5l_and2_2_6.A VPWR.t2 sg13_lv_pmos ad=0.2128p pd=1.5u as=0.2128p ps=1.5u w=1.12u l=0.13u
X2874 VGND.t260 VPWR.t1661 VGND.t260 VGND.t1057 sg13_lv_nmos ad=79.8f pd=0.8u as=0 ps=0 w=0.42u l=1u
X2875 VGND.t870 a_3694_14482# sg13cmos5l_buf_16_33.A VGND.t882 sg13_lv_nmos ad=0.1406p pd=1.12u as=0.1406p ps=1.12u w=0.74u l=0.13u
X2876 VPWR.t66 VGND.t310 VPWR.t65 VPWR.t64 sg13_lv_pmos ad=0.19p pd=1.38u as=0 ps=0 w=1u l=1u
X2877 VGND.t1107 VPWR.t1647 VGND.t18 VGND.t1108 sg13_lv_nmos ad=79.8f pd=0.8u as=0 ps=0 w=0.42u l=1u
R0 VPWR.n182 VPWR.t682 17.2247
R1 VPWR.n42 VPWR.t312 17.2247
R2 VPWR.n360 VPWR.t1095 17.2247
R3 VPWR.n484 VPWR.t1 17.2247
R4 VPWR.n464 VPWR.t1351 17.2247
R5 VPWR.n479 VPWR.t1300 17.2247
R6 VPWR.n494 VPWR.t1348 17.2247
R7 VPWR.t67 VPWR.n74 17.0005
R8 VPWR.t67 VPWR.n968 17.0005
R9 VPWR.t67 VPWR.n75 17.0005
R10 VPWR.t67 VPWR.n965 17.0005
R11 VPWR.t67 VPWR.n76 17.0005
R12 VPWR.t67 VPWR.n962 17.0005
R13 VPWR.t67 VPWR.n77 17.0005
R14 VPWR.t67 VPWR.n959 17.0005
R15 VPWR.t67 VPWR.n78 17.0005
R16 VPWR.t67 VPWR.n956 17.0005
R17 VPWR.t67 VPWR.n79 17.0005
R18 VPWR.t67 VPWR.n953 17.0005
R19 VPWR.t67 VPWR.n82 17.0005
R20 VPWR.t67 VPWR.n950 17.0005
R21 VPWR.t67 VPWR.n83 17.0005
R22 VPWR.t67 VPWR.n947 17.0005
R23 VPWR.t67 VPWR.n84 17.0005
R24 VPWR.t67 VPWR.n944 17.0005
R25 VPWR.t67 VPWR.n85 17.0005
R26 VPWR.t67 VPWR.n941 17.0005
R27 VPWR.t67 VPWR.n86 17.0005
R28 VPWR.t67 VPWR.n938 17.0005
R29 VPWR.t67 VPWR.n87 17.0005
R30 VPWR.t67 VPWR.n101 17.0005
R31 VPWR.t67 VPWR.n915 17.0005
R32 VPWR.t64 VPWR.n56 5.64879
R33 VPWR.t64 VPWR.n37 17.0005
R34 VPWR.n908 VPWR.t64 17.0005
R35 VPWR.t61 VPWR.n171 17.0005
R36 VPWR.t61 VPWR.n233 17.0005
R37 VPWR.t61 VPWR.n172 17.0005
R38 VPWR.t61 VPWR.n230 17.0005
R39 VPWR.t61 VPWR.n173 17.0005
R40 VPWR.t61 VPWR.n227 17.0005
R41 VPWR.t61 VPWR.n174 17.0005
R42 VPWR.t61 VPWR.n224 17.0005
R43 VPWR.t61 VPWR.n175 17.0005
R44 VPWR.t61 VPWR.n221 17.0005
R45 VPWR.t61 VPWR.n176 17.0005
R46 VPWR.t61 VPWR.n218 17.0005
R47 VPWR.t61 VPWR.n177 17.0005
R48 VPWR.t61 VPWR.n215 17.0005
R49 VPWR.t61 VPWR.n178 17.0005
R50 VPWR.t61 VPWR.n126 17.0005
R51 VPWR.t61 VPWR.n35 17.0005
R52 VPWR.n826 VPWR.t61 17.0005
R53 VPWR.t58 VPWR.n3 0.955419
R54 VPWR.t58 VPWR.n30 3.31609
R55 VPWR.n30 VPWR.n29 0.0709887
R56 VPWR.t58 VPWR.n765 17.0005
R57 VPWR.t58 VPWR.n744 17.0005
R58 VPWR.n34 VPWR.n33 0.119913
R59 VPWR.t58 VPWR.n759 17.0005
R60 VPWR.t58 VPWR.n59 5.64741
R61 VPWR.n18 VPWR.n17 0.207922
R62 VPWR.t58 VPWR.n823 17.0005
R63 VPWR.t58 VPWR.n784 17.0005
R64 VPWR.t58 VPWR.n787 17.0005
R65 VPWR.t58 VPWR.n812 17.0005
R66 VPWR.t5 VPWR.n5 1.00641
R67 VPWR.t5 VPWR.n735 17.0005
R68 VPWR.t5 VPWR.n235 17.0005
R69 VPWR.t5 VPWR.n732 17.0005
R70 VPWR.t5 VPWR.n236 17.0005
R71 VPWR.t5 VPWR.n726 17.0005
R72 VPWR.t5 VPWR.n237 17.0005
R73 VPWR.t5 VPWR.n724 17.0005
R74 VPWR.t5 VPWR.n238 17.0005
R75 VPWR.t5 VPWR.n721 17.0005
R76 VPWR.t5 VPWR.n239 17.0005
R77 VPWR.t5 VPWR.n718 17.0005
R78 VPWR.t5 VPWR.n240 17.0005
R79 VPWR.t5 VPWR.n715 17.0005
R80 VPWR.t5 VPWR.n241 17.0005
R81 VPWR.t5 VPWR.n712 17.0005
R82 VPWR.t5 VPWR.n244 17.0005
R83 VPWR.t5 VPWR.n258 17.0005
R84 VPWR.t5 VPWR.n688 17.0005
R85 VPWR.t2 VPWR.n671 17.0005
R86 VPWR.t2 VPWR.n574 17.0005
R87 VPWR.t2 VPWR.n669 17.0005
R88 VPWR.t2 VPWR.n575 17.0005
R89 VPWR.t2 VPWR.n666 17.0005
R90 VPWR.t2 VPWR.n576 17.0005
R91 VPWR.t2 VPWR.n663 17.0005
R92 VPWR.t2 VPWR.n599 17.0005
R93 VPWR.t2 VPWR.n660 17.0005
R94 VPWR.t2 VPWR.n600 17.0005
R95 VPWR.t2 VPWR.n657 17.0005
R96 VPWR.t2 VPWR.n601 17.0005
R97 VPWR.t2 VPWR.n654 17.0005
R98 VPWR.t2 VPWR.n602 17.0005
R99 VPWR.t2 VPWR.n603 17.0005
R100 VPWR.t2 VPWR.n636 17.0005
R101 VPWR.t2 VPWR.n572 17.0005
R102 VPWR.n682 VPWR.t2 17.0005
R103 VPWR.t8 VPWR.n287 17.0005
R104 VPWR.t8 VPWR.n356 17.0005
R105 VPWR.t8 VPWR.n288 17.0005
R106 VPWR.t8 VPWR.n353 17.0005
R107 VPWR.t8 VPWR.n289 17.0005
R108 VPWR.t8 VPWR.n350 17.0005
R109 VPWR.t8 VPWR.n290 17.0005
R110 VPWR.t8 VPWR.n347 17.0005
R111 VPWR.t8 VPWR.n291 17.0005
R112 VPWR.t8 VPWR.n344 17.0005
R113 VPWR.t8 VPWR.n292 17.0005
R114 VPWR.t8 VPWR.n336 17.0005
R115 VPWR.t8 VPWR.n334 17.0005
R116 VPWR.t8 VPWR.n299 17.0005
R117 VPWR.t8 VPWR.n282 17.0005
R118 VPWR.n569 VPWR.t8 17.0005
R119 VPWR.t79 VPWR.n404 17.0005
R120 VPWR.t79 VPWR.n405 17.0005
R121 VPWR.t79 VPWR.n553 17.0005
R122 VPWR.t79 VPWR.n406 17.0005
R123 VPWR.t79 VPWR.n550 17.0005
R124 VPWR.t79 VPWR.n407 17.0005
R125 VPWR.t79 VPWR.n547 17.0005
R126 VPWR.t79 VPWR.n408 17.0005
R127 VPWR.t79 VPWR.n544 17.0005
R128 VPWR.t79 VPWR.n409 17.0005
R129 VPWR.t79 VPWR.n541 17.0005
R130 VPWR.t79 VPWR.n410 17.0005
R131 VPWR.t79 VPWR.n538 17.0005
R132 VPWR.t79 VPWR.n411 17.0005
R133 VPWR.t79 VPWR.n535 17.0005
R134 VPWR.t79 VPWR.n414 17.0005
R135 VPWR.t79 VPWR.n532 17.0005
R136 VPWR.t79 VPWR.n415 17.0005
R137 VPWR.t79 VPWR.n529 17.0005
R138 VPWR.t79 VPWR.n416 17.0005
R139 VPWR.t79 VPWR.n526 17.0005
R140 VPWR.t79 VPWR.n417 17.0005
R141 VPWR.t79 VPWR.n523 17.0005
R142 VPWR.t79 VPWR.n418 17.0005
R143 VPWR.t79 VPWR.n520 17.0005
R144 VPWR.t79 VPWR.n419 17.0005
R145 VPWR.t79 VPWR.n514 17.0005
R146 VPWR.n25 VPWR.n24 0.169602
R147 VPWR.n14 VPWR.n13 0.182353
R148 VPWR.t79 VPWR.n426 17.0005
R149 VPWR.t79 VPWR.n442 17.0005
R150 VPWR.t79 VPWR.n427 17.0005
R151 VPWR.t79 VPWR.n439 17.0005
R152 VPWR.t79 VPWR.n23 3.28357
R153 VPWR.n212 VPWR.t1624 15.2621
R154 VPWR.n777 VPWR.t1637 15.2621
R155 VPWR.n512 VPWR.t1686 15.2621
R156 VPWR.n481 VPWR.t1696 15.2621
R157 VPWR.n189 VPWR.t1629 15.2617
R158 VPWR.n21 VPWR.t1693 15.2617
R159 VPWR.n976 VPWR.n64 9.0005
R160 VPWR.n911 VPWR.n64 9.0005
R161 VPWR.n508 VPWR.n506 9.0005
R162 VPWR.n510 VPWR.n504 9.0005
R163 VPWR.n567 VPWR.n381 9.0005
R164 VPWR.n563 VPWR.n381 9.0005
R165 VPWR.n68 VPWR.n67 9.0005
R166 VPWR.n972 VPWR.n971 9.0005
R167 VPWR.n15 VPWR.t896 8.79392
R168 VPWR.n40 VPWR.t907 8.78742
R169 VPWR.n821 VPWR.t211 8.78642
R170 VPWR.n17 VPWR.t890 8.78642
R171 VPWR.n638 VPWR.t553 8.78642
R172 VPWR.n332 VPWR.t814 8.78642
R173 VPWR.n50 VPWR.t820 8.78642
R174 VPWR.n444 VPWR.t1435 8.78642
R175 VPWR.n555 VPWR.t1404 8.78642
R176 VPWR.n54 VPWR.t1410 8.78642
R177 VPWR.n963 VPWR.t221 8.76154
R178 VPWR.n960 VPWR.t219 8.76154
R179 VPWR.n957 VPWR.t218 8.76154
R180 VPWR.n954 VPWR.t1555 8.76154
R181 VPWR.n951 VPWR.t1553 8.76154
R182 VPWR.n81 VPWR.t1551 8.76154
R183 VPWR.n949 VPWR.t1549 8.76154
R184 VPWR.n946 VPWR.t1547 8.76154
R185 VPWR.n940 VPWR.t1543 8.76154
R186 VPWR.n95 VPWR.t561 8.76154
R187 VPWR.n93 VPWR.t563 8.76154
R188 VPWR.n91 VPWR.t565 8.76154
R189 VPWR.n89 VPWR.t1579 8.76154
R190 VPWR.n921 VPWR.t1581 8.76154
R191 VPWR.n923 VPWR.t1583 8.76154
R192 VPWR.n925 VPWR.t1585 8.76154
R193 VPWR.n927 VPWR.t1587 8.76154
R194 VPWR.n931 VPWR.t1591 8.76154
R195 VPWR.n886 VPWR.t685 8.76154
R196 VPWR.n888 VPWR.t687 8.76154
R197 VPWR.n890 VPWR.t689 8.76154
R198 VPWR.n892 VPWR.t1527 8.76154
R199 VPWR.n893 VPWR.t1529 8.76154
R200 VPWR.n852 VPWR.t1531 8.76154
R201 VPWR.n850 VPWR.t1533 8.76154
R202 VPWR.n848 VPWR.t1535 8.76154
R203 VPWR.n844 VPWR.t1539 8.76154
R204 VPWR.n838 VPWR.t1424 8.76154
R205 VPWR.n836 VPWR.t1426 8.76154
R206 VPWR.n834 VPWR.t739 8.76154
R207 VPWR.n832 VPWR.t740 8.76154
R208 VPWR.n895 VPWR.t742 8.76154
R209 VPWR.n897 VPWR.t744 8.76154
R210 VPWR.n899 VPWR.t746 8.76154
R211 VPWR.n901 VPWR.t748 8.76154
R212 VPWR.n905 VPWR.t752 8.76154
R213 VPWR.n164 VPWR.t1266 8.76154
R214 VPWR.n162 VPWR.t1269 8.76154
R215 VPWR.n205 VPWR.t804 8.76154
R216 VPWR.n199 VPWR.t800 8.76154
R217 VPWR.n196 VPWR.t798 8.76154
R218 VPWR.n193 VPWR.t796 8.76154
R219 VPWR.n191 VPWR.t794 8.76154
R220 VPWR.n180 VPWR.t792 8.76154
R221 VPWR.n183 VPWR.t791 8.76154
R222 VPWR.n185 VPWR.t1263 8.76154
R223 VPWR.n188 VPWR.t1261 8.76154
R224 VPWR.t153 VPWR.t719 8.76154
R225 VPWR.n168 VPWR.t717 8.76154
R226 VPWR.n231 VPWR.t715 8.76154
R227 VPWR.n228 VPWR.t713 8.76154
R228 VPWR.n225 VPWR.t711 8.76154
R229 VPWR.n219 VPWR.t707 8.76154
R230 VPWR.n745 VPWR.t906 8.76154
R231 VPWR.n749 VPWR.t1101 8.76154
R232 VPWR.n752 VPWR.t1099 8.76154
R233 VPWR.n33 VPWR.t913 8.76154
R234 VPWR.n762 VPWR.t911 8.76154
R235 VPWR.n758 VPWR.t909 8.76154
R236 VPWR.n768 VPWR.t919 8.76154
R237 VPWR.n31 VPWR.t915 8.76154
R238 VPWR.n252 VPWR.t419 8.76154
R239 VPWR.n250 VPWR.t421 8.76154
R240 VPWR.n248 VPWR.t261 8.76154
R241 VPWR.n246 VPWR.t262 8.76154
R242 VPWR.n694 VPWR.t264 8.76154
R243 VPWR.n696 VPWR.t266 8.76154
R244 VPWR.n698 VPWR.t268 8.76154
R245 VPWR.n700 VPWR.t270 8.76154
R246 VPWR.n704 VPWR.t274 8.76154
R247 VPWR.n733 VPWR.t667 8.76154
R248 VPWR.n730 VPWR.t665 8.76154
R249 VPWR.n728 VPWR.t663 8.76154
R250 VPWR.n725 VPWR.t661 8.76154
R251 VPWR.n723 VPWR.t659 8.76154
R252 VPWR.n720 VPWR.t656 8.76154
R253 VPWR.n717 VPWR.t654 8.76154
R254 VPWR.n714 VPWR.t652 8.76154
R255 VPWR.n681 VPWR.t838 8.76154
R256 VPWR.n677 VPWR.t836 8.76154
R257 VPWR.n674 VPWR.t834 8.76154
R258 VPWR.n670 VPWR.t832 8.76154
R259 VPWR.n668 VPWR.t830 8.76154
R260 VPWR.n665 VPWR.t634 8.76154
R261 VPWR.n662 VPWR.t632 8.76154
R262 VPWR.n579 VPWR.t630 8.76154
R263 VPWR.n593 VPWR.t1226 8.76154
R264 VPWR.n596 VPWR.t1224 8.76154
R265 VPWR.n658 VPWR.t1222 8.76154
R266 VPWR.n655 VPWR.t1220 8.76154
R267 VPWR.n652 VPWR.t1218 8.76154
R268 VPWR.n648 VPWR.t1214 8.76154
R269 VPWR.n590 VPWR.t1175 8.76154
R270 VPWR.n588 VPWR.t1176 8.76154
R271 VPWR.n586 VPWR.t1178 8.76154
R272 VPWR.t25 VPWR.t842 8.76154
R273 VPWR.n371 VPWR.t623 8.76154
R274 VPWR.n368 VPWR.t621 8.76154
R275 VPWR.n365 VPWR.t497 8.76154
R276 VPWR.n362 VPWR.t495 8.76154
R277 VPWR.n359 VPWR.t493 8.76154
R278 VPWR.n357 VPWR.t491 8.76154
R279 VPWR.n355 VPWR.t489 8.76154
R280 VPWR.n352 VPWR.t487 8.76154
R281 VPWR.n346 VPWR.t483 8.76154
R282 VPWR.n386 VPWR.t1155 8.76154
R283 VPWR.n388 VPWR.t1153 8.76154
R284 VPWR.n391 VPWR.t1151 8.76154
R285 VPWR.n397 VPWR.t1147 8.76154
R286 VPWR.n546 VPWR.t1110 8.76154
R287 VPWR.n543 VPWR.t1108 8.76154
R288 VPWR.n540 VPWR.t1091 8.76154
R289 VPWR.n537 VPWR.t1089 8.76154
R290 VPWR.n534 VPWR.t1087 8.76154
R291 VPWR.n530 VPWR.t1085 8.76154
R292 VPWR.n527 VPWR.t1083 8.76154
R293 VPWR.n524 VPWR.t1081 8.76154
R294 VPWR.n518 VPWR.t1077 8.76154
R295 VPWR.n452 VPWR.t1345 8.76154
R296 VPWR.n448 VPWR.t1341 8.76154
R297 VPWR.n446 VPWR.t1339 8.76154
R298 VPWR.n466 VPWR.t1337 8.76154
R299 VPWR.n468 VPWR.t1335 8.76154
R300 VPWR.n470 VPWR.t1333 8.76154
R301 VPWR.n472 VPWR.t1330 8.76154
R302 VPWR.n474 VPWR.t1328 8.76154
R303 VPWR.n476 VPWR.t1326 8.76154
R304 VPWR.n95 VPWR.t846 8.76054
R305 VPWR.n91 VPWR.t850 8.76054
R306 VPWR.n89 VPWR.t852 8.76054
R307 VPWR.n921 VPWR.t854 8.76054
R308 VPWR.n923 VPWR.t856 8.76054
R309 VPWR.n925 VPWR.t858 8.76054
R310 VPWR.n927 VPWR.t468 8.76054
R311 VPWR.n929 VPWR.t469 8.76054
R312 VPWR.n931 VPWR.t471 8.76054
R313 VPWR.n936 VPWR.t475 8.76054
R314 VPWR.n939 VPWR.t477 8.76054
R315 VPWR.n942 VPWR.t479 8.76054
R316 VPWR.n945 VPWR.t757 8.76054
R317 VPWR.n948 VPWR.t759 8.76054
R318 VPWR.n952 VPWR.t761 8.76054
R319 VPWR.n955 VPWR.t763 8.76054
R320 VPWR.n958 VPWR.t765 8.76054
R321 VPWR.n964 VPWR.t769 8.76054
R322 VPWR.t217 VPWR.t330 8.76054
R323 VPWR.n886 VPWR.t1277 8.76054
R324 VPWR.n890 VPWR.t1281 8.76054
R325 VPWR.n892 VPWR.t1283 8.76054
R326 VPWR.n893 VPWR.t1285 8.76054
R327 VPWR.n852 VPWR.t1287 8.76054
R328 VPWR.n850 VPWR.t1289 8.76054
R329 VPWR.n848 VPWR.t1291 8.76054
R330 VPWR.n846 VPWR.t1573 8.76054
R331 VPWR.n844 VPWR.t1575 8.76054
R332 VPWR.n838 VPWR.t1271 8.76054
R333 VPWR.n836 VPWR.t1273 8.76054
R334 VPWR.n834 VPWR.t723 8.76054
R335 VPWR.n832 VPWR.t724 8.76054
R336 VPWR.n895 VPWR.t726 8.76054
R337 VPWR.n897 VPWR.t728 8.76054
R338 VPWR.n899 VPWR.t730 8.76054
R339 VPWR.n901 VPWR.t732 8.76054
R340 VPWR.n905 VPWR.t736 8.76054
R341 VPWR.n197 VPWR.t578 8.76054
R342 VPWR.n203 VPWR.t582 8.76054
R343 VPWR.n206 VPWR.t584 8.76054
R344 VPWR.n209 VPWR.t586 8.76054
R345 VPWR.n214 VPWR.t588 8.76054
R346 VPWR.n217 VPWR.t590 8.76054
R347 VPWR.n220 VPWR.t592 8.76054
R348 VPWR.n223 VPWR.t1255 8.76054
R349 VPWR.n226 VPWR.t1257 8.76054
R350 VPWR.n170 VPWR.t149 8.76054
R351 VPWR.n167 VPWR.t151 8.76054
R352 VPWR.n782 VPWR.t213 8.76054
R353 VPWR.n778 VPWR.t215 8.76054
R354 VPWR.n17 VPWR.t892 8.76054
R355 VPWR.n17 VPWR.t894 8.76054
R356 VPWR.n757 VPWR.t898 8.76054
R357 VPWR.n751 VPWR.t902 8.76054
R358 VPWR.n770 VPWR.t789 8.76054
R359 VPWR.n27 VPWR.t154 8.76054
R360 VPWR.n252 VPWR.t636 8.76054
R361 VPWR.n248 VPWR.t640 8.76054
R362 VPWR.n246 VPWR.t642 8.76054
R363 VPWR.n694 VPWR.t644 8.76054
R364 VPWR.n696 VPWR.t646 8.76054
R365 VPWR.n698 VPWR.t648 8.76054
R366 VPWR.n700 VPWR.t305 8.76054
R367 VPWR.n702 VPWR.t306 8.76054
R368 VPWR.n704 VPWR.t308 8.76054
R369 VPWR.n713 VPWR.t501 8.76054
R370 VPWR.n719 VPWR.t505 8.76054
R371 VPWR.n722 VPWR.t507 8.76054
R372 VPWR.n727 VPWR.t509 8.76054
R373 VPWR.n731 VPWR.t511 8.76054
R374 VPWR.n734 VPWR.t513 8.76054
R375 VPWR.t146 VPWR.t515 8.76054
R376 VPWR.n640 VPWR.t555 8.76054
R377 VPWR.n643 VPWR.t557 8.76054
R378 VPWR.n646 VPWR.t1198 8.76054
R379 VPWR.n649 VPWR.t1200 8.76054
R380 VPWR.n653 VPWR.t1202 8.76054
R381 VPWR.n656 VPWR.t1204 8.76054
R382 VPWR.n659 VPWR.t1206 8.76054
R383 VPWR.n595 VPWR.t1210 8.76054
R384 VPWR.n588 VPWR.t1354 8.76054
R385 VPWR.n586 VPWR.t1356 8.76054
R386 VPWR.n584 VPWR.t1181 8.76054
R387 VPWR.n581 VPWR.t1182 8.76054
R388 VPWR.n578 VPWR.t1184 8.76054
R389 VPWR.n661 VPWR.t1186 8.76054
R390 VPWR.n664 VPWR.t1188 8.76054
R391 VPWR.n667 VPWR.t1190 8.76054
R392 VPWR.n675 VPWR.t1194 8.76054
R393 VPWR.n293 VPWR.t818 8.76054
R394 VPWR.n335 VPWR.t822 8.76054
R395 VPWR.n339 VPWR.t824 8.76054
R396 VPWR.n340 VPWR.t826 8.76054
R397 VPWR.n342 VPWR.t828 8.76054
R398 VPWR.n345 VPWR.t1163 8.76054
R399 VPWR.n348 VPWR.t1165 8.76054
R400 VPWR.n364 VPWR.t1096 8.76054
R401 VPWR.n367 VPWR.t1172 8.76054
R402 VPWR.n52 VPWR.t1412 8.76054
R403 VPWR.n401 VPWR.t1414 8.76054
R404 VPWR.n398 VPWR.t1416 8.76054
R405 VPWR.n395 VPWR.t1418 8.76054
R406 VPWR.n392 VPWR.t1438 8.76054
R407 VPWR.n389 VPWR.t1440 8.76054
R408 VPWR.n440 VPWR.t1359 8.76054
R409 VPWR.n522 VPWR.t1395 8.76054
R410 VPWR.n525 VPWR.t1397 8.76054
R411 VPWR.n528 VPWR.t1361 8.76054
R412 VPWR.n531 VPWR.t1362 8.76054
R413 VPWR.n413 VPWR.t1364 8.76054
R414 VPWR.n533 VPWR.t1366 8.76054
R415 VPWR.n536 VPWR.t1368 8.76054
R416 VPWR.n539 VPWR.t1370 8.76054
R417 VPWR.n545 VPWR.t1374 8.76054
R418 VPWR.n561 VPWR.t1408 8.76054
R419 VPWR.t61 VPWR.n36 0.446285
R420 VPWR.t55 VPWR.n57 0.381354
R421 VPWR.t58 VPWR.t905 0.755074
R422 VPWR.t410 VPWR.n56 0.0296542
R423 VPWR.n58 VPWR.t61 5.64741
R424 VPWR.n15 VPWR.n59 0.0317231
R425 VPWR.n61 VPWR.t0 5.64879
R426 VPWR.n62 VPWR.t78 0.266785
R427 VPWR.t1012 VPWR.n63 0.280345
R428 VPWR.n41 VPWR.n40 0.0341352
R429 VPWR.n45 VPWR.n44 0.0341352
R430 VPWR.n48 VPWR.n47 0.0341352
R431 VPWR.n51 VPWR.n50 0.0341352
R432 VPWR.n55 VPWR.n54 0.0341352
R433 VPWR.t67 VPWR.n72 8.47111
R434 VPWR.t67 VPWR.n80 8.47111
R435 VPWR.t67 VPWR.n935 8.47111
R436 VPWR.t67 VPWR.n932 8.47111
R437 VPWR.t67 VPWR.n930 8.47111
R438 VPWR.t67 VPWR.n928 8.47111
R439 VPWR.t67 VPWR.n926 8.47111
R440 VPWR.t67 VPWR.n924 8.47111
R441 VPWR.t67 VPWR.n88 8.47111
R442 VPWR.t67 VPWR.n90 8.47111
R443 VPWR.t67 VPWR.n92 8.47111
R444 VPWR.t67 VPWR.n94 8.47111
R445 VPWR.t67 VPWR.n96 8.47111
R446 VPWR.t67 VPWR.n99 8.47111
R447 VPWR.t67 VPWR.n123 8.47111
R448 VPWR.t67 VPWR.n118 8.47111
R449 VPWR.t67 VPWR.n103 8.47111
R450 VPWR.t67 VPWR.n105 8.47111
R451 VPWR.t64 VPWR.n0 0.569078
R452 VPWR.t64 VPWR.n906 8.47111
R453 VPWR.t64 VPWR.n904 8.47111
R454 VPWR.t64 VPWR.n902 8.47111
R455 VPWR.t64 VPWR.n900 8.47111
R456 VPWR.t64 VPWR.n898 8.47111
R457 VPWR.t64 VPWR.n831 8.47111
R458 VPWR.t64 VPWR.n833 8.47111
R459 VPWR.t64 VPWR.n835 8.47111
R460 VPWR.t64 VPWR.n837 8.47111
R461 VPWR.t64 VPWR.n839 8.47111
R462 VPWR.t64 VPWR.n841 8.47111
R463 VPWR.t64 VPWR.n843 8.47111
R464 VPWR.t64 VPWR.n845 8.47111
R465 VPWR.t64 VPWR.n847 8.47111
R466 VPWR.t64 VPWR.n849 8.47111
R467 VPWR.t64 VPWR.n851 8.47111
R468 VPWR.t64 VPWR.n894 8.47111
R469 VPWR.t64 VPWR.n891 8.47111
R470 VPWR.t64 VPWR.n889 8.47111
R471 VPWR.t64 VPWR.n887 8.47111
R472 VPWR.t64 VPWR.n885 8.47111
R473 VPWR.t64 VPWR.n881 8.47111
R474 VPWR.t64 VPWR.n855 8.47111
R475 VPWR.t64 VPWR.n857 8.47111
R476 VPWR.t64 VPWR.n872 8.47111
R477 VPWR.t64 VPWR.n867 8.47111
R478 VPWR.t61 VPWR.n2 0.806079
R479 VPWR.t61 VPWR.n169 8.47111
R480 VPWR.t61 VPWR.n211 8.47111
R481 VPWR.t61 VPWR.n207 8.47111
R482 VPWR.t61 VPWR.n204 8.47111
R483 VPWR.t61 VPWR.n201 8.47111
R484 VPWR.t61 VPWR.n198 8.47111
R485 VPWR.t61 VPWR.n195 8.47111
R486 VPWR.t61 VPWR.n179 8.47111
R487 VPWR.t61 VPWR.n181 8.47111
R488 VPWR.t61 VPWR.n184 8.47111
R489 VPWR.t61 VPWR.n186 8.47111
R490 VPWR.t61 VPWR.n166 8.47111
R491 VPWR.t61 VPWR.n127 8.47111
R492 VPWR.t61 VPWR.n129 8.47111
R493 VPWR.t61 VPWR.n158 8.47111
R494 VPWR.t61 VPWR.n132 8.47111
R495 VPWR.t61 VPWR.n134 8.47111
R496 VPWR.t61 VPWR.n149 8.47111
R497 VPWR.t61 VPWR.n144 8.47111
R498 VPWR.t58 VPWR.n738 8.47111
R499 VPWR.t58 VPWR.n742 8.47111
R500 VPWR.t58 VPWR.n772 8.47111
R501 VPWR.t58 VPWR.n769 8.47111
R502 VPWR.t58 VPWR.n767 8.47111
R503 VPWR.t58 VPWR.n34 4.17692
R504 VPWR.t58 VPWR.n761 8.47111
R505 VPWR.t58 VPWR.n41 4.22715
R506 VPWR.t58 VPWR.n747 8.47111
R507 VPWR.t58 VPWR.n750 8.47111
R508 VPWR.t58 VPWR.n753 8.47111
R509 VPWR.t58 VPWR.n756 8.47111
R510 VPWR.t58 VPWR.n18 1.99767
R511 VPWR.t58 VPWR.n780 8.47111
R512 VPWR.t58 VPWR.n819 8.47111
R513 VPWR.t58 VPWR.n785 8.47111
R514 VPWR.t58 VPWR.n809 8.47111
R515 VPWR.t58 VPWR.n804 8.47111
R516 VPWR.t58 VPWR.n789 8.47111
R517 VPWR.t58 VPWR.n791 8.47111
R518 VPWR.t5 VPWR.n729 8.47111
R519 VPWR.t5 VPWR.n242 8.47111
R520 VPWR.t5 VPWR.n45 4.22715
R521 VPWR.t5 VPWR.n707 8.47111
R522 VPWR.t5 VPWR.n705 8.47111
R523 VPWR.t5 VPWR.n703 8.47111
R524 VPWR.t5 VPWR.n701 8.47111
R525 VPWR.t5 VPWR.n699 8.47111
R526 VPWR.t5 VPWR.n697 8.47111
R527 VPWR.t5 VPWR.n245 8.47111
R528 VPWR.t5 VPWR.n247 8.47111
R529 VPWR.t5 VPWR.n249 8.47111
R530 VPWR.t5 VPWR.n251 8.47111
R531 VPWR.t5 VPWR.n253 8.47111
R532 VPWR.t5 VPWR.n256 8.47111
R533 VPWR.t5 VPWR.n280 8.47111
R534 VPWR.t5 VPWR.n275 8.47111
R535 VPWR.t5 VPWR.n260 8.47111
R536 VPWR.t5 VPWR.n262 8.47111
R537 VPWR.t2 VPWR.n48 4.22715
R538 VPWR.t2 VPWR.n679 8.47111
R539 VPWR.t2 VPWR.n676 8.47111
R540 VPWR.t2 VPWR.n673 8.47111
R541 VPWR.t2 VPWR.n577 8.47111
R542 VPWR.t2 VPWR.n580 8.47111
R543 VPWR.t2 VPWR.n583 8.47111
R544 VPWR.t2 VPWR.n585 8.47111
R545 VPWR.t2 VPWR.n587 8.47111
R546 VPWR.t2 VPWR.n589 8.47111
R547 VPWR.t2 VPWR.n591 8.47111
R548 VPWR.t2 VPWR.n594 8.47111
R549 VPWR.t2 VPWR.n597 8.47111
R550 VPWR.t2 VPWR.n651 8.47111
R551 VPWR.t2 VPWR.n647 8.47111
R552 VPWR.t2 VPWR.n644 8.47111
R553 VPWR.t2 VPWR.n642 8.47111
R554 VPWR.t2 VPWR.n604 8.47111
R555 VPWR.t2 VPWR.n633 8.47111
R556 VPWR.t2 VPWR.n607 8.47111
R557 VPWR.t2 VPWR.n609 8.47111
R558 VPWR.t2 VPWR.n624 8.47111
R559 VPWR.t2 VPWR.n619 8.47111
R560 VPWR.t8 VPWR.n379 8.47111
R561 VPWR.t8 VPWR.n378 8.47111
R562 VPWR.t8 VPWR.n375 8.47111
R563 VPWR.n7 VPWR.n373 0.169267
R564 VPWR.n8 VPWR.n7 0.135263
R565 VPWR.t8 VPWR.n8 2.30471
R566 VPWR.n10 VPWR.n286 0.169267
R567 VPWR.n11 VPWR.n10 0.135263
R568 VPWR.t8 VPWR.n11 2.30471
R569 VPWR.t8 VPWR.n369 8.47111
R570 VPWR.t8 VPWR.n366 8.47111
R571 VPWR.t8 VPWR.n363 8.47111
R572 VPWR.t8 VPWR.n361 8.47111
R573 VPWR.t8 VPWR.n341 8.47111
R574 VPWR.t8 VPWR.n338 8.47111
R575 VPWR.t8 VPWR.n51 4.22715
R576 VPWR.t8 VPWR.n295 8.47111
R577 VPWR.t8 VPWR.n330 8.47111
R578 VPWR.t8 VPWR.n301 8.47111
R579 VPWR.t8 VPWR.n323 8.47111
R580 VPWR.t8 VPWR.n318 8.47111
R581 VPWR.t8 VPWR.n303 8.47111
R582 VPWR.t8 VPWR.n305 8.47111
R583 VPWR.t79 VPWR.n387 8.47111
R584 VPWR.t79 VPWR.n390 8.47111
R585 VPWR.t79 VPWR.n393 8.47111
R586 VPWR.t79 VPWR.n396 8.47111
R587 VPWR.t79 VPWR.n399 8.47111
R588 VPWR.t79 VPWR.n402 8.47111
R589 VPWR.t79 VPWR.n55 4.22715
R590 VPWR.t79 VPWR.n559 8.47111
R591 VPWR.t79 VPWR.n412 8.47111
R592 VPWR.t79 VPWR.n517 8.47111
R593 VPWR.t79 VPWR.n25 4.15208
R594 VPWR.t79 VPWR.n422 8.47111
R595 VPWR.n13 VPWR.n425 0.16977
R596 VPWR.n23 VPWR.n438 0.385917
R597 VPWR.n23 VPWR.n22 0.236732
R598 VPWR.t79 VPWR.n435 8.47111
R599 VPWR.n491 VPWR.t0 8.47111
R600 VPWR.n500 VPWR.t0 8.47111
R601 VPWR.n502 VPWR.t0 8.47111
R602 VPWR.t0 VPWR.n477 8.47111
R603 VPWR.t0 VPWR.n475 8.47111
R604 VPWR.t0 VPWR.n473 8.47111
R605 VPWR.t0 VPWR.n471 8.47111
R606 VPWR.t0 VPWR.n469 8.47111
R607 VPWR.t0 VPWR.n445 8.47111
R608 VPWR.t0 VPWR.n447 8.47111
R609 VPWR.t0 VPWR.n449 8.47111
R610 VPWR.t0 VPWR.n451 8.47111
R611 VPWR.t0 VPWR.n453 8.47111
R612 VPWR.t0 VPWR.n462 8.47111
R613 VPWR.t0 VPWR.n458 8.47111
R614 VPWR.t0 VPWR.n483 8.47111
R615 VPWR.n110 VPWR.t1611 7.62628
R616 VPWR.n114 VPWR.t1610 7.62628
R617 VPWR.n121 VPWR.t1609 7.62628
R618 VPWR.n917 VPWR.t1608 7.62628
R619 VPWR.n863 VPWR.t1619 7.62628
R620 VPWR.n870 VPWR.t1618 7.62628
R621 VPWR.n874 VPWR.t1617 7.62628
R622 VPWR.n879 VPWR.t1616 7.62628
R623 VPWR.n140 VPWR.t1628 7.62628
R624 VPWR.n147 VPWR.t1627 7.62628
R625 VPWR.n151 VPWR.t1626 7.62628
R626 VPWR.n156 VPWR.t1625 7.62628
R627 VPWR.n796 VPWR.t1643 7.62628
R628 VPWR.n800 VPWR.t1642 7.62628
R629 VPWR.n807 VPWR.t1641 7.62628
R630 VPWR.n814 VPWR.t1640 7.62628
R631 VPWR.n820 VPWR.t1639 7.62628
R632 VPWR.n16 VPWR.t1638 7.62628
R633 VPWR.n28 VPWR.t1636 7.62628
R634 VPWR.n774 VPWR.t1635 7.62628
R635 VPWR.n267 VPWR.t1655 7.62628
R636 VPWR.n271 VPWR.t1654 7.62628
R637 VPWR.n278 VPWR.t1653 7.62628
R638 VPWR.n690 VPWR.t1652 7.62628
R639 VPWR.n43 VPWR.t1651 7.62628
R640 VPWR.n615 VPWR.t1664 7.62628
R641 VPWR.n622 VPWR.t1663 7.62628
R642 VPWR.n626 VPWR.t1662 7.62628
R643 VPWR.n631 VPWR.t1661 7.62628
R644 VPWR.n637 VPWR.t1660 7.62628
R645 VPWR.n310 VPWR.t1677 7.62628
R646 VPWR.n314 VPWR.t1676 7.62628
R647 VPWR.n321 VPWR.t1675 7.62628
R648 VPWR.n325 VPWR.t1674 7.62628
R649 VPWR.n331 VPWR.t1673 7.62628
R650 VPWR.n49 VPWR.t1672 7.62628
R651 VPWR.n284 VPWR.t1671 7.62628
R652 VPWR.n372 VPWR.t1670 7.62628
R653 VPWR.n431 VPWR.t1690 7.62628
R654 VPWR.n22 VPWR.t1689 7.62628
R655 VPWR.n443 VPWR.t1688 7.62628
R656 VPWR.n423 VPWR.t1687 7.62628
R657 VPWR.n554 VPWR.t1685 7.62628
R658 VPWR.n53 VPWR.t1684 7.62628
R659 VPWR.n486 VPWR.t1695 7.62628
R660 VPWR.n460 VPWR.t1697 7.62628
R661 VPWR.n498 VPWR.t1698 7.62628
R662 VPWR.n489 VPWR.t1699 7.62628
R663 VPWR.n109 VPWR.t1615 7.62594
R664 VPWR.n113 VPWR.t1614 7.62594
R665 VPWR.n120 VPWR.t1613 7.62594
R666 VPWR.n916 VPWR.t1612 7.62594
R667 VPWR.n862 VPWR.t1623 7.62594
R668 VPWR.n869 VPWR.t1622 7.62594
R669 VPWR.n873 VPWR.t1621 7.62594
R670 VPWR.n878 VPWR.t1620 7.62594
R671 VPWR.n139 VPWR.t1634 7.62594
R672 VPWR.n146 VPWR.t1633 7.62594
R673 VPWR.n150 VPWR.t1632 7.62594
R674 VPWR.n155 VPWR.t1631 7.62594
R675 VPWR.n159 VPWR.t1630 7.62594
R676 VPWR.n795 VPWR.t1650 7.62594
R677 VPWR.n799 VPWR.t1649 7.62594
R678 VPWR.n806 VPWR.t1648 7.62594
R679 VPWR.n813 VPWR.t1647 7.62594
R680 VPWR.n39 VPWR.t1646 7.62594
R681 VPWR.n32 VPWR.t1645 7.62594
R682 VPWR.n739 VPWR.t1644 7.62594
R683 VPWR.n266 VPWR.t1659 7.62594
R684 VPWR.n270 VPWR.t1658 7.62594
R685 VPWR.n277 VPWR.t1657 7.62594
R686 VPWR.n689 VPWR.t1656 7.62594
R687 VPWR.n614 VPWR.t1669 7.62594
R688 VPWR.n621 VPWR.t1668 7.62594
R689 VPWR.n625 VPWR.t1667 7.62594
R690 VPWR.n630 VPWR.t1666 7.62594
R691 VPWR.n46 VPWR.t1665 7.62594
R692 VPWR.n309 VPWR.t1683 7.62594
R693 VPWR.n313 VPWR.t1682 7.62594
R694 VPWR.n320 VPWR.t1681 7.62594
R695 VPWR.n324 VPWR.t1680 7.62594
R696 VPWR.n9 VPWR.t1679 7.62594
R697 VPWR.n6 VPWR.t1678 7.62594
R698 VPWR.n430 VPWR.t1694 7.62594
R699 VPWR.n12 VPWR.t1692 7.62594
R700 VPWR.n24 VPWR.t1691 7.62594
R701 VPWR.n488 VPWR.t1037 6.10712
R702 VPWR.n190 VPWR.t1260 6.00573
R703 VPWR.n160 VPWR.t1268 5.99801
R704 VPWR.n47 VPWR.t840 5.99801
R705 VPWR.n775 VPWR.t400 5.99545
R706 VPWR.n966 VPWR.t223 5.97235
R707 VPWR.n97 VPWR.t560 5.97235
R708 VPWR.n884 VPWR.t684 5.97235
R709 VPWR.n840 VPWR.t1423 5.97235
R710 VPWR.n755 VPWR.t1098 5.97235
R711 VPWR.n254 VPWR.t418 5.97235
R712 VPWR.n711 VPWR.t651 5.97235
R713 VPWR.n582 VPWR.t629 5.97235
R714 VPWR.n584 VPWR.t1180 5.97235
R715 VPWR.n10 VPWR.t625 5.97235
R716 VPWR.n549 VPWR.t1112 5.97235
R717 VPWR.n478 VPWR.t1325 5.97235
R718 VPWR.n943 VPWR.t1545 5.97212
R719 VPWR.n937 VPWR.t1542 5.97212
R720 VPWR.n929 VPWR.t1589 5.97212
R721 VPWR.n933 VPWR.t1593 5.97212
R722 VPWR.n846 VPWR.t1537 5.97212
R723 VPWR.n842 VPWR.t1541 5.97212
R724 VPWR.n903 VPWR.t750 5.97212
R725 VPWR.n907 VPWR.t754 5.97212
R726 VPWR.n208 VPWR.t806 5.97212
R727 VPWR.n202 VPWR.t802 5.97212
R728 VPWR.n222 VPWR.t709 5.97212
R729 VPWR.n216 VPWR.t706 5.97212
R730 VPWR.n771 VPWR.t921 5.97212
R731 VPWR.n766 VPWR.t917 5.97212
R732 VPWR.n702 VPWR.t272 5.97212
R733 VPWR.n706 VPWR.t276 5.97212
R734 VPWR.n650 VPWR.t1216 5.97212
R735 VPWR.n645 VPWR.t1213 5.97212
R736 VPWR.n349 VPWR.t485 5.97212
R737 VPWR.n343 VPWR.t482 5.97212
R738 VPWR.n394 VPWR.t1149 5.97212
R739 VPWR.n400 VPWR.t1146 5.97212
R740 VPWR.n521 VPWR.t1079 5.97212
R741 VPWR.n516 VPWR.t1076 5.97212
R742 VPWR.n454 VPWR.t1347 5.97212
R743 VPWR.n450 VPWR.t1343 5.97212
R744 VPWR.n933 VPWR.t473 5.97192
R745 VPWR.n934 VPWR.t474 5.97192
R746 VPWR.n73 VPWR.t329 5.97192
R747 VPWR.n842 VPWR.t1577 5.97192
R748 VPWR.n840 VPWR.t1270 5.97192
R749 VPWR.n229 VPWR.t1259 5.97192
R750 VPWR.n232 VPWR.t148 5.97192
R751 VPWR.n822 VPWR.t210 5.97192
R752 VPWR.n706 VPWR.t310 5.97192
R753 VPWR.n634 VPWR.t552 5.97192
R754 VPWR.n590 VPWR.t1353 5.97192
R755 VPWR.n351 VPWR.t1167 5.97192
R756 VPWR.n385 VPWR.t1442 5.97192
R757 VPWR.n519 VPWR.t1394 5.97192
R758 VPWR.n97 VPWR.t845 5.97169
R759 VPWR.n93 VPWR.t848 5.97169
R760 VPWR.n961 VPWR.t767 5.97169
R761 VPWR.n967 VPWR.t771 5.97169
R762 VPWR.n884 VPWR.t1276 5.97169
R763 VPWR.n888 VPWR.t1279 5.97169
R764 VPWR.n903 VPWR.t734 5.97169
R765 VPWR.n907 VPWR.t738 5.97169
R766 VPWR.n187 VPWR.t683 5.97169
R767 VPWR.n194 VPWR.t577 5.97169
R768 VPWR.n200 VPWR.t580 5.97169
R769 VPWR.n754 VPWR.t900 5.97169
R770 VPWR.n748 VPWR.t904 5.97169
R771 VPWR.n29 VPWR.t155 5.97169
R772 VPWR.n254 VPWR.t635 5.97169
R773 VPWR.n250 VPWR.t638 5.97169
R774 VPWR.n709 VPWR.t311 5.97169
R775 VPWR.n710 VPWR.t500 5.97169
R776 VPWR.n716 VPWR.t503 5.97169
R777 VPWR.n598 VPWR.t1208 5.97169
R778 VPWR.n592 VPWR.t1212 5.97169
R779 VPWR.n672 VPWR.t1192 5.97169
R780 VPWR.n678 VPWR.t1196 5.97169
R781 VPWR.n333 VPWR.t813 5.97169
R782 VPWR.n297 VPWR.t816 5.97169
R783 VPWR.n354 VPWR.t1168 5.97169
R784 VPWR.n370 VPWR.t1173 5.97169
R785 VPWR.n437 VPWR.t1432 5.97169
R786 VPWR.n542 VPWR.t1372 5.97169
R787 VPWR.n548 VPWR.t1376 5.97169
R788 VPWR.n551 VPWR.t1403 5.97169
R789 VPWR.n557 VPWR.t1406 5.97169
R790 VPWR.n108 VPWR.t1474 5.97001
R791 VPWR.n106 VPWR.t1477 5.97001
R792 VPWR.n104 VPWR.t1478 5.97001
R793 VPWR.n117 VPWR.t1481 5.97001
R794 VPWR.n119 VPWR.t1482 5.97001
R795 VPWR.n914 VPWR.t1485 5.97001
R796 VPWR.n100 VPWR.t1486 5.97001
R797 VPWR.n919 VPWR.t159 5.97001
R798 VPWR.n860 VPWR.t404 5.97001
R799 VPWR.n866 VPWR.t407 5.97001
R800 VPWR.n868 VPWR.t408 5.97001
R801 VPWR.n858 VPWR.t355 5.97001
R802 VPWR.n856 VPWR.t356 5.97001
R803 VPWR.n829 VPWR.t359 5.97001
R804 VPWR.n877 VPWR.t360 5.97001
R805 VPWR.n882 VPWR.t66 5.97001
R806 VPWR.n830 VPWR.t247 5.97001
R807 VPWR.n137 VPWR.t1494 5.97001
R808 VPWR.n143 VPWR.t1497 5.97001
R809 VPWR.n145 VPWR.t1498 5.97001
R810 VPWR.n135 VPWR.t1501 5.97001
R811 VPWR.n133 VPWR.t1502 5.97001
R812 VPWR.n125 VPWR.t1505 5.97001
R813 VPWR.n154 VPWR.t1506 5.97001
R814 VPWR.n130 VPWR.t244 5.97001
R815 VPWR.n794 VPWR.t593 5.97001
R816 VPWR.n792 VPWR.t596 5.97001
R817 VPWR.n790 VPWR.t597 5.97001
R818 VPWR.n803 VPWR.t600 5.97001
R819 VPWR.n805 VPWR.t601 5.97001
R820 VPWR.n811 VPWR.t1452 5.97001
R821 VPWR.n786 VPWR.t1453 5.97001
R822 VPWR.n818 VPWR.t1457 5.97001
R823 VPWR.n817 VPWR.t1456 5.97001
R824 VPWR.n779 VPWR.t1461 5.97001
R825 VPWR.n781 VPWR.t1460 5.97001
R826 VPWR.n17 VPWR.t71 5.97001
R827 VPWR.n773 VPWR.t100 5.97001
R828 VPWR.n740 VPWR.t103 5.97001
R829 VPWR.n743 VPWR.t102 5.97001
R830 VPWR.t1230 VPWR.t106 5.97001
R831 VPWR.n265 VPWR.t369 5.97001
R832 VPWR.n263 VPWR.t372 5.97001
R833 VPWR.n261 VPWR.t373 5.97001
R834 VPWR.n274 VPWR.t376 5.97001
R835 VPWR.n276 VPWR.t377 5.97001
R836 VPWR.n687 VPWR.t380 5.97001
R837 VPWR.n257 VPWR.t381 5.97001
R838 VPWR.n708 VPWR.t174 5.97001
R839 VPWR.n692 VPWR.t169 5.97001
R840 VPWR.n243 VPWR.t177 5.97001
R841 VPWR.n612 VPWR.t450 5.97001
R842 VPWR.n618 VPWR.t453 5.97001
R843 VPWR.n620 VPWR.t454 5.97001
R844 VPWR.n610 VPWR.t457 5.97001
R845 VPWR.n608 VPWR.t458 5.97001
R846 VPWR.n573 VPWR.t289 5.97001
R847 VPWR.n629 VPWR.t290 5.97001
R848 VPWR.n635 VPWR.t294 5.97001
R849 VPWR.n605 VPWR.t293 5.97001
R850 VPWR.n641 VPWR.t297 5.97001
R851 VPWR.n308 VPWR.t1017 5.97001
R852 VPWR.n306 VPWR.t1020 5.97001
R853 VPWR.n304 VPWR.t1021 5.97001
R854 VPWR.n317 VPWR.t1024 5.97001
R855 VPWR.n319 VPWR.t1025 5.97001
R856 VPWR.n283 VPWR.t923 5.97001
R857 VPWR.n300 VPWR.t924 5.97001
R858 VPWR.n329 VPWR.t186 5.97001
R859 VPWR.n328 VPWR.t927 5.97001
R860 VPWR.n294 VPWR.t190 5.97001
R861 VPWR.n296 VPWR.t189 5.97001
R862 VPWR.n10 VPWR.t9 5.97001
R863 VPWR.n337 VPWR.t193 5.97001
R864 VPWR.n7 VPWR.t12 5.97001
R865 VPWR.n7 VPWR.t11 5.97001
R866 VPWR.t16 VPWR.t15 5.97001
R867 VPWR.n377 VPWR.t14 5.97001
R868 VPWR.n403 VPWR.t166 5.97001
R869 VPWR.n428 VPWR.t532 5.97001
R870 VPWR.n20 VPWR.t536 5.97001
R871 VPWR.n434 VPWR.t535 5.97001
R872 VPWR.n441 VPWR.t540 5.97001
R873 VPWR.n438 VPWR.t539 5.97001
R874 VPWR.n13 VPWR.t953 5.97001
R875 VPWR.n13 VPWR.t952 5.97001
R876 VPWR.n420 VPWR.t973 5.97001
R877 VPWR.n552 VPWR.t197 5.97001
R878 VPWR.n560 VPWR.t164 5.97001
R879 VPWR.n558 VPWR.t163 5.97001
R880 VPWR.n487 VPWR.t46 5.97001
R881 VPWR.n459 VPWR.t233 5.97001
R882 VPWR.n463 VPWR.t232 5.97001
R883 VPWR.n501 VPWR.t198 5.97001
R884 VPWR.n496 VPWR.t980 5.97001
R885 VPWR.n492 VPWR.t1038 5.97001
R886 VPWR.n108 VPWR.t412 5.96957
R887 VPWR.n106 VPWR.t415 5.96957
R888 VPWR.n104 VPWR.t416 5.96957
R889 VPWR.n117 VPWR.t362 5.96957
R890 VPWR.n119 VPWR.t363 5.96957
R891 VPWR.n914 VPWR.t366 5.96957
R892 VPWR.n100 VPWR.t367 5.96957
R893 VPWR.n919 VPWR.t69 5.96957
R894 VPWR.n860 VPWR.t1507 5.96957
R895 VPWR.n866 VPWR.t1510 5.96957
R896 VPWR.n868 VPWR.t1511 5.96957
R897 VPWR.n858 VPWR.t1514 5.96957
R898 VPWR.n856 VPWR.t1515 5.96957
R899 VPWR.n829 VPWR.t1518 5.96957
R900 VPWR.n877 VPWR.t1519 5.96957
R901 VPWR.n882 VPWR.t246 5.96957
R902 VPWR.n830 VPWR.t240 5.96957
R903 VPWR.n137 VPWR.t603 5.96957
R904 VPWR.n143 VPWR.t606 5.96957
R905 VPWR.n145 VPWR.t607 5.96957
R906 VPWR.n135 VPWR.t610 5.96957
R907 VPWR.n133 VPWR.t611 5.96957
R908 VPWR.n125 VPWR.t1463 5.96957
R909 VPWR.n154 VPWR.t1464 5.96957
R910 VPWR.n130 VPWR.t1467 5.96957
R911 VPWR.n128 VPWR.t1468 5.96957
R912 VPWR.n163 VPWR.t1471 5.96957
R913 VPWR.n794 VPWR.t384 5.96957
R914 VPWR.n792 VPWR.t387 5.96957
R915 VPWR.n790 VPWR.t388 5.96957
R916 VPWR.n803 VPWR.t391 5.96957
R917 VPWR.n805 VPWR.t392 5.96957
R918 VPWR.n811 VPWR.t395 5.96957
R919 VPWR.n786 VPWR.t396 5.96957
R920 VPWR.n817 VPWR.t171 5.96957
R921 VPWR.n746 VPWR.t178 5.96957
R922 VPWR.n760 VPWR.t181 5.96957
R923 VPWR.n763 VPWR.t182 5.96957
R924 VPWR.n764 VPWR.t185 5.96957
R925 VPWR.n29 VPWR.t397 5.96957
R926 VPWR.n265 VPWR.t459 5.96957
R927 VPWR.n263 VPWR.t462 5.96957
R928 VPWR.n261 VPWR.t463 5.96957
R929 VPWR.n274 VPWR.t466 5.96957
R930 VPWR.n276 VPWR.t467 5.96957
R931 VPWR.n687 VPWR.t299 5.96957
R932 VPWR.n257 VPWR.t300 5.96957
R933 VPWR.n692 VPWR.t303 5.96957
R934 VPWR.n612 VPWR.t1026 5.96957
R935 VPWR.n618 VPWR.t1029 5.96957
R936 VPWR.n620 VPWR.t1030 5.96957
R937 VPWR.n610 VPWR.t1033 5.96957
R938 VPWR.n608 VPWR.t1034 5.96957
R939 VPWR.n573 VPWR.t929 5.96957
R940 VPWR.n629 VPWR.t930 5.96957
R941 VPWR.n605 VPWR.t933 5.96957
R942 VPWR.n680 VPWR.t22 5.96957
R943 VPWR.n308 VPWR.t542 5.96957
R944 VPWR.n306 VPWR.t545 5.96957
R945 VPWR.n304 VPWR.t546 5.96957
R946 VPWR.n317 VPWR.t549 5.96957
R947 VPWR.n319 VPWR.t550 5.96957
R948 VPWR.n283 VPWR.t956 5.96957
R949 VPWR.n300 VPWR.t957 5.96957
R950 VPWR.n328 VPWR.t977 5.96957
R951 VPWR.n10 VPWR.t167 5.96957
R952 VPWR.n285 VPWR.t32 5.96957
R953 VPWR.n7 VPWR.t33 5.96957
R954 VPWR.n374 VPWR.t36 5.96957
R955 VPWR.n376 VPWR.t37 5.96957
R956 VPWR.n428 VPWR.t1039 5.96957
R957 VPWR.n434 VPWR.t1042 5.96957
R958 VPWR.n13 VPWR.t200 5.96957
R959 VPWR.n424 VPWR.t203 5.96957
R960 VPWR.n421 VPWR.t304 5.96957
R961 VPWR.n515 VPWR.t237 5.96957
R962 VPWR.n210 VPWR.t195 5.96091
R963 VPWR.n17 VPWR.t72 5.96091
R964 VPWR.n24 VPWR.t975 5.96091
R965 VPWR.n457 VPWR.t235 5.96091
R966 VPWR.n165 VPWR.t1472 5.96047
R967 VPWR.n436 VPWR.t1043 5.96047
R968 VPWR.t5 VPWR.t132 0.733596
R969 VPWR.n109 VPWR.t413 5.65005
R970 VPWR.n110 VPWR.t1475 5.65005
R971 VPWR.n113 VPWR.t361 5.65005
R972 VPWR.n114 VPWR.t1479 5.65005
R973 VPWR.n120 VPWR.t364 5.65005
R974 VPWR.n121 VPWR.t1483 5.65005
R975 VPWR.n916 VPWR.t68 5.65005
R976 VPWR.n917 VPWR.t158 5.65005
R977 VPWR.n862 VPWR.t1508 5.65005
R978 VPWR.n863 VPWR.t405 5.65005
R979 VPWR.n869 VPWR.t1512 5.65005
R980 VPWR.n870 VPWR.t354 5.65005
R981 VPWR.n873 VPWR.t1516 5.65005
R982 VPWR.n874 VPWR.t357 5.65005
R983 VPWR.n878 VPWR.t245 5.65005
R984 VPWR.n879 VPWR.t65 5.65005
R985 VPWR.n139 VPWR.t604 5.65005
R986 VPWR.n140 VPWR.t1495 5.65005
R987 VPWR.n146 VPWR.t608 5.65005
R988 VPWR.n147 VPWR.t1499 5.65005
R989 VPWR.n150 VPWR.t612 5.65005
R990 VPWR.n151 VPWR.t1503 5.65005
R991 VPWR.n155 VPWR.t1465 5.65005
R992 VPWR.n156 VPWR.t243 5.65005
R993 VPWR.n159 VPWR.t1469 5.65005
R994 VPWR.n795 VPWR.t385 5.65005
R995 VPWR.n796 VPWR.t594 5.65005
R996 VPWR.n799 VPWR.t389 5.65005
R997 VPWR.n800 VPWR.t598 5.65005
R998 VPWR.n806 VPWR.t393 5.65005
R999 VPWR.n807 VPWR.t602 5.65005
R1000 VPWR.n813 VPWR.t170 5.65005
R1001 VPWR.n814 VPWR.t1454 5.65005
R1002 VPWR.n820 VPWR.t1458 5.65005
R1003 VPWR.n16 VPWR.t70 5.65005
R1004 VPWR.n39 VPWR.t179 5.65005
R1005 VPWR.n32 VPWR.t183 5.65005
R1006 VPWR.n28 VPWR.t101 5.65005
R1007 VPWR.n739 VPWR.t398 5.65005
R1008 VPWR.n774 VPWR.t104 5.65005
R1009 VPWR.n266 VPWR.t460 5.65005
R1010 VPWR.n267 VPWR.t370 5.65005
R1011 VPWR.n270 VPWR.t464 5.65005
R1012 VPWR.n271 VPWR.t374 5.65005
R1013 VPWR.n277 VPWR.t298 5.65005
R1014 VPWR.n278 VPWR.t378 5.65005
R1015 VPWR.n689 VPWR.t301 5.65005
R1016 VPWR.n690 VPWR.t168 5.65005
R1017 VPWR.n43 VPWR.t175 5.65005
R1018 VPWR.n614 VPWR.t1027 5.65005
R1019 VPWR.n615 VPWR.t451 5.65005
R1020 VPWR.n621 VPWR.t1031 5.65005
R1021 VPWR.n622 VPWR.t455 5.65005
R1022 VPWR.n625 VPWR.t928 5.65005
R1023 VPWR.n626 VPWR.t288 5.65005
R1024 VPWR.n630 VPWR.t931 5.65005
R1025 VPWR.n631 VPWR.t291 5.65005
R1026 VPWR.n637 VPWR.t295 5.65005
R1027 VPWR.n46 VPWR.t23 5.65005
R1028 VPWR.n309 VPWR.t543 5.65005
R1029 VPWR.n310 VPWR.t1018 5.65005
R1030 VPWR.n313 VPWR.t547 5.65005
R1031 VPWR.n314 VPWR.t1022 5.65005
R1032 VPWR.n320 VPWR.t551 5.65005
R1033 VPWR.n321 VPWR.t922 5.65005
R1034 VPWR.n324 VPWR.t958 5.65005
R1035 VPWR.n325 VPWR.t925 5.65005
R1036 VPWR.n331 VPWR.t187 5.65005
R1037 VPWR.n49 VPWR.t191 5.65005
R1038 VPWR.n9 VPWR.t31 5.65005
R1039 VPWR.n284 VPWR.t10 5.65005
R1040 VPWR.n6 VPWR.t34 5.65005
R1041 VPWR.n372 VPWR.t13 5.65005
R1042 VPWR.n430 VPWR.t1040 5.65005
R1043 VPWR.n431 VPWR.t533 5.65005
R1044 VPWR.n22 VPWR.t537 5.65005
R1045 VPWR.n443 VPWR.t541 5.65005
R1046 VPWR.n12 VPWR.t201 5.65005
R1047 VPWR.n423 VPWR.t954 5.65005
R1048 VPWR.n24 VPWR.t236 5.65005
R1049 VPWR.n554 VPWR.t162 5.65005
R1050 VPWR.n53 VPWR.t165 5.65005
R1051 VPWR.n486 VPWR.t45 5.65005
R1052 VPWR.n460 VPWR.t231 5.65005
R1053 VPWR.n498 VPWR.t199 5.65005
R1054 VPWR.n489 VPWR.t1036 5.65005
R1055 VPWR.n189 VPWR.t1473 5.64493
R1056 VPWR.n212 VPWR.t196 5.64493
R1057 VPWR.n777 VPWR.t73 5.64493
R1058 VPWR.n21 VPWR.t1044 5.64493
R1059 VPWR.n512 VPWR.t974 5.64493
R1060 VPWR.n481 VPWR.t234 5.64493
R1061 VPWR.t67 VPWR.n920 5.64096
R1062 VPWR.t67 VPWR.n102 5.64096
R1063 VPWR.t67 VPWR.n116 5.64096
R1064 VPWR.t67 VPWR.n107 5.64096
R1065 VPWR.t64 VPWR.n854 5.64096
R1066 VPWR.t64 VPWR.n876 5.64096
R1067 VPWR.t64 VPWR.n859 5.64096
R1068 VPWR.t64 VPWR.n865 5.64096
R1069 VPWR.t61 VPWR.n161 5.64096
R1070 VPWR.t61 VPWR.n131 5.64096
R1071 VPWR.t61 VPWR.n153 5.64096
R1072 VPWR.t61 VPWR.n136 5.64096
R1073 VPWR.t61 VPWR.n142 5.64096
R1074 VPWR.t58 VPWR.n776 5.64096
R1075 VPWR.t58 VPWR.n783 5.64096
R1076 VPWR.t58 VPWR.n816 5.64096
R1077 VPWR.t58 VPWR.n788 5.64096
R1078 VPWR.t58 VPWR.n802 5.64096
R1079 VPWR.t58 VPWR.n793 5.64096
R1080 VPWR.t5 VPWR.n693 5.64096
R1081 VPWR.t5 VPWR.n259 5.64096
R1082 VPWR.t5 VPWR.n273 5.64096
R1083 VPWR.t5 VPWR.n264 5.64096
R1084 VPWR.t2 VPWR.n639 5.64096
R1085 VPWR.t2 VPWR.n606 5.64096
R1086 VPWR.t2 VPWR.n628 5.64096
R1087 VPWR.t2 VPWR.n611 5.64096
R1088 VPWR.t2 VPWR.n617 5.64096
R1089 VPWR.t8 VPWR.n298 5.64096
R1090 VPWR.t8 VPWR.n327 5.64096
R1091 VPWR.t8 VPWR.n302 5.64096
R1092 VPWR.t8 VPWR.n316 5.64096
R1093 VPWR.t8 VPWR.n307 5.64096
R1094 VPWR.t79 VPWR.n556 5.64096
R1095 VPWR.t79 VPWR.n14 1.99043
R1096 VPWR.t79 VPWR.n433 5.64096
R1097 VPWR.n497 VPWR.t0 5.64013
R1098 VPWR.t0 VPWR.n456 5.64013
R1099 VPWR.n4 VPWR.n487 0.222554
R1100 VPWR.t67 VPWR.n112 5.62104
R1101 VPWR.t64 VPWR.n861 5.62104
R1102 VPWR.t61 VPWR.n138 5.62104
R1103 VPWR.t58 VPWR.n798 5.62104
R1104 VPWR.t5 VPWR.n269 5.62104
R1105 VPWR.t2 VPWR.n613 5.62104
R1106 VPWR.t8 VPWR.n312 5.62104
R1107 VPWR.t79 VPWR.n429 5.62104
R1108 VPWR.t67 VPWR.n922 5.61485
R1109 VPWR.t67 VPWR.n98 5.61485
R1110 VPWR.t64 VPWR.n896 5.61485
R1111 VPWR.t64 VPWR.n853 5.61485
R1112 VPWR.t64 VPWR.n883 5.61485
R1113 VPWR.t61 VPWR.n192 5.61485
R1114 VPWR.t5 VPWR.n695 5.61485
R1115 VPWR.t5 VPWR.n255 5.61485
R1116 VPWR.t8 VPWR.n358 5.61485
R1117 VPWR.n495 VPWR.t0 5.61485
R1118 VPWR.t0 VPWR.n60 5.61485
R1119 VPWR.t0 VPWR.n467 5.61485
R1120 VPWR.t0 VPWR.n455 5.61485
R1121 VPWR.t0 VPWR.n465 5.61485
R1122 VPWR.t0 VPWR.n485 5.61485
R1123 VPWR.n511 VPWR.n503 5.16578
R1124 VPWR.n562 VPWR.t75 5.16578
R1125 VPWR.t63 VPWR.n974 4.9845
R1126 VPWR.n13 VPWR.n511 4.5005
R1127 VPWR.n571 VPWR.n570 4.5005
R1128 VPWR.n684 VPWR.n683 4.5005
R1129 VPWR.n686 VPWR.n685 4.5005
R1130 VPWR.n810 VPWR.n124 4.5005
R1131 VPWR.n828 VPWR.n827 4.5005
R1132 VPWR.n910 VPWR.n909 4.5005
R1133 VPWR.n913 VPWR.n912 4.5005
R1134 VPWR.n975 VPWR.t99 4.5005
R1135 VPWR.n562 VPWR.t80 4.5005
R1136 VPWR.t131 VPWR.n568 4.5005
R1137 VPWR.t3 VPWR.n234 4.5005
R1138 VPWR.n736 VPWR.t6 4.5005
R1139 VPWR.n824 VPWR.t91 4.5005
R1140 VPWR.t96 VPWR.n825 4.5005
R1141 VPWR.n969 VPWR.t117 4.5005
R1142 VPWR.n507 VPWR.n281 4.49573
R1143 VPWR.n974 VPWR.n973 4.49573
R1144 VPWR.n979 VPWR.n978 4.49046
R1145 VPWR.n977 VPWR.n64 4.49046
R1146 VPWR.n979 VPWR.n65 4.49046
R1147 VPWR.n505 VPWR.n504 4.49046
R1148 VPWR.n509 VPWR.n508 4.49046
R1149 VPWR.n566 VPWR.n382 4.49046
R1150 VPWR.n565 VPWR.n381 4.49046
R1151 VPWR.n564 VPWR.n382 4.49046
R1152 VPWR.n972 VPWR.n69 4.49046
R1153 VPWR.n970 VPWR.n68 4.49046
R1154 VPWR.n488 VPWR.t0 4.20293
R1155 VPWR.n493 VPWR.t0 3.30723
R1156 VPWR.t0 VPWR.n62 2.00611
R1157 VPWR.t0 VPWR.n480 2.72142
R1158 VPWR.n63 VPWR.t0 1.99426
R1159 VPWR.t67 VPWR.n71 2.72092
R1160 VPWR.n508 VPWR.n381 2.17938
R1161 VPWR.n972 VPWR.n64 2.17938
R1162 VPWR.t55 VPWR.t519 1.34764
R1163 VPWR.t55 VPWR.t156 1.28728
R1164 VPWR.t64 VPWR.t143 0.268393
R1165 VPWR.n26 VPWR.n70 4.87397
R1166 VPWR.t217 VPWR.t216 1.16606
R1167 VPWR.t56 VPWR.t57 1.11104
R1168 VPWR.t61 VPWR.n19 0.965039
R1169 VPWR.n380 VPWR.t131 1.08388
R1170 VPWR.t135 VPWR.t3 1.08173
R1171 VPWR.t1113 VPWR.t566 1.07797
R1172 VPWR.t146 VPWR.n5 0.00321781
R1173 VPWR.t125 VPWR.t120 1.06555
R1174 VPWR.t881 VPWR.t62 1.06049
R1175 VPWR.t57 VPWR.t205 1.05789
R1176 VPWR.t226 VPWR.t63 1.04781
R1177 VPWR.t126 VPWR.n66 1.0476
R1178 VPWR.t26 VPWR.t28 1.04727
R1179 VPWR.n737 VPWR.t335 1.04625
R1180 VPWR.t0 VPWR.t75 1.03097
R1181 VPWR.t108 VPWR.t110 1.02346
R1182 VPWR.t80 VPWR.n384 1.01996
R1183 VPWR.t430 VPWR.t3 1.01797
R1184 VPWR.t216 VPWR.t113 1.01784
R1185 VPWR.t129 VPWR.t128 1.01476
R1186 VPWR.t250 VPWR.t986 1.01428
R1187 VPWR.n3 VPWR.t59 0.00205267
R1188 VPWR.t56 VPWR.t86 1.00662
R1189 VPWR.t20 VPWR.t21 1.00499
R1190 VPWR.t99 VPWR.t86 0.997282
R1191 VPWR.t16 VPWR.t20 0.994964
R1192 VPWR.t1060 VPWR.n57 0.849462
R1193 VPWR.t25 VPWR.t26 0.980553
R1194 VPWR.n386 VPWR.t1113 0.967265
R1195 VPWR.t430 VPWR.t28 0.959645
R1196 VPWR.n384 VPWR.t566 0.957928
R1197 VPWR.t5 VPWR.n1 0.351713
R1198 VPWR.t0 VPWR.n38 1.75382
R1199 VPWR.n737 VPWR.t1230 0.94065
R1200 VPWR.n66 VPWR.t250 0.927858
R1201 VPWR.t113 VPWR.t116 0.924442
R1202 VPWR.t21 VPWR.t128 0.905559
R1203 VPWR.t882 VPWR.n36 0.774312
R1204 VPWR.t116 VPWR.t67 0.882501
R1205 VPWR.t80 VPWR.n383 0.855139
R1206 VPWR.t91 VPWR.t348 0.853209
R1207 VPWR.t335 VPWR.t348 0.850283
R1208 VPWR.n383 VPWR.t81 0.848722
R1209 VPWR.t986 VPWR.t205 0.834838
R1210 VPWR.t283 VPWR.n380 0.827834
R1211 VPWR.t117 VPWR.t116 0.803556
R1212 VPWR.t108 VPWR.n26 0.177362
R1213 VPWR.t239 VPWR.t125 0.718
R1214 VPWR.n1 VPWR.t440 0.67679
R1215 VPWR.n2 VPWR.t96 0.0124327
R1216 VPWR.n912 VPWR.n910 0.66578
R1217 VPWR.n910 VPWR.n828 0.66578
R1218 VPWR.n828 VPWR.n124 0.66578
R1219 VPWR.n685 VPWR.n124 0.66578
R1220 VPWR.n685 VPWR.n684 0.66578
R1221 VPWR.n684 VPWR.n571 0.66578
R1222 VPWR.n969 VPWR.n70 0.66578
R1223 VPWR.n825 VPWR.n70 0.66578
R1224 VPWR.n825 VPWR.n824 0.66578
R1225 VPWR.n824 VPWR.n736 0.66578
R1226 VPWR.n736 VPWR.n234 0.66578
R1227 VPWR.n568 VPWR.n234 0.66578
R1228 VPWR.n4 VPWR.t0 0.739986
R1229 VPWR.t58 VPWR.t348 0.636529
R1230 VPWR.t519 VPWR.t63 0.621806
R1231 VPWR.n0 VPWR.n830 0.00630072
R1232 VPWR.t67 VPWR.t125 0.614103
R1233 VPWR.t8 VPWR.t20 0.604965
R1234 VPWR.t8 VPWR.t128 0.604686
R1235 VPWR.t55 VPWR.t986 0.604558
R1236 VPWR.t126 VPWR.t519 0.562356
R1237 VPWR.t2 VPWR.t26 0.552247
R1238 VPWR.t55 VPWR.n66 0.552196
R1239 VPWR.t6 VPWR.n1 0.339399
R1240 VPWR.n38 VPWR.t1012 0.524107
R1241 VPWR.n36 VPWR.t881 0.0480156
R1242 VPWR.n384 VPWR.t79 0.505694
R1243 VPWR.t79 VPWR.t1113 0.505218
R1244 VPWR.t2 VPWR.t430 0.505164
R1245 VPWR.n976 VPWR.n975 0.4845
R1246 VPWR.n57 VPWR.t226 0.0453737
R1247 VPWR VPWR.n979 0.42994
R1248 VPWR.t55 VPWR.t57 0.399095
R1249 VPWR.t79 VPWR.n383 0.391967
R1250 VPWR.t8 VPWR.n380 0.384705
R1251 VPWR.t78 VPWR.n63 0.478293
R1252 VPWR.t2 VPWR.t135 0.379994
R1253 VPWR.n62 VPWR.t77 0.0865478
R1254 VPWR.n71 VPWR.t117 0.355888
R1255 VPWR.n975 VPWR 0.3525
R1256 VPWR.n480 VPWR.n479 0.339861
R1257 VPWR.n480 VPWR.n478 0.334092
R1258 VPWR.n511 VPWR.n510 0.31202
R1259 VPWR.n563 VPWR.n562 0.31202
R1260 VPWR.t67 VPWR.t216 0.294144
R1261 VPWR.t55 VPWR.t86 0.291807
R1262 VPWR.n494 VPWR.n493 0.283933
R1263 VPWR.n493 VPWR.n492 0.248945
R1264 VPWR.n71 VPWR.t120 0.235241
R1265 VPWR.n571 VPWR.n281 0.22754
R1266 VPWR.n568 VPWR.n567 0.22754
R1267 VPWR.n503 VPWR.n60 0.200486
R1268 VPWR.t77 VPWR.t75 0.199137
R1269 VPWR.n479 VPWR.n60 0.195825
R1270 VPWR.n485 VPWR.n484 0.195486
R1271 VPWR.n465 VPWR.n464 0.195486
R1272 VPWR.n495 VPWR.n494 0.195486
R1273 VPWR.n107 VPWR.n106 0.190118
R1274 VPWR.n117 VPWR.n116 0.190118
R1275 VPWR.n914 VPWR.n102 0.190118
R1276 VPWR.n920 VPWR.n919 0.190118
R1277 VPWR.n866 VPWR.n865 0.190118
R1278 VPWR.n859 VPWR.n858 0.190118
R1279 VPWR.n876 VPWR.n829 0.190118
R1280 VPWR.n882 VPWR.n854 0.190118
R1281 VPWR.n143 VPWR.n142 0.190118
R1282 VPWR.n136 VPWR.n135 0.190118
R1283 VPWR.n153 VPWR.n125 0.190118
R1284 VPWR.n131 VPWR.n130 0.190118
R1285 VPWR.n793 VPWR.n792 0.190118
R1286 VPWR.n803 VPWR.n802 0.190118
R1287 VPWR.n811 VPWR.n788 0.190118
R1288 VPWR.n817 VPWR.n816 0.190118
R1289 VPWR.t1230 VPWR.n776 0.190118
R1290 VPWR.n264 VPWR.n263 0.190118
R1291 VPWR.n274 VPWR.n273 0.190118
R1292 VPWR.n687 VPWR.n259 0.190118
R1293 VPWR.n693 VPWR.n692 0.190118
R1294 VPWR.n618 VPWR.n617 0.190118
R1295 VPWR.n611 VPWR.n610 0.190118
R1296 VPWR.n628 VPWR.n573 0.190118
R1297 VPWR.n606 VPWR.n605 0.190118
R1298 VPWR.n307 VPWR.n306 0.190118
R1299 VPWR.n317 VPWR.n316 0.190118
R1300 VPWR.n302 VPWR.n283 0.190118
R1301 VPWR.n328 VPWR.n327 0.190118
R1302 VPWR.n434 VPWR.n433 0.190118
R1303 VPWR.n463 VPWR.n456 0.183859
R1304 VPWR.n497 VPWR.n496 0.183859
R1305 VPWR.n921 VPWR.n88 0.173289
R1306 VPWR.n924 VPWR.n923 0.173289
R1307 VPWR.n894 VPWR.n893 0.173289
R1308 VPWR.n852 VPWR.n851 0.173289
R1309 VPWR.n895 VPWR.n831 0.173289
R1310 VPWR.n898 VPWR.n897 0.173289
R1311 VPWR.n191 VPWR.n179 0.173289
R1312 VPWR.n694 VPWR.n245 0.173289
R1313 VPWR.n697 VPWR.n696 0.173289
R1314 VPWR.n341 VPWR.n339 0.173289
R1315 VPWR.n469 VPWR.n468 0.173289
R1316 VPWR.n466 VPWR.n445 0.173289
R1317 VPWR.n462 VPWR.n459 0.169539
R1318 VPWR.n501 VPWR.n500 0.169539
R1319 VPWR.n492 VPWR.n491 0.169539
R1320 VPWR.n190 VPWR.n189 0.16689
R1321 VPWR.n15 VPWR.n777 0.166554
R1322 VPWR.n482 VPWR.n481 0.166554
R1323 VPWR.n464 VPWR.n455 0.165825
R1324 VPWR.n104 VPWR.n103 0.162039
R1325 VPWR.n123 VPWR.n119 0.162039
R1326 VPWR.n100 VPWR.n99 0.162039
R1327 VPWR.n872 VPWR.n868 0.162039
R1328 VPWR.n856 VPWR.n855 0.162039
R1329 VPWR.n881 VPWR.n877 0.162039
R1330 VPWR.n149 VPWR.n145 0.162039
R1331 VPWR.n133 VPWR.n132 0.162039
R1332 VPWR.n158 VPWR.n154 0.162039
R1333 VPWR.n128 VPWR.n127 0.162039
R1334 VPWR.n790 VPWR.n789 0.162039
R1335 VPWR.n809 VPWR.n805 0.162039
R1336 VPWR.n786 VPWR.n785 0.162039
R1337 VPWR.n34 VPWR.n763 0.281447
R1338 VPWR.n740 VPWR.n738 0.162039
R1339 VPWR.n261 VPWR.n260 0.162039
R1340 VPWR.n280 VPWR.n276 0.162039
R1341 VPWR.n257 VPWR.n256 0.162039
R1342 VPWR.n624 VPWR.n620 0.162039
R1343 VPWR.n608 VPWR.n607 0.162039
R1344 VPWR.n633 VPWR.n629 0.162039
R1345 VPWR.n304 VPWR.n303 0.162039
R1346 VPWR.n323 VPWR.n319 0.162039
R1347 VPWR.n301 VPWR.n300 0.162039
R1348 VPWR.n22 VPWR.n20 0.162039
R1349 VPWR.n90 VPWR.n89 0.158289
R1350 VPWR.n926 VPWR.n925 0.158289
R1351 VPWR.n892 VPWR.n891 0.158289
R1352 VPWR.n850 VPWR.n849 0.158289
R1353 VPWR.n833 VPWR.n832 0.158289
R1354 VPWR.n900 VPWR.n899 0.158289
R1355 VPWR.n181 VPWR.n180 0.158289
R1356 VPWR.n247 VPWR.n246 0.158289
R1357 VPWR.n699 VPWR.n698 0.158289
R1358 VPWR.n363 VPWR.n362 0.158289
R1359 VPWR.n471 VPWR.n470 0.158289
R1360 VPWR.n447 VPWR.n446 0.158289
R1361 VPWR.n98 VPWR.n97 0.157986
R1362 VPWR.n884 VPWR.n883 0.157986
R1363 VPWR.n255 VPWR.n254 0.157986
R1364 VPWR.n455 VPWR.n454 0.157986
R1365 VPWR.n483 VPWR.n482 0.153289
R1366 VPWR.n162 VPWR.n161 0.152618
R1367 VPWR.n783 VPWR.n782 0.148868
R1368 VPWR.n640 VPWR.n639 0.148868
R1369 VPWR.n298 VPWR.n297 0.148868
R1370 VPWR.n557 VPWR.n556 0.148868
R1371 VPWR.n97 VPWR.n96 0.143289
R1372 VPWR.n92 VPWR.n91 0.143289
R1373 VPWR.n928 VPWR.n927 0.143289
R1374 VPWR.n933 VPWR.n932 0.143289
R1375 VPWR.n73 VPWR.n72 0.143289
R1376 VPWR.n885 VPWR.n884 0.143289
R1377 VPWR.n890 VPWR.n889 0.143289
R1378 VPWR.n848 VPWR.n847 0.143289
R1379 VPWR.n843 VPWR.n842 0.143289
R1380 VPWR.n840 VPWR.n839 0.143289
R1381 VPWR.n835 VPWR.n834 0.143289
R1382 VPWR.n902 VPWR.n901 0.143289
R1383 VPWR.n907 VPWR.n906 0.143289
R1384 VPWR.n184 VPWR.n183 0.143289
R1385 VPWR.n195 VPWR.n194 0.143289
R1386 VPWR.n208 VPWR.n207 0.143289
R1387 VPWR.n757 VPWR.n756 0.143289
R1388 VPWR.n254 VPWR.n253 0.143289
R1389 VPWR.n249 VPWR.n248 0.143289
R1390 VPWR.n701 VPWR.n700 0.143289
R1391 VPWR.n706 VPWR.n705 0.143289
R1392 VPWR.n643 VPWR.n642 0.143289
R1393 VPWR.n590 VPWR.n589 0.143289
R1394 VPWR.n585 VPWR.n584 0.143289
R1395 VPWR.n48 VPWR.n681 0.176809
R1396 VPWR.n366 VPWR.n365 0.143289
R1397 VPWR.n400 VPWR.n399 0.143289
R1398 VPWR.n385 VPWR.n387 0.143289
R1399 VPWR.n478 VPWR.n477 0.143289
R1400 VPWR.n473 VPWR.n472 0.143289
R1401 VPWR.n449 VPWR.n448 0.143289
R1402 VPWR.n454 VPWR.n453 0.143289
R1403 VPWR.n487 VPWR.n485 0.139575
R1404 VPWR.n465 VPWR.n463 0.139575
R1405 VPWR.n496 VPWR.n495 0.139575
R1406 VPWR.n22 VPWR.n21 0.13351
R1407 VPWR.n213 VPWR.n212 0.133174
R1408 VPWR.n513 VPWR.n512 0.133174
R1409 VPWR.n919 VPWR.n98 0.132075
R1410 VPWR.n883 VPWR.n882 0.132075
R1411 VPWR.n692 VPWR.n255 0.132075
R1412 VPWR.n29 VPWR.n27 0.194107
R1413 VPWR.n111 VPWR.n109 0.12922
R1414 VPWR.n115 VPWR.n113 0.12922
R1415 VPWR.n122 VPWR.n120 0.12922
R1416 VPWR.n918 VPWR.n916 0.12922
R1417 VPWR.n864 VPWR.n862 0.12922
R1418 VPWR.n871 VPWR.n869 0.12922
R1419 VPWR.n875 VPWR.n873 0.12922
R1420 VPWR.n880 VPWR.n878 0.12922
R1421 VPWR.n141 VPWR.n139 0.12922
R1422 VPWR.n148 VPWR.n146 0.12922
R1423 VPWR.n152 VPWR.n150 0.12922
R1424 VPWR.n157 VPWR.n155 0.12922
R1425 VPWR.n160 VPWR.n159 0.12922
R1426 VPWR.n797 VPWR.n795 0.12922
R1427 VPWR.n801 VPWR.n799 0.12922
R1428 VPWR.n808 VPWR.n806 0.12922
R1429 VPWR.n815 VPWR.n813 0.12922
R1430 VPWR.n40 VPWR.n39 0.12922
R1431 VPWR.n268 VPWR.n266 0.12922
R1432 VPWR.n272 VPWR.n270 0.12922
R1433 VPWR.n279 VPWR.n277 0.12922
R1434 VPWR.n691 VPWR.n689 0.12922
R1435 VPWR.n616 VPWR.n614 0.12922
R1436 VPWR.n623 VPWR.n621 0.12922
R1437 VPWR.n627 VPWR.n625 0.12922
R1438 VPWR.n632 VPWR.n630 0.12922
R1439 VPWR.n47 VPWR.n46 0.12922
R1440 VPWR.n311 VPWR.n309 0.12922
R1441 VPWR.n315 VPWR.n313 0.12922
R1442 VPWR.n322 VPWR.n320 0.12922
R1443 VPWR.n326 VPWR.n324 0.12922
R1444 VPWR.n432 VPWR.n430 0.12922
R1445 VPWR.n111 VPWR.n110 0.128884
R1446 VPWR.n115 VPWR.n114 0.128884
R1447 VPWR.n122 VPWR.n121 0.128884
R1448 VPWR.n918 VPWR.n917 0.128884
R1449 VPWR.n864 VPWR.n863 0.128884
R1450 VPWR.n871 VPWR.n870 0.128884
R1451 VPWR.n875 VPWR.n874 0.128884
R1452 VPWR.n880 VPWR.n879 0.128884
R1453 VPWR.n141 VPWR.n140 0.128884
R1454 VPWR.n148 VPWR.n147 0.128884
R1455 VPWR.n152 VPWR.n151 0.128884
R1456 VPWR.n157 VPWR.n156 0.128884
R1457 VPWR.n797 VPWR.n796 0.128884
R1458 VPWR.n801 VPWR.n800 0.128884
R1459 VPWR.n808 VPWR.n807 0.128884
R1460 VPWR.n815 VPWR.n814 0.128884
R1461 VPWR.n821 VPWR.n820 0.128884
R1462 VPWR.n17 VPWR.n16 0.128884
R1463 VPWR.n775 VPWR.n774 0.128884
R1464 VPWR.n268 VPWR.n267 0.128884
R1465 VPWR.n272 VPWR.n271 0.128884
R1466 VPWR.n279 VPWR.n278 0.128884
R1467 VPWR.n691 VPWR.n690 0.128884
R1468 VPWR.n44 VPWR.n43 0.128884
R1469 VPWR.n616 VPWR.n615 0.128884
R1470 VPWR.n623 VPWR.n622 0.128884
R1471 VPWR.n627 VPWR.n626 0.128884
R1472 VPWR.n632 VPWR.n631 0.128884
R1473 VPWR.n638 VPWR.n637 0.128884
R1474 VPWR.n311 VPWR.n310 0.128884
R1475 VPWR.n315 VPWR.n314 0.128884
R1476 VPWR.n322 VPWR.n321 0.128884
R1477 VPWR.n326 VPWR.n325 0.128884
R1478 VPWR.n332 VPWR.n331 0.128884
R1479 VPWR.n50 VPWR.n49 0.128884
R1480 VPWR.n432 VPWR.n431 0.128884
R1481 VPWR.n444 VPWR.n443 0.128884
R1482 VPWR.n555 VPWR.n554 0.128884
R1483 VPWR.n54 VPWR.n53 0.128884
R1484 VPWR.t47 VPWR.n486 0.128884
R1485 VPWR.n461 VPWR.n460 0.128884
R1486 VPWR.n499 VPWR.n498 0.128884
R1487 VPWR.n490 VPWR.n489 0.128884
R1488 VPWR.n922 VPWR.n921 0.128325
R1489 VPWR.n893 VPWR.n853 0.128325
R1490 VPWR.n896 VPWR.n895 0.128325
R1491 VPWR.n192 VPWR.n191 0.128325
R1492 VPWR.n695 VPWR.n694 0.128325
R1493 VPWR.n358 VPWR.n357 0.128325
R1494 VPWR.n467 VPWR.n466 0.128325
R1495 VPWR.n95 VPWR.n94 0.128289
R1496 VPWR.n94 VPWR.n93 0.128289
R1497 VPWR.n930 VPWR.n929 0.128289
R1498 VPWR.n931 VPWR.n930 0.128289
R1499 VPWR.n887 VPWR.n886 0.128289
R1500 VPWR.n888 VPWR.n887 0.128289
R1501 VPWR.n846 VPWR.n845 0.128289
R1502 VPWR.n845 VPWR.n844 0.128289
R1503 VPWR.n838 VPWR.n837 0.128289
R1504 VPWR.n837 VPWR.n836 0.128289
R1505 VPWR.n904 VPWR.n903 0.128289
R1506 VPWR.n905 VPWR.n904 0.128289
R1507 VPWR.n186 VPWR.n185 0.128289
R1508 VPWR.n198 VPWR.n197 0.128289
R1509 VPWR.n205 VPWR.n204 0.128289
R1510 VPWR.n170 VPWR.n169 0.128289
R1511 VPWR.n754 VPWR.n753 0.128289
R1512 VPWR.n750 VPWR.n749 0.128289
R1513 VPWR.n767 VPWR.n766 0.128289
R1514 VPWR.n768 VPWR.n767 0.128289
R1515 VPWR.n252 VPWR.n251 0.128289
R1516 VPWR.n251 VPWR.n250 0.128289
R1517 VPWR.n703 VPWR.n702 0.128289
R1518 VPWR.n704 VPWR.n703 0.128289
R1519 VPWR.n651 VPWR.n650 0.128289
R1520 VPWR.n598 VPWR.n597 0.128289
R1521 VPWR.n588 VPWR.n587 0.128289
R1522 VPWR.n587 VPWR.n586 0.128289
R1523 VPWR.n662 VPWR.n577 0.128289
R1524 VPWR.n673 VPWR.n672 0.128289
R1525 VPWR.n369 VPWR.n368 0.128289
R1526 VPWR.n397 VPWR.n396 0.128289
R1527 VPWR.n390 VPWR.n389 0.128289
R1528 VPWR.n476 VPWR.n475 0.128289
R1529 VPWR.n475 VPWR.n474 0.128289
R1530 VPWR.n451 VPWR.n450 0.128289
R1531 VPWR.n452 VPWR.n451 0.128289
R1532 VPWR.n923 VPWR.n922 0.127986
R1533 VPWR.n853 VPWR.n852 0.127986
R1534 VPWR.n897 VPWR.n896 0.127986
R1535 VPWR.n193 VPWR.n192 0.127986
R1536 VPWR.n696 VPWR.n695 0.127986
R1537 VPWR.n359 VPWR.n358 0.127986
R1538 VPWR.n468 VPWR.n467 0.127986
R1539 VPWR.n370 VPWR.n369 0.124539
R1540 VPWR.t131 VPWR.n379 0.120789
R1541 VPWR.n112 VPWR.n111 0.119294
R1542 VPWR.n864 VPWR.n861 0.119294
R1543 VPWR.n141 VPWR.n138 0.119294
R1544 VPWR.n798 VPWR.n797 0.119294
R1545 VPWR.n269 VPWR.n268 0.119294
R1546 VPWR.n616 VPWR.n613 0.119294
R1547 VPWR.n312 VPWR.n311 0.119294
R1548 VPWR.n432 VPWR.n429 0.119294
R1549 VPWR.n210 VPWR.n178 0.11425
R1550 VPWR.n457 VPWR.n61 0.172055
R1551 VPWR.n758 VPWR.n40 0.114125
R1552 VPWR.n335 VPWR.n50 0.114125
R1553 VPWR.n54 VPWR.n52 0.114125
R1554 VPWR.n96 VPWR.n95 0.113289
R1555 VPWR.n93 VPWR.n92 0.113289
R1556 VPWR.n929 VPWR.n928 0.113289
R1557 VPWR.n932 VPWR.n931 0.113289
R1558 VPWR.t217 VPWR.n72 0.113289
R1559 VPWR.n886 VPWR.n885 0.113289
R1560 VPWR.n889 VPWR.n888 0.113289
R1561 VPWR.n847 VPWR.n846 0.113289
R1562 VPWR.n844 VPWR.n843 0.113289
R1563 VPWR.n839 VPWR.n838 0.113289
R1564 VPWR.n836 VPWR.n835 0.113289
R1565 VPWR.n903 VPWR.n902 0.113289
R1566 VPWR.n906 VPWR.n905 0.113289
R1567 VPWR.n185 VPWR.n184 0.113289
R1568 VPWR.n201 VPWR.n200 0.113289
R1569 VPWR.n202 VPWR.n201 0.113289
R1570 VPWR.n167 VPWR.n19 0.186446
R1571 VPWR.n753 VPWR.n752 0.113289
R1572 VPWR.n751 VPWR.n750 0.113289
R1573 VPWR.n769 VPWR.n768 0.113289
R1574 VPWR.n253 VPWR.n252 0.113289
R1575 VPWR.n250 VPWR.n249 0.113289
R1576 VPWR.n702 VPWR.n701 0.113289
R1577 VPWR.n705 VPWR.n704 0.113289
R1578 VPWR.n648 VPWR.n647 0.113289
R1579 VPWR.n595 VPWR.n594 0.113289
R1580 VPWR.n589 VPWR.n588 0.113289
R1581 VPWR.n586 VPWR.n585 0.113289
R1582 VPWR.n580 VPWR.n579 0.113289
R1583 VPWR.n676 VPWR.n675 0.113289
R1584 VPWR.n11 VPWR.n371 0.45341
R1585 VPWR.n394 VPWR.n393 0.113289
R1586 VPWR.n393 VPWR.n392 0.113289
R1587 VPWR.n477 VPWR.n476 0.113289
R1588 VPWR.n474 VPWR.n473 0.113289
R1589 VPWR.n450 VPWR.n449 0.113289
R1590 VPWR.n453 VPWR.n452 0.113289
R1591 VPWR.n950 VPWR.n948 0.113
R1592 VPWR.n82 VPWR.n81 0.113
R1593 VPWR.n953 VPWR.n952 0.113
R1594 VPWR.n951 VPWR.n79 0.113
R1595 VPWR.n215 VPWR.n214 0.113
R1596 VPWR.n233 VPWR.n231 0.113
R1597 VPWR.n725 VPWR.n237 0.113
R1598 VPWR.n727 VPWR.n726 0.113
R1599 VPWR.n728 VPWR.n236 0.113
R1600 VPWR.n732 VPWR.n731 0.113
R1601 VPWR.n654 VPWR.n653 0.113
R1602 VPWR.n660 VPWR.n658 0.113
R1603 VPWR.n661 VPWR.n576 0.113
R1604 VPWR.n670 VPWR.n574 0.113
R1605 VPWR.n357 VPWR.n287 0.113
R1606 VPWR.n532 VPWR.n530 0.113
R1607 VPWR.n414 VPWR.n413 0.113
R1608 VPWR.n535 VPWR.n534 0.113
R1609 VPWR.n533 VPWR.n411 0.113
R1610 VPWR.n367 VPWR.n366 0.109539
R1611 VPWR.n760 VPWR.n759 0.10925
R1612 VPWR.n764 VPWR.n744 0.10925
R1613 VPWR.n30 VPWR.n743 0.392694
R1614 VPWR.n244 VPWR.n243 0.10925
R1615 VPWR.n337 VPWR.n336 0.10925
R1616 VPWR.n404 VPWR.n403 0.10925
R1617 VPWR.n515 VPWR.n514 0.10925
R1618 VPWR.n112 VPWR.n108 0.108516
R1619 VPWR.n861 VPWR.n860 0.108516
R1620 VPWR.n138 VPWR.n137 0.108516
R1621 VPWR.n798 VPWR.n794 0.108516
R1622 VPWR.n269 VPWR.n265 0.108516
R1623 VPWR.n613 VPWR.n612 0.108516
R1624 VPWR.n312 VPWR.n308 0.108516
R1625 VPWR.n429 VPWR.n428 0.108516
R1626 VPWR.n286 VPWR.n285 0.108
R1627 VPWR.n374 VPWR.n373 0.108
R1628 VPWR.n425 VPWR.n424 0.108
R1629 VPWR.n484 VPWR.n483 0.105789
R1630 VPWR.n33 VPWR.n32 0.103337
R1631 VPWR.n741 VPWR.n739 0.103337
R1632 VPWR.n10 VPWR.n9 0.103337
R1633 VPWR.n7 VPWR.n6 0.103337
R1634 VPWR.n13 VPWR.n12 0.103337
R1635 VPWR.n38 VPWR.t1422 0.103052
R1636 VPWR.n29 VPWR.n28 0.103002
R1637 VPWR.n286 VPWR.n284 0.103002
R1638 VPWR.n373 VPWR.n372 0.103002
R1639 VPWR.n425 VPWR.n423 0.103002
R1640 VPWR.n818 VPWR.n784 0.10175
R1641 VPWR.n636 VPWR.n635 0.10175
R1642 VPWR.n329 VPWR.n299 0.10175
R1643 VPWR.n442 VPWR.n441 0.10175
R1644 VPWR.n553 VPWR.n552 0.10175
R1645 VPWR.n44 VPWR.n42 0.101625
R1646 VPWR.n503 VPWR.n502 0.100789
R1647 VPWR.n187 VPWR.n186 0.099539
R1648 VPWR.n45 VPWR.n709 0.133059
R1649 VPWR.n91 VPWR.n90 0.098289
R1650 VPWR.n927 VPWR.n926 0.098289
R1651 VPWR.n935 VPWR.n933 0.098289
R1652 VPWR.n935 VPWR.n934 0.098289
R1653 VPWR.n891 VPWR.n890 0.098289
R1654 VPWR.n849 VPWR.n848 0.098289
R1655 VPWR.n842 VPWR.n841 0.098289
R1656 VPWR.n841 VPWR.n840 0.098289
R1657 VPWR.n834 VPWR.n833 0.098289
R1658 VPWR.n901 VPWR.n900 0.098289
R1659 VPWR.n0 VPWR.n907 0.171846
R1660 VPWR.n199 VPWR.n198 0.098289
R1661 VPWR.n204 VPWR.n203 0.098289
R1662 VPWR.n778 VPWR.n18 0.341708
R1663 VPWR.n756 VPWR.n755 0.098289
R1664 VPWR.n748 VPWR.n747 0.098289
R1665 VPWR.n745 VPWR.n41 0.131809
R1666 VPWR.n772 VPWR.n771 0.098289
R1667 VPWR.n248 VPWR.n247 0.098289
R1668 VPWR.n700 VPWR.n699 0.098289
R1669 VPWR.n707 VPWR.n706 0.098289
R1670 VPWR.n711 VPWR.n242 0.098289
R1671 VPWR.n644 VPWR.n643 0.098289
R1672 VPWR.n645 VPWR.n644 0.098289
R1673 VPWR.n592 VPWR.n591 0.098289
R1674 VPWR.n591 VPWR.n590 0.098289
R1675 VPWR.n584 VPWR.n583 0.098289
R1676 VPWR.n583 VPWR.n582 0.098289
R1677 VPWR.n679 VPWR.n678 0.098289
R1678 VPWR.n293 VPWR.n51 0.131809
R1679 VPWR.n396 VPWR.n395 0.098289
R1680 VPWR.n391 VPWR.n390 0.098289
R1681 VPWR.n517 VPWR.n516 0.098289
R1682 VPWR.n55 VPWR.n561 0.131809
R1683 VPWR.n472 VPWR.n471 0.098289
R1684 VPWR.n448 VPWR.n447 0.098289
R1685 VPWR.n947 VPWR.n945 0.098
R1686 VPWR.n949 VPWR.n83 0.098
R1687 VPWR.n956 VPWR.n955 0.098
R1688 VPWR.n954 VPWR.n78 0.098
R1689 VPWR.n218 VPWR.n217 0.098
R1690 VPWR.n230 VPWR.n228 0.098
R1691 VPWR.n723 VPWR.n238 0.098
R1692 VPWR.n724 VPWR.n722 0.098
R1693 VPWR.n730 VPWR.n235 0.098
R1694 VPWR.n735 VPWR.n734 0.098
R1695 VPWR.n657 VPWR.n656 0.098
R1696 VPWR.n657 VPWR.n655 0.098
R1697 VPWR.n664 VPWR.n575 0.098
R1698 VPWR.n668 VPWR.n575 0.098
R1699 VPWR.n340 VPWR.n292 0.098
R1700 VPWR.n355 VPWR.n288 0.098
R1701 VPWR.n529 VPWR.n527 0.098
R1702 VPWR.n531 VPWR.n415 0.098
R1703 VPWR.n538 VPWR.n537 0.098
R1704 VPWR.n536 VPWR.n410 0.098
R1705 VPWR.n770 VPWR.n769 0.094539
R1706 VPWR.n364 VPWR.n363 0.094539
R1707 VPWR.n58 VPWR.n190 0.0317231
R1708 VPWR.n360 VPWR.n359 0.093
R1709 VPWR.n490 VPWR.n488 0.0905716
R1710 VPWR.n377 VPWR.n376 0.0905
R1711 VPWR.n421 VPWR.n420 0.0905
R1712 VPWR.t110 VPWR.n56 0.0695551
R1713 VPWR.n190 VPWR.n126 0.08675
R1714 VPWR.n17 VPWR.n15 0.162006
R1715 VPWR.n482 VPWR.n61 0.0296542
R1716 VPWR.n89 VPWR.n88 0.083289
R1717 VPWR.n925 VPWR.n924 0.083289
R1718 VPWR.n894 VPWR.n892 0.083289
R1719 VPWR.n851 VPWR.n850 0.083289
R1720 VPWR.n832 VPWR.n831 0.083289
R1721 VPWR.n899 VPWR.n898 0.083289
R1722 VPWR.n180 VPWR.n179 0.083289
R1723 VPWR.n196 VPWR.n195 0.083289
R1724 VPWR.n207 VPWR.n206 0.083289
R1725 VPWR.n19 VPWR.t153 0.0104222
R1726 VPWR.n246 VPWR.n245 0.083289
R1727 VPWR.n698 VPWR.n697 0.083289
R1728 VPWR.n647 VPWR.n646 0.083289
R1729 VPWR.n594 VPWR.n593 0.083289
R1730 VPWR.n581 VPWR.n580 0.083289
R1731 VPWR.n677 VPWR.n676 0.083289
R1732 VPWR.n341 VPWR.n340 0.083289
R1733 VPWR.n362 VPWR.n361 0.083289
R1734 VPWR.n399 VPWR.n398 0.083289
R1735 VPWR.n388 VPWR.n387 0.083289
R1736 VPWR.n470 VPWR.n469 0.083289
R1737 VPWR.n446 VPWR.n445 0.083289
R1738 VPWR.n934 VPWR.n87 0.083
R1739 VPWR.n938 VPWR.n937 0.083
R1740 VPWR.n944 VPWR.n942 0.083
R1741 VPWR.n946 VPWR.n84 0.083
R1742 VPWR.n959 VPWR.n958 0.083
R1743 VPWR.n957 VPWR.n77 0.083
R1744 VPWR.n967 VPWR.n75 0.083
R1745 VPWR.n968 VPWR.n966 0.083
R1746 VPWR.n216 VPWR.n176 0.083
R1747 VPWR.n221 VPWR.n220 0.083
R1748 VPWR.n227 VPWR.n225 0.083
R1749 VPWR.n229 VPWR.n173 0.083
R1750 VPWR.n233 VPWR.n232 0.083
R1751 VPWR.n823 VPWR.n822 0.083
R1752 VPWR.n31 VPWR.n744 0.083
R1753 VPWR.n712 VPWR.n711 0.083
R1754 VPWR.n710 VPWR.n241 0.083
R1755 VPWR.n720 VPWR.n239 0.083
R1756 VPWR.n721 VPWR.n719 0.083
R1757 VPWR.n634 VPWR.n603 0.083
R1758 VPWR.n654 VPWR.n652 0.083
R1759 VPWR.n660 VPWR.n659 0.083
R1760 VPWR.n665 VPWR.n576 0.083
R1761 VPWR.n667 VPWR.n574 0.083
R1762 VPWR.n334 VPWR.n333 0.083
R1763 VPWR.n344 VPWR.n343 0.083
R1764 VPWR.n342 VPWR.n291 0.083
R1765 VPWR.n352 VPWR.n289 0.083
R1766 VPWR.n353 VPWR.n351 0.083
R1767 VPWR.n516 VPWR.n419 0.083
R1768 VPWR.n520 VPWR.n519 0.083
R1769 VPWR.n526 VPWR.n524 0.083
R1770 VPWR.n528 VPWR.n416 0.083
R1771 VPWR.n541 VPWR.n540 0.083
R1772 VPWR.n539 VPWR.n409 0.083
R1773 VPWR.n549 VPWR.n407 0.083
R1774 VPWR.n550 VPWR.n548 0.083
R1775 VPWR.n551 VPWR.n405 0.083
R1776 VPWR.n356 VPWR.n354 0.08175
R1777 VPWR.n182 VPWR.n181 0.080789
R1778 VPWR.n361 VPWR.n360 0.080789
R1779 VPWR.n913 VPWR.n101 0.0805
R1780 VPWR.n909 VPWR.n37 0.0805
R1781 VPWR.n827 VPWR.n35 0.0805
R1782 VPWR.n165 VPWR.n164 0.0805
R1783 VPWR.n810 VPWR.n787 0.0805
R1784 VPWR.n686 VPWR.n258 0.0805
R1785 VPWR.n683 VPWR.n572 0.0805
R1786 VPWR.n570 VPWR.n282 0.0805
R1787 VPWR.n105 VPWR.n104 0.079539
R1788 VPWR.n119 VPWR.n118 0.079539
R1789 VPWR.n868 VPWR.n867 0.079539
R1790 VPWR.n857 VPWR.n856 0.079539
R1791 VPWR.n145 VPWR.n144 0.079539
R1792 VPWR.n134 VPWR.n133 0.079539
R1793 VPWR.n129 VPWR.n128 0.079539
R1794 VPWR.n791 VPWR.n790 0.079539
R1795 VPWR.n805 VPWR.n804 0.079539
R1796 VPWR.n819 VPWR.n818 0.079539
R1797 VPWR.n780 VPWR.n779 0.079539
R1798 VPWR.n747 VPWR.n746 0.079539
R1799 VPWR.n773 VPWR.n772 0.079539
R1800 VPWR.n262 VPWR.n261 0.079539
R1801 VPWR.n276 VPWR.n275 0.079539
R1802 VPWR.n708 VPWR.n707 0.079539
R1803 VPWR.n620 VPWR.n619 0.079539
R1804 VPWR.n609 VPWR.n608 0.079539
R1805 VPWR.n635 VPWR.n604 0.079539
R1806 VPWR.n680 VPWR.n679 0.079539
R1807 VPWR.n305 VPWR.n304 0.079539
R1808 VPWR.n319 VPWR.n318 0.079539
R1809 VPWR.n330 VPWR.n329 0.079539
R1810 VPWR.n295 VPWR.n294 0.079539
R1811 VPWR.n376 VPWR.n375 0.079539
R1812 VPWR.n378 VPWR.t16 0.079539
R1813 VPWR.n422 VPWR.n421 0.079539
R1814 VPWR.n560 VPWR.n559 0.079539
R1815 VPWR.n106 VPWR.n105 0.072039
R1816 VPWR.n118 VPWR.n117 0.072039
R1817 VPWR.n867 VPWR.n866 0.072039
R1818 VPWR.n858 VPWR.n857 0.072039
R1819 VPWR.n144 VPWR.n143 0.072039
R1820 VPWR.n135 VPWR.n134 0.072039
R1821 VPWR.n130 VPWR.n129 0.072039
R1822 VPWR.n166 VPWR.n163 0.072039
R1823 VPWR.n792 VPWR.n791 0.072039
R1824 VPWR.n804 VPWR.n803 0.072039
R1825 VPWR.n819 VPWR.n817 0.072039
R1826 VPWR.n781 VPWR.n780 0.072039
R1827 VPWR.n761 VPWR.n760 0.072039
R1828 VPWR.n743 VPWR.n742 0.072039
R1829 VPWR.n263 VPWR.n262 0.072039
R1830 VPWR.n275 VPWR.n274 0.072039
R1831 VPWR.n243 VPWR.n242 0.072039
R1832 VPWR.n619 VPWR.n618 0.072039
R1833 VPWR.n610 VPWR.n609 0.072039
R1834 VPWR.n605 VPWR.n604 0.072039
R1835 VPWR.n642 VPWR.n641 0.072039
R1836 VPWR.n306 VPWR.n305 0.072039
R1837 VPWR.n318 VPWR.n317 0.072039
R1838 VPWR.n330 VPWR.n328 0.072039
R1839 VPWR.n296 VPWR.n295 0.072039
R1840 VPWR.n338 VPWR.n337 0.072039
R1841 VPWR.n285 VPWR.n8 0.41216
R1842 VPWR.n375 VPWR.n374 0.072039
R1843 VPWR.n378 VPWR.n377 0.072039
R1844 VPWR.n403 VPWR.n402 0.072039
R1845 VPWR.n435 VPWR.n434 0.072039
R1846 VPWR.n424 VPWR.n422 0.072039
R1847 VPWR.n420 VPWR.n25 0.241134
R1848 VPWR.n517 VPWR.n515 0.072039
R1849 VPWR.n559 VPWR.n558 0.072039
R1850 VPWR.n459 VPWR.n458 0.072039
R1851 VPWR.n502 VPWR.n501 0.072039
R1852 VPWR.n442 VPWR.n440 0.07175
R1853 VPWR.t25 VPWR.n47 0.069125
R1854 VPWR.n81 VPWR.n80 0.068289
R1855 VPWR.n952 VPWR.n80 0.068289
R1856 VPWR.n211 VPWR.n209 0.068289
R1857 VPWR.n169 VPWR.n168 0.068289
R1858 VPWR.n762 VPWR.n761 0.068289
R1859 VPWR.n729 VPWR.n727 0.068289
R1860 VPWR.n729 VPWR.n728 0.068289
R1861 VPWR.n651 VPWR.n649 0.068289
R1862 VPWR.n597 VPWR.n596 0.068289
R1863 VPWR.n578 VPWR.n577 0.068289
R1864 VPWR.n674 VPWR.n673 0.068289
R1865 VPWR.n339 VPWR.n338 0.068289
R1866 VPWR.n402 VPWR.n401 0.068289
R1867 VPWR.n413 VPWR.n412 0.068289
R1868 VPWR.n534 VPWR.n412 0.068289
R1869 VPWR.n936 VPWR.n86 0.068
R1870 VPWR.n941 VPWR.n940 0.068
R1871 VPWR.n941 VPWR.n939 0.068
R1872 VPWR.n943 VPWR.n85 0.068
R1873 VPWR.n962 VPWR.n961 0.068
R1874 VPWR.n960 VPWR.n76 0.068
R1875 VPWR.n964 VPWR.n76 0.068
R1876 VPWR.n965 VPWR.n963 0.068
R1877 VPWR.n219 VPWR.n175 0.068
R1878 VPWR.n224 VPWR.n223 0.068
R1879 VPWR.n224 VPWR.n222 0.068
R1880 VPWR.n226 VPWR.n174 0.068
R1881 VPWR.n715 VPWR.n714 0.068
R1882 VPWR.n713 VPWR.n240 0.068
R1883 VPWR.n717 VPWR.n240 0.068
R1884 VPWR.n718 VPWR.n716 0.068
R1885 VPWR.n347 VPWR.n346 0.068
R1886 VPWR.n345 VPWR.n290 0.068
R1887 VPWR.n349 VPWR.n290 0.068
R1888 VPWR.n350 VPWR.n348 0.068
R1889 VPWR.n518 VPWR.n418 0.068
R1890 VPWR.n523 VPWR.n522 0.068
R1891 VPWR.n523 VPWR.n521 0.068
R1892 VPWR.n525 VPWR.n417 0.068
R1893 VPWR.n544 VPWR.n543 0.068
R1894 VPWR.n542 VPWR.n408 0.068
R1895 VPWR.n546 VPWR.n408 0.068
R1896 VPWR.n547 VPWR.n545 0.068
R1897 VPWR.n166 VPWR.n165 0.067039
R1898 VPWR.n211 VPWR.n210 0.067039
R1899 VPWR.n436 VPWR.n435 0.067039
R1900 VPWR.n458 VPWR.n457 0.067039
R1901 VPWR.n115 VPWR.n103 0.065789
R1902 VPWR.n123 VPWR.n122 0.065789
R1903 VPWR.n918 VPWR.n99 0.065789
R1904 VPWR.n872 VPWR.n871 0.065789
R1905 VPWR.n875 VPWR.n855 0.065789
R1906 VPWR.n881 VPWR.n880 0.065789
R1907 VPWR.n149 VPWR.n148 0.065789
R1908 VPWR.n152 VPWR.n132 0.065789
R1909 VPWR.n158 VPWR.n157 0.065789
R1910 VPWR.n160 VPWR.n127 0.065789
R1911 VPWR.n801 VPWR.n789 0.065789
R1912 VPWR.n809 VPWR.n808 0.065789
R1913 VPWR.n815 VPWR.n785 0.065789
R1914 VPWR.n775 VPWR.n738 0.065789
R1915 VPWR.n272 VPWR.n260 0.065789
R1916 VPWR.n280 VPWR.n279 0.065789
R1917 VPWR.n691 VPWR.n256 0.065789
R1918 VPWR.n624 VPWR.n623 0.065789
R1919 VPWR.n627 VPWR.n607 0.065789
R1920 VPWR.n633 VPWR.n632 0.065789
R1921 VPWR.n315 VPWR.n303 0.065789
R1922 VPWR.n323 VPWR.n322 0.065789
R1923 VPWR.n326 VPWR.n301 0.065789
R1924 VPWR.n213 VPWR.n177 0.06425
R1925 VPWR.n779 VPWR.n778 0.06425
R1926 VPWR.n746 VPWR.n745 0.06425
R1927 VPWR.n294 VPWR.n293 0.06425
R1928 VPWR.n437 VPWR.n427 0.06425
R1929 VPWR.n514 VPWR.n513 0.06425
R1930 VPWR.n561 VPWR.n560 0.06425
R1931 VPWR.n709 VPWR.n708 0.063
R1932 VPWR.t62 VPWR.n2 0.169871
R1933 VPWR.n742 VPWR.n741 0.062039
R1934 VPWR.n462 VPWR.n461 0.062039
R1935 VPWR.n500 VPWR.n499 0.062039
R1936 VPWR.n491 VPWR.n490 0.062039
R1937 VPWR.n379 VPWR.t129 0.060789
R1938 VPWR.n168 VPWR.n167 0.0605
R1939 VPWR.t91 VPWR.t93 0.0605
R1940 VPWR.n646 VPWR.n645 0.0605
R1941 VPWR.n649 VPWR.n648 0.0605
R1942 VPWR.n596 VPWR.n595 0.0605
R1943 VPWR.n593 VPWR.n592 0.0605
R1944 VPWR.n582 VPWR.n581 0.0605
R1945 VPWR.n579 VPWR.n578 0.0605
R1946 VPWR.n675 VPWR.n674 0.0605
R1947 VPWR.n678 VPWR.n677 0.0605
R1948 VPWR.t410 VPWR.t411 0.05925
R1949 VPWR.n215 VPWR.n213 0.05675
R1950 VPWR.n439 VPWR.n437 0.05675
R1951 VPWR.n513 VPWR.n24 0.116418
R1952 VPWR.n912 VPWR.n911 0.05506
R1953 VPWR.n971 VPWR.n969 0.05506
R1954 VPWR.n938 VPWR.n936 0.053
R1955 VPWR.n940 VPWR.n86 0.053
R1956 VPWR.n939 VPWR.n85 0.053
R1957 VPWR.n944 VPWR.n943 0.053
R1958 VPWR.n961 VPWR.n77 0.053
R1959 VPWR.n962 VPWR.n960 0.053
R1960 VPWR.n965 VPWR.n964 0.053
R1961 VPWR.n963 VPWR.n75 0.053
R1962 VPWR.n58 VPWR.n188 0.114943
R1963 VPWR.n221 VPWR.n219 0.053
R1964 VPWR.n223 VPWR.n175 0.053
R1965 VPWR.n222 VPWR.n174 0.053
R1966 VPWR.n227 VPWR.n226 0.053
R1967 VPWR.n171 VPWR.n170 0.053
R1968 VPWR.n766 VPWR.n765 0.053
R1969 VPWR.n714 VPWR.n241 0.053
R1970 VPWR.n715 VPWR.n713 0.053
R1971 VPWR.n718 VPWR.n717 0.053
R1972 VPWR.n716 VPWR.n239 0.053
R1973 VPWR.n650 VPWR.n602 0.053
R1974 VPWR.n599 VPWR.n598 0.053
R1975 VPWR.n663 VPWR.n662 0.053
R1976 VPWR.n672 VPWR.n671 0.053
R1977 VPWR.n346 VPWR.n291 0.053
R1978 VPWR.n347 VPWR.n345 0.053
R1979 VPWR.n350 VPWR.n349 0.053
R1980 VPWR.n348 VPWR.n289 0.053
R1981 VPWR.n520 VPWR.n518 0.053
R1982 VPWR.n522 VPWR.n418 0.053
R1983 VPWR.n521 VPWR.n417 0.053
R1984 VPWR.n526 VPWR.n525 0.053
R1985 VPWR.n543 VPWR.n409 0.053
R1986 VPWR.n544 VPWR.n542 0.053
R1987 VPWR.n547 VPWR.n546 0.053
R1988 VPWR.n545 VPWR.n407 0.053
R1989 VPWR.t99 VPWR.t156 0.0513919
R1990 VPWR.n771 VPWR.n770 0.04925
R1991 VPWR.n440 VPWR.n426 0.04925
R1992 VPWR.n499 VPWR.n497 0.0448003
R1993 VPWR.n461 VPWR.n456 0.0448003
R1994 VPWR.n4 VPWR.t47 0.00680486
R1995 VPWR.n978 VPWR.n977 0.0436411
R1996 VPWR.n509 VPWR.n505 0.0436411
R1997 VPWR.n977 VPWR.n65 0.0436411
R1998 VPWR.n970 VPWR.n69 0.0436411
R1999 VPWR.n566 VPWR.n565 0.0436411
R2000 VPWR.n565 VPWR.n564 0.0436411
R2001 VPWR.n506 VPWR.n281 0.04274
R2002 VPWR.n974 VPWR.n67 0.04274
R2003 VPWR.n920 VPWR.n918 0.0423097
R2004 VPWR.n122 VPWR.n102 0.0423097
R2005 VPWR.n116 VPWR.n115 0.0423097
R2006 VPWR.n111 VPWR.n107 0.0423097
R2007 VPWR.n880 VPWR.n854 0.0423097
R2008 VPWR.n876 VPWR.n875 0.0423097
R2009 VPWR.n871 VPWR.n859 0.0423097
R2010 VPWR.n865 VPWR.n864 0.0423097
R2011 VPWR.n161 VPWR.n160 0.0423097
R2012 VPWR.n157 VPWR.n131 0.0423097
R2013 VPWR.n153 VPWR.n152 0.0423097
R2014 VPWR.n148 VPWR.n136 0.0423097
R2015 VPWR.n142 VPWR.n141 0.0423097
R2016 VPWR.n776 VPWR.n775 0.0423097
R2017 VPWR.n821 VPWR.n783 0.0423097
R2018 VPWR.n816 VPWR.n815 0.0423097
R2019 VPWR.n808 VPWR.n788 0.0423097
R2020 VPWR.n802 VPWR.n801 0.0423097
R2021 VPWR.n797 VPWR.n793 0.0423097
R2022 VPWR.n693 VPWR.n691 0.0423097
R2023 VPWR.n279 VPWR.n259 0.0423097
R2024 VPWR.n273 VPWR.n272 0.0423097
R2025 VPWR.n268 VPWR.n264 0.0423097
R2026 VPWR.n639 VPWR.n638 0.0423097
R2027 VPWR.n632 VPWR.n606 0.0423097
R2028 VPWR.n628 VPWR.n627 0.0423097
R2029 VPWR.n623 VPWR.n611 0.0423097
R2030 VPWR.n617 VPWR.n616 0.0423097
R2031 VPWR.n332 VPWR.n298 0.0423097
R2032 VPWR.n327 VPWR.n326 0.0423097
R2033 VPWR.n322 VPWR.n302 0.0423097
R2034 VPWR.n316 VPWR.n315 0.0423097
R2035 VPWR.n311 VPWR.n307 0.0423097
R2036 VPWR.n556 VPWR.n555 0.0423097
R2037 VPWR.n14 VPWR.n444 0.347826
R2038 VPWR.n433 VPWR.n432 0.0423097
R2039 VPWR.n782 VPWR.n781 0.04175
R2040 VPWR.n641 VPWR.n640 0.04175
R2041 VPWR.n297 VPWR.n296 0.04175
R2042 VPWR.n558 VPWR.n557 0.04175
R2043 VPWR.n915 VPWR.n913 0.0405
R2044 VPWR.n909 VPWR.n908 0.0405
R2045 VPWR.n827 VPWR.n826 0.0405
R2046 VPWR.n812 VPWR.n810 0.0405
R2047 VPWR.n688 VPWR.n686 0.0405
R2048 VPWR.n683 VPWR.n682 0.0405
R2049 VPWR.n570 VPWR.n569 0.0405
R2050 VPWR.n354 VPWR.n287 0.03925
R2051 VPWR.n937 VPWR.n87 0.038
R2052 VPWR.n942 VPWR.n84 0.038
R2053 VPWR.n947 VPWR.n946 0.038
R2054 VPWR.n958 VPWR.n78 0.038
R2055 VPWR.n959 VPWR.n957 0.038
R2056 VPWR.n968 VPWR.n967 0.038
R2057 VPWR.n966 VPWR.n74 0.038
R2058 VPWR.n74 VPWR.n73 0.038
R2059 VPWR.n163 VPWR.n162 0.038
R2060 VPWR.n218 VPWR.n216 0.038
R2061 VPWR.n220 VPWR.n176 0.038
R2062 VPWR.n225 VPWR.n173 0.038
R2063 VPWR.n230 VPWR.n229 0.038
R2064 VPWR.n232 VPWR.n172 0.038
R2065 VPWR.n822 VPWR.n784 0.038
R2066 VPWR.n59 VPWR.n757 0.0999426
R2067 VPWR.n33 VPWR.n31 0.0976683
R2068 VPWR.n712 VPWR.n710 0.038
R2069 VPWR.n721 VPWR.n720 0.038
R2070 VPWR.n719 VPWR.n238 0.038
R2071 VPWR.n735 VPWR.n733 0.038
R2072 VPWR.n5 VPWR.n733 0.118705
R2073 VPWR.n636 VPWR.n634 0.038
R2074 VPWR.n652 VPWR.n601 0.038
R2075 VPWR.n659 VPWR.n600 0.038
R2076 VPWR.n666 VPWR.n665 0.038
R2077 VPWR.n669 VPWR.n667 0.038
R2078 VPWR.n333 VPWR.n299 0.038
R2079 VPWR.n343 VPWR.n292 0.038
R2080 VPWR.n344 VPWR.n342 0.038
R2081 VPWR.n353 VPWR.n352 0.038
R2082 VPWR.n351 VPWR.n288 0.038
R2083 VPWR.n519 VPWR.n419 0.038
R2084 VPWR.n524 VPWR.n416 0.038
R2085 VPWR.n529 VPWR.n528 0.038
R2086 VPWR.n540 VPWR.n410 0.038
R2087 VPWR.n541 VPWR.n539 0.038
R2088 VPWR.n550 VPWR.n549 0.038
R2089 VPWR.n548 VPWR.n406 0.038
R2090 VPWR.n553 VPWR.n551 0.038
R2091 VPWR.n164 VPWR.n126 0.03425
R2092 VPWR.n194 VPWR.n193 0.0305
R2093 VPWR.n197 VPWR.n196 0.0305
R2094 VPWR.n200 VPWR.n199 0.0305
R2095 VPWR.n203 VPWR.n202 0.0305
R2096 VPWR.n206 VPWR.n205 0.0305
R2097 VPWR.n209 VPWR.n208 0.0305
R2098 VPWR.n27 VPWR.n773 0.0305
R2099 VPWR.n401 VPWR.n400 0.0305
R2100 VPWR.n398 VPWR.n397 0.0305
R2101 VPWR.n395 VPWR.n394 0.0305
R2102 VPWR.n392 VPWR.n391 0.0305
R2103 VPWR.n389 VPWR.n388 0.0305
R2104 VPWR.n386 VPWR.n385 0.0305
R2105 VPWR.n188 VPWR.n187 0.02925
R2106 VPWR.n945 VPWR.n83 0.023
R2107 VPWR.n950 VPWR.n949 0.023
R2108 VPWR.n955 VPWR.n79 0.023
R2109 VPWR.n956 VPWR.n954 0.023
R2110 VPWR.n217 VPWR.n177 0.023
R2111 VPWR.n228 VPWR.n172 0.023
R2112 VPWR.n724 VPWR.n723 0.023
R2113 VPWR.n722 VPWR.n237 0.023
R2114 VPWR.n732 VPWR.n730 0.023
R2115 VPWR.n734 VPWR.n235 0.023
R2116 VPWR.n656 VPWR.n601 0.023
R2117 VPWR.n655 VPWR.n600 0.023
R2118 VPWR.n666 VPWR.n664 0.023
R2119 VPWR.n669 VPWR.n668 0.023
R2120 VPWR.n356 VPWR.n355 0.023
R2121 VPWR.n527 VPWR.n415 0.023
R2122 VPWR.n532 VPWR.n531 0.023
R2123 VPWR.n537 VPWR.n411 0.023
R2124 VPWR.n538 VPWR.n536 0.023
R2125 VPWR.n911 VPWR.n65 0.0220706
R2126 VPWR.n978 VPWR.n976 0.0220706
R2127 VPWR.n506 VPWR.n505 0.0220706
R2128 VPWR.n510 VPWR.n509 0.0220706
R2129 VPWR.n567 VPWR.n566 0.0220706
R2130 VPWR.n564 VPWR.n563 0.0220706
R2131 VPWR.n69 VPWR.n67 0.0220706
R2132 VPWR.n971 VPWR.n970 0.0220706
R2133 VPWR.n382 VPWR.n381 0.02162
R2134 VPWR.n979 VPWR.n64 0.02162
R2135 VPWR.n42 VPWR.n244 0.0205
R2136 VPWR.n101 VPWR.n100 0.01925
R2137 VPWR.n877 VPWR.n37 0.01925
R2138 VPWR.n154 VPWR.n35 0.01925
R2139 VPWR.n787 VPWR.n786 0.01925
R2140 VPWR.n258 VPWR.n257 0.01925
R2141 VPWR.n629 VPWR.n572 0.01925
R2142 VPWR.n681 VPWR.n680 0.01925
R2143 VPWR.n300 VPWR.n282 0.01925
R2144 VPWR.n441 VPWR.n427 0.01925
R2145 VPWR.n552 VPWR.n406 0.01925
R2146 VPWR.n3 VPWR.t93 0.0186778
R2147 VPWR.n183 VPWR.n182 0.018
R2148 VPWR.n741 VPWR.n740 0.018
R2149 VPWR.n755 VPWR.n754 0.0155
R2150 VPWR.n752 VPWR.n751 0.0155
R2151 VPWR.n749 VPWR.n748 0.0155
R2152 VPWR.n20 VPWR.n436 0.013
R2153 VPWR.n915 VPWR.n914 0.01175
R2154 VPWR.n908 VPWR.n829 0.01175
R2155 VPWR.n826 VPWR.n125 0.01175
R2156 VPWR.n812 VPWR.n811 0.01175
R2157 VPWR.n763 VPWR.n762 0.01175
R2158 VPWR.n765 VPWR.n764 0.01175
R2159 VPWR.n688 VPWR.n687 0.01175
R2160 VPWR.n682 VPWR.n573 0.01175
R2161 VPWR.n569 VPWR.n283 0.01175
R2162 VPWR.n439 VPWR.n438 0.01175
R2163 VPWR.n508 VPWR.n507 0.0115476
R2164 VPWR.n507 VPWR.n504 0.0115476
R2165 VPWR.n973 VPWR.n68 0.0115476
R2166 VPWR.n973 VPWR.n972 0.0115476
R2167 VPWR.n948 VPWR.n82 0.008
R2168 VPWR.n953 VPWR.n951 0.008
R2169 VPWR.n214 VPWR.n178 0.008
R2170 VPWR.n231 VPWR.n171 0.008
R2171 VPWR.n759 VPWR.n758 0.008
R2172 VPWR.n726 VPWR.n725 0.008
R2173 VPWR.n731 VPWR.n236 0.008
R2174 VPWR.n653 VPWR.n602 0.008
R2175 VPWR.n658 VPWR.n599 0.008
R2176 VPWR.n663 VPWR.n661 0.008
R2177 VPWR.n671 VPWR.n670 0.008
R2178 VPWR.n336 VPWR.n335 0.008
R2179 VPWR.n52 VPWR.n404 0.008
R2180 VPWR.n530 VPWR.n414 0.008
R2181 VPWR.n535 VPWR.n533 0.008
R2182 VPWR.n823 VPWR.n821 0.0055
R2183 VPWR.n638 VPWR.n603 0.0055
R2184 VPWR.n334 VPWR.n332 0.0055
R2185 VPWR.n444 VPWR.n426 0.0055
R2186 VPWR.n555 VPWR.n405 0.0055
R2187 VPWR.n365 VPWR.n364 0.00425
R2188 VPWR.n368 VPWR.n367 0.00425
R2189 VPWR.n371 VPWR.n370 0.00425
R2190 VPWR.t64 VPWR.t411 8.50445
R2191 VPWR.t64 VPWR.n26 1.14377
R2192 VPWR.t61 VPWR.t85 1.04585
R2193 VPWR.t58 VPWR.n737 1.04477
R2194 VGND.n609 VGND.n608 63703.7
R2195 VGND.t40 VGND.n813 6300
R2196 VGND.t40 VGND.n79 6300
R2197 VGND.n639 VGND.n79 6300
R2198 VGND.n640 VGND.n639 6300
R2199 VGND.n641 VGND.n640 6300
R2200 VGND.t2 VGND.n641 6300
R2201 VGND.t2 VGND.n260 6300
R2202 VGND.n608 VGND.n260 6300
R2203 VGND.n10 VGND.n14 5948.99
R2204 VGND.t40 VGND.n14 5785.71
R2205 VGND.t40 VGND.n78 5785.71
R2206 VGND.n644 VGND.n78 5785.71
R2207 VGND.n644 VGND.n643 5785.71
R2208 VGND.n643 VGND.n642 5785.71
R2209 VGND.n642 VGND.t2 5785.71
R2210 VGND.t2 VGND.n258 5785.71
R2211 VGND.n609 VGND.n258 5785.71
R2212 VGND.n10 VGND.t1340 183.804
R2213 VGND.n10 VGND.t1350 183.805
R2214 VGND.n10 VGND.t1360 183.805
R2215 VGND.t1379 VGND.n10 183.806
R2216 VGND.t1386 VGND.n10 182.042
R2217 VGND.t1399 VGND.n10 183.806
R2218 VGND.t1414 VGND.n10 183.805
R2219 VGND.n813 VGND.n10 6413.31
R2220 VGND.n811 VGND.t1454 687.192
R2221 VGND.t1455 VGND.n809 687.192
R2222 VGND.n12 VGND.t847 35.5278
R2223 VGND.t848 VGND.n11 35.5278
R2224 VGND.n48 VGND.t1453 645.394
R2225 VGND.t1456 VGND.n808 642.857
R2226 VGND.n796 VGND.t846 642.857
R2227 VGND.t1457 VGND.n807 598.523
R2228 VGND.n797 VGND.t844 598.523
R2229 VGND.t1458 VGND.n806 554.188
R2230 VGND.n798 VGND.t1467 554.188
R2231 VGND.t1459 VGND.n805 509.853
R2232 VGND.n799 VGND.t1466 509.853
R2233 VGND.t1460 VGND.n804 465.517
R2234 VGND.n800 VGND.t1465 465.517
R2235 VGND.n27 VGND.t1506 16.3503
R2236 VGND.n813 VGND.n80 427.132
R2237 VGND.n699 VGND.n14 427.132
R2238 VGND.n137 VGND.n79 427.132
R2239 VGND.n87 VGND.n78 427.132
R2240 VGND.n639 VGND.n206 427.132
R2241 VGND.n645 VGND.n644 427.132
R2242 VGND.n643 VGND.n0 427.132
R2243 VGND.n641 VGND.n261 427.132
R2244 VGND.n642 VGND.n257 427.132
R2245 VGND.n436 VGND.n260 427.132
R2246 VGND.n423 VGND.n258 427.132
R2247 VGND.n18 VGND.n609 427.132
R2248 VGND.t1461 VGND.n803 421.183
R2249 VGND.n801 VGND.t1464 421.183
R2250 VGND.n10 VGND.t1342 182.042
R2251 VGND.n10 VGND.t1352 182.042
R2252 VGND.n10 VGND.t1362 182.042
R2253 VGND.n10 VGND.t1367 182.036
R2254 VGND.t1401 VGND.n10 182.042
R2255 VGND.t1416 VGND.n10 182.042
R2256 VGND.n763 VGND.t196 398.572
R2257 VGND.t197 VGND.n741 398.572
R2258 VGND.t1577 VGND.n734 398.572
R2259 VGND.n773 VGND.t836 398.572
R2260 VGND.t27 VGND.n722 398.572
R2261 VGND.t817 VGND.n651 398.572
R2262 VGND.t433 VGND.n120 398.572
R2263 VGND.n663 VGND.t434 398.572
R2264 VGND.n676 VGND.t173 398.572
R2265 VGND.n679 VGND.t78 398.572
R2266 VGND.t79 VGND.n101 398.572
R2267 VGND.t179 VGND.n94 398.572
R2268 VGND.n687 VGND.t180 398.572
R2269 VGND.n232 VGND.t11 398.572
R2270 VGND.n246 VGND.t212 398.572
R2271 VGND.n297 VGND.t20 398.572
R2272 VGND.t21 VGND.n296 398.572
R2273 VGND.t59 VGND.n289 398.572
R2274 VGND.n305 VGND.t60 398.572
R2275 VGND.n306 VGND.t278 398.572
R2276 VGND.n313 VGND.t295 398.572
R2277 VGND.t296 VGND.n279 398.572
R2278 VGND.n315 VGND.t768 398.572
R2279 VGND.n328 VGND.t585 398.572
R2280 VGND.n378 VGND.t262 398.572
R2281 VGND.t263 VGND.n367 398.572
R2282 VGND.t713 VGND.n356 398.572
R2283 VGND.t155 VGND.n353 398.572
R2284 VGND.n396 VGND.t156 398.572
R2285 VGND.n403 VGND.t474 398.572
R2286 VGND.t475 VGND.n344 398.572
R2287 VGND.t446 VGND.n488 398.572
R2288 VGND.n499 VGND.t643 398.572
R2289 VGND.t684 VGND.n473 398.572
R2290 VGND.n511 VGND.t592 398.572
R2291 VGND.t667 VGND.n463 398.572
R2292 VGND.t240 VGND.n456 398.572
R2293 VGND.t872 VGND.n564 398.572
R2294 VGND.t873 VGND.n563 398.572
R2295 VGND.n585 VGND.t1447 398.572
R2296 VGND.n588 VGND.t1479 398.572
R2297 VGND.t1480 VGND.n548 398.572
R2298 VGND.t1514 VGND.n541 398.572
R2299 VGND.n597 VGND.t1515 398.572
R2300 VGND.t648 VGND.n539 398.572
R2301 VGND.n606 VGND.t599 398.572
R2302 VGND.n10 VGND.t1384 183.805
R2303 VGND.t808 VGND.n131 385.714
R2304 VGND.t632 VGND.t220 385.714
R2305 VGND.t792 VGND.t546 385.714
R2306 VGND.t786 VGND.t552 385.714
R2307 VGND.t708 VGND.n474 385.714
R2308 VGND.t514 VGND.n454 385.714
R2309 VGND.t1507 VGND.n565 385.714
R2310 VGND.n215 VGND.t1511 381.43
R2311 VGND.n638 VGND.t152 381.43
R2312 VGND.t1462 VGND.n802 376.848
R2313 VGND.n802 VGND.t1463 376.848
R2314 VGND.t195 VGND.n743 372.858
R2315 VGND.n765 VGND.t199 372.858
R2316 VGND.n771 VGND.t1576 372.858
R2317 VGND.n794 VGND.t842 372.858
R2318 VGND.t816 VGND.n650 372.858
R2319 VGND.n662 VGND.t432 372.858
R2320 VGND.t435 VGND.n119 372.858
R2321 VGND.t172 VGND.n107 372.858
R2322 VGND.n677 VGND.t175 372.858
R2323 VGND.t77 VGND.n103 372.858
R2324 VGND.n680 VGND.t80 372.858
R2325 VGND.n686 VGND.t178 372.858
R2326 VGND.t182 VGND.n93 372.858
R2327 VGND.t348 VGND.n91 372.858
R2328 VGND.n690 VGND.t831 372.858
R2329 VGND.t630 VGND.n216 372.858
R2330 VGND.t219 VGND.n197 372.858
R2331 VGND.n219 VGND.t633 372.858
R2332 VGND.n226 VGND.t791 372.858
R2333 VGND.t547 VGND.n187 372.858
R2334 VGND.t794 VGND.n186 372.858
R2335 VGND.n230 VGND.t9 372.858
R2336 VGND.t12 VGND.n183 372.858
R2337 VGND.n238 VGND.t785 372.858
R2338 VGND.t553 VGND.n174 372.858
R2339 VGND.n247 VGND.t215 372.858
R2340 VGND.t773 VGND.n155 372.858
R2341 VGND.t19 VGND.n46 375.315
R2342 VGND.n298 VGND.t22 372.858
R2343 VGND.n304 VGND.t58 372.858
R2344 VGND.n307 VGND.t280 372.858
R2345 VGND.t294 VGND.n281 372.858
R2346 VGND.n31 VGND.t297 375.315
R2347 VGND.t767 VGND.n278 372.858
R2348 VGND.n316 VGND.t770 372.858
R2349 VGND.t584 VGND.t208 372.858
R2350 VGND.n329 VGND.t587 372.858
R2351 VGND.n636 VGND.t64 372.858
R2352 VGND.t261 VGND.n369 372.858
R2353 VGND.n380 VGND.t264 372.858
R2354 VGND.t715 VGND.n354 372.858
R2355 VGND.n394 VGND.t154 372.858
R2356 VGND.t158 VGND.n352 372.858
R2357 VGND.t473 VGND.n346 372.858
R2358 VGND.n404 VGND.t476 372.858
R2359 VGND.n335 VGND.t38 372.858
R2360 VGND.n489 VGND.t445 372.858
R2361 VGND.n503 VGND.t683 372.858
R2362 VGND.t686 VGND.n472 372.858
R2363 VGND.n512 VGND.t594 372.858
R2364 VGND.t665 VGND.n464 372.858
R2365 VGND.n515 VGND.t668 372.858
R2366 VGND.n521 VGND.t239 372.858
R2367 VGND.n622 VGND.t706 372.858
R2368 VGND.t1494 VGND.n45 46.0428
R2369 VGND.n587 VGND.t1449 372.858
R2370 VGND.t1478 VGND.n550 372.858
R2371 VGND.n590 VGND.t1481 372.858
R2372 VGND.n598 VGND.t647 372.858
R2373 VGND.t650 VGND.n538 372.858
R2374 VGND.n607 VGND.t602 372.858
R2375 VGND.t201 VGND.n530 372.858
R2376 VGND.t1505 VGND.n612 372.858
R2377 VGND.n611 VGND.t1508 372.858
R2378 VGND.t1421 VGND.n10 185.452
R2379 VGND.t815 VGND.n132 363.495
R2380 VGND.t5 VGND.n46 13.8942
R2381 VGND.n148 VGND.t183 363.471
R2382 VGND.t5 VGND.n31 13.894
R2383 VGND.n33 VGND.t63 52.5394
R2384 VGND.t477 VGND.n343 363.471
R2385 VGND.n448 VGND.t243 363.471
R2386 VGND.n146 VGND.t75 363.469
R2387 VGND.t629 VGND.n198 363.469
R2388 VGND.t30 VGND.n720 362.846
R2389 VGND.t216 VGND.n164 362.846
R2390 VGND.t153 VGND.n393 362.846
R2391 VGND.t595 VGND.n429 362.846
R2392 VGND.t869 VGND.n29 363.127
R2393 VGND.t1450 VGND.n24 362.846
R2394 VGND.n21 VGND.t1517 362.846
R2395 VGND.t603 VGND.n26 362.846
R2396 VGND.n652 VGND.t1426 360
R2397 VGND.t1504 VGND.n336 360
R2398 VGND.n502 VGND.t1424 360
R2399 VGND.n620 VGND.t1475 360
R2400 VGND.n567 VGND.t1433 360
R2401 VGND.t1448 VGND.t1495 360
R2402 VGND.t806 VGND.n718 355.714
R2403 VGND.n214 VGND.t1510 355.714
R2404 VGND.t418 VGND.n355 355.714
R2405 VGND.t624 VGND.n476 355.714
R2406 VGND.n528 VGND.t639 355.714
R2407 VGND.n411 VGND.t150 350.613
R2408 VGND.t200 VGND.n740 347.144
R2409 VGND.t431 VGND.n121 347.144
R2410 VGND.n664 VGND.t436 347.144
R2411 VGND.t176 VGND.n104 347.144
R2412 VGND.t81 VGND.n100 347.144
R2413 VGND.t177 VGND.n95 347.144
R2414 VGND.n217 VGND.t217 347.144
R2415 VGND.t634 VGND.n195 347.144
R2416 VGND.t790 VGND.n189 347.144
R2417 VGND.n228 VGND.t548 347.144
R2418 VGND.n229 VGND.t795 347.144
R2419 VGND.t6 VGND.n185 347.144
R2420 VGND.t784 VGND.n176 347.144
R2421 VGND.n240 VGND.t554 347.144
R2422 VGND.n245 VGND.t209 347.144
R2423 VGND.t23 VGND.n295 347.144
R2424 VGND.t57 VGND.n290 347.144
R2425 VGND.t281 VGND.n286 347.144
R2426 VGND.t771 VGND.n276 347.144
R2427 VGND.n327 VGND.t583 347.144
R2428 VGND.t588 VGND.n264 347.144
R2429 VGND.t265 VGND.n366 347.144
R2430 VGND.t711 VGND.n357 347.144
R2431 VGND.n397 VGND.t159 347.144
R2432 VGND.n402 VGND.t472 347.144
R2433 VGND.n500 VGND.t645 347.144
R2434 VGND.n505 VGND.t687 347.144
R2435 VGND.n510 VGND.t589 347.144
R2436 VGND.n513 VGND.t664 347.144
R2437 VGND.t238 VGND.n457 347.144
R2438 VGND.t1482 VGND.n547 347.144
R2439 VGND.t1512 VGND.n542 347.144
R2440 VGND.n600 VGND.t651 347.144
R2441 VGND.n605 VGND.t596 347.144
R2442 VGND.t1345 VGND.n10 183.806
R2443 VGND.t1369 VGND.n10 183.804
R2444 VGND.t1404 VGND.n10 183.806
R2445 VGND.t1578 VGND.t833 334.286
R2446 VGND.t834 VGND.t1579 334.286
R2447 VGND.t1580 VGND.t835 334.286
R2448 VGND.t876 VGND.t29 334.286
R2449 VGND.t804 VGND.n130 334.286
R2450 VGND.t447 VGND.t604 334.286
R2451 VGND.t605 VGND.t448 334.286
R2452 VGND.t449 VGND.t606 334.286
R2453 VGND.t640 VGND.t701 334.286
R2454 VGND.t702 VGND.t641 334.286
R2455 VGND.t642 VGND.t703 334.286
R2456 VGND.t242 VGND.t417 334.286
R2457 VGND.t621 VGND.n453 334.286
R2458 VGND.n803 VGND.t1462 332.512
R2459 VGND.t1463 VGND.n801 332.512
R2460 VGND.n27 VGND.n30 12.5835
R2461 VGND.t622 VGND.n333 328.56
R2462 VGND.t36 VGND.n414 328.56
R2463 VGND.t1493 VGND.n16 328.56
R2464 VGND.n17 VGND.t1476 328.56
R2465 VGND.n770 VGND.t1574 321.43
R2466 VGND.n653 VGND.t821 321.43
R2467 VGND.n661 VGND.t430 321.43
R2468 VGND.t350 VGND.n118 321.43
R2469 VGND.t347 VGND.n108 321.43
R2470 VGND.n681 VGND.t82 321.43
R2471 VGND.n685 VGND.t92 321.43
R2472 VGND.n220 VGND.t533 321.43
R2473 VGND.n225 VGND.t235 321.43
R2474 VGND.t774 VGND.n182 321.43
R2475 VGND.n237 VGND.t783 321.43
R2476 VGND.t555 VGND.n173 321.43
R2477 VGND.t564 VGND.n169 321.43
R2478 VGND.n299 VGND.t46 321.43
R2479 VGND.n303 VGND.t56 321.43
R2480 VGND.n308 VGND.t283 321.43
R2481 VGND.t292 VGND.n282 321.43
R2482 VGND.t582 VGND.n266 321.43
R2483 VGND.n381 VGND.t266 321.43
R2484 VGND.n389 VGND.t764 321.43
R2485 VGND.t160 VGND.n351 321.43
R2486 VGND.t169 VGND.n347 321.43
R2487 VGND.n491 VGND.t450 321.43
R2488 VGND.n497 VGND.t619 321.43
R2489 VGND.t697 VGND.n467 321.43
R2490 VGND.n516 VGND.t670 321.43
R2491 VGND.n595 VGND.t1492 321.43
R2492 VGND.t661 VGND.n533 321.43
R2493 VGND.t479 VGND.n198 320.613
R2494 VGND.n720 VGND.t416 319.99
R2495 VGND.n393 VGND.t74 319.99
R2496 VGND.n443 VGND.t627 319.99
R2497 VGND.t663 VGND.n36 77.2375
R2498 VGND.t1419 VGND.n10 183.806
R2499 VGND.n10 VGND.t1411 182.042
R2500 VGND.t1406 VGND.n10 182.042
R2501 VGND.t1396 VGND.n10 182.042
R2502 VGND.n10 VGND.t1391 182.042
R2503 VGND.n10 VGND.t1389 183.806
R2504 VGND.n10 VGND.t1381 182.042
R2505 VGND.t1376 VGND.n10 182.042
R2506 VGND.n10 VGND.t1371 182.042
R2507 VGND.n10 VGND.t1365 183.806
R2508 VGND.n10 VGND.t1357 182.042
R2509 VGND.n10 VGND.t1355 183.806
R2510 VGND.n10 VGND.t1347 182.042
R2511 VGND.n10 VGND.t1337 181.875
R2512 VGND.t772 VGND.t151 317.144
R2513 VGND.t868 VGND.n700 312.858
R2514 VGND.n688 VGND.t710 312.858
R2515 VGND.t636 VGND.n88 312.858
R2516 VGND.n49 VGND.t34 320.065
R2517 VGND.t765 VGND.n635 312.858
R2518 VGND.n412 VGND.t282 312.858
R2519 VGND.t707 VGND.n424 312.858
R2520 VGND.n47 VGND.t894 320.721
R2521 VGND.t1425 VGND.n552 312.858
R2522 VGND.t1496 VGND.n610 312.858
R2523 VGND.t838 VGND.t1540 308.572
R2524 VGND.t1541 VGND.t839 308.572
R2525 VGND.t852 VGND.t1542 308.572
R2526 VGND.t865 VGND.t1556 308.572
R2527 VGND.t24 VGND.t866 308.572
R2528 VGND.t867 VGND.t26 308.572
R2529 VGND.t360 VGND.t335 308.572
R2530 VGND.t336 VGND.t361 308.572
R2531 VGND.t362 VGND.t337 308.572
R2532 VGND.t338 VGND.t363 308.572
R2533 VGND.t1468 VGND.t874 308.572
R2534 VGND.t875 VGND.t1469 308.572
R2535 VGND.t1470 VGND.t877 308.572
R2536 VGND.t1444 VGND.t890 308.572
R2537 VGND.t892 VGND.t1445 308.572
R2538 VGND.t1446 VGND.t893 308.572
R2539 VGND.t478 VGND.n637 304.286
R2540 VGND.t28 VGND.t832 300
R2541 VGND.t236 VGND.t241 300
R2542 VGND.t1566 VGND.n739 295.714
R2543 VGND.t1573 VGND.n736 295.714
R2544 VGND.n775 VGND.t853 295.714
R2545 VGND.t1555 VGND.n724 295.714
R2546 VGND.n665 VGND.t352 295.714
R2547 VGND.n668 VGND.t359 295.714
R2548 VGND.n671 VGND.t339 295.714
R2549 VGND.n674 VGND.t346 295.714
R2550 VGND.t83 VGND.n99 295.714
R2551 VGND.t91 VGND.n96 295.714
R2552 VGND.t534 VGND.n194 295.714
R2553 VGND.t234 VGND.n190 295.714
R2554 VGND.n234 VGND.t775 295.714
R2555 VGND.t782 VGND.n177 295.714
R2556 VGND.n241 VGND.t556 295.714
R2557 VGND.n244 VGND.t563 295.714
R2558 VGND.t47 VGND.n294 295.714
R2559 VGND.t55 VGND.n291 295.714
R2560 VGND.t284 VGND.n285 295.714
R2561 VGND.n311 VGND.t291 295.714
R2562 VGND.t100 VGND.n275 295.714
R2563 VGND.n326 VGND.t581 295.714
R2564 VGND.n398 VGND.t161 295.714
R2565 VGND.n401 VGND.t168 295.714
R2566 VGND.t451 VGND.n485 295.714
R2567 VGND.t618 VGND.n480 295.714
R2568 VGND.n506 VGND.t689 295.714
R2569 VGND.n509 VGND.t696 295.714
R2570 VGND.t671 VGND.n461 295.714
R2571 VGND.t679 VGND.n458 295.714
R2572 VGND.t878 VGND.n561 295.714
R2573 VGND.n583 VGND.t1443 295.714
R2574 VGND.t1484 VGND.n546 295.714
R2575 VGND.n601 VGND.t653 295.714
R2576 VGND.n604 VGND.t660 295.714
R2577 VGND.n804 VGND.t1461 288.178
R2578 VGND.t1464 VGND.n800 288.178
R2579 VGND.n784 VGND.t33 287.144
R2580 VGND.n317 VGND.t4 287.144
R2581 VGND.t299 VGND.n262 287.144
R2582 VGND.n392 VGND.t73 287.144
R2583 VGND.n501 VGND.t705 287.144
R2584 VGND.t203 VGND.n527 287.144
R2585 VGND.t108 VGND.t1521 282.858
R2586 VGND.t1522 VGND.t109 282.858
R2587 VGND.t110 VGND.t1523 282.858
R2588 VGND.t573 VGND.t111 282.858
R2589 VGND.t112 VGND.t574 282.858
R2590 VGND.n767 VGND.t1567 270
R2591 VGND.t854 VGND.n729 270
R2592 VGND.n780 VGND.t1554 270
R2593 VGND.t358 VGND.n115 270
R2594 VGND.t340 VGND.n111 270
R2595 VGND.n682 VGND.t84 270
R2596 VGND.n684 VGND.t90 270
R2597 VGND.n221 VGND.t535 270
R2598 VGND.n224 VGND.t233 270
R2599 VGND.n178 VGND.t781 270
R2600 VGND.t557 VGND.n172 270
R2601 VGND.n300 VGND.t48 270
R2602 VGND.n302 VGND.t54 270
R2603 VGND.t285 VGND.n284 270
R2604 VGND.t290 VGND.t16 270
R2605 VGND.n318 VGND.t101 270
R2606 VGND.n320 VGND.t107 270
R2607 VGND.t575 VGND.n269 270
R2608 VGND.t580 VGND.n267 270
R2609 VGND.t162 VGND.n350 270
R2610 VGND.t167 VGND.n348 270
R2611 VGND.n492 VGND.t452 270
R2612 VGND.n496 VGND.t617 270
R2613 VGND.t690 VGND.n470 270
R2614 VGND.n519 VGND.t678 270
R2615 VGND.n578 VGND.t879 270
R2616 VGND.t1442 VGND.n555 270
R2617 VGND.n592 VGND.t1485 270
R2618 VGND.n594 VGND.t1490 270
R2619 VGND.t654 VGND.n536 270
R2620 VGND.n747 VGND.t1276 252.065
R2621 VGND.t1278 VGND.n749 252.065
R2622 VGND.n745 VGND.t1280 252.065
R2623 VGND.n751 VGND.t1313 252.065
R2624 VGND.t1198 VGND.n138 252.065
R2625 VGND.n135 VGND.t1200 252.065
R2626 VGND.t1202 VGND.n140 252.065
R2627 VGND.t1143 VGND.n207 252.065
R2628 VGND.n204 VGND.t1145 252.065
R2629 VGND.t1148 VGND.n209 252.065
R2630 VGND.n202 VGND.t1150 252.065
R2631 VGND.t1104 VGND.t5 108.999
R2632 VGND.n373 VGND.t1052 252.065
R2633 VGND.t1054 VGND.n375 252.065
R2634 VGND.n371 VGND.t1056 252.065
R2635 VGND.n377 VGND.t1058 252.065
R2636 VGND.n342 VGND.t1063 252.065
R2637 VGND.t1065 VGND.n406 252.065
R2638 VGND.n340 VGND.t1067 252.065
R2639 VGND.t1069 VGND.n408 252.065
R2640 VGND.n338 VGND.t1071 252.065
R2641 VGND.t944 VGND.n437 252.065
R2642 VGND.n434 VGND.t946 252.065
R2643 VGND.t949 VGND.n439 252.065
R2644 VGND.t984 VGND.n449 252.065
R2645 VGND.n754 VGND.t1321 252.041
R2646 VGND.t1323 VGND.n715 252.041
R2647 VGND.n756 VGND.t1325 252.041
R2648 VGND.t1327 VGND.n711 252.041
R2649 VGND.n758 VGND.t1329 252.041
R2650 VGND.t1331 VGND.n707 252.041
R2651 VGND.n760 VGND.t1333 252.041
R2652 VGND.t1335 VGND.n703 252.041
R2653 VGND.n148 VGND.t1207 252.041
R2654 VGND.t1187 VGND.n162 252.041
R2655 VGND.n251 VGND.t1189 252.041
R2656 VGND.t1191 VGND.n158 252.041
R2657 VGND.t1193 VGND.n255 252.041
R2658 VGND.t1060 VGND.n343 252.041
R2659 VGND.n448 VGND.t956 252.041
R2660 VGND.t928 VGND.n28 108.945
R2661 VGND.n27 VGND.n29 0.369499
R2662 VGND.n40 VGND.n27 9.63482
R2663 VGND.t1273 VGND.n80 251.417
R2664 VGND.n137 VGND.t1195 251.417
R2665 VGND.t1205 VGND.n144 251.417
R2666 VGND.t1231 VGND.n151 251.417
R2667 VGND.t1211 VGND.n152 251.417
R2668 VGND.n206 VGND.t1140 251.417
R2669 VGND.n164 VGND.t1185 251.417
R2670 VGND.t5 VGND.t1100 108.722
R2671 VGND.t1112 VGND.n7 251.417
R2672 VGND.t1135 VGND.n8 251.417
R2673 VGND.t1049 VGND.n261 251.417
R2674 VGND.n436 VGND.t941 251.417
R2675 VGND.t976 VGND.n429 251.417
R2676 VGND.t958 VGND.n451 251.417
R2677 VGND.n44 VGND.t897 108.722
R2678 VGND.n24 VGND.t902 251.417
R2679 VGND.n26 VGND.t915 251.417
R2680 VGND.t1571 VGND.n737 244.286
R2681 VGND.n776 VGND.t855 244.286
R2682 VGND.t1553 VGND.n725 244.286
R2683 VGND.n666 VGND.t354 244.286
R2684 VGND.n667 VGND.t357 244.286
R2685 VGND.n672 VGND.t341 244.286
R2686 VGND.n673 VGND.t344 244.286
R2687 VGND.t85 VGND.n98 244.286
R2688 VGND.t89 VGND.n97 244.286
R2689 VGND.t536 VGND.n193 244.286
R2690 VGND.t232 VGND.n191 244.286
R2691 VGND.n235 VGND.t777 244.286
R2692 VGND.n236 VGND.t780 244.286
R2693 VGND.n242 VGND.t558 244.286
R2694 VGND.n243 VGND.t561 244.286
R2695 VGND.t49 VGND.n293 244.286
R2696 VGND.t53 VGND.n292 244.286
R2697 VGND.n310 VGND.t289 244.286
R2698 VGND.t102 VGND.n274 244.286
R2699 VGND.t106 VGND.n273 244.286
R2700 VGND.n324 VGND.t576 244.286
R2701 VGND.n325 VGND.t579 244.286
R2702 VGND.n399 VGND.t163 244.286
R2703 VGND.n400 VGND.t166 244.286
R2704 VGND.t453 VGND.n484 244.286
R2705 VGND.t616 VGND.n481 244.286
R2706 VGND.n507 VGND.t691 244.286
R2707 VGND.n508 VGND.t694 244.286
R2708 VGND.t673 VGND.n460 244.286
R2709 VGND.t880 VGND.n560 244.286
R2710 VGND.n582 VGND.t1441 244.286
R2711 VGND.t1489 VGND.n544 244.286
R2712 VGND.n602 VGND.t655 244.286
R2713 VGND.n603 VGND.t658 244.286
R2714 VGND.n805 VGND.t1460 243.843
R2715 VGND.t1465 VGND.n799 243.843
R2716 VGND.n1 VGND.t1136 109.644
R2717 VGND.t1275 VGND.n747 243.494
R2718 VGND.n749 VGND.t1277 243.494
R2719 VGND.t1279 VGND.n745 243.494
R2720 VGND.n751 VGND.t1282 243.494
R2721 VGND.n762 VGND.t1303 243.494
R2722 VGND.n138 VGND.t1197 243.494
R2723 VGND.t1199 VGND.n135 243.494
R2724 VGND.n140 VGND.t1201 243.494
R2725 VGND.t1203 VGND.n132 243.494
R2726 VGND.n149 VGND.t1209 243.494
R2727 VGND.n207 VGND.t1142 243.494
R2728 VGND.t1144 VGND.n204 243.494
R2729 VGND.n209 VGND.t1146 243.494
R2730 VGND.t1149 VGND.n202 243.494
R2731 VGND.n211 VGND.t1151 243.494
R2732 VGND.t1101 VGND.t5 109.986
R2733 VGND.t5 VGND.t1103 109.992
R2734 VGND.t1051 VGND.n373 243.494
R2735 VGND.n375 VGND.t1053 243.494
R2736 VGND.t1055 VGND.n371 243.494
R2737 VGND.n377 VGND.t1057 243.494
R2738 VGND.t1062 VGND.n342 243.494
R2739 VGND.n406 VGND.t1064 243.494
R2740 VGND.t1066 VGND.n340 243.494
R2741 VGND.n408 VGND.t1068 243.494
R2742 VGND.t1070 VGND.n338 243.494
R2743 VGND.n410 VGND.t1072 243.494
R2744 VGND.n437 VGND.t943 243.494
R2745 VGND.t945 VGND.n434 243.494
R2746 VGND.n439 VGND.t947 243.494
R2747 VGND.t950 VGND.n432 243.494
R2748 VGND.n449 VGND.t957 243.494
R2749 VGND.n27 VGND.t899 109.986
R2750 VGND.t1301 VGND.n703 243.47
R2751 VGND.n760 VGND.t1299 243.47
R2752 VGND.t1295 VGND.n707 243.47
R2753 VGND.n758 VGND.t1293 243.47
R2754 VGND.t1289 VGND.n711 243.47
R2755 VGND.n756 VGND.t1287 243.47
R2756 VGND.t1284 VGND.n715 243.47
R2757 VGND.n146 VGND.t1206 243.47
R2758 VGND.n255 VGND.t1169 243.47
R2759 VGND.t1166 VGND.n158 243.47
R2760 VGND.n251 VGND.t1163 243.47
R2761 VGND.t1160 VGND.n162 243.47
R2762 VGND.t5 VGND.n38 9.30721
R2763 VGND.t5 VGND.t1110 109.981
R2764 VGND.n27 VGND.n34 9.30721
R2765 VGND.t901 VGND.n28 243.583
R2766 VGND.n144 VGND.t1225 242.846
R2767 VGND.t1232 VGND.n90 242.846
R2768 VGND.t1212 VGND.n89 242.846
R2769 VGND.n7 VGND.t1134 242.846
R2770 VGND.t987 VGND.n426 242.846
R2771 VGND.t959 VGND.n425 242.846
R2772 VGND.t300 VGND.n49 101.418
R2773 VGND.n754 VGND.t32 239.185
R2774 VGND.n39 VGND.n27 9.14339
R2775 VGND.n769 VGND.t1317 235.714
R2776 VGND.t1319 VGND.n719 235.714
R2777 VGND.t1283 VGND.n716 235.714
R2778 VGND.n787 VGND.t1285 235.714
R2779 VGND.t1288 VGND.n712 235.714
R2780 VGND.n789 VGND.t1291 235.714
R2781 VGND.t1294 VGND.n708 235.714
R2782 VGND.n791 VGND.t1297 235.714
R2783 VGND.t1300 VGND.n704 235.714
R2784 VGND.n793 VGND.t1302 235.714
R2785 VGND.t1221 VGND.n109 235.714
R2786 VGND.n229 VGND.t1155 235.714
R2787 VGND.t1183 VGND.n168 235.714
R2788 VGND.t1159 VGND.n163 235.714
R2789 VGND.n250 VGND.t1161 235.714
R2790 VGND.t1164 VGND.n159 235.714
R2791 VGND.n254 VGND.t1168 235.714
R2792 VGND.t1129 VGND.n32 238.173
R2793 VGND.n312 VGND.t1131 235.714
R2794 VGND.n637 VGND.t1137 235.714
R2795 VGND.t1075 VGND.n332 235.714
R2796 VGND.t954 VGND.t709 235.714
R2797 VGND.t974 VGND.n466 235.714
R2798 VGND.t980 VGND.n459 235.714
R2799 VGND.t986 VGND.n453 235.714
R2800 VGND.t1506 VGND.t900 235.714
R2801 VGND.t905 VGND.n543 235.714
R2802 VGND.t913 VGND.n532 235.714
R2803 VGND.n36 VGND.t918 239.81
R2804 VGND.n40 VGND.t933 242.431
R2805 VGND.t935 VGND.n35 243.578
R2806 VGND.t822 VGND.t796 231.429
R2807 VGND.t798 VGND.t823 231.429
R2808 VGND.t824 VGND.t799 231.429
R2809 VGND.t427 VGND.t1562 231.429
R2810 VGND.t1563 VGND.t428 231.429
R2811 VGND.t429 VGND.t1564 231.429
R2812 VGND.t267 VGND.t749 231.429
R2813 VGND.t750 VGND.t268 231.429
R2814 VGND.t269 VGND.t751 231.429
R2815 VGND.t761 VGND.t69 231.429
R2816 VGND.t70 VGND.t762 231.429
R2817 VGND.t763 VGND.t71 231.429
R2818 VGND.n764 VGND.t1314 227.143
R2819 VGND.t1316 VGND.n738 227.143
R2820 VGND.t1320 VGND.n717 227.143
R2821 VGND.n786 VGND.t1322 227.143
R2822 VGND.t1324 VGND.n713 227.143
R2823 VGND.n788 VGND.t1326 227.143
R2824 VGND.t1328 VGND.n709 227.143
R2825 VGND.n790 VGND.t1330 227.143
R2826 VGND.t1332 VGND.n705 227.143
R2827 VGND.n792 VGND.t1334 227.143
R2828 VGND.t1336 VGND.n701 227.143
R2829 VGND.n688 VGND.t1230 227.143
R2830 VGND.t1153 VGND.n200 227.143
R2831 VGND.t1158 VGND.n180 227.143
R2832 VGND.t1184 VGND.n166 227.143
R2833 VGND.n249 VGND.t1186 227.143
R2834 VGND.t1188 VGND.n160 227.143
R2835 VGND.n253 VGND.t1190 227.143
R2836 VGND.t1192 VGND.n156 227.143
R2837 VGND.t1130 VGND.n287 227.143
R2838 VGND.n314 VGND.t1132 227.143
R2839 VGND.n379 VGND.t1059 227.143
R2840 VGND.t1099 VGND.n332 227.143
R2841 VGND.t971 VGND.n471 227.143
R2842 VGND.t975 VGND.n465 227.143
R2843 VGND.n517 VGND.t979 227.143
R2844 VGND.n619 VGND.t985 227.143
R2845 VGND.t929 VGND.n30 230.911
R2846 VGND.n589 VGND.t903 227.143
R2847 VGND.t910 VGND.n537 227.143
R2848 VGND.t914 VGND.n531 227.143
R2849 VGND.n19 VGND.t916 109.639
R2850 VGND.n39 VGND.t919 234.351
R2851 VGND.t921 VGND.n34 234.188
R2852 VGND.n41 VGND.t938 102.457
R2853 VGND.t174 VGND.t1223 222.857
R2854 VGND.t308 VGND.n200 222.857
R2855 VGND.t586 VGND.t1133 222.857
R2856 VGND.n390 VGND.t72 222.857
R2857 VGND.t970 VGND.t685 222.857
R2858 VGND.t909 VGND.t649 222.857
R2859 VGND.n762 VGND.t1304 222.065
R2860 VGND.t1210 VGND.n149 222.065
R2861 VGND.t1180 VGND.n211 222.065
R2862 VGND.t1074 VGND.n410 222.065
R2863 VGND.t951 VGND.n432 222.065
R2864 VGND.t927 VGND.n47 102.709
R2865 VGND.n27 VGND.n42 96.0268
R2866 VGND.n411 VGND.t1074 222.042
R2867 VGND.t5 VGND.t1111 222.041
R2868 VGND.n37 VGND.t1116 102.703
R2869 VGND.n27 VGND.n35 8.48812
R2870 VGND.t1226 VGND.n145 221.417
R2871 VGND.n89 VGND.t1233 221.417
R2872 VGND.t1139 VGND.n0 221.417
R2873 VGND.n425 VGND.t988 221.417
R2874 VGND.n17 VGND.t939 221.417
R2875 VGND.n768 VGND.t1569 218.571
R2876 VGND.n768 VGND.t1570 218.571
R2877 VGND.t856 VGND.n728 218.571
R2878 VGND.n779 VGND.t1552 218.571
R2879 VGND.n655 VGND.t825 218.571
R2880 VGND.n659 VGND.t426 218.571
R2881 VGND.t355 VGND.n116 218.571
R2882 VGND.t356 VGND.n116 218.571
R2883 VGND.t342 VGND.n110 218.571
R2884 VGND.t343 VGND.n110 218.571
R2885 VGND.n683 VGND.t87 218.571
R2886 VGND.n683 VGND.t88 218.571
R2887 VGND.n222 VGND.t537 218.571
R2888 VGND.n223 VGND.t230 218.571
R2889 VGND.t778 VGND.n179 218.571
R2890 VGND.t779 VGND.n179 218.571
R2891 VGND.t560 VGND.n171 218.571
R2892 VGND.n301 VGND.t51 218.571
R2893 VGND.n301 VGND.t52 218.571
R2894 VGND.t288 VGND.n283 218.571
R2895 VGND.n319 VGND.t105 218.571
R2896 VGND.t577 VGND.n268 218.571
R2897 VGND.n383 VGND.t270 218.571
R2898 VGND.n387 VGND.t760 218.571
R2899 VGND.t164 VGND.n349 218.571
R2900 VGND.t165 VGND.n349 218.571
R2901 VGND.n493 VGND.t455 218.571
R2902 VGND.n495 VGND.t615 218.571
R2903 VGND.t693 VGND.n469 218.571
R2904 VGND.n518 VGND.t674 218.571
R2905 VGND.n518 VGND.t675 218.571
R2906 VGND.n579 VGND.t881 218.571
R2907 VGND.t1440 VGND.n556 218.571
R2908 VGND.n593 VGND.t1488 218.571
R2909 VGND.t657 VGND.n535 218.571
R2910 VGND.t10 VGND.t1156 214.286
R2911 VGND.t977 VGND.t666 214.286
R2912 VGND.t769 VGND.t8 210
R2913 VGND.t1304 VGND.n700 205.714
R2914 VGND.t800 VGND.t826 205.714
R2915 VGND.t827 VGND.t802 205.714
R2916 VGND.t803 VGND.t828 205.714
R2917 VGND.t829 VGND.t421 205.714
R2918 VGND.t422 VGND.t830 205.714
R2919 VGND.t1559 VGND.t423 205.714
R2920 VGND.t424 VGND.t1560 205.714
R2921 VGND.t1561 VGND.t425 205.714
R2922 VGND.t1204 VGND.n117 205.714
R2923 VGND.n678 VGND.t1226 205.714
R2924 VGND.t1233 VGND.n88 205.714
R2925 VGND.t1154 VGND.n199 205.714
R2926 VGND.n37 VGND.t1139 213.578
R2927 VGND.t752 VGND.t271 205.714
R2928 VGND.t272 VGND.t753 205.714
R2929 VGND.t754 VGND.t273 205.714
R2930 VGND.t274 VGND.t755 205.714
R2931 VGND.t756 VGND.t275 205.714
R2932 VGND.t65 VGND.t757 205.714
R2933 VGND.t758 VGND.t67 205.714
R2934 VGND.t68 VGND.t759 205.714
R2935 VGND.t625 VGND.t952 205.714
R2936 VGND.t988 VGND.n424 205.714
R2937 VGND.n591 VGND.t904 205.714
R2938 VGND.t922 VGND.n35 102.703
R2939 VGND.t939 VGND.n610 205.714
R2940 VGND.n213 VGND.t308 204.274
R2941 VGND.n748 VGND.t1275 200.613
R2942 VGND.t1277 VGND.n746 200.613
R2943 VGND.n750 VGND.t1279 200.613
R2944 VGND.t1282 VGND.n744 200.613
R2945 VGND.t1197 VGND.n136 200.613
R2946 VGND.n139 VGND.t1199 200.613
R2947 VGND.t1201 VGND.n134 200.613
R2948 VGND.n141 VGND.t1203 200.613
R2949 VGND.t1209 VGND.n92 200.613
R2950 VGND.t1230 VGND.n150 200.613
R2951 VGND.t1142 VGND.n205 200.613
R2952 VGND.n208 VGND.t1144 200.613
R2953 VGND.t1146 VGND.n203 200.613
R2954 VGND.n210 VGND.t1149 200.613
R2955 VGND.t1151 VGND.n201 200.613
R2956 VGND.n212 VGND.t1153 200.613
R2957 VGND.n256 VGND.t1194 200.613
R2958 VGND.t5 VGND.t1105 109.993
R2959 VGND.n374 VGND.t1051 200.613
R2960 VGND.t1053 VGND.n372 200.613
R2961 VGND.n376 VGND.t1055 200.613
R2962 VGND.t1057 VGND.n370 200.613
R2963 VGND.n405 VGND.t1062 200.613
R2964 VGND.t1064 VGND.n341 200.613
R2965 VGND.n407 VGND.t1066 200.613
R2966 VGND.t1068 VGND.n339 200.613
R2967 VGND.n409 VGND.t1070 200.613
R2968 VGND.t1072 VGND.n337 200.613
R2969 VGND.t943 VGND.n435 200.613
R2970 VGND.n438 VGND.t945 200.613
R2971 VGND.t947 VGND.n433 200.613
R2972 VGND.n440 VGND.t950 200.613
R2973 VGND.n445 VGND.t955 200.613
R2974 VGND.t969 VGND.n431 200.613
R2975 VGND.t957 VGND.n427 200.613
R2976 VGND.n41 VGND.n27 7.66905
R2977 VGND.t1322 VGND.n755 199.989
R2978 VGND.n714 VGND.t1324 199.989
R2979 VGND.t1326 VGND.n757 199.989
R2980 VGND.n710 VGND.t1328 199.989
R2981 VGND.t1330 VGND.n759 199.989
R2982 VGND.n706 VGND.t1332 199.989
R2983 VGND.t1334 VGND.n761 199.989
R2984 VGND.n702 VGND.t1336 199.989
R2985 VGND.n90 VGND.t1212 199.989
R2986 VGND.t1186 VGND.n248 199.989
R2987 VGND.n161 VGND.t1188 199.989
R2988 VGND.t1190 VGND.n252 199.989
R2989 VGND.n157 VGND.t1192 199.989
R2990 VGND.n1 VGND.t1114 243.139
R2991 VGND.n333 VGND.t1099 199.989
R2992 VGND.t953 VGND.n443 199.989
R2993 VGND.n426 VGND.t959 199.989
R2994 VGND.t908 VGND.n21 199.989
R2995 VGND.n19 VGND.t201 54.5677
R2996 VGND.n15 VGND.t921 199.989
R2997 VGND.n806 VGND.t1459 199.507
R2998 VGND.t1466 VGND.n798 199.507
R2999 VGND.t1098 VGND.t628 197.143
R3000 VGND.t1516 VGND.t907 197.143
R3001 VGND.t1569 VGND.n738 192.857
R3002 VGND.t1570 VGND.n737 192.857
R3003 VGND.n777 VGND.t857 192.857
R3004 VGND.t1551 VGND.n726 192.857
R3005 VGND.t825 VGND.n128 192.857
R3006 VGND.t826 VGND.n127 192.857
R3007 VGND.t425 VGND.n124 192.857
R3008 VGND.t426 VGND.n123 192.857
R3009 VGND.n666 VGND.t355 192.857
R3010 VGND.n673 VGND.t343 192.857
R3011 VGND.t87 VGND.n98 192.857
R3012 VGND.t88 VGND.n97 192.857
R3013 VGND.t538 VGND.n192 192.857
R3014 VGND.t229 VGND.n192 192.857
R3015 VGND.n235 VGND.t778 192.857
R3016 VGND.n236 VGND.t779 192.857
R3017 VGND.n242 VGND.t559 192.857
R3018 VGND.n243 VGND.t560 192.857
R3019 VGND.t51 VGND.n293 192.857
R3020 VGND.t52 VGND.n292 192.857
R3021 VGND.n309 VGND.t287 192.857
R3022 VGND.t104 VGND.n274 192.857
R3023 VGND.n325 VGND.t578 192.857
R3024 VGND.t270 VGND.n364 192.857
R3025 VGND.t271 VGND.n363 192.857
R3026 VGND.t759 VGND.n360 192.857
R3027 VGND.t760 VGND.n359 192.857
R3028 VGND.n399 VGND.t164 192.857
R3029 VGND.n400 VGND.t165 192.857
R3030 VGND.t456 VGND.n483 192.857
R3031 VGND.t614 VGND.n482 192.857
R3032 VGND.n507 VGND.t692 192.857
R3033 VGND.n508 VGND.t693 192.857
R3034 VGND.t674 VGND.n460 192.857
R3035 VGND.t675 VGND.n459 192.857
R3036 VGND.t882 VGND.n559 192.857
R3037 VGND.n581 VGND.t1439 192.857
R3038 VGND.t1487 VGND.n545 192.857
R3039 VGND.t1488 VGND.n544 192.857
R3040 VGND.n602 VGND.t656 192.857
R3041 VGND.n603 VGND.t657 192.857
R3042 VGND.t1280 VGND.n744 192.042
R3043 VGND.n750 VGND.t1278 192.042
R3044 VGND.t1276 VGND.n746 192.042
R3045 VGND.n748 VGND.t1273 192.042
R3046 VGND.n150 VGND.t1229 192.042
R3047 VGND.t1207 VGND.n92 192.042
R3048 VGND.n141 VGND.t1202 192.042
R3049 VGND.t1200 VGND.n134 192.042
R3050 VGND.n139 VGND.t1198 192.042
R3051 VGND.t1195 VGND.n136 192.042
R3052 VGND.n256 VGND.t1193 192.042
R3053 VGND.n212 VGND.t1152 192.042
R3054 VGND.t1150 VGND.n201 192.042
R3055 VGND.n210 VGND.t1148 192.042
R3056 VGND.t1145 VGND.n203 192.042
R3057 VGND.n208 VGND.t1143 192.042
R3058 VGND.t1140 VGND.n205 192.042
R3059 VGND.t1109 VGND.t5 108.965
R3060 VGND.t1106 VGND.t5 109.001
R3061 VGND.t1102 VGND.t5 109.001
R3062 VGND.t1071 VGND.n337 192.042
R3063 VGND.n409 VGND.t1069 192.042
R3064 VGND.t1067 VGND.n339 192.042
R3065 VGND.n407 VGND.t1065 192.042
R3066 VGND.t1063 VGND.n341 192.042
R3067 VGND.n405 VGND.t1060 192.042
R3068 VGND.t1056 VGND.n370 192.042
R3069 VGND.n376 VGND.t1054 192.042
R3070 VGND.t1052 VGND.n372 192.042
R3071 VGND.n374 VGND.t1049 192.042
R3072 VGND.t956 VGND.n427 192.042
R3073 VGND.t968 VGND.n431 192.042
R3074 VGND.n445 VGND.t954 192.042
R3075 VGND.n440 VGND.t949 192.042
R3076 VGND.t946 VGND.n433 192.042
R3077 VGND.n438 VGND.t944 192.042
R3078 VGND.t941 VGND.n435 192.042
R3079 VGND.n450 VGND.t984 192.042
R3080 VGND.t937 VGND.n42 12.9737
R3081 VGND.n27 VGND.n28 0.0870047
R3082 VGND.n27 VGND.n44 0.281786
R3083 VGND.n755 VGND.t1283 191.417
R3084 VGND.t1285 VGND.n714 191.417
R3085 VGND.n757 VGND.t1288 191.417
R3086 VGND.t1291 VGND.n710 191.417
R3087 VGND.n759 VGND.t1294 191.417
R3088 VGND.t1297 VGND.n706 191.417
R3089 VGND.n761 VGND.t1300 191.417
R3090 VGND.t1302 VGND.n702 191.417
R3091 VGND.n145 VGND.t1205 191.417
R3092 VGND.n152 VGND.t1231 191.417
R3093 VGND.n248 VGND.t1159 191.417
R3094 VGND.t1161 VGND.n161 191.417
R3095 VGND.n252 VGND.t1164 191.417
R3096 VGND.t1168 VGND.n157 191.417
R3097 VGND.n8 VGND.t1112 191.417
R3098 VGND.n414 VGND.t1075 191.417
R3099 VGND.n451 VGND.t986 191.417
R3100 VGND.t930 VGND.n29 108.635
R3101 VGND.t933 VGND.n15 191.417
R3102 VGND.n16 VGND.t935 191.417
R3103 VGND.t32 VGND.n717 188.571
R3104 VGND.t8 VGND.n277 188.571
R3105 VGND.t1076 VGND.t45 188.571
R3106 VGND.t704 VGND.n477 188.571
R3107 VGND.t932 VGND.t871 188.571
R3108 VGND.t906 VGND.t1513 188.571
R3109 VGND.n39 VGND.t205 101.412
R3110 VGND.t936 VGND.t1434 188.571
R3111 VGND.t1314 VGND.n742 184.286
R3112 VGND.t1318 VGND.n735 184.286
R3113 VGND.n785 VGND.t1320 184.286
R3114 VGND.n786 VGND.t1284 184.286
R3115 VGND.t1287 VGND.n713 184.286
R3116 VGND.n788 VGND.t1289 184.286
R3117 VGND.t1293 VGND.n709 184.286
R3118 VGND.n790 VGND.t1295 184.286
R3119 VGND.t1299 VGND.n705 184.286
R3120 VGND.n792 VGND.t1301 184.286
R3121 VGND.t1303 VGND.n701 184.286
R3122 VGND.n675 VGND.t1222 184.286
R3123 VGND.t1225 VGND.n104 184.286
R3124 VGND.t1206 VGND.n678 184.286
R3125 VGND.n689 VGND.t1232 184.286
R3126 VGND.t1156 VGND.n184 184.286
R3127 VGND.t1182 VGND.n170 184.286
R3128 VGND.n249 VGND.t1160 184.286
R3129 VGND.t1163 VGND.n160 184.286
R3130 VGND.n253 VGND.t1166 184.286
R3131 VGND.t1169 VGND.n156 184.286
R3132 VGND.t1132 VGND.n280 184.286
R3133 VGND.t1134 VGND.n264 184.286
R3134 VGND.n330 VGND.t1114 184.286
R3135 VGND.t1138 VGND.n38 100.883
R3136 VGND.t1059 VGND.n368 184.286
R3137 VGND.n415 VGND.t1076 184.286
R3138 VGND.t644 VGND.t704 184.286
R3139 VGND.t973 VGND.n468 184.286
R3140 VGND.n514 VGND.t977 184.286
R3141 VGND.n520 VGND.t981 184.286
R3142 VGND.t985 VGND.t512 184.286
R3143 VGND.n621 VGND.t987 184.286
R3144 VGND.n575 VGND.t932 184.286
R3145 VGND.t903 VGND.n549 184.286
R3146 VGND.n596 VGND.t906 184.286
R3147 VGND.t912 VGND.n534 184.286
R3148 VGND.t919 VGND.n526 184.286
R3149 VGND.t934 VGND.n34 100.883
R3150 VGND.n529 VGND.t936 184.286
R3151 VGND.t1451 VGND.t1487 180
R3152 VGND.n766 VGND.t1315 175.714
R3153 VGND.t1321 VGND.n716 175.714
R3154 VGND.n787 VGND.t1323 175.714
R3155 VGND.t1325 VGND.n712 175.714
R3156 VGND.n789 VGND.t1327 175.714
R3157 VGND.t1329 VGND.n708 175.714
R3158 VGND.n791 VGND.t1331 175.714
R3159 VGND.t1333 VGND.n704 175.714
R3160 VGND.n793 VGND.t1335 175.714
R3161 VGND.t1223 VGND.n105 175.714
R3162 VGND.n689 VGND.t1211 175.714
R3163 VGND.t1155 VGND.n185 175.714
R3164 VGND.n233 VGND.t1157 175.714
R3165 VGND.t1181 VGND.n171 175.714
R3166 VGND.t1185 VGND.n163 175.714
R3167 VGND.n250 VGND.t1187 175.714
R3168 VGND.t1189 VGND.n159 175.714
R3169 VGND.n254 VGND.t1191 175.714
R3170 VGND.t1133 VGND.n265 175.714
R3171 VGND.n330 VGND.t1135 175.714
R3172 VGND.n635 VGND.t1137 175.714
R3173 VGND.n413 VGND.t1098 175.714
R3174 VGND.t952 VGND.n475 175.714
R3175 VGND.n504 VGND.t970 175.714
R3176 VGND.t972 VGND.n469 175.714
R3177 VGND.n513 VGND.t976 175.714
R3178 VGND.t978 VGND.n462 175.714
R3179 VGND.n621 VGND.t958 175.714
R3180 VGND.n566 VGND.t900 175.714
R3181 VGND.t907 VGND.n540 175.714
R3182 VGND.n599 VGND.t909 175.714
R3183 VGND.t911 VGND.n535 175.714
R3184 VGND.n40 VGND.t920 99.5774
R3185 VGND.t1157 VGND.t13 171.429
R3186 VGND.t213 VGND.t1184 171.429
R3187 VGND.t279 VGND.t1130 171.429
R3188 VGND.t593 VGND.t975 171.429
R3189 VGND.t669 VGND.t978 171.429
R3190 VGND.t600 VGND.t914 171.429
R3191 VGND.n767 VGND.t1568 167.143
R3192 VGND.n769 VGND.t1571 167.143
R3193 VGND.t858 VGND.n727 167.143
R3194 VGND.n778 VGND.t1549 167.143
R3195 VGND.n654 VGND.t824 167.143
R3196 VGND.n656 VGND.t827 167.143
R3197 VGND.n658 VGND.t424 167.143
R3198 VGND.n660 VGND.t427 167.143
R3199 VGND.t354 VGND.n117 167.143
R3200 VGND.t344 VGND.n109 167.143
R3201 VGND.n682 VGND.t85 167.143
R3202 VGND.n684 VGND.t89 167.143
R3203 VGND.n222 VGND.t227 167.143
R3204 VGND.n223 VGND.t539 167.143
R3205 VGND.t777 VGND.n180 167.143
R3206 VGND.t780 VGND.n178 167.143
R3207 VGND.t558 VGND.n172 167.143
R3208 VGND.t561 VGND.n170 167.143
R3209 VGND.n300 VGND.t49 167.143
R3210 VGND.n302 VGND.t53 167.143
R3211 VGND.t286 VGND.n284 167.143
R3212 VGND.t420 VGND.t286 167.143
R3213 VGND.t287 VGND.t1503 167.143
R3214 VGND.t14 VGND.t288 167.143
R3215 VGND.t289 VGND.t16 167.143
R3216 VGND.n318 VGND.t102 167.143
R3217 VGND.t579 VGND.n267 167.143
R3218 VGND.n382 VGND.t269 167.143
R3219 VGND.n384 VGND.t272 167.143
R3220 VGND.n386 VGND.t758 167.143
R3221 VGND.n388 VGND.t761 167.143
R3222 VGND.t163 VGND.n350 167.143
R3223 VGND.t166 VGND.n348 167.143
R3224 VGND.n494 VGND.t458 167.143
R3225 VGND.n494 VGND.t613 167.143
R3226 VGND.t691 VGND.n470 167.143
R3227 VGND.t694 VGND.n468 167.143
R3228 VGND.n517 VGND.t673 167.143
R3229 VGND.n519 VGND.t677 167.143
R3230 VGND.n580 VGND.t883 167.143
R3231 VGND.t1438 VGND.n557 167.143
R3232 VGND.n592 VGND.t1486 167.143
R3233 VGND.n594 VGND.t1489 167.143
R3234 VGND.t655 VGND.n536 167.143
R3235 VGND.t658 VGND.n534 167.143
R3236 VGND.t1575 VGND.t1318 162.857
R3237 VGND.t1222 VGND.t170 162.857
R3238 VGND.t681 VGND.t969 162.857
R3239 VGND.t646 VGND.t908 162.857
R3240 VGND.n807 VGND.t1458 155.173
R3241 VGND.t1467 VGND.n797 155.173
R3242 VGND.t1518 VGND.t104 154.286
R3243 VGND.t105 VGND.t1519 154.286
R3244 VGND.t1520 VGND.t106 154.286
R3245 VGND.t576 VGND.t113 154.286
R3246 VGND.t114 VGND.t577 154.286
R3247 VGND.t578 VGND.t115 154.286
R3248 VGND.t72 VGND.t712 150
R3249 VGND.t626 VGND.t953 150
R3250 VGND.t1315 VGND.t1565 145.714
R3251 VGND.t805 VGND.t1319 145.714
R3252 VGND.t896 VGND.t929 145.714
R3253 VGND.t1486 VGND.t0 145.714
R3254 VGND.t918 VGND.t638 145.714
R3255 VGND.t1567 VGND.n739 141.429
R3256 VGND.t1572 VGND.n736 141.429
R3257 VGND.t1548 VGND.n727 141.429
R3258 VGND.n778 VGND.t859 141.429
R3259 VGND.t823 VGND.n129 141.429
R3260 VGND.t828 VGND.n126 141.429
R3261 VGND.t423 VGND.n125 141.429
R3262 VGND.t428 VGND.n122 141.429
R3263 VGND.n665 VGND.t353 141.429
R3264 VGND.n674 VGND.t345 141.429
R3265 VGND.t84 VGND.n99 141.429
R3266 VGND.t90 VGND.n96 141.429
R3267 VGND.t226 VGND.n193 141.429
R3268 VGND.t540 VGND.n191 141.429
R3269 VGND.n234 VGND.t776 141.429
R3270 VGND.t781 VGND.n177 141.429
R3271 VGND.n241 VGND.t557 141.429
R3272 VGND.n244 VGND.t562 141.429
R3273 VGND.t48 VGND.n294 141.429
R3274 VGND.t54 VGND.n291 141.429
R3275 VGND.n285 VGND.t285 141.429
R3276 VGND.n311 VGND.t290 141.429
R3277 VGND.t1111 VGND.t766 141.429
R3278 VGND.t107 VGND.n272 141.429
R3279 VGND.n323 VGND.t575 141.429
R3280 VGND.t268 VGND.n365 141.429
R3281 VGND.t273 VGND.n362 141.429
R3282 VGND.t757 VGND.n361 141.429
R3283 VGND.t762 VGND.n358 141.429
R3284 VGND.n398 VGND.t162 141.429
R3285 VGND.n401 VGND.t167 141.429
R3286 VGND.t443 VGND.t951 141.429
R3287 VGND.t612 VGND.n483 141.429
R3288 VGND.t459 VGND.n482 141.429
R3289 VGND.n506 VGND.t690 141.429
R3290 VGND.n509 VGND.t695 141.429
R3291 VGND.t672 VGND.n461 141.429
R3292 VGND.t678 VGND.n458 141.429
R3293 VGND.n580 VGND.t1437 141.429
R3294 VGND.t884 VGND.n557 141.429
R3295 VGND.t1485 VGND.n546 141.429
R3296 VGND.t1490 VGND.n543 141.429
R3297 VGND.n601 VGND.t654 141.429
R3298 VGND.n604 VGND.t659 141.429
R3299 VGND.t211 VGND.t1183 137.143
R3300 VGND.t277 VGND.t1129 137.143
R3301 VGND.t591 VGND.t974 137.143
R3302 VGND.t981 VGND.t680 137.143
R3303 VGND.t598 VGND.t913 137.143
R3304 VGND.t1543 VGND.t854 128.571
R3305 VGND.t855 VGND.t1544 128.571
R3306 VGND.t1545 VGND.t856 128.571
R3307 VGND.t857 VGND.t1546 128.571
R3308 VGND.t1547 VGND.t858 128.571
R3309 VGND.t859 VGND.t1548 128.571
R3310 VGND.t1549 VGND.t860 128.571
R3311 VGND.t861 VGND.t1551 128.571
R3312 VGND.t1552 VGND.t862 128.571
R3313 VGND.t863 VGND.t1553 128.571
R3314 VGND.t1554 VGND.t864 128.571
R3315 VGND.t332 VGND.t356 128.571
R3316 VGND.t357 VGND.t333 128.571
R3317 VGND.t334 VGND.t358 128.571
R3318 VGND.t364 VGND.t340 128.571
R3319 VGND.t341 VGND.t365 128.571
R3320 VGND.t366 VGND.t342 128.571
R3321 VGND.t1194 VGND.t531 128.571
R3322 VGND.t879 VGND.t1471 128.571
R3323 VGND.t1472 VGND.t880 128.571
R3324 VGND.t881 VGND.t1473 128.571
R3325 VGND.t1435 VGND.t882 128.571
R3326 VGND.t883 VGND.t1436 128.571
R3327 VGND.t1437 VGND.t884 128.571
R3328 VGND.t885 VGND.t1438 128.571
R3329 VGND.t1439 VGND.t886 128.571
R3330 VGND.t887 VGND.t1440 128.571
R3331 VGND.t1441 VGND.t888 128.571
R3332 VGND.t889 VGND.t1442 128.571
R3333 VGND.t33 VGND.n718 124.287
R3334 VGND.n214 VGND.t309 124.287
R3335 VGND.n634 VGND.t299 124.287
R3336 VGND.t705 VGND.n476 124.287
R3337 VGND.n528 VGND.t203 124.287
R3338 VGND.n766 VGND.t1566 115.715
R3339 VGND.n770 VGND.t1573 115.715
R3340 VGND.t853 VGND.n730 115.715
R3341 VGND.n777 VGND.t1547 115.715
R3342 VGND.t860 VGND.n726 115.715
R3343 VGND.n781 VGND.t1555 115.715
R3344 VGND.n653 VGND.t822 115.715
R3345 VGND.n657 VGND.t829 115.715
R3346 VGND.n657 VGND.t422 115.715
R3347 VGND.n661 VGND.t429 115.715
R3348 VGND.t352 VGND.n118 115.715
R3349 VGND.t359 VGND.n114 115.715
R3350 VGND.t339 VGND.n112 115.715
R3351 VGND.t346 VGND.n108 115.715
R3352 VGND.n681 VGND.t83 115.715
R3353 VGND.n685 VGND.t91 115.715
R3354 VGND.n221 VGND.t225 115.715
R3355 VGND.n224 VGND.t541 115.715
R3356 VGND.t775 VGND.n182 115.715
R3357 VGND.t563 VGND.n169 115.715
R3358 VGND.n299 VGND.t47 115.715
R3359 VGND.n303 VGND.t55 115.715
R3360 VGND.n308 VGND.t284 115.715
R3361 VGND.t291 VGND.n282 115.715
R3362 VGND.n321 VGND.t108 115.715
R3363 VGND.t574 VGND.n270 115.715
R3364 VGND.n381 VGND.t267 115.715
R3365 VGND.n385 VGND.t274 115.715
R3366 VGND.n385 VGND.t756 115.715
R3367 VGND.n389 VGND.t763 115.715
R3368 VGND.t161 VGND.n351 115.715
R3369 VGND.t168 VGND.n347 115.715
R3370 VGND.n493 VGND.t611 115.715
R3371 VGND.n495 VGND.t460 115.715
R3372 VGND.t689 VGND.n471 115.715
R3373 VGND.t696 VGND.n467 115.715
R3374 VGND.n516 VGND.t671 115.715
R3375 VGND.n520 VGND.t679 115.715
R3376 VGND.n577 VGND.t878 115.715
R3377 VGND.t1436 VGND.n559 115.715
R3378 VGND.n581 VGND.t885 115.715
R3379 VGND.t1443 VGND.n554 115.715
R3380 VGND.t904 VGND.t1483 115.715
R3381 VGND.n591 VGND.t1484 115.715
R3382 VGND.n595 VGND.t1491 115.715
R3383 VGND.t653 VGND.n537 115.715
R3384 VGND.t660 VGND.n533 115.715
R3385 VGND.t1313 VGND.t193 111.43
R3386 VGND.t1131 VGND.t293 111.43
R3387 VGND.t1058 VGND.t259 111.43
R3388 VGND.t73 VGND.t714 111.43
R3389 VGND.t902 VGND.t1477 111.43
R3390 VGND.t1452 VGND.n48 91.7675
R3391 VGND.n808 VGND.t1457 110.838
R3392 VGND.t844 VGND.n796 110.838
R3393 VGND.t849 VGND.n43 645.394
R3394 VGND.t416 VGND.n719 107.144
R3395 VGND.n215 VGND.t479 107.144
R3396 VGND.t1558 VGND.n275 107.144
R3397 VGND.n638 VGND.t478 107.144
R3398 VGND.t627 VGND.n475 107.144
R3399 VGND.t1509 VGND.t901 107.144
R3400 VGND.t607 VGND.t451 102.858
R3401 VGND.t452 VGND.t608 102.858
R3402 VGND.t609 VGND.t453 102.858
R3403 VGND.t455 VGND.t610 102.858
R3404 VGND.t611 VGND.t456 102.858
R3405 VGND.t458 VGND.t612 102.858
R3406 VGND.t613 VGND.t459 102.858
R3407 VGND.t460 VGND.t614 102.858
R3408 VGND.t615 VGND.t461 102.858
R3409 VGND.t698 VGND.t616 102.858
R3410 VGND.t617 VGND.t699 102.858
R3411 VGND.t700 VGND.t618 102.858
R3412 VGND.t832 VGND.n721 98.5719
R3413 VGND.n794 VGND.t868 98.5719
R3414 VGND.t710 VGND.n91 98.5719
R3415 VGND.n690 VGND.t636 98.5719
R3416 VGND.t531 VGND.n155 98.5719
R3417 VGND.t34 VGND.n263 98.5719
R3418 VGND.n636 VGND.t765 98.5719
R3419 VGND.n413 VGND.t622 98.5719
R3420 VGND.n415 VGND.t36 98.5719
R3421 VGND.n522 VGND.t236 98.5719
R3422 VGND.n622 VGND.t707 98.5719
R3423 VGND.t894 VGND.n45 112.823
R3424 VGND.t840 VGND.n30 72.9583
R3425 VGND.n586 VGND.t1425 98.5719
R3426 VGND.t0 VGND.n545 98.5719
R3427 VGND.t1474 VGND.n530 98.5719
R3428 VGND.n529 VGND.t1493 98.5719
R3429 VGND.n612 VGND.t1476 98.5719
R3430 VGND.n611 VGND.t1496 98.5719
R3431 VGND.t688 VGND.t971 94.2862
R3432 VGND.t652 VGND.t910 94.2862
R3433 VGND.t1565 VGND.n740 90.0005
R3434 VGND.t1574 VGND.n735 90.0005
R3435 VGND.n774 VGND.t852 90.0005
R3436 VGND.t1546 VGND.n728 90.0005
R3437 VGND.n779 VGND.t861 90.0005
R3438 VGND.t1556 VGND.n723 90.0005
R3439 VGND.t821 VGND.n130 90.0005
R3440 VGND.t421 VGND.n126 90.0005
R3441 VGND.t830 VGND.n125 90.0005
R3442 VGND.t430 VGND.n121 90.0005
R3443 VGND.n664 VGND.t350 90.0005
R3444 VGND.n669 VGND.t360 90.0005
R3445 VGND.n670 VGND.t338 90.0005
R3446 VGND.n675 VGND.t347 90.0005
R3447 VGND.t82 VGND.n100 90.0005
R3448 VGND.t92 VGND.n95 90.0005
R3449 VGND.t224 VGND.n194 90.0005
R3450 VGND.t542 VGND.n190 90.0005
R3451 VGND.n233 VGND.t774 90.0005
R3452 VGND.n245 VGND.t564 90.0005
R3453 VGND.t46 VGND.n295 90.0005
R3454 VGND.t56 VGND.n290 90.0005
R3455 VGND.t283 VGND.n286 90.0005
R3456 VGND.n312 VGND.t292 90.0005
R3457 VGND.t99 VGND.n276 90.0005
R3458 VGND.t109 VGND.n271 90.0005
R3459 VGND.n322 VGND.t573 90.0005
R3460 VGND.t266 VGND.n366 90.0005
R3461 VGND.t755 VGND.n362 90.0005
R3462 VGND.t275 VGND.n361 90.0005
R3463 VGND.t764 VGND.n357 90.0005
R3464 VGND.n397 VGND.t160 90.0005
R3465 VGND.n402 VGND.t169 90.0005
R3466 VGND.t450 VGND.n486 90.0005
R3467 VGND.t610 VGND.n484 90.0005
R3468 VGND.t461 VGND.n481 90.0005
R3469 VGND.t619 VGND.n479 90.0005
R3470 VGND.n505 VGND.t688 90.0005
R3471 VGND.n510 VGND.t697 90.0005
R3472 VGND.t670 VGND.n462 90.0005
R3473 VGND.t680 VGND.n457 90.0005
R3474 VGND.t877 VGND.n562 90.0005
R3475 VGND.n579 VGND.t1435 90.0005
R3476 VGND.t886 VGND.n556 90.0005
R3477 VGND.n584 VGND.t1444 90.0005
R3478 VGND.t1483 VGND.n547 90.0005
R3479 VGND.t1492 VGND.n542 90.0005
R3480 VGND.n600 VGND.t652 90.0005
R3481 VGND.n605 VGND.t661 90.0005
R3482 VGND.t562 VGND.t1182 85.7148
R3483 VGND.t191 VGND.t100 85.7148
R3484 VGND.t695 VGND.t973 85.7148
R3485 VGND.t659 VGND.t912 85.7148
R3486 VGND.t309 VGND.t1154 81.4291
R3487 VGND.n309 VGND.t420 77.1434
R3488 VGND.n326 VGND.t192 77.1434
R3489 VGND.t150 VGND.n336 77.1434
R3490 VGND.n502 VGND.t626 77.1434
R3491 VGND.n620 VGND.t621 77.1434
R3492 VGND.n567 VGND.t1509 77.1434
R3493 VGND.t915 VGND.t1474 77.1434
R3494 VGND.t282 VGND.t565 72.8576
R3495 VGND.t1510 VGND.n213 71.4177
R3496 VGND.t1453 VGND.n811 66.503
R3497 VGND.n809 VGND.t1456 66.503
R3498 VGND.t846 VGND.n12 82.2354
R3499 VGND.n11 VGND.t849 82.2354
R3500 VGND.t193 VGND.n743 64.2862
R3501 VGND.n765 VGND.t200 64.2862
R3502 VGND.n771 VGND.t1575 64.2862
R3503 VGND.t833 VGND.n733 64.2862
R3504 VGND.n772 VGND.t1580 64.2862
R3505 VGND.t1540 VGND.n731 64.2862
R3506 VGND.t839 VGND.n731 64.2862
R3507 VGND.n776 VGND.t1545 64.2862
R3508 VGND.t862 VGND.n725 64.2862
R3509 VGND.n782 VGND.t24 64.2862
R3510 VGND.n782 VGND.t867 64.2862
R3511 VGND.n783 VGND.t30 64.2862
R3512 VGND.n650 VGND.t815 64.2862
R3513 VGND.n652 VGND.t820 64.2862
R3514 VGND.t796 VGND.n129 64.2862
R3515 VGND.n656 VGND.t803 64.2862
R3516 VGND.n658 VGND.t1559 64.2862
R3517 VGND.t1564 VGND.n122 64.2862
R3518 VGND.n662 VGND.t431 64.2862
R3519 VGND.t436 VGND.n119 64.2862
R3520 VGND.t353 VGND.t1204 64.2862
R3521 VGND.n667 VGND.t332 64.2862
R3522 VGND.t361 VGND.n113 64.2862
R3523 VGND.t337 VGND.n113 64.2862
R3524 VGND.n672 VGND.t366 64.2862
R3525 VGND.t170 VGND.n107 64.2862
R3526 VGND.n677 VGND.t176 64.2862
R3527 VGND.t75 VGND.n103 64.2862
R3528 VGND.n680 VGND.t81 64.2862
R3529 VGND.n686 VGND.t177 64.2862
R3530 VGND.t183 VGND.n93 64.2862
R3531 VGND.n216 VGND.t629 64.2862
R3532 VGND.n220 VGND.t223 64.2862
R3533 VGND.n225 VGND.t543 64.2862
R3534 VGND.t795 VGND.n186 64.2862
R3535 VGND.n230 VGND.t6 64.2862
R3536 VGND.t13 VGND.n183 64.2862
R3537 VGND.n237 VGND.t549 64.2862
R3538 VGND.t789 VGND.n173 64.2862
R3539 VGND.t209 VGND.n168 64.2862
R3540 VGND.n247 VGND.t216 64.2862
R3541 VGND.t17 VGND.n46 52.5382
R3542 VGND.n298 VGND.t23 64.2862
R3543 VGND.n304 VGND.t57 64.2862
R3544 VGND.n33 VGND.t62 375.315
R3545 VGND.n307 VGND.t281 64.2862
R3546 VGND.t293 VGND.n281 64.2862
R3547 VGND.t298 VGND.n31 52.5375
R3548 VGND.t766 VGND.n278 64.2862
R3549 VGND.n319 VGND.t1518 64.2862
R3550 VGND.t1523 VGND.n271 64.2862
R3551 VGND.n322 VGND.t110 64.2862
R3552 VGND.t115 VGND.n268 64.2862
R3553 VGND.t192 VGND.t580 64.2862
R3554 VGND.t581 VGND.t662 64.2862
R3555 VGND.t207 VGND.t582 64.2862
R3556 VGND.t583 VGND.t208 64.2862
R3557 VGND.n329 VGND.t588 64.2862
R3558 VGND.t259 VGND.n369 64.2862
R3559 VGND.n380 VGND.t265 64.2862
R3560 VGND.t749 VGND.n365 64.2862
R3561 VGND.n384 VGND.t754 64.2862
R3562 VGND.n386 VGND.t65 64.2862
R3563 VGND.t71 VGND.n358 64.2862
R3564 VGND.n390 VGND.t711 64.2862
R3565 VGND.t716 VGND.n354 64.2862
R3566 VGND.n394 VGND.t153 64.2862
R3567 VGND.t159 VGND.n352 64.2862
R3568 VGND.t472 VGND.n346 64.2862
R3569 VGND.n404 VGND.t477 64.2862
R3570 VGND.n489 VGND.t443 64.2862
R3571 VGND.t604 VGND.n487 64.2862
R3572 VGND.n490 VGND.t449 64.2862
R3573 VGND.n492 VGND.t609 64.2862
R3574 VGND.n496 VGND.t698 64.2862
R3575 VGND.n498 VGND.t640 64.2862
R3576 VGND.t703 VGND.n478 64.2862
R3577 VGND.t645 VGND.n477 64.2862
R3578 VGND.n503 VGND.t681 64.2862
R3579 VGND.t687 VGND.n472 64.2862
R3580 VGND.t589 VGND.n466 64.2862
R3581 VGND.n512 VGND.t595 64.2862
R3582 VGND.t664 VGND.n464 64.2862
R3583 VGND.n515 VGND.t669 64.2862
R3584 VGND.n521 VGND.t238 64.2862
R3585 VGND.t243 VGND.n455 64.2862
R3586 VGND.n575 VGND.t869 64.2862
R3587 VGND.n576 VGND.t1468 64.2862
R3588 VGND.n576 VGND.t875 64.2862
R3589 VGND.t1473 VGND.n560 64.2862
R3590 VGND.n582 VGND.t887 64.2862
R3591 VGND.t1445 VGND.n553 64.2862
R3592 VGND.t893 VGND.n553 64.2862
R3593 VGND.n587 VGND.t1450 64.2862
R3594 VGND.t1477 VGND.n550 64.2862
R3595 VGND.n590 VGND.t1482 64.2862
R3596 VGND.n596 VGND.t1512 64.2862
R3597 VGND.t1517 VGND.n540 64.2862
R3598 VGND.n598 VGND.t646 64.2862
R3599 VGND.t651 VGND.n538 64.2862
R3600 VGND.t596 VGND.n532 64.2862
R3601 VGND.n607 VGND.t603 64.2862
R3602 VGND.t1491 VGND.t905 60.0005
R3603 VGND.n785 VGND.t806 55.7148
R3604 VGND.n316 VGND.t190 55.7148
R3605 VGND.t151 VGND.n263 55.7148
R3606 VGND.n391 VGND.t418 55.7148
R3607 VGND.n500 VGND.t624 55.7148
R3608 VGND.t639 VGND.n526 55.7148
R3609 VGND.t1434 VGND.n27 54.9227
R3610 VGND.t628 VGND.n334 54.9217
R3611 VGND.n27 VGND.n45 2.10023
R3612 VGND.n27 VGND.t896 54.8979
R3613 VGND.t842 VGND.n699 54.2748
R3614 VGND.n151 VGND.t348 54.2748
R3615 VGND.t831 VGND.n87 54.2748
R3616 VGND.n645 VGND.t773 54.2748
R3617 VGND.t45 VGND.n257 54.2748
R3618 VGND.t706 VGND.n423 54.2748
R3619 VGND.t1508 VGND.n18 54.2748
R3620 VGND.t217 VGND.t631 51.4291
R3621 VGND.t221 VGND.t634 51.4291
R3622 VGND.t533 VGND.t222 51.4291
R3623 VGND.t223 VGND.t534 51.4291
R3624 VGND.t535 VGND.t224 51.4291
R3625 VGND.t225 VGND.t536 51.4291
R3626 VGND.t537 VGND.t226 51.4291
R3627 VGND.t227 VGND.t538 51.4291
R3628 VGND.t539 VGND.t229 51.4291
R3629 VGND.t230 VGND.t540 51.4291
R3630 VGND.t541 VGND.t232 51.4291
R3631 VGND.t233 VGND.t542 51.4291
R3632 VGND.t543 VGND.t234 51.4291
R3633 VGND.t235 VGND.t544 51.4291
R3634 VGND.t545 VGND.t790 51.4291
R3635 VGND.t548 VGND.t793 51.4291
R3636 VGND.t549 VGND.t782 51.4291
R3637 VGND.t783 VGND.t550 51.4291
R3638 VGND.t551 VGND.t784 51.4291
R3639 VGND.t554 VGND.t787 51.4291
R3640 VGND.t788 VGND.t555 51.4291
R3641 VGND.t556 VGND.t789 51.4291
R3642 VGND.t1503 VGND.n283 51.4291
R3643 VGND.t662 VGND.n266 51.4291
R3644 VGND.n412 VGND.t1504 51.4291
R3645 VGND.t1424 VGND.n474 51.4291
R3646 VGND.t955 VGND.t968 51.4291
R3647 VGND.t1475 VGND.n454 51.4291
R3648 VGND.t1433 VGND.n565 51.4291
R3649 VGND.t776 VGND.t1158 42.8576
R3650 VGND.t559 VGND.t1181 42.8576
R3651 VGND.t74 VGND.t716 42.8576
R3652 VGND.t692 VGND.t972 42.8576
R3653 VGND.t979 VGND.t672 42.8576
R3654 VGND.t656 VGND.t911 42.8576
R3655 VGND.n444 VGND.t708 41.4177
R3656 VGND.n763 VGND.t195 38.5719
R3657 VGND.t199 VGND.n741 38.5719
R3658 VGND.t1576 VGND.n734 38.5719
R3659 VGND.t1579 VGND.n733 38.5719
R3660 VGND.n772 VGND.t834 38.5719
R3661 VGND.n773 VGND.t838 38.5719
R3662 VGND.n774 VGND.t1541 38.5719
R3663 VGND.t1544 VGND.n729 38.5719
R3664 VGND.n780 VGND.t863 38.5719
R3665 VGND.t866 VGND.n723 38.5719
R3666 VGND.t26 VGND.n722 38.5719
R3667 VGND.t29 VGND.n721 38.5719
R3668 VGND.n783 VGND.t876 38.5719
R3669 VGND.n651 VGND.t816 38.5719
R3670 VGND.t819 VGND.n131 38.5719
R3671 VGND.n654 VGND.t798 38.5719
R3672 VGND.t802 VGND.n127 38.5719
R3673 VGND.t1560 VGND.n124 38.5719
R3674 VGND.n660 VGND.t1563 38.5719
R3675 VGND.t432 VGND.n120 38.5719
R3676 VGND.n663 VGND.t435 38.5719
R3677 VGND.t333 VGND.n115 38.5719
R3678 VGND.n669 VGND.t336 38.5719
R3679 VGND.n670 VGND.t362 38.5719
R3680 VGND.t365 VGND.n111 38.5719
R3681 VGND.n676 VGND.t172 38.5719
R3682 VGND.t175 VGND.n105 38.5719
R3683 VGND.n679 VGND.t77 38.5719
R3684 VGND.t80 VGND.n101 38.5719
R3685 VGND.t178 VGND.n94 38.5719
R3686 VGND.n687 VGND.t182 38.5719
R3687 VGND.n217 VGND.t630 38.5719
R3688 VGND.n218 VGND.t219 38.5719
R3689 VGND.t633 VGND.n196 38.5719
R3690 VGND.t222 VGND.n195 38.5719
R3691 VGND.t544 VGND.n189 38.5719
R3692 VGND.t791 VGND.n188 38.5719
R3693 VGND.n227 VGND.t547 38.5719
R3694 VGND.n228 VGND.t794 38.5719
R3695 VGND.t9 VGND.n184 38.5719
R3696 VGND.n232 VGND.t12 38.5719
R3697 VGND.t550 VGND.n176 38.5719
R3698 VGND.t785 VGND.n175 38.5719
R3699 VGND.n239 VGND.t553 38.5719
R3700 VGND.n240 VGND.t788 38.5719
R3701 VGND.n246 VGND.t211 38.5719
R3702 VGND.t215 VGND.n166 38.5719
R3703 VGND.n297 VGND.t19 38.5719
R3704 VGND.t22 VGND.n296 38.5719
R3705 VGND.t58 VGND.n289 38.5719
R3706 VGND.n305 VGND.t62 38.5719
R3707 VGND.n306 VGND.t277 38.5719
R3708 VGND.t280 VGND.n287 38.5719
R3709 VGND.n313 VGND.t294 38.5719
R3710 VGND.t297 VGND.n279 38.5719
R3711 VGND.n315 VGND.t767 38.5719
R3712 VGND.t770 VGND.n277 38.5719
R3713 VGND.t1519 VGND.n273 38.5719
R3714 VGND.n321 VGND.t1522 38.5719
R3715 VGND.t111 VGND.n270 38.5719
R3716 VGND.n324 VGND.t114 38.5719
R3717 VGND.n328 VGND.t584 38.5719
R3718 VGND.t587 VGND.n265 38.5719
R3719 VGND.n634 VGND.t772 38.5719
R3720 VGND.t64 VGND.n38 45.6164
R3721 VGND.n378 VGND.t261 38.5719
R3722 VGND.t264 VGND.n367 38.5719
R3723 VGND.n382 VGND.t750 38.5719
R3724 VGND.t753 VGND.n363 38.5719
R3725 VGND.t67 VGND.n360 38.5719
R3726 VGND.n388 VGND.t70 38.5719
R3727 VGND.t712 VGND.n356 38.5719
R3728 VGND.t154 VGND.n353 38.5719
R3729 VGND.n396 VGND.t158 38.5719
R3730 VGND.n403 VGND.t473 38.5719
R3731 VGND.t476 VGND.n344 38.5719
R3732 VGND.t38 VGND.t566 38.5719
R3733 VGND.t445 VGND.n488 38.5719
R3734 VGND.t448 VGND.n487 38.5719
R3735 VGND.n490 VGND.t605 38.5719
R3736 VGND.t608 VGND.n485 38.5719
R3737 VGND.t699 VGND.n480 38.5719
R3738 VGND.n498 VGND.t702 38.5719
R3739 VGND.t641 VGND.n478 38.5719
R3740 VGND.n499 VGND.t644 38.5719
R3741 VGND.t683 VGND.n473 38.5719
R3742 VGND.n504 VGND.t686 38.5719
R3743 VGND.n511 VGND.t591 38.5719
R3744 VGND.t594 VGND.n465 38.5719
R3745 VGND.n514 VGND.t665 38.5719
R3746 VGND.t668 VGND.n463 38.5719
R3747 VGND.t239 VGND.n456 38.5719
R3748 VGND.n522 VGND.t242 38.5719
R3749 VGND.t417 VGND.n455 38.5719
R3750 VGND.t871 VGND.n564 38.5719
R3751 VGND.t874 VGND.n563 38.5719
R3752 VGND.t1469 VGND.n562 38.5719
R3753 VGND.n578 VGND.t1472 38.5719
R3754 VGND.t888 VGND.n555 38.5719
R3755 VGND.n584 VGND.t892 38.5719
R3756 VGND.n585 VGND.t1446 38.5719
R3757 VGND.t1495 VGND.n551 38.5719
R3758 VGND.t1449 VGND.n551 38.5719
R3759 VGND.n588 VGND.t1478 38.5719
R3760 VGND.t1481 VGND.n548 38.5719
R3761 VGND.n593 VGND.t1451 38.5719
R3762 VGND.t1513 VGND.n541 38.5719
R3763 VGND.n597 VGND.t1516 38.5719
R3764 VGND.t647 VGND.n539 38.5719
R3765 VGND.n599 VGND.t650 38.5719
R3766 VGND.n606 VGND.t598 38.5719
R3767 VGND.t602 VGND.n531 38.5719
R3768 VGND.n41 VGND.t1505 47.2546
R3769 VGND.t1454 VGND.n810 38.3909
R3770 VGND.n810 VGND.t1455 38.3909
R3771 VGND.n12 VGND.n10 0.879875
R3772 VGND.n10 VGND.n11 0.879875
R3773 VGND.t1317 VGND.t1572 34.2862
R3774 VGND.t345 VGND.t1221 34.2862
R3775 VGND.t4 VGND.t99 34.2862
R3776 VGND.t101 VGND.t1558 34.2862
R3777 VGND.n784 VGND.t805 30.0005
R3778 VGND.t1229 VGND.t1210 30.0005
R3779 VGND.t1152 VGND.t1180 30.0005
R3780 VGND.t1511 VGND.n199 30.0005
R3781 VGND.n317 VGND.t191 30.0005
R3782 VGND.t152 VGND.n262 30.0005
R3783 VGND.n392 VGND.t419 30.0005
R3784 VGND.n501 VGND.t625 30.0005
R3785 VGND.t638 VGND.n527 30.0005
R3786 VGND.t923 VGND.n42 15.0018
R3787 VGND.n752 VGND.t1577 28.5605
R3788 VGND.n752 VGND.t1578 28.5605
R3789 VGND.t835 VGND.n732 28.5605
R3790 VGND.t836 VGND.n732 28.5605
R3791 VGND.n753 VGND.t27 28.5605
R3792 VGND.n753 VGND.t28 28.5605
R3793 VGND.n142 VGND.t818 28.5605
R3794 VGND.n143 VGND.t433 28.5605
R3795 VGND.t434 VGND.n143 28.5605
R3796 VGND.t173 VGND.n106 28.5605
R3797 VGND.n106 VGND.t174 28.5605
R3798 VGND.t78 VGND.n102 28.5605
R3799 VGND.n102 VGND.t79 28.5605
R3800 VGND.n147 VGND.t179 28.5605
R3801 VGND.t180 VGND.n147 28.5605
R3802 VGND.n231 VGND.t10 28.5605
R3803 VGND.t11 VGND.n231 28.5605
R3804 VGND.t212 VGND.n167 28.5605
R3805 VGND.n167 VGND.t213 28.5605
R3806 VGND.t20 VGND.n5 28.5605
R3807 VGND.n5 VGND.t21 28.5605
R3808 VGND.n6 VGND.t59 28.5605
R3809 VGND.t60 VGND.n6 28.5605
R3810 VGND.t278 VGND.n4 28.5605
R3811 VGND.n4 VGND.t279 28.5605
R3812 VGND.t768 VGND.n3 28.5605
R3813 VGND.n3 VGND.t769 28.5605
R3814 VGND.t585 VGND.n2 28.5605
R3815 VGND.n2 VGND.t586 28.5605
R3816 VGND.n395 VGND.t155 28.5605
R3817 VGND.t156 VGND.n395 28.5605
R3818 VGND.t474 VGND.n345 28.5605
R3819 VGND.n345 VGND.t475 28.5605
R3820 VGND.n441 VGND.t446 28.5605
R3821 VGND.n441 VGND.t447 28.5605
R3822 VGND.n442 VGND.t642 28.5605
R3823 VGND.t643 VGND.n442 28.5605
R3824 VGND.n446 VGND.t684 28.5605
R3825 VGND.t685 VGND.n446 28.5605
R3826 VGND.t592 VGND.n430 28.5605
R3827 VGND.n430 VGND.t593 28.5605
R3828 VGND.t666 VGND.n428 28.5605
R3829 VGND.n428 VGND.t667 28.5605
R3830 VGND.n447 VGND.t240 28.5605
R3831 VGND.t241 VGND.n447 28.5605
R3832 VGND.n23 VGND.t872 28.5605
R3833 VGND.n23 VGND.t873 28.5605
R3834 VGND.n22 VGND.t1514 28.5605
R3835 VGND.t1515 VGND.n22 28.5605
R3836 VGND.n20 VGND.t648 28.5605
R3837 VGND.t649 VGND.n20 28.5605
R3838 VGND.t599 VGND.n25 28.5605
R3839 VGND.n25 VGND.t600 28.5605
R3840 VGND.n310 VGND.t14 25.7148
R3841 VGND.n327 VGND.t207 25.7148
R3842 VGND.t565 VGND.n335 25.7148
R3843 VGND.n619 VGND.t514 25.7148
R3844 VGND.n566 VGND.t1507 25.7148
R3845 VGND.t1568 VGND.t1316 17.1434
R3846 VGND.n43 VGND.n10 14.076
R3847 VGND.n796 VGND.n10 17.0005
R3848 VGND.n797 VGND.n10 17.0005
R3849 VGND.n798 VGND.n10 17.0005
R3850 VGND.n799 VGND.n10 17.0005
R3851 VGND.n800 VGND.n10 17.0005
R3852 VGND.n801 VGND.n10 17.0005
R3853 VGND.n802 VGND.n10 17.0005
R3854 VGND.n803 VGND.n10 17.0005
R3855 VGND.n804 VGND.n10 17.0005
R3856 VGND.n805 VGND.n10 17.0005
R3857 VGND.n806 VGND.n10 17.0005
R3858 VGND.n807 VGND.n10 17.0005
R3859 VGND.n808 VGND.n10 17.0005
R3860 VGND.n809 VGND.n10 17.0005
R3861 VGND.n811 VGND.n10 17.0005
R3862 VGND.t1274 VGND.n794 17.0005
R3863 VGND.t1274 VGND.n700 17.0005
R3864 VGND.t1274 VGND.n701 17.0005
R3865 VGND.t1274 VGND.n793 17.0005
R3866 VGND.t1274 VGND.n792 17.0005
R3867 VGND.t1274 VGND.n704 17.0005
R3868 VGND.t1274 VGND.n705 17.0005
R3869 VGND.t1274 VGND.n791 17.0005
R3870 VGND.t1274 VGND.n790 17.0005
R3871 VGND.t1274 VGND.n708 17.0005
R3872 VGND.t1274 VGND.n709 17.0005
R3873 VGND.t1274 VGND.n789 17.0005
R3874 VGND.t1274 VGND.n788 17.0005
R3875 VGND.t1274 VGND.n712 17.0005
R3876 VGND.t1274 VGND.n713 17.0005
R3877 VGND.t1274 VGND.n787 17.0005
R3878 VGND.t1274 VGND.n786 17.0005
R3879 VGND.t1274 VGND.n716 17.0005
R3880 VGND.t1274 VGND.n717 17.0005
R3881 VGND.t1274 VGND.n785 17.0005
R3882 VGND.t1274 VGND.n718 17.0005
R3883 VGND.t1274 VGND.n784 17.0005
R3884 VGND.t1274 VGND.n719 17.0005
R3885 VGND.t1274 VGND.n783 17.0005
R3886 VGND.t1274 VGND.n721 17.0005
R3887 VGND.t1274 VGND.n722 17.0005
R3888 VGND.t1274 VGND.n782 17.0005
R3889 VGND.t1274 VGND.n723 17.0005
R3890 VGND.t1274 VGND.n781 17.0005
R3891 VGND.t1274 VGND.n724 17.0005
R3892 VGND.t1274 VGND.n780 17.0005
R3893 VGND.t1274 VGND.n725 17.0005
R3894 VGND.t1274 VGND.n779 17.0005
R3895 VGND.t1274 VGND.n726 17.0005
R3896 VGND.t1274 VGND.n778 17.0005
R3897 VGND.t1274 VGND.n727 17.0005
R3898 VGND.t1274 VGND.n777 17.0005
R3899 VGND.t1274 VGND.n728 17.0005
R3900 VGND.t1274 VGND.n776 17.0005
R3901 VGND.t1274 VGND.n729 17.0005
R3902 VGND.t1274 VGND.n775 17.0005
R3903 VGND.t1274 VGND.n730 17.0005
R3904 VGND.t1274 VGND.n774 17.0005
R3905 VGND.t1274 VGND.n731 17.0005
R3906 VGND.t1274 VGND.n773 17.0005
R3907 VGND.t1274 VGND.n772 17.0005
R3908 VGND.t1274 VGND.n733 17.0005
R3909 VGND.t1274 VGND.n734 17.0005
R3910 VGND.t1274 VGND.n771 17.0005
R3911 VGND.t1274 VGND.n735 17.0005
R3912 VGND.t1274 VGND.n770 17.0005
R3913 VGND.t1274 VGND.n736 17.0005
R3914 VGND.t1274 VGND.n769 17.0005
R3915 VGND.t1274 VGND.n737 17.0005
R3916 VGND.t1274 VGND.n768 17.0005
R3917 VGND.t1274 VGND.n738 17.0005
R3918 VGND.t1274 VGND.n767 17.0005
R3919 VGND.t1274 VGND.n739 17.0005
R3920 VGND.t1274 VGND.n766 17.0005
R3921 VGND.t1274 VGND.n740 17.0005
R3922 VGND.t1274 VGND.n765 17.0005
R3923 VGND.t1274 VGND.n741 17.0005
R3924 VGND.t1274 VGND.n764 17.0005
R3925 VGND.t1274 VGND.n742 17.0005
R3926 VGND.t1274 VGND.n763 17.0005
R3927 VGND.t1274 VGND.n743 17.0005
R3928 VGND.t1196 VGND.n690 17.0005
R3929 VGND.t1196 VGND.n88 17.0005
R3930 VGND.t1196 VGND.n689 17.0005
R3931 VGND.t1196 VGND.n91 17.0005
R3932 VGND.t1196 VGND.n688 17.0005
R3933 VGND.t1196 VGND.n93 17.0005
R3934 VGND.t1196 VGND.n687 17.0005
R3935 VGND.t1196 VGND.n94 17.0005
R3936 VGND.t1196 VGND.n686 17.0005
R3937 VGND.t1196 VGND.n95 17.0005
R3938 VGND.t1196 VGND.n685 17.0005
R3939 VGND.t1196 VGND.n96 17.0005
R3940 VGND.t1196 VGND.n684 17.0005
R3941 VGND.t1196 VGND.n97 17.0005
R3942 VGND.t1196 VGND.n683 17.0005
R3943 VGND.t1196 VGND.n98 17.0005
R3944 VGND.t1196 VGND.n682 17.0005
R3945 VGND.t1196 VGND.n99 17.0005
R3946 VGND.t1196 VGND.n681 17.0005
R3947 VGND.t1196 VGND.n100 17.0005
R3948 VGND.t1196 VGND.n680 17.0005
R3949 VGND.t1196 VGND.n101 17.0005
R3950 VGND.t1196 VGND.n679 17.0005
R3951 VGND.t1196 VGND.n103 17.0005
R3952 VGND.t1196 VGND.n678 17.0005
R3953 VGND.t1196 VGND.n104 17.0005
R3954 VGND.t1196 VGND.n677 17.0005
R3955 VGND.t1196 VGND.n105 17.0005
R3956 VGND.t1196 VGND.n676 17.0005
R3957 VGND.t1196 VGND.n107 17.0005
R3958 VGND.t1196 VGND.n675 17.0005
R3959 VGND.t1196 VGND.n108 17.0005
R3960 VGND.t1196 VGND.n674 17.0005
R3961 VGND.t1196 VGND.n109 17.0005
R3962 VGND.t1196 VGND.n673 17.0005
R3963 VGND.t1196 VGND.n110 17.0005
R3964 VGND.t1196 VGND.n672 17.0005
R3965 VGND.t1196 VGND.n111 17.0005
R3966 VGND.t1196 VGND.n671 17.0005
R3967 VGND.t1196 VGND.n112 17.0005
R3968 VGND.t1196 VGND.n670 17.0005
R3969 VGND.t1196 VGND.n113 17.0005
R3970 VGND.t1196 VGND.n669 17.0005
R3971 VGND.t1196 VGND.n114 17.0005
R3972 VGND.t1196 VGND.n668 17.0005
R3973 VGND.t1196 VGND.n115 17.0005
R3974 VGND.t1196 VGND.n667 17.0005
R3975 VGND.t1196 VGND.n116 17.0005
R3976 VGND.t1196 VGND.n666 17.0005
R3977 VGND.t1196 VGND.n117 17.0005
R3978 VGND.t1196 VGND.n665 17.0005
R3979 VGND.t1196 VGND.n118 17.0005
R3980 VGND.t1196 VGND.n664 17.0005
R3981 VGND.t1196 VGND.n119 17.0005
R3982 VGND.t1196 VGND.n663 17.0005
R3983 VGND.t1196 VGND.n120 17.0005
R3984 VGND.t1196 VGND.n662 17.0005
R3985 VGND.t1196 VGND.n121 17.0005
R3986 VGND.t1196 VGND.n661 17.0005
R3987 VGND.t1196 VGND.n122 17.0005
R3988 VGND.t1196 VGND.n660 17.0005
R3989 VGND.t1196 VGND.n123 17.0005
R3990 VGND.t1196 VGND.n659 17.0005
R3991 VGND.t1196 VGND.n124 17.0005
R3992 VGND.t1196 VGND.n658 17.0005
R3993 VGND.t1196 VGND.n125 17.0005
R3994 VGND.t1196 VGND.n657 17.0005
R3995 VGND.t1196 VGND.n126 17.0005
R3996 VGND.t1196 VGND.n656 17.0005
R3997 VGND.t1196 VGND.n127 17.0005
R3998 VGND.t1196 VGND.n655 17.0005
R3999 VGND.t1196 VGND.n128 17.0005
R4000 VGND.t1196 VGND.n654 17.0005
R4001 VGND.t1196 VGND.n129 17.0005
R4002 VGND.t1196 VGND.n653 17.0005
R4003 VGND.t1196 VGND.n130 17.0005
R4004 VGND.t1196 VGND.n652 17.0005
R4005 VGND.t1196 VGND.n131 17.0005
R4006 VGND.t1196 VGND.n651 17.0005
R4007 VGND.t1196 VGND.n650 17.0005
R4008 VGND.n646 VGND.n155 17.0005
R4009 VGND.n646 VGND.n156 17.0005
R4010 VGND.n646 VGND.n254 17.0005
R4011 VGND.n646 VGND.n253 17.0005
R4012 VGND.n646 VGND.n159 17.0005
R4013 VGND.n646 VGND.n160 17.0005
R4014 VGND.n646 VGND.n250 17.0005
R4015 VGND.n646 VGND.n249 17.0005
R4016 VGND.n646 VGND.n163 17.0005
R4017 VGND.n646 VGND.n247 17.0005
R4018 VGND.n646 VGND.n166 17.0005
R4019 VGND.n646 VGND.n246 17.0005
R4020 VGND.n646 VGND.n168 17.0005
R4021 VGND.n646 VGND.n245 17.0005
R4022 VGND.n646 VGND.n169 17.0005
R4023 VGND.n646 VGND.n244 17.0005
R4024 VGND.n646 VGND.n170 17.0005
R4025 VGND.n646 VGND.n243 17.0005
R4026 VGND.n646 VGND.n171 17.0005
R4027 VGND.n646 VGND.n242 17.0005
R4028 VGND.n646 VGND.n172 17.0005
R4029 VGND.n646 VGND.n241 17.0005
R4030 VGND.n646 VGND.n173 17.0005
R4031 VGND.n646 VGND.n240 17.0005
R4032 VGND.n646 VGND.n174 17.0005
R4033 VGND.n646 VGND.n239 17.0005
R4034 VGND.n646 VGND.n175 17.0005
R4035 VGND.n646 VGND.n238 17.0005
R4036 VGND.n646 VGND.n176 17.0005
R4037 VGND.n646 VGND.n237 17.0005
R4038 VGND.n646 VGND.n177 17.0005
R4039 VGND.n646 VGND.n178 17.0005
R4040 VGND.n646 VGND.n236 17.0005
R4041 VGND.n646 VGND.n179 17.0005
R4042 VGND.n646 VGND.n235 17.0005
R4043 VGND.n646 VGND.n180 17.0005
R4044 VGND.n646 VGND.n234 17.0005
R4045 VGND.n646 VGND.n182 17.0005
R4046 VGND.n646 VGND.n233 17.0005
R4047 VGND.n646 VGND.n183 17.0005
R4048 VGND.n646 VGND.n232 17.0005
R4049 VGND.n646 VGND.n184 17.0005
R4050 VGND.n646 VGND.n230 17.0005
R4051 VGND.n646 VGND.n185 17.0005
R4052 VGND.n646 VGND.n229 17.0005
R4053 VGND.n646 VGND.n186 17.0005
R4054 VGND.n646 VGND.n228 17.0005
R4055 VGND.n646 VGND.n187 17.0005
R4056 VGND.n646 VGND.n227 17.0005
R4057 VGND.n646 VGND.n188 17.0005
R4058 VGND.n646 VGND.n226 17.0005
R4059 VGND.n646 VGND.n189 17.0005
R4060 VGND.n646 VGND.n225 17.0005
R4061 VGND.n646 VGND.n190 17.0005
R4062 VGND.n646 VGND.n224 17.0005
R4063 VGND.n646 VGND.n191 17.0005
R4064 VGND.n646 VGND.n223 17.0005
R4065 VGND.n646 VGND.n192 17.0005
R4066 VGND.n646 VGND.n222 17.0005
R4067 VGND.n646 VGND.n193 17.0005
R4068 VGND.n646 VGND.n221 17.0005
R4069 VGND.n646 VGND.n194 17.0005
R4070 VGND.n646 VGND.n220 17.0005
R4071 VGND.n646 VGND.n195 17.0005
R4072 VGND.n646 VGND.n219 17.0005
R4073 VGND.n646 VGND.n196 17.0005
R4074 VGND.n646 VGND.n218 17.0005
R4075 VGND.n646 VGND.n197 17.0005
R4076 VGND.n646 VGND.n217 17.0005
R4077 VGND.n646 VGND.n216 17.0005
R4078 VGND.n646 VGND.n215 17.0005
R4079 VGND.n646 VGND.n199 17.0005
R4080 VGND.n646 VGND.n214 17.0005
R4081 VGND.n646 VGND.n200 17.0005
R4082 VGND.t5 VGND.n37 8.48812
R4083 VGND.t5 VGND.n636 17.0005
R4084 VGND.t5 VGND.n635 17.0005
R4085 VGND.n637 VGND.t5 17.0005
R4086 VGND.t5 VGND.n638 17.0005
R4087 VGND.t5 VGND.n262 17.0005
R4088 VGND.t5 VGND.n634 17.0005
R4089 VGND.t5 VGND.n263 17.0005
R4090 VGND.t5 VGND.n49 9.14381
R4091 VGND.t5 VGND.n330 17.0005
R4092 VGND.t5 VGND.n264 17.0005
R4093 VGND.t5 VGND.n329 17.0005
R4094 VGND.t5 VGND.n265 17.0005
R4095 VGND.t5 VGND.n328 17.0005
R4096 VGND.t5 VGND.t208 17.0005
R4097 VGND.t5 VGND.n327 17.0005
R4098 VGND.t5 VGND.n266 17.0005
R4099 VGND.t5 VGND.n326 17.0005
R4100 VGND.t5 VGND.n267 17.0005
R4101 VGND.t5 VGND.n325 17.0005
R4102 VGND.t5 VGND.n268 17.0005
R4103 VGND.t5 VGND.n324 17.0005
R4104 VGND.t5 VGND.n269 17.0005
R4105 VGND.t5 VGND.n323 17.0005
R4106 VGND.t5 VGND.n270 17.0005
R4107 VGND.t5 VGND.n322 17.0005
R4108 VGND.t5 VGND.n271 17.0005
R4109 VGND.t5 VGND.n321 17.0005
R4110 VGND.t5 VGND.n272 17.0005
R4111 VGND.t5 VGND.n320 17.0005
R4112 VGND.t5 VGND.n273 17.0005
R4113 VGND.t5 VGND.n319 17.0005
R4114 VGND.t5 VGND.n274 17.0005
R4115 VGND.t5 VGND.n318 17.0005
R4116 VGND.t5 VGND.n275 17.0005
R4117 VGND.t5 VGND.n317 17.0005
R4118 VGND.t5 VGND.n276 17.0005
R4119 VGND.t5 VGND.n316 17.0005
R4120 VGND.t5 VGND.n277 17.0005
R4121 VGND.t5 VGND.n315 17.0005
R4122 VGND.t5 VGND.n278 17.0005
R4123 VGND.t5 VGND.n279 17.0005
R4124 VGND.t5 VGND.n314 17.0005
R4125 VGND.t5 VGND.n280 17.0005
R4126 VGND.t5 VGND.n313 17.0005
R4127 VGND.t5 VGND.n281 17.0005
R4128 VGND.t5 VGND.n312 17.0005
R4129 VGND.t5 VGND.n282 17.0005
R4130 VGND.t5 VGND.n311 17.0005
R4131 VGND.t5 VGND.t16 17.0005
R4132 VGND.t5 VGND.n310 17.0005
R4133 VGND.t5 VGND.n283 17.0005
R4134 VGND.t5 VGND.n309 17.0005
R4135 VGND.t5 VGND.n284 17.0005
R4136 VGND.t5 VGND.n285 17.0005
R4137 VGND.t5 VGND.n308 17.0005
R4138 VGND.t5 VGND.n286 17.0005
R4139 VGND.t5 VGND.n307 17.0005
R4140 VGND.t5 VGND.n287 17.0005
R4141 VGND.t5 VGND.n306 17.0005
R4142 VGND.t5 VGND.n32 13.8941
R4143 VGND.t5 VGND.n33 13.8945
R4144 VGND.t5 VGND.n305 17.0005
R4145 VGND.t5 VGND.n289 17.0005
R4146 VGND.t5 VGND.n304 17.0005
R4147 VGND.t5 VGND.n290 17.0005
R4148 VGND.t5 VGND.n303 17.0005
R4149 VGND.t5 VGND.n291 17.0005
R4150 VGND.t5 VGND.n302 17.0005
R4151 VGND.t5 VGND.n292 17.0005
R4152 VGND.t5 VGND.n301 17.0005
R4153 VGND.t5 VGND.n293 17.0005
R4154 VGND.t5 VGND.n300 17.0005
R4155 VGND.t5 VGND.n294 17.0005
R4156 VGND.t5 VGND.n299 17.0005
R4157 VGND.t5 VGND.n295 17.0005
R4158 VGND.t5 VGND.n298 17.0005
R4159 VGND.t5 VGND.n296 17.0005
R4160 VGND.t5 VGND.n297 17.0005
R4161 VGND.n416 VGND.n415 17.0005
R4162 VGND.n416 VGND.n332 17.0005
R4163 VGND.n416 VGND.n413 17.0005
R4164 VGND.n416 VGND.n335 17.0005
R4165 VGND.n416 VGND.n412 17.0005
R4166 VGND.n416 VGND.n336 17.0005
R4167 VGND.n416 VGND.n404 17.0005
R4168 VGND.n416 VGND.n344 17.0005
R4169 VGND.n416 VGND.n403 17.0005
R4170 VGND.n416 VGND.n346 17.0005
R4171 VGND.n416 VGND.n402 17.0005
R4172 VGND.n416 VGND.n347 17.0005
R4173 VGND.n416 VGND.n401 17.0005
R4174 VGND.n416 VGND.n348 17.0005
R4175 VGND.n416 VGND.n400 17.0005
R4176 VGND.n416 VGND.n349 17.0005
R4177 VGND.n416 VGND.n399 17.0005
R4178 VGND.n416 VGND.n350 17.0005
R4179 VGND.n416 VGND.n398 17.0005
R4180 VGND.n416 VGND.n351 17.0005
R4181 VGND.n416 VGND.n397 17.0005
R4182 VGND.n416 VGND.n352 17.0005
R4183 VGND.n416 VGND.n396 17.0005
R4184 VGND.n416 VGND.n353 17.0005
R4185 VGND.n416 VGND.n394 17.0005
R4186 VGND.n416 VGND.n354 17.0005
R4187 VGND.n416 VGND.n392 17.0005
R4188 VGND.n416 VGND.n355 17.0005
R4189 VGND.n416 VGND.n391 17.0005
R4190 VGND.n416 VGND.n356 17.0005
R4191 VGND.n416 VGND.n390 17.0005
R4192 VGND.n416 VGND.n357 17.0005
R4193 VGND.n416 VGND.n389 17.0005
R4194 VGND.n416 VGND.n358 17.0005
R4195 VGND.n416 VGND.n388 17.0005
R4196 VGND.n416 VGND.n359 17.0005
R4197 VGND.n416 VGND.n387 17.0005
R4198 VGND.n416 VGND.n360 17.0005
R4199 VGND.n416 VGND.n386 17.0005
R4200 VGND.n416 VGND.n361 17.0005
R4201 VGND.n416 VGND.n385 17.0005
R4202 VGND.n416 VGND.n362 17.0005
R4203 VGND.n416 VGND.n384 17.0005
R4204 VGND.n416 VGND.n363 17.0005
R4205 VGND.n416 VGND.n383 17.0005
R4206 VGND.n416 VGND.n364 17.0005
R4207 VGND.n416 VGND.n382 17.0005
R4208 VGND.n416 VGND.n365 17.0005
R4209 VGND.n416 VGND.n381 17.0005
R4210 VGND.n416 VGND.n366 17.0005
R4211 VGND.n416 VGND.n380 17.0005
R4212 VGND.n416 VGND.n367 17.0005
R4213 VGND.n416 VGND.n379 17.0005
R4214 VGND.n416 VGND.n368 17.0005
R4215 VGND.n416 VGND.n378 17.0005
R4216 VGND.n416 VGND.n369 17.0005
R4217 VGND.t942 VGND.n622 17.0005
R4218 VGND.t942 VGND.n424 17.0005
R4219 VGND.t942 VGND.n621 17.0005
R4220 VGND.t942 VGND.n453 17.0005
R4221 VGND.t942 VGND.n620 17.0005
R4222 VGND.t942 VGND.n454 17.0005
R4223 VGND.t942 VGND.n619 17.0005
R4224 VGND.t942 VGND.n455 17.0005
R4225 VGND.t942 VGND.n522 17.0005
R4226 VGND.t942 VGND.n456 17.0005
R4227 VGND.t942 VGND.n521 17.0005
R4228 VGND.t942 VGND.n457 17.0005
R4229 VGND.t942 VGND.n520 17.0005
R4230 VGND.t942 VGND.n458 17.0005
R4231 VGND.t942 VGND.n519 17.0005
R4232 VGND.t942 VGND.n459 17.0005
R4233 VGND.t942 VGND.n518 17.0005
R4234 VGND.t942 VGND.n460 17.0005
R4235 VGND.t942 VGND.n517 17.0005
R4236 VGND.t942 VGND.n461 17.0005
R4237 VGND.t942 VGND.n516 17.0005
R4238 VGND.t942 VGND.n462 17.0005
R4239 VGND.t942 VGND.n515 17.0005
R4240 VGND.t942 VGND.n463 17.0005
R4241 VGND.t942 VGND.n514 17.0005
R4242 VGND.t942 VGND.n464 17.0005
R4243 VGND.t942 VGND.n513 17.0005
R4244 VGND.t942 VGND.n512 17.0005
R4245 VGND.t942 VGND.n465 17.0005
R4246 VGND.t942 VGND.n511 17.0005
R4247 VGND.t942 VGND.n466 17.0005
R4248 VGND.t942 VGND.n510 17.0005
R4249 VGND.t942 VGND.n467 17.0005
R4250 VGND.t942 VGND.n509 17.0005
R4251 VGND.t942 VGND.n468 17.0005
R4252 VGND.t942 VGND.n508 17.0005
R4253 VGND.t942 VGND.n469 17.0005
R4254 VGND.t942 VGND.n507 17.0005
R4255 VGND.t942 VGND.n470 17.0005
R4256 VGND.t942 VGND.n506 17.0005
R4257 VGND.t942 VGND.n471 17.0005
R4258 VGND.t942 VGND.n505 17.0005
R4259 VGND.t942 VGND.n472 17.0005
R4260 VGND.t942 VGND.n504 17.0005
R4261 VGND.t942 VGND.n473 17.0005
R4262 VGND.t942 VGND.n503 17.0005
R4263 VGND.t942 VGND.n474 17.0005
R4264 VGND.t942 VGND.n502 17.0005
R4265 VGND.t942 VGND.n475 17.0005
R4266 VGND.t942 VGND.n501 17.0005
R4267 VGND.t942 VGND.n476 17.0005
R4268 VGND.t942 VGND.n500 17.0005
R4269 VGND.t942 VGND.n477 17.0005
R4270 VGND.t942 VGND.n499 17.0005
R4271 VGND.t942 VGND.n478 17.0005
R4272 VGND.t942 VGND.n498 17.0005
R4273 VGND.t942 VGND.n479 17.0005
R4274 VGND.t942 VGND.n497 17.0005
R4275 VGND.t942 VGND.n480 17.0005
R4276 VGND.t942 VGND.n496 17.0005
R4277 VGND.t942 VGND.n481 17.0005
R4278 VGND.t942 VGND.n495 17.0005
R4279 VGND.t942 VGND.n482 17.0005
R4280 VGND.t942 VGND.n494 17.0005
R4281 VGND.t942 VGND.n483 17.0005
R4282 VGND.t942 VGND.n493 17.0005
R4283 VGND.t942 VGND.n484 17.0005
R4284 VGND.t942 VGND.n492 17.0005
R4285 VGND.t942 VGND.n485 17.0005
R4286 VGND.t942 VGND.n491 17.0005
R4287 VGND.t942 VGND.n486 17.0005
R4288 VGND.t942 VGND.n490 17.0005
R4289 VGND.t942 VGND.n487 17.0005
R4290 VGND.t942 VGND.n488 17.0005
R4291 VGND.t942 VGND.n489 17.0005
R4292 VGND.n27 VGND.n611 17.0005
R4293 VGND.n27 VGND.n610 17.0005
R4294 VGND.n612 VGND.n27 17.0005
R4295 VGND.n27 VGND.n529 17.0005
R4296 VGND.n27 VGND.n526 17.0005
R4297 VGND.n27 VGND.n528 17.0005
R4298 VGND.n27 VGND.n527 17.0005
R4299 VGND.n27 VGND.n36 12.2559
R4300 VGND.n27 VGND.n530 17.0005
R4301 VGND.n27 VGND.n607 17.0005
R4302 VGND.n27 VGND.n531 17.0005
R4303 VGND.n27 VGND.n606 17.0005
R4304 VGND.n27 VGND.n532 17.0005
R4305 VGND.n27 VGND.n605 17.0005
R4306 VGND.n27 VGND.n533 17.0005
R4307 VGND.n27 VGND.n604 17.0005
R4308 VGND.n27 VGND.n534 17.0005
R4309 VGND.n27 VGND.n603 17.0005
R4310 VGND.n27 VGND.n535 17.0005
R4311 VGND.n27 VGND.n602 17.0005
R4312 VGND.n27 VGND.n536 17.0005
R4313 VGND.n27 VGND.n601 17.0005
R4314 VGND.n27 VGND.n537 17.0005
R4315 VGND.n27 VGND.n600 17.0005
R4316 VGND.n27 VGND.n538 17.0005
R4317 VGND.n27 VGND.n599 17.0005
R4318 VGND.n27 VGND.n539 17.0005
R4319 VGND.n27 VGND.n598 17.0005
R4320 VGND.n27 VGND.n540 17.0005
R4321 VGND.n27 VGND.n597 17.0005
R4322 VGND.n27 VGND.n541 17.0005
R4323 VGND.n27 VGND.n596 17.0005
R4324 VGND.n27 VGND.n542 17.0005
R4325 VGND.n27 VGND.n595 17.0005
R4326 VGND.n27 VGND.n543 17.0005
R4327 VGND.n27 VGND.n594 17.0005
R4328 VGND.n27 VGND.n544 17.0005
R4329 VGND.n27 VGND.n593 17.0005
R4330 VGND.n27 VGND.n545 17.0005
R4331 VGND.n27 VGND.n592 17.0005
R4332 VGND.n27 VGND.n546 17.0005
R4333 VGND.n27 VGND.n591 17.0005
R4334 VGND.n27 VGND.n547 17.0005
R4335 VGND.n27 VGND.n590 17.0005
R4336 VGND.n27 VGND.n548 17.0005
R4337 VGND.n27 VGND.n589 17.0005
R4338 VGND.n27 VGND.n549 17.0005
R4339 VGND.n27 VGND.n588 17.0005
R4340 VGND.n27 VGND.n550 17.0005
R4341 VGND.n27 VGND.n587 17.0005
R4342 VGND.n27 VGND.n551 17.0005
R4343 VGND.n27 VGND.n586 17.0005
R4344 VGND.n27 VGND.n552 17.0005
R4345 VGND.n27 VGND.n585 17.0005
R4346 VGND.n27 VGND.n553 17.0005
R4347 VGND.n27 VGND.n584 17.0005
R4348 VGND.n27 VGND.n554 17.0005
R4349 VGND.n27 VGND.n583 17.0005
R4350 VGND.n27 VGND.n555 17.0005
R4351 VGND.n27 VGND.n582 17.0005
R4352 VGND.n27 VGND.n556 17.0005
R4353 VGND.n27 VGND.n581 17.0005
R4354 VGND.n27 VGND.n557 17.0005
R4355 VGND.n27 VGND.n580 17.0005
R4356 VGND.n27 VGND.n559 17.0005
R4357 VGND.n27 VGND.n579 17.0005
R4358 VGND.n27 VGND.n560 17.0005
R4359 VGND.n27 VGND.n578 17.0005
R4360 VGND.n27 VGND.n561 17.0005
R4361 VGND.n27 VGND.n577 17.0005
R4362 VGND.n27 VGND.n562 17.0005
R4363 VGND.n27 VGND.n576 17.0005
R4364 VGND.n27 VGND.n563 17.0005
R4365 VGND.n27 VGND.n564 17.0005
R4366 VGND.n27 VGND.n575 17.0005
R4367 VGND.n27 VGND.n567 17.0005
R4368 VGND.n27 VGND.n565 17.0005
R4369 VGND.n27 VGND.n566 17.0005
R4370 VGND.n27 VGND.n47 8.48859
R4371 VGND.t566 VGND.n334 16.3513
R4372 VGND.t512 VGND.n450 16.3264
R4373 VGND.n142 VGND.t807 15.7034
R4374 VGND.t709 VGND.n444 15.7034
R4375 VGND.t196 VGND.n742 12.8576
R4376 VGND.n764 VGND.t197 12.8576
R4377 VGND.t1542 VGND.n730 12.8576
R4378 VGND.n775 VGND.t1543 12.8576
R4379 VGND.t864 VGND.n724 12.8576
R4380 VGND.n781 VGND.t865 12.8576
R4381 VGND.t807 VGND.t817 12.8576
R4382 VGND.t818 VGND.t808 12.8576
R4383 VGND.t1426 VGND.t819 12.8576
R4384 VGND.t820 VGND.t804 12.8576
R4385 VGND.t799 VGND.n128 12.8576
R4386 VGND.n655 VGND.t800 12.8576
R4387 VGND.n659 VGND.t1561 12.8576
R4388 VGND.t1562 VGND.n123 12.8576
R4389 VGND.n668 VGND.t334 12.8576
R4390 VGND.t335 VGND.n114 12.8576
R4391 VGND.t363 VGND.n112 12.8576
R4392 VGND.n671 VGND.t364 12.8576
R4393 VGND.t631 VGND.n197 12.8576
R4394 VGND.n218 VGND.t632 12.8576
R4395 VGND.t220 VGND.n196 12.8576
R4396 VGND.n219 VGND.t221 12.8576
R4397 VGND.n226 VGND.t545 12.8576
R4398 VGND.t546 VGND.n188 12.8576
R4399 VGND.n227 VGND.t792 12.8576
R4400 VGND.t793 VGND.n187 12.8576
R4401 VGND.n238 VGND.t551 12.8576
R4402 VGND.t552 VGND.n175 12.8576
R4403 VGND.n239 VGND.t786 12.8576
R4404 VGND.t787 VGND.n174 12.8576
R4405 VGND.t295 VGND.n280 12.8576
R4406 VGND.n314 VGND.t296 12.8576
R4407 VGND.n320 VGND.t1520 12.8576
R4408 VGND.t1521 VGND.n272 12.8576
R4409 VGND.n323 VGND.t112 12.8576
R4410 VGND.t113 VGND.n269 12.8576
R4411 VGND.t262 VGND.n368 12.8576
R4412 VGND.n379 VGND.t263 12.8576
R4413 VGND.t751 VGND.n364 12.8576
R4414 VGND.n383 VGND.t752 12.8576
R4415 VGND.n387 VGND.t68 12.8576
R4416 VGND.t69 VGND.n359 12.8576
R4417 VGND.n391 VGND.t713 12.8576
R4418 VGND.t714 VGND.n355 12.8576
R4419 VGND.t606 VGND.n486 12.8576
R4420 VGND.n491 VGND.t607 12.8576
R4421 VGND.n497 VGND.t700 12.8576
R4422 VGND.t701 VGND.n479 12.8576
R4423 VGND.n577 VGND.t1470 12.8576
R4424 VGND.t1471 VGND.n561 12.8576
R4425 VGND.n583 VGND.t889 12.8576
R4426 VGND.t890 VGND.n554 12.8576
R4427 VGND.t1447 VGND.n552 12.8576
R4428 VGND.n586 VGND.t1448 12.8576
R4429 VGND.t1479 VGND.n549 12.8576
R4430 VGND.n589 VGND.t1480 12.8576
R4431 VGND.n815 VGND.n73 9.0005
R4432 VGND.n648 VGND.n73 9.0005
R4433 VGND.n572 VGND.n570 9.0005
R4434 VGND.n574 VGND.n568 9.0005
R4435 VGND.n617 VGND.n523 9.0005
R4436 VGND.n613 VGND.n523 9.0005
R4437 VGND.n83 VGND.n82 9.0005
R4438 VGND.n694 VGND.n693 9.0005
R4439 VGND.t190 VGND.t771 8.57193
R4440 VGND.t419 VGND.t715 8.57193
R4441 VGND.t677 VGND.t980 8.57193
R4442 VGND.n61 VGND.t1422 0.0719145
R4443 VGND.t1420 VGND.n10 8.501
R4444 VGND.n60 VGND.t1417 0.130189
R4445 VGND.t1415 VGND.n10 8.501
R4446 VGND.t1412 VGND.n59 0.130189
R4447 VGND.n58 VGND.t1407 0.215686
R4448 VGND.t1405 VGND.n10 8.501
R4449 VGND.n57 VGND.t1402 0.130189
R4450 VGND.t1400 VGND.n10 8.501
R4451 VGND.n56 VGND.t1397 0.130189
R4452 VGND.t1395 VGND.n10 8.501
R4453 VGND.n55 VGND.t1392 0.130189
R4454 VGND.t1390 VGND.n10 8.501
R4455 VGND.n54 VGND.t1387 0.130189
R4456 VGND.t1385 VGND.n10 8.501
R4457 VGND.n53 VGND.t1382 0.130189
R4458 VGND.t1380 VGND.n10 8.501
R4459 VGND.n52 VGND.t1377 0.130189
R4460 VGND.t1375 VGND.n10 8.501
R4461 VGND.n51 VGND.t1372 0.130189
R4462 VGND.t1370 VGND.n10 8.501
R4463 VGND.n50 VGND.n10 3.33079
R4464 VGND.n68 VGND.n10 2.31501
R4465 VGND.n67 VGND.t1363 0.130189
R4466 VGND.t1361 VGND.n10 8.501
R4467 VGND.n66 VGND.t1358 0.130189
R4468 VGND.t1356 VGND.n10 8.501
R4469 VGND.n65 VGND.t1353 0.130189
R4470 VGND.t1351 VGND.n10 8.501
R4471 VGND.n64 VGND.t1348 0.130189
R4472 VGND.t1346 VGND.n10 8.501
R4473 VGND.n63 VGND.t1343 0.130189
R4474 VGND.t1341 VGND.n10 8.501
R4475 VGND.n10 VGND.n62 3.33079
R4476 VGND.n69 VGND.t5 1.35976
R4477 VGND.n72 VGND.t924 0.152573
R4478 VGND.t917 VGND.n71 0.633676
R4479 VGND.n70 VGND.n27 1.0909
R4480 VGND.n10 VGND.n61 4.2093
R4481 VGND.n60 VGND.n10 3.33079
R4482 VGND.n10 VGND.n59 3.33079
R4483 VGND.n57 VGND.n10 3.33079
R4484 VGND.n10 VGND.n56 3.33079
R4485 VGND.n55 VGND.n10 3.33079
R4486 VGND.n10 VGND.n54 3.33079
R4487 VGND.n53 VGND.n10 3.33079
R4488 VGND.n10 VGND.n52 3.33079
R4489 VGND.n51 VGND.n10 3.33079
R4490 VGND.n50 VGND.t1368 0.0863258
R4491 VGND.n10 VGND.n67 3.33079
R4492 VGND.n66 VGND.n10 3.33079
R4493 VGND.n10 VGND.n65 3.33079
R4494 VGND.n64 VGND.n10 3.33079
R4495 VGND.n10 VGND.n63 3.33079
R4496 VGND.t1339 VGND.n62 0.0863258
R4497 VGND.t1410 VGND.n795 5.16578
R4498 VGND.t931 VGND.n574 4.61666
R4499 VGND.n613 VGND.t206 4.61666
R4500 VGND.n623 VGND.t444 4.5005
R4501 VGND.n629 VGND.t994 4.5005
R4502 VGND.t260 VGND.n630 4.5005
R4503 VGND.t18 VGND.n153 4.5005
R4504 VGND.n647 VGND.t1147 4.5005
R4505 VGND.t797 VGND.n649 4.5005
R4506 VGND.n814 VGND.t310 4.5005
R4507 VGND.t194 VGND.n75 4.5005
R4508 VGND.t1356 VGND.n812 4.5005
R4509 VGND.t513 VGND.n618 4.5005
R4510 VGND.t1019 VGND.n331 4.5005
R4511 VGND.n632 VGND.t1073 4.5005
R4512 VGND.t1115 VGND.n633 4.5005
R4513 VGND.t1165 VGND.n85 4.5005
R4514 VGND.n691 VGND.t1208 4.5005
R4515 VGND.n697 VGND.t41 4.5005
R4516 VGND.n795 VGND.t1298 4.5005
R4517 VGND.n571 VGND.n421 4.49573
R4518 VGND.n696 VGND.n695 4.49573
R4519 VGND.n818 VGND.n817 4.49046
R4520 VGND.n816 VGND.n73 4.49046
R4521 VGND.n818 VGND.n74 4.49046
R4522 VGND.n569 VGND.n568 4.49046
R4523 VGND.n573 VGND.n572 4.49046
R4524 VGND.n616 VGND.n524 4.49046
R4525 VGND.n615 VGND.n523 4.49046
R4526 VGND.n614 VGND.n524 4.49046
R4527 VGND.n694 VGND.n84 4.49046
R4528 VGND.n692 VGND.n83 4.49046
R4529 VGND.t5 VGND.n13 0.903505
R4530 VGND.n27 VGND.t202 4.177
R4531 VGND.n10 VGND.n58 2.33238
R4532 VGND.t845 VGND.n68 0.383459
R4533 VGND.n27 VGND.n72 2.06295
R4534 VGND.t1018 VGND.n259 2.75379
R4535 VGND.n572 VGND.n523 2.17938
R4536 VGND.n694 VGND.n73 2.17938
R4537 VGND.n646 VGND.t1162 1.97623
R4538 VGND.t5 VGND.t301 1.76601
R4539 VGND.n69 VGND.t1117 0.0899486
R4540 VGND.n27 VGND.n525 1.4151
R4541 VGND.n70 VGND.t841 0.0854993
R4542 VGND.t125 VGND.t93 1.26877
R4543 VGND.t1196 VGND.t181 1.24547
R4544 VGND.t1274 VGND.t1281 1.21971
R4545 VGND.t5 VGND.t1107 1.21971
R4546 VGND.t122 VGND.t125 1.21624
R4547 VGND.t837 VGND.t198 1.20493
R4548 VGND.t228 VGND.t218 1.1884
R4549 VGND.n13 VGND.t1113 0.013847
R4550 VGND.t590 VGND.t676 1.15703
R4551 VGND.n27 VGND.t898 1.15509
R4552 VGND.n77 VGND.t302 1.14392
R4553 VGND.t351 VGND.t171 1.11701
R4554 VGND.t1237 VGND.t42 1.10768
R4555 VGND.t851 VGND.n81 1.09461
R4556 VGND.t801 VGND.n133 1.09062
R4557 VGND.t1224 VGND.t171 1.08322
R4558 VGND.n558 VGND.t870 1.08258
R4559 VGND.t7 VGND.t210 1.0811
R4560 VGND.n165 VGND.t214 1.08052
R4561 VGND.t25 VGND.t1550 1.07761
R4562 VGND.t801 VGND.t351 1.07617
R4563 VGND.t157 VGND.n419 1.07467
R4564 VGND.t76 VGND.t1224 1.07097
R4565 VGND.n419 VGND.t66 1.06772
R4566 VGND.t96 VGND.t302 1.06683
R4567 VGND.t50 VGND.n288 1.06341
R4568 VGND.t122 VGND.n76 1.06341
R4569 VGND.t31 VGND.t1286 1.05584
R4570 VGND.t1010 VGND.n626 1.05378
R4571 VGND.n81 VGND.t845 1.0535
R4572 VGND.t601 VGND.t597 1.05134
R4573 VGND.t597 VGND.t1 1.05003
R4574 VGND.n181 VGND.t7 1.04475
R4575 VGND.n625 VGND.t726 1.04408
R4576 VGND.t228 VGND.t231 1.0436
R4577 VGND.t103 VGND.t5 0.387642
R4578 VGND.t1 VGND.t891 1.04047
R4579 VGND.t86 VGND.n86 1.03978
R4580 VGND.n417 VGND.t1061 1.03974
R4581 VGND.t218 VGND.t1147 1.03456
R4582 VGND.t457 VGND.t454 1.03329
R4583 VGND.n625 VGND.t139 1.02826
R4584 VGND.t682 VGND.t590 1.02684
R4585 VGND.t1290 VGND.t1292 1.01465
R4586 VGND.n9 VGND.t15 0.40549
R4587 VGND.n418 VGND.t157 1.01246
R4588 VGND.t620 VGND.t457 1.00967
R4589 VGND.t620 VGND.t682 1.00757
R4590 VGND.t137 VGND.t139 1.00756
R4591 VGND.n624 VGND.t134 1.00457
R4592 VGND.t5 VGND.n9 0.196829
R4593 VGND.t134 VGND.t137 0.999184
R4594 VGND.t726 VGND.n626 0.990468
R4595 VGND.n86 VGND.t76 0.988247
R4596 VGND.n422 VGND.t942 0.979464
R4597 VGND.t891 VGND.t870 0.974591
R4598 VGND.t66 VGND.n420 0.965668
R4599 VGND.t1550 VGND.t837 0.959848
R4600 VGND.t198 VGND.t194 0.942091
R4601 VGND.n417 VGND.t1073 0.940234
R4602 VGND.t50 VGND.t61 0.920109
R4603 VGND.t260 VGND.n631 0.915053
R4604 VGND.t994 VGND.n628 0.915053
R4605 VGND.t1165 VGND.t1167 0.911226
R4606 VGND.t96 VGND.t93 0.910534
R4607 VGND.t454 VGND.t444 0.898162
R4608 VGND.n288 VGND.t18 0.898101
R4609 VGND.t310 VGND.n76 0.898101
R4610 VGND.t1298 VGND.n698 0.887897
R4611 VGND.t1061 VGND.n418 0.885453
R4612 VGND.t1298 VGND.t1296 0.873947
R4613 VGND.t39 VGND.t1073 0.870905
R4614 VGND.t204 VGND.t206 0.866232
R4615 VGND.t676 VGND.t237 0.852664
R4616 VGND.t1286 VGND.t1290 0.834398
R4617 VGND.n71 VGND.n27 0.683203
R4618 VGND.t25 VGND.t31 0.802429
R4619 VGND.t1019 VGND.n627 0.801572
R4620 VGND.n624 VGND.t994 0.801326
R4621 VGND.t1296 VGND.t1274 0.800627
R4622 VGND.t931 VGND.n558 0.799786
R4623 VGND.t1147 VGND.n154 0.791318
R4624 VGND.t1296 VGND.t1292 0.784895
R4625 VGND.t260 VGND.n420 0.784482
R4626 VGND.n71 VGND.t204 0.0610663
R4627 VGND.t39 VGND.t37 0.734447
R4628 VGND.t1141 VGND.n154 0.708781
R4629 VGND.t349 VGND.t1208 0.705589
R4630 VGND.n627 VGND.t3 0.682974
R4631 VGND.t1050 VGND.n631 0.669243
R4632 VGND.t989 VGND.n628 0.669243
R4633 VGND.t841 VGND.t931 0.665917
R4634 VGND.n812 VGND.n75 0.66578
R4635 VGND.n814 VGND.n75 0.66578
R4636 VGND.n649 VGND.n647 0.66578
R4637 VGND.n647 VGND.n153 0.66578
R4638 VGND.n630 VGND.n153 0.66578
R4639 VGND.n630 VGND.n629 0.66578
R4640 VGND.n629 VGND.n623 0.66578
R4641 VGND.n795 VGND.n697 0.66578
R4642 VGND.n691 VGND.n85 0.66578
R4643 VGND.n633 VGND.n85 0.66578
R4644 VGND.n633 VGND.n632 0.66578
R4645 VGND.n632 VGND.n331 0.66578
R4646 VGND.n618 VGND.n331 0.66578
R4647 VGND.t532 VGND.t1167 0.66087
R4648 VGND.n70 VGND.t895 0.534202
R4649 VGND.n627 VGND.n259 0.655078
R4650 VGND.t1274 VGND.n699 0.649813
R4651 VGND.t1274 VGND.n702 0.649813
R4652 VGND.t1274 VGND.n761 0.649813
R4653 VGND.t1274 VGND.n706 0.649813
R4654 VGND.t1274 VGND.n759 0.649813
R4655 VGND.t1274 VGND.n710 0.649813
R4656 VGND.t1274 VGND.n757 0.649813
R4657 VGND.t1274 VGND.n714 0.649813
R4658 VGND.t1274 VGND.n755 0.649813
R4659 VGND.t1274 VGND.n720 0.649813
R4660 VGND.t1274 VGND.n753 0.649813
R4661 VGND.t1274 VGND.n732 0.649813
R4662 VGND.t1274 VGND.n752 0.649813
R4663 VGND.t1274 VGND.n80 0.649813
R4664 VGND.t1196 VGND.n87 0.649813
R4665 VGND.t1196 VGND.n89 0.649813
R4666 VGND.t1196 VGND.n90 0.649813
R4667 VGND.t1196 VGND.n152 0.649813
R4668 VGND.t1196 VGND.n151 0.649813
R4669 VGND.t1196 VGND.n147 0.649813
R4670 VGND.t1196 VGND.n102 0.649813
R4671 VGND.t1196 VGND.n145 0.649813
R4672 VGND.t1196 VGND.n144 0.649813
R4673 VGND.t1196 VGND.n106 0.649813
R4674 VGND.t1196 VGND.n143 0.649813
R4675 VGND.t1196 VGND.n142 0.649813
R4676 VGND.t1196 VGND.n137 0.649813
R4677 VGND.n646 VGND.n645 0.649813
R4678 VGND.n646 VGND.n157 0.649813
R4679 VGND.n646 VGND.n252 0.649813
R4680 VGND.n646 VGND.n161 0.649813
R4681 VGND.n646 VGND.n248 0.649813
R4682 VGND.n646 VGND.n164 0.649813
R4683 VGND.n646 VGND.n167 0.649813
R4684 VGND.n646 VGND.n231 0.649813
R4685 VGND.n646 VGND.n213 0.649813
R4686 VGND.n646 VGND.n206 0.649813
R4687 VGND.t5 VGND.n0 0.649813
R4688 VGND.t5 VGND.n8 0.649813
R4689 VGND.t5 VGND.n7 0.649813
R4690 VGND.t5 VGND.n2 0.649813
R4691 VGND.t5 VGND.n3 0.649813
R4692 VGND.t5 VGND.n4 0.649813
R4693 VGND.t5 VGND.n6 0.649813
R4694 VGND.t5 VGND.n5 0.649813
R4695 VGND.n640 VGND.t5 427.5
R4696 VGND.n416 VGND.n257 0.649813
R4697 VGND.n416 VGND.n414 0.649813
R4698 VGND.n416 VGND.n333 0.649813
R4699 VGND.n416 VGND.n345 0.649813
R4700 VGND.n416 VGND.n395 0.649813
R4701 VGND.n416 VGND.n393 0.649813
R4702 VGND.n416 VGND.n261 0.649813
R4703 VGND.t942 VGND.n423 0.649813
R4704 VGND.t942 VGND.n425 0.649813
R4705 VGND.t942 VGND.n426 0.649813
R4706 VGND.t942 VGND.n451 0.649813
R4707 VGND.t942 VGND.n447 0.649813
R4708 VGND.t942 VGND.n428 0.649813
R4709 VGND.t942 VGND.n429 0.649813
R4710 VGND.t942 VGND.n430 0.649813
R4711 VGND.t942 VGND.n446 0.649813
R4712 VGND.t942 VGND.n444 0.649813
R4713 VGND.t942 VGND.n443 0.649813
R4714 VGND.t942 VGND.n442 0.649813
R4715 VGND.t942 VGND.n441 0.649813
R4716 VGND.t942 VGND.n436 0.649813
R4717 VGND.n27 VGND.n18 0.649813
R4718 VGND.n27 VGND.n17 0.649813
R4719 VGND.n27 VGND.n16 0.649813
R4720 VGND.n27 VGND.n15 0.649813
R4721 VGND.n27 VGND.n19 0.356967
R4722 VGND.n27 VGND.n26 0.649813
R4723 VGND.n27 VGND.n25 0.649813
R4724 VGND.n27 VGND.n20 0.649813
R4725 VGND.n27 VGND.n21 0.649813
R4726 VGND.n27 VGND.n22 0.649813
R4727 VGND.n27 VGND.n24 0.649813
R4728 VGND.n27 VGND.n23 0.649813
R4729 VGND.n608 VGND.n44 427.5
R4730 VGND.t1274 VGND.n698 0.635634
R4731 VGND.n416 VGND.t39 0.632534
R4732 VGND.t1274 VGND.t31 0.620732
R4733 VGND.t843 VGND.n698 0.620188
R4734 VGND.n646 VGND.t1167 0.617165
R4735 VGND.t637 VGND.t349 0.611097
R4736 VGND.t1196 VGND.t349 0.608794
R4737 VGND.t1274 VGND.t1290 0.604578
R4738 VGND.t86 VGND.t181 0.603967
R4739 VGND.t895 VGND.t898 0.602045
R4740 VGND VGND.n818 0.56194
R4741 VGND.n69 VGND.t35 0.439794
R4742 VGND.t137 VGND.n259 0.553856
R4743 VGND.n420 VGND.n416 0.529193
R4744 VGND.t214 VGND.t1162 0.526459
R4745 VGND.n649 VGND.n648 0.52498
R4746 VGND.n693 VGND.n691 0.52498
R4747 VGND.n525 VGND.t924 0.508205
R4748 VGND.t1274 VGND.t1550 0.505489
R4749 VGND.t1208 VGND.t181 0.504074
R4750 VGND.t1162 VGND.t1165 0.497155
R4751 VGND.n77 VGND.t41 0.495657
R4752 VGND.t301 VGND.t35 0.492708
R4753 VGND.n9 VGND.t61 0.199554
R4754 VGND.t942 VGND.t620 0.490425
R4755 VGND.n27 VGND.n558 0.481929
R4756 VGND.n418 VGND.n416 0.473062
R4757 VGND.n525 VGND.t206 0.466018
R4758 VGND.n624 VGND.n259 0.464458
R4759 VGND.n419 VGND.n416 0.46381
R4760 VGND.n81 VGND.n10 0.463092
R4761 VGND.t1196 VGND.n86 0.462968
R4762 VGND.n27 VGND.t891 0.454585
R4763 VGND.t42 VGND.n76 0.427478
R4764 VGND.t5 VGND.n288 0.427478
R4765 VGND.t942 VGND.t454 0.427355
R4766 VGND.n623 VGND.n421 0.4229
R4767 VGND.n618 VGND.n617 0.4229
R4768 VGND.n631 VGND.n416 0.413575
R4769 VGND.n628 VGND.n259 0.413575
R4770 VGND.t1117 VGND.t1118 0.397273
R4771 VGND.t850 VGND.n43 91.7676
R4772 VGND.t1196 VGND.n133 0.383696
R4773 VGND.n646 VGND.n154 0.357895
R4774 VGND.t444 VGND.n422 0.347617
R4775 VGND.n452 VGND.t513 0.344594
R4776 VGND.t42 VGND.t96 0.344014
R4777 VGND.n68 VGND.t1366 0.238436
R4778 VGND.t1196 VGND.t351 0.33813
R4779 VGND.t1019 VGND.t1018 0.334655
R4780 VGND.t942 VGND.n452 0.331759
R4781 VGND.n625 VGND.n259 0.323112
R4782 VGND.n626 VGND.n259 0.316092
R4783 VGND.n133 VGND.t797 0.31572
R4784 VGND.t1196 VGND.t1224 0.308482
R4785 VGND.t1408 VGND.n58 0.0850573
R4786 VGND.t202 VGND.t917 0.286144
R4787 VGND.n13 VGND.t1115 0.332214
R4788 VGND.t301 VGND.t1115 0.279487
R4789 VGND.n646 VGND.n165 0.26651
R4790 VGND.t1274 VGND.t198 0.264957
R4791 VGND.t42 VGND.t125 0.252599
R4792 VGND.t1010 VGND.t1018 0.252401
R4793 VGND.n646 VGND.n181 0.245901
R4794 VGND.t601 VGND.t202 0.237394
R4795 VGND.t1339 VGND.t1341 0.226736
R4796 VGND.t1346 VGND.t1344 0.226736
R4797 VGND.t1349 VGND.t1351 0.226736
R4798 VGND.t1356 VGND.t1354 0.226736
R4799 VGND.t1359 VGND.t1361 0.226736
R4800 VGND.t1366 VGND.t1364 0.226736
R4801 VGND.t1370 VGND.t1368 0.226736
R4802 VGND.t1373 VGND.t1375 0.226736
R4803 VGND.t1380 VGND.t1378 0.226736
R4804 VGND.t1383 VGND.t1385 0.226736
R4805 VGND.t1390 VGND.t1388 0.226736
R4806 VGND.t1393 VGND.t1395 0.226736
R4807 VGND.t1400 VGND.t1398 0.226736
R4808 VGND.t1403 VGND.t1405 0.226736
R4809 VGND.t1415 VGND.t1413 0.226736
R4810 VGND.t1418 VGND.t1420 0.226736
R4811 VGND.t310 VGND.t1237 0.218652
R4812 VGND.t1338 VGND.n62 0.130189
R4813 VGND.n64 VGND.t1349 0.0863258
R4814 VGND.n66 VGND.t1359 0.0863258
R4815 VGND.n51 VGND.t1373 0.0863258
R4816 VGND.n53 VGND.t1383 0.0863258
R4817 VGND.n55 VGND.t1393 0.0863258
R4818 VGND.n57 VGND.t1403 0.0863258
R4819 VGND.n60 VGND.t1418 0.0863258
R4820 VGND.t1413 VGND.n59 0.0863258
R4821 VGND.t1398 VGND.n56 0.0863258
R4822 VGND.t1388 VGND.n54 0.0863258
R4823 VGND.t1378 VGND.n52 0.0863258
R4824 VGND.n50 VGND.t851 0.130189
R4825 VGND.t1364 VGND.n67 0.0863258
R4826 VGND.t1354 VGND.n65 0.0863258
R4827 VGND.t1344 VGND.n63 0.0863258
R4828 VGND.t940 VGND.n72 0.153437
R4829 VGND.n165 VGND.t210 0.197124
R4830 VGND.n452 VGND.t237 0.192704
R4831 VGND.n646 VGND.t218 0.191897
R4832 VGND.n181 VGND.t231 0.190363
R4833 VGND.t42 VGND.n77 0.179293
R4834 VGND.n27 VGND.t597 0.166297
R4835 VGND.n417 VGND.n416 0.160879
R4836 VGND.t1423 VGND.n61 0.0716963
R4837 VGND.t1408 VGND.t1410 0.135506
R4838 VGND.t942 VGND.t590 0.129874
R4839 VGND.t42 VGND.t40 0.113833
R4840 VGND.t2 VGND.n259 0.113833
R4841 VGND.t194 VGND.t1281 0.10675
R4842 VGND.t18 VGND.t1107 0.10675
R4843 VGND.t1341 VGND.t1343 0.0855
R4844 VGND.t1348 VGND.t1346 0.0855
R4845 VGND.t1351 VGND.t1353 0.0855
R4846 VGND.t1358 VGND.t1356 0.0855
R4847 VGND.t1361 VGND.t1363 0.0855
R4848 VGND.t1372 VGND.t1370 0.0855
R4849 VGND.t1375 VGND.t1377 0.0855
R4850 VGND.t1382 VGND.t1380 0.0855
R4851 VGND.t1385 VGND.t1387 0.0855
R4852 VGND.t1392 VGND.t1390 0.0855
R4853 VGND.t1395 VGND.t1397 0.0855
R4854 VGND.t1402 VGND.t1400 0.0855
R4855 VGND.t1405 VGND.t1407 0.0855
R4856 VGND.t1412 VGND.t1410 0.0855
R4857 VGND.t1417 VGND.t1415 0.0855
R4858 VGND.t1420 VGND.t1422 0.07425
R4859 VGND.n817 VGND.n816 0.0436411
R4860 VGND.n573 VGND.n569 0.0436411
R4861 VGND.n816 VGND.n74 0.0436411
R4862 VGND.n692 VGND.n84 0.0436411
R4863 VGND.n616 VGND.n615 0.0436411
R4864 VGND.n615 VGND.n614 0.0436411
R4865 VGND.n570 VGND.n421 0.04274
R4866 VGND.n696 VGND.n82 0.04274
R4867 VGND.t1274 VGND.n703 0.0258175
R4868 VGND.t1274 VGND.n760 0.0258175
R4869 VGND.t1274 VGND.n707 0.0258175
R4870 VGND.t1274 VGND.n758 0.0258175
R4871 VGND.t1274 VGND.n711 0.0258175
R4872 VGND.t1274 VGND.n756 0.0258175
R4873 VGND.t1274 VGND.n715 0.0258175
R4874 VGND.t1274 VGND.n754 0.0258175
R4875 VGND.t1274 VGND.n744 0.0258175
R4876 VGND.t1274 VGND.n750 0.0258175
R4877 VGND.t1274 VGND.n746 0.0258175
R4878 VGND.t1274 VGND.n748 0.0258175
R4879 VGND.t1196 VGND.n150 0.0258175
R4880 VGND.t1196 VGND.n92 0.0258175
R4881 VGND.t1196 VGND.n148 0.0258175
R4882 VGND.t1196 VGND.n146 0.0258175
R4883 VGND.t1196 VGND.n141 0.0258175
R4884 VGND.t1196 VGND.n134 0.0258175
R4885 VGND.t1196 VGND.n139 0.0258175
R4886 VGND.t1196 VGND.n136 0.0258175
R4887 VGND.n646 VGND.n256 0.0258175
R4888 VGND.n646 VGND.n255 0.0258175
R4889 VGND.n646 VGND.n158 0.0258175
R4890 VGND.n646 VGND.n251 0.0258175
R4891 VGND.n646 VGND.n162 0.0258175
R4892 VGND.n646 VGND.n198 0.0258175
R4893 VGND.n646 VGND.n212 0.0258175
R4894 VGND.n646 VGND.n201 0.0258175
R4895 VGND.n646 VGND.n210 0.0258175
R4896 VGND.n646 VGND.n203 0.0258175
R4897 VGND.n646 VGND.n208 0.0258175
R4898 VGND.n646 VGND.n205 0.0258175
R4899 VGND.n32 VGND.t276 52.5379
R4900 VGND.t5 VGND.t1108 109.992
R4901 VGND.n416 VGND.n411 0.0258175
R4902 VGND.n416 VGND.n337 0.0258175
R4903 VGND.n416 VGND.n409 0.0258175
R4904 VGND.n416 VGND.n339 0.0258175
R4905 VGND.n416 VGND.n407 0.0258175
R4906 VGND.n416 VGND.n341 0.0258175
R4907 VGND.n416 VGND.n405 0.0258175
R4908 VGND.n416 VGND.n343 0.0258175
R4909 VGND.n416 VGND.n370 0.0258175
R4910 VGND.n416 VGND.n376 0.0258175
R4911 VGND.n416 VGND.n372 0.0258175
R4912 VGND.n416 VGND.n374 0.0258175
R4913 VGND.t942 VGND.n450 0.0258175
R4914 VGND.t942 VGND.n427 0.0258175
R4915 VGND.t942 VGND.n448 0.0258175
R4916 VGND.t942 VGND.n431 0.0258175
R4917 VGND.t942 VGND.n445 0.0258175
R4918 VGND.t942 VGND.n440 0.0258175
R4919 VGND.t942 VGND.n433 0.0258175
R4920 VGND.t942 VGND.n438 0.0258175
R4921 VGND.t942 VGND.n435 0.0258175
R4922 VGND.n648 VGND.n74 0.0220706
R4923 VGND.n817 VGND.n815 0.0220706
R4924 VGND.n570 VGND.n569 0.0220706
R4925 VGND.n574 VGND.n573 0.0220706
R4926 VGND.n617 VGND.n616 0.0220706
R4927 VGND.n614 VGND.n613 0.0220706
R4928 VGND.n84 VGND.n82 0.0220706
R4929 VGND.n693 VGND.n692 0.0220706
R4930 VGND.n524 VGND.n523 0.02162
R4931 VGND.n818 VGND.n73 0.02162
R4932 VGND.n812 VGND 0.01986
R4933 VGND.n422 VGND.t948 0.0159033
R4934 VGND.n815 VGND.n814 0.01458
R4935 VGND.n697 VGND.n696 0.01458
R4936 VGND.n572 VGND.n571 0.0115476
R4937 VGND.n571 VGND.n568 0.0115476
R4938 VGND.n695 VGND.n83 0.0115476
R4939 VGND.n695 VGND.n694 0.0115476
R4940 VGND.n10 VGND.t1409 183.805
R4941 VGND.t1394 VGND.n10 183.805
R4942 VGND.t1374 VGND.n10 183.805
R4943 VGND.n416 VGND.n334 0.00196766
R4944 VGND.t1274 VGND.n762 0.00194928
R4945 VGND.t1274 VGND.n751 0.00194928
R4946 VGND.t1274 VGND.n745 0.00194928
R4947 VGND.t1274 VGND.n749 0.00194928
R4948 VGND.t1274 VGND.n747 0.00194928
R4949 VGND.t1196 VGND.n149 0.00194928
R4950 VGND.t1196 VGND.n132 0.00194928
R4951 VGND.t1196 VGND.n140 0.00194928
R4952 VGND.t1196 VGND.n135 0.00194928
R4953 VGND.t1196 VGND.n138 0.00194928
R4954 VGND.n646 VGND.n211 0.00194928
R4955 VGND.n646 VGND.n202 0.00194928
R4956 VGND.n646 VGND.n209 0.00194928
R4957 VGND.n646 VGND.n204 0.00194928
R4958 VGND.n646 VGND.n207 0.00194928
R4959 VGND.n416 VGND.n410 0.00194928
R4960 VGND.n416 VGND.n338 0.00194928
R4961 VGND.n416 VGND.n408 0.00194928
R4962 VGND.n416 VGND.n340 0.00194928
R4963 VGND.n416 VGND.n406 0.00194928
R4964 VGND.n416 VGND.n342 0.00194928
R4965 VGND.n416 VGND.n377 0.00194928
R4966 VGND.n416 VGND.n371 0.00194928
R4967 VGND.n416 VGND.n375 0.00194928
R4968 VGND.n416 VGND.n373 0.00194928
R4969 VGND.t942 VGND.n449 0.00194928
R4970 VGND.t942 VGND.n432 0.00194928
R4971 VGND.t942 VGND.n439 0.00194928
R4972 VGND.t942 VGND.n434 0.00194928
R4973 VGND.t942 VGND.n437 0.00194928
R4974 VGND.n48 VGND.n10 14.0759
R4975 VGND.n810 VGND.n10 1.25129
R4976 VGND.t5 VGND.n1 1.05577
C0 a_5108_838# VPWR 2.21571f
C1 sg13cmos5l_buf_1_6.A a_5684_6132# 0.04843f
C2 sg13cmos5l_buf_1_5.A sg13cmos5l_buf_16_34.X 0.06162f
C3 sg13cmos5l_xor2_1_6.X sg13cmos5l_and2_2_3.B 0.02572f
C4 sg13cmos5l_buf_16_31.X sg13cmos5l_and2_2_0.X 0.06722f
C5 a_13916_11752# VPWR 0.25248f
C6 a_8948_13692# a_10292_12934# 0.02189f
C7 sg13cmos5l_buf_16_30.A a_5504_1718# 0.03802f
C8 sg13cmos5l_and2_2_2.B sg13cmos5l_buf_16_19.A 0.02389f
C9 sg13cmos5l_buf_1_6.A a_10318_5410# 0.01092f
C10 sg13cmos5l_buf_16_8.A sg13cmos5l_xor2_1_0.B 0.71967f
C11 a_10318_8434# VPWR 2.25886f
C12 sg13cmos5l_buf_1_22.X out_xor[6] 0.11867f
C13 a_6332_9192# VPWR 0.2502f
C14 sg13cmos5l_buf_16_4.A a_9524_6886# 0.60079f
C15 sg13cmos5l_buf_16_5.X VPWR 3.97753f
C16 a_4462_5410# sg13cmos5l_buf_16_7.X 0.07695f
C17 sg13cmos5l_buf_16_3.X a_10318_5410# 0.5778f
C18 a_13472_13098# VPWR 0.07435f
C19 a_3694_10704# sg13cmos5l_and2_2_6.A 1.29316f
C20 a_12350_13728# VPWR 0.01075f
C21 sg13cmos5l_xor2_1_4.X a_14344_8468# 0.17071f
C22 a_3694_14482# sg13cmos5l_buf_16_33.A 1.29313f
C23 sg13cmos5l_buf_16_11.A VPWR 3.31013f
C24 a_5204_11422# a_5024_11586# 0.0364f
C25 sg13cmos5l_buf_16_24.X a_6094_10704# 0.08668f
C26 sg13cmos5l_and2_2_2.B sg13cmos5l_buf_16_27.X 0.03461f
C27 sg13cmos5l_and2_2_0.B a_4052_12934# 0.02996f
C28 a_5224_7050# VPWR 0.18957f
C29 sg13cmos5l_buf_16_1.X VPWR 4.06045f
C30 a_2147_13692# VPWR 0.58381f
C31 sg13cmos5l_and2_2_3.B a_13745_11508# 0.05072f
C32 sg13cmos5l_and2_2_5.B a_11565_8028# 0.34969f
C33 sg13cmos5l_buf_16_34.X sg13cmos5l_and2_2_6.A 0.11262f
C34 sg13cmos5l_buf_16_8.A VPWR 3.97299f
C35 a_5710_1632# VPWR 2.23524f
C36 a_3668_3108# sg13cmos5l_buf_16_7.A 1.35325f
C37 sg13cmos5l_buf_16_19.A a_5204_11422# 0.61423f
C38 sg13cmos5l_and2_2_0.B sg13cmos5l_and2_2_1.X 1.29196f
C39 sg13cmos5l_and2_2_1.X a_3968_13814# 0.03802f
C40 sg13cmos5l_and2_2_2.B sg13cmos5l_buf_16_18.A 0.33148f
C41 sg13cmos5l_buf_1_22.X a_14824_13004# 0.33441f
C42 sg13cmos5l_xor2_1_0.B a_8538_2578# 0.41585f
C43 sg13cmos5l_buf_16_20.A sg13cmos5l_buf_16_24.A 0.05491f
C44 a_3694_14482# glitch_en[2] 0.04742f
C45 a_6161_12574# a_6332_12216# 0.41432f
C46 a_6765_12564# sg13cmos5l_buf_16_19.A 0.22946f
C47 sg13cmos5l_and2_2_3.X out_xor[5] 0.01429f
C48 a_3488_14610# VPWR 0.07233f
C49 sg13cmos5l_buf_16_15.A sg13cmos5l_buf_16_24.X 0.2915f
C50 sg13cmos5l_buf_16_27.X glitch_en[3] 0.07238f
C51 sg13cmos5l_buf_16_14.A a_3668_9156# 0.64891f
C52 sg13cmos5l_buf_1_2.X a_14536_1718# 0.01156f
C53 sg13cmos5l_and2_2_3.B sg13cmos5l_buf_1_15.X 0.52491f
C54 glitch_en[5] glitch_en[4] 0.01599f
C55 a_5518_6922# enable 0.0778f
C56 a_9524_6886# sg13cmos5l_buf_1_6.A 0.03358f
C57 a_15016_12302# VPWR 0.17765f
C58 a_11898_13691# a_11924_13728# 0.41432f
C59 a_11272_13728# sg13cmos5l_and2_2_5.B 0.2906f
C60 a_6548_13692# sg13cmos5l_buf_16_37.X 0.61804f
C61 sg13cmos5l_buf_16_33.A sg13cmos5l_buf_16_18.A 0.27302f
C62 a_6094_3898# VPWR 2.18569f
C63 a_14824_10704# VPWR 0.36546f
C64 a_11565_8028# sg13cmos5l_buf_16_4.A 0.23562f
C65 sg13cmos5l_buf_16_7.X sg13cmos5l_buf_16_30.A 0.02417f
C66 a_8538_2578# VPWR 0.31462f
C67 sg13cmos5l_buf_16_6.X VPWR 3.62483f
C68 sg13cmos5l_buf_16_0.A a_6094_3144# 0.0535f
C69 a_14720_14610# VPWR 0.07393f
C70 sg13cmos5l_buf_16_22.X sg13cmos5l_xor2_1_4.X 0.30347f
C71 sg13cmos5l_xor2_1_0.B a_3668_4620# 0.05748f
C72 sg13cmos5l_buf_16_5.A a_5108_838# 0.60418f
C73 a_9617_8484# sg13cmos5l_xor2_1_5.X 0.27638f
C74 sg13cmos5l_buf_1_5.A a_10292_4620# 0.02645f
C75 sg13cmos5l_xor2_1_4.X sg13cmos5l_xor2_1_5.X 0.11647f
C76 sg13cmos5l_buf_16_28.X enable 0.19046f
C77 a_13667_12956# VPWR 0.57944f
C78 sg13cmos5l_buf_16_39.A a_6164_2350# 0.61093f
C79 sg13cmos5l_xor2_1_4.X sg13cmos5l_buf_1_14.X 0.07575f
C80 sg13cmos5l_buf_16_14.A sg13cmos5l_buf_16_34.A 0.02288f
C81 sg13cmos5l_buf_16_31.X a_5684_6132# 0.10772f
C82 sg13cmos5l_buf_1_5.A a_6836_9156# 0.01433f
C83 sg13cmos5l_buf_1_17.X a_11924_13728# 0.0146f
C84 a_13745_11508# sg13cmos5l_xor2_1_7.X 0.31422f
C85 sg13cmos5l_buf_16_23.X sg13cmos5l_and2_2_5.B 0.15555f
C86 sg13cmos5l_buf_16_5.X sg13cmos5l_buf_16_5.A 0.04292f
C87 a_9056_7766# VPWR 0.07114f
C88 sg13cmos5l_buf_16_24.A VPWR 3.4423f
C89 a_5684_6132# a_6094_4656# 0.01391f
C90 sg13cmos5l_buf_16_15.X glitch_en[1] 0.0108f
C91 a_13288_8562# VPWR 0.14746f
C92 sg13cmos5l_and2_2_4.B VPWR 0.56188f
C93 a_5320_6254# VPWR 0.12411f
C94 a_3694_3898# enable 0.0447f
C95 sg13cmos5l_buf_16_28.X a_4462_5410# 0.01022f
C96 a_3488_7766# VPWR 0.09155f
C97 a_2147_13692# sg13cmos5l_and2_2_1.X 0.20607f
C98 sg13cmos5l_buf_16_24.X sg13cmos5l_buf_16_20.A 0.02488f
C99 sg13cmos5l_and2_2_6.X a_6766_8434# 0.09025f
C100 a_3668_4620# VPWR 2.19054f
C101 sg13cmos5l_buf_16_31.X sg13cmos5l_buf_1_6.A 3.07383f
C102 sg13cmos5l_buf_16_23.X sg13cmos5l_buf_16_37.A 0.05906f
C103 a_5684_6132# a_5504_6254# 0.0364f
C104 sg13cmos5l_buf_1_5.A a_5684_6132# 0.05981f
C105 a_1672_14516# VPWR 0.29473f
C106 a_3668_9156# VPWR 2.23415f
C107 a_5710_1632# sg13cmos5l_buf_16_5.A 1.35923f
C108 a_7432_14516# glitch_en[3] 0.3298f
C109 sg13cmos5l_buf_1_5.A a_10318_5410# 0.08431f
C110 sg13cmos5l_buf_16_10.A sg13cmos5l_buf_16_5.X 0.07581f
C111 a_6766_8434# VPWR 2.27655f
C112 sg13cmos5l_and2_2_3.B VPWR 0.83061f
C113 sg13cmos5l_and2_2_3.B a_13581_9988# 0.35683f
C114 sg13cmos5l_buf_16_15.A a_6332_12216# 0.01075f
C115 sg13cmos5l_xor2_1_5.X sg13cmos5l_buf_1_4.A 0.02144f
C116 sg13cmos5l_and2_2_0.B sg13cmos5l_buf_16_13.A 0.22654f
C117 sg13cmos5l_and2_2_6.A a_6836_9156# 0.0425f
C118 sg13cmos5l_buf_1_17.A VPWR 1.96287f
C119 sg13cmos5l_buf_16_6.X a_9788_8728# 0.0156f
C120 sg13cmos5l_buf_16_33.A sg13cmos5l_and2_2_2.B 0.13567f
C121 a_3694_8434# a_3694_7680# 0.18924f
C122 a_3694_7680# enable 0.08956f
C123 sg13cmos5l_buf_1_5.A sg13cmos5l_buf_1_6.A 0.66641f
C124 sg13cmos5l_and2_2_6.A a_7520_7766# 0.04565f
C125 a_3488_10790# VPWR 0.09212f
C126 a_11272_13728# glitch_en[4] 0.33094f
C127 sg13cmos5l_and2_2_3.X sg13cmos5l_buf_1_22.X 0.1233f
C128 a_3875_5396# a_3680_5538# 0.02895f
C129 sg13cmos5l_buf_1_5.A sg13cmos5l_buf_16_3.X 0.04869f
C130 sg13cmos5l_buf_16_34.A VPWR 3.39664f
C131 a_8948_13692# VPWR 2.35913f
C132 a_6161_9550# a_6332_9192# 0.41432f
C133 sg13cmos5l_and2_2_6.B sg13cmos5l_buf_16_24.A 0.39943f
C134 sg13cmos5l_buf_16_24.X VPWR 3.80931f
C135 a_14536_1718# VPWR 0.14079f
C136 a_14444_14442# a_14824_14516# 0.07249f
C137 a_13576_14516# sg13cmos5l_and2_2_3.B 0.28895f
C138 sg13cmos5l_buf_16_34.X a_3694_7680# 1.2948f
C139 sg13cmos5l_buf_16_35.A sg13cmos5l_buf_1_6.A 0.048f
C140 a_14344_11492# VPWR 0.27112f
C141 sg13cmos5l_buf_16_27.X a_11924_13728# 0.01187f
C142 sg13cmos5l_and2_2_2.B a_6765_12564# 0.32482f
C143 a_6094_3898# sg13cmos5l_buf_16_0.A 1.29491f
C144 sg13cmos5l_buf_16_23.X glitch_en[4] 0.07155f
C145 a_14824_5444# out_xor[2] 0.28895f
C146 sg13cmos5l_buf_16_33.A a_5204_11422# 0.09991f
C147 a_12232_12216# a_12040_12302# 0.01225f
C148 sg13cmos5l_buf_16_37.X VPWR 3.61055f
C149 a_3496_5538# VPWR 0.14367f
C150 sg13cmos5l_xor2_1_4.X a_13916_8728# 0.14436f
C151 a_6164_2350# sg13cmos5l_buf_1_2.A 0.03691f
C152 a_4721_6526# sg13cmos5l_buf_1_6.A 0.25855f
C153 sg13cmos5l_and2_2_6.B a_6766_8434# 0.02917f
C154 a_14444_14442# sg13cmos5l_xor2_1_6.X 0.01484f
C155 sg13cmos5l_xor2_1_7.X VPWR 0.18445f
C156 sg13cmos5l_buf_16_39.A sg13cmos5l_buf_1_2.X 0.1683f
C157 a_6548_13692# a_7796_12934# 0.02845f
C158 a_3668_12180# a_3488_12302# 0.0364f
C159 a_13480_7766# a_13664_7766# 0.11523f
C160 a_6094_3898# sg13cmos5l_buf_16_10.A 0.0117f
C161 a_13664_4026# VPWR 0.11601f
C162 a_13768_7680# sg13cmos5l_buf_1_4.A 0.2906f
C163 a_13768_9192# VPWR 0.30285f
C164 sg13cmos5l_buf_16_33.A glitch_en[2] 0.04109f
C165 sg13cmos5l_buf_16_24.A a_6862_9946# 0.64114f
C166 a_14536_7050# VPWR 0.15149f
C167 sg13cmos5l_buf_1_23.A a_13480_7766# 0.01787f
C168 sg13cmos5l_buf_16_5.X a_6094_3144# 0.60219f
C169 a_5518_6922# a_5684_6132# 0.1301f
C170 sg13cmos5l_and2_2_6.X sg13cmos5l_buf_16_25.A 0.06995f
C171 sg13cmos5l_and2_2_0.B sg13cmos5l_buf_16_8.A 0.33009f
C172 sg13cmos5l_buf_1_5.A a_4436_9910# 0.02951f
C173 a_6164_2350# sg13cmos5l_buf_16_30.A 1.30149f
C174 sg13cmos5l_xor2_1_6.X a_11898_13691# 0.25068f
C175 sg13cmos5l_and2_2_3.X sg13cmos5l_buf_1_11.X 0.72392f
C176 sg13cmos5l_buf_1_17.X a_10292_12934# 0.02699f
C177 sg13cmos5l_buf_16_37.A a_10112_13098# 0.0395f
C178 sg13cmos5l_and2_2_6.B sg13cmos5l_buf_16_24.X 0.19178f
C179 sg13cmos5l_buf_1_15.X a_14252_9906# 0.29175f
C180 sg13cmos5l_buf_16_33.A sg13cmos5l_buf_1_5.A 0.05981f
C181 sg13cmos5l_buf_16_5.X a_5108_838# 1.30812f
C182 a_2728_14610# VPWR 0.19157f
C183 sg13cmos5l_buf_16_31.X a_6094_4656# 1.32148f
C184 sg13cmos5l_buf_16_25.A VPWR 3.49809f
C185 sg13cmos5l_buf_16_15.A a_3668_12180# 0.65407f
C186 a_5518_6922# sg13cmos5l_buf_1_6.A 0.03307f
C187 sg13cmos5l_buf_1_5.A a_5204_11422# 0.05441f
C188 sg13cmos5l_buf_16_28.X a_5684_6132# 1.33308f
C189 sg13cmos5l_and2_2_6.X sg13cmos5l_buf_1_23.A 1.07723f
C190 a_6332_12216# VPWR 0.25565f
C191 a_11898_13691# a_11656_13814# 0.03572f
C192 a_4174_13728# a_6548_13692# 0.03943f
C193 sg13cmos5l_and2_2_6.B sg13cmos5l_buf_16_37.X 0.10099f
C194 a_15016_4742# VPWR 0.17315f
C195 sg13cmos5l_buf_16_31.X sg13cmos5l_buf_1_5.A 0.21786f
C196 sg13cmos5l_and2_2_5.B a_10292_12934# 0.07247f
C197 a_13664_7766# VPWR 0.06268f
C198 a_3694_2386# VPWR 2.5039f
C199 sg13cmos5l_buf_1_5.A a_6765_12564# 0.14745f
C200 sg13cmos5l_buf_1_23.A VPWR 1.06085f
C201 sg13cmos5l_and2_2_1.B VPWR 0.55699f
C202 sg13cmos5l_buf_16_31.X sg13cmos5l_buf_16_7.X 0.03114f
C203 a_5710_1632# a_5108_838# 0.03594f
C204 sg13cmos5l_and2_2_6.A a_4436_9910# 0.09428f
C205 sg13cmos5l_buf_1_5.A a_6094_4656# 0.02027f
C206 sg13cmos5l_buf_16_1.X a_10318_8434# 0.59066f
C207 sg13cmos5l_xor2_1_4.X a_13576_9278# 0.05844f
C208 sg13cmos5l_buf_16_28.X sg13cmos5l_buf_1_6.A 0.08514f
C209 sg13cmos5l_buf_16_14.A a_3694_8434# 0.06953f
C210 sg13cmos5l_buf_16_7.X a_6094_4656# 0.57856f
C211 a_3668_4620# a_3488_4742# 0.0364f
C212 sg13cmos5l_buf_16_33.A sg13cmos5l_and2_2_6.A 0.0808f
C213 sg13cmos5l_buf_16_14.A enable 0.03834f
C214 sg13cmos5l_buf_16_5.X a_5710_1632# 0.05916f
C215 sg13cmos5l_buf_16_24.X a_6862_9946# 1.37803f
C216 a_9262_7680# VPWR 2.20407f
C217 sg13cmos5l_xor2_1_6.X sg13cmos5l_and2_2_5.B 0.0693f
C218 sg13cmos5l_xor2_1_0.B sg13cmos5l_buf_16_39.A 0.34252f
C219 sg13cmos5l_buf_1_15.X sg13cmos5l_buf_16_22.X 0.01525f
C220 sg13cmos5l_buf_16_37.A a_10292_12934# 0.017f
C221 sg13cmos5l_buf_16_8.A sg13cmos5l_buf_16_11.A 0.03043f
C222 a_14344_8468# VPWR 0.264f
C223 a_6094_3898# a_6094_3144# 0.18924f
C224 sg13cmos5l_buf_16_4.X a_8110_6168# 0.0116f
C225 a_4689_6168# VPWR 0.01075f
C226 sg13cmos5l_buf_16_34.X sg13cmos5l_buf_16_14.A 0.38716f
C227 a_15104_8562# VPWR 0.10668f
C228 sg13cmos5l_and2_2_6.B sg13cmos5l_buf_16_25.A 0.08367f
C229 sg13cmos5l_buf_16_31.X a_4721_6526# 0.41648f
C230 sg13cmos5l_and2_2_5.B a_11656_13814# 0.02116f
C231 sg13cmos5l_buf_16_4.X VPWR 3.51038f
C232 a_14824_6956# out_xor[3] 0.28955f
C233 sg13cmos5l_buf_16_19.A a_6094_10704# 0.0582f
C234 sg13cmos5l_xor2_1_0.B sg13cmos5l_buf_16_7.A 0.10267f
C235 a_14252_9906# VPWR 0.34791f
C236 a_13581_9988# a_14252_9906# 0.02728f
C237 sg13cmos5l_buf_1_5.A sg13cmos5l_buf_16_35.A 0.05622f
C238 sg13cmos5l_buf_1_2.A sg13cmos5l_buf_1_2.X 0.01876f
C239 sg13cmos5l_buf_16_39.A VPWR 5.39332f
C240 sg13cmos5l_and2_2_0.B a_3668_9156# 0.04471f
C241 a_3668_9156# sg13cmos5l_buf_16_13.A 1.35129f
C242 a_1672_14516# sg13cmos5l_and2_2_0.B 0.28943f
C243 sg13cmos5l_buf_16_2.A a_13745_8484# 0.09312f
C244 sg13cmos5l_buf_16_6.X a_10318_8434# 0.04218f
C245 a_7796_12934# VPWR 2.43902f
C246 sg13cmos5l_and2_2_6.B sg13cmos5l_buf_1_23.A 0.03433f
C247 sg13cmos5l_buf_16_2.A a_8110_6168# 0.01791f
C248 a_13664_5538# VPWR 0.11893f
C249 sg13cmos5l_buf_1_5.A sg13cmos5l_and2_2_6.A 0.10848f
C250 sg13cmos5l_buf_1_6.A a_4892_6168# 0.11764f
C251 sg13cmos5l_xor2_1_6.X sg13cmos5l_buf_16_27.X 0.25766f
C252 sg13cmos5l_and2_2_6.A a_7629_8028# 0.12029f
C253 a_13667_12956# a_13472_13098# 0.02895f
C254 a_3694_10704# VPWR 2.27185f
C255 a_1480_14610# glitch_en[0] 0.06428f
C256 sg13cmos5l_buf_16_22.X a_13745_8484# 0.42739f
C257 sg13cmos5l_buf_16_2.A VPWR 4.382f
C258 sg13cmos5l_buf_16_7.A VPWR 3.72874f
C259 a_3694_8434# VPWR 2.18947f
C260 a_14444_14442# VPWR 0.28366f
C261 sg13cmos5l_buf_1_11.X sg13cmos5l_xor2_1_4.X 0.05297f
C262 VPWR enable 1.63887f
C263 sg13cmos5l_xor2_1_5.X a_13745_8484# 0.0583f
C264 a_3668_12180# VPWR 2.33005f
C265 sg13cmos5l_buf_16_6.X sg13cmos5l_buf_16_1.X 0.21913f
C266 sg13cmos5l_buf_16_13.A sg13cmos5l_buf_16_34.A 0.18238f
C267 sg13cmos5l_and2_2_1.B sg13cmos5l_and2_2_1.X 0.81501f
C268 sg13cmos5l_and2_2_6.A sg13cmos5l_buf_16_35.A 0.06609f
C269 sg13cmos5l_and2_2_0.B sg13cmos5l_buf_16_34.A 0.25418f
C270 a_6548_13692# sg13cmos5l_buf_16_27.X 1.32819f
C271 sg13cmos5l_buf_16_23.X a_11272_13728# 0.01933f
C272 sg13cmos5l_buf_16_15.X sg13cmos5l_buf_16_15.A 0.09218f
C273 sg13cmos5l_xor2_1_0.B a_8564_2680# 0.03711f
C274 sg13cmos5l_buf_16_7.X a_3668_3108# 0.0908f
C275 sg13cmos5l_buf_16_22.X VPWR 3.43119f
C276 sg13cmos5l_buf_16_22.X a_13581_9988# 0.12413f
C277 a_14824_14516# out_xor[7] 0.28827f
C278 sg13cmos5l_xor2_1_6.X glitch_en[4] 0.03033f
C279 sg13cmos5l_buf_16_34.X VPWR 3.86087f
C280 sg13cmos5l_xor2_1_0.B sg13cmos5l_and2_2_0.X 0.06841f
C281 sg13cmos5l_buf_1_6.A sg13cmos5l_buf_1_5.X 0.04285f
C282 sg13cmos5l_xor2_1_5.X VPWR 0.68964f
C283 a_11898_13691# VPWR 0.26396f
C284 sg13cmos5l_buf_1_14.X VPWR 0.54135f
C285 a_4174_13728# VPWR 2.19398f
C286 a_6862_9946# sg13cmos5l_buf_1_23.A 0.02512f
C287 sg13cmos5l_buf_16_11.A a_3668_4620# 0.58966f
C288 a_4462_5410# VPWR 2.20754f
C289 VPWR out_xor[2] 0.14045f
C290 sg13cmos5l_buf_16_31.X sg13cmos5l_buf_16_28.X 0.07163f
C291 a_8000_1718# VPWR 0.07825f
C292 a_3872_13098# VPWR 0.12088f
C293 sg13cmos5l_buf_1_5.A a_5518_6922# 0.05138f
C294 sg13cmos5l_buf_16_39.A a_8104_1632# 0.012f
C295 sg13cmos5l_and2_2_6.B a_7796_12934# 0.02232f
C296 a_10112_4026# VPWR 0.11854f
C297 sg13cmos5l_xor2_1_0.B sg13cmos5l_buf_1_2.A 0.03393f
C298 sg13cmos5l_xor2_1_6.X out_xor[7] 0.06146f
C299 sg13cmos5l_buf_16_8.A a_3668_4620# 1.37653f
C300 a_9344_7050# VPWR 0.06942f
C301 sg13cmos5l_buf_16_18.A sg13cmos5l_buf_16_15.A 0.04534f
C302 sg13cmos5l_buf_1_17.X VPWR 1.20091f
C303 sg13cmos5l_buf_16_10.A a_3694_2386# 0.06056f
C304 a_8564_2680# VPWR 0.27141f
C305 sg13cmos5l_and2_2_0.X VPWR 0.86625f
C306 a_3020_14442# a_2728_14610# 0.03269f
C307 VPWR out_xor[3] 0.1333f
C308 sg13cmos5l_buf_16_35.A a_9617_8484# 0.09184f
C309 a_3694_2386# a_5984_2514# 0.0364f
C310 sg13cmos5l_buf_1_5.A sg13cmos5l_buf_16_28.X 0.1072f
C311 a_10292_4620# a_10112_4742# 0.0364f
C312 a_4168_10074# VPWR 0.16109f
C313 a_4052_12934# a_3668_12180# 0.12256f
C314 sg13cmos5l_xor2_1_6.X glitch_en[6] 0.04734f
C315 a_3304_14610# glitch_en[1] 0.05864f
C316 a_3875_5396# sg13cmos5l_xor2_1_0.B 0.12058f
C317 sg13cmos5l_buf_16_2.A a_10318_3898# 0.60196f
C318 sg13cmos5l_and2_2_5.B VPWR 1.7226f
C319 sg13cmos5l_buf_16_0.A sg13cmos5l_buf_16_39.A 0.01412f
C320 sg13cmos5l_buf_1_2.A VPWR 0.38278f
C321 a_6161_9550# sg13cmos5l_buf_1_23.A 0.25482f
C322 sg13cmos5l_buf_1_6.A a_13768_3932# 0.32815f
C323 VPWR out_xor[4] 0.25089f
C324 a_3020_14442# sg13cmos5l_and2_2_1.B 0.28895f
C325 a_12232_12216# VPWR 0.32132f
C326 a_9788_8728# sg13cmos5l_xor2_1_5.X 0.12039f
C327 a_14824_9192# sg13cmos5l_buf_1_14.X 0.31638f
C328 a_10292_4620# sg13cmos5l_buf_16_2.X 0.60365f
C329 sg13cmos5l_buf_16_7.X a_3694_3898# 0.04158f
C330 sg13cmos5l_buf_16_31.X a_4892_6168# 0.01885f
C331 a_5024_11586# VPWR 0.07029f
C332 sg13cmos5l_and2_2_4.B a_13667_12956# 0.3457f
C333 a_4174_13728# a_4052_12934# 0.09102f
C334 a_13768_7680# VPWR 0.2893f
C335 sg13cmos5l_xor2_1_7.X a_13916_11752# 0.12312f
C336 a_3694_14482# VPWR 2.16022f
C337 a_4052_12934# a_3872_13098# 0.0364f
C338 sg13cmos5l_xor2_1_6.X glitch_en[5] 0.31172f
C339 sg13cmos5l_buf_16_37.A VPWR 3.59246f
C340 sg13cmos5l_buf_16_30.A VPWR 3.58021f
C341 a_6836_9156# sg13cmos5l_and2_2_6.X 0.63904f
C342 sg13cmos5l_and2_2_0.B sg13cmos5l_and2_2_1.B 0.02272f
C343 sg13cmos5l_buf_16_33.A a_6094_10704# 0.56942f
C344 VPWR out_xor[5] 0.17125f
C345 a_3875_5396# VPWR 0.53753f
C346 sg13cmos5l_buf_16_19.A VPWR 1.02704f
C347 a_13745_8484# a_13916_8728# 0.41432f
C348 sg13cmos5l_and2_2_1.X a_4174_13728# 0.59389f
C349 sg13cmos5l_and2_2_2.B a_6548_13692# 0.01745f
C350 a_10292_4620# VPWR 2.19661f
C351 a_4840_11586# a_3694_10704# 0.01121f
C352 sg13cmos5l_and2_2_3.B a_13667_12956# 0.03066f
C353 a_5204_11422# a_6094_10704# 0.01302f
C354 sg13cmos5l_buf_16_4.A VPWR 1.08341f
C355 a_6836_9156# VPWR 2.18576f
C356 a_6161_12574# sg13cmos5l_buf_1_5.A 0.28216f
C357 sg13cmos5l_buf_16_15.X VPWR 3.80708f
C358 sg13cmos5l_buf_1_17.A a_13667_12956# 0.20977f
C359 a_13916_8728# VPWR 0.2501f
C360 sg13cmos5l_buf_16_27.X VPWR 3.24748f
C361 a_9160_7050# a_9344_7050# 0.11523f
C362 a_3668_12180# a_4840_11586# 0.0111f
C363 sg13cmos5l_buf_16_4.X sg13cmos5l_buf_16_38.A 0.01657f
C364 sg13cmos5l_buf_16_10.A enable 0.01798f
C365 a_10318_5410# sg13cmos5l_buf_16_2.X 0.06715f
C366 VPWR out_xor[6] 0.34181f
C367 a_7520_7766# VPWR 0.06633f
C368 sg13cmos5l_and2_2_3.B sg13cmos5l_and2_2_4.B 1.28156f
C369 sg13cmos5l_xor2_1_0.B a_8494_3144# 0.04705f
C370 a_14824_9192# out_xor[4] 0.2906f
C371 a_3694_2386# a_5108_838# 0.01068f
C372 sg13cmos5l_buf_1_2.A a_8104_1632# 0.33391f
C373 sg13cmos5l_buf_16_33.A sg13cmos5l_buf_16_15.A 0.28557f
C374 a_3694_3898# a_3668_3108# 0.11845f
C375 sg13cmos5l_buf_16_28.X a_5518_6922# 0.60574f
C376 a_5684_6132# VPWR 2.19361f
C377 sg13cmos5l_buf_1_5.A sg13cmos5l_buf_1_5.X 0.07387f
C378 sg13cmos5l_buf_16_5.X a_3694_2386# 0.02416f
C379 sg13cmos5l_buf_1_23.A a_10318_8434# 0.01068f
C380 sg13cmos5l_buf_16_18.A VPWR 3.41183f
C381 sg13cmos5l_buf_1_23.A a_6332_9192# 0.11764f
C382 sg13cmos5l_buf_16_15.A a_5204_11422# 0.08728f
C383 a_10318_5410# VPWR 2.23113f
C384 VPWR glitch_en[4] 0.51908f
C385 a_4721_6526# a_4892_6168# 0.41432f
C386 a_5684_6132# sg13cmos5l_buf_16_28.A 0.57749f
C387 sg13cmos5l_buf_16_24.X sg13cmos5l_buf_16_24.A 0.97297f
C388 sg13cmos5l_buf_1_6.A a_8110_6168# 0.08151f
C389 sg13cmos5l_buf_1_5.A a_6094_10704# 0.06694f
C390 sg13cmos5l_buf_16_31.X a_7220_5374# 0.04502f
C391 sg13cmos5l_buf_16_2.A sg13cmos5l_buf_16_38.A 0.0609f
C392 a_10318_8434# a_9262_7680# 0.05296f
C393 sg13cmos5l_buf_16_34.A a_3488_7766# 0.03873f
C394 sg13cmos5l_and2_2_6.B sg13cmos5l_buf_16_19.A 0.07735f
C395 sg13cmos5l_buf_1_2.A sg13cmos5l_buf_16_5.A 0.02142f
C396 sg13cmos5l_and2_2_3.B sg13cmos5l_buf_1_17.A 0.15373f
C397 a_8494_3144# VPWR 2.36415f
C398 sg13cmos5l_buf_1_6.A VPWR 1.32349f
C399 sg13cmos5l_and2_2_0.B a_3694_10704# 0.10241f
C400 a_7220_5374# a_6094_4656# 0.10281f
C401 a_4436_9910# sg13cmos5l_buf_16_14.A 1.37862f
C402 a_14824_13004# VPWR 0.35238f
C403 sg13cmos5l_buf_16_0.A sg13cmos5l_buf_1_2.A 0.01892f
C404 a_6094_3144# sg13cmos5l_buf_16_39.A 0.04852f
C405 a_3668_9156# sg13cmos5l_buf_16_34.A 0.01721f
C406 sg13cmos5l_buf_1_4.A a_14720_7050# 0.06202f
C407 sg13cmos5l_and2_2_3.X a_13745_11508# 0.41175f
C408 sg13cmos5l_buf_16_13.A a_3694_8434# 0.59328f
C409 sg13cmos5l_and2_2_6.B a_6836_9156# 0.03085f
C410 sg13cmos5l_and2_2_1.B a_2147_13692# 0.32384f
C411 a_3694_14482# sg13cmos5l_and2_2_1.X 0.04637f
C412 sg13cmos5l_and2_2_0.B a_3694_8434# 0.09911f
C413 a_5992_14516# sg13cmos5l_and2_2_2.B 0.28895f
C414 sg13cmos5l_buf_16_3.X VPWR 3.33725f
C415 VPWR out_xor[7] 0.11793f
C416 sg13cmos5l_and2_2_0.B enable 0.03211f
C417 a_4840_1002# VPWR 0.15897f
C418 sg13cmos5l_and2_2_0.B a_3668_12180# 0.0415f
C419 sg13cmos5l_buf_1_6.A sg13cmos5l_buf_16_28.A 0.03007f
C420 sg13cmos5l_and2_2_6.B sg13cmos5l_buf_16_27.X 0.17697f
C421 a_10292_4620# a_10318_3898# 0.10636f
C422 sg13cmos5l_buf_16_1.X a_9262_7680# 0.12317f
C423 sg13cmos5l_buf_16_23.X a_10292_12934# 1.3557f
C424 sg13cmos5l_buf_1_15.X sg13cmos5l_buf_1_11.X 0.12637f
C425 sg13cmos5l_buf_16_20.A a_4436_9910# 0.59739f
C426 sg13cmos5l_buf_1_6.A a_13768_5444# 0.03015f
C427 sg13cmos5l_buf_1_5.A a_7220_5374# 0.08615f
C428 a_9585_8752# VPWR 0.01075f
C429 a_7432_14516# VPWR 0.37103f
C430 a_13576_9278# VPWR 0.17901f
C431 sg13cmos5l_buf_16_15.A sg13cmos5l_buf_1_5.A 0.01552f
C432 sg13cmos5l_buf_16_34.X sg13cmos5l_buf_16_13.A 0.04031f
C433 sg13cmos5l_buf_16_33.A sg13cmos5l_buf_16_20.A 0.35529f
C434 a_6094_10704# sg13cmos5l_and2_2_6.A 0.01312f
C435 sg13cmos5l_and2_2_0.B sg13cmos5l_buf_16_34.X 0.36276f
C436 sg13cmos5l_buf_1_22.X VPWR 0.81402f
C437 a_15016_13814# VPWR 0.17302f
C438 a_9524_6886# a_8110_6168# 0.08261f
C439 sg13cmos5l_and2_2_3.X sg13cmos5l_buf_1_15.X 0.4028f
C440 sg13cmos5l_and2_2_0.B a_4174_13728# 0.02811f
C441 sg13cmos5l_buf_16_15.X sg13cmos5l_and2_2_1.X 0.03362f
C442 a_5992_14516# sg13cmos5l_buf_16_33.A 0.02447f
C443 VPWR glitch_en[6] 0.25899f
C444 a_11272_13728# a_11656_13814# 0.03269f
C445 a_4840_11586# a_5024_11586# 0.11523f
C446 a_5204_11422# sg13cmos5l_buf_16_20.A 1.35224f
C447 sg13cmos5l_buf_16_35.A a_7220_5374# 0.04702f
C448 a_9524_6886# VPWR 2.26726f
C449 sg13cmos5l_buf_16_1.X sg13cmos5l_buf_16_4.X 0.01916f
C450 sg13cmos5l_buf_16_18.A a_4052_12934# 0.58956f
C451 a_1864_13814# VPWR 0.18669f
C452 sg13cmos5l_and2_2_2.B VPWR 0.79676f
C453 a_6862_9946# a_6836_9156# 0.11845f
C454 a_10318_8434# sg13cmos5l_buf_16_2.A 0.01424f
C455 a_5504_1718# VPWR 0.09118f
C456 sg13cmos5l_buf_1_23.A sg13cmos5l_buf_16_6.X 0.01634f
C457 a_3694_7680# sg13cmos5l_buf_16_28.X 0.03692f
C458 sg13cmos5l_buf_16_5.X enable 0.0682f
C459 VPWR glitch_en[5] 0.56189f
C460 sg13cmos5l_and2_2_0.B sg13cmos5l_and2_2_0.X 0.02932f
C461 sg13cmos5l_buf_1_5.A sg13cmos5l_buf_16_14.A 0.01623f
C462 sg13cmos5l_xor2_1_6.X a_11924_13728# 0.11687f
C463 sg13cmos5l_buf_16_37.X a_8948_13692# 0.04878f
C464 a_4436_9910# VPWR 2.20521f
C465 sg13cmos5l_buf_16_11.A enable 0.18868f
C466 sg13cmos5l_buf_16_6.X a_9262_7680# 0.19136f
C467 a_5992_14516# glitch_en[2] 0.3193f
C468 sg13cmos5l_buf_16_22.X a_10318_8434# 1.30038f
C469 sg13cmos5l_buf_16_33.A VPWR 3.82114f
C470 sg13cmos5l_buf_16_24.A sg13cmos5l_buf_1_23.A 0.07703f
C471 sg13cmos5l_buf_1_2.X a_14720_1718# 0.06162f
C472 sg13cmos5l_and2_2_0.B a_4168_10074# 0.01107f
C473 sg13cmos5l_buf_16_1.X sg13cmos5l_buf_16_2.A 0.40813f
C474 a_10318_8434# sg13cmos5l_xor2_1_5.X 0.09679f
C475 sg13cmos5l_buf_1_5.A sg13cmos5l_buf_16_20.A 0.66173f
C476 sg13cmos5l_buf_16_25.A a_6766_8434# 0.59968f
C477 a_7432_14516# sg13cmos5l_and2_2_6.B 0.28895f
C478 VPWR glitch_en[3] 0.35942f
C479 a_5204_11422# VPWR 2.2217f
C480 sg13cmos5l_xor2_1_7.X a_14344_11492# 0.47839f
C481 a_3488_4026# VPWR 0.0906f
C482 sg13cmos5l_buf_1_11.X VPWR 0.65656f
C483 a_13576_14516# glitch_en[5] 0.32083f
C484 sg13cmos5l_buf_1_11.X a_13581_9988# 0.0109f
C485 a_4462_5410# sg13cmos5l_buf_16_11.A 1.38167f
C486 sg13cmos5l_buf_16_6.X sg13cmos5l_buf_16_4.X 0.2306f
C487 a_3488_2514# VPWR 0.09599f
C488 sg13cmos5l_buf_16_0.A a_8494_3144# 0.59332f
C489 sg13cmos5l_buf_16_31.X VPWR 8.3691f
C490 a_6161_9550# a_6836_9156# 0.03775f
C491 sg13cmos5l_and2_2_0.B a_3694_14482# 0.04212f
C492 a_6765_12564# VPWR 0.55185f
C493 sg13cmos5l_xor2_1_0.B sg13cmos5l_buf_16_7.X 0.09541f
C494 sg13cmos5l_and2_2_6.A sg13cmos5l_buf_16_14.A 0.82172f
C495 sg13cmos5l_and2_2_3.X VPWR 1.45253f
C496 sg13cmos5l_buf_16_1.X sg13cmos5l_xor2_1_5.X 0.08525f
C497 sg13cmos5l_buf_1_5.A sg13cmos5l_buf_16_2.X 0.01226f
C498 sg13cmos5l_and2_2_3.X a_13581_9988# 0.2067f
C499 sg13cmos5l_buf_16_39.A a_8538_2578# 0.13907f
C500 a_6094_4656# VPWR 2.2216f
C501 sg13cmos5l_and2_2_2.B sg13cmos5l_and2_2_6.B 0.08834f
C502 sg13cmos5l_buf_16_4.X a_9056_7766# 0.03947f
C503 sg13cmos5l_buf_16_31.X sg13cmos5l_buf_16_28.A 0.71633f
C504 sg13cmos5l_and2_2_0.B a_3875_5396# 0.35676f
C505 VPWR glitch_en[2] 0.25432f
C506 a_11565_8028# VPWR 0.54864f
C507 sg13cmos5l_buf_1_4.A sg13cmos5l_buf_1_5.X 0.04309f
C508 sg13cmos5l_buf_16_8.A a_4462_5410# 0.02509f
C509 sg13cmos5l_and2_2_6.X a_7629_8028# 0.20614f
C510 sg13cmos5l_buf_1_5.A a_8110_6168# 0.0235f
C511 sg13cmos5l_and2_2_2.B a_4052_12934# 0.02708f
C512 a_10292_12934# a_10112_13098# 0.0364f
C513 a_5710_1632# a_8000_1718# 0.0364f
C514 sg13cmos5l_and2_2_0.X sg13cmos5l_buf_16_11.A 0.01203f
C515 sg13cmos5l_buf_16_20.A sg13cmos5l_and2_2_6.A 0.08918f
C516 a_13472_8562# VPWR 0.07246f
C517 a_13768_3932# sg13cmos5l_buf_1_1.A 0.28895f
C518 sg13cmos5l_buf_16_24.X a_6332_12216# 0.01208f
C519 a_6094_3898# enable 0.60196f
C520 a_7336_7766# a_7520_7766# 0.11523f
C521 sg13cmos5l_and2_2_0.B sg13cmos5l_buf_16_15.X 0.46154f
C522 a_5504_6254# VPWR 0.06896f
C523 sg13cmos5l_buf_1_5.A VPWR 1.92919f
C524 a_7629_8028# VPWR 0.53823f
C525 sg13cmos5l_buf_16_6.X sg13cmos5l_buf_16_2.A 0.51521f
C526 sg13cmos5l_and2_2_5.B a_10318_8434# 0.06694f
C527 sg13cmos5l_and2_2_6.X sg13cmos5l_buf_16_35.A 0.25328f
C528 sg13cmos5l_buf_16_6.X enable 0.07018f
C529 sg13cmos5l_buf_16_7.X VPWR 3.98042f
C530 sg13cmos5l_buf_16_35.A a_8110_6168# 0.59238f
C531 VPWR glitch_en[1] 0.27918f
C532 sg13cmos5l_buf_16_24.X sg13cmos5l_buf_1_23.A 0.11536f
C533 sg13cmos5l_buf_16_33.A a_4052_12934# 0.10106f
C534 sg13cmos5l_buf_16_8.A sg13cmos5l_and2_2_0.X 0.15414f
C535 sg13cmos5l_buf_1_5.A sg13cmos5l_buf_16_28.A 0.10816f
C536 a_3488_9278# VPWR 0.0912f
C537 a_1480_14610# VPWR 0.15487f
C538 sg13cmos5l_buf_16_30.A a_5108_838# 0.04844f
C539 sg13cmos5l_and2_2_6.B glitch_en[3] 0.02138f
C540 sg13cmos5l_buf_1_5.A a_13768_5444# 0.32083f
C541 a_11272_13728# VPWR 0.32958f
C542 sg13cmos5l_buf_16_35.A VPWR 4.01559f
C543 sg13cmos5l_buf_16_22.X sg13cmos5l_buf_16_6.X 0.01436f
C544 sg13cmos5l_buf_1_5.X a_14824_5444# 0.32154f
C545 sg13cmos5l_and2_2_6.A sg13cmos5l_and2_2_6.X 0.01088f
C546 sg13cmos5l_and2_2_5.B sg13cmos5l_buf_16_1.X 0.04162f
C547 sg13cmos5l_buf_16_5.X sg13cmos5l_buf_16_30.A 0.96409f
C548 sg13cmos5l_buf_16_6.X sg13cmos5l_xor2_1_5.X 0.3132f
C549 sg13cmos5l_buf_16_33.A sg13cmos5l_and2_2_1.X 0.01891f
C550 a_14444_14442# sg13cmos5l_and2_2_4.B 0.28855f
C551 sg13cmos5l_buf_16_35.A sg13cmos5l_buf_16_28.A 0.07235f
C552 sg13cmos5l_xor2_1_0.B a_3668_3108# 0.09357f
C553 VPWR glitch_en[0] 0.2564f
C554 sg13cmos5l_buf_1_2.A a_5710_1632# 0.01532f
C555 sg13cmos5l_buf_1_6.A sg13cmos5l_buf_16_38.A 0.10554f
C556 sg13cmos5l_and2_2_6.A VPWR 3.53324f
C557 a_4721_6526# VPWR 0.25773f
C558 sg13cmos5l_buf_1_1.A a_14824_3144# 0.32435f
C559 sg13cmos5l_buf_16_23.X VPWR 3.59721f
C560 sg13cmos5l_buf_1_4.A a_14824_6956# 0.32396f
C561 a_3668_9156# a_3694_8434# 0.10636f
C562 a_8538_2578# a_8564_2680# 0.41432f
C563 a_14720_1718# VPWR 0.06899f
C564 sg13cmos5l_xor2_1_6.X a_14824_14516# 0.33574f
C565 a_13713_11776# VPWR 0.01143f
C566 sg13cmos5l_and2_2_6.B sg13cmos5l_buf_1_5.A 0.03659f
C567 a_8948_13692# a_7796_12934# 0.03601f
C568 sg13cmos5l_buf_16_30.A a_5710_1632# 0.59783f
C569 a_5320_6254# a_4462_5410# 0.0111f
C570 sg13cmos5l_buf_16_8.A a_3875_5396# 0.02292f
C571 sg13cmos5l_and2_2_6.B a_7629_8028# 0.32979f
C572 a_3668_3108# VPWR 2.21642f
C573 a_6129_9192# VPWR 0.01071f
C574 sg13cmos5l_buf_16_15.A a_6161_12574# 0.09713f
C575 a_4462_5410# a_3668_4620# 0.02278f
C576 sg13cmos5l_buf_16_34.X a_3668_9156# 0.12189f
C577 sg13cmos5l_buf_16_1.X sg13cmos5l_buf_16_4.A 0.25221f
C578 sg13cmos5l_xor2_1_4.X a_13745_8484# 0.27973f
C579 a_13288_13098# VPWR 0.15298f
C580 a_11924_13728# VPWR 0.25048f
C581 sg13cmos5l_buf_1_23.A sg13cmos5l_buf_16_25.A 0.10518f
C582 sg13cmos5l_and2_2_3.B sg13cmos5l_buf_16_22.X 0.13461f
C583 sg13cmos5l_and2_2_1.B a_2728_14610# 0.02116f
C584 a_3680_5538# VPWR 0.06997f
C585 sg13cmos5l_buf_16_35.A a_9788_8728# 0.01007f
C586 sg13cmos5l_and2_2_5.B sg13cmos5l_buf_16_6.X 0.30118f
C587 a_8538_2578# sg13cmos5l_buf_1_2.A 0.25619f
C588 a_3694_8434# sg13cmos5l_buf_16_34.A 1.38759f
C589 sg13cmos5l_and2_2_6.B sg13cmos5l_buf_16_35.A 0.09173f
C590 sg13cmos5l_buf_1_1.A out_xor[1] 0.02868f
C591 sg13cmos5l_buf_16_34.A enable 0.19787f
C592 a_11656_13814# a_10292_12934# 0.0111f
C593 a_5518_6922# VPWR 2.20951f
C594 sg13cmos5l_buf_16_37.X a_7796_12934# 1.35646f
C595 a_9617_8484# VPWR 0.25689f
C596 sg13cmos5l_buf_1_1.A VPWR 0.63635f
C597 sg13cmos5l_xor2_1_4.X VPWR 0.31551f
C598 sg13cmos5l_and2_2_0.X a_3668_4620# 0.06562f
C599 sg13cmos5l_buf_16_34.X a_3488_10790# 0.03947f
C600 a_14720_7050# VPWR 0.06713f
C601 sg13cmos5l_buf_1_23.A a_13664_7766# 0.06371f
C602 a_15016_2514# VPWR 0.18909f
C603 a_5518_6922# sg13cmos5l_buf_16_28.A 0.04023f
C604 a_3668_3108# a_3488_3230# 0.0364f
C605 sg13cmos5l_buf_16_34.X sg13cmos5l_buf_16_34.A 0.22378f
C606 sg13cmos5l_buf_16_15.X a_3488_14610# 0.03891f
C607 sg13cmos5l_and2_2_6.B sg13cmos5l_and2_2_6.A 1.39849f
C608 a_5108_838# a_4840_1002# 0.03513f
C609 sg13cmos5l_xor2_1_0.B a_3694_3898# 0.09815f
C610 a_14824_10704# out_xor[5] 0.29193f
C611 sg13cmos5l_xor2_1_6.X a_11656_13814# 0.02781f
C612 sg13cmos5l_buf_16_1.X a_10318_5410# 1.308f
C613 sg13cmos5l_buf_1_17.X sg13cmos5l_buf_1_17.A 0.61222f
C614 sg13cmos5l_buf_16_28.X VPWR 3.31459f
C615 a_3304_14610# VPWR 0.12842f
C616 a_4168_10074# a_3668_9156# 0.01121f
C617 sg13cmos5l_buf_16_6.X sg13cmos5l_buf_16_4.A 0.01449f
C618 sg13cmos5l_buf_1_2.X a_14824_1632# 0.32525f
C619 sg13cmos5l_and2_2_0.B a_4436_9910# 0.01317f
C620 a_15016_12302# out_xor[6] 0.01785f
C621 sg13cmos5l_buf_16_1.X sg13cmos5l_buf_1_6.A 0.13291f
C622 sg13cmos5l_and2_2_0.B sg13cmos5l_buf_16_33.A 0.09218f
C623 a_12040_12302# VPWR 0.1589f
C624 a_3694_3898# VPWR 2.18239f
C625 sg13cmos5l_buf_16_7.X sg13cmos5l_buf_16_10.A 0.34277f
C626 sg13cmos5l_and2_2_5.B sg13cmos5l_buf_1_17.A 0.0694f
C627 sg13cmos5l_buf_1_4.A VPWR 0.64538f
C628 a_6164_2350# VPWR 2.3734f
C629 sg13cmos5l_buf_1_17.A a_12232_12216# 0.34673f
C630 sg13cmos5l_buf_16_22.X a_13768_9192# 0.03276f
C631 sg13cmos5l_buf_16_24.A a_6836_9156# 0.07067f
C632 a_3875_5396# a_3668_4620# 0.01996f
C633 a_9617_8484# a_9788_8728# 0.41432f
C634 a_10112_13098# VPWR 0.08937f
C635 sg13cmos5l_and2_2_0.B sg13cmos5l_buf_16_31.X 0.03244f
C636 sg13cmos5l_buf_16_4.X a_9262_7680# 0.59824f
C637 sg13cmos5l_buf_1_5.A a_6161_9550# 0.03072f
C638 a_8872_7766# VPWR 0.14117f
C639 a_3020_14442# glitch_en[1] 0.3294f
C640 sg13cmos5l_buf_16_20.A a_6094_10704# 0.07462f
C641 sg13cmos5l_buf_1_5.A sg13cmos5l_buf_16_38.A 0.06922f
C642 a_4892_6168# VPWR 0.25016f
C643 sg13cmos5l_buf_16_1.X a_9524_6886# 0.04593f
C644 a_6161_12574# VPWR 0.28205f
C645 a_3694_7680# VPWR 2.20181f
C646 sg13cmos5l_buf_16_7.A a_3694_2386# 0.60365f
C647 sg13cmos5l_buf_1_23.A sg13cmos5l_buf_16_2.A 0.56518f
C648 a_6836_9156# a_6766_8434# 0.11005f
C649 a_2147_13692# a_1864_13814# 0.02801f
C650 a_14824_5444# VPWR 0.3443f
C651 sg13cmos5l_buf_16_6.X sg13cmos5l_buf_1_6.A 0.20265f
C652 sg13cmos5l_buf_1_15.X a_13745_11508# 0.0932f
C653 a_8948_13692# sg13cmos5l_buf_16_37.A 1.36525f
C654 sg13cmos5l_buf_16_2.A a_9262_7680# 1.31583f
C655 sg13cmos5l_buf_16_27.X sg13cmos5l_buf_1_17.A 0.01984f
C656 sg13cmos5l_and2_2_0.B glitch_en[1] 0.05412f
C657 a_14824_1632# out_xor[0] 0.2906f
C658 a_14824_14516# VPWR 0.25132f
C659 sg13cmos5l_buf_16_10.A a_3668_3108# 0.58078f
C660 sg13cmos5l_buf_16_24.X sg13cmos5l_buf_16_19.A 0.15593f
C661 sg13cmos5l_buf_16_22.X sg13cmos5l_buf_1_23.A 0.36982f
C662 sg13cmos5l_and2_2_6.A a_6161_9550# 0.41301f
C663 a_10292_12934# VPWR 2.43815f
C664 sg13cmos5l_buf_1_23.A sg13cmos5l_xor2_1_5.X 0.28998f
C665 sg13cmos5l_and2_2_3.X a_13916_11752# 0.0411f
C666 sg13cmos5l_buf_16_15.A sg13cmos5l_buf_16_20.A 0.0248f
C667 sg13cmos5l_buf_1_5.X VPWR 0.49496f
C668 sg13cmos5l_buf_16_37.X sg13cmos5l_buf_16_37.A 0.05825f
C669 a_8948_13692# sg13cmos5l_buf_16_27.X 0.01919f
C670 sg13cmos5l_buf_1_6.A a_5320_6254# 0.03264f
C671 sg13cmos5l_buf_16_31.X sg13cmos5l_buf_16_11.A 0.02473f
C672 a_6094_10704# VPWR 2.28634f
C673 a_14720_14610# glitch_en[6] 0.0593f
C674 a_10318_8434# a_11565_8028# 0.01862f
C675 sg13cmos5l_buf_16_2.A sg13cmos5l_buf_16_4.X 0.15012f
C676 a_3488_8562# VPWR 0.0906f
C677 sg13cmos5l_xor2_1_6.X VPWR 0.37136f
C678 a_13768_5444# sg13cmos5l_buf_1_5.X 0.30346f
C679 sg13cmos5l_buf_16_6.X a_9524_6886# 0.02103f
C680 sg13cmos5l_buf_16_8.A a_3488_4026# 0.03984f
C681 sg13cmos5l_and2_2_0.B sg13cmos5l_and2_2_6.A 0.04362f
C682 sg13cmos5l_xor2_1_5.X a_14344_8468# 0.32083f
C683 a_3488_12302# VPWR 0.09436f
C684 a_14824_1632# VPWR 0.28396f
C685 sg13cmos5l_buf_1_14.X a_14344_8468# 0.2906f
C686 sg13cmos5l_buf_16_31.X a_2147_13692# 0.16214f
C687 sg13cmos5l_buf_16_31.X sg13cmos5l_buf_16_8.A 0.34261f
C688 sg13cmos5l_buf_1_5.A a_6332_9192# 0.01742f
C689 a_8110_6168# a_7220_5374# 0.01174f
C690 sg13cmos5l_buf_16_37.X sg13cmos5l_buf_16_27.X 0.01149f
C691 sg13cmos5l_buf_16_7.X sg13cmos5l_buf_16_5.X 0.11611f
C692 a_8948_13692# glitch_en[4] 0.01359f
C693 sg13cmos5l_and2_2_4.B glitch_en[6] 0.07879f
C694 sg13cmos5l_buf_16_20.A sg13cmos5l_buf_16_14.A 0.05647f
C695 sg13cmos5l_buf_1_5.A sg13cmos5l_buf_16_11.A 0.02504f
C696 a_11656_13814# VPWR 0.14036f
C697 a_6548_13692# VPWR 2.33177f
C698 a_7220_5374# VPWR 2.28488f
C699 sg13cmos5l_buf_16_11.A sg13cmos5l_buf_16_7.X 0.16579f
C700 a_3668_12180# a_3694_10704# 0.01476f
C701 sg13cmos5l_buf_16_15.A VPWR 4.69813f
C702 sg13cmos5l_buf_1_2.X VPWR 1.66681f
C703 sg13cmos5l_and2_2_5.B sg13cmos5l_buf_1_23.A 0.03442f
C704 a_3694_8434# enable 0.01901f
C705 a_7336_7766# a_5518_6922# 0.01179f
C706 a_13745_11508# VPWR 0.26202f
C707 sg13cmos5l_buf_1_5.A sg13cmos5l_buf_16_1.X 0.11639f
C708 sg13cmos5l_buf_16_28.A a_7220_5374# 1.3501f
C709 a_13768_3932# VPWR 0.32923f
C710 a_3694_3898# sg13cmos5l_buf_16_10.A 1.35709f
C711 a_14824_10704# sg13cmos5l_buf_1_11.X 0.32342f
C712 a_14824_6956# VPWR 0.28083f
C713 sg13cmos5l_buf_16_34.X a_3694_10704# 0.60416f
C714 sg13cmos5l_buf_1_23.A a_13768_7680# 0.31647f
C715 a_8990_2704# VPWR 0.01392f
C716 sg13cmos5l_buf_16_22.X sg13cmos5l_buf_16_2.A 0.56045f
C717 a_6836_9156# sg13cmos5l_buf_16_25.A 1.33898f
C718 sg13cmos5l_buf_16_34.X a_3694_8434# 0.04538f
C719 sg13cmos5l_and2_2_6.B a_6094_10704# 0.03779f
C720 a_3020_14442# a_3304_14610# 0.01225f
C721 sg13cmos5l_and2_2_6.A a_6332_9192# 0.01857f
C722 sg13cmos5l_xor2_1_5.X sg13cmos5l_buf_16_2.A 0.08672f
C723 sg13cmos5l_buf_16_34.X enable 0.09967f
C724 sg13cmos5l_buf_16_39.A a_8564_2680# 0.01039f
C725 a_6164_2350# a_5984_2514# 0.0364f
C726 a_3694_2386# sg13cmos5l_buf_16_30.A 0.01901f
C727 a_6094_4656# a_6094_3898# 0.16971f
C728 sg13cmos5l_buf_1_15.X VPWR 0.62456f
C729 a_4462_5410# enable 0.03748f
C730 sg13cmos5l_buf_1_15.X a_13581_9988# 0.02518f
C731 a_13667_12956# sg13cmos5l_and2_2_3.X 0.12024f
C732 sg13cmos5l_buf_16_14.A VPWR 3.59454f
C733 a_4436_9910# a_3668_9156# 0.08245f
C734 sg13cmos5l_buf_16_6.X a_11565_8028# 0.11943f
C735 sg13cmos5l_buf_16_2.A a_10112_4026# 0.03947f
C736 sg13cmos5l_and2_2_0.B sg13cmos5l_buf_16_28.X 0.02161f
C737 sg13cmos5l_buf_16_22.X sg13cmos5l_xor2_1_5.X 1.95837f
C738 sg13cmos5l_buf_1_22.X a_14344_11492# 0.2906f
C739 a_6836_9156# sg13cmos5l_buf_1_23.A 0.05136f
C740 sg13cmos5l_buf_1_6.A a_13664_4026# 0.0605f
C741 a_6129_12216# VPWR 0.01187f
C742 sg13cmos5l_buf_16_39.A sg13cmos5l_buf_1_2.A 0.18425f
C743 sg13cmos5l_buf_16_8.A a_4721_6526# 0.08926f
C744 sg13cmos5l_and2_2_6.B a_6548_13692# 0.06386f
C745 a_9262_7680# sg13cmos5l_buf_16_4.A 0.02662f
C746 a_10112_4742# VPWR 0.11914f
C747 a_14824_3144# out_xor[1] 0.29491f
C748 a_13288_13098# a_13472_13098# 0.11523f
C749 sg13cmos5l_buf_1_5.A sg13cmos5l_buf_16_6.X 0.11541f
C750 sg13cmos5l_buf_16_20.A VPWR 3.46951f
C751 sg13cmos5l_and2_2_4.B sg13cmos5l_and2_2_3.X 0.11636f
C752 sg13cmos5l_and2_2_2.B sg13cmos5l_buf_16_24.X 0.48672f
C753 a_13480_7766# VPWR 0.1444f
C754 a_14824_3144# VPWR 0.35802f
C755 a_5992_14516# VPWR 0.32755f
C756 a_6094_10704# a_6862_9946# 0.06893f
C757 a_4052_12934# sg13cmos5l_buf_16_15.A 1.35289f
C758 a_8104_1632# sg13cmos5l_buf_1_2.X 0.29665f
C759 a_13768_9192# a_13576_9278# 0.01225f
C760 sg13cmos5l_and2_2_3.B sg13cmos5l_buf_1_11.X 0.09285f
C761 VPWR out_xor[0] 0.24411f
C762 sg13cmos5l_xor2_1_0.B VPWR 4.55083f
C763 sg13cmos5l_buf_16_8.A a_3668_3108# 0.06722f
C764 a_13288_8562# a_13472_8562# 0.11523f
C765 sg13cmos5l_buf_1_17.X a_11898_13691# 0.09901f
C766 sg13cmos5l_buf_1_5.A sg13cmos5l_buf_16_24.A 0.05088f
C767 sg13cmos5l_and2_2_5.B sg13cmos5l_buf_16_2.A 0.08626f
C768 sg13cmos5l_buf_16_35.A sg13cmos5l_buf_16_6.X 0.43237f
C769 sg13cmos5l_buf_16_2.X VPWR 3.63173f
C770 sg13cmos5l_buf_16_37.A a_7796_12934# 0.60505f
C771 sg13cmos5l_and2_2_0.X a_4462_5410# 0.58554f
C772 sg13cmos5l_and2_2_3.B sg13cmos5l_and2_2_3.X 1.72467f
C773 a_5320_6254# a_5504_6254# 0.11523f
C774 sg13cmos5l_buf_16_33.A sg13cmos5l_buf_16_24.X 0.02362f
C775 a_13745_8484# VPWR 0.25341f
C776 sg13cmos5l_and2_2_6.X VPWR 1.03785f
C777 sg13cmos5l_buf_16_2.A a_13768_7680# 0.0137f
C778 a_8110_6168# VPWR 2.27374f
C779 sg13cmos5l_buf_16_5.A sg13cmos5l_buf_1_2.X 0.01003f
C780 sg13cmos5l_buf_16_34.X a_4168_10074# 0.01072f
C781 a_6094_3144# a_6164_2350# 0.11005f
C782 a_9617_8484# sg13cmos5l_buf_16_1.X 0.03865f
C783 sg13cmos5l_and2_2_5.B sg13cmos5l_buf_16_22.X 0.12068f
C784 sg13cmos5l_buf_16_24.X a_5204_11422# 0.09942f
C785 a_3668_4620# sg13cmos5l_buf_16_7.X 0.07698f
C786 VPWR out_xor[1] 0.16973f
C787 sg13cmos5l_and2_2_5.B sg13cmos5l_xor2_1_5.X 0.03693f
C788 sg13cmos5l_and2_2_0.B a_3694_7680# 0.10296f
C789 a_13581_9988# VPWR 0.58194f
C790 sg13cmos5l_buf_1_14.X out_xor[4] 0.05788f
C791 sg13cmos5l_buf_1_5.A a_6766_8434# 0.01722f
C792 sg13cmos5l_buf_1_2.A a_8000_1718# 0.06036f
C793 a_6766_8434# a_7629_8028# 0.0173f
C794 sg13cmos5l_buf_16_24.X a_6765_12564# 0.16526f
C795 sg13cmos5l_buf_16_2.A a_10292_4620# 0.09854f
C796 sg13cmos5l_buf_16_28.X a_5224_7050# 0.04023f
C797 a_3668_9156# a_3488_9278# 0.0364f
C798 a_1672_14516# a_1480_14610# 0.01225f
C799 sg13cmos5l_buf_16_2.A sg13cmos5l_buf_16_4.A 0.06408f
C800 sg13cmos5l_buf_16_28.A VPWR 3.44031f
C801 sg13cmos5l_buf_16_5.X a_6164_2350# 0.06996f
C802 sg13cmos5l_buf_1_23.A a_13576_9278# 0.01191f
C803 a_3694_14482# a_4174_13728# 0.11122f
C804 a_13768_5444# VPWR 0.31796f
C805 sg13cmos5l_buf_16_11.A a_3694_3898# 0.06085f
C806 sg13cmos5l_buf_16_2.A a_13916_8728# 0.01007f
C807 sg13cmos5l_buf_1_2.A a_8564_2680# 0.11841f
C808 sg13cmos5l_and2_2_5.B sg13cmos5l_buf_1_17.X 0.03633f
C809 a_6766_8434# sg13cmos5l_buf_16_35.A 1.32496f
C810 sg13cmos5l_buf_16_15.X a_3668_12180# 1.29121f
C811 a_4721_6526# a_5320_6254# 0.03572f
C812 sg13cmos5l_buf_1_17.X a_12232_12216# 0.28827f
C813 a_1672_14516# glitch_en[0] 0.32815f
C814 a_3875_5396# a_4462_5410# 0.01061f
C815 sg13cmos5l_buf_16_4.X sg13cmos5l_buf_1_6.A 0.02903f
C816 sg13cmos5l_buf_16_24.X sg13cmos5l_buf_1_5.A 1.15165f
C817 a_13576_14516# VPWR 0.38177f
C818 a_3488_3230# VPWR 0.09182f
C819 sg13cmos5l_buf_1_11.X a_13768_9192# 0.28895f
C820 sg13cmos5l_and2_2_6.A a_3668_9156# 0.03335f
C821 sg13cmos5l_buf_16_6.X a_5518_6922# 1.29726f
C822 sg13cmos5l_buf_16_8.A a_3694_3898# 0.59597f
C823 sg13cmos5l_buf_16_6.X a_9617_8484# 0.40244f
C824 sg13cmos5l_buf_16_22.X a_13916_8728# 0.01748f
C825 a_8494_3144# sg13cmos5l_buf_16_39.A 1.31212f
C826 sg13cmos5l_and2_2_3.X sg13cmos5l_xor2_1_7.X 0.25384f
C827 sg13cmos5l_buf_16_13.A a_3488_8562# 0.03984f
C828 sg13cmos5l_and2_2_6.B sg13cmos5l_and2_2_6.X 0.52752f
C829 sg13cmos5l_and2_2_6.A a_6766_8434# 0.08192f
C830 a_3304_14610# a_3488_14610# 0.11523f
C831 a_6164_2350# a_5710_1632# 0.1456f
C832 sg13cmos5l_buf_16_27.X a_11898_13691# 0.39734f
C833 a_5684_6132# enable 0.03759f
C834 sg13cmos5l_buf_16_2.A a_10318_5410# 0.07019f
C835 a_9262_7680# a_9524_6886# 0.11493f
C836 sg13cmos5l_buf_16_2.X a_10318_3898# 1.35325f
C837 a_15104_11586# VPWR 0.10628f
C838 a_3875_5396# sg13cmos5l_and2_2_0.X 0.24451f
C839 sg13cmos5l_buf_16_38.A a_7220_5374# 0.60329f
C840 a_9788_8728# VPWR 0.2502f
C841 a_14824_9192# VPWR 0.35601f
C842 sg13cmos5l_and2_2_6.B VPWR 1.30461f
C843 sg13cmos5l_buf_16_2.A a_8494_3144# 0.04102f
C844 a_4052_12934# VPWR 2.25691f
C845 a_8104_1632# VPWR 0.29835f
C846 a_9160_7050# a_8110_6168# 0.01121f
C847 a_3694_7680# a_5224_7050# 0.0111f
C848 sg13cmos5l_buf_16_2.A sg13cmos5l_buf_1_6.A 0.11062f
C849 sg13cmos5l_xor2_1_0.B sg13cmos5l_buf_16_0.A 0.07085f
C850 a_5684_6132# a_4462_5410# 0.07914f
C851 sg13cmos5l_buf_16_27.X sg13cmos5l_buf_1_17.X 0.29224f
C852 a_4174_13728# sg13cmos5l_buf_16_18.A 1.34828f
C853 sg13cmos5l_buf_16_8.A a_4892_6168# 0.0119f
C854 sg13cmos5l_buf_1_6.A enable 0.08823f
C855 a_8948_13692# sg13cmos5l_buf_16_23.X 0.60166f
C856 sg13cmos5l_and2_2_0.B sg13cmos5l_buf_16_15.A 0.16747f
C857 sg13cmos5l_buf_16_2.A sg13cmos5l_buf_16_3.X 0.63963f
C858 a_10318_3898# VPWR 2.3717f
C859 sg13cmos5l_buf_16_4.X a_9524_6886# 1.31676f
C860 a_9160_7050# VPWR 0.14626f
C861 sg13cmos5l_and2_2_1.X VPWR 0.89978f
C862 sg13cmos5l_buf_16_14.A a_6161_9550# 0.09488f
C863 a_6862_9946# sg13cmos5l_and2_2_6.X 0.06867f
C864 a_14536_1718# a_14720_1718# 0.11523f
C865 sg13cmos5l_and2_2_5.B sg13cmos5l_buf_16_4.A 0.05274f
C866 sg13cmos5l_buf_16_5.A VPWR 3.52829f
C867 sg13cmos5l_and2_2_1.B sg13cmos5l_buf_16_31.X 0.34018f
C868 sg13cmos5l_xor2_1_0.B sg13cmos5l_buf_16_10.A 0.07973f
C869 sg13cmos5l_buf_1_5.A sg13cmos5l_buf_16_25.A 0.17975f
C870 sg13cmos5l_buf_1_6.A out_xor[2] 0.01522f
C871 sg13cmos5l_buf_16_0.A VPWR 3.42302f
C872 a_6862_9946# VPWR 2.22069f
C873 a_14444_14442# glitch_en[6] 0.3343f
C874 sg13cmos5l_buf_1_5.A a_6332_12216# 0.13668f
C875 sg13cmos5l_buf_16_22.X a_13576_9278# 0.029f
C876 sg13cmos5l_and2_2_0.B sg13cmos5l_buf_16_14.A 0.05999f
C877 sg13cmos5l_buf_16_15.X a_3694_14482# 0.58973f
C878 sg13cmos5l_buf_16_14.A sg13cmos5l_buf_16_13.A 0.04248f
C879 sg13cmos5l_buf_16_2.A a_9524_6886# 0.08504f
C880 a_3668_4620# a_3694_3898# 0.10636f
C881 a_8872_7766# a_9056_7766# 0.11523f
C882 a_4840_11586# VPWR 0.14257f
C883 sg13cmos5l_buf_1_5.A sg13cmos5l_buf_1_23.A 0.20092f
C884 sg13cmos5l_buf_16_27.X sg13cmos5l_buf_16_37.A 0.01837f
C885 a_13745_11508# a_13916_11752# 0.41432f
C886 sg13cmos5l_buf_16_7.X a_3694_2386# 1.29387f
C887 sg13cmos5l_buf_16_10.A VPWR 3.29346f
C888 sg13cmos5l_and2_2_5.B glitch_en[4] 0.01102f
C889 sg13cmos5l_buf_1_11.X a_14252_9906# 0.01058f
C890 a_3496_5538# a_3680_5538# 0.11523f
C891 a_3694_10704# a_4436_9910# 0.11802f
C892 a_5984_2514# VPWR 0.08893f
C893 sg13cmos5l_buf_1_17.A a_12040_12302# 0.0752f
C894 sg13cmos5l_and2_2_6.A sg13cmos5l_buf_16_25.A 0.17432f
C895 a_15104_6254# VPWR 0.07861f
C896 sg13cmos5l_buf_16_33.A a_3694_10704# 0.0635f
C897 sg13cmos5l_and2_2_3.X a_14252_9906# 0.32803f
C898 sg13cmos5l_buf_1_23.A sg13cmos5l_buf_16_35.A 0.05149f
C899 sg13cmos5l_and2_2_2.B a_4174_13728# 0.02449f
C900 a_3488_4742# VPWR 0.09077f
C901 sg13cmos5l_and2_2_0.B sg13cmos5l_xor2_1_0.B 0.11158f
C902 sg13cmos5l_buf_16_33.A a_3668_12180# 0.06578f
C903 sg13cmos5l_and2_2_1.X a_4052_12934# 0.05773f
C904 a_8110_6168# sg13cmos5l_buf_16_38.A 1.37076f
C905 a_5204_11422# a_3694_10704# 0.0753f
C906 sg13cmos5l_buf_1_15.X a_13916_11752# 0.0104f
C907 a_3020_14442# VPWR 0.2983f
C908 a_6161_9550# VPWR 0.24738f
C909 sg13cmos5l_buf_16_5.A a_8104_1632# 0.01756f
C910 sg13cmos5l_buf_16_34.X a_4436_9910# 0.04037f
C911 sg13cmos5l_buf_16_35.A a_9262_7680# 0.01786f
C912 a_13713_8752# VPWR 0.01071f
C913 a_13768_9192# sg13cmos5l_xor2_1_4.X 0.3343f
C914 a_9524_6886# a_9344_7050# 0.0364f
C915 sg13cmos5l_buf_16_14.A a_6332_9192# 0.01047f
C916 a_10318_5410# a_10292_4620# 0.11845f
C917 sg13cmos5l_and2_2_6.B a_6862_9946# 0.06015f
C918 sg13cmos5l_and2_2_6.A sg13cmos5l_buf_1_23.A 1.54168f
C919 sg13cmos5l_buf_16_38.A VPWR 3.58741f
C920 a_7336_7766# VPWR 0.13993f
C921 sg13cmos5l_buf_16_7.A a_3488_2514# 0.03984f
C922 a_14536_7050# a_14720_7050# 0.11523f
C923 sg13cmos5l_xor2_1_6.X a_14720_14610# 0.06165f
C924 sg13cmos5l_buf_16_33.A a_4174_13728# 0.04993f
C925 sg13cmos5l_xor2_1_0.B a_6094_3144# 1.38279f
C926 sg13cmos5l_buf_16_31.X enable 0.21341f
C927 sg13cmos5l_buf_16_28.A sg13cmos5l_buf_16_38.A 0.02729f
C928 sg13cmos5l_buf_16_18.A sg13cmos5l_buf_16_27.X 0.02887f
C929 sg13cmos5l_buf_16_13.A VPWR 3.42331f
C930 sg13cmos5l_and2_2_0.B VPWR 1.81081f
C931 sg13cmos5l_buf_16_27.X glitch_en[4] 0.16933f
C932 a_6094_4656# enable 0.07554f
C933 sg13cmos5l_buf_16_2.A a_11565_8028# 0.05627f
C934 sg13cmos5l_buf_1_11.X sg13cmos5l_buf_16_22.X 0.09605f
C935 sg13cmos5l_buf_16_35.A sg13cmos5l_buf_16_4.X 0.08106f
C936 a_6094_10704# sg13cmos5l_buf_16_24.A 1.34755f
C937 sg13cmos5l_buf_1_5.A a_13664_5538# 0.0605f
C938 a_3668_3108# a_3694_2386# 0.10636f
C939 a_3968_13814# VPWR 0.09124f
C940 sg13cmos5l_buf_16_4.A sg13cmos5l_buf_1_6.A 0.01133f
C941 sg13cmos5l_buf_16_3.X a_10292_4620# 1.35625f
C942 sg13cmos5l_buf_16_2.A a_13472_8562# 0.03915f
C943 sg13cmos5l_xor2_1_6.X sg13cmos5l_and2_2_4.B 0.07112f
C944 sg13cmos5l_buf_16_31.X a_4462_5410# 0.03294f
C945 sg13cmos5l_xor2_1_0.B sg13cmos5l_buf_16_5.X 0.06102f
C946 sg13cmos5l_buf_1_5.A sg13cmos5l_buf_16_2.A 0.03559f
C947 sg13cmos5l_buf_16_34.A a_3694_7680# 0.59333f
C948 sg13cmos5l_buf_1_5.A enable 0.38651f
C949 a_14824_13004# out_xor[6] 0.28827f
C950 sg13cmos5l_buf_16_7.X sg13cmos5l_buf_16_7.A 0.01656f
C951 a_6094_3144# VPWR 2.21415f
C952 sg13cmos5l_buf_16_24.X a_6161_12574# 0.4406f
C953 a_4436_9910# a_4168_10074# 0.03513f
C954 a_10292_12934# sg13cmos5l_buf_1_17.A 0.60142f
C955 sg13cmos5l_buf_16_7.X enable 0.30626f
C956 sg13cmos5l_buf_1_4.A a_14536_7050# 0.01352f
C957 out_xor[0] VGND 0.71386f
C958 out_xor[1] VGND 0.93353f
C959 out_xor[2] VGND 0.96802f
C960 out_xor[3] VGND 0.86148f
C961 out_xor[4] VGND 0.73784f
C962 out_xor[5] VGND 0.90254f
C963 out_xor[6] VGND 0.86015f
C964 out_xor[7] VGND 2.27746f
C965 VPWR VGND 0.3655p
C966 a_4840_1002# VGND 0.13795f ; **FLOATING
C967 a_14720_1718# VGND 0.03807f ; **FLOATING
C968 a_14536_1718# VGND 0.14395f ; **FLOATING
C969 a_14824_1632# VGND 0.84946f
C970 a_8000_1718# VGND 0.04237f ; **FLOATING
C971 a_8104_1632# VGND 1.83087f
C972 a_5504_1718# VGND 0.08397f ; **FLOATING
C973 a_15016_2514# VGND 0.13827f ; **FLOATING
C974 a_8694_2398# VGND 5.25366f
C975 a_8564_2680# VGND 0.13885f
C976 sg13cmos5l_buf_1_2.A VGND 0.11108f
C977 a_5984_2514# VGND 0.04276f ; **FLOATING
C978 a_3488_2514# VGND 0.09056f ; **FLOATING
C979 a_3488_3230# VGND 0.0912f ; **FLOATING
C980 sg13cmos5l_buf_1_1.A VGND 0.74158f
C981 a_13664_4026# VGND 0.06838f ; **FLOATING
C982 a_10112_4026# VGND 0.06173f ; **FLOATING
C983 a_3488_4026# VGND 0.09308f ; **FLOATING
C984 a_15016_4742# VGND 0.14702f ; **FLOATING
C985 a_10112_4742# VGND 0.05947f ; **FLOATING
C986 a_3488_4742# VGND 0.09072f ; **FLOATING
C987 sg13cmos5l_buf_1_5.X VGND 1.05782f
C988 a_13664_5538# VGND 0.06047f ; **FLOATING
C989 a_4105_5452# VGND 1.25593f
C990 a_3680_5538# VGND 0.04608f ; **FLOATING
C991 a_3496_5538# VGND 0.14382f ; **FLOATING
C992 a_15104_6254# VGND 0.12253f ; **FLOATING
C993 a_5504_6254# VGND 0.03689f ; **FLOATING
C994 a_5320_6254# VGND 0.07545f ; **FLOATING
C995 a_4892_6168# VGND 0.1069f
C996 a_8110_6168# VGND 0.0144f
C997 sg13cmos5l_buf_1_6.A VGND 0.22617f
C998 a_14720_7050# VGND 0.03861f ; **FLOATING
C999 a_14536_7050# VGND 0.13546f ; **FLOATING
C1000 a_9344_7050# VGND 0.0377f ; **FLOATING
C1001 a_9160_7050# VGND 0.12043f ; **FLOATING
C1002 a_5224_7050# VGND 0.09794f ; **FLOATING
C1003 sg13cmos5l_buf_1_4.A VGND 0.98718f
C1004 a_13664_7766# VGND 0.04337f ; **FLOATING
C1005 a_13480_7766# VGND 0.13873f ; **FLOATING
C1006 a_13768_7680# VGND 0.09847f
C1007 a_11659_8028# VGND 0.14046f
C1008 a_9056_7766# VGND 0.03882f ; **FLOATING
C1009 a_8872_7766# VGND 0.137f ; **FLOATING
C1010 a_9262_7680# VGND 0.05178f
C1011 a_7723_8028# VGND 0.07363f
C1012 a_7520_7766# VGND 0.03776f ; **FLOATING
C1013 a_7336_7766# VGND 0.11922f ; **FLOATING
C1014 a_3488_7766# VGND 0.09061f ; **FLOATING
C1015 a_15104_8562# VGND 0.09691f ; **FLOATING
C1016 a_14010_8446# VGND 0.01114f
C1017 a_13472_8562# VGND 0.04468f ; **FLOATING
C1018 a_13288_8562# VGND 0.16751f ; **FLOATING
C1019 a_9882_8446# VGND 0.01813f
C1020 a_14344_8468# VGND 0.40391f
C1021 sg13cmos5l_xor2_1_5.X VGND 0.01045f
C1022 a_9788_8728# VGND 2.87425f
C1023 a_3488_8562# VGND 0.08972f ; **FLOATING
C1024 a_14824_9192# VGND 0.29022f
C1025 a_13576_9278# VGND 0.09753f ; **FLOATING
C1026 a_6332_9192# VGND 0.10802f
C1027 a_13768_9192# VGND 0.24246f
C1028 a_6426_9550# VGND 0.09755f
C1029 a_3488_9278# VGND 0.09036f ; **FLOATING
C1030 a_13675_9988# VGND 1.72002f
C1031 a_4168_10074# VGND 0.12664f ; **FLOATING
C1032 a_3488_10790# VGND 0.09068f ; **FLOATING
C1033 a_15104_11586# VGND 0.09598f ; **FLOATING
C1034 a_13713_11776# VGND 0.69434f
C1035 a_13745_11508# VGND 0.06437f
C1036 a_5024_11586# VGND 0.03798f ; **FLOATING
C1037 a_4840_11586# VGND 0.11962f ; **FLOATING
C1038 a_15016_12302# VGND 0.13521f ; **FLOATING
C1039 a_12040_12302# VGND 0.13405f ; **FLOATING
C1040 a_6332_12216# VGND 0.87713f
C1041 a_6129_12216# VGND 1.57687f
C1042 sg13cmos5l_buf_16_19.A VGND 0.08275f
C1043 a_6859_12564# VGND 0.80372f
C1044 a_6426_12574# VGND 1.93234f
C1045 a_3488_12302# VGND 0.0924f ; **FLOATING
C1046 a_13897_13012# VGND 1.40265f
C1047 a_14824_13004# VGND 0.44074f
C1048 sg13cmos5l_buf_1_22.X VGND 0.22284f
C1049 a_13472_13098# VGND 0.04905f ; **FLOATING
C1050 a_13288_13098# VGND 0.16012f ; **FLOATING
C1051 a_10112_13098# VGND 0.04277f ; **FLOATING
C1052 sg13cmos5l_buf_1_17.A VGND 0.46644f
C1053 a_3872_13098# VGND 0.05947f ; **FLOATING
C1054 a_15016_13814# VGND 0.15046f ; **FLOATING
C1055 a_11924_13728# VGND 0.51404f
C1056 a_12054_14086# VGND 4.27277f
C1057 a_11656_13814# VGND 0.09791f ; **FLOATING
C1058 a_3968_13814# VGND 0.09026f ; **FLOATING
C1059 a_2377_14076# VGND 3.80524f
C1060 a_1864_13814# VGND 0.13386f ; **FLOATING
C1061 a_14720_14610# VGND 0.0429f ; **FLOATING
C1062 sg13cmos5l_and2_2_6.B VGND 0.15036f
C1063 a_3488_14610# VGND 0.04249f ; **FLOATING
C1064 a_3304_14610# VGND 0.11243f ; **FLOATING
C1065 a_2728_14610# VGND 0.13045f ; **FLOATING
C1066 sg13cmos5l_buf_16_15.X VGND 0.03191f
C1067 sg13cmos5l_and2_2_0.B VGND 0.11187f
C1068 a_1480_14610# VGND 0.13449f ; **FLOATING
C1069 VGND.t5 VGND 0.13305f
C1070 VGND.t125 VGND 3.33921f
C1071 VGND.t122 VGND 0.27804f
C1072 VGND.t1339 VGND 9.17552f
C1073 VGND.t1349 VGND 0.70114f
C1074 VGND.t1354 VGND 0.42534f
C1075 VGND.t1359 VGND 0.63388f
C1076 VGND.t1364 VGND 3.60982f
C1077 VGND.t1366 VGND 3.60982f
C1078 VGND.t845 VGND 2.13336f
C1079 VGND.t1368 VGND 0.27168f
C1080 VGND.t1373 VGND 1.80431f
C1081 VGND.t1393 VGND 0.25268f
C1082 VGND.t86 VGND 3.54309f
C1083 VGND.t1224 VGND 9.37235f
C1084 VGND.t171 VGND 17.26045f
C1085 VGND.t801 VGND 0.01688f
C1086 VGND.t218 VGND 0.28278f
C1087 VGND.t1167 VGND 5.49541f
C1088 VGND.t532 VGND 5.64254f
C1089 VGND.t214 VGND 4.12375f
C1090 VGND.t231 VGND 0.0209f
C1091 VGND.t228 VGND 0.21412f
C1092 VGND.t35 VGND 11.41225f
C1093 VGND.t15 VGND 0.94371f
C1094 VGND.t50 VGND 0.7223f
C1095 VGND.t1107 VGND 0.1123f
C1096 VGND.t39 VGND 0.10564f
C1097 VGND.t1073 VGND 1.241f
C1098 VGND.t157 VGND 1.2448f
C1099 VGND.t66 VGND 4.63699f
C1100 VGND.t237 VGND 0.01545f
C1101 VGND.t676 VGND 1.40422f
C1102 VGND.t682 VGND 0.82686f
C1103 VGND.t620 VGND 0.06382f
C1104 VGND.t457 VGND 2.00778f
C1105 VGND.t206 VGND 0.03089f
C1106 VGND.t204 VGND 0.06965f
C1107 VGND.t924 VGND 0.61746f
C1108 VGND.t895 VGND 2.57414f
C1109 VGND.t202 VGND 0.77594f
C1110 VGND.t601 VGND 0.50984f
C1111 VGND.t1 VGND 0.45711f
C1112 VGND.t940 VGND 1.44098f
C1113 VGND.t139 VGND 3.08407f
C1114 VGND.t1018 VGND 1.70437f
C1115 VGND.t1010 VGND 7.19959f
C1116 VGND.t3 VGND 0.22284f
C1117 VGND.t1286 VGND 5.59078f
C1118 VGND.t31 VGND 0.11108f
C1119 VGND.t25 VGND 0.06477f
C1120 VGND.t837 VGND 2.19668f
C1121 VGND.t1281 VGND 0.16249f
C1122 VGND.t194 VGND 0.2707f
C1123 VGND.t1418 VGND 0.64609f
C1124 VGND.t1423 VGND 0.41016f
C1125 VGND.t1420 VGND 0.64609f
C1126 VGND.t1375 VGND 1.257f
C1127 VGND.t1361 VGND 0.63388f
C1128 VPWR.t64 VGND 0.1726f
C1129 VPWR.t5 VGND 18.6749f
C1130 VPWR.n1 VGND 0.22471f
C1131 VPWR.t61 VGND 23.24434f
C1132 VPWR.n6 VGND 0.08249f
C1133 VPWR.n7 VGND 0.13305f
C1134 VPWR.n9 VGND 0.08249f
C1135 VPWR.n10 VGND 0.13298f
C1136 VPWR.n12 VGND 0.08249f
C1137 VPWR.n13 VGND 0.13342f
C1138 VPWR.n15 VGND 0.05976f
C1139 VPWR.n16 VGND 0.08865f
C1140 VPWR.n17 VGND 0.17497f
C1141 VPWR.n20 VGND 0.02831f
C1142 VPWR.n21 VGND 0.04836f
C1143 VPWR.n22 VGND 0.16083f
C1144 VPWR.n24 VGND 0.15365f
C1145 VPWR.n26 VGND 1.10542f
C1146 VPWR.n27 VGND 0.0264f
C1147 VPWR.n28 VGND 0.08249f
C1148 VPWR.n29 VGND 0.1001f
C1149 VPWR.n31 VGND 0.0249f
C1150 VPWR.n32 VGND 0.08249f
C1151 VPWR.n33 VGND 0.06375f
C1152 VPWR.n38 VGND 0.01698f
C1153 VPWR.n39 VGND 0.08863f
C1154 VPWR.n40 VGND 0.06725f
C1155 VPWR.n42 VGND 0.01533f
C1156 VPWR.n43 VGND 0.08865f
C1157 VPWR.n44 VGND 0.0523f
C1158 VPWR.n46 VGND 0.08863f
C1159 VPWR.n47 VGND 0.06917f
C1160 VPWR.n49 VGND 0.08865f
C1161 VPWR.n50 VGND 0.06723f
C1162 VPWR.n52 VGND 0.02028f
C1163 VPWR.n53 VGND 0.08865f
C1164 VPWR.n54 VGND 0.06723f
C1165 VPWR.t93 VGND 0.28685f
C1166 VPWR.n60 VGND 0.01451f
C1167 VPWR.n63 VGND 0.04888f
C1168 VPWR.n64 VGND 2.76948f
C1169 VPWR.n65 VGND 0.01329f
C1170 VPWR.t86 VGND 0.31024f
C1171 VPWR.t126 VGND 0.25268f
C1172 VPWR.n66 VGND 0.79226f
C1173 VPWR.t57 VGND 0.13584f
C1174 VPWR.t1060 VGND 1.05454f
C1175 VPWR.n67 VGND 0.02659f
C1176 VPWR.n68 VGND 1.32935f
C1177 VPWR.n69 VGND 0.01329f
C1178 VPWR.n70 VGND 0.51049f
C1179 VPWR.t120 VGND 0.52998f
C1180 VPWR.n71 VGND 0.19785f
C1181 VPWR.t116 VGND 0.64862f
C1182 VPWR.t117 VGND 0.52998f
C1183 VPWR.t217 VGND 0.56702f
C1184 VPWR.t329 VGND 0.02186f
C1185 VPWR.n73 VGND 0.02862f
C1186 VPWR.t1551 VGND 0.02389f
C1187 VPWR.n81 VGND 0.02575f
C1188 VPWR.t852 VGND 0.02389f
C1189 VPWR.t1579 VGND 0.02389f
C1190 VPWR.n89 VGND 0.0437f
C1191 VPWR.t850 VGND 0.02389f
C1192 VPWR.t565 VGND 0.02389f
C1193 VPWR.n91 VGND 0.0435f
C1194 VPWR.t848 VGND 0.02434f
C1195 VPWR.t563 VGND 0.02389f
C1196 VPWR.n93 VGND 0.04756f
C1197 VPWR.t846 VGND 0.02389f
C1198 VPWR.t561 VGND 2.34863f
C1199 VPWR.n95 VGND 0.04333f
C1200 VPWR.t845 VGND 0.02279f
C1201 VPWR.t560 VGND 0.02186f
C1202 VPWR.n97 VGND 0.05598f
C1203 VPWR.t367 VGND 0.01961f
C1204 VPWR.t1486 VGND 0.01961f
C1205 VPWR.n100 VGND 0.04735f
C1206 VPWR.t416 VGND 0.01961f
C1207 VPWR.t1478 VGND 0.01961f
C1208 VPWR.n104 VGND 0.05251f
C1209 VPWR.t415 VGND 0.0196f
C1210 VPWR.t1477 VGND 0.0196f
C1211 VPWR.n106 VGND 0.05336f
C1212 VPWR.t412 VGND 0.01961f
C1213 VPWR.t1474 VGND 0.01961f
C1214 VPWR.n108 VGND 0.05408f
C1215 VPWR.t413 VGND 0.02105f
C1216 VPWR.n109 VGND 0.08863f
C1217 VPWR.t1475 VGND 0.02105f
C1218 VPWR.n110 VGND 0.08865f
C1219 VPWR.n111 VGND 0.07513f
C1220 VPWR.t361 VGND 0.04912f
C1221 VPWR.n113 VGND 0.08863f
C1222 VPWR.t1479 VGND 0.42777f
C1223 VPWR.n114 VGND 0.08865f
C1224 VPWR.n115 VGND 0.07185f
C1225 VPWR.t362 VGND 0.04768f
C1226 VPWR.t1481 VGND 0.42632f
C1227 VPWR.n117 VGND 0.05336f
C1228 VPWR.t363 VGND 0.01961f
C1229 VPWR.t1482 VGND 0.01961f
C1230 VPWR.n119 VGND 0.05251f
C1231 VPWR.t364 VGND 0.02105f
C1232 VPWR.n120 VGND 0.08863f
C1233 VPWR.t1483 VGND 4.66496f
C1234 VPWR.n121 VGND 0.08865f
C1235 VPWR.n122 VGND 0.07185f
C1236 VPWR.n124 VGND 0.41875f
C1237 VPWR.t1463 VGND 0.07575f
C1238 VPWR.t1505 VGND 0.07575f
C1239 VPWR.n125 VGND 0.04797f
C1240 VPWR.t1468 VGND 0.01961f
C1241 VPWR.n128 VGND 0.03377f
C1242 VPWR.t1467 VGND 0.0196f
C1243 VPWR.t244 VGND 0.8101f
C1244 VPWR.n130 VGND 0.05336f
C1245 VPWR.t611 VGND 0.01961f
C1246 VPWR.t1502 VGND 0.01961f
C1247 VPWR.n133 VGND 0.05251f
C1248 VPWR.t610 VGND 0.1319f
C1249 VPWR.t1501 VGND 0.07575f
C1250 VPWR.n135 VGND 0.05336f
C1251 VPWR.t603 VGND 0.01961f
C1252 VPWR.t1494 VGND 0.01961f
C1253 VPWR.n137 VGND 0.05408f
C1254 VPWR.t604 VGND 0.13335f
C1255 VPWR.n139 VGND 0.08863f
C1256 VPWR.t1495 VGND 0.0772f
C1257 VPWR.n140 VGND 0.08865f
C1258 VPWR.n141 VGND 0.07513f
C1259 VPWR.t606 VGND 0.1319f
C1260 VPWR.t1497 VGND 0.07575f
C1261 VPWR.n143 VGND 0.05336f
C1262 VPWR.t607 VGND 0.01961f
C1263 VPWR.t1498 VGND 0.07576f
C1264 VPWR.n145 VGND 0.05251f
C1265 VPWR.t608 VGND 0.13335f
C1266 VPWR.n146 VGND 0.08863f
C1267 VPWR.t1499 VGND 0.13335f
C1268 VPWR.n147 VGND 0.08865f
C1269 VPWR.n148 VGND 0.07185f
C1270 VPWR.t612 VGND 0.0772f
C1271 VPWR.n150 VGND 0.08863f
C1272 VPWR.t1503 VGND 0.0772f
C1273 VPWR.n151 VGND 0.08865f
C1274 VPWR.n152 VGND 0.07185f
C1275 VPWR.t1464 VGND 0.01961f
C1276 VPWR.t1506 VGND 0.01961f
C1277 VPWR.n154 VGND 0.04735f
C1278 VPWR.t1465 VGND 0.02105f
C1279 VPWR.n155 VGND 0.08863f
C1280 VPWR.t243 VGND 0.81155f
C1281 VPWR.n156 VGND 0.08865f
C1282 VPWR.n157 VGND 0.07185f
C1283 VPWR.t1469 VGND 0.27372f
C1284 VPWR.n159 VGND 0.08863f
C1285 VPWR.t1268 VGND 0.0582f
C1286 VPWR.n160 VGND 0.07157f
C1287 VPWR.t1471 VGND 0.27228f
C1288 VPWR.t1269 VGND 0.08907f
C1289 VPWR.n162 VGND 0.02438f
C1290 VPWR.n163 VGND 0.02644f
C1291 VPWR.t1472 VGND 0.0196f
C1292 VPWR.t1266 VGND 0.01613f
C1293 VPWR.n164 VGND 0.01964f
C1294 VPWR.n165 VGND 0.02905f
C1295 VPWR.t882 VGND 1.32942f
C1296 VPWR.t153 VGND 0.39127f
C1297 VPWR.t719 VGND 0.02389f
C1298 VPWR.t717 VGND 0.02389f
C1299 VPWR.t151 VGND 0.02389f
C1300 VPWR.n167 VGND 0.02663f
C1301 VPWR.n168 VGND 0.02319f
C1302 VPWR.t149 VGND 0.02389f
C1303 VPWR.n170 VGND 0.02446f
C1304 VPWR.t792 VGND 0.02389f
C1305 VPWR.n180 VGND 0.02933f
C1306 VPWR.t791 VGND 0.02389f
C1307 VPWR.t682 VGND 0.02365f
C1308 VPWR.n182 VGND 0.01638f
C1309 VPWR.n183 VGND 0.02341f
C1310 VPWR.t1263 VGND 0.02389f
C1311 VPWR.n185 VGND 0.02903f
C1312 VPWR.t1261 VGND 0.07785f
C1313 VPWR.t683 VGND 0.0207f
C1314 VPWR.n187 VGND 0.02653f
C1315 VPWR.n188 VGND 0.02209f
C1316 VPWR.t1473 VGND 0.01883f
C1317 VPWR.n189 VGND 0.05313f
C1318 VPWR.t1260 VGND 0.02199f
C1319 VPWR.n190 VGND 0.05943f
C1320 VPWR.t794 VGND 0.02389f
C1321 VPWR.n191 VGND 0.03368f
C1322 VPWR.t577 VGND 0.02279f
C1323 VPWR.t796 VGND 0.02389f
C1324 VPWR.n193 VGND 0.02573f
C1325 VPWR.n194 VGND 0.02819f
C1326 VPWR.t578 VGND 0.02389f
C1327 VPWR.t798 VGND 0.02389f
C1328 VPWR.n196 VGND 0.02199f
C1329 VPWR.n197 VGND 0.02344f
C1330 VPWR.t580 VGND 0.02434f
C1331 VPWR.t800 VGND 0.02389f
C1332 VPWR.n199 VGND 0.0224f
C1333 VPWR.n200 VGND 0.02705f
C1334 VPWR.t582 VGND 0.02389f
C1335 VPWR.t802 VGND 0.02434f
C1336 VPWR.n202 VGND 0.02705f
C1337 VPWR.n203 VGND 0.0224f
C1338 VPWR.t584 VGND 0.02389f
C1339 VPWR.t804 VGND 0.02389f
C1340 VPWR.n205 VGND 0.02344f
C1341 VPWR.n206 VGND 0.02199f
C1342 VPWR.t586 VGND 0.88038f
C1343 VPWR.t806 VGND 0.02279f
C1344 VPWR.n208 VGND 0.02819f
C1345 VPWR.n209 VGND 0.02173f
C1346 VPWR.t195 VGND 3.56501f
C1347 VPWR.n210 VGND 0.0307f
C1348 VPWR.t196 VGND 3.56424f
C1349 VPWR.n212 VGND 0.04836f
C1350 VPWR.n213 VGND 0.02519f
C1351 VPWR.t588 VGND 0.02389f
C1352 VPWR.n214 VGND 0.02022f
C1353 VPWR.t706 VGND 0.02279f
C1354 VPWR.n216 VGND 0.02438f
C1355 VPWR.t590 VGND 0.02389f
C1356 VPWR.n217 VGND 0.02022f
C1357 VPWR.t707 VGND 0.02389f
C1358 VPWR.n219 VGND 0.02022f
C1359 VPWR.t592 VGND 0.24632f
C1360 VPWR.n220 VGND 0.02022f
C1361 VPWR.t709 VGND 0.02434f
C1362 VPWR.n222 VGND 0.02438f
C1363 VPWR.t1255 VGND 0.46874f
C1364 VPWR.n223 VGND 0.02022f
C1365 VPWR.t711 VGND 0.02389f
C1366 VPWR.n225 VGND 0.02022f
C1367 VPWR.t1257 VGND 0.02389f
C1368 VPWR.n226 VGND 0.02015f
C1369 VPWR.t713 VGND 0.02389f
C1370 VPWR.n228 VGND 0.02022f
C1371 VPWR.t1259 VGND 0.02186f
C1372 VPWR.n229 VGND 0.02445f
C1373 VPWR.t715 VGND 0.02389f
C1374 VPWR.n231 VGND 0.02022f
C1375 VPWR.t148 VGND 0.02186f
C1376 VPWR.n232 VGND 0.02445f
C1377 VPWR.n234 VGND 0.41875f
C1378 VPWR.t177 VGND 0.99212f
C1379 VPWR.n243 VGND 0.02991f
C1380 VPWR.t642 VGND 0.02389f
C1381 VPWR.t262 VGND 0.02389f
C1382 VPWR.n246 VGND 0.0437f
C1383 VPWR.t640 VGND 0.02389f
C1384 VPWR.t261 VGND 0.02389f
C1385 VPWR.n248 VGND 0.0435f
C1386 VPWR.t638 VGND 0.02434f
C1387 VPWR.t421 VGND 0.02389f
C1388 VPWR.n250 VGND 0.04756f
C1389 VPWR.t636 VGND 0.02389f
C1390 VPWR.t419 VGND 0.02389f
C1391 VPWR.n252 VGND 0.04333f
C1392 VPWR.t635 VGND 0.02279f
C1393 VPWR.t418 VGND 0.02186f
C1394 VPWR.n254 VGND 0.05598f
C1395 VPWR.t300 VGND 0.01961f
C1396 VPWR.t381 VGND 0.01961f
C1397 VPWR.n257 VGND 0.04735f
C1398 VPWR.t463 VGND 0.01961f
C1399 VPWR.t373 VGND 0.02307f
C1400 VPWR.n261 VGND 0.05251f
C1401 VPWR.t462 VGND 0.0196f
C1402 VPWR.t372 VGND 0.0196f
C1403 VPWR.n263 VGND 0.05336f
C1404 VPWR.t459 VGND 0.07576f
C1405 VPWR.t369 VGND 0.02316f
C1406 VPWR.n265 VGND 0.05408f
C1407 VPWR.t460 VGND 0.0772f
C1408 VPWR.n266 VGND 0.08863f
C1409 VPWR.t370 VGND 0.02461f
C1410 VPWR.n267 VGND 0.08865f
C1411 VPWR.n268 VGND 0.07513f
C1412 VPWR.t464 VGND 0.0772f
C1413 VPWR.n270 VGND 0.08863f
C1414 VPWR.t374 VGND 3.0102f
C1415 VPWR.n271 VGND 0.08865f
C1416 VPWR.n272 VGND 0.07185f
C1417 VPWR.t466 VGND 0.07575f
C1418 VPWR.t376 VGND 3.0053f
C1419 VPWR.n274 VGND 0.05336f
C1420 VPWR.t467 VGND 0.01961f
C1421 VPWR.t377 VGND 0.24999f
C1422 VPWR.n276 VGND 0.05251f
C1423 VPWR.t298 VGND 0.02105f
C1424 VPWR.n277 VGND 0.08863f
C1425 VPWR.t378 VGND 0.25143f
C1426 VPWR.n278 VGND 0.08865f
C1427 VPWR.n279 VGND 0.07185f
C1428 VPWR.n281 VGND 0.08475f
C1429 VPWR.t956 VGND 0.0196f
C1430 VPWR.t923 VGND 0.07575f
C1431 VPWR.n283 VGND 0.04797f
C1432 VPWR.t21 VGND 8.26179f
C1433 VPWR.t20 VGND 0.02807f
C1434 VPWR.t33 VGND 0.01961f
C1435 VPWR.t11 VGND 0.69568f
C1436 VPWR.t10 VGND 0.69712f
C1437 VPWR.n284 VGND 0.08249f
C1438 VPWR.t32 VGND 0.0196f
C1439 VPWR.n285 VGND 0.03201f
C1440 VPWR.n286 VGND 0.04094f
C1441 VPWR.t31 VGND 0.02105f
C1442 VPWR.t820 VGND 0.02395f
C1443 VPWR.t191 VGND 0.81027f
C1444 VPWR.t190 VGND 0.27681f
C1445 VPWR.t818 VGND 0.0558f
C1446 VPWR.n293 VGND 0.02491f
C1447 VPWR.n294 VGND 0.02792f
C1448 VPWR.t816 VGND 0.02434f
C1449 VPWR.t189 VGND 0.0196f
C1450 VPWR.n296 VGND 0.02662f
C1451 VPWR.n297 VGND 0.02885f
C1452 VPWR.t957 VGND 0.04768f
C1453 VPWR.t924 VGND 0.01961f
C1454 VPWR.n300 VGND 0.04735f
C1455 VPWR.t546 VGND 0.07576f
C1456 VPWR.t1021 VGND 0.07576f
C1457 VPWR.n304 VGND 0.05251f
C1458 VPWR.t545 VGND 0.07575f
C1459 VPWR.t1020 VGND 0.07575f
C1460 VPWR.n306 VGND 0.05336f
C1461 VPWR.t542 VGND 0.01961f
C1462 VPWR.t1017 VGND 0.07576f
C1463 VPWR.n308 VGND 0.05408f
C1464 VPWR.t543 VGND 0.0772f
C1465 VPWR.n309 VGND 0.08863f
C1466 VPWR.t1018 VGND 0.13335f
C1467 VPWR.n310 VGND 0.08865f
C1468 VPWR.n311 VGND 0.07513f
C1469 VPWR.t547 VGND 0.13335f
C1470 VPWR.n313 VGND 0.08863f
C1471 VPWR.t1022 VGND 0.0772f
C1472 VPWR.n314 VGND 0.08865f
C1473 VPWR.n315 VGND 0.07185f
C1474 VPWR.t549 VGND 0.07575f
C1475 VPWR.t1024 VGND 0.0196f
C1476 VPWR.n317 VGND 0.05336f
C1477 VPWR.t550 VGND 0.01961f
C1478 VPWR.t1025 VGND 0.01961f
C1479 VPWR.n319 VGND 0.05251f
C1480 VPWR.t551 VGND 0.02105f
C1481 VPWR.n320 VGND 0.08863f
C1482 VPWR.t922 VGND 0.0772f
C1483 VPWR.n321 VGND 0.08865f
C1484 VPWR.n322 VGND 0.07185f
C1485 VPWR.t958 VGND 0.04912f
C1486 VPWR.n324 VGND 0.08863f
C1487 VPWR.t925 VGND 0.04912f
C1488 VPWR.n325 VGND 0.08865f
C1489 VPWR.n326 VGND 0.07185f
C1490 VPWR.t977 VGND 0.0196f
C1491 VPWR.t927 VGND 0.04768f
C1492 VPWR.n328 VGND 0.05336f
C1493 VPWR.t186 VGND 0.34534f
C1494 VPWR.n329 VGND 0.02975f
C1495 VPWR.t814 VGND 1.00716f
C1496 VPWR.t187 VGND 0.34678f
C1497 VPWR.n331 VGND 0.08865f
C1498 VPWR.n332 VGND 0.06181f
C1499 VPWR.t813 VGND 0.02279f
C1500 VPWR.n333 VGND 0.02438f
C1501 VPWR.t822 VGND 0.02389f
C1502 VPWR.n335 VGND 0.02028f
C1503 VPWR.t193 VGND 0.55162f
C1504 VPWR.n337 VGND 0.02991f
C1505 VPWR.t824 VGND 0.02389f
C1506 VPWR.n339 VGND 0.0297f
C1507 VPWR.t826 VGND 0.02389f
C1508 VPWR.n340 VGND 0.02528f
C1509 VPWR.t828 VGND 0.02389f
C1510 VPWR.n342 VGND 0.02022f
C1511 VPWR.t482 VGND 0.02279f
C1512 VPWR.n343 VGND 0.02438f
C1513 VPWR.t1163 VGND 0.02389f
C1514 VPWR.n345 VGND 0.02022f
C1515 VPWR.t483 VGND 0.02389f
C1516 VPWR.n346 VGND 0.02022f
C1517 VPWR.t1165 VGND 0.02389f
C1518 VPWR.n348 VGND 0.02015f
C1519 VPWR.t485 VGND 0.02434f
C1520 VPWR.n349 VGND 0.02438f
C1521 VPWR.t1167 VGND 0.02186f
C1522 VPWR.n351 VGND 0.02445f
C1523 VPWR.t487 VGND 0.24186f
C1524 VPWR.n352 VGND 0.02022f
C1525 VPWR.t1168 VGND 1.59702f
C1526 VPWR.n354 VGND 0.02438f
C1527 VPWR.t489 VGND 0.02389f
C1528 VPWR.n355 VGND 0.02022f
C1529 VPWR.t491 VGND 0.02389f
C1530 VPWR.n357 VGND 0.02973f
C1531 VPWR.t1095 VGND 0.02365f
C1532 VPWR.t493 VGND 0.02389f
C1533 VPWR.n359 VGND 0.02878f
C1534 VPWR.n360 VGND 0.02004f
C1535 VPWR.t495 VGND 0.95322f
C1536 VPWR.n362 VGND 0.02933f
C1537 VPWR.t497 VGND 0.02389f
C1538 VPWR.t1096 VGND 0.01613f
C1539 VPWR.n364 VGND 0.02073f
C1540 VPWR.n365 VGND 0.02274f
C1541 VPWR.t621 VGND 0.02389f
C1542 VPWR.t1172 VGND 0.12176f
C1543 VPWR.n367 VGND 0.0212f
C1544 VPWR.n368 VGND 0.02216f
C1545 VPWR.t623 VGND 0.02389f
C1546 VPWR.t1173 VGND 0.02434f
C1547 VPWR.n370 VGND 0.02618f
C1548 VPWR.n371 VGND 0.02568f
C1549 VPWR.t625 VGND 0.02186f
C1550 VPWR.t167 VGND 0.01961f
C1551 VPWR.t9 VGND 0.01961f
C1552 VPWR.t12 VGND 0.37053f
C1553 VPWR.t34 VGND 0.46142f
C1554 VPWR.t36 VGND 0.45997f
C1555 VPWR.t13 VGND 0.86579f
C1556 VPWR.n372 VGND 0.08249f
C1557 VPWR.n373 VGND 0.04094f
C1558 VPWR.n374 VGND 0.02985f
C1559 VPWR.t14 VGND 0.51342f
C1560 VPWR.t37 VGND 0.87179f
C1561 VPWR.n376 VGND 0.0292f
C1562 VPWR.n377 VGND 0.029f
C1563 VPWR.t15 VGND 1.00723f
C1564 VPWR.n380 VGND 0.69904f
C1565 VPWR.n381 VGND 2.76948f
C1566 VPWR.n382 VGND 1.32935f
C1567 VPWR.n383 VGND 0.65266f
C1568 VPWR.t80 VGND 2.01346f
C1569 VPWR.n384 VGND 0.31095f
C1570 VPWR.t566 VGND 4.58851f
C1571 VPWR.t1113 VGND 0.39914f
C1572 VPWR.n385 VGND 0.02825f
C1573 VPWR.n386 VGND 0.29382f
C1574 VPWR.t1440 VGND 0.02389f
C1575 VPWR.t1153 VGND 0.02389f
C1576 VPWR.n388 VGND 0.02199f
C1577 VPWR.n389 VGND 0.02337f
C1578 VPWR.t1438 VGND 0.02389f
C1579 VPWR.t1151 VGND 0.02389f
C1580 VPWR.n391 VGND 0.0224f
C1581 VPWR.n392 VGND 0.02289f
C1582 VPWR.t1418 VGND 0.02389f
C1583 VPWR.t1149 VGND 0.02434f
C1584 VPWR.n394 VGND 0.02705f
C1585 VPWR.n395 VGND 0.0224f
C1586 VPWR.t1416 VGND 0.02389f
C1587 VPWR.t1147 VGND 0.02389f
C1588 VPWR.n397 VGND 0.02344f
C1589 VPWR.n398 VGND 0.02199f
C1590 VPWR.t1414 VGND 0.02389f
C1591 VPWR.t1146 VGND 0.02279f
C1592 VPWR.n400 VGND 0.02819f
C1593 VPWR.n401 VGND 0.02173f
C1594 VPWR.t166 VGND 0.07575f
C1595 VPWR.n403 VGND 0.02991f
C1596 VPWR.t1364 VGND 0.02389f
C1597 VPWR.n413 VGND 0.02575f
C1598 VPWR.t304 VGND 0.01961f
C1599 VPWR.t973 VGND 0.0196f
C1600 VPWR.n420 VGND 0.03011f
C1601 VPWR.n421 VGND 0.0292f
C1602 VPWR.t954 VGND 0.02105f
C1603 VPWR.n423 VGND 0.08249f
C1604 VPWR.t203 VGND 0.0196f
C1605 VPWR.n424 VGND 0.02985f
C1606 VPWR.n425 VGND 0.04094f
C1607 VPWR.t201 VGND 0.124f
C1608 VPWR.t537 VGND 0.0772f
C1609 VPWR.t1039 VGND 0.0335f
C1610 VPWR.t532 VGND 0.01961f
C1611 VPWR.n428 VGND 0.05408f
C1612 VPWR.t1040 VGND 0.03494f
C1613 VPWR.n430 VGND 0.08863f
C1614 VPWR.t533 VGND 0.0772f
C1615 VPWR.n431 VGND 0.08865f
C1616 VPWR.n432 VGND 0.07513f
C1617 VPWR.t1042 VGND 0.0196f
C1618 VPWR.t535 VGND 0.07575f
C1619 VPWR.n434 VGND 0.05336f
C1620 VPWR.t536 VGND 0.01961f
C1621 VPWR.t1043 VGND 0.1319f
C1622 VPWR.n436 VGND 0.02576f
C1623 VPWR.t1044 VGND 0.13113f
C1624 VPWR.t1432 VGND 0.02434f
C1625 VPWR.n437 VGND 0.02438f
C1626 VPWR.t539 VGND 0.07575f
C1627 VPWR.n438 VGND 0.03686f
C1628 VPWR.t1359 VGND 0.61015f
C1629 VPWR.n440 VGND 0.01994f
C1630 VPWR.t540 VGND 0.07576f
C1631 VPWR.n441 VGND 0.02459f
C1632 VPWR.t1435 VGND 0.02464f
C1633 VPWR.t541 VGND 0.0772f
C1634 VPWR.n443 VGND 0.08865f
C1635 VPWR.n444 VGND 0.0628f
C1636 VPWR.t200 VGND 0.12256f
C1637 VPWR.t952 VGND 0.0196f
C1638 VPWR.t953 VGND 0.01961f
C1639 VPWR.t1339 VGND 0.02389f
C1640 VPWR.n446 VGND 0.02933f
C1641 VPWR.t1341 VGND 0.02389f
C1642 VPWR.n448 VGND 0.02912f
C1643 VPWR.t1343 VGND 0.02434f
C1644 VPWR.n450 VGND 0.03319f
C1645 VPWR.t1345 VGND 0.02389f
C1646 VPWR.n452 VGND 0.02903f
C1647 VPWR.t1347 VGND 0.02279f
C1648 VPWR.n454 VGND 0.03738f
C1649 VPWR.t235 VGND 0.03728f
C1650 VPWR.n457 VGND 0.03398f
C1651 VPWR.t233 VGND 0.20638f
C1652 VPWR.n459 VGND 0.03389f
C1653 VPWR.t231 VGND 0.42895f
C1654 VPWR.n460 VGND 0.08865f
C1655 VPWR.n461 VGND 0.05313f
C1656 VPWR.t232 VGND 0.24073f
C1657 VPWR.n463 VGND 0.0387f
C1658 VPWR.t1351 VGND 0.14023f
C1659 VPWR.n464 VGND 0.03236f
C1660 VPWR.n465 VGND 0.0105f
C1661 VPWR.t1337 VGND 0.02389f
C1662 VPWR.n466 VGND 0.03368f
C1663 VPWR.t1335 VGND 0.02389f
C1664 VPWR.n468 VGND 0.03371f
C1665 VPWR.t1333 VGND 0.02389f
C1666 VPWR.n470 VGND 0.02933f
C1667 VPWR.t1330 VGND 0.02389f
C1668 VPWR.n472 VGND 0.02912f
C1669 VPWR.t1328 VGND 2.25454f
C1670 VPWR.n474 VGND 0.02903f
C1671 VPWR.t1326 VGND 0.02389f
C1672 VPWR.n476 VGND 0.02896f
C1673 VPWR.t1325 VGND 0.02186f
C1674 VPWR.n478 VGND 0.04914f
C1675 VPWR.t1300 VGND 0.15363f
C1676 VPWR.n479 VGND 0.04411f
C1677 VPWR.n480 VGND 0.02156f
C1678 VPWR.t234 VGND 0.03651f
C1679 VPWR.n481 VGND 0.05314f
C1680 VPWR.n482 VGND 0.04503f
C1681 VPWR.t1 VGND 0.17385f
C1682 VPWR.n484 VGND 0.02828f
C1683 VPWR.n485 VGND 0.0105f
C1684 VPWR.n486 VGND 0.08865f
C1685 VPWR.t77 VGND 0.07857f
C1686 VPWR.t78 VGND 0.21128f
C1687 VPWR.t1422 VGND 3.30623f
C1688 VPWR.t45 VGND 8.4311f
C1689 VPWR.t46 VGND 8.42966f
C1690 VPWR.n487 VGND 0.03982f
C1691 VPWR.t198 VGND 0.28166f
C1692 VPWR.t980 VGND 0.08712f
C1693 VPWR.t1348 VGND 0.13536f
C1694 VPWR.t1038 VGND 0.0196f
C1695 VPWR.t1037 VGND 0.02042f
C1696 VPWR.n488 VGND 0.03859f
C1697 VPWR.t1036 VGND 0.02105f
C1698 VPWR.n489 VGND 0.08865f
C1699 VPWR.n490 VGND 0.0564f
C1700 VPWR.n492 VGND 0.04575f
C1701 VPWR.n493 VGND 0.01575f
C1702 VPWR.n494 VGND 0.04021f
C1703 VPWR.n495 VGND 0.0105f
C1704 VPWR.n496 VGND 0.0387f
C1705 VPWR.t199 VGND 0.35062f
C1706 VPWR.n498 VGND 0.08865f
C1707 VPWR.n499 VGND 0.05313f
C1708 VPWR.n501 VGND 0.03389f
C1709 VPWR.n503 VGND 0.04727f
C1710 VPWR.n504 VGND 1.10779f
C1711 VPWR.n505 VGND 0.01329f
C1712 VPWR.n506 VGND 0.02659f
C1713 VPWR.n508 VGND 2.76948f
C1714 VPWR.n509 VGND 0.01329f
C1715 VPWR.n510 VGND 0.11133f
C1716 VPWR.n511 VGND 0.50043f
C1717 VPWR.t236 VGND 2.81955f
C1718 VPWR.t975 VGND 0.13603f
C1719 VPWR.t974 VGND 0.13527f
C1720 VPWR.n512 VGND 0.04836f
C1721 VPWR.n513 VGND 0.02958f
C1722 VPWR.t237 VGND 2.8181f
C1723 VPWR.n515 VGND 0.02991f
C1724 VPWR.t1076 VGND 0.02279f
C1725 VPWR.n516 VGND 0.02912f
C1726 VPWR.t1077 VGND 0.02389f
C1727 VPWR.n518 VGND 0.02022f
C1728 VPWR.t1394 VGND 0.02186f
C1729 VPWR.n519 VGND 0.02445f
C1730 VPWR.t1079 VGND 0.02434f
C1731 VPWR.n521 VGND 0.02438f
C1732 VPWR.t1395 VGND 0.02389f
C1733 VPWR.n522 VGND 0.02015f
C1734 VPWR.t1081 VGND 0.02389f
C1735 VPWR.n524 VGND 0.02022f
C1736 VPWR.t1397 VGND 0.09461f
C1737 VPWR.n525 VGND 0.02022f
C1738 VPWR.t1083 VGND 0.02389f
C1739 VPWR.n527 VGND 0.02022f
C1740 VPWR.t1361 VGND 0.02389f
C1741 VPWR.n528 VGND 0.02022f
C1742 VPWR.t1085 VGND 0.02389f
C1743 VPWR.n530 VGND 0.02022f
C1744 VPWR.t1362 VGND 0.43615f
C1745 VPWR.n531 VGND 0.02022f
C1746 VPWR.t1366 VGND 0.02389f
C1747 VPWR.n533 VGND 0.02022f
C1748 VPWR.t1087 VGND 0.02389f
C1749 VPWR.n534 VGND 0.02575f
C1750 VPWR.t1368 VGND 0.02389f
C1751 VPWR.n536 VGND 0.02022f
C1752 VPWR.t1089 VGND 0.02389f
C1753 VPWR.n537 VGND 0.02022f
C1754 VPWR.t1370 VGND 0.02389f
C1755 VPWR.n539 VGND 0.02022f
C1756 VPWR.t1091 VGND 2.27178f
C1757 VPWR.n540 VGND 0.02022f
C1758 VPWR.t1372 VGND 0.02434f
C1759 VPWR.n542 VGND 0.02438f
C1760 VPWR.t1108 VGND 0.27918f
C1761 VPWR.n543 VGND 0.02022f
C1762 VPWR.t1374 VGND 0.02389f
C1763 VPWR.n545 VGND 0.02022f
C1764 VPWR.t1110 VGND 0.02389f
C1765 VPWR.n546 VGND 0.02015f
C1766 VPWR.t1376 VGND 0.02279f
C1767 VPWR.n548 VGND 0.02438f
C1768 VPWR.t1112 VGND 0.02186f
C1769 VPWR.n549 VGND 0.02445f
C1770 VPWR.t1403 VGND 0.02279f
C1771 VPWR.n551 VGND 0.02438f
C1772 VPWR.t197 VGND 1.33356f
C1773 VPWR.n552 VGND 0.02459f
C1774 VPWR.t1404 VGND 2.02628f
C1775 VPWR.t162 VGND 1.335f
C1776 VPWR.n554 VGND 0.08865f
C1777 VPWR.n555 VGND 0.06181f
C1778 VPWR.t163 VGND 0.0196f
C1779 VPWR.t1406 VGND 0.02434f
C1780 VPWR.n557 VGND 0.02885f
C1781 VPWR.n558 VGND 0.02662f
C1782 VPWR.t1408 VGND 0.02389f
C1783 VPWR.t164 VGND 0.01961f
C1784 VPWR.n560 VGND 0.02792f
C1785 VPWR.n561 VGND 0.02491f
C1786 VPWR.t1410 VGND 0.02395f
C1787 VPWR.t165 VGND 0.0772f
C1788 VPWR.t1412 VGND 0.02389f
C1789 VPWR.t1155 VGND 0.02389f
C1790 VPWR.t1442 VGND 1.88151f
C1791 VPWR.t81 VGND 2.01346f
C1792 VPWR.t79 VGND 17.4961f
C1793 VPWR.n562 VGND 0.50043f
C1794 VPWR.n563 VGND 0.11133f
C1795 VPWR.n564 VGND 0.01329f
C1796 VPWR.n565 VGND 0.02659f
C1797 VPWR.n566 VGND 0.01329f
C1798 VPWR.n567 VGND 0.08475f
C1799 VPWR.n568 VGND 0.28083f
C1800 VPWR.t8 VGND 17.4961f
C1801 VPWR.n571 VGND 0.28083f
C1802 VPWR.t929 VGND 0.0196f
C1803 VPWR.t289 VGND 0.0196f
C1804 VPWR.n573 VGND 0.04797f
C1805 VPWR.t25 VGND 0.50393f
C1806 VPWR.t630 VGND 0.02389f
C1807 VPWR.t1184 VGND 0.02389f
C1808 VPWR.n578 VGND 0.02319f
C1809 VPWR.n579 VGND 0.02428f
C1810 VPWR.t629 VGND 0.02186f
C1811 VPWR.t1182 VGND 0.02389f
C1812 VPWR.n581 VGND 0.02345f
C1813 VPWR.n582 VGND 0.02809f
C1814 VPWR.t1181 VGND 0.02389f
C1815 VPWR.t1180 VGND 0.02186f
C1816 VPWR.n584 VGND 0.04772f
C1817 VPWR.t1356 VGND 0.02389f
C1818 VPWR.t1178 VGND 0.13287f
C1819 VPWR.n586 VGND 0.04333f
C1820 VPWR.t1354 VGND 0.02389f
C1821 VPWR.t1176 VGND 0.02389f
C1822 VPWR.n588 VGND 0.04333f
C1823 VPWR.t1353 VGND 0.02186f
C1824 VPWR.t1175 VGND 1.84865f
C1825 VPWR.n590 VGND 0.04772f
C1826 VPWR.t1226 VGND 0.02389f
C1827 VPWR.t1212 VGND 0.02279f
C1828 VPWR.n592 VGND 0.02802f
C1829 VPWR.n593 VGND 0.02345f
C1830 VPWR.t1224 VGND 0.02389f
C1831 VPWR.t1210 VGND 0.02389f
C1832 VPWR.n595 VGND 0.02435f
C1833 VPWR.n596 VGND 0.02319f
C1834 VPWR.t1208 VGND 0.02434f
C1835 VPWR.n598 VGND 0.0287f
C1836 VPWR.t933 VGND 0.07575f
C1837 VPWR.t293 VGND 0.0196f
C1838 VPWR.n605 VGND 0.05336f
C1839 VPWR.t1034 VGND 0.01961f
C1840 VPWR.t458 VGND 0.10383f
C1841 VPWR.n608 VGND 0.05251f
C1842 VPWR.t1033 VGND 0.0196f
C1843 VPWR.t457 VGND 0.07575f
C1844 VPWR.n610 VGND 0.05336f
C1845 VPWR.t1026 VGND 0.01961f
C1846 VPWR.t450 VGND 0.01961f
C1847 VPWR.n612 VGND 0.05408f
C1848 VPWR.t1027 VGND 0.02105f
C1849 VPWR.n614 VGND 0.08863f
C1850 VPWR.t451 VGND 0.0772f
C1851 VPWR.n615 VGND 0.08865f
C1852 VPWR.n616 VGND 0.07513f
C1853 VPWR.t1029 VGND 0.0196f
C1854 VPWR.t453 VGND 0.07575f
C1855 VPWR.n618 VGND 0.05336f
C1856 VPWR.t1030 VGND 0.15998f
C1857 VPWR.t454 VGND 0.01961f
C1858 VPWR.n620 VGND 0.05251f
C1859 VPWR.t1031 VGND 0.16142f
C1860 VPWR.n621 VGND 0.08863f
C1861 VPWR.t455 VGND 0.0772f
C1862 VPWR.n622 VGND 0.08865f
C1863 VPWR.n623 VGND 0.07185f
C1864 VPWR.t928 VGND 0.02105f
C1865 VPWR.n625 VGND 0.08863f
C1866 VPWR.t288 VGND 0.10527f
C1867 VPWR.n626 VGND 0.08865f
C1868 VPWR.n627 VGND 0.07185f
C1869 VPWR.t930 VGND 0.01961f
C1870 VPWR.t290 VGND 0.13191f
C1871 VPWR.n629 VGND 0.04735f
C1872 VPWR.t931 VGND 0.0772f
C1873 VPWR.n630 VGND 0.08863f
C1874 VPWR.t291 VGND 0.13335f
C1875 VPWR.n631 VGND 0.08865f
C1876 VPWR.n632 VGND 0.07185f
C1877 VPWR.t552 VGND 0.02186f
C1878 VPWR.n634 VGND 0.02445f
C1879 VPWR.t294 VGND 0.01961f
C1880 VPWR.n635 VGND 0.02975f
C1881 VPWR.t553 VGND 0.02395f
C1882 VPWR.t295 VGND 0.10527f
C1883 VPWR.n637 VGND 0.08865f
C1884 VPWR.n638 VGND 0.06174f
C1885 VPWR.t297 VGND 0.10383f
C1886 VPWR.t555 VGND 0.02389f
C1887 VPWR.n640 VGND 0.02469f
C1888 VPWR.n641 VGND 0.02662f
C1889 VPWR.t557 VGND 2.15195f
C1890 VPWR.n643 VGND 0.02912f
C1891 VPWR.t1198 VGND 0.02389f
C1892 VPWR.t1213 VGND 0.02279f
C1893 VPWR.n645 VGND 0.02802f
C1894 VPWR.n646 VGND 0.02345f
C1895 VPWR.t1200 VGND 0.95034f
C1896 VPWR.t1214 VGND 0.02389f
C1897 VPWR.n648 VGND 0.02435f
C1898 VPWR.n649 VGND 0.02319f
C1899 VPWR.t1216 VGND 0.07883f
C1900 VPWR.n650 VGND 0.0287f
C1901 VPWR.t1218 VGND 0.02389f
C1902 VPWR.n652 VGND 0.02022f
C1903 VPWR.t1202 VGND 0.02389f
C1904 VPWR.n653 VGND 0.02022f
C1905 VPWR.t1220 VGND 0.02389f
C1906 VPWR.n655 VGND 0.02022f
C1907 VPWR.t1204 VGND 0.02389f
C1908 VPWR.n656 VGND 0.02022f
C1909 VPWR.t1222 VGND 0.02389f
C1910 VPWR.n658 VGND 0.02022f
C1911 VPWR.t1206 VGND 0.02389f
C1912 VPWR.n659 VGND 0.02022f
C1913 VPWR.t1186 VGND 0.02389f
C1914 VPWR.n661 VGND 0.02022f
C1915 VPWR.t632 VGND 0.02389f
C1916 VPWR.n662 VGND 0.02453f
C1917 VPWR.t1188 VGND 0.02389f
C1918 VPWR.n664 VGND 0.02022f
C1919 VPWR.t634 VGND 0.49827f
C1920 VPWR.n665 VGND 0.02022f
C1921 VPWR.t1190 VGND 0.02389f
C1922 VPWR.n667 VGND 0.02022f
C1923 VPWR.t830 VGND 0.02389f
C1924 VPWR.n668 VGND 0.02022f
C1925 VPWR.t832 VGND 1.95041f
C1926 VPWR.n670 VGND 0.02022f
C1927 VPWR.t1192 VGND 0.02434f
C1928 VPWR.n672 VGND 0.0287f
C1929 VPWR.t1194 VGND 0.02389f
C1930 VPWR.t834 VGND 0.02389f
C1931 VPWR.n674 VGND 0.02319f
C1932 VPWR.n675 VGND 0.02435f
C1933 VPWR.t1196 VGND 0.02279f
C1934 VPWR.t836 VGND 0.02389f
C1935 VPWR.n677 VGND 0.02345f
C1936 VPWR.n678 VGND 0.02802f
C1937 VPWR.t838 VGND 0.02389f
C1938 VPWR.t22 VGND 0.01961f
C1939 VPWR.n680 VGND 0.02573f
C1940 VPWR.n681 VGND 0.02465f
C1941 VPWR.t23 VGND 0.02105f
C1942 VPWR.t840 VGND 0.02444f
C1943 VPWR.t842 VGND 0.02389f
C1944 VPWR.t135 VGND 7.01952f
C1945 VPWR.t2 VGND 17.4959f
C1946 VPWR.n684 VGND 0.41875f
C1947 VPWR.n685 VGND 0.41875f
C1948 VPWR.t299 VGND 0.0196f
C1949 VPWR.t380 VGND 0.0196f
C1950 VPWR.n687 VGND 0.04797f
C1951 VPWR.t301 VGND 0.02105f
C1952 VPWR.n689 VGND 0.08863f
C1953 VPWR.t168 VGND 0.02105f
C1954 VPWR.n690 VGND 0.08865f
C1955 VPWR.n691 VGND 0.07185f
C1956 VPWR.t303 VGND 0.0196f
C1957 VPWR.t169 VGND 0.0196f
C1958 VPWR.n692 VGND 0.05737f
C1959 VPWR.t644 VGND 0.02389f
C1960 VPWR.t264 VGND 0.02389f
C1961 VPWR.n694 VGND 0.04806f
C1962 VPWR.t646 VGND 1.72706f
C1963 VPWR.t266 VGND 0.13794f
C1964 VPWR.n696 VGND 0.04808f
C1965 VPWR.t648 VGND 0.03751f
C1966 VPWR.t268 VGND 0.02389f
C1967 VPWR.n698 VGND 0.0437f
C1968 VPWR.t305 VGND 0.48008f
C1969 VPWR.t270 VGND 0.02389f
C1970 VPWR.n700 VGND 0.0435f
C1971 VPWR.t306 VGND 0.02389f
C1972 VPWR.t272 VGND 0.02434f
C1973 VPWR.n702 VGND 0.04756f
C1974 VPWR.t308 VGND 0.93627f
C1975 VPWR.t274 VGND 0.02389f
C1976 VPWR.n704 VGND 0.04333f
C1977 VPWR.t310 VGND 0.02186f
C1978 VPWR.t276 VGND 0.02279f
C1979 VPWR.n706 VGND 0.05189f
C1980 VPWR.t311 VGND 0.0207f
C1981 VPWR.t174 VGND 0.01961f
C1982 VPWR.n708 VGND 0.02786f
C1983 VPWR.n709 VGND 0.02906f
C1984 VPWR.t175 VGND 0.99356f
C1985 VPWR.t312 VGND 0.02365f
C1986 VPWR.t500 VGND 0.02279f
C1987 VPWR.n710 VGND 0.02438f
C1988 VPWR.t651 VGND 0.02186f
C1989 VPWR.n711 VGND 0.02918f
C1990 VPWR.t501 VGND 0.02389f
C1991 VPWR.n713 VGND 0.02022f
C1992 VPWR.t652 VGND 0.02389f
C1993 VPWR.n714 VGND 0.02015f
C1994 VPWR.t503 VGND 0.02434f
C1995 VPWR.n716 VGND 0.02438f
C1996 VPWR.t654 VGND 0.02389f
C1997 VPWR.n717 VGND 0.02022f
C1998 VPWR.t505 VGND 0.02389f
C1999 VPWR.n719 VGND 0.02022f
C2000 VPWR.t656 VGND 0.1987f
C2001 VPWR.n720 VGND 0.02022f
C2002 VPWR.t507 VGND 0.02389f
C2003 VPWR.n722 VGND 0.02022f
C2004 VPWR.t659 VGND 0.02389f
C2005 VPWR.n723 VGND 0.02022f
C2006 VPWR.t661 VGND 0.02389f
C2007 VPWR.n725 VGND 0.02022f
C2008 VPWR.t509 VGND 0.02389f
C2009 VPWR.n727 VGND 0.02575f
C2010 VPWR.t663 VGND 0.94026f
C2011 VPWR.n728 VGND 0.02575f
C2012 VPWR.t665 VGND 0.02389f
C2013 VPWR.n730 VGND 0.02022f
C2014 VPWR.t511 VGND 1.17421f
C2015 VPWR.n731 VGND 0.02022f
C2016 VPWR.t667 VGND 0.02389f
C2017 VPWR.n733 VGND 0.02199f
C2018 VPWR.t513 VGND 0.37352f
C2019 VPWR.n734 VGND 0.02022f
C2020 VPWR.t515 VGND 0.48937f
C2021 VPWR.t132 VGND 0.53267f
C2022 VPWR.n736 VGND 0.41875f
C2023 VPWR.t348 VGND 0.5331f
C2024 VPWR.t335 VGND 1.84002f
C2025 VPWR.n737 VGND 0.36954f
C2026 VPWR.t1230 VGND 0.26386f
C2027 VPWR.t398 VGND 0.65184f
C2028 VPWR.n739 VGND 0.08249f
C2029 VPWR.t103 VGND 0.01961f
C2030 VPWR.n740 VGND 0.02855f
C2031 VPWR.n741 VGND 0.03158f
C2032 VPWR.t102 VGND 2.21373f
C2033 VPWR.n743 VGND 0.03731f
C2034 VPWR.t179 VGND 0.17654f
C2035 VPWR.t907 VGND 0.02395f
C2036 VPWR.t178 VGND 0.07576f
C2037 VPWR.t906 VGND 1.81624f
C2038 VPWR.n745 VGND 0.02491f
C2039 VPWR.n746 VGND 0.02792f
C2040 VPWR.t1101 VGND 0.1351f
C2041 VPWR.t904 VGND 1.00262f
C2042 VPWR.n748 VGND 0.02583f
C2043 VPWR.n749 VGND 0.02271f
C2044 VPWR.t1099 VGND 0.02389f
C2045 VPWR.t902 VGND 0.02389f
C2046 VPWR.n751 VGND 0.02216f
C2047 VPWR.n752 VGND 0.02209f
C2048 VPWR.t1098 VGND 0.02186f
C2049 VPWR.t900 VGND 0.02434f
C2050 VPWR.n754 VGND 0.02687f
C2051 VPWR.n755 VGND 0.02589f
C2052 VPWR.t898 VGND 0.02389f
C2053 VPWR.n757 VGND 0.02834f
C2054 VPWR.t909 VGND 0.02389f
C2055 VPWR.n758 VGND 0.02028f
C2056 VPWR.t181 VGND 0.11895f
C2057 VPWR.n760 VGND 0.02991f
C2058 VPWR.t182 VGND 0.01961f
C2059 VPWR.t911 VGND 1.01418f
C2060 VPWR.n762 VGND 0.02081f
C2061 VPWR.n763 VGND 0.03192f
C2062 VPWR.t913 VGND 0.0795f
C2063 VPWR.t915 VGND 0.02389f
C2064 VPWR.t183 VGND 0.02105f
C2065 VPWR.t185 VGND 0.0196f
C2066 VPWR.n764 VGND 0.02452f
C2067 VPWR.t917 VGND 0.02434f
C2068 VPWR.n766 VGND 0.0287f
C2069 VPWR.t919 VGND 0.02389f
C2070 VPWR.n768 VGND 0.02903f
C2071 VPWR.t921 VGND 0.91896f
C2072 VPWR.t789 VGND 2.56894f
C2073 VPWR.n770 VGND 0.02292f
C2074 VPWR.n771 VGND 0.02747f
C2075 VPWR.t154 VGND 0.87607f
C2076 VPWR.t100 VGND 0.01961f
C2077 VPWR.n773 VGND 0.02627f
C2078 VPWR.t155 VGND 1.42285f
C2079 VPWR.t397 VGND 0.4899f
C2080 VPWR.t101 VGND 2.21517f
C2081 VPWR.t400 VGND 0.18021f
C2082 VPWR.t104 VGND 0.28265f
C2083 VPWR.n774 VGND 0.08865f
C2084 VPWR.n775 VGND 0.07169f
C2085 VPWR.t106 VGND 0.28121f
C2086 VPWR.t59 VGND 0.54276f
C2087 VPWR.t905 VGND 0.36792f
C2088 VPWR.t896 VGND 0.02481f
C2089 VPWR.t73 VGND 0.01883f
C2090 VPWR.n777 VGND 0.05314f
C2091 VPWR.t890 VGND 0.02395f
C2092 VPWR.t70 VGND 0.97784f
C2093 VPWR.t1461 VGND 0.01961f
C2094 VPWR.t215 VGND 0.02389f
C2095 VPWR.n778 VGND 0.02647f
C2096 VPWR.n779 VGND 0.02792f
C2097 VPWR.t213 VGND 1.46168f
C2098 VPWR.t1460 VGND 0.04739f
C2099 VPWR.n781 VGND 0.02662f
C2100 VPWR.n782 VGND 0.02469f
C2101 VPWR.t396 VGND 0.01961f
C2102 VPWR.t1453 VGND 0.01961f
C2103 VPWR.n786 VGND 0.04735f
C2104 VPWR.t388 VGND 0.36924f
C2105 VPWR.t597 VGND 0.01961f
C2106 VPWR.n790 VGND 0.05251f
C2107 VPWR.t387 VGND 0.07575f
C2108 VPWR.t596 VGND 0.0196f
C2109 VPWR.n792 VGND 0.05336f
C2110 VPWR.t384 VGND 0.32677f
C2111 VPWR.t593 VGND 0.01961f
C2112 VPWR.n794 VGND 0.05408f
C2113 VPWR.t385 VGND 0.38436f
C2114 VPWR.n795 VGND 0.08863f
C2115 VPWR.t594 VGND 0.02105f
C2116 VPWR.n796 VGND 0.08865f
C2117 VPWR.n797 VGND 0.07513f
C2118 VPWR.t389 VGND 0.37068f
C2119 VPWR.n799 VGND 0.08863f
C2120 VPWR.t598 VGND 0.0772f
C2121 VPWR.n800 VGND 0.08865f
C2122 VPWR.n801 VGND 0.07185f
C2123 VPWR.t391 VGND 0.0196f
C2124 VPWR.t600 VGND 0.07575f
C2125 VPWR.n803 VGND 0.05336f
C2126 VPWR.t392 VGND 0.06331f
C2127 VPWR.t601 VGND 0.01961f
C2128 VPWR.n805 VGND 0.05251f
C2129 VPWR.t393 VGND 0.17705f
C2130 VPWR.n806 VGND 0.08863f
C2131 VPWR.t602 VGND 0.02105f
C2132 VPWR.n807 VGND 0.08865f
C2133 VPWR.n808 VGND 0.07185f
C2134 VPWR.t395 VGND 0.1319f
C2135 VPWR.t1452 VGND 0.0196f
C2136 VPWR.n811 VGND 0.04797f
C2137 VPWR.t170 VGND 3.07587f
C2138 VPWR.n813 VGND 0.08863f
C2139 VPWR.t1454 VGND 0.02105f
C2140 VPWR.n814 VGND 0.08865f
C2141 VPWR.n815 VGND 0.07185f
C2142 VPWR.t171 VGND 3.07443f
C2143 VPWR.t1456 VGND 0.0196f
C2144 VPWR.n817 VGND 0.05336f
C2145 VPWR.t1457 VGND 0.01961f
C2146 VPWR.n818 VGND 0.02975f
C2147 VPWR.t211 VGND 0.02395f
C2148 VPWR.t1458 VGND 0.04884f
C2149 VPWR.n820 VGND 0.08865f
C2150 VPWR.n821 VGND 0.06174f
C2151 VPWR.t210 VGND 0.02186f
C2152 VPWR.n822 VGND 0.02445f
C2153 VPWR.t892 VGND 0.02389f
C2154 VPWR.t71 VGND 0.97639f
C2155 VPWR.t72 VGND 0.0196f
C2156 VPWR.t894 VGND 0.02389f
C2157 VPWR.n824 VGND 0.41875f
C2158 VPWR.n825 VGND 0.41875f
C2159 VPWR.n828 VGND 0.41875f
C2160 VPWR.t1518 VGND 0.0196f
C2161 VPWR.t359 VGND 0.07575f
C2162 VPWR.n829 VGND 0.04797f
C2163 VPWR.n830 VGND 0.52273f
C2164 VPWR.t724 VGND 0.02412f
C2165 VPWR.t740 VGND 0.02389f
C2166 VPWR.n832 VGND 0.0437f
C2167 VPWR.t723 VGND 0.04081f
C2168 VPWR.t739 VGND 0.02389f
C2169 VPWR.n834 VGND 0.0435f
C2170 VPWR.t1273 VGND 0.02389f
C2171 VPWR.t1426 VGND 0.02389f
C2172 VPWR.n836 VGND 0.0434f
C2173 VPWR.t1271 VGND 0.02389f
C2174 VPWR.t1424 VGND 1.06028f
C2175 VPWR.n838 VGND 0.04326f
C2176 VPWR.t1270 VGND 0.02186f
C2177 VPWR.t1423 VGND 0.02186f
C2178 VPWR.n840 VGND 0.05195f
C2179 VPWR.t1577 VGND 0.49354f
C2180 VPWR.t1541 VGND 1.02708f
C2181 VPWR.n842 VGND 0.05189f
C2182 VPWR.t1575 VGND 0.13973f
C2183 VPWR.t1539 VGND 0.02389f
C2184 VPWR.n844 VGND 0.04333f
C2185 VPWR.t1573 VGND 0.02811f
C2186 VPWR.t1537 VGND 0.02434f
C2187 VPWR.n846 VGND 0.04756f
C2188 VPWR.t1291 VGND 0.08181f
C2189 VPWR.t1535 VGND 0.02389f
C2190 VPWR.n848 VGND 0.0435f
C2191 VPWR.t1289 VGND 0.25973f
C2192 VPWR.t1533 VGND 1.10658f
C2193 VPWR.n850 VGND 0.0437f
C2194 VPWR.t1287 VGND 0.97238f
C2195 VPWR.t1531 VGND 0.02389f
C2196 VPWR.n852 VGND 0.04808f
C2197 VPWR.t1515 VGND 0.01961f
C2198 VPWR.t356 VGND 0.01961f
C2199 VPWR.n856 VGND 0.05251f
C2200 VPWR.t1514 VGND 0.1319f
C2201 VPWR.t355 VGND 0.1319f
C2202 VPWR.n858 VGND 0.05336f
C2203 VPWR.t1507 VGND 0.01961f
C2204 VPWR.t404 VGND 0.01961f
C2205 VPWR.n860 VGND 0.05408f
C2206 VPWR.t1508 VGND 0.02105f
C2207 VPWR.n862 VGND 0.08863f
C2208 VPWR.t405 VGND 0.0772f
C2209 VPWR.n863 VGND 0.08865f
C2210 VPWR.n864 VGND 0.07513f
C2211 VPWR.t1510 VGND 0.0196f
C2212 VPWR.t407 VGND 0.07575f
C2213 VPWR.n866 VGND 0.05336f
C2214 VPWR.t1511 VGND 0.01961f
C2215 VPWR.t408 VGND 0.01961f
C2216 VPWR.n868 VGND 0.05251f
C2217 VPWR.t1512 VGND 0.13335f
C2218 VPWR.n869 VGND 0.08863f
C2219 VPWR.t354 VGND 0.13335f
C2220 VPWR.n870 VGND 0.08865f
C2221 VPWR.n871 VGND 0.07185f
C2222 VPWR.t1516 VGND 0.02105f
C2223 VPWR.n873 VGND 0.08863f
C2224 VPWR.t357 VGND 0.0772f
C2225 VPWR.n874 VGND 0.08865f
C2226 VPWR.n875 VGND 0.07185f
C2227 VPWR.t1519 VGND 0.01961f
C2228 VPWR.t360 VGND 0.04768f
C2229 VPWR.n877 VGND 0.04735f
C2230 VPWR.t245 VGND 0.02105f
C2231 VPWR.n878 VGND 0.08863f
C2232 VPWR.t65 VGND 0.12699f
C2233 VPWR.n879 VGND 0.08865f
C2234 VPWR.n880 VGND 0.07185f
C2235 VPWR.t246 VGND 0.0196f
C2236 VPWR.t66 VGND 0.09747f
C2237 VPWR.n882 VGND 0.05737f
C2238 VPWR.t1276 VGND 0.02279f
C2239 VPWR.t684 VGND 0.02186f
C2240 VPWR.n884 VGND 0.05598f
C2241 VPWR.t1277 VGND 0.02389f
C2242 VPWR.t685 VGND 0.02494f
C2243 VPWR.n886 VGND 0.04333f
C2244 VPWR.t1279 VGND 0.02434f
C2245 VPWR.t687 VGND 0.02389f
C2246 VPWR.n888 VGND 0.04756f
C2247 VPWR.t1281 VGND 0.02389f
C2248 VPWR.t689 VGND 0.02389f
C2249 VPWR.n890 VGND 0.0435f
C2250 VPWR.t1283 VGND 0.02389f
C2251 VPWR.t1527 VGND 0.02389f
C2252 VPWR.n892 VGND 0.0437f
C2253 VPWR.t1285 VGND 0.02389f
C2254 VPWR.t1529 VGND 0.02389f
C2255 VPWR.n893 VGND 0.04806f
C2256 VPWR.t726 VGND 1.26717f
C2257 VPWR.t742 VGND 0.02389f
C2258 VPWR.n895 VGND 0.04806f
C2259 VPWR.t728 VGND 0.02389f
C2260 VPWR.t744 VGND 0.02389f
C2261 VPWR.n897 VGND 0.04808f
C2262 VPWR.t730 VGND 0.02389f
C2263 VPWR.t746 VGND 0.02389f
C2264 VPWR.n899 VGND 0.0437f
C2265 VPWR.t732 VGND 0.02389f
C2266 VPWR.t748 VGND 0.02389f
C2267 VPWR.n901 VGND 0.0435f
C2268 VPWR.t734 VGND 0.02434f
C2269 VPWR.t750 VGND 0.02434f
C2270 VPWR.n903 VGND 0.05172f
C2271 VPWR.t736 VGND 0.02389f
C2272 VPWR.t752 VGND 0.02389f
C2273 VPWR.n905 VGND 0.0434f
C2274 VPWR.t738 VGND 0.02279f
C2275 VPWR.t754 VGND 0.02279f
C2276 VPWR.n907 VGND 0.05377f
C2277 VPWR.t240 VGND 2.0099f
C2278 VPWR.t247 VGND 8.05689f
C2279 VPWR.t110 VGND 14.59141f
C2280 VPWR.n910 VGND 0.41875f
C2281 VPWR.n911 VGND 0.03046f
C2282 VPWR.n912 VGND 0.22654f
C2283 VPWR.t366 VGND 0.0196f
C2284 VPWR.t1485 VGND 4.66352f
C2285 VPWR.n914 VGND 0.04797f
C2286 VPWR.t68 VGND 2.06088f
C2287 VPWR.n916 VGND 0.08863f
C2288 VPWR.t158 VGND 0.02105f
C2289 VPWR.n917 VGND 0.08865f
C2290 VPWR.n918 VGND 0.07185f
C2291 VPWR.t69 VGND 2.05944f
C2292 VPWR.t159 VGND 0.0196f
C2293 VPWR.n919 VGND 0.05737f
C2294 VPWR.t854 VGND 0.02389f
C2295 VPWR.t1581 VGND 0.02389f
C2296 VPWR.n921 VGND 0.04806f
C2297 VPWR.t856 VGND 0.02389f
C2298 VPWR.t1583 VGND 0.02389f
C2299 VPWR.n923 VGND 0.04808f
C2300 VPWR.t858 VGND 0.02751f
C2301 VPWR.t1585 VGND 0.02389f
C2302 VPWR.n925 VGND 0.0437f
C2303 VPWR.t468 VGND 0.02389f
C2304 VPWR.t1587 VGND 0.02389f
C2305 VPWR.n927 VGND 0.0435f
C2306 VPWR.t469 VGND 1.97211f
C2307 VPWR.t1589 VGND 0.02434f
C2308 VPWR.n929 VGND 0.04756f
C2309 VPWR.t471 VGND 0.02389f
C2310 VPWR.t1591 VGND 0.02389f
C2311 VPWR.n931 VGND 0.04333f
C2312 VPWR.t473 VGND 0.02186f
C2313 VPWR.t1593 VGND 0.02279f
C2314 VPWR.n933 VGND 0.05189f
C2315 VPWR.t474 VGND 0.02186f
C2316 VPWR.n934 VGND 0.02918f
C2317 VPWR.t475 VGND 0.02389f
C2318 VPWR.n936 VGND 0.02015f
C2319 VPWR.t1542 VGND 0.02279f
C2320 VPWR.n937 VGND 0.02438f
C2321 VPWR.t477 VGND 0.02389f
C2322 VPWR.n939 VGND 0.02022f
C2323 VPWR.t1543 VGND 0.02389f
C2324 VPWR.n940 VGND 0.02022f
C2325 VPWR.t479 VGND 1.89248f
C2326 VPWR.n942 VGND 0.02022f
C2327 VPWR.t1545 VGND 0.05672f
C2328 VPWR.n943 VGND 0.02438f
C2329 VPWR.t757 VGND 0.02389f
C2330 VPWR.n945 VGND 0.02022f
C2331 VPWR.t1547 VGND 0.94678f
C2332 VPWR.n946 VGND 0.02022f
C2333 VPWR.t759 VGND 0.02389f
C2334 VPWR.n948 VGND 0.02022f
C2335 VPWR.t1549 VGND 0.02389f
C2336 VPWR.n949 VGND 0.02022f
C2337 VPWR.t1553 VGND 0.02389f
C2338 VPWR.n951 VGND 0.02022f
C2339 VPWR.t761 VGND 0.02389f
C2340 VPWR.n952 VGND 0.02575f
C2341 VPWR.t1555 VGND 0.02389f
C2342 VPWR.n954 VGND 0.02022f
C2343 VPWR.t763 VGND 0.02389f
C2344 VPWR.n955 VGND 0.02022f
C2345 VPWR.t218 VGND 0.02389f
C2346 VPWR.n957 VGND 0.02022f
C2347 VPWR.t765 VGND 0.02389f
C2348 VPWR.n958 VGND 0.02022f
C2349 VPWR.t219 VGND 0.55653f
C2350 VPWR.n960 VGND 0.02022f
C2351 VPWR.t767 VGND 0.02434f
C2352 VPWR.n961 VGND 0.02438f
C2353 VPWR.t221 VGND 0.02389f
C2354 VPWR.n963 VGND 0.02015f
C2355 VPWR.t769 VGND 0.02389f
C2356 VPWR.n964 VGND 0.02022f
C2357 VPWR.t223 VGND 0.02186f
C2358 VPWR.n966 VGND 0.02445f
C2359 VPWR.t771 VGND 0.02279f
C2360 VPWR.n967 VGND 0.02438f
C2361 VPWR.t330 VGND 0.28298f
C2362 VPWR.t125 VGND 1.39378f
C2363 VPWR.t239 VGND 0.38124f
C2364 VPWR.t67 VGND 17.4961f
C2365 VPWR.n969 VGND 0.22654f
C2366 VPWR.n970 VGND 0.01329f
C2367 VPWR.n971 VGND 0.03046f
C2368 VPWR.n972 VGND 2.76948f
C2369 VPWR.n974 VGND 0.50319f
C2370 VPWR.n975 VGND 0.2631f
C2371 VPWR.n976 VGND 0.16562f
C2372 VPWR.n977 VGND 0.02659f
C2373 VPWR.n978 VGND 0.01329f
C2374 VPWR.n979 VGND 0.56719f
.ends
