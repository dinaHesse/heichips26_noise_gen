** sch_path: /home/maliuluisik/heichips26_noise_gen/macros/heichips26_digital_project/macros/glitch/testbenches/xschem/glitch_tb_tran.sch
**.subckt glitch_tb_tran
VDD VDD GND {VDD}
ven enable GND pulse(0 1.5 100p 100p 100p 3n 6n)
x2 VDD GND enable vosc glitch_pex
C1 vosc GND 0.1f
**** begin user architecture code

.include ../../../netlist/xspice/glitch.xspice
.include ../../../netlist/pex/glitch_magic_pex_3.spice
.param VDD=1.5
.param temp=27
.options klu method=gear reltol=1e-4 abstol=1e-12 gmin=1e-15 rshunt=1e12
.control

set num_threads=8

*save all

* User Constants
let tstop = 14n
let tstep = 30p

* Operating Point Analysis
op
remzerovec
write glitch_tb_tran.raw
set appendwrite

* Transient Analysis
tran $&tstep $&tstop
* uic
write glitch_tb_tran.raw

plot v(enable) v(vosc)
plot i(VDD)

meas tran t_rise1 when v(vosc)=0.75 rise=3
meas tran t_rise2 when v(vosc)=0.75 rise=4
let T_osc = t_rise2 - t_rise1
let f_osc = 1/T_osc
print T_osc
print f_osc

* Writing Data
unset appendwrite
set wr_vecnames
set wr_singlescale
wrdata ../plot_simulations/data/glitch_tb_tran.txt enable vosc
*quit
.endc

.lib cornerMOSlv.lib mos_tt
.lib cornerMOShv.lib mos_tt
.lib cornerRES.lib res_typ
.lib cornerDIO.lib dio_tt

**** end user architecture code
**.ends
.GLOBAL GND
.GLOBAL VDD
.end
