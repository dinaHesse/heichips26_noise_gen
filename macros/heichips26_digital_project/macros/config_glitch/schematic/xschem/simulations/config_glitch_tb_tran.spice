** sch_path: /home/maliuluisik/heichips26_noise_gen/macros/heichips26_digital_project/macros/config_glitch/testbenches/xschem/config_glitch_tb_tran.sch
**.subckt config_glitch_tb_tran
VDD VDD GND {VDD}
ven enable GND pulse(0 1.5 100p 100p 100p 3n 6n)
C1[7] vosc[7] GND 0.1f
C1[6] vosc[6] GND 0.1f
C1[5] vosc[5] GND 0.1f
C1[4] vosc[4] GND 0.1f
C1[3] vosc[3] GND 0.1f
C1[2] vosc[2] GND 0.1f
C1[1] vosc[1] GND 0.1f
C1[0] vosc[0] GND 0.1f
x1 VDD GND enable vosc[7] vosc[6] vosc[5] vosc[4] vosc[3] vosc[2] vosc[1] vosc[0] VDD VDD GND VDD VDD VDD VDD config_glitch_pex
**** begin user architecture code

.include ../../../netlist/xspice/config_glitch.xspice
.include ../../../netlist/pex/config_glitch_magic_pex_3.spice
.param VDD=1.5
.param temp=27
.options klu method=gear reltol=1e-4 abstol=1e-12 gmin=1e-15 rshunt=1e12
.control

set num_threads=8

*save all

* User Constants
let tstop = 7n
let tstep = 30p

* Operating Point Analysis
op
remzerovec
write config_glitch_tb_tran.raw
set appendwrite

* Transient Analysis
tran $&tstep $&tstop
* uic
write config_glitch_tb_tran.raw

plot v(enable)  v(vosc[0]) v(vosc[1])
plot vosc[2]
plot v(vosc[7:0])

plot i(VDD)

meas tran t_rise1 when v(vosc[0])=0.75 rise=3
meas tran t_rise2 when v(vosc[0])=0.75 rise=4
let T_osc = t_rise2 - t_rise1
let f_osc = 1/T_osc
print T_osc
print f_osc

* Writing Data
unset appendwrite
set wr_vecnames
set wr_singlescale
wrdata ../plot_simulations/data/config_glitch_tb_tran.txt enable vosc[7:0]
*quit
.endc

.lib cornerMOSlv.lib mos_tt
.lib cornerMOShv.lib mos_tt
.lib cornerRES.lib res_typ
.lib cornerDIO.lib dio_tt

**** end user architecture code
**.ends
.GLOBAL GND
.GLOBAL VDD
.end
