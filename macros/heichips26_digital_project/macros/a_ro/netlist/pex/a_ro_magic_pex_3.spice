* PEX produced on Thu Oct  1 10:07:26 PM CEST 2026 using scripts/sak-pex.sh with m=3 and s=1 (extresist threshold=10000 mOhm, minres=1000 mOhm, mindelay=1 ps)
* NGSPICE file created from a_ro_pex.ext - technology: ihp-sg13cmos5l

.subckt a_ro_pex VPWR VGND enable osc osc_tap[0] osc_tap[1] osc_tap[2]
+ osc_tap[3] osc_tap[4] osc_tap[5] osc_tap[6] osc_tap[7] invsel[0] invsel[1]
+ invsel[2] invsel[3] invsel[4] invsel[5]
X0 sg13cmos5l_inv_1_473.Y sg13cmos5l_inv_1_663.Y VGND.t199 VGND.t523 sg13_lv_nmos ad=0.2516p pd=2.16u as=0.2516p ps=2.16u w=0.74u l=0.13u
X1 sg13cmos5l_inv_1_65.A sg13cmos5l_inv_1_1011.A VPWR.t319 VPWR.t8 sg13_lv_pmos ad=0.3808p pd=2.92u as=0.3808p ps=2.92u w=1.12u l=0.13u
X2 sg13cmos5l_inv_1_981.A sg13cmos5l_inv_1_65.Y VPWR.t733 VPWR.t11 sg13_lv_pmos ad=0.3808p pd=2.92u as=0.3808p ps=2.92u w=1.12u l=0.13u
X3 VPWR.t770 sg13cmos5l_inv_1_105.A sg13cmos5l_inv_1_105.Y VPWR.t0 sg13_lv_pmos ad=0.3808p pd=2.92u as=0.3808p ps=2.92u w=1.12u l=0.13u
X4 sg13cmos5l_inv_1_186.A sg13cmos5l_inv_1_213.Y VPWR.t512 VPWR.t49 sg13_lv_pmos ad=0.3808p pd=2.92u as=0.3808p ps=2.92u w=1.12u l=0.13u
X5 sg13cmos5l_inv_1_142.A sg13cmos5l_inv_1_186.Y VGND.t335 VGND.t1233 sg13_lv_nmos ad=0.2516p pd=2.16u as=0.2516p ps=2.16u w=0.74u l=0.13u
X6 VGND.t191 sg13cmos5l_nand2_1_1.B sg13cmos5l_nor3_1_0.Y VGND.t4 sg13_lv_nmos ad=0.2618p pd=2.22u as=0.1694p ps=1.21u w=0.77u l=0.13u
X7 sg13cmos5l_inv_1_500.Y sg13cmos5l_inv_1_502.Y VGND.t147 VGND.t146 sg13_lv_nmos ad=0.2516p pd=2.16u as=0.2516p ps=2.16u w=0.74u l=0.13u
X8 sg13cmos5l_inv_1_241.A sg13cmos5l_inv_1_344.Y VGND.t117 VGND.t11 sg13_lv_nmos ad=0.2516p pd=2.16u as=0.2516p ps=2.16u w=0.74u l=0.13u
X9 VPWR.t1384 sg13cmos5l_inv_1_848.Y sg13cmos5l_inv_1_836.A VPWR.t39 sg13_lv_pmos ad=0.3808p pd=2.92u as=0.3808p ps=2.92u w=1.12u l=0.13u
X10 VGND.t1513 VPWR.t1599 VGND.t1227 VGND.t1512 sg13_lv_nmos ad=0.1428p pd=1.52u as=0 ps=0 w=0.42u l=1u
X11 sg13cmos5l_inv_1_816.Y sg13cmos5l_inv_1_816.A VPWR.t275 VPWR.t21 sg13_lv_pmos ad=0.3808p pd=2.92u as=0.3808p ps=2.92u w=1.12u l=0.13u
X12 VPWR.t1469 VGND.t3 VPWR.t1468 VPWR.t26 sg13_lv_pmos ad=0.34p pd=2.68u as=0 ps=0 w=1u l=1u
X13 sg13cmos5l_inv_1_101.Y sg13cmos5l_inv_1_1010.Y VGND.t373 VGND.t424 sg13_lv_nmos ad=0.2516p pd=2.16u as=0.2516p ps=2.16u w=0.74u l=0.13u
X14 VGND.t16 sg13cmos5l_inv_1_184.A sg13cmos5l_inv_1_184.Y VGND.t11 sg13_lv_nmos ad=0.2516p pd=2.16u as=0.2516p ps=2.16u w=0.74u l=0.13u
X15 VGND.t3 sg13cmos5l_inv_1_908.A sg13cmos5l_inv_1_905.A VGND.t936 sg13_lv_nmos ad=0.2516p pd=2.16u as=0.2516p ps=2.16u w=0.74u l=0.13u
X16 VPWR.t1237 sg13cmos5l_mux2_1_4.S a_9758_3168# VPWR.t8 sg13_lv_pmos ad=0.253p pd=1.53u as=0.3325p ps=1.665u w=1u l=0.13u
X17 VGND.t508 sg13cmos5l_inv_1_980.A sg13cmos5l_inv_1_964.A VGND.t4 sg13_lv_nmos ad=0.2516p pd=2.16u as=0.2516p ps=2.16u w=0.74u l=0.13u
X18 sg13cmos5l_inv_1_838.Y sg13cmos5l_inv_1_823.Y VGND.t69 VGND.t1326 sg13_lv_nmos ad=0.2516p pd=2.16u as=0.2516p ps=2.16u w=0.74u l=0.13u
X19 a_14360_11776# sg13cmos5l_buf_1_8.A.t3 a_14027_11654# VGND.t1434 sg13_lv_nmos ad=0.54188p pd=3.42u as=0.1216p ps=1.02u w=0.64u l=0.13u
X20 sg13cmos5l_inv_1_494.Y sg13cmos5l_inv_1_484.Y VGND.t188 VGND.t867 sg13_lv_nmos ad=0.2516p pd=2.16u as=0.2516p ps=2.16u w=0.74u l=0.13u
X21 a_14645_4211# a_13607_3898# a_14422_3898# VPWR.t49 sg13_lv_pmos ad=0.135p pd=1.27u as=0.4425p ps=1.885u w=1u l=0.13u
X22 sg13cmos5l_inv_1_548.Y sg13cmos5l_inv_1_545.Y VGND.t49 VGND.t319 sg13_lv_nmos ad=0.2516p pd=2.16u as=0.2516p ps=2.16u w=0.74u l=0.13u
X23 VPWR.t519 sg13cmos5l_inv_1_931.A sg13cmos5l_inv_1_931.Y VPWR.t5 sg13_lv_pmos ad=0.3808p pd=2.92u as=0.3808p ps=2.92u w=1.12u l=0.13u
X24 sg13cmos5l_inv_1_108.Y sg13cmos5l_mux4_1_16.A2 VPWR.t501 VPWR.t0 sg13_lv_pmos ad=0.3808p pd=2.92u as=0.3808p ps=2.92u w=1.12u l=0.13u
X25 sg13cmos5l_inv_1_994.Y sg13cmos5l_inv_1_994.A VGND.t1058 VGND.t1057 sg13_lv_nmos ad=0.2516p pd=2.16u as=0.2516p ps=2.16u w=0.74u l=0.13u
X26 sg13cmos5l_inv_1_1.Y sg13cmos5l_inv_1_0.Y VGND.t64 VGND.t407 sg13_lv_nmos ad=0.2516p pd=2.16u as=0.2516p ps=2.16u w=0.74u l=0.13u
X27 VPWR.t854 sg13cmos5l_inv_1_910.A sg13cmos5l_inv_1_909.A VPWR.t26 sg13_lv_pmos ad=0.3808p pd=2.92u as=0.3808p ps=2.92u w=1.12u l=0.13u
X28 sg13cmos5l_inv_1_83.Y sg13cmos5l_inv_1_88.Y VGND.t78 VGND.t1286 sg13_lv_nmos ad=0.2516p pd=2.16u as=0.2516p ps=2.16u w=0.74u l=0.13u
X29 VGND.t76 a_8123_8472# a_8560_8434# VGND.t890 sg13_lv_nmos ad=0.148p pd=1.14u as=0.3367p ps=1.65u w=0.74u l=0.13u
X30 sg13cmos5l_inv_1_898.Y sg13cmos5l_inv_1_898.A VGND.t3 VGND.t456 sg13_lv_nmos ad=0.2516p pd=2.16u as=0.2516p ps=2.16u w=0.74u l=0.13u
X31 VPWR.t243 VGND.t88 VPWR.t242 VPWR.t21 sg13_lv_pmos ad=0.34p pd=2.68u as=0 ps=0 w=1u l=1u
X32 VPWR.t411 sg13cmos5l_inv_1_258.A sg13cmos5l_inv_1_257.A VPWR.t11 sg13_lv_pmos ad=0.3808p pd=2.92u as=0.3808p ps=2.92u w=1.12u l=0.13u
X33 sg13cmos5l_mux4_1_2.A2 sg13cmos5l_inv_1_31.Y VPWR.t269 VPWR.t49 sg13_lv_pmos ad=0.3808p pd=2.92u as=0.3808p ps=2.92u w=1.12u l=0.13u
X34 sg13cmos5l_inv_1_280.Y sg13cmos5l_inv_1_279.Y VGND.t111 VGND.t1441 sg13_lv_nmos ad=0.2516p pd=2.16u as=0.2516p ps=2.16u w=0.74u l=0.13u
X35 VGND.t52 sg13cmos5l_inv_1_294.Y sg13cmos5l_inv_1_297.Y VGND.t305 sg13_lv_nmos ad=0.2516p pd=2.16u as=0.2516p ps=2.16u w=0.74u l=0.13u
X36 sg13cmos5l_inv_1_881.A sg13cmos5l_inv_1_920.A VGND.t229 VGND.t1415 sg13_lv_nmos ad=0.2516p pd=2.16u as=0.2516p ps=2.16u w=0.74u l=0.13u
X37 VPWR.t130 VGND.t155 VPWR.t129 VPWR.t26 sg13_lv_pmos ad=0.34p pd=2.68u as=0 ps=0 w=1u l=1u
X38 sg13cmos5l_mux4_1_13.A3 sg13cmos5l_inv_1_875.Y VPWR.t878 VPWR.t42 sg13_lv_pmos ad=0.3808p pd=2.92u as=0.3808p ps=2.92u w=1.12u l=0.13u
X39 sg13cmos5l_inv_1_902.Y sg13cmos5l_inv_1_903.Y VPWR.t1257 VPWR.t26 sg13_lv_pmos ad=0.3808p pd=2.92u as=0.3808p ps=2.92u w=1.12u l=0.13u
X40 sg13cmos5l_inv_1_215.Y sg13cmos5l_inv_1_106.Y VPWR.t1 VPWR.t0 sg13_lv_pmos ad=0.3808p pd=2.92u as=0.3808p ps=2.92u w=1.12u l=0.13u
X41 VGND.t10 sg13cmos5l_inv_1_930.A sg13cmos5l_inv_1_931.A VGND.t150 sg13_lv_nmos ad=0.2516p pd=2.16u as=0.2516p ps=2.16u w=0.74u l=0.13u
X42 sg13cmos5l_inv_1_714.A sg13cmos5l_inv_1_726.A VPWR.t441 VPWR.t2 sg13_lv_pmos ad=0.3808p pd=2.92u as=0.3808p ps=2.92u w=1.12u l=0.13u
X43 sg13cmos5l_buf_1_10.A a_808_4656# VPWR.t783 VPWR.t49 sg13_lv_pmos ad=0.42p pd=2.99u as=0.2114p ps=1.54u w=1.12u l=0.13u
X44 VGND.t21 sg13cmos5l_inv_1_2.A sg13cmos5l_inv_1_2.Y VGND.t1460 sg13_lv_nmos ad=0.2516p pd=2.16u as=0.2516p ps=2.16u w=0.74u l=0.13u
X45 VGND.t866 sg13cmos5l_inv_1_525.A a_4052_12606# VGND.t907 sg13_lv_nmos ad=0.1824p pd=1.21u as=0.2304p ps=1.36u w=0.64u l=0.13u
X46 VGND.t199 sg13cmos5l_inv_1_487.A sg13cmos5l_inv_1_677.A VGND.t1119 sg13_lv_nmos ad=0.2516p pd=2.16u as=0.2516p ps=2.16u w=0.74u l=0.13u
X47 sg13cmos5l_inv_1_285.Y sg13cmos5l_inv_1_287.Y VPWR.t847 VPWR.t8 sg13_lv_pmos ad=0.3808p pd=2.92u as=0.3808p ps=2.92u w=1.12u l=0.13u
X48 VGND.t69 sg13cmos5l_inv_1_834.Y sg13cmos5l_inv_1_824.A VGND.t316 sg13_lv_nmos ad=0.2516p pd=2.16u as=0.2516p ps=2.16u w=0.74u l=0.13u
X49 sg13cmos5l_buf_1_23.X a_18664_16028# VPWR.t438 VPWR.t42 sg13_lv_pmos ad=0.42p pd=2.99u as=0.2114p ps=1.54u w=1.12u l=0.13u
X50 sg13cmos5l_inv_1_166.A sg13cmos5l_inv_1_958.Y VPWR.t596 VPWR.t29 sg13_lv_pmos ad=0.3808p pd=2.92u as=0.3808p ps=2.92u w=1.12u l=0.13u
X51 VPWR.t164 VGND.t23 VPWR.t163 VPWR.t39 sg13_lv_pmos ad=0.34p pd=2.68u as=0 ps=0 w=1u l=1u
X52 a_7414_12970# sg13cmos5l_mux4_1_5.S0.t6 a_7333_13237# VPWR.t26 sg13_lv_pmos ad=0.4425p pd=1.885u as=0.20762p ps=1.605u w=1u l=0.13u
X53 sg13cmos5l_inv_1_109.Y sg13cmos5l_inv_1_108.Y VGND.t354 VGND.t963 sg13_lv_nmos ad=0.2516p pd=2.16u as=0.2516p ps=2.16u w=0.74u l=0.13u
X54 sg13cmos5l_inv_1_166.Y sg13cmos5l_inv_1_166.A VGND.t128 VGND.t359 sg13_lv_nmos ad=0.2516p pd=2.16u as=0.2516p ps=2.16u w=0.74u l=0.13u
X55 VGND.t100 sg13cmos5l_inv_1_557.A sg13cmos5l_inv_1_557.Y VGND.t22 sg13_lv_nmos ad=0.2516p pd=2.16u as=0.2516p ps=2.16u w=0.74u l=0.13u
X56 VPWR.t1501 sg13cmos5l_a22oi_1_0.A2 a_8383_12192# VPWR.t2 sg13_lv_pmos ad=0.3808p pd=2.92u as=0.2744p ps=1.61u w=1.12u l=0.13u
X57 VGND.t315 sg13cmos5l_inv_1_702.Y sg13cmos5l_inv_1_715.Y VGND.t625 sg13_lv_nmos ad=0.2516p pd=2.16u as=0.2516p ps=2.16u w=0.74u l=0.13u
X58 sg13cmos5l_inv_1_504.A sg13cmos5l_inv_1_505.Y VPWR.t341 VPWR.t5 sg13_lv_pmos ad=0.3808p pd=2.92u as=0.3808p ps=2.92u w=1.12u l=0.13u
X59 a_4357_7731# sg13cmos5l_mux4_1_6.A2 VPWR.t1072 VPWR.t14 sg13_lv_pmos ad=0.20762p pd=1.605u as=0.29275p ps=1.785u w=1u l=0.13u
X60 VGND.t23 sg13cmos5l_inv_1_827.A sg13cmos5l_inv_1_827.Y VGND.t22 sg13_lv_nmos ad=0.2516p pd=2.16u as=0.2516p ps=2.16u w=0.74u l=0.13u
X61 a_4141_12267# a_3623_12606# a_3934_12606# VPWR.t2 sg13_lv_pmos ad=0.16p pd=1.32u as=0.19p ps=1.38u w=1u l=0.13u
X62 VGND.t140 sg13cmos5l_inv_1_570.A sg13cmos5l_mux4_1_10.A2 VGND.t22 sg13_lv_nmos ad=0.2516p pd=2.16u as=0.2516p ps=2.16u w=0.74u l=0.13u
X63 VGND.t49 sg13cmos5l_inv_1_553.Y sg13cmos5l_inv_1_543.Y VGND.t50 sg13_lv_nmos ad=0.2516p pd=2.16u as=0.2516p ps=2.16u w=0.74u l=0.13u
X64 VGND.t207 sg13cmos5l_inv_1_582.A sg13cmos5l_inv_1_581.A VGND.t743 sg13_lv_nmos ad=0.2516p pd=2.16u as=0.2516p ps=2.16u w=0.74u l=0.13u
X65 VPWR.t603 sg13cmos5l_inv_1_171.A sg13cmos5l_inv_1_171.Y VPWR.t14 sg13_lv_pmos ad=0.3808p pd=2.92u as=0.3808p ps=2.92u w=1.12u l=0.13u
X66 VGND.t1505 VPWR.t1602 VGND.t747 VGND.t1506 sg13_lv_nmos ad=79.8f pd=0.8u as=0 ps=0 w=0.42u l=1u
X67 VPWR.t1214 sg13cmos5l_inv_1_583.A sg13cmos5l_inv_1_684.A VPWR.t21 sg13_lv_pmos ad=0.3808p pd=2.92u as=0.3808p ps=2.92u w=1.12u l=0.13u
X68 sg13cmos5l_inv_1_1004.Y sg13cmos5l_inv_1_400.Y VPWR.t961 VPWR.t14 sg13_lv_pmos ad=0.3808p pd=2.92u as=0.3808p ps=2.92u w=1.12u l=0.13u
X69 sg13cmos5l_inv_1_394.Y sg13cmos5l_inv_1_394.A VPWR.t834 VPWR.t14 sg13_lv_pmos ad=0.3808p pd=2.92u as=0.3808p ps=2.92u w=1.12u l=0.13u
X70 VGND.t342 sg13cmos5l_inv_1_356.A sg13cmos5l_inv_1_356.Y VGND.t881 sg13_lv_nmos ad=0.2516p pd=2.16u as=0.2516p ps=2.16u w=0.74u l=0.13u
X71 sg13cmos5l_inv_1_858.Y sg13cmos5l_inv_1_857.Y VPWR.t444 VPWR.t42 sg13_lv_pmos ad=0.3808p pd=2.92u as=0.3808p ps=2.92u w=1.12u l=0.13u
X72 VPWR.t1031 sg13cmos5l_mux4_1_12.A3 sg13cmos5l_inv_1_758.A VPWR.t26 sg13_lv_pmos ad=0.3808p pd=2.92u as=0.3808p ps=2.92u w=1.12u l=0.13u
X73 VPWR.t840 sg13cmos5l_mux4_1_15.X a_15475_11725# VPWR.t2 sg13_lv_pmos ad=0.22315p pd=1.555u as=0.415p ps=1.83u w=1u l=0.13u
X74 sg13cmos5l_inv_1_399.Y sg13cmos5l_inv_1_398.Y VGND.t354 VGND.t887 sg13_lv_nmos ad=0.2516p pd=2.16u as=0.2516p ps=2.16u w=0.74u l=0.13u
X75 sg13cmos5l_inv_1_579.Y sg13cmos5l_inv_1_625.Y VGND.t46 VGND.t1190 sg13_lv_nmos ad=0.2516p pd=2.16u as=0.2516p ps=2.16u w=0.74u l=0.13u
X76 sg13cmos5l_inv_1_391.A sg13cmos5l_inv_1_407.Y VGND.t76 VGND.t1174 sg13_lv_nmos ad=0.2516p pd=2.16u as=0.2516p ps=2.16u w=0.74u l=0.13u
X77 VPWR.t492 sg13cmos5l_inv_1_356.Y sg13cmos5l_inv_1_366.A VPWR.t29 sg13_lv_pmos ad=0.3808p pd=2.92u as=0.3808p ps=2.92u w=1.12u l=0.13u
X78 sg13cmos5l_inv_1_925.A sg13cmos5l_inv_1_475.Y VGND.t199 VGND.t872 sg13_lv_nmos ad=0.2516p pd=2.16u as=0.2516p ps=2.16u w=0.74u l=0.13u
X79 sg13cmos5l_inv_1_56.Y sg13cmos5l_inv_1_60.Y VPWR.t1155 VPWR.t11 sg13_lv_pmos ad=0.3808p pd=2.92u as=0.3808p ps=2.92u w=1.12u l=0.13u
X80 sg13cmos5l_inv_1_981.A sg13cmos5l_inv_1_65.Y VGND.t373 VGND.t424 sg13_lv_nmos ad=0.2516p pd=2.16u as=0.2516p ps=2.16u w=0.74u l=0.13u
X81 VPWR.t727 sg13cmos5l_inv_1_324.Y a_4661_3149# VPWR.t8 sg13_lv_pmos ad=0.34p pd=2.68u as=0.135p ps=1.27u w=1u l=0.13u
X82 VGND.t478 sg13cmos5l_mux4_1_12.A1 a_14036_12606# VGND.t519 sg13_lv_nmos ad=0.1824p pd=1.21u as=0.2304p ps=1.36u w=0.64u l=0.13u
X83 VPWR.t1490 sg13cmos5l_inv_1_38.Y sg13cmos5l_inv_1_16.A VPWR.t8 sg13_lv_pmos ad=0.3808p pd=2.92u as=0.3808p ps=2.92u w=1.12u l=0.13u
X84 sg13cmos5l_inv_1_345.A sg13cmos5l_inv_1_439.Y VGND.t12 VGND.t11 sg13_lv_nmos ad=0.2516p pd=2.16u as=0.2516p ps=2.16u w=0.74u l=0.13u
X85 sg13cmos5l_inv_1_808.A sg13cmos5l_inv_1_806.Y VGND.t567 VGND.t22 sg13_lv_nmos ad=0.2516p pd=2.16u as=0.2516p ps=2.16u w=0.74u l=0.13u
X86 VPWR.t1180 sg13cmos5l_inv_1_1007.Y sg13cmos5l_inv_1_474.Y VPWR.t5 sg13_lv_pmos ad=0.3808p pd=2.92u as=0.3808p ps=2.92u w=1.12u l=0.13u
X87 sg13cmos5l_inv_1_13.Y sg13cmos5l_inv_1_20.Y VGND.t256 VGND.t276 sg13_lv_nmos ad=0.2516p pd=2.16u as=0.2516p ps=2.16u w=0.74u l=0.13u
X88 VGND.t470 VPWR.t1524 VGND.t470 VGND.t11 sg13_lv_nmos ad=0.1428p pd=1.52u as=0 ps=0 w=0.42u l=1u
X89 VGND.t5 sg13cmos5l_inv_1_973.Y sg13cmos5l_inv_1_944.Y VGND.t190 sg13_lv_nmos ad=0.2516p pd=2.16u as=0.2516p ps=2.16u w=0.74u l=0.13u
X90 sg13cmos5l_inv_1_55.Y sg13cmos5l_inv_1_46.Y VPWR.t685 VPWR.t8 sg13_lv_pmos ad=0.3808p pd=2.92u as=0.3808p ps=2.92u w=1.12u l=0.13u
X91 sg13cmos5l_inv_1_310.Y sg13cmos5l_inv_1_306.Y VPWR.t139 VPWR.t11 sg13_lv_pmos ad=0.3808p pd=2.92u as=0.3808p ps=2.92u w=1.12u l=0.13u
X92 VPWR.t626 sg13cmos5l_inv_1_980.A sg13cmos5l_inv_1_964.A VPWR.t29 sg13_lv_pmos ad=0.3808p pd=2.92u as=0.3808p ps=2.92u w=1.12u l=0.13u
X93 VGND.t263 sg13cmos5l_inv_1_534.A sg13cmos5l_inv_1_534.Y VGND.t416 sg13_lv_nmos ad=0.2516p pd=2.16u as=0.2516p ps=2.16u w=0.74u l=0.13u
X94 VGND.t28 sg13cmos5l_inv_1_55.Y sg13cmos5l_inv_1_42.A VGND.t370 sg13_lv_nmos ad=0.2516p pd=2.16u as=0.2516p ps=2.16u w=0.74u l=0.13u
X95 sg13cmos5l_mux2_1_3.S sg13cmos5l_nor3_1_2.B VPWR.t1471 VPWR.t5 sg13_lv_pmos ad=0.3808p pd=2.92u as=0.3808p ps=2.92u w=1.12u l=0.13u
X96 VGND.t174 sg13cmos5l_inv_1_751.A sg13cmos5l_inv_1_749.A VGND.t1466 sg13_lv_nmos ad=0.2516p pd=2.16u as=0.2516p ps=2.16u w=0.74u l=0.13u
X97 VPWR.t1009 sg13cmos5l_inv_1_926.A sg13cmos5l_inv_1_926.Y VPWR.t5 sg13_lv_pmos ad=0.3808p pd=2.92u as=0.3808p ps=2.92u w=1.12u l=0.13u
X98 VGND.t88 sg13cmos5l_inv_1_902.Y sg13cmos5l_inv_1_889.A VGND.t931 sg13_lv_nmos ad=0.2516p pd=2.16u as=0.2516p ps=2.16u w=0.74u l=0.13u
X99 sg13cmos5l_inv_1_464.Y sg13cmos5l_inv_1_463.Y VPWR.t914 VPWR.t0 sg13_lv_pmos ad=0.3808p pd=2.92u as=0.3808p ps=2.92u w=1.12u l=0.13u
X100 sg13cmos5l_inv_1_542.A sg13cmos5l_inv_1_548.Y VGND.t49 VGND.t1187 sg13_lv_nmos ad=0.2516p pd=2.16u as=0.2516p ps=2.16u w=0.74u l=0.13u
X101 VPWR.t817 sg13cmos5l_inv_1_271.A sg13cmos5l_inv_1_270.A VPWR.t49 sg13_lv_pmos ad=0.3808p pd=2.92u as=0.3808p ps=2.92u w=1.12u l=0.13u
X102 sg13cmos5l_inv_1_359.Y sg13cmos5l_inv_1_366.Y VGND.t342 VGND.t959 sg13_lv_nmos ad=0.2516p pd=2.16u as=0.2516p ps=2.16u w=0.74u l=0.13u
X103 sg13cmos5l_inv_1_616.Y sg13cmos5l_inv_1_616.A VGND.t136 VGND.t671 sg13_lv_nmos ad=0.2516p pd=2.16u as=0.2516p ps=2.16u w=0.74u l=0.13u
X104 VPWR.t1341 sg13cmos5l_inv_1_975.A sg13cmos5l_inv_1_627.A VPWR.t42 sg13_lv_pmos ad=0.3808p pd=2.92u as=0.3808p ps=2.92u w=1.12u l=0.13u
X105 VPWR.t1208 sg13cmos5l_inv_1_427.A sg13cmos5l_inv_1_427.Y VPWR.t0 sg13_lv_pmos ad=0.3808p pd=2.92u as=0.3808p ps=2.92u w=1.12u l=0.13u
X106 sg13cmos5l_inv_1_473.Y sg13cmos5l_inv_1_663.Y VPWR.t640 VPWR.t5 sg13_lv_pmos ad=0.3808p pd=2.92u as=0.3808p ps=2.92u w=1.12u l=0.13u
X107 a_9260_9906# sg13cmos5l_buf_1_12.X VGND.t191 VGND.t190 sg13_lv_nmos ad=0.187p pd=1.78u as=0.14875p ps=1.16u w=0.55u l=0.13u
X108 a_7071_8434# sg13cmos5l_mux4_1_5.S0.t5 a_6934_8434# VGND.t858 sg13_lv_nmos ad=76.8f pd=0.88u as=0.1776p ps=1.195u w=0.64u l=0.13u
X109 sg13cmos5l_inv_1_604.Y sg13cmos5l_inv_1_605.Y VPWR.t1392 VPWR.t39 sg13_lv_pmos ad=0.3808p pd=2.92u as=0.3808p ps=2.92u w=1.12u l=0.13u
X110 VGND.t578 sg13cmos5l_mux4_1_14.A1 sg13cmos5l_inv_1_779.A VGND.t577 sg13_lv_nmos ad=0.2516p pd=2.16u as=0.2516p ps=2.16u w=0.74u l=0.13u
X111 VPWR.t741 sg13cmos5l_inv_1_37.A a_18664_3144# VPWR.t8 sg13_lv_pmos ad=0.2114p pd=1.54u as=0.2856p ps=2.36u w=0.84u l=0.13u
X112 sg13cmos5l_inv_1_500.Y sg13cmos5l_inv_1_502.Y VPWR.t342 VPWR.t5 sg13_lv_pmos ad=0.3808p pd=2.92u as=0.3808p ps=2.92u w=1.12u l=0.13u
X113 VGND.t76 VPWR.t1548 VGND.t76 VGND.t1584 sg13_lv_nmos ad=0.1428p pd=1.52u as=0 ps=0 w=0.42u l=1u
X114 a_14346_14482# sg13cmos5l_inv_1_884.Y VGND.t92 VGND.t91 sg13_lv_nmos ad=80f pd=0.89u as=0.1824p ps=1.21u w=0.64u l=0.13u
X115 sg13cmos5l_inv_1_252.Y sg13cmos5l_inv_1_252.A VPWR.t411 VPWR.t11 sg13_lv_pmos ad=0.3808p pd=2.92u as=0.3808p ps=2.92u w=1.12u l=0.13u
X116 sg13cmos5l_inv_1_623.Y sg13cmos5l_inv_1_624.Y VGND.t207 VGND.t627 sg13_lv_nmos ad=0.2516p pd=2.16u as=0.2516p ps=2.16u w=0.74u l=0.13u
X117 sg13cmos5l_inv_1_340.Y sg13cmos5l_inv_1_341.Y VPWR.t1363 VPWR.t0 sg13_lv_pmos ad=0.3808p pd=2.92u as=0.3808p ps=2.92u w=1.12u l=0.13u
X118 VPWR.t188 VGND.t335 VPWR.t187 VPWR.t14 sg13_lv_pmos ad=0.34p pd=2.68u as=0 ps=0 w=1u l=1u
X119 VPWR.t1478 VGND.t567 VPWR.t1477 VPWR.t42 sg13_lv_pmos ad=0.34p pd=2.68u as=0 ps=0 w=1u l=1u
X120 VPWR.t992 sg13cmos5l_inv_1_908.A sg13cmos5l_inv_1_905.A VPWR.t26 sg13_lv_pmos ad=0.3808p pd=2.92u as=0.3808p ps=2.92u w=1.12u l=0.13u
X121 VGND.t501 sg13cmos5l_inv_1_258.A sg13cmos5l_inv_1_257.A VGND.t1451 sg13_lv_nmos ad=0.2516p pd=2.16u as=0.2516p ps=2.16u w=0.74u l=0.13u
X122 VGND.t56 sg13cmos5l_inv_1_608.A sg13cmos5l_inv_1_608.Y VGND.t22 sg13_lv_nmos ad=0.2516p pd=2.16u as=0.2516p ps=2.16u w=0.74u l=0.13u
X123 sg13cmos5l_inv_1_892.A sg13cmos5l_mux4_1_14.A3 VPWR.t558 VPWR.t21 sg13_lv_pmos ad=0.3808p pd=2.92u as=0.3808p ps=2.92u w=1.12u l=0.13u
X124 a_8805_10240# sg13cmos5l_nor3_1_1.A VPWR.t1107 VPWR.t5 sg13_lv_pmos ad=0.2464p pd=1.56u as=0.3808p ps=2.92u w=1.12u l=0.13u
X125 sg13cmos5l_inv_1_494.Y sg13cmos5l_inv_1_484.Y VPWR.t926 VPWR.t5 sg13_lv_pmos ad=0.3808p pd=2.92u as=0.3808p ps=2.92u w=1.12u l=0.13u
X126 VGND.t92 sg13cmos5l_mux2_1_4.S.t4 a_14989_14488# VGND.t1473 sg13_lv_nmos ad=0.1543p pd=1.18u as=0.2304p ps=2u w=0.64u l=0.13u
X127 sg13cmos5l_inv_1_57.Y sg13cmos5l_inv_1_66.Y VPWR.t1189 VPWR.t11 sg13_lv_pmos ad=0.3808p pd=2.92u as=0.3808p ps=2.92u w=1.12u l=0.13u
X128 sg13cmos5l_inv_1_941.A sg13cmos5l_inv_1_1002.A VGND.t6 VGND.t190 sg13_lv_nmos ad=0.2516p pd=2.16u as=0.2516p ps=2.16u w=0.74u l=0.13u
X129 VPWR.t158 VGND.t435 VPWR.t157 VPWR.t8 sg13_lv_pmos ad=0.34p pd=2.68u as=0 ps=0 w=1u l=1u
X130 VGND.t149 sg13cmos5l_buf_1_27.X a_18856_9980# VGND.t685 sg13_lv_nmos ad=0.14875p pd=1.16u as=0.187p ps=1.78u w=0.55u l=0.13u
X131 sg13cmos5l_nor2b_1_0.A a_808_16028# VPWR.t307 VPWR.t42 sg13_lv_pmos ad=0.42p pd=2.99u as=0.2114p ps=1.54u w=1.12u l=0.13u
X132 VPWR.t343 sg13cmos5l_buf_1_27.X a_18856_9980# VPWR.t5 sg13_lv_pmos ad=0.2114p pd=1.54u as=0.2856p ps=2.36u w=0.84u l=0.13u
X133 a_9004_12216# sg13cmos5l_nor3_1_2.B sg13cmos5l_a22oi_1_0.A2 VPWR.t2 sg13_lv_pmos ad=0.1176p pd=1.33u as=0.3808p ps=2.92u w=1.12u l=0.13u
X134 sg13cmos5l_inv_1_845.Y sg13cmos5l_inv_1_844.Y VPWR.t1337 VPWR.t42 sg13_lv_pmos ad=0.3808p pd=2.92u as=0.3808p ps=2.92u w=1.12u l=0.13u
X135 a_4798_12970# sg13cmos5l_mux4_1_9.X a_4701_12970# VGND.t1124 sg13_lv_nmos ad=0.1628p pd=1.18u as=0.13135p ps=1.095u w=0.74u l=0.13u
X136 sg13cmos5l_inv_1_898.Y sg13cmos5l_inv_1_898.A VPWR.t582 VPWR.t26 sg13_lv_pmos ad=0.3808p pd=2.92u as=0.3808p ps=2.92u w=1.12u l=0.13u
X137 VGND.t54 sg13cmos5l_inv_1_322.A sg13cmos5l_inv_1_323.A VGND.t55 sg13_lv_nmos ad=0.2516p pd=2.16u as=0.2516p ps=2.16u w=0.74u l=0.13u
X138 sg13cmos5l_inv_1_114.A sg13cmos5l_inv_1_953.Y VGND.t8 VGND.t4 sg13_lv_nmos ad=0.2516p pd=2.16u as=0.2516p ps=2.16u w=0.74u l=0.13u
X139 a_8315_11752# sg13cmos5l_a21oi_1_0.B1 sg13cmos5l_a21oi_1_0.Y VPWR.t2 sg13_lv_pmos ad=0.2128p pd=1.5u as=0.3808p ps=2.92u w=1.12u l=0.13u
X140 VGND.t46 sg13cmos5l_inv_1_580.A sg13cmos5l_inv_1_582.A VGND.t62 sg13_lv_nmos ad=0.2516p pd=2.16u as=0.2516p ps=2.16u w=0.74u l=0.13u
X141 sg13cmos5l_inv_1_254.Y sg13cmos5l_inv_1_442.Y VGND.t240 VGND.t418 sg13_lv_nmos ad=0.2516p pd=2.16u as=0.2516p ps=2.16u w=0.74u l=0.13u
X142 sg13cmos5l_inv_1_614.A sg13cmos5l_inv_1_589.Y VGND.t44 VGND.t22 sg13_lv_nmos ad=0.2516p pd=2.16u as=0.2516p ps=2.16u w=0.74u l=0.13u
X143 VPWR.t1173 sg13cmos5l_inv_1_692.A sg13cmos5l_inv_1_690.A VPWR.t21 sg13_lv_pmos ad=0.3808p pd=2.92u as=0.3808p ps=2.92u w=1.12u l=0.13u
X144 sg13cmos5l_inv_1_596.Y sg13cmos5l_inv_1_585.Y VGND.t558 VGND.t562 sg13_lv_nmos ad=0.2516p pd=2.16u as=0.2516p ps=2.16u w=0.74u l=0.13u
X145 VPWR.t1354 sg13cmos5l_inv_1_575.Y sg13cmos5l_inv_1_573.A VPWR.t42 sg13_lv_pmos ad=0.3808p pd=2.92u as=0.3808p ps=2.92u w=1.12u l=0.13u
X146 sg13cmos5l_inv_1_847.Y sg13cmos5l_inv_1_846.Y VGND.t66 VGND.t67 sg13_lv_nmos ad=0.2516p pd=2.16u as=0.2516p ps=2.16u w=0.74u l=0.13u
X147 VGND.t128 sg13cmos5l_inv_1_171.A sg13cmos5l_inv_1_171.Y VGND.t481 sg13_lv_nmos ad=0.2516p pd=2.16u as=0.2516p ps=2.16u w=0.74u l=0.13u
X148 VPWR.t815 sg13cmos5l_inv_1_582.A sg13cmos5l_inv_1_581.A VPWR.t21 sg13_lv_pmos ad=0.3808p pd=2.92u as=0.3808p ps=2.92u w=1.12u l=0.13u
X149 VPWR.t679 sg13cmos5l_inv_1_276.A sg13cmos5l_inv_1_268.A VPWR.t49 sg13_lv_pmos ad=0.3808p pd=2.92u as=0.3808p ps=2.92u w=1.12u l=0.13u
X150 sg13cmos5l_inv_1_394.Y sg13cmos5l_inv_1_394.A VGND.t76 VGND.t768 sg13_lv_nmos ad=0.2516p pd=2.16u as=0.2516p ps=2.16u w=0.74u l=0.13u
X151 VPWR.t270 sg13cmos5l_inv_1_549.A sg13cmos5l_inv_1_545.A VPWR.t39 sg13_lv_pmos ad=0.3808p pd=2.92u as=0.3808p ps=2.92u w=1.12u l=0.13u
X152 VPWR.t116 VGND.t670 VPWR.t115 VPWR.t21 sg13_lv_pmos ad=0.19p pd=1.38u as=0 ps=0 w=1u l=1u
X153 sg13cmos5l_inv_1_579.Y sg13cmos5l_inv_1_625.Y VPWR.t1215 VPWR.t21 sg13_lv_pmos ad=0.3808p pd=2.92u as=0.3808p ps=2.92u w=1.12u l=0.13u
X154 VGND.t412 sg13cmos5l_inv_1_639.A sg13cmos5l_mux4_1_7.A3 VGND.t510 sg13_lv_nmos ad=0.2516p pd=2.16u as=0.2516p ps=2.16u w=0.74u l=0.13u
X155 VGND.t1529 VPWR.t1588 VGND.t866 VGND.t1530 sg13_lv_nmos ad=79.8f pd=0.8u as=0 ps=0 w=0.42u l=1u
X156 VPWR.t607 sg13cmos5l_inv_1_478.A sg13cmos5l_inv_1_478.Y VPWR.t26 sg13_lv_pmos ad=0.3808p pd=2.92u as=0.3808p ps=2.92u w=1.12u l=0.13u
X157 sg13cmos5l_inv_1_304.A sg13cmos5l_inv_1_283.A VPWR.t1121 VPWR.t8 sg13_lv_pmos ad=0.3808p pd=2.92u as=0.3808p ps=2.92u w=1.12u l=0.13u
X158 sg13cmos5l_inv_1_212.Y sg13cmos5l_inv_1_185.Y VPWR.t1046 VPWR.t49 sg13_lv_pmos ad=0.3808p pd=2.92u as=0.3808p ps=2.92u w=1.12u l=0.13u
X159 VPWR.t1445 sg13cmos5l_inv_1_989.A sg13cmos5l_inv_1_448.A VPWR.t49 sg13_lv_pmos ad=0.3808p pd=2.92u as=0.3808p ps=2.92u w=1.12u l=0.13u
X160 a_15489_9540# sg13cmos5l_mux2_1_4.S a_14998_9582# VGND.t640 sg13_lv_nmos ad=0.1216p pd=1.02u as=0.54188p ps=3.42u w=0.64u l=0.13u
X161 VGND.t92 sg13cmos5l_inv_1_913.A sg13cmos5l_inv_1_915.A VGND.t462 sg13_lv_nmos ad=0.2516p pd=2.16u as=0.2516p ps=2.16u w=0.74u l=0.13u
X162 VPWR.t570 sg13cmos5l_inv_1_683.A sg13cmos5l_inv_1_683.Y VPWR.t21 sg13_lv_pmos ad=0.3808p pd=2.92u as=0.3808p ps=2.92u w=1.12u l=0.13u
X163 VPWR.t336 sg13cmos5l_buf_1_9.A.t6 a_8653_16000# VPWR.t42 sg13_lv_pmos ad=0.34367p pd=1.775u as=0.34p ps=2.68u w=1u l=0.13u
X164 VGND.t428 sg13cmos5l_inv_1_37.A a_18664_3144# VGND.t1652 sg13_lv_nmos ad=0.14875p pd=1.16u as=0.187p ps=1.78u w=0.55u l=0.13u
X165 a_7905_13012# sg13cmos5l_buf_1_9.A.t3 a_7414_12970# VGND.t710 sg13_lv_nmos ad=0.1216p pd=1.02u as=0.54188p ps=3.42u w=0.64u l=0.13u
X166 sg13cmos5l_inv_1_321.A sg13cmos5l_inv_1_334.A VGND.t54 VGND.t348 sg13_lv_nmos ad=0.2516p pd=2.16u as=0.2516p ps=2.16u w=0.74u l=0.13u
X167 VGND.t43 sg13cmos5l_inv_1_241.Y sg13cmos5l_inv_1_69.A VGND.t1352 sg13_lv_nmos ad=0.2516p pd=2.16u as=0.2516p ps=2.16u w=0.74u l=0.13u
X168 a_4701_13264# sg13cmos5l_nor3_1_2.B VPWR.t1473 VPWR.t26 sg13_lv_pmos ad=0.3325p pd=1.665u as=0.253p ps=1.53u w=1u l=0.13u
X169 sg13cmos5l_inv_1_843.A sg13cmos5l_inv_1_841.Y VGND.t37 VGND.t22 sg13_lv_nmos ad=0.2516p pd=2.16u as=0.2516p ps=2.16u w=0.74u l=0.13u
X170 sg13cmos5l_inv_1_550.Y sg13cmos5l_inv_1_551.Y VGND.t558 VGND.t660 sg13_lv_nmos ad=0.2516p pd=2.16u as=0.2516p ps=2.16u w=0.74u l=0.13u
X171 VPWR.t662 sg13cmos5l_inv_1_308.A sg13cmos5l_inv_1_308.Y VPWR.t11 sg13_lv_pmos ad=0.3808p pd=2.92u as=0.3808p ps=2.92u w=1.12u l=0.13u
X172 VPWR.t1081 sg13cmos5l_mux2_1_3.S a_9659_7736# VPWR.t14 sg13_lv_pmos ad=0.253p pd=1.53u as=0.2856p ps=2.36u w=0.84u l=0.13u
X173 VPWR.t552 sg13cmos5l_inv_1_534.A sg13cmos5l_inv_1_534.Y VPWR.t21 sg13_lv_pmos ad=0.3808p pd=2.92u as=0.3808p ps=2.92u w=1.12u l=0.13u
X174 VGND.t939 sg13cmos5l_inv_1_446.A sg13cmos5l_inv_1_441.A VGND.t11 sg13_lv_nmos ad=0.2516p pd=2.16u as=0.2516p ps=2.16u w=0.74u l=0.13u
X175 sg13cmos5l_mux4_1_16.X a_9633_6516# VGND.t354 VGND.t1079 sg13_lv_nmos ad=0.2516p pd=2.16u as=0.1543p ps=1.18u w=0.74u l=0.13u
X176 sg13cmos5l_inv_1_717.A sg13cmos5l_inv_1_729.Y VPWR.t775 VPWR.t2 sg13_lv_pmos ad=0.3808p pd=2.92u as=0.3808p ps=2.92u w=1.12u l=0.13u
X177 a_14634_15630# sg13cmos5l_inv_1_874.Y VGND.t171 VGND.t598 sg13_lv_nmos ad=80f pd=0.89u as=0.1824p ps=1.21u w=0.64u l=0.13u
X178 VGND.t54 VPWR.t1519 VGND.t54 VGND.t1621 sg13_lv_nmos ad=0.1428p pd=1.52u as=0 ps=0 w=0.42u l=1u
X179 a_8086_15994# a_8653_16000# a_8577_16036# VPWR.t42 sg13_lv_pmos ad=0.34p pd=2.68u as=0.2225p ps=1.445u w=1u l=0.13u
X180 sg13cmos5l_inv_1_925.A sg13cmos5l_inv_1_475.Y VPWR.t931 VPWR.t5 sg13_lv_pmos ad=0.3808p pd=2.92u as=0.3808p ps=2.92u w=1.12u l=0.13u
X181 VGND.t197 sg13cmos5l_inv_1_975.A sg13cmos5l_inv_1_627.A VGND.t22 sg13_lv_nmos ad=0.2516p pd=2.16u as=0.2516p ps=2.16u w=0.74u l=0.13u
X182 sg13cmos5l_inv_1_162.Y sg13cmos5l_inv_1_162.A VGND.t128 VGND.t359 sg13_lv_nmos ad=0.2516p pd=2.16u as=0.2516p ps=2.16u w=0.74u l=0.13u
X183 sg13cmos5l_inv_1_544.Y sg13cmos5l_inv_1_541.Y VPWR.t1368 VPWR.t39 sg13_lv_pmos ad=0.3808p pd=2.92u as=0.3808p ps=2.92u w=1.12u l=0.13u
X184 VPWR.t359 sg13cmos5l_buf_1_9.A.t5 a_13895_15630# VPWR.t21 sg13_lv_pmos ad=0.22315p pd=1.555u as=0.34p ps=2.68u w=1u l=0.13u
X185 sg13cmos5l_inv_1_15.Y sg13cmos5l_inv_1_220.Y VPWR.t801 VPWR.t11 sg13_lv_pmos ad=0.3808p pd=2.92u as=0.3808p ps=2.92u w=1.12u l=0.13u
X186 a_18764_5370# sg13cmos5l_inv_1_217.A VGND.t214 VGND.t11 sg13_lv_nmos ad=0.187p pd=1.78u as=0.14875p ps=1.16u w=0.55u l=0.13u
X187 sg13cmos5l_inv_1_668.A sg13cmos5l_inv_1_689.Y VGND.t527 VGND.t1429 sg13_lv_nmos ad=0.2516p pd=2.16u as=0.2516p ps=2.16u w=0.74u l=0.13u
X188 a_15275_7644# a_15419_8040# a_15608_7680# VPWR.t14 sg13_lv_pmos ad=0.2225p pd=1.445u as=0.34p ps=2.68u w=1u l=0.13u
X189 a_14998_9582# a_15565_9466# a_15489_9540# VPWR.t29 sg13_lv_pmos ad=0.34p pd=2.68u as=0.2225p ps=1.445u w=1u l=0.13u
X190 sg13cmos5l_inv_1_893.Y sg13cmos5l_inv_1_892.Y VGND.t229 VGND.t450 sg13_lv_nmos ad=0.2516p pd=2.16u as=0.2516p ps=2.16u w=0.74u l=0.13u
X191 sg13cmos5l_inv_1_790.Y sg13cmos5l_inv_1_789.Y VPWR.t1309 VPWR.t42 sg13_lv_pmos ad=0.3808p pd=2.92u as=0.3808p ps=2.92u w=1.12u l=0.13u
X192 sg13cmos5l_inv_1_220.A sg13cmos5l_inv_1_216.Y VGND.t292 VGND.t725 sg13_lv_nmos ad=0.2516p pd=2.16u as=0.2516p ps=2.16u w=0.74u l=0.13u
X193 VPWR.t536 sg13cmos5l_inv_1_99.Y sg13cmos5l_inv_1_77.Y VPWR.t49 sg13_lv_pmos ad=0.3808p pd=2.92u as=0.3808p ps=2.92u w=1.12u l=0.13u
X194 a_7905_13012# sg13cmos5l_buf_1_9.A.t3 a_6910_12970# VPWR.t26 sg13_lv_pmos ad=0.2225p pd=1.445u as=0.34p ps=2.68u w=1u l=0.13u
X195 VPWR.t1179 sg13cmos5l_inv_1_739.A sg13cmos5l_inv_1_740.A VPWR.t26 sg13_lv_pmos ad=0.3808p pd=2.92u as=0.3808p ps=2.92u w=1.12u l=0.13u
X196 VGND.t191 sg13cmos5l_mux2_1_4.X sg13cmos5l_nor3_1_0.Y VGND.t4 sg13_lv_nmos ad=0.1463p pd=1.15u as=0.2618p ps=2.22u w=0.77u l=0.13u
X197 a_15834_3898# a_15768_4088# VGND.t435 VGND.t525 sg13_lv_nmos ad=0.3367p pd=1.65u as=0.148p ps=1.14u w=0.74u l=0.13u
X198 VPWR.t1242 sg13cmos5l_inv_1_826.Y sg13cmos5l_mux4_1_14.A1 VPWR.t39 sg13_lv_pmos ad=0.3808p pd=2.92u as=0.3808p ps=2.92u w=1.12u l=0.13u
X199 VGND.t174 sg13cmos5l_nor3_1_1.A sg13cmos5l_a22oi_1_0.A2 VGND.t1071 sg13_lv_nmos ad=0.2516p pd=2.16u as=0.1406p ps=1.12u w=0.74u l=0.13u
X200 VPWR.t951 sg13cmos5l_inv_1_759.A sg13cmos5l_inv_1_987.A VPWR.t2 sg13_lv_pmos ad=0.3808p pd=2.92u as=0.3808p ps=2.92u w=1.12u l=0.13u
X201 sg13cmos5l_inv_1_780.A sg13cmos5l_inv_1_779.Y VGND.t578 VGND.t580 sg13_lv_nmos ad=0.2516p pd=2.16u as=0.2516p ps=2.16u w=0.74u l=0.13u
X202 sg13cmos5l_inv_1_865.Y sg13cmos5l_inv_1_792.Y VPWR.t853 VPWR.t42 sg13_lv_pmos ad=0.3808p pd=2.92u as=0.3808p ps=2.92u w=1.12u l=0.13u
X203 VGND.t201 sg13cmos5l_inv_1_412.A sg13cmos5l_inv_1_411.A VGND.t457 sg13_lv_nmos ad=0.2516p pd=2.16u as=0.2516p ps=2.16u w=0.74u l=0.13u
X204 a_6910_12970# a_6599_12970# a_6836_12970# VGND.t749 sg13_lv_nmos ad=0.1472p pd=1.1u as=76.8f ps=0.88u w=0.64u l=0.13u
X205 VPWR.t638 sg13cmos5l_buf_1_4.X a_18856_7680# VPWR.t14 sg13_lv_pmos ad=0.2114p pd=1.54u as=0.2856p ps=2.36u w=0.84u l=0.13u
X206 sg13cmos5l_buf_1_27.X a_18664_9192# VPWR.t432 VPWR.t29 sg13_lv_pmos ad=0.42p pd=2.99u as=0.2114p ps=1.54u w=1.12u l=0.13u
X207 a_13831_4165# sg13cmos5l_inv_1_85.A VPWR.t302 VPWR.t49 sg13_lv_pmos ad=0.415p pd=1.83u as=0.22315p ps=1.555u w=1u l=0.13u
X208 sg13cmos5l_mux4_1_16.X a_9633_6516# VPWR.t744 VPWR.t0 sg13_lv_pmos ad=0.3808p pd=2.92u as=0.34367p ps=1.775u w=1.12u l=0.13u
X209 VGND.t37 sg13cmos5l_inv_1_843.A sg13cmos5l_inv_1_843.Y VGND.t22 sg13_lv_nmos ad=0.2516p pd=2.16u as=0.2516p ps=2.16u w=0.74u l=0.13u
X210 a_9432_3406# sg13cmos5l_mux2_1_4.S VPWR.t1237 VPWR.t8 sg13_lv_pmos ad=0.2856p pd=2.36u as=0.253p ps=1.53u w=0.84u l=0.13u
X211 VPWR.t399 sg13cmos5l_inv_1_235.A sg13cmos5l_inv_1_235.Y VPWR.t49 sg13_lv_pmos ad=0.3808p pd=2.92u as=0.3808p ps=2.92u w=1.12u l=0.13u
X212 VGND.t145 sg13cmos5l_inv_1_517.A sg13cmos5l_inv_1_947.A VGND.t340 sg13_lv_nmos ad=0.2516p pd=2.16u as=0.2516p ps=2.16u w=0.74u l=0.13u
X213 sg13cmos5l_inv_1_747.Y sg13cmos5l_inv_1_756.Y VPWR.t278 VPWR.t2 sg13_lv_pmos ad=0.3808p pd=2.92u as=0.3808p ps=2.92u w=1.12u l=0.13u
X214 sg13cmos5l_inv_1_37.A sg13cmos5l_inv_1_1.Y VGND.t64 VGND.t63 sg13_lv_nmos ad=0.2516p pd=2.16u as=0.2516p ps=2.16u w=0.74u l=0.13u
X215 sg13cmos5l_inv_1_454.Y sg13cmos5l_inv_1_464.Y VGND.t343 VGND.t11 sg13_lv_nmos ad=0.2516p pd=2.16u as=0.2516p ps=2.16u w=0.74u l=0.13u
X216 sg13cmos5l_inv_1_114.A sg13cmos5l_inv_1_953.Y VPWR.t938 VPWR.t29 sg13_lv_pmos ad=0.3808p pd=2.92u as=0.3808p ps=2.92u w=1.12u l=0.13u
X217 a_8086_15994# a_7271_15994# a_8010_15994# VGND.t45 sg13_lv_nmos ad=0.1776p pd=1.195u as=80f ps=0.89u w=0.64u l=0.13u
X218 sg13cmos5l_inv_1_113.A sg13cmos5l_inv_1_118.Y VGND.t165 VGND.t337 sg13_lv_nmos ad=0.2516p pd=2.16u as=0.2516p ps=2.16u w=0.74u l=0.13u
X219 VGND.t6 sg13cmos5l_inv_1_978.A sg13cmos5l_inv_1_977.A VGND.t4 sg13_lv_nmos ad=0.2516p pd=2.16u as=0.2516p ps=2.16u w=0.74u l=0.13u
X220 VPWR.t293 sg13cmos5l_inv_1_580.A sg13cmos5l_inv_1_582.A VPWR.t21 sg13_lv_pmos ad=0.3808p pd=2.92u as=0.3808p ps=2.92u w=1.12u l=0.13u
X221 VPWR.t913 sg13cmos5l_inv_1_693.A sg13cmos5l_inv_1_644.A VPWR.t21 sg13_lv_pmos ad=0.3808p pd=2.92u as=0.3808p ps=2.92u w=1.12u l=0.13u
X222 VGND.t527 sg13cmos5l_inv_1_668.A sg13cmos5l_inv_1_668.Y VGND.t526 sg13_lv_nmos ad=0.2516p pd=2.16u as=0.2516p ps=2.16u w=0.74u l=0.13u
X223 sg13cmos5l_inv_1_36.A sg13cmos5l_inv_1_39.A VPWR.t546 VPWR.t8 sg13_lv_pmos ad=0.3808p pd=2.92u as=0.3808p ps=2.92u w=1.12u l=0.13u
X224 a_7495_3195# sg13cmos5l_inv_1_287.A VPWR.t714 VPWR.t8 sg13_lv_pmos ad=0.415p pd=1.83u as=0.22315p ps=1.555u w=1u l=0.13u
X225 a_3934_3534# a_5005_3418# a_4929_3492# VGND.t1285 sg13_lv_nmos ad=0.2176p pd=1.96u as=0.1216p ps=1.02u w=0.64u l=0.13u
X226 VGND.t29 sg13cmos5l_inv_1_575.Y sg13cmos5l_inv_1_573.A VGND.t22 sg13_lv_nmos ad=0.2516p pd=2.16u as=0.2516p ps=2.16u w=0.74u l=0.13u
X227 sg13cmos5l_inv_1_557.A sg13cmos5l_inv_1_568.Y VGND.t100 VGND.t22 sg13_lv_nmos ad=0.2516p pd=2.16u as=0.2516p ps=2.16u w=0.74u l=0.13u
X228 VPWR.t168 VGND.t478 VPWR.t167 VPWR.t26 sg13_lv_pmos ad=0.34p pd=2.68u as=0 ps=0 w=1u l=1u
X229 sg13cmos5l_inv_1_523.Y sg13cmos5l_inv_1_515.Y VGND.t145 VGND.t231 sg13_lv_nmos ad=0.2516p pd=2.16u as=0.2516p ps=2.16u w=0.74u l=0.13u
X230 VGND.t92 sg13cmos5l_buf_1_9.A.t4 a_13607_14482# VGND.t635 sg13_lv_nmos ad=0.1872p pd=1.225u as=0.2176p ps=1.96u w=0.64u l=0.13u
X231 sg13cmos5l_inv_1_462.A sg13cmos5l_inv_1_364.A VGND.t201 VGND.t851 sg13_lv_nmos ad=0.2516p pd=2.16u as=0.2516p ps=2.16u w=0.74u l=0.13u
X232 VPWR.t107 VGND.t267 VPWR.t106 VPWR.t29 sg13_lv_pmos ad=0.34p pd=2.68u as=0 ps=0 w=1u l=1u
X233 VPWR.t828 sg13cmos5l_inv_1_589.A sg13cmos5l_inv_1_589.Y VPWR.t39 sg13_lv_pmos ad=0.3808p pd=2.92u as=0.3808p ps=2.92u w=1.12u l=0.13u
X234 a_8795_11752# sg13cmos5l_nor3_1_1.B sg13cmos5l_a21oi_1_0.A1 VPWR.t2 sg13_lv_pmos ad=0.2128p pd=1.5u as=0.3808p ps=2.92u w=1.12u l=0.13u
X235 sg13cmos5l_inv_1_980.A sg13cmos5l_inv_1_923.Y VPWR.t746 VPWR.t5 sg13_lv_pmos ad=0.3808p pd=2.92u as=0.3808p ps=2.92u w=1.12u l=0.13u
X236 VPWR.t311 sg13cmos5l_inv_1_679.A sg13cmos5l_inv_1_553.A VPWR.t39 sg13_lv_pmos ad=0.3808p pd=2.92u as=0.3808p ps=2.92u w=1.12u l=0.13u
X237 VGND.t41 VPWR.t1573 VGND.t41 VGND.t1551 sg13_lv_nmos ad=0.1428p pd=1.52u as=0 ps=0 w=0.42u l=1u
X238 VPWR.t1068 sg13cmos5l_inv_1_707.A sg13cmos5l_inv_1_707.Y VPWR.t26 sg13_lv_pmos ad=0.3808p pd=2.92u as=0.3808p ps=2.92u w=1.12u l=0.13u
X239 VPWR.t216 VGND.t147 VPWR.t215 VPWR.t2 sg13_lv_pmos ad=0.34p pd=2.68u as=0 ps=0 w=1u l=1u
X240 VGND.t90 VPWR.t1605 VGND.t90 VGND.t1501 sg13_lv_nmos ad=0.1428p pd=1.52u as=0 ps=0 w=0.42u l=1u
X241 sg13cmos5l_inv_1_741.Y sg13cmos5l_inv_1_1003.Y VGND.t174 VGND.t469 sg13_lv_nmos ad=0.2516p pd=2.16u as=0.2516p ps=2.16u w=0.74u l=0.13u
X242 VPWR.t1169 sg13cmos5l_inv_1_92.A sg13cmos5l_inv_1_1011.A VPWR.t8 sg13_lv_pmos ad=0.3808p pd=2.92u as=0.3808p ps=2.92u w=1.12u l=0.13u
X243 VPWR.t698 sg13cmos5l_inv_1_449.A sg13cmos5l_inv_1_337.A VPWR.t49 sg13_lv_pmos ad=0.3808p pd=2.92u as=0.3808p ps=2.92u w=1.12u l=0.13u
X244 sg13cmos5l_inv_1_688.A sg13cmos5l_inv_1_556.Y VGND.t558 VGND.t557 sg13_lv_nmos ad=0.2516p pd=2.16u as=0.2516p ps=2.16u w=0.74u l=0.13u
X245 VPWR.t4 VGND.t1546 VPWR.t3 VPWR.t2 sg13_lv_pmos ad=0.34p pd=2.68u as=0 ps=0 w=1u l=1u
X246 VGND.t866 sg13cmos5l_buf_1_8.A.t4 a_3623_12606# VGND.t1435 sg13_lv_nmos ad=0.1872p pd=1.225u as=0.2176p ps=1.96u w=0.64u l=0.13u
X247 a_4141_7731# a_3623_8070# a_3934_8070# VPWR.t14 sg13_lv_pmos ad=0.16p pd=1.32u as=0.19p ps=1.38u w=1u l=0.13u
X248 sg13cmos5l_inv_1_181.Y sg13cmos5l_inv_1_152.Y VPWR.t1067 VPWR.t0 sg13_lv_pmos ad=0.3808p pd=2.92u as=0.3808p ps=2.92u w=1.12u l=0.13u
X249 sg13cmos5l_inv_1_837.Y sg13cmos5l_inv_1_836.Y VPWR.t898 VPWR.t39 sg13_lv_pmos ad=0.3808p pd=2.92u as=0.3808p ps=2.92u w=1.12u l=0.13u
X250 sg13cmos5l_inv_1_191.A sg13cmos5l_inv_1_109.Y VGND.t225 VGND.t11 sg13_lv_nmos ad=0.2516p pd=2.16u as=0.2516p ps=2.16u w=0.74u l=0.13u
X251 VPWR.t55 VGND.t76 VPWR.t54 VPWR.t14 sg13_lv_pmos ad=0.34p pd=2.68u as=0 ps=0 w=1u l=1u
X252 VPWR.t1142 sg13cmos5l_inv_1_913.A sg13cmos5l_inv_1_915.A VPWR.t26 sg13_lv_pmos ad=0.3808p pd=2.92u as=0.3808p ps=2.92u w=1.12u l=0.13u
X253 sg13cmos5l_inv_1_762.Y sg13cmos5l_inv_1_757.Y VGND.t347 VGND.t458 sg13_lv_nmos ad=0.2516p pd=2.16u as=0.2516p ps=2.16u w=0.74u l=0.13u
X254 sg13cmos5l_buf_1_27.X a_18664_9192# VGND.t149 VGND.t272 sg13_lv_nmos ad=0.2886p pd=2.26u as=0.14875p ps=1.16u w=0.74u l=0.13u
X255 sg13cmos5l_mux2_1_4.S.t0 a_10504_9192# VPWR.t772 VPWR.t29 sg13_lv_pmos ad=0.42p pd=2.99u as=0.2114p ps=1.54u w=1.12u l=0.13u
X256 a_9825_11776# sg13cmos5l_or2_1_0.X VPWR.t576 VPWR.t2 sg13_lv_pmos ad=0.2125p pd=1.425u as=0.19p ps=1.38u w=1u l=0.13u
X257 a_14913_12564# sg13cmos5l_mux2_1_4.S.t3 a_14422_12606# VGND.t1637 sg13_lv_nmos ad=0.1216p pd=1.02u as=0.54188p ps=3.42u w=0.64u l=0.13u
X258 sg13cmos5l_inv_1_15.Y sg13cmos5l_inv_1_220.Y VGND.t292 VGND.t725 sg13_lv_nmos ad=0.2516p pd=2.16u as=0.2516p ps=2.16u w=0.74u l=0.13u
X259 VGND.t73 VPWR.t1521 VGND.t73 VGND.t1619 sg13_lv_nmos ad=0.1428p pd=1.52u as=0 ps=0 w=0.42u l=1u
X260 VGND.t117 sg13cmos5l_inv_1_438.A sg13cmos5l_inv_1_437.A VGND.t11 sg13_lv_nmos ad=0.2516p pd=2.16u as=0.2516p ps=2.16u w=0.74u l=0.13u
X261 sg13cmos5l_inv_1_959.Y sg13cmos5l_inv_1_959.A VGND.t6 VGND.t4 sg13_lv_nmos ad=0.2516p pd=2.16u as=0.2516p ps=2.16u w=0.74u l=0.13u
X262 VGND.t155 VPWR.t1581 VGND.t155 VGND.t1540 sg13_lv_nmos ad=0.1428p pd=1.52u as=0 ps=0 w=0.42u l=1u
X263 sg13cmos5l_inv_1_462.Y sg13cmos5l_inv_1_462.A VPWR.t506 VPWR.t0 sg13_lv_pmos ad=0.3808p pd=2.92u as=0.3808p ps=2.92u w=1.12u l=0.13u
X264 a_7582_15994# a_7271_15994# a_7508_15994# VGND.t45 sg13_lv_nmos ad=0.1472p pd=1.1u as=76.8f ps=0.88u w=0.64u l=0.13u
X265 sg13cmos5l_inv_1_895.Y sg13cmos5l_inv_1_894.Y VGND.t229 VGND.t726 sg13_lv_nmos ad=0.2516p pd=2.16u as=0.2516p ps=2.16u w=0.74u l=0.13u
X266 VPWR.t414 sg13cmos5l_inv_1_442.A sg13cmos5l_inv_1_442.Y VPWR.t11 sg13_lv_pmos ad=0.3808p pd=2.92u as=0.3808p ps=2.92u w=1.12u l=0.13u
X267 VGND.t92 sg13cmos5l_inv_1_878.A sg13cmos5l_mux4_1_14.A3 VGND.t462 sg13_lv_nmos ad=0.2516p pd=2.16u as=0.2516p ps=2.16u w=0.74u l=0.13u
X268 VPWR.t132 VGND.t155 VPWR.t130 VPWR.t26 sg13_lv_pmos ad=0.19p pd=1.38u as=0 ps=0 w=1u l=1u
X269 VGND.t246 sg13cmos5l_inv_1_298.A sg13cmos5l_inv_1_298.Y VGND.t834 sg13_lv_nmos ad=0.2516p pd=2.16u as=0.2516p ps=2.16u w=0.74u l=0.13u
X270 a_9279_6558# sg13cmos5l_mux4_1_5.S0.t3 a_9142_6558# VGND.t861 sg13_lv_nmos ad=76.8f pd=0.88u as=0.1776p ps=1.195u w=0.64u l=0.13u
X271 VPWR.t845 sg13cmos5l_inv_1_76.A sg13cmos5l_inv_1_75.A VPWR.t49 sg13_lv_pmos ad=0.3808p pd=2.92u as=0.3808p ps=2.92u w=1.12u l=0.13u
X272 sg13cmos5l_inv_1_790.Y sg13cmos5l_inv_1_789.Y VGND.t197 VGND.t22 sg13_lv_nmos ad=0.2516p pd=2.16u as=0.2516p ps=2.16u w=0.74u l=0.13u
X273 sg13cmos5l_inv_1_101.Y sg13cmos5l_inv_1_1010.Y VPWR.t560 VPWR.t8 sg13_lv_pmos ad=0.3808p pd=2.92u as=0.3808p ps=2.92u w=1.12u l=0.13u
X274 VGND.t1510 VPWR.t1600 VGND.t670 VGND.t1511 sg13_lv_nmos ad=79.8f pd=0.8u as=0 ps=0 w=0.42u l=1u
X275 sg13cmos5l_inv_1_7.A sg13cmos5l_inv_1_5.Y VGND.t492 VGND.t491 sg13_lv_nmos ad=0.2516p pd=2.16u as=0.2516p ps=2.16u w=0.74u l=0.13u
X276 a_13918_3898# a_13607_3898# a_13844_3898# VGND.t605 sg13_lv_nmos ad=0.1472p pd=1.1u as=76.8f ps=0.88u w=0.64u l=0.13u
X277 a_6430_8434# sg13cmos5l_mux4_1_5.S0.t5 a_6343_8701# VPWR.t29 sg13_lv_pmos ad=0.19p pd=1.38u as=0.415p ps=1.83u w=1u l=0.13u
X278 VGND.t435 sg13cmos5l_buf_1_8.A.t1 a_16156_3898# VGND.t1432 sg13_lv_nmos ad=0.18945p pd=1.27u as=0.13135p ps=1.095u w=0.74u l=0.13u
X279 a_7495_16261# sg13cmos5l_mux4_1_8.A0 VPWR.t1227 VPWR.t42 sg13_lv_pmos ad=0.415p pd=1.83u as=0.22315p ps=1.555u w=1u l=0.13u
X280 VPWR.t1255 sg13cmos5l_inv_1_372.Y sg13cmos5l_inv_1_377.Y VPWR.t14 sg13_lv_pmos ad=0.3808p pd=2.92u as=0.3808p ps=2.92u w=1.12u l=0.13u
X281 VGND.t614 sg13cmos5l_inv_1_372.A sg13cmos5l_inv_1_372.Y VGND.t929 sg13_lv_nmos ad=0.2516p pd=2.16u as=0.2516p ps=2.16u w=0.74u l=0.13u
X282 sg13cmos5l_inv_1_928.A sg13cmos5l_inv_1_994.Y VGND.t149 VGND.t870 sg13_lv_nmos ad=0.2516p pd=2.16u as=0.2516p ps=2.16u w=0.74u l=0.13u
X283 sg13cmos5l_inv_1_865.Y sg13cmos5l_inv_1_792.Y VGND.t23 VGND.t22 sg13_lv_nmos ad=0.2516p pd=2.16u as=0.2516p ps=2.16u w=0.74u l=0.13u
X284 VGND.t126 sg13cmos5l_inv_1_744.Y sg13cmos5l_mux4_1_7.A2 VGND.t517 sg13_lv_nmos ad=0.2516p pd=2.16u as=0.2516p ps=2.16u w=0.74u l=0.13u
X285 VPWR.t1025 sg13cmos5l_inv_1_236.A sg13cmos5l_inv_1_236.Y VPWR.t49 sg13_lv_pmos ad=0.3808p pd=2.92u as=0.3808p ps=2.92u w=1.12u l=0.13u
X286 a_8349_8728# sg13cmos5l_mux2_1_3.S VPWR.t1082 VPWR.t29 sg13_lv_pmos ad=0.3325p pd=1.665u as=0.253p ps=1.53u w=1u l=0.13u
X287 VPWR.t396 sg13cmos5l_mux4_1_5.S0.t5 a_6119_8434# VPWR.t29 sg13_lv_pmos ad=0.22315p pd=1.555u as=0.34p ps=2.68u w=1u l=0.13u
X288 osc_tap[3] a_18856_9980# VPWR.t343 VPWR.t5 sg13_lv_pmos ad=0.42p pd=2.99u as=0.2114p ps=1.54u w=1.12u l=0.13u
X289 sg13cmos5l_inv_1_982.A sg13cmos5l_inv_1_925.Y VGND.t143 VGND.t190 sg13_lv_nmos ad=0.2516p pd=2.16u as=0.2516p ps=2.16u w=0.74u l=0.13u
X290 sg13cmos5l_inv_1_893.Y sg13cmos5l_inv_1_892.Y VPWR.t578 VPWR.t26 sg13_lv_pmos ad=0.3808p pd=2.92u as=0.3808p ps=2.92u w=1.12u l=0.13u
X291 sg13cmos5l_nor4_1_0.A sg13cmos5l_mux2_1_0.X a_10551_10240# VPWR.t5 sg13_lv_pmos ad=0.3808p pd=2.92u as=0.2128p ps=1.5u w=1.12u l=0.13u
X292 VPWR.t355 a_9326_3410# sg13cmos5l_mux2_1_4.X VPWR.t8 sg13_lv_pmos ad=0.2198p pd=1.52u as=0.6048p ps=3.32u w=1.12u l=0.13u
X293 VPWR.t256 sg13cmos5l_inv_1_978.A sg13cmos5l_inv_1_977.A VPWR.t29 sg13_lv_pmos ad=0.3808p pd=2.92u as=0.3808p ps=2.92u w=1.12u l=0.13u
X294 VGND.t325 sg13cmos5l_inv_1_606.A sg13cmos5l_inv_1_606.Y VGND.t1212 sg13_lv_nmos ad=0.2516p pd=2.16u as=0.2516p ps=2.16u w=0.74u l=0.13u
X295 VPWR.t601 sg13cmos5l_mux4_1_12.A1 a_14125_12267# VPWR.t2 sg13_lv_pmos ad=0.29275p pd=1.785u as=0.16p ps=1.32u w=1u l=0.13u
X296 sg13cmos5l_inv_1_296.A sg13cmos5l_inv_1_295.Y VPWR.t143 VPWR.t11 sg13_lv_pmos ad=0.3808p pd=2.92u as=0.3808p ps=2.92u w=1.12u l=0.13u
X297 sg13cmos5l_inv_1_404.Y sg13cmos5l_inv_1_393.Y VPWR.t326 VPWR.t14 sg13_lv_pmos ad=0.3808p pd=2.92u as=0.3808p ps=2.92u w=1.12u l=0.13u
X298 sg13cmos5l_inv_1_679.A sg13cmos5l_inv_1_534.Y VGND.t44 VGND.t22 sg13_lv_nmos ad=0.2516p pd=2.16u as=0.2516p ps=2.16u w=0.74u l=0.13u
X299 VPWR.t73 VGND.t197 VPWR.t72 VPWR.t39 sg13_lv_pmos ad=0.34p pd=2.68u as=0 ps=0 w=1u l=1u
X300 VGND.t347 sg13cmos5l_inv_1_731.Y sg13cmos5l_inv_1_757.Y VGND.t912 sg13_lv_nmos ad=0.2516p pd=2.16u as=0.2516p ps=2.16u w=0.74u l=0.13u
X301 a_4438_12606# a_5005_12490# a_4929_12564# VPWR.t2 sg13_lv_pmos ad=0.34p pd=2.68u as=0.2225p ps=1.445u w=1u l=0.13u
X302 a_8383_12608# sg13cmos5l_a22oi_1_0.B1 VGND.t133 VGND.t132 sg13_lv_nmos ad=0.13875p pd=1.115u as=0.2553p ps=2.17u w=0.74u l=0.13u
X303 sg13cmos5l_mux4_1_11.A2 a_14913_12564# VGND.t478 VGND.t952 sg13_lv_nmos ad=0.2516p pd=2.16u as=0.1543p ps=1.18u w=0.74u l=0.13u
X304 sg13cmos5l_inv_1_280.Y sg13cmos5l_inv_1_279.Y VPWR.t1440 VPWR.t8 sg13_lv_pmos ad=0.3808p pd=2.92u as=0.3808p ps=2.92u w=1.12u l=0.13u
X305 sg13cmos5l_inv_1_213.Y sg13cmos5l_inv_1_213.A VPWR.t1252 VPWR.t49 sg13_lv_pmos ad=0.3808p pd=2.92u as=0.3808p ps=2.92u w=1.12u l=0.13u
X306 sg13cmos5l_mux4_1_6.X a_4929_8028# VPWR.t717 VPWR.t14 sg13_lv_pmos ad=0.3808p pd=2.92u as=0.34367p ps=1.775u w=1.12u l=0.13u
X307 VGND.t329 sg13cmos5l_inv_1_671.A sg13cmos5l_inv_1_672.A VGND.t328 sg13_lv_nmos ad=0.2516p pd=2.16u as=0.2516p ps=2.16u w=0.74u l=0.13u
X308 VPWR.t1128 sg13cmos5l_inv_1_925.A sg13cmos5l_inv_1_925.Y VPWR.t5 sg13_lv_pmos ad=0.3808p pd=2.92u as=0.3808p ps=2.92u w=1.12u l=0.13u
X309 VGND.t399 sg13cmos5l_inv_1_272.A sg13cmos5l_inv_1_325.A VGND.t507 sg13_lv_nmos ad=0.2516p pd=2.16u as=0.2516p ps=2.16u w=0.74u l=0.13u
X310 VGND.t8 sg13cmos5l_inv_1_933.Y sg13cmos5l_inv_1_935.A VGND.t7 sg13_lv_nmos ad=0.2516p pd=2.16u as=0.2516p ps=2.16u w=0.74u l=0.13u
X311 sg13cmos5l_inv_1_480.A sg13cmos5l_inv_1_648.Y VGND.t3 VGND.t1161 sg13_lv_nmos ad=0.2516p pd=2.16u as=0.2516p ps=2.16u w=0.74u l=0.13u
X312 VGND.t984 sg13cmos5l_inv_1_378.Y sg13cmos5l_inv_1_350.A VGND.t1016 sg13_lv_nmos ad=0.2516p pd=2.16u as=0.2516p ps=2.16u w=0.74u l=0.13u
X313 VPWR.t525 sg13cmos5l_inv_1_15.Y sg13cmos5l_inv_1_20.Y VPWR.t11 sg13_lv_pmos ad=0.3808p pd=2.92u as=0.3808p ps=2.92u w=1.12u l=0.13u
X314 VGND.t1 sg13cmos5l_inv_1_106.A sg13cmos5l_inv_1_106.Y VGND.t270 sg13_lv_nmos ad=0.2516p pd=2.16u as=0.2516p ps=2.16u w=0.74u l=0.13u
X315 VGND.t342 VPWR.t1550 VGND.t342 VGND.t1582 sg13_lv_nmos ad=0.1428p pd=1.52u as=0 ps=0 w=0.42u l=1u
X316 sg13cmos5l_mux2_1_4.S a_10504_9192# VGND.t191 VGND.t4 sg13_lv_nmos ad=0.2886p pd=2.26u as=0.14875p ps=1.16u w=0.74u l=0.13u
X317 VPWR.t1147 sg13cmos5l_inv_1_487.A sg13cmos5l_inv_1_677.A VPWR.t2 sg13_lv_pmos ad=0.3808p pd=2.92u as=0.3808p ps=2.92u w=1.12u l=0.13u
X318 sg13cmos5l_inv_1_165.Y sg13cmos5l_inv_1_171.Y VGND.t1094 VGND.t359 sg13_lv_nmos ad=0.2516p pd=2.16u as=0.2516p ps=2.16u w=0.74u l=0.13u
X319 osc_tap[5] a_18856_14516# VGND.t552 VGND.t551 sg13_lv_nmos ad=0.2886p pd=2.26u as=0.14875p ps=1.16u w=0.74u l=0.13u
X320 VGND.t123 sg13cmos5l_inv_1_59.Y sg13cmos5l_inv_1_102.Y VGND.t349 sg13_lv_nmos ad=0.2516p pd=2.16u as=0.2516p ps=2.16u w=0.74u l=0.13u
X321 VPWR.t245 VGND.t88 VPWR.t244 VPWR.t26 sg13_lv_pmos ad=0.34p pd=2.68u as=0 ps=0 w=1u l=1u
X322 VGND.t33 VPWR.t1511 VGND.t33 VGND.t1635 sg13_lv_nmos ad=0.1428p pd=1.52u as=0 ps=0 w=0.42u l=1u
X323 VGND.t29 sg13cmos5l_inv_1_542.A sg13cmos5l_inv_1_541.A VGND.t22 sg13_lv_nmos ad=0.2516p pd=2.16u as=0.2516p ps=2.16u w=0.74u l=0.13u
X324 VPWR.t1105 sg13cmos5l_inv_1_728.Y sg13cmos5l_inv_1_706.A VPWR.t26 sg13_lv_pmos ad=0.3808p pd=2.92u as=0.3808p ps=2.92u w=1.12u l=0.13u
X325 VPWR.t722 sg13cmos5l_inv_1_702.Y sg13cmos5l_inv_1_715.Y VPWR.t2 sg13_lv_pmos ad=0.3808p pd=2.92u as=0.3808p ps=2.92u w=1.12u l=0.13u
X326 VPWR.t1279 sg13cmos5l_inv_1_85.A sg13cmos5l_inv_1_85.Y VPWR.t8 sg13_lv_pmos ad=0.3808p pd=2.92u as=0.3808p ps=2.92u w=1.12u l=0.13u
X327 sg13cmos5l_inv_1_166.Y sg13cmos5l_inv_1_166.A VPWR.t953 VPWR.t29 sg13_lv_pmos ad=0.3808p pd=2.92u as=0.3808p ps=2.92u w=1.12u l=0.13u
X328 VPWR.t483 sg13cmos5l_inv_1_557.A sg13cmos5l_inv_1_557.Y VPWR.t39 sg13_lv_pmos ad=0.3808p pd=2.92u as=0.3808p ps=2.92u w=1.12u l=0.13u
X329 VPWR.t643 sg13cmos5l_inv_1_668.A sg13cmos5l_inv_1_668.Y VPWR.t26 sg13_lv_pmos ad=0.3808p pd=2.92u as=0.3808p ps=2.92u w=1.12u l=0.13u
X330 VGND.t3 sg13cmos5l_inv_1_948.A sg13cmos5l_inv_1_693.A VGND.t1406 sg13_lv_nmos ad=0.2516p pd=2.16u as=0.2516p ps=2.16u w=0.74u l=0.13u
X331 VPWR.t680 sg13cmos5l_inv_1_827.A sg13cmos5l_inv_1_827.Y VPWR.t39 sg13_lv_pmos ad=0.3808p pd=2.92u as=0.3808p ps=2.92u w=1.12u l=0.13u
X332 VPWR.t373 sg13cmos5l_a21oi_1_0.A1 a_8315_11752# VPWR.t2 sg13_lv_pmos ad=0.2128p pd=1.5u as=0.2128p ps=1.5u w=1.12u l=0.13u
X333 sg13cmos5l_inv_1_24.Y sg13cmos5l_inv_1_13.Y VPWR.t747 VPWR.t11 sg13_lv_pmos ad=0.3808p pd=2.92u as=0.3808p ps=2.92u w=1.12u l=0.13u
X334 sg13cmos5l_inv_1_288.Y sg13cmos5l_inv_1_282.Y VPWR.t1425 VPWR.t8 sg13_lv_pmos ad=0.3808p pd=2.92u as=0.3808p ps=2.92u w=1.12u l=0.13u
X335 VGND.t107 sg13cmos5l_inv_1_391.A sg13cmos5l_inv_1_391.Y VGND.t702 sg13_lv_nmos ad=0.2516p pd=2.16u as=0.2516p ps=2.16u w=0.74u l=0.13u
X336 sg13cmos5l_mux4_1_16.A1 sg13cmos5l_inv_1_397.Y VPWR.t1104 VPWR.t14 sg13_lv_pmos ad=0.3808p pd=2.92u as=0.3808p ps=2.92u w=1.12u l=0.13u
X337 VGND.t342 sg13cmos5l_inv_1_357.A sg13cmos5l_inv_1_356.A VGND.t468 sg13_lv_nmos ad=0.2516p pd=2.16u as=0.2516p ps=2.16u w=0.74u l=0.13u
X338 VGND.t155 sg13cmos5l_inv_1_714.A sg13cmos5l_inv_1_712.A VGND.t1028 sg13_lv_nmos ad=0.2516p pd=2.16u as=0.2516p ps=2.16u w=0.74u l=0.13u
X339 sg13cmos5l_inv_1_400.Y sg13cmos5l_inv_1_399.Y VGND.t354 VGND.t922 sg13_lv_nmos ad=0.2516p pd=2.16u as=0.2516p ps=2.16u w=0.74u l=0.13u
X340 a_7700_15994# sg13cmos5l_mux4_1_5.S0.t7 a_7582_15994# VGND.t45 sg13_lv_nmos ad=0.2304p pd=1.36u as=0.1472p ps=1.1u w=0.64u l=0.13u
X341 VPWR.t939 sg13cmos5l_inv_1_356.A sg13cmos5l_inv_1_356.Y VPWR.t29 sg13_lv_pmos ad=0.3808p pd=2.92u as=0.3808p ps=2.92u w=1.12u l=0.13u
X342 VGND.t1194 sg13cmos5l_inv_1_821.A sg13cmos5l_inv_1_821.Y VGND.t1193 sg13_lv_nmos ad=0.2516p pd=2.16u as=0.2516p ps=2.16u w=0.74u l=0.13u
X343 VGND.t329 sg13cmos5l_inv_1_632.A sg13cmos5l_inv_1_631.A VGND.t764 sg13_lv_nmos ad=0.2516p pd=2.16u as=0.2516p ps=2.16u w=0.74u l=0.13u
X344 sg13cmos5l_inv_1_217.A sg13cmos5l_inv_1_107.Y VGND.t157 VGND.t400 sg13_lv_nmos ad=0.2516p pd=2.16u as=0.2516p ps=2.16u w=0.74u l=0.13u
X345 VGND.t229 sg13cmos5l_inv_1_875.A sg13cmos5l_inv_1_875.Y VGND.t1346 sg13_lv_nmos ad=0.2516p pd=2.16u as=0.2516p ps=2.16u w=0.74u l=0.13u
X346 sg13cmos5l_inv_1_959.Y sg13cmos5l_inv_1_959.A VPWR.t996 VPWR.t29 sg13_lv_pmos ad=0.3808p pd=2.92u as=0.3808p ps=2.92u w=1.12u l=0.13u
X347 VPWR.t1015 sg13cmos5l_inv_1_898.Y sg13cmos5l_inv_1_886.Y VPWR.t21 sg13_lv_pmos ad=0.3808p pd=2.92u as=0.3808p ps=2.92u w=1.12u l=0.13u
X348 sg13cmos5l_inv_1_439.A sg13cmos5l_inv_1_450.Y VGND.t12 VGND.t11 sg13_lv_nmos ad=0.2516p pd=2.16u as=0.2516p ps=2.16u w=0.74u l=0.13u
X349 VGND.t92 sg13cmos5l_inv_1_879.A sg13cmos5l_inv_1_878.A VGND.t968 sg13_lv_nmos ad=0.2516p pd=2.16u as=0.2516p ps=2.16u w=0.74u l=0.13u
X350 sg13cmos5l_inv_1_86.Y sg13cmos5l_inv_1_84.Y VGND.t123 VGND.t293 sg13_lv_nmos ad=0.2516p pd=2.16u as=0.2516p ps=2.16u w=0.74u l=0.13u
X351 VPWR.t139 sg13cmos5l_inv_1_307.A sg13cmos5l_inv_1_308.A VPWR.t11 sg13_lv_pmos ad=0.3808p pd=2.92u as=0.3808p ps=2.92u w=1.12u l=0.13u
X352 a_8577_3492# sg13cmos5l_mux4_1_5.S1.t2 a_8086_3534# VGND.t71 sg13_lv_nmos ad=0.1216p pd=1.02u as=0.54188p ps=3.42u w=0.64u l=0.13u
X353 a_9142_6558# sg13cmos5l_mux4_1_5.S0.t3 a_9061_6219# VPWR.t0 sg13_lv_pmos ad=0.4425p pd=1.885u as=0.20762p ps=1.605u w=1u l=0.13u
X354 a_14132_15630# sg13cmos5l_mux4_1_13.A0 VGND.t171 VGND.t170 sg13_lv_nmos ad=76.8f pd=0.88u as=0.1872p ps=1.225u w=0.64u l=0.13u
X355 sg13cmos5l_inv_1_421.A sg13cmos5l_inv_1_451.A VPWR.t556 VPWR.t49 sg13_lv_pmos ad=0.3808p pd=2.92u as=0.3808p ps=2.92u w=1.12u l=0.13u
X356 VPWR.t489 sg13cmos5l_nand2_1_1.Y a_10268_9172# VPWR.t29 sg13_lv_pmos ad=0.3808p pd=2.92u as=0.2128p ps=1.5u w=1.12u l=0.15u
X357 sg13cmos5l_inv_1_808.A sg13cmos5l_inv_1_806.Y VPWR.t887 VPWR.t39 sg13_lv_pmos ad=0.3808p pd=2.92u as=0.3808p ps=2.92u w=1.12u l=0.13u
X358 sg13cmos5l_inv_1_348.Y sg13cmos5l_inv_1_348.A VGND.t430 VGND.t429 sg13_lv_nmos ad=0.2516p pd=2.16u as=0.2516p ps=2.16u w=0.74u l=0.13u
X359 a_6910_12970# a_7981_12976# a_7905_13012# VGND.t1067 sg13_lv_nmos ad=0.2176p pd=1.96u as=0.1216p ps=1.02u w=0.64u l=0.13u
X360 sg13cmos5l_inv_1_708.A sg13cmos5l_inv_1_725.Y VPWR.t1063 VPWR.t26 sg13_lv_pmos ad=0.3808p pd=2.92u as=0.3808p ps=2.92u w=1.12u l=0.13u
X361 sg13cmos5l_inv_1_619.Y sg13cmos5l_inv_1_619.A VPWR.t816 VPWR.t42 sg13_lv_pmos ad=0.3808p pd=2.92u as=0.3808p ps=2.92u w=1.12u l=0.13u
X362 VPWR.t1136 a_4556_3858# sg13cmos5l_buf_1_9.A.t0 VPWR.t49 sg13_lv_pmos ad=0.2114p pd=1.54u as=0.42p ps=2.99u w=1.12u l=0.13u
X363 VPWR.t1464 sg13cmos5l_inv_1_751.A sg13cmos5l_inv_1_749.A VPWR.t2 sg13_lv_pmos ad=0.3808p pd=2.92u as=0.3808p ps=2.92u w=1.12u l=0.13u
X364 sg13cmos5l_inv_1_1000.Y sg13cmos5l_inv_1_942.Y VGND.t149 VGND.t973 sg13_lv_nmos ad=0.2516p pd=2.16u as=0.2516p ps=2.16u w=0.74u l=0.13u
X365 VGND.t984 sg13cmos5l_inv_1_372.Y sg13cmos5l_inv_1_377.Y VGND.t1234 sg13_lv_nmos ad=0.2516p pd=2.16u as=0.2516p ps=2.16u w=0.74u l=0.13u
X366 VGND.t39 VPWR.t1568 VGND.t39 VGND.t1558 sg13_lv_nmos ad=0.1428p pd=1.52u as=0 ps=0 w=0.42u l=1u
X367 sg13cmos5l_inv_1_956.Y sg13cmos5l_inv_1_202.Y VGND.t10 VGND.t994 sg13_lv_nmos ad=0.2516p pd=2.16u as=0.2516p ps=2.16u w=0.74u l=0.13u
X368 VGND.t78 sg13cmos5l_mux4_1_5.S1.t1 a_13799_3534# VGND.t77 sg13_lv_nmos ad=0.1872p pd=1.225u as=0.2176p ps=1.96u w=0.64u l=0.13u
X369 VPWR.t172 VGND.t478 VPWR.t171 VPWR.t26 sg13_lv_pmos ad=0.34p pd=2.68u as=0 ps=0 w=1u l=1u
X370 VGND.t902 VPWR.t1561 VGND.t902 VGND.t190 sg13_lv_nmos ad=0.1428p pd=1.52u as=0 ps=0 w=0.42u l=1u
X371 sg13cmos5l_inv_1_359.Y sg13cmos5l_inv_1_366.Y VPWR.t1013 VPWR.t29 sg13_lv_pmos ad=0.3808p pd=2.92u as=0.3808p ps=2.92u w=1.12u l=0.13u
X372 VGND.t342 sg13cmos5l_mux4_1_5.S0.t4 a_3623_8070# VGND.t862 sg13_lv_nmos ad=0.1872p pd=1.225u as=0.2176p ps=1.96u w=0.64u l=0.13u
X373 sg13cmos5l_inv_1_793.A sg13cmos5l_inv_1_804.A VPWR.t888 VPWR.t42 sg13_lv_pmos ad=0.3808p pd=2.92u as=0.3808p ps=2.92u w=1.12u l=0.13u
X374 sg13cmos5l_inv_1_1007.Y sg13cmos5l_inv_1_924.Y VGND.t143 VGND.t190 sg13_lv_nmos ad=0.2516p pd=2.16u as=0.2516p ps=2.16u w=0.74u l=0.13u
X375 sg13cmos5l_inv_1_53.Y sg13cmos5l_inv_1_48.Y VGND.t596 VGND.t1430 sg13_lv_nmos ad=0.2516p pd=2.16u as=0.2516p ps=2.16u w=0.74u l=0.13u
X376 sg13cmos5l_inv_1_651.Y sg13cmos5l_inv_1_652.Y VGND.t250 VGND.t956 sg13_lv_nmos ad=0.2516p pd=2.16u as=0.2516p ps=2.16u w=0.74u l=0.13u
X377 sg13cmos5l_inv_1_895.Y sg13cmos5l_inv_1_894.Y VPWR.t802 VPWR.t26 sg13_lv_pmos ad=0.3808p pd=2.92u as=0.3808p ps=2.92u w=1.12u l=0.13u
X378 sg13cmos5l_inv_1_250.Y sg13cmos5l_inv_1_252.Y VPWR.t411 VPWR.t11 sg13_lv_pmos ad=0.3808p pd=2.92u as=0.3808p ps=2.92u w=1.12u l=0.13u
X379 sg13cmos5l_inv_1_381.Y sg13cmos5l_inv_1_383.Y VGND.t107 VGND.t106 sg13_lv_nmos ad=0.2516p pd=2.16u as=0.2516p ps=2.16u w=0.74u l=0.13u
X380 VGND.t49 VPWR.t1618 VGND.t49 VGND.t1486 sg13_lv_nmos ad=0.1428p pd=1.52u as=0 ps=0 w=0.42u l=1u
X381 sg13cmos5l_inv_1_744.Y sg13cmos5l_inv_1_743.Y VGND.t126 VGND.t473 sg13_lv_nmos ad=0.2516p pd=2.16u as=0.2516p ps=2.16u w=0.74u l=0.13u
X382 VPWR.t377 sg13cmos5l_inv_1_608.A sg13cmos5l_inv_1_608.Y VPWR.t39 sg13_lv_pmos ad=0.3808p pd=2.92u as=0.3808p ps=2.92u w=1.12u l=0.13u
X383 VGND.t250 sg13cmos5l_inv_1_642.A sg13cmos5l_inv_1_642.Y VGND.t394 sg13_lv_nmos ad=0.2516p pd=2.16u as=0.2516p ps=2.16u w=0.74u l=0.13u
X384 VGND.t15 VPWR.t1557 VGND.t15 VGND.t1573 sg13_lv_nmos ad=0.1428p pd=1.52u as=0 ps=0 w=0.42u l=1u
X385 VGND.t437 sg13cmos5l_inv_1_669.A sg13cmos5l_inv_1_664.A VGND.t916 sg13_lv_nmos ad=0.2516p pd=2.16u as=0.2516p ps=2.16u w=0.74u l=0.13u
X386 sg13cmos5l_inv_1_563.Y sg13cmos5l_inv_1_563.A VPWR.t1246 VPWR.t42 sg13_lv_pmos ad=0.3808p pd=2.92u as=0.3808p ps=2.92u w=1.12u l=0.13u
X387 sg13cmos5l_a22oi_1_0.A1 a_7905_13012# VGND.t133 VGND.t873 sg13_lv_nmos ad=0.2516p pd=2.16u as=0.1543p ps=1.18u w=0.74u l=0.13u
X388 sg13cmos5l_inv_1_950.A sg13cmos5l_inv_1_514.Y VGND.t145 VGND.t1444 sg13_lv_nmos ad=0.2516p pd=2.16u as=0.2516p ps=2.16u w=0.74u l=0.13u
X389 sg13cmos5l_inv_1_115.A sg13cmos5l_inv_1_114.Y VGND.t8 VGND.t4 sg13_lv_nmos ad=0.2516p pd=2.16u as=0.2516p ps=2.16u w=0.74u l=0.13u
X390 sg13cmos5l_mux4_1_7.A1 sg13cmos5l_inv_1_676.Y VGND.t723 VGND.t1002 sg13_lv_nmos ad=0.2516p pd=2.16u as=0.2516p ps=2.16u w=0.74u l=0.13u
X391 sg13cmos5l_inv_1_317.Y sg13cmos5l_inv_1_314.Y VGND.t248 VGND.t1141 sg13_lv_nmos ad=0.2516p pd=2.16u as=0.2516p ps=2.16u w=0.74u l=0.13u
X392 VGND.t1378 VPWR.t143 VGND.t1378 VGND.t1633 sg13_lv_nmos ad=0.1428p pd=1.52u as=0 ps=0 w=0.42u l=1u
X393 a_14645_14795# a_13607_14482# a_14422_14482# VPWR.t21 sg13_lv_pmos ad=0.135p pd=1.27u as=0.4425p ps=1.885u w=1u l=0.13u
X394 a_16304_7685# sg13cmos5l_buf_1_8.A.t2 a_15608_7680# VPWR.t14 sg13_lv_pmos ad=0.20762p pd=1.605u as=0.4425p ps=1.885u w=1u l=0.13u
X395 a_8309_16307# a_7271_15994# a_8086_15994# VPWR.t42 sg13_lv_pmos ad=0.135p pd=1.27u as=0.4425p ps=1.885u w=1u l=0.13u
X396 a_16531_7731# sg13cmos5l_inv_1_179.A VPWR.t1066 VPWR.t14 sg13_lv_pmos ad=0.16p pd=1.32u as=0.29275p ps=1.785u w=1u l=0.13u
X397 VGND.t10 sg13cmos5l_mux2_1_4.S a_15565_9466# VGND.t641 sg13_lv_nmos ad=0.1543p pd=1.18u as=0.2304p ps=2u w=0.64u l=0.13u
X398 VGND.t866 sg13cmos5l_inv_1_519.Y sg13cmos5l_inv_1_532.A VGND.t865 sg13_lv_nmos ad=0.2516p pd=2.16u as=0.2516p ps=2.16u w=0.74u l=0.13u
X399 VPWR.t590 sg13cmos5l_inv_1_141.A sg13cmos5l_inv_1_141.Y VPWR.t0 sg13_lv_pmos ad=0.3808p pd=2.92u as=0.3808p ps=2.92u w=1.12u l=0.13u
X400 sg13cmos5l_inv_1_991.A sg13cmos5l_inv_1_990.Y VGND.t5 VGND.t4 sg13_lv_nmos ad=0.2516p pd=2.16u as=0.2516p ps=2.16u w=0.74u l=0.13u
X401 sg13cmos5l_inv_1_614.A sg13cmos5l_inv_1_589.Y VPWR.t321 VPWR.t39 sg13_lv_pmos ad=0.3808p pd=2.92u as=0.3808p ps=2.92u w=1.12u l=0.13u
X402 a_15662_4084# sg13cmos5l_mux4_1_1.X a_15834_3898# VGND.t499 sg13_lv_nmos ad=0.1628p pd=1.18u as=0.3367p ps=1.65u w=0.74u l=0.13u
X403 VPWR.t1125 sg13cmos5l_inv_1_671.A sg13cmos5l_inv_1_672.A VPWR.t26 sg13_lv_pmos ad=0.3808p pd=2.92u as=0.3808p ps=2.92u w=1.12u l=0.13u
X404 sg13cmos5l_inv_1_722.Y sg13cmos5l_inv_1_699.Y VGND.t184 VGND.t1082 sg13_lv_nmos ad=0.2516p pd=2.16u as=0.2516p ps=2.16u w=0.74u l=0.13u
X405 sg13cmos5l_mux4_1_16.A1 sg13cmos5l_inv_1_397.Y VGND.t76 VGND.t227 sg13_lv_nmos ad=0.2516p pd=2.16u as=0.2516p ps=2.16u w=0.74u l=0.13u
X406 a_7582_15994# a_8653_16000# a_8577_16036# VGND.t742 sg13_lv_nmos ad=0.2176p pd=1.96u as=0.1216p ps=1.02u w=0.64u l=0.13u
X407 sg13cmos5l_inv_1_480.A sg13cmos5l_inv_1_648.Y VPWR.t1187 VPWR.t26 sg13_lv_pmos ad=0.3808p pd=2.92u as=0.3808p ps=2.92u w=1.12u l=0.13u
X408 VPWR.t1294 sg13cmos5l_inv_1_316.A sg13cmos5l_inv_1_322.A VPWR.t49 sg13_lv_pmos ad=0.3808p pd=2.92u as=0.3808p ps=2.92u w=1.12u l=0.13u
X409 VGND.t90 sg13cmos5l_inv_1_768.A sg13cmos5l_inv_1_767.A VGND.t582 sg13_lv_nmos ad=0.2516p pd=2.16u as=0.2516p ps=2.16u w=0.74u l=0.13u
X410 VPWR.t34 VGND.t1521 VPWR.t33 VPWR.t21 sg13_lv_pmos ad=0.34p pd=2.68u as=0 ps=0 w=1u l=1u
X411 sg13cmos5l_inv_1_549.A sg13cmos5l_inv_1_571.Y VGND.t29 VGND.t22 sg13_lv_nmos ad=0.2516p pd=2.16u as=0.2516p ps=2.16u w=0.74u l=0.13u
X412 VPWR.t1164 sg13cmos5l_inv_1_70.A sg13cmos5l_inv_1_70.Y VPWR.t11 sg13_lv_pmos ad=0.3808p pd=2.92u as=0.3808p ps=2.92u w=1.12u l=0.13u
X413 VPWR.t763 sg13cmos5l_inv_1_328.Y sg13cmos5l_inv_1_336.A VPWR.t8 sg13_lv_pmos ad=0.3808p pd=2.92u as=0.3808p ps=2.92u w=1.12u l=0.13u
X414 VPWR.t162 VGND.t29 VPWR.t161 VPWR.t42 sg13_lv_pmos ad=0.34p pd=2.68u as=0 ps=0 w=1u l=1u
X415 VGND.t329 sg13cmos5l_inv_1_684.A sg13cmos5l_inv_1_684.Y VGND.t328 sg13_lv_nmos ad=0.2516p pd=2.16u as=0.2516p ps=2.16u w=0.74u l=0.13u
X416 VGND.t229 sg13cmos5l_inv_1_888.Y sg13cmos5l_inv_1_873.A VGND.t333 sg13_lv_nmos ad=0.2516p pd=2.16u as=0.2516p ps=2.16u w=0.74u l=0.13u
X417 VGND.t360 sg13cmos5l_buf_1_4.X a_18856_7680# VGND.t481 sg13_lv_nmos ad=0.14875p pd=1.16u as=0.187p ps=1.78u w=0.55u l=0.13u
X418 VPWR.t411 sg13cmos5l_inv_1_243.A sg13cmos5l_inv_1_273.A VPWR.t11 sg13_lv_pmos ad=0.3808p pd=2.92u as=0.3808p ps=2.92u w=1.12u l=0.13u
X419 VPWR.t420 sg13cmos5l_inv_1_270.Y sg13cmos5l_inv_1_414.A VPWR.t49 sg13_lv_pmos ad=0.3808p pd=2.92u as=0.3808p ps=2.92u w=1.12u l=0.13u
X420 sg13cmos5l_inv_1_313.Y sg13cmos5l_inv_1_309.Y VPWR.t139 VPWR.t11 sg13_lv_pmos ad=0.3808p pd=2.92u as=0.3808p ps=2.92u w=1.12u l=0.13u
X421 a_7582_3534# a_7271_3534# a_7508_3534# VGND.t1281 sg13_lv_nmos ad=0.1472p pd=1.1u as=76.8f ps=0.88u w=0.64u l=0.13u
X422 sg13cmos5l_inv_1_896.Y sg13cmos5l_inv_1_891.Y VGND.t229 VGND.t228 sg13_lv_nmos ad=0.2516p pd=2.16u as=0.2516p ps=2.16u w=0.74u l=0.13u
X423 VPWR.t550 sg13cmos5l_a21oi_1_1.A1 a_8795_11752# VPWR.t2 sg13_lv_pmos ad=0.2128p pd=1.5u as=0.2128p ps=1.5u w=1.12u l=0.13u
X424 sg13cmos5l_mux4_1_1.X a_15105_3492# VGND.t435 VGND.t434 sg13_lv_nmos ad=0.2516p pd=2.16u as=0.1543p ps=1.18u w=0.74u l=0.13u
X425 VGND.t1 sg13cmos5l_inv_1_137.A sg13cmos5l_inv_1_138.A VGND.t270 sg13_lv_nmos ad=0.2516p pd=2.16u as=0.2516p ps=2.16u w=0.74u l=0.13u
X426 sg13cmos5l_inv_1_224.A sg13cmos5l_inv_1_228.Y VPWR.t609 VPWR.t0 sg13_lv_pmos ad=0.3808p pd=2.92u as=0.3808p ps=2.92u w=1.12u l=0.13u
X427 a_9633_6516# sg13cmos5l_mux4_1_5.S1.t5 a_9142_6558# VGND.t652 sg13_lv_nmos ad=0.1216p pd=1.02u as=0.54188p ps=3.42u w=0.64u l=0.13u
X428 a_14206_15630# sg13cmos5l_buf_1_9.A.t5 a_14119_15291# VPWR.t21 sg13_lv_pmos ad=0.19p pd=1.38u as=0.415p ps=1.83u w=1u l=0.13u
X429 sg13cmos5l_inv_1_725.Y sg13cmos5l_inv_1_724.Y VGND.t155 VGND.t154 sg13_lv_nmos ad=0.2516p pd=2.16u as=0.2516p ps=2.16u w=0.74u l=0.13u
X430 sg13cmos5l_mux4_1_4.A2 sg13cmos5l_inv_1_970.A VGND.t143 VGND.t4 sg13_lv_nmos ad=0.2516p pd=2.16u as=0.2516p ps=2.16u w=0.74u l=0.13u
X431 VGND.t527 sg13cmos5l_inv_1_680.A sg13cmos5l_inv_1_680.Y VGND.t530 sg13_lv_nmos ad=0.2516p pd=2.16u as=0.2516p ps=2.16u w=0.74u l=0.13u
X432 sg13cmos5l_mux4_1_6.X a_4929_8028# VGND.t162 VGND.t619 sg13_lv_nmos ad=0.2516p pd=2.16u as=0.1543p ps=1.18u w=0.74u l=0.13u
X433 a_14110_3534# a_13799_3534# a_14036_3534# VGND.t740 sg13_lv_nmos ad=0.1472p pd=1.1u as=76.8f ps=0.88u w=0.64u l=0.13u
X434 VPWR.t1072 sg13cmos5l_inv_1_346.Y a_4141_7731# VPWR.t14 sg13_lv_pmos ad=0.29275p pd=1.785u as=0.16p ps=1.32u w=1u l=0.13u
X435 VPWR.t621 sg13cmos5l_inv_1_564.A sg13cmos5l_inv_1_564.Y VPWR.t39 sg13_lv_pmos ad=0.3808p pd=2.92u as=0.3808p ps=2.92u w=1.12u l=0.13u
X436 sg13cmos5l_inv_1_843.A sg13cmos5l_inv_1_841.Y VPWR.t1382 VPWR.t39 sg13_lv_pmos ad=0.3808p pd=2.92u as=0.3808p ps=2.92u w=1.12u l=0.13u
X437 VPWR.t900 VGND.t225 VPWR.t899 VPWR.t0 sg13_lv_pmos ad=0.34p pd=2.68u as=0 ps=0 w=1u l=1u
X438 VGND.t73 VPWR.t1522 VGND.t73 VGND.t1618 sg13_lv_nmos ad=79.8f pd=0.8u as=0 ps=0 w=0.42u l=1u
X439 a_8577_16036# sg13cmos5l_buf_1_9.A.t6 a_7582_15994# VPWR.t42 sg13_lv_pmos ad=0.2225p pd=1.445u as=0.34p ps=2.68u w=1u l=0.13u
X440 sg13cmos5l_inv_1_953.Y sg13cmos5l_inv_1_959.Y VGND.t902 VGND.t4 sg13_lv_nmos ad=0.2516p pd=2.16u as=0.2516p ps=2.16u w=0.74u l=0.13u
X441 VPWR.t1154 sg13cmos5l_inv_1_63.A sg13cmos5l_inv_1_66.A VPWR.t11 sg13_lv_pmos ad=0.3808p pd=2.92u as=0.3808p ps=2.92u w=1.12u l=0.13u
X442 sg13cmos5l_inv_1_956.Y sg13cmos5l_inv_1_202.Y VPWR.t1044 VPWR.t29 sg13_lv_pmos ad=0.3808p pd=2.92u as=0.3808p ps=2.92u w=1.12u l=0.13u
X443 sg13cmos5l_inv_1_173.Y sg13cmos5l_inv_1_149.Y VPWR.t591 VPWR.t14 sg13_lv_pmos ad=0.3808p pd=2.92u as=0.3808p ps=2.92u w=1.12u l=0.13u
X444 sg13cmos5l_inv_1_163.Y sg13cmos5l_inv_1_162.Y VGND.t128 VGND.t359 sg13_lv_nmos ad=0.2516p pd=2.16u as=0.2516p ps=2.16u w=0.74u l=0.13u
X445 VGND.t229 sg13cmos5l_inv_1_880.A sg13cmos5l_inv_1_879.A VGND.t728 sg13_lv_nmos ad=0.2516p pd=2.16u as=0.2516p ps=2.16u w=0.74u l=0.13u
X446 sg13cmos5l_inv_1_793.A sg13cmos5l_inv_1_804.A VGND.t567 VGND.t22 sg13_lv_nmos ad=0.2516p pd=2.16u as=0.2516p ps=2.16u w=0.74u l=0.13u
X447 sg13cmos5l_inv_1_162.Y sg13cmos5l_inv_1_162.A VPWR.t1389 VPWR.t29 sg13_lv_pmos ad=0.3808p pd=2.92u as=0.3808p ps=2.92u w=1.12u l=0.13u
X448 VPWR.t1335 sg13cmos5l_inv_1_774.Y sg13cmos5l_inv_1_769.Y VPWR.t39 sg13_lv_pmos ad=0.3808p pd=2.92u as=0.3808p ps=2.92u w=1.12u l=0.13u
X449 VGND.t621 sg13cmos5l_inv_1_100.A sg13cmos5l_inv_1_103.A VGND.t1116 sg13_lv_nmos ad=0.2516p pd=2.16u as=0.2516p ps=2.16u w=0.74u l=0.13u
X450 VGND.t130 sg13cmos5l_inv_1_169.Y sg13cmos5l_inv_1_158.Y VGND.t1087 sg13_lv_nmos ad=0.2516p pd=2.16u as=0.2516p ps=2.16u w=0.74u l=0.13u
X451 a_4798_12970# sg13cmos5l_mux2_1_2.A0 a_4701_13264# VPWR.t26 sg13_lv_pmos ad=0.2225p pd=1.445u as=0.3325p ps=1.665u w=1u l=0.13u
X452 sg13cmos5l_inv_1_83.Y sg13cmos5l_inv_1_88.Y VPWR.t1293 VPWR.t49 sg13_lv_pmos ad=0.3808p pd=2.92u as=0.3808p ps=2.92u w=1.12u l=0.13u
X453 VGND.t478 VPWR.t1584 VGND.t478 VGND.t713 sg13_lv_nmos ad=0.1428p pd=1.52u as=0 ps=0 w=0.42u l=1u
X454 sg13cmos5l_a21oi_1_0.A2 sg13cmos5l_a22oi_1_0.B1 a_8383_12192# VPWR.t2 sg13_lv_pmos ad=0.2128p pd=1.5u as=0.2716p ps=1.605u w=1.12u l=0.13u
X455 a_9948_10240# sg13cmos5l_nor3_1_0.Y a_9846_10240# VPWR.t5 sg13_lv_pmos ad=0.2128p pd=1.5u as=0.2128p ps=1.5u w=1.12u l=0.13u
X456 VGND.t26 sg13cmos5l_inv_1_744.Y a_18664_13004# VGND.t516 sg13_lv_nmos ad=0.14875p pd=1.16u as=0.187p ps=1.78u w=0.55u l=0.13u
X457 sg13cmos5l_inv_1_49.A sg13cmos5l_mux4_1_1.A3 VGND.t28 VGND.t593 sg13_lv_nmos ad=0.2516p pd=2.16u as=0.2516p ps=2.16u w=0.74u l=0.13u
X458 sg13cmos5l_inv_1_220.A sg13cmos5l_inv_1_216.Y VPWR.t1396 VPWR.t8 sg13_lv_pmos ad=0.3808p pd=2.92u as=0.3808p ps=2.92u w=1.12u l=0.13u
X459 a_9142_6558# a_9709_6442# a_9633_6516# VPWR.t0 sg13_lv_pmos ad=0.34p pd=2.68u as=0.2225p ps=1.445u w=1u l=0.13u
X460 VPWR.t1222 sg13cmos5l_inv_1_682.A sg13cmos5l_inv_1_681.A VPWR.t21 sg13_lv_pmos ad=0.3808p pd=2.92u as=0.3808p ps=2.92u w=1.12u l=0.13u
X461 VGND.t612 VPWR.t1570 VGND.t612 VGND.t1556 sg13_lv_nmos ad=79.8f pd=0.8u as=0 ps=0 w=0.42u l=1u
X462 VPWR.t180 VGND.t342 VPWR.t179 VPWR.t14 sg13_lv_pmos ad=0.34p pd=2.68u as=0 ps=0 w=1u l=1u
X463 VGND.t342 VPWR.t1556 VGND.t342 VGND.t1574 sg13_lv_nmos ad=0.1428p pd=1.52u as=0 ps=0 w=0.42u l=1u
X464 VGND.t329 sg13cmos5l_inv_1_674.A sg13cmos5l_inv_1_675.A VGND.t1056 sg13_lv_nmos ad=0.2516p pd=2.16u as=0.2516p ps=2.16u w=0.74u l=0.13u
X465 VGND.t113 sg13cmos5l_buf_1_6.A a_18280_5444# VGND.t11 sg13_lv_nmos ad=0.14875p pd=1.16u as=0.187p ps=1.78u w=0.55u l=0.13u
X466 sg13cmos5l_inv_1_159.Y sg13cmos5l_inv_1_159.A VGND.t130 VGND.t869 sg13_lv_nmos ad=0.2516p pd=2.16u as=0.2516p ps=2.16u w=0.74u l=0.13u
X467 sg13cmos5l_inv_1_1010.Y sg13cmos5l_inv_1_278.Y VGND.t373 VGND.t1197 sg13_lv_nmos ad=0.2516p pd=2.16u as=0.2516p ps=2.16u w=0.74u l=0.13u
X468 sg13cmos5l_inv_1_651.Y sg13cmos5l_inv_1_652.Y VPWR.t1010 VPWR.t26 sg13_lv_pmos ad=0.3808p pd=2.92u as=0.3808p ps=2.92u w=1.12u l=0.13u
X469 sg13cmos5l_inv_1_382.A sg13cmos5l_inv_1_454.Y VGND.t134 VGND.t11 sg13_lv_nmos ad=0.2516p pd=2.16u as=0.2516p ps=2.16u w=0.74u l=0.13u
X470 sg13cmos5l_inv_1_115.A sg13cmos5l_inv_1_114.Y VPWR.t532 VPWR.t29 sg13_lv_pmos ad=0.3808p pd=2.92u as=0.3808p ps=2.92u w=1.12u l=0.13u
X471 VPWR.t897 sg13cmos5l_inv_1_843.A sg13cmos5l_inv_1_843.Y VPWR.t39 sg13_lv_pmos ad=0.3808p pd=2.92u as=0.3808p ps=2.92u w=1.12u l=0.13u
X472 VGND.t322 sg13cmos5l_inv_1_526.Y sg13cmos5l_inv_1_531.A VGND.t475 sg13_lv_nmos ad=0.2516p pd=2.16u as=0.2516p ps=2.16u w=0.74u l=0.13u
X473 sg13cmos5l_inv_1_948.A sg13cmos5l_inv_1_949.Y VGND.t3 VGND.t192 sg13_lv_nmos ad=0.2516p pd=2.16u as=0.2516p ps=2.16u w=0.74u l=0.13u
X474 VPWR.t491 sg13cmos5l_inv_1_517.A sg13cmos5l_inv_1_947.A VPWR.t2 sg13_lv_pmos ad=0.3808p pd=2.92u as=0.3808p ps=2.92u w=1.12u l=0.13u
X475 sg13cmos5l_inv_1_37.A sg13cmos5l_inv_1_1.Y VPWR.t294 VPWR.t8 sg13_lv_pmos ad=0.3808p pd=2.92u as=0.3808p ps=2.92u w=1.12u l=0.13u
X476 VGND.t480 sg13cmos5l_inv_1_762.Y sg13cmos5l_inv_1_733.A VGND.t479 sg13_lv_nmos ad=0.2516p pd=2.16u as=0.2516p ps=2.16u w=0.74u l=0.13u
X477 sg13cmos5l_inv_1_113.A sg13cmos5l_inv_1_118.Y VPWR.t488 VPWR.t29 sg13_lv_pmos ad=0.3808p pd=2.92u as=0.3808p ps=2.92u w=1.12u l=0.13u
X478 sg13cmos5l_inv_1_775.A sg13cmos5l_inv_1_771.Y VPWR.t484 VPWR.t39 sg13_lv_pmos ad=0.3808p pd=2.92u as=0.3808p ps=2.92u w=1.12u l=0.13u
X479 sg13cmos5l_inv_1_235.A sg13cmos5l_inv_1_236.Y VGND.t212 VGND.t11 sg13_lv_nmos ad=0.2516p pd=2.16u as=0.2516p ps=2.16u w=0.74u l=0.13u
X480 sg13cmos5l_inv_1_991.A sg13cmos5l_inv_1_990.Y VPWR.t598 VPWR.t29 sg13_lv_pmos ad=0.3808p pd=2.92u as=0.3808p ps=2.92u w=1.12u l=0.13u
X481 sg13cmos5l_nor3_1_1.B sg13cmos5l_nand2_1_1.B VGND.t188 VGND.t760 sg13_lv_nmos ad=0.2516p pd=2.16u as=0.2516p ps=2.16u w=0.74u l=0.13u
X482 a_8223_15994# sg13cmos5l_mux4_1_5.S0.t7 a_8086_15994# VGND.t1262 sg13_lv_nmos ad=76.8f pd=0.88u as=0.1776p ps=1.195u w=0.64u l=0.13u
X483 VGND.t92 sg13cmos5l_mux4_1_14.A3 a_14559_14482# VGND.t422 sg13_lv_nmos ad=0.2176p pd=1.96u as=76.8f ps=0.88u w=0.64u l=0.13u
X484 VGND.t5 sg13cmos5l_inv_1_350.Y sg13cmos5l_inv_1_974.A VGND.t4 sg13_lv_nmos ad=0.2516p pd=2.16u as=0.2516p ps=2.16u w=0.74u l=0.13u
X485 VPWR.t276 sg13cmos5l_buf_1_23.X a_18856_16752# VPWR.t42 sg13_lv_pmos ad=0.2114p pd=1.54u as=0.2856p ps=2.36u w=0.84u l=0.13u
X486 VGND.t155 VPWR.t1581 VGND.t155 VGND.t1541 sg13_lv_nmos ad=79.8f pd=0.8u as=0 ps=0 w=0.42u l=1u
X487 VGND.t39 sg13cmos5l_inv_1_713.A sg13cmos5l_inv_1_696.A VGND.t790 sg13_lv_nmos ad=0.2516p pd=2.16u as=0.2516p ps=2.16u w=0.74u l=0.13u
X488 VGND.t449 sg13cmos5l_inv_1_340.Y sg13cmos5l_inv_1_375.Y VGND.t914 sg13_lv_nmos ad=0.2516p pd=2.16u as=0.2516p ps=2.16u w=0.74u l=0.13u
X489 sg13cmos5l_inv_1_187.Y sg13cmos5l_inv_1_187.A VPWR.t1239 VPWR.t49 sg13_lv_pmos ad=0.3808p pd=2.92u as=0.3808p ps=2.92u w=1.12u l=0.13u
X490 VPWR.t973 sg13cmos5l_inv_1_669.A sg13cmos5l_inv_1_664.A VPWR.t26 sg13_lv_pmos ad=0.3808p pd=2.92u as=0.3808p ps=2.92u w=1.12u l=0.13u
X491 VPWR.t480 sg13cmos5l_inv_1_66.A sg13cmos5l_inv_1_66.Y VPWR.t11 sg13_lv_pmos ad=0.3808p pd=2.92u as=0.3808p ps=2.92u w=1.12u l=0.13u
X492 sg13cmos5l_inv_1_557.A sg13cmos5l_inv_1_568.Y VPWR.t482 VPWR.t39 sg13_lv_pmos ad=0.3808p pd=2.92u as=0.3808p ps=2.92u w=1.12u l=0.13u
X493 VPWR.t690 sg13cmos5l_inv_1_768.A sg13cmos5l_inv_1_767.A VPWR.t21 sg13_lv_pmos ad=0.3808p pd=2.92u as=0.3808p ps=2.92u w=1.12u l=0.13u
X494 sg13cmos5l_inv_1_654.Y sg13cmos5l_mux4_1_7.A1 VGND.t412 VGND.t411 sg13_lv_nmos ad=0.2516p pd=2.16u as=0.2516p ps=2.16u w=0.74u l=0.13u
X495 sg13cmos5l_inv_1_97.Y sg13cmos5l_inv_1_61.Y VGND.t292 VGND.t1322 sg13_lv_nmos ad=0.2516p pd=2.16u as=0.2516p ps=2.16u w=0.74u l=0.13u
X496 VGND.t123 sg13cmos5l_inv_1_70.A sg13cmos5l_inv_1_70.Y VGND.t1137 sg13_lv_nmos ad=0.2516p pd=2.16u as=0.2516p ps=2.16u w=0.74u l=0.13u
X497 sg13cmos5l_inv_1_523.Y sg13cmos5l_inv_1_515.Y VPWR.t404 VPWR.t2 sg13_lv_pmos ad=0.3808p pd=2.92u as=0.3808p ps=2.92u w=1.12u l=0.13u
X498 sg13cmos5l_mux4_1_7.A1 sg13cmos5l_inv_1_676.Y VPWR.t1052 VPWR.t26 sg13_lv_pmos ad=0.3808p pd=2.92u as=0.3808p ps=2.92u w=1.12u l=0.13u
X499 sg13cmos5l_mux4_1_12.A1 sg13cmos5l_inv_1_711.Y VGND.t229 VGND.t1108 sg13_lv_nmos ad=0.2516p pd=2.16u as=0.2516p ps=2.16u w=0.74u l=0.13u
X500 sg13cmos5l_inv_1_313.Y sg13cmos5l_inv_1_309.Y VGND.t260 VGND.t259 sg13_lv_nmos ad=0.2516p pd=2.16u as=0.2516p ps=2.16u w=0.74u l=0.13u
X501 VGND.t612 sg13cmos5l_nor4_1_0.Y a_9996_11500# VGND.t924 sg13_lv_nmos ad=0.15745p pd=1.175u as=0.1216p ps=1.02u w=0.64u l=0.13u
X502 VPWR.t792 sg13cmos5l_buf_1_9.A.t3 a_7981_12976# VPWR.t26 sg13_lv_pmos ad=0.34367p pd=1.775u as=0.34p ps=2.68u w=1u l=0.13u
X503 sg13cmos5l_inv_1_318.Y sg13cmos5l_inv_1_319.Y VGND.t19 VGND.t1418 sg13_lv_nmos ad=0.2516p pd=2.16u as=0.2516p ps=2.16u w=0.74u l=0.13u
X504 VPWR.t1322 sg13cmos5l_inv_1_422.A sg13cmos5l_inv_1_449.A VPWR.t49 sg13_lv_pmos ad=0.3808p pd=2.92u as=0.3808p ps=2.92u w=1.12u l=0.13u
X505 VGND.t866 sg13cmos5l_inv_1_532.Y a_4575_12606# VGND.t1241 sg13_lv_nmos ad=0.2176p pd=1.96u as=76.8f ps=0.88u w=0.64u l=0.13u
X506 sg13cmos5l_mux4_1_4.A2 sg13cmos5l_inv_1_970.A VPWR.t1307 VPWR.t29 sg13_lv_pmos ad=0.3808p pd=2.92u as=0.3808p ps=2.92u w=1.12u l=0.13u
X507 VGND.t126 sg13cmos5l_inv_1_753.A sg13cmos5l_inv_1_752.A VGND.t1155 sg13_lv_nmos ad=0.2516p pd=2.16u as=0.2516p ps=2.16u w=0.74u l=0.13u
X508 a_4929_16036# sg13cmos5l_buf_1_9.A.t7 a_4438_15994# VGND.t672 sg13_lv_nmos ad=0.1216p pd=1.02u as=0.54188p ps=3.42u w=0.64u l=0.13u
X509 a_4929_12564# sg13cmos5l_buf_1_10.A a_4438_12606# VGND.t1105 sg13_lv_nmos ad=0.1216p pd=1.02u as=0.54188p ps=3.42u w=0.64u l=0.13u
X510 VGND.t23 VPWR.t1611 VGND.t23 VGND.t22 sg13_lv_nmos ad=79.8f pd=0.8u as=0 ps=0 w=0.42u l=1u
X511 sg13cmos5l_inv_1_471.Y sg13cmos5l_inv_1_474.Y VGND.t269 VGND.t903 sg13_lv_nmos ad=0.2516p pd=2.16u as=0.2516p ps=2.16u w=0.74u l=0.13u
X512 VPWR.t272 sg13cmos5l_inv_1_147.Y sg13cmos5l_inv_1_148.A VPWR.t0 sg13_lv_pmos ad=0.3808p pd=2.92u as=0.3808p ps=2.92u w=1.12u l=0.13u
X513 VPWR.t1086 sg13cmos5l_inv_1_393.A sg13cmos5l_inv_1_393.Y VPWR.t14 sg13_lv_pmos ad=0.3808p pd=2.92u as=0.3808p ps=2.92u w=1.12u l=0.13u
X514 sg13cmos5l_inv_1_853.Y sg13cmos5l_inv_1_854.Y VPWR.t819 VPWR.t42 sg13_lv_pmos ad=0.3808p pd=2.92u as=0.3808p ps=2.92u w=1.12u l=0.13u
X515 sg13cmos5l_inv_1_463.Y sg13cmos5l_inv_1_461.Y VGND.t343 VGND.t11 sg13_lv_nmos ad=0.2516p pd=2.16u as=0.2516p ps=2.16u w=0.74u l=0.13u
X516 sg13cmos5l_inv_1_953.Y sg13cmos5l_inv_1_959.Y VPWR.t959 VPWR.t29 sg13_lv_pmos ad=0.3808p pd=2.92u as=0.3808p ps=2.92u w=1.12u l=0.13u
X517 VGND.t6 sg13cmos5l_inv_1_976.A sg13cmos5l_inv_1_976.Y VGND.t4 sg13_lv_nmos ad=0.2516p pd=2.16u as=0.2516p ps=2.16u w=0.74u l=0.13u
X518 sg13cmos5l_o21ai_1_0.B1 sg13cmos5l_nor2b_1_0.A a_1228_15240# VPWR.t21 sg13_lv_pmos ad=0.3808p pd=2.92u as=0.1176p ps=1.33u w=1.12u l=0.13u
X519 VGND.t621 sg13cmos5l_inv_1_63.A sg13cmos5l_inv_1_66.A VGND.t1116 sg13_lv_nmos ad=0.2516p pd=2.16u as=0.2516p ps=2.16u w=0.74u l=0.13u
X520 sg13cmos5l_mux2_1_3.X a_9982_8050# VGND.t105 VGND.t104 sg13_lv_nmos ad=0.4033p pd=2.57u as=0.148p ps=1.14u w=0.74u l=0.13u
X521 a_9432_3406# sg13cmos5l_mux2_1_4.S VGND.t73 VGND.t1215 sg13_lv_nmos ad=0.187p pd=1.78u as=0.18945p ps=1.27u w=0.55u l=0.13u
X522 VPWR.t1106 sg13cmos5l_nor3_1_1.A a_9004_12216# VPWR.t2 sg13_lv_pmos ad=0.4032p pd=2.96u as=0.1176p ps=1.33u w=1.12u l=0.13u
X523 sg13cmos5l_inv_1_756.Y sg13cmos5l_inv_1_748.Y VGND.t41 VGND.t1649 sg13_lv_nmos ad=0.2516p pd=2.16u as=0.2516p ps=2.16u w=0.74u l=0.13u
X524 VGND.t117 sg13cmos5l_inv_1_427.Y sg13cmos5l_inv_1_438.A VGND.t11 sg13_lv_nmos ad=0.2516p pd=2.16u as=0.2516p ps=2.16u w=0.74u l=0.13u
X525 sg13cmos5l_inv_1_762.Y sg13cmos5l_inv_1_757.Y VPWR.t584 VPWR.t2 sg13_lv_pmos ad=0.3808p pd=2.92u as=0.3808p ps=2.92u w=1.12u l=0.13u
X526 VPWR.t143 sg13cmos5l_inv_1_296.A sg13cmos5l_inv_1_296.Y VPWR.t11 sg13_lv_pmos ad=0.3808p pd=2.92u as=0.3808p ps=2.92u w=1.12u l=0.13u
X527 sg13cmos5l_inv_1_433.A sg13cmos5l_inv_1_462.Y VPWR.t1428 VPWR.t0 sg13_lv_pmos ad=0.3808p pd=2.92u as=0.3808p ps=2.92u w=1.12u l=0.13u
X528 sg13cmos5l_inv_1_616.Y sg13cmos5l_inv_1_616.A VPWR.t759 VPWR.t42 sg13_lv_pmos ad=0.3808p pd=2.92u as=0.3808p ps=2.92u w=1.12u l=0.13u
X529 sg13cmos5l_inv_1_896.Y sg13cmos5l_inv_1_891.Y VPWR.t402 VPWR.t26 sg13_lv_pmos ad=0.3808p pd=2.92u as=0.3808p ps=2.92u w=1.12u l=0.13u
X530 VPWR.t313 sg13cmos5l_mux4_1_5.S0.t6 a_6599_12970# VPWR.t26 sg13_lv_pmos ad=0.22315p pd=1.555u as=0.34p ps=2.68u w=1u l=0.13u
X531 VGND.t1565 VPWR.t1563 VGND.t1564 VGND.t190 sg13_lv_nmos ad=0.1428p pd=1.52u as=0 ps=0 w=0.42u l=1u
X532 VPWR.t493 sg13cmos5l_inv_1_429.A sg13cmos5l_inv_1_426.A VPWR.t49 sg13_lv_pmos ad=0.3808p pd=2.92u as=0.3808p ps=2.92u w=1.12u l=0.13u
X533 VGND.t754 VPWR.t1536 VGND.t754 VGND.t1591 sg13_lv_nmos ad=0.1428p pd=1.52u as=0 ps=0 w=0.42u l=1u
X534 VGND.t126 VPWR.t1585 VGND.t126 VGND.t1534 sg13_lv_nmos ad=0.1428p pd=1.52u as=0 ps=0 w=0.42u l=1u
X535 sg13cmos5l_buf_1_4.X a_18664_6956# VGND.t335 VGND.t1102 sg13_lv_nmos ad=0.2886p pd=2.26u as=0.14875p ps=1.16u w=0.74u l=0.13u
X536 VGND.t160 invsel[4] a_808_13004# VGND.t1483 sg13_lv_nmos ad=0.14875p pd=1.16u as=0.187p ps=1.78u w=0.55u l=0.13u
X537 VGND.t197 VPWR.t1613 VGND.t197 VGND.t22 sg13_lv_nmos ad=0.1428p pd=1.52u as=0 ps=0 w=0.42u l=1u
X538 a_10162_9570# sg13cmos5l_nand2_1_1.Y VGND.t191 VGND.t4 sg13_lv_nmos ad=0.2516p pd=2.16u as=0.1406p ps=1.12u w=0.74u l=0.15u
X539 sg13cmos5l_inv_1_623.Y sg13cmos5l_inv_1_624.Y VPWR.t724 VPWR.t42 sg13_lv_pmos ad=0.3808p pd=2.92u as=0.3808p ps=2.92u w=1.12u l=0.13u
X540 VGND.t527 sg13cmos5l_inv_1_689.A sg13cmos5l_inv_1_689.Y VGND.t589 sg13_lv_nmos ad=0.2516p pd=2.16u as=0.2516p ps=2.16u w=0.74u l=0.13u
X541 VGND.t133 sg13cmos5l_inv_1_485.Y sg13cmos5l_inv_1_496.A VGND.t1301 sg13_lv_nmos ad=0.2516p pd=2.16u as=0.2516p ps=2.16u w=0.74u l=0.13u
X542 VGND.t225 VPWR.t1532 VGND.t225 VGND.t11 sg13_lv_nmos ad=0.1428p pd=1.52u as=0 ps=0 w=0.42u l=1u
X543 VPWR.t906 VGND.t225 VPWR.t905 VPWR.t49 sg13_lv_pmos ad=0.34p pd=2.68u as=0 ps=0 w=1u l=1u
X544 sg13cmos5l_inv_1_602.Y sg13cmos5l_inv_1_601.Y VPWR.t479 VPWR.t39 sg13_lv_pmos ad=0.3808p pd=2.92u as=0.3808p ps=2.92u w=1.12u l=0.13u
X545 VPWR.t964 sg13cmos5l_inv_1_525.A a_4141_12267# VPWR.t2 sg13_lv_pmos ad=0.29275p pd=1.785u as=0.16p ps=1.32u w=1u l=0.13u
X546 VGND.t107 VPWR.t1543 VGND.t107 VGND.t1590 sg13_lv_nmos ad=0.1428p pd=1.52u as=0 ps=0 w=0.42u l=1u
X547 VGND.t162 sg13cmos5l_mux4_1_5.S0.t5 a_6119_8434# VGND.t856 sg13_lv_nmos ad=0.1872p pd=1.225u as=0.2176p ps=1.96u w=0.64u l=0.13u
X548 VGND.t39 sg13cmos5l_inv_1_717.A sg13cmos5l_inv_1_716.A VGND.t121 sg13_lv_nmos ad=0.2516p pd=2.16u as=0.2516p ps=2.16u w=0.74u l=0.13u
X549 VGND.t322 sg13cmos5l_inv_1_525.A sg13cmos5l_inv_1_526.A VGND.t906 sg13_lv_nmos ad=0.2516p pd=2.16u as=0.2516p ps=2.16u w=0.74u l=0.13u
X550 sg13cmos5l_inv_1_332.A sg13cmos5l_inv_1_301.A VPWR.t143 VPWR.t11 sg13_lv_pmos ad=0.3808p pd=2.92u as=0.3808p ps=2.92u w=1.12u l=0.13u
X551 VPWR.t657 sg13cmos5l_buf_1_7.X a_2920_3932# VPWR.t49 sg13_lv_pmos ad=0.2114p pd=1.54u as=0.2856p ps=2.36u w=0.84u l=0.13u
X552 VGND.t310 sg13cmos5l_inv_1_599.Y sg13cmos5l_inv_1_588.A VGND.t311 sg13_lv_nmos ad=0.2516p pd=2.16u as=0.2516p ps=2.16u w=0.74u l=0.13u
X553 a_15201_15588# sg13cmos5l_mux2_1_4.S.t5 a_14710_15630# VGND.t1639 sg13_lv_nmos ad=0.1216p pd=1.02u as=0.54188p ps=3.42u w=0.64u l=0.13u
X554 sg13cmos5l_inv_1_227.A sg13cmos5l_inv_1_206.Y VGND.t16 VGND.t11 sg13_lv_nmos ad=0.2516p pd=2.16u as=0.2516p ps=2.16u w=0.74u l=0.13u
X555 VPWR.t639 sg13cmos5l_inv_1_19.A sg13cmos5l_inv_1_14.A VPWR.t11 sg13_lv_pmos ad=0.3808p pd=2.92u as=0.3808p ps=2.92u w=1.12u l=0.13u
X556 VPWR.t1414 sg13cmos5l_inv_1_320.A sg13cmos5l_inv_1_320.Y VPWR.t8 sg13_lv_pmos ad=0.3808p pd=2.92u as=0.3808p ps=2.92u w=1.12u l=0.13u
X557 a_15834_4192# a_15768_4088# VPWR.t642 VPWR.t49 sg13_lv_pmos ad=0.2975p pd=1.595u as=0.2198p ps=1.52u w=1u l=0.13u
X558 a_9061_6219# sg13cmos5l_mux4_1_16.A2 VPWR.t500 VPWR.t0 sg13_lv_pmos ad=0.20762p pd=1.605u as=0.29275p ps=1.785u w=1u l=0.13u
X559 sg13cmos5l_inv_1_679.A sg13cmos5l_inv_1_534.Y VPWR.t892 VPWR.t39 sg13_lv_pmos ad=0.3808p pd=2.92u as=0.3808p ps=2.92u w=1.12u l=0.13u
X560 VPWR.t1058 sg13cmos5l_inv_1_731.Y sg13cmos5l_inv_1_757.Y VPWR.t2 sg13_lv_pmos ad=0.3808p pd=2.92u as=0.3808p ps=2.92u w=1.12u l=0.13u
X561 sg13cmos5l_inv_1_144.Y sg13cmos5l_inv_1_181.Y VGND.t335 VGND.t1420 sg13_lv_nmos ad=0.2516p pd=2.16u as=0.2516p ps=2.16u w=0.74u l=0.13u
X562 VPWR.t1191 sg13cmos5l_inv_1_350.Y sg13cmos5l_inv_1_974.A VPWR.t29 sg13_lv_pmos ad=0.3808p pd=2.92u as=0.3808p ps=2.92u w=1.12u l=0.13u
X563 sg13cmos5l_inv_1_847.Y sg13cmos5l_inv_1_846.Y VPWR.t296 VPWR.t42 sg13_lv_pmos ad=0.3808p pd=2.92u as=0.3808p ps=2.92u w=1.12u l=0.13u
X564 a_3847_16261# sg13cmos5l_inv_1_565.Y VPWR.t1273 VPWR.t42 sg13_lv_pmos ad=0.415p pd=1.83u as=0.22315p ps=1.555u w=1u l=0.13u
X565 VPWR.t1096 sg13cmos5l_inv_1_674.A sg13cmos5l_inv_1_675.A VPWR.t26 sg13_lv_pmos ad=0.3808p pd=2.92u as=0.3808p ps=2.92u w=1.12u l=0.13u
X566 VGND.t503 sg13cmos5l_inv_1_557.Y sg13cmos5l_inv_1_564.A VGND.t813 sg13_lv_nmos ad=0.2516p pd=2.16u as=0.2516p ps=2.16u w=0.74u l=0.13u
X567 sg13cmos5l_inv_1_656.Y sg13cmos5l_inv_1_655.Y VGND.t412 VGND.t1413 sg13_lv_nmos ad=0.2516p pd=2.16u as=0.2516p ps=2.16u w=0.74u l=0.13u
X568 sg13cmos5l_inv_1_513.A sg13cmos5l_inv_1_527.A VGND.t160 VGND.t948 sg13_lv_nmos ad=0.2516p pd=2.16u as=0.2516p ps=2.16u w=0.74u l=0.13u
X569 VPWR.t625 sg13cmos5l_inv_1_272.A sg13cmos5l_inv_1_325.A VPWR.t8 sg13_lv_pmos ad=0.3808p pd=2.92u as=0.3808p ps=2.92u w=1.12u l=0.13u
X570 VGND.t123 sg13cmos5l_inv_1_66.A sg13cmos5l_inv_1_66.Y VGND.t327 sg13_lv_nmos ad=0.2516p pd=2.16u as=0.2516p ps=2.16u w=0.74u l=0.13u
X571 VGND.t723 sg13cmos5l_inv_1_634.A sg13cmos5l_inv_1_633.A VGND.t1006 sg13_lv_nmos ad=0.2516p pd=2.16u as=0.2516p ps=2.16u w=0.74u l=0.13u
X572 VGND.t288 sg13cmos5l_inv_1_305.A a_4052_3534# VGND.t1479 sg13_lv_nmos ad=0.1824p pd=1.21u as=0.2304p ps=1.36u w=0.64u l=0.13u
X573 a_7117_13237# a_6599_12970# a_6910_12970# VPWR.t26 sg13_lv_pmos ad=0.16p pd=1.32u as=0.19p ps=1.38u w=1u l=0.13u
X574 VPWR.t446 sg13cmos5l_buf_1_9.A a_4072_3932# VPWR.t49 sg13_lv_pmos ad=0.2114p pd=1.54u as=0.2856p ps=2.36u w=0.84u l=0.13u
X575 VPWR.t1062 sg13cmos5l_inv_1_378.Y sg13cmos5l_inv_1_350.A VPWR.t29 sg13_lv_pmos ad=0.3808p pd=2.92u as=0.3808p ps=2.92u w=1.12u l=0.13u
X576 VGND.t10 sg13cmos5l_inv_1_988.A sg13cmos5l_mux4_1_15.A2 VGND.t152 sg13_lv_nmos ad=0.2516p pd=2.16u as=0.2516p ps=2.16u w=0.74u l=0.13u
X577 VPWR.t557 sg13cmos5l_mux4_1_14.A3 a_14645_14795# VPWR.t21 sg13_lv_pmos ad=0.34p pd=2.68u as=0.135p ps=1.27u w=1u l=0.13u
X578 VPWR.t798 sg13cmos5l_mux2_1_4.S.t2 a_14989_3904# VPWR.t49 sg13_lv_pmos ad=0.34367p pd=1.775u as=0.34p ps=2.68u w=1u l=0.13u
X579 sg13cmos5l_buf_1_0.A sg13cmos5l_inv_1_120.Y VPWR.t429 VPWR.t14 sg13_lv_pmos ad=0.3808p pd=2.92u as=0.3808p ps=2.92u w=1.12u l=0.13u
X580 sg13cmos5l_inv_1_594.Y sg13cmos5l_inv_1_595.Y VGND.t310 VGND.t1452 sg13_lv_nmos ad=0.2516p pd=2.16u as=0.2516p ps=2.16u w=0.74u l=0.13u
X581 sg13cmos5l_inv_1_720.Y sg13cmos5l_inv_1_723.Y VGND.t1163 VGND.t1162 sg13_lv_nmos ad=0.2516p pd=2.16u as=0.2516p ps=2.16u w=0.74u l=0.13u
X582 VPWR.t516 sg13cmos5l_inv_1_981.A sg13cmos5l_inv_1_981.Y VPWR.t11 sg13_lv_pmos ad=0.3808p pd=2.92u as=0.3808p ps=2.92u w=1.12u l=0.13u
X583 sg13cmos5l_inv_1_165.Y sg13cmos5l_inv_1_171.Y VPWR.t1127 VPWR.t29 sg13_lv_pmos ad=0.3808p pd=2.92u as=0.3808p ps=2.92u w=1.12u l=0.13u
X584 VGND.t435 VPWR.t1516 VGND.t435 VGND.t1624 sg13_lv_nmos ad=0.1428p pd=1.52u as=0 ps=0 w=0.42u l=1u
X585 VPWR.t497 sg13cmos5l_inv_1_59.Y sg13cmos5l_inv_1_102.Y VPWR.t8 sg13_lv_pmos ad=0.3808p pd=2.92u as=0.3808p ps=2.92u w=1.12u l=0.13u
X586 VPWR.t197 VGND.t212 VPWR.t196 VPWR.t49 sg13_lv_pmos ad=0.34p pd=2.68u as=0 ps=0 w=1u l=1u
X587 VPWR.t622 sg13cmos5l_inv_1_542.A sg13cmos5l_inv_1_541.A VPWR.t39 sg13_lv_pmos ad=0.3808p pd=2.92u as=0.3808p ps=2.92u w=1.12u l=0.13u
X588 VGND.t478 VPWR.t1583 VGND.t478 VGND.t1537 sg13_lv_nmos ad=0.1428p pd=1.52u as=0 ps=0 w=0.42u l=1u
X589 VPWR.t1227 sg13cmos5l_mux4_1_5.S0.t7 a_7271_15994# VPWR.t42 sg13_lv_pmos ad=0.22315p pd=1.555u as=0.34p ps=2.68u w=1u l=0.13u
X590 sg13cmos5l_inv_1_728.Y sg13cmos5l_inv_1_715.Y VGND.t315 VGND.t1468 sg13_lv_nmos ad=0.2516p pd=2.16u as=0.2516p ps=2.16u w=0.74u l=0.13u
X591 VPWR.t128 VGND.t153 VPWR.t126 VPWR.t5 sg13_lv_pmos ad=0.19p pd=1.38u as=0 ps=0 w=1u l=1u
X592 VPWR.t1357 sg13cmos5l_inv_1_241.Y sg13cmos5l_inv_1_69.A VPWR.t49 sg13_lv_pmos ad=0.3808p pd=2.92u as=0.3808p ps=2.92u w=1.12u l=0.13u
X593 VGND.t107 sg13cmos5l_inv_1_418.Y sg13cmos5l_inv_1_383.Y VGND.t356 sg13_lv_nmos ad=0.2516p pd=2.16u as=0.2516p ps=2.16u w=0.74u l=0.13u
X594 VGND.t153 VPWR.t1565 VGND.t153 VGND.t190 sg13_lv_nmos ad=79.8f pd=0.8u as=0 ps=0 w=0.42u l=1u
X595 sg13cmos5l_inv_1_851.Y sg13cmos5l_inv_1_851.A VPWR.t417 VPWR.t42 sg13_lv_pmos ad=0.3808p pd=2.92u as=0.3808p ps=2.92u w=1.12u l=0.13u
X596 VGND.t250 sg13cmos5l_inv_1_641.A sg13cmos5l_inv_1_640.A VGND.t483 sg13_lv_nmos ad=0.2516p pd=2.16u as=0.2516p ps=2.16u w=0.74u l=0.13u
X597 VPWR.t46 VGND.t174 VPWR.t45 VPWR.t26 sg13_lv_pmos ad=0.19p pd=1.38u as=0 ps=0 w=1u l=1u
X598 sg13cmos5l_nor3_1_1.B sg13cmos5l_nand2_1_1.B VPWR.t825 VPWR.t5 sg13_lv_pmos ad=0.3808p pd=2.92u as=0.3808p ps=2.92u w=1.12u l=0.13u
X599 sg13cmos5l_inv_1_18.A sg13cmos5l_inv_1_24.Y VPWR.t421 VPWR.t11 sg13_lv_pmos ad=0.3808p pd=2.92u as=0.3808p ps=2.92u w=1.12u l=0.13u
X600 sg13cmos5l_inv_1_286.Y sg13cmos5l_inv_1_288.Y VPWR.t1295 VPWR.t8 sg13_lv_pmos ad=0.3808p pd=2.92u as=0.3808p ps=2.92u w=1.12u l=0.13u
X601 VGND.t162 sg13cmos5l_inv_1_411.Y sg13cmos5l_inv_1_357.A VGND.t161 sg13_lv_nmos ad=0.2516p pd=2.16u as=0.2516p ps=2.16u w=0.74u l=0.13u
X602 VPWR.t286 sg13cmos5l_mux4_1_5.S0.t2 a_3623_3534# VPWR.t8 sg13_lv_pmos ad=0.22315p pd=1.555u as=0.34p ps=2.68u w=1u l=0.13u
X603 sg13cmos5l_inv_1_1004.Y sg13cmos5l_inv_1_400.Y VGND.t354 VGND.t904 sg13_lv_nmos ad=0.2516p pd=2.16u as=0.2516p ps=2.16u w=0.74u l=0.13u
X604 sg13cmos5l_inv_1_853.Y sg13cmos5l_inv_1_854.Y VGND.t116 VGND.t22 sg13_lv_nmos ad=0.2516p pd=2.16u as=0.2516p ps=2.16u w=0.74u l=0.13u
X605 VGND.t480 sg13cmos5l_mux4_1_12.A3 sg13cmos5l_inv_1_758.A VGND.t479 sg13_lv_nmos ad=0.2516p pd=2.16u as=0.2516p ps=2.16u w=0.74u l=0.13u
X606 sg13cmos5l_inv_1_546.Y sg13cmos5l_inv_1_543.Y VGND.t49 VGND.t48 sg13_lv_nmos ad=0.2516p pd=2.16u as=0.2516p ps=2.16u w=0.74u l=0.13u
X607 VPWR.t1071 sg13cmos5l_inv_1_714.A sg13cmos5l_inv_1_712.A VPWR.t2 sg13_lv_pmos ad=0.3808p pd=2.92u as=0.3808p ps=2.92u w=1.12u l=0.13u
X608 a_14422_3898# a_13607_3898# a_14346_3898# VGND.t606 sg13_lv_nmos ad=0.1776p pd=1.195u as=80f ps=0.89u w=0.64u l=0.13u
X609 VPWR.t592 sg13cmos5l_inv_1_357.A sg13cmos5l_inv_1_356.A VPWR.t29 sg13_lv_pmos ad=0.3808p pd=2.92u as=0.3808p ps=2.92u w=1.12u l=0.13u
X610 sg13cmos5l_inv_1_509.Y sg13cmos5l_inv_1_509.A VPWR.t1148 VPWR.t26 sg13_lv_pmos ad=0.3808p pd=2.92u as=0.3808p ps=2.92u w=1.12u l=0.13u
X611 a_18764_5370# sg13cmos5l_inv_1_217.A VPWR.t390 VPWR.t0 sg13_lv_pmos ad=0.2856p pd=2.36u as=0.2114p ps=1.54u w=0.84u l=0.13u
X612 sg13cmos5l_inv_1_654.Y sg13cmos5l_mux4_1_7.A1 VPWR.t549 VPWR.t26 sg13_lv_pmos ad=0.3808p pd=2.92u as=0.3808p ps=2.92u w=1.12u l=0.13u
X613 VGND.t547 sg13cmos5l_inv_1_6.Y sg13cmos5l_inv_1_38.Y VGND.t546 sg13_lv_nmos ad=0.2516p pd=2.16u as=0.2516p ps=2.16u w=0.74u l=0.13u
X614 sg13cmos5l_inv_1_300.Y sg13cmos5l_inv_1_298.Y VPWR.t143 VPWR.t11 sg13_lv_pmos ad=0.3808p pd=2.92u as=0.3808p ps=2.92u w=1.12u l=0.13u
X615 VPWR.t465 sg13cmos5l_inv_1_976.A sg13cmos5l_inv_1_976.Y VPWR.t29 sg13_lv_pmos ad=0.3808p pd=2.92u as=0.3808p ps=2.92u w=1.12u l=0.13u
X616 VGND.t26 a_18764_12180# sg13cmos5l_buf_1_18.A VGND.t738 sg13_lv_nmos ad=0.14875p pd=1.16u as=0.2886p ps=2.26u w=0.74u l=0.13u
X617 sg13cmos5l_inv_1_133.Y sg13cmos5l_inv_1_132.Y VPWR.t958 VPWR.t14 sg13_lv_pmos ad=0.3808p pd=2.92u as=0.3808p ps=2.92u w=1.12u l=0.13u
X618 sg13cmos5l_mux4_1_12.A1 sg13cmos5l_inv_1_711.Y VPWR.t1137 VPWR.t26 sg13_lv_pmos ad=0.3808p pd=2.92u as=0.3808p ps=2.92u w=1.12u l=0.13u
X619 VGND.t52 sg13cmos5l_inv_1_296.A sg13cmos5l_inv_1_296.Y VGND.t1277 sg13_lv_nmos ad=0.2516p pd=2.16u as=0.2516p ps=2.16u w=0.74u l=0.13u
X620 sg13cmos5l_inv_1_90.Y sg13cmos5l_inv_1_86.Y VGND.t123 VGND.t1656 sg13_lv_nmos ad=0.2516p pd=2.16u as=0.2516p ps=2.16u w=0.74u l=0.13u
X621 VPWR.t139 sg13cmos5l_inv_1_304.A sg13cmos5l_inv_1_304.Y VPWR.t11 sg13_lv_pmos ad=0.3808p pd=2.92u as=0.3808p ps=2.92u w=1.12u l=0.13u
X622 VGND.t16 sg13cmos5l_inv_1_185.A sg13cmos5l_inv_1_185.Y VGND.t11 sg13_lv_nmos ad=0.2516p pd=2.16u as=0.2516p ps=2.16u w=0.74u l=0.13u
X623 VGND.t126 sg13cmos5l_inv_1_747.Y sg13cmos5l_inv_1_750.Y VGND.t494 sg13_lv_nmos ad=0.2516p pd=2.16u as=0.2516p ps=2.16u w=0.74u l=0.13u
X624 sg13cmos5l_inv_1_310.Y sg13cmos5l_inv_1_306.Y VGND.t352 VGND.t542 sg13_lv_nmos ad=0.2516p pd=2.16u as=0.2516p ps=2.16u w=0.74u l=0.13u
X625 sg13cmos5l_inv_1_347.Y sg13cmos5l_inv_1_348.Y VGND.t430 VGND.t1061 sg13_lv_nmos ad=0.2516p pd=2.16u as=0.2516p ps=2.16u w=0.74u l=0.13u
X626 VGND.t174 sg13cmos5l_inv_1_492.A sg13cmos5l_inv_1_491.A VGND.t1439 sg13_lv_nmos ad=0.2516p pd=2.16u as=0.2516p ps=2.16u w=0.74u l=0.13u
X627 sg13cmos5l_inv_1_86.Y sg13cmos5l_inv_1_84.Y VPWR.t450 VPWR.t8 sg13_lv_pmos ad=0.3808p pd=2.92u as=0.3808p ps=2.92u w=1.12u l=0.13u
X628 VPWR.t51 VGND.t54 VPWR.t50 VPWR.t49 sg13_lv_pmos ad=0.34p pd=2.68u as=0 ps=0 w=1u l=1u
X629 VGND.t396 sg13cmos5l_inv_1_90.Y sg13cmos5l_inv_1_89.Y VGND.t555 sg13_lv_nmos ad=0.2516p pd=2.16u as=0.2516p ps=2.16u w=0.74u l=0.13u
X630 sg13cmos5l_inv_1_471.Y sg13cmos5l_inv_1_474.Y VPWR.t960 VPWR.t5 sg13_lv_pmos ad=0.3808p pd=2.92u as=0.3808p ps=2.92u w=1.12u l=0.13u
X631 VPWR.t1029 sg13cmos5l_inv_1_416.Y sg13cmos5l_inv_1_427.A VPWR.t0 sg13_lv_pmos ad=0.3808p pd=2.92u as=0.3808p ps=2.92u w=1.12u l=0.13u
X632 a_3847_7731# sg13cmos5l_inv_1_421.A VPWR.t924 VPWR.t14 sg13_lv_pmos ad=0.415p pd=1.83u as=0.22315p ps=1.555u w=1u l=0.13u
X633 VGND.t269 sg13cmos5l_inv_1_490.A sg13cmos5l_inv_1_489.A VGND.t1181 sg13_lv_nmos ad=0.2516p pd=2.16u as=0.2516p ps=2.16u w=0.74u l=0.13u
X634 VPWR.t1411 sg13cmos5l_inv_1_783.A sg13cmos5l_inv_1_782.A VPWR.t39 sg13_lv_pmos ad=0.3808p pd=2.92u as=0.3808p ps=2.92u w=1.12u l=0.13u
X635 VPWR.t844 sg13cmos5l_inv_1_510.Y sg13cmos5l_inv_1_685.Y VPWR.t21 sg13_lv_pmos ad=0.3808p pd=2.92u as=0.3808p ps=2.92u w=1.12u l=0.13u
X636 VPWR.t83 VGND.t529 VPWR.t82 VPWR.t26 sg13_lv_pmos ad=0.34p pd=2.68u as=0 ps=0 w=1u l=1u
X637 VGND.t147 sg13cmos5l_inv_1_677.A sg13cmos5l_inv_1_677.Y VGND.t445 sg13_lv_nmos ad=0.2516p pd=2.16u as=0.2516p ps=2.16u w=0.74u l=0.13u
X638 VGND.t225 VPWR.t1531 VGND.t225 VGND.t11 sg13_lv_nmos ad=0.1428p pd=1.52u as=0 ps=0 w=0.42u l=1u
X639 sg13cmos5l_mux4_1_11.A3 a_15201_15588# VPWR.t1386 VPWR.t21 sg13_lv_pmos ad=0.3808p pd=2.92u as=0.34367p ps=1.775u w=1.12u l=0.13u
X640 a_10159_7704# sg13cmos5l_mux4_1_16.X a_9982_8050# VPWR.t14 sg13_lv_pmos ad=0.2975p pd=1.595u as=0.2225p ps=1.445u w=1u l=0.13u
X641 sg13cmos5l_inv_1_45.Y sg13cmos5l_inv_1_53.Y VGND.t596 VGND.t1132 sg13_lv_nmos ad=0.2516p pd=2.16u as=0.2516p ps=2.16u w=0.74u l=0.13u
X642 a_14827_11673# sg13cmos5l_nor3_1_2.B.t2 VGND.t184 VGND.t779 sg13_lv_nmos ad=0.2176p pd=1.96u as=0.1872p ps=1.225u w=0.64u l=0.13u
X643 sg13cmos5l_inv_1_332.A sg13cmos5l_inv_1_301.A VGND.t52 VGND.t1145 sg13_lv_nmos ad=0.2516p pd=2.16u as=0.2516p ps=2.16u w=0.74u l=0.13u
X644 sg13cmos5l_inv_1_53.Y sg13cmos5l_inv_1_48.Y VPWR.t1432 VPWR.t8 sg13_lv_pmos ad=0.3808p pd=2.92u as=0.3808p ps=2.92u w=1.12u l=0.13u
X645 VPWR.t79 VGND.t126 VPWR.t78 VPWR.t2 sg13_lv_pmos ad=0.34p pd=2.68u as=0 ps=0 w=1u l=1u
X646 VPWR.t260 sg13cmos5l_inv_1_929.A sg13cmos5l_inv_1_988.A VPWR.t5 sg13_lv_pmos ad=0.3808p pd=2.92u as=0.3808p ps=2.92u w=1.12u l=0.13u
X647 VPWR.t1223 sg13cmos5l_inv_1_572.A sg13cmos5l_inv_1_571.A VPWR.t42 sg13_lv_pmos ad=0.3808p pd=2.92u as=0.3808p ps=2.92u w=1.12u l=0.13u
X648 VPWR.t1433 sg13cmos5l_buf_1_8.A.t1 a_16094_4192# VPWR.t49 sg13_lv_pmos ad=0.253p pd=1.53u as=0.3325p ps=1.665u w=1u l=0.13u
X649 sg13cmos5l_inv_1_73.A sg13cmos5l_inv_1_67.Y VPWR.t1282 VPWR.t11 sg13_lv_pmos ad=0.3808p pd=2.92u as=0.3808p ps=2.92u w=1.12u l=0.13u
X650 sg13cmos5l_inv_1_99.Y sg13cmos5l_inv_1_98.Y VGND.t396 VGND.t1398 sg13_lv_nmos ad=0.2516p pd=2.16u as=0.2516p ps=2.16u w=0.74u l=0.13u
X651 sg13cmos5l_inv_1_459.A sg13cmos5l_inv_1_433.Y VPWR.t875 VPWR.t0 sg13_lv_pmos ad=0.3808p pd=2.92u as=0.3808p ps=2.92u w=1.12u l=0.13u
X652 sg13cmos5l_inv_1_107.Y sg13cmos5l_inv_1_128.Y VGND.t157 VGND.t156 sg13_lv_nmos ad=0.2516p pd=2.16u as=0.2516p ps=2.16u w=0.74u l=0.13u
X653 a_14125_4165# a_13607_3898# a_13918_3898# VPWR.t49 sg13_lv_pmos ad=0.16p pd=1.32u as=0.19p ps=1.38u w=1u l=0.13u
X654 VGND.t94 sg13cmos5l_inv_1_575.A sg13cmos5l_inv_1_575.Y VGND.t93 sg13_lv_nmos ad=0.2516p pd=2.16u as=0.2516p ps=2.16u w=0.74u l=0.13u
X655 sg13cmos5l_inv_1_791.A sg13cmos5l_inv_1_608.Y VGND.t56 VGND.t22 sg13_lv_nmos ad=0.2516p pd=2.16u as=0.2516p ps=2.16u w=0.74u l=0.13u
X656 VPWR.t1349 sg13cmos5l_inv_1_234.A sg13cmos5l_inv_1_233.A VPWR.t49 sg13_lv_pmos ad=0.3808p pd=2.92u as=0.3808p ps=2.92u w=1.12u l=0.13u
X657 VPWR.t1456 sg13cmos5l_inv_1_560.A sg13cmos5l_inv_1_560.Y VPWR.t42 sg13_lv_pmos ad=0.3808p pd=2.92u as=0.3808p ps=2.92u w=1.12u l=0.13u
X658 VGND.t723 sg13cmos5l_inv_1_636.A sg13cmos5l_inv_1_635.A VGND.t1372 sg13_lv_nmos ad=0.2516p pd=2.16u as=0.2516p ps=2.16u w=0.74u l=0.13u
X659 a_14422_14482# sg13cmos5l_buf_1_9.A.t4 a_14341_14749# VPWR.t21 sg13_lv_pmos ad=0.4425p pd=1.885u as=0.20762p ps=1.605u w=1u l=0.13u
X660 VPWR.t738 sg13cmos5l_inv_1_240.Y sg13cmos5l_inv_1_243.A VPWR.t11 sg13_lv_pmos ad=0.3808p pd=2.92u as=0.3808p ps=2.92u w=1.12u l=0.13u
X661 a_8086_15994# sg13cmos5l_mux4_1_5.S0.t7 a_8005_16261# VPWR.t42 sg13_lv_pmos ad=0.4425p pd=1.885u as=0.20762p ps=1.605u w=1u l=0.13u
X662 VPWR.t304 sg13cmos5l_inv_1_883.A sg13cmos5l_inv_1_883.Y VPWR.t21 sg13_lv_pmos ad=0.3808p pd=2.92u as=0.3808p ps=2.92u w=1.12u l=0.13u
X663 a_6934_8434# a_7501_8440# a_7425_8476# VPWR.t29 sg13_lv_pmos ad=0.34p pd=2.68u as=0.2225p ps=1.445u w=1u l=0.13u
X664 VPWR.t327 sg13cmos5l_inv_1_717.A sg13cmos5l_inv_1_716.A VPWR.t5 sg13_lv_pmos ad=0.3808p pd=2.92u as=0.3808p ps=2.92u w=1.12u l=0.13u
X665 VPWR.t788 sg13cmos5l_inv_1_416.A sg13cmos5l_inv_1_416.Y VPWR.t49 sg13_lv_pmos ad=0.3808p pd=2.92u as=0.3808p ps=2.92u w=1.12u l=0.13u
X666 VPWR.t346 sg13cmos5l_inv_1_988.A sg13cmos5l_mux4_1_15.A2 VPWR.t29 sg13_lv_pmos ad=0.3808p pd=2.92u as=0.3808p ps=2.92u w=1.12u l=0.13u
X667 a_7414_12970# a_7981_12976# a_7905_13012# VPWR.t26 sg13_lv_pmos ad=0.34p pd=2.68u as=0.2225p ps=1.445u w=1u l=0.13u
X668 VPWR.t414 sg13cmos5l_inv_1_256.A sg13cmos5l_inv_1_251.A VPWR.t11 sg13_lv_pmos ad=0.3808p pd=2.92u as=0.3808p ps=2.92u w=1.12u l=0.13u
X669 sg13cmos5l_buf_1_0.A sg13cmos5l_inv_1_120.Y VGND.t267 VGND.t266 sg13_lv_nmos ad=0.2516p pd=2.16u as=0.2516p ps=2.16u w=0.74u l=0.13u
X670 sg13cmos5l_inv_1_950.A sg13cmos5l_inv_1_514.Y VPWR.t1443 VPWR.t2 sg13_lv_pmos ad=0.3808p pd=2.92u as=0.3808p ps=2.92u w=1.12u l=0.13u
X671 VPWR.t20 VGND.t939 VPWR.t19 VPWR.t0 sg13_lv_pmos ad=0.19p pd=1.38u as=0 ps=0 w=1u l=1u
X672 VPWR.t911 a_18764_18228# sg13cmos5l_buf_1_21.A VPWR.t39 sg13_lv_pmos ad=0.2114p pd=1.54u as=0.42p ps=2.99u w=1.12u l=0.13u
X673 VGND.t373 sg13cmos5l_inv_1_981.A sg13cmos5l_inv_1_981.Y VGND.t372 sg13_lv_nmos ad=0.2516p pd=2.16u as=0.2516p ps=2.16u w=0.74u l=0.13u
X674 sg13cmos5l_inv_1_82.A sg13cmos5l_inv_1_89.Y VGND.t396 VGND.t488 sg13_lv_nmos ad=0.2516p pd=2.16u as=0.2516p ps=2.16u w=0.74u l=0.13u
X675 sg13cmos5l_inv_1_401.Y sg13cmos5l_inv_1_386.Y VPWR.t398 VPWR.t14 sg13_lv_pmos ad=0.3808p pd=2.92u as=0.3808p ps=2.92u w=1.12u l=0.13u
X676 VGND.t335 VPWR.t1540 VGND.t335 VGND.t1594 sg13_lv_nmos ad=0.1428p pd=1.52u as=0 ps=0 w=0.42u l=1u
X677 sg13cmos5l_inv_1_552.Y sg13cmos5l_inv_1_564.Y VGND.t503 VGND.t814 sg13_lv_nmos ad=0.2516p pd=2.16u as=0.2516p ps=2.16u w=0.74u l=0.13u
X678 VPWR.t154 VGND.t1611 VPWR.t153 VPWR.t49 sg13_lv_pmos ad=0.34p pd=2.68u as=0 ps=0 w=1u l=1u
X679 sg13cmos5l_inv_1_851.Y sg13cmos5l_inv_1_851.A VGND.t116 VGND.t22 sg13_lv_nmos ad=0.2516p pd=2.16u as=0.2516p ps=2.16u w=0.74u l=0.13u
X680 VPWR.t1441 sg13cmos5l_inv_1_445.A a_9365_6173# VPWR.t0 sg13_lv_pmos ad=0.34p pd=2.68u as=0.135p ps=1.27u w=1u l=0.13u
X681 sg13cmos5l_inv_1_722.Y sg13cmos5l_inv_1_699.Y VPWR.t1119 VPWR.t2 sg13_lv_pmos ad=0.3808p pd=2.92u as=0.3808p ps=2.92u w=1.12u l=0.13u
X682 sg13cmos5l_inv_1_704.Y sg13cmos5l_inv_1_703.Y VGND.t184 VGND.t365 sg13_lv_nmos ad=0.2516p pd=2.16u as=0.2516p ps=2.16u w=0.74u l=0.13u
X683 sg13cmos5l_inv_1_656.Y sg13cmos5l_inv_1_655.Y VPWR.t1415 VPWR.t26 sg13_lv_pmos ad=0.3808p pd=2.92u as=0.3808p ps=2.92u w=1.12u l=0.13u
X684 VGND.t529 VPWR.t1595 VGND.t987 VGND.t1519 sg13_lv_nmos ad=0.1428p pd=1.52u as=0 ps=0 w=0.42u l=1u
X685 VGND.t102 sg13cmos5l_inv_1_478.A sg13cmos5l_inv_1_478.Y VGND.t485 sg13_lv_nmos ad=0.2516p pd=2.16u as=0.2516p ps=2.16u w=0.74u l=0.13u
X686 sg13cmos5l_inv_1_161.Y sg13cmos5l_inv_1_163.Y VGND.t128 VGND.t359 sg13_lv_nmos ad=0.2516p pd=2.16u as=0.2516p ps=2.16u w=0.74u l=0.13u
X687 a_10042_8434# sg13cmos5l_nand2_1_1.B VGND.t76 VGND.t757 sg13_lv_nmos ad=0.1406p pd=1.12u as=0.2516p ps=2.16u w=0.74u l=0.13u
X688 sg13cmos5l_inv_1_549.A sg13cmos5l_inv_1_571.Y VPWR.t469 VPWR.t39 sg13_lv_pmos ad=0.3808p pd=2.92u as=0.3808p ps=2.92u w=1.12u l=0.13u
X689 VGND.t43 sg13cmos5l_inv_1_1011.A a_7700_3534# VGND.t112 sg13_lv_nmos ad=0.1824p pd=1.21u as=0.2304p ps=1.36u w=0.64u l=0.13u
X690 VPWR.t301 sg13cmos5l_mux4_1_5.S1.t1 a_13799_3534# VPWR.t8 sg13_lv_pmos ad=0.22315p pd=1.555u as=0.34p ps=2.68u w=1u l=0.13u
X691 a_10096_8050# sg13cmos5l_mux2_1_3.A0 a_9982_8050# VGND.t1306 sg13_lv_nmos ad=0.3367p pd=1.65u as=0.1628p ps=1.18u w=0.74u l=0.13u
X692 sg13cmos5l_inv_1_367.Y sg13cmos5l_inv_1_347.Y VGND.t540 VGND.t949 sg13_lv_nmos ad=0.2516p pd=2.16u as=0.2516p ps=2.16u w=0.74u l=0.13u
X693 sg13cmos5l_inv_1_190.A sg13cmos5l_inv_1_224.Y VPWR.t1085 VPWR.t0 sg13_lv_pmos ad=0.3808p pd=2.92u as=0.3808p ps=2.92u w=1.12u l=0.13u
X694 sg13cmos5l_inv_1_971.Y sg13cmos5l_mux4_1_4.A2 VGND.t143 VGND.t4 sg13_lv_nmos ad=0.2516p pd=2.16u as=0.2516p ps=2.16u w=0.74u l=0.13u
X695 sg13cmos5l_inv_1_725.Y sg13cmos5l_inv_1_724.Y VPWR.t348 VPWR.t2 sg13_lv_pmos ad=0.3808p pd=2.92u as=0.3808p ps=2.92u w=1.12u l=0.13u
X696 VGND.t435 sg13cmos5l_inv_1_100.A a_14228_3534# VGND.t1117 sg13_lv_nmos ad=0.1824p pd=1.21u as=0.2304p ps=1.36u w=0.64u l=0.13u
X697 a_15056_11771# sg13cmos5l_nor3_1_2.B.t2 a_14360_11776# VPWR.t2 sg13_lv_pmos ad=0.20762p pd=1.605u as=0.4425p ps=1.885u w=1u l=0.13u
X698 VGND.t343 sg13cmos5l_inv_1_441.A sg13cmos5l_inv_1_440.A VGND.t11 sg13_lv_nmos ad=0.2516p pd=2.16u as=0.2516p ps=2.16u w=0.74u l=0.13u
X699 VPWR.t1372 sg13cmos5l_inv_1_780.A sg13cmos5l_inv_1_780.Y VPWR.t39 sg13_lv_pmos ad=0.3808p pd=2.92u as=0.3808p ps=2.92u w=1.12u l=0.13u
X700 sg13cmos5l_nor4_1_0.Y sg13cmos5l_nor3_1_1.Y VGND.t191 VGND.t190 sg13_lv_nmos ad=0.1406p pd=1.12u as=0.1406p ps=1.12u w=0.74u l=0.13u
X701 VGND.t244 sg13cmos5l_inv_1_244.A sg13cmos5l_inv_1_239.A VGND.t1645 sg13_lv_nmos ad=0.2516p pd=2.16u as=0.2516p ps=2.16u w=0.74u l=0.13u
X702 sg13cmos5l_inv_1_807.A sg13cmos5l_inv_1_808.A VPWR.t372 VPWR.t42 sg13_lv_pmos ad=0.3808p pd=2.92u as=0.3808p ps=2.92u w=1.12u l=0.13u
X703 VGND.t37 sg13cmos5l_buf_1_23.X a_18856_16752# VGND.t22 sg13_lv_nmos ad=0.14875p pd=1.16u as=0.187p ps=1.78u w=0.55u l=0.13u
X704 VPWR.t912 sg13cmos5l_inv_1_61.A sg13cmos5l_inv_1_61.Y VPWR.t11 sg13_lv_pmos ad=0.3808p pd=2.92u as=0.3808p ps=2.92u w=1.12u l=0.13u
X705 VGND.t244 sg13cmos5l_inv_1_238.A sg13cmos5l_inv_1_244.A VGND.t1356 sg13_lv_nmos ad=0.2516p pd=2.16u as=0.2516p ps=2.16u w=0.74u l=0.13u
X706 sg13cmos5l_inv_1_249.Y sg13cmos5l_inv_1_273.Y VPWR.t411 VPWR.t11 sg13_lv_pmos ad=0.3808p pd=2.92u as=0.3808p ps=2.92u w=1.12u l=0.13u
X707 sg13cmos5l_inv_1_163.Y sg13cmos5l_inv_1_162.Y VPWR.t771 VPWR.t29 sg13_lv_pmos ad=0.3808p pd=2.92u as=0.3808p ps=2.92u w=1.12u l=0.13u
X708 sg13cmos5l_inv_1_874.A sg13cmos5l_inv_1_861.A VGND.t171 VGND.t1201 sg13_lv_nmos ad=0.2516p pd=2.16u as=0.2516p ps=2.16u w=0.74u l=0.13u
X709 VGND.t143 sg13cmos5l_inv_1_983.Y sg13cmos5l_inv_1_921.Y VGND.t190 sg13_lv_nmos ad=0.2516p pd=2.16u as=0.2516p ps=2.16u w=0.74u l=0.13u
X710 VGND.t646 sg13cmos5l_inv_1_3.Y sg13cmos5l_inv_1_0.A VGND.t645 sg13_lv_nmos ad=0.2516p pd=2.16u as=0.2516p ps=2.16u w=0.74u l=0.13u
X711 sg13cmos5l_inv_1_118.A sg13cmos5l_inv_1_140.Y VPWR.t1091 VPWR.t14 sg13_lv_pmos ad=0.3808p pd=2.92u as=0.3808p ps=2.92u w=1.12u l=0.13u
X712 VGND.t69 a_18764_18228# sg13cmos5l_buf_1_21.A VGND.t1333 sg13_lv_nmos ad=0.14875p pd=1.16u as=0.2886p ps=2.26u w=0.74u l=0.13u
X713 VPWR.t113 VGND.t1565 VPWR.t112 VPWR.t5 sg13_lv_pmos ad=0.34p pd=2.68u as=0 ps=0 w=1u l=1u
X714 VGND.t354 sg13cmos5l_mux4_1_5.S0.t3 a_8327_6558# VGND.t859 sg13_lv_nmos ad=0.1872p pd=1.225u as=0.2176p ps=1.96u w=0.64u l=0.13u
X715 VPWR.t1120 sg13cmos5l_inv_1_169.Y sg13cmos5l_inv_1_158.Y VPWR.t29 sg13_lv_pmos ad=0.3808p pd=2.92u as=0.3808p ps=2.92u w=1.12u l=0.13u
X716 VPWR.t1146 sg13cmos5l_inv_1_100.A sg13cmos5l_inv_1_103.A VPWR.t8 sg13_lv_pmos ad=0.3808p pd=2.92u as=0.3808p ps=2.92u w=1.12u l=0.13u
X717 sg13cmos5l_nor2b_1_0.B_N a_808_18264# VPWR.t867 VPWR.t39 sg13_lv_pmos ad=0.42p pd=2.99u as=0.2114p ps=1.54u w=1.12u l=0.13u
X718 VPWR.t836 sg13cmos5l_mux2_1_4.S sg13cmos5l_nand2_1_1.Y VPWR.t29 sg13_lv_pmos ad=0.3808p pd=2.92u as=0.2128p ps=1.5u w=1.12u l=0.13u
X719 VGND.t29 sg13cmos5l_inv_1_572.A sg13cmos5l_inv_1_571.A VGND.t22 sg13_lv_nmos ad=0.2516p pd=2.16u as=0.2516p ps=2.16u w=0.74u l=0.13u
X720 VGND.t126 sg13cmos5l_inv_1_739.A sg13cmos5l_inv_1_740.A VGND.t494 sg13_lv_nmos ad=0.2516p pd=2.16u as=0.2516p ps=2.16u w=0.74u l=0.13u
X721 VPWR.t236 VGND.t113 VPWR.t235 VPWR.t0 sg13_lv_pmos ad=0.34p pd=2.68u as=0 ps=0 w=1u l=1u
X722 VPWR.t280 sg13cmos5l_mux4_1_8.A1 sg13cmos5l_inv_1_628.Y VPWR.t42 sg13_lv_pmos ad=0.3808p pd=2.92u as=0.3808p ps=2.92u w=1.12u l=0.13u
X723 VPWR.t395 sg13cmos5l_inv_1_402.A sg13cmos5l_inv_1_412.A VPWR.t14 sg13_lv_pmos ad=0.3808p pd=2.92u as=0.3808p ps=2.92u w=1.12u l=0.13u
X724 VPWR.t134 VGND.t155 VPWR.t133 VPWR.t2 sg13_lv_pmos ad=0.34p pd=2.68u as=0 ps=0 w=1u l=1u
X725 VGND.t567 VPWR.t1607 VGND.t567 VGND.t22 sg13_lv_nmos ad=0.1428p pd=1.52u as=0 ps=0 w=0.42u l=1u
X726 sg13cmos5l_inv_1_241.Y sg13cmos5l_inv_1_241.A VPWR.t753 VPWR.t11 sg13_lv_pmos ad=0.3808p pd=2.92u as=0.3808p ps=2.92u w=1.12u l=0.13u
X727 sg13cmos5l_mux4_1_0.A0 sg13cmos5l_inv_1_159.Y VGND.t130 VGND.t459 sg13_lv_nmos ad=0.2516p pd=2.16u as=0.2516p ps=2.16u w=0.74u l=0.13u
X728 VGND.t100 sg13cmos5l_inv_1_560.A sg13cmos5l_inv_1_560.Y VGND.t22 sg13_lv_nmos ad=0.2516p pd=2.16u as=0.2516p ps=2.16u w=0.74u l=0.13u
X729 sg13cmos5l_inv_1_389.A sg13cmos5l_inv_1_382.Y VPWR.t339 VPWR.t0 sg13_lv_pmos ad=0.3808p pd=2.92u as=0.3808p ps=2.92u w=1.12u l=0.13u
X730 sg13cmos5l_inv_1_159.Y sg13cmos5l_inv_1_159.A VPWR.t928 VPWR.t29 sg13_lv_pmos ad=0.3808p pd=2.92u as=0.3808p ps=2.92u w=1.12u l=0.13u
X731 sg13cmos5l_mux2_1_1.X a_8446_8434# VGND.t76 VGND.t703 sg13_lv_nmos ad=0.4033p pd=2.57u as=0.148p ps=1.14u w=0.74u l=0.13u
X732 VGND.t399 sg13cmos5l_inv_1_256.A sg13cmos5l_inv_1_251.A VGND.t1393 sg13_lv_nmos ad=0.2516p pd=2.16u as=0.2516p ps=2.16u w=0.74u l=0.13u
X733 VGND.t174 VPWR.t1586 VGND.t174 VGND.t1533 sg13_lv_nmos ad=0.1428p pd=1.52u as=0 ps=0 w=0.42u l=1u
X734 sg13cmos5l_inv_1_1010.Y sg13cmos5l_inv_1_278.Y VPWR.t1221 VPWR.t8 sg13_lv_pmos ad=0.3808p pd=2.92u as=0.3808p ps=2.92u w=1.12u l=0.13u
X735 a_9498_3514# a_9432_3406# VGND.t73 VGND.t1129 sg13_lv_nmos ad=0.3367p pd=1.65u as=0.148p ps=1.14u w=0.74u l=0.13u
X736 VPWR.t599 sg13cmos5l_inv_1_526.Y sg13cmos5l_inv_1_531.A VPWR.t2 sg13_lv_pmos ad=0.3808p pd=2.92u as=0.3808p ps=2.92u w=1.12u l=0.13u
X737 VPWR.t190 VGND.t143 VPWR.t189 VPWR.t5 sg13_lv_pmos ad=0.34p pd=2.68u as=0 ps=0 w=1u l=1u
X738 a_14324_15630# sg13cmos5l_buf_1_9.A.t5 a_14206_15630# VGND.t708 sg13_lv_nmos ad=0.2304p pd=1.36u as=0.1472p ps=1.1u w=0.64u l=0.13u
X739 VGND.t1097 sg13cmos5l_inv_1_514.A sg13cmos5l_inv_1_514.Y VGND.t1096 sg13_lv_nmos ad=0.2516p pd=2.16u as=0.2516p ps=2.16u w=0.74u l=0.13u
X740 a_6910_12970# sg13cmos5l_mux4_1_5.S0.t6 a_6823_13237# VPWR.t26 sg13_lv_pmos ad=0.19p pd=1.38u as=0.415p ps=1.83u w=1u l=0.13u
X741 VPWR.t602 sg13cmos5l_inv_1_762.Y sg13cmos5l_inv_1_733.A VPWR.t2 sg13_lv_pmos ad=0.3808p pd=2.92u as=0.3808p ps=2.92u w=1.12u l=0.13u
X742 VPWR.t718 sg13cmos5l_inv_1_59.A sg13cmos5l_inv_1_59.Y VPWR.t11 sg13_lv_pmos ad=0.3808p pd=2.92u as=0.3808p ps=2.92u w=1.12u l=0.13u
X743 sg13cmos5l_inv_1_402.A sg13cmos5l_inv_1_403.Y VPWR.t490 VPWR.t14 sg13_lv_pmos ad=0.3808p pd=2.92u as=0.3808p ps=2.92u w=1.12u l=0.13u
X744 VGND.t15 sg13cmos5l_inv_1_370.Y sg13cmos5l_inv_1_369.A VGND.t964 sg13_lv_nmos ad=0.2516p pd=2.16u as=0.2516p ps=2.16u w=0.74u l=0.13u
X745 sg13cmos5l_inv_1_872.A sg13cmos5l_inv_1_850.Y VPWR.t868 VPWR.t42 sg13_lv_pmos ad=0.3808p pd=2.92u as=0.3808p ps=2.92u w=1.12u l=0.13u
X746 a_4701_12970# sg13cmos5l_nor3_1_2.B VGND.t866 VGND.t1474 sg13_lv_nmos ad=0.13135p pd=1.095u as=0.18945p ps=1.27u w=0.74u l=0.13u
X747 sg13cmos5l_inv_1_58.A sg13cmos5l_inv_1_56.Y VGND.t256 VGND.t1147 sg13_lv_nmos ad=0.2516p pd=2.16u as=0.2516p ps=2.16u w=0.74u l=0.13u
X748 a_16094_4192# sg13cmos5l_mux4_1_1.X a_15662_4084# VPWR.t49 sg13_lv_pmos ad=0.3325p pd=1.665u as=0.2225p ps=1.445u w=1u l=0.13u
X749 VGND.t94 sg13cmos5l_nor2b_1_0.A sg13cmos5l_o21ai_1_0.B1 VGND.t804 sg13_lv_nmos ad=0.2516p pd=2.16u as=0.1406p ps=1.12u w=0.74u l=0.13u
X750 sg13cmos5l_inv_1_940.A sg13cmos5l_inv_1_976.Y VGND.t6 VGND.t190 sg13_lv_nmos ad=0.2516p pd=2.16u as=0.2516p ps=2.16u w=0.74u l=0.13u
X751 sg13cmos5l_buf_1_8.A a_2920_3932# VGND.t54 VGND.t544 sg13_lv_nmos ad=0.2886p pd=2.26u as=0.14875p ps=1.16u w=0.74u l=0.13u
X752 sg13cmos5l_inv_1_194.Y sg13cmos5l_inv_1_187.Y VPWR.t691 VPWR.t49 sg13_lv_pmos ad=0.3808p pd=2.92u as=0.3808p ps=2.92u w=1.12u l=0.13u
X753 a_7425_8476# sg13cmos5l_mux4_1_5.S1.t7 a_6934_8434# VGND.t74 sg13_lv_nmos ad=0.1216p pd=1.02u as=0.54188p ps=3.42u w=0.64u l=0.13u
X754 VGND.t621 sg13cmos5l_inv_1_103.A sg13cmos5l_inv_1_59.A VGND.t620 sg13_lv_nmos ad=0.2516p pd=2.16u as=0.2516p ps=2.16u w=0.74u l=0.13u
X755 VPWR.t1281 sg13cmos5l_inv_1_67.A sg13cmos5l_inv_1_67.Y VPWR.t11 sg13_lv_pmos ad=0.3808p pd=2.92u as=0.3808p ps=2.92u w=1.12u l=0.13u
X756 VPWR.t851 sg13cmos5l_inv_1_713.A sg13cmos5l_inv_1_696.A VPWR.t2 sg13_lv_pmos ad=0.3808p pd=2.92u as=0.3808p ps=2.92u w=1.12u l=0.13u
X757 sg13cmos5l_inv_1_216.Y sg13cmos5l_inv_1_97.Y VGND.t292 VGND.t1353 sg13_lv_nmos ad=0.2516p pd=2.16u as=0.2516p ps=2.16u w=0.74u l=0.13u
X758 sg13cmos5l_mux4_1_11.A1 a_14913_14524# VPWR.t1152 VPWR.t21 sg13_lv_pmos ad=0.3808p pd=2.92u as=0.34367p ps=1.775u w=1.12u l=0.13u
X759 sg13cmos5l_inv_1_1003.Y sg13cmos5l_inv_1_480.Y VPWR.t1197 VPWR.t26 sg13_lv_pmos ad=0.3808p pd=2.92u as=0.3808p ps=2.92u w=1.12u l=0.13u
X760 a_14913_14524# sg13cmos5l_mux2_1_4.S.t4 a_14422_14482# VGND.t1472 sg13_lv_nmos ad=0.1216p pd=1.02u as=0.54188p ps=3.42u w=0.64u l=0.13u
X761 VPWR.t31 VGND.t971 VPWR.t30 VPWR.t29 sg13_lv_pmos ad=0.19p pd=1.38u as=0 ps=0 w=1u l=1u
X762 sg13cmos5l_inv_1_97.Y sg13cmos5l_inv_1_61.Y VPWR.t1328 VPWR.t8 sg13_lv_pmos ad=0.3808p pd=2.92u as=0.3808p ps=2.92u w=1.12u l=0.13u
X763 VPWR.t358 sg13cmos5l_buf_1_8.A a_2248_3932# VPWR.t49 sg13_lv_pmos ad=0.2114p pd=1.54u as=0.2856p ps=2.36u w=0.84u l=0.13u
X764 VGND.t315 sg13cmos5l_inv_1_707.A sg13cmos5l_inv_1_707.Y VGND.t1025 sg13_lv_nmos ad=0.2516p pd=2.16u as=0.2516p ps=2.16u w=0.74u l=0.13u
X765 sg13cmos5l_inv_1_971.Y sg13cmos5l_mux4_1_4.A2 VPWR.t580 VPWR.t29 sg13_lv_pmos ad=0.3808p pd=2.92u as=0.3808p ps=2.92u w=1.12u l=0.13u
X766 sg13cmos5l_nor2b_1_0.B_N a_808_18264# VGND.t807 VGND.t806 sg13_lv_nmos ad=0.2886p pd=2.26u as=0.14875p ps=1.16u w=0.74u l=0.13u
X767 VPWR.t241 VGND.t90 VPWR.t240 VPWR.t21 sg13_lv_pmos ad=0.34p pd=2.68u as=0 ps=0 w=1u l=1u
X768 VGND.t3 VPWR.t1591 VGND.t3 VGND.t1524 sg13_lv_nmos ad=0.1428p pd=1.52u as=0 ps=0 w=0.42u l=1u
X769 sg13cmos5l_inv_1_882.A sg13cmos5l_inv_1_916.A VPWR.t689 VPWR.t21 sg13_lv_pmos ad=0.3808p pd=2.92u as=0.3808p ps=2.92u w=1.12u l=0.13u
X770 VPWR.t1182 sg13cmos5l_inv_1_753.A sg13cmos5l_inv_1_752.A VPWR.t2 sg13_lv_pmos ad=0.3808p pd=2.92u as=0.3808p ps=2.92u w=1.12u l=0.13u
X771 sg13cmos5l_inv_1_940.A sg13cmos5l_inv_1_976.Y VPWR.t517 VPWR.t5 sg13_lv_pmos ad=0.3808p pd=2.92u as=0.3808p ps=2.92u w=1.12u l=0.13u
X772 VPWR.t263 sg13cmos5l_inv_1_147.A sg13cmos5l_inv_1_147.Y VPWR.t0 sg13_lv_pmos ad=0.3808p pd=2.92u as=0.3808p ps=2.92u w=1.12u l=0.13u
X773 sg13cmos5l_inv_1_704.Y sg13cmos5l_inv_1_703.Y VPWR.t509 VPWR.t5 sg13_lv_pmos ad=0.3808p pd=2.92u as=0.3808p ps=2.92u w=1.12u l=0.13u
X774 VPWR.t13 VGND.t1628 VPWR.t12 VPWR.t11 sg13_lv_pmos ad=0.34p pd=2.68u as=0 ps=0 w=1u l=1u
X775 sg13cmos5l_inv_1_861.A sg13cmos5l_inv_1_890.A VPWR.t371 VPWR.t42 sg13_lv_pmos ad=0.3808p pd=2.92u as=0.3808p ps=2.92u w=1.12u l=0.13u
X776 sg13cmos5l_inv_1_464.Y sg13cmos5l_inv_1_463.Y VGND.t343 VGND.t11 sg13_lv_nmos ad=0.2516p pd=2.16u as=0.2516p ps=2.16u w=0.74u l=0.13u
X777 sg13cmos5l_inv_1_807.A sg13cmos5l_inv_1_808.A VGND.t23 VGND.t22 sg13_lv_nmos ad=0.2516p pd=2.16u as=0.2516p ps=2.16u w=0.74u l=0.13u
X778 VPWR.t1325 sg13cmos5l_inv_1_439.A sg13cmos5l_inv_1_439.Y VPWR.t0 sg13_lv_pmos ad=0.3808p pd=2.92u as=0.3808p ps=2.92u w=1.12u l=0.13u
X779 VGND.t6 sg13cmos5l_inv_1_977.A sg13cmos5l_inv_1_976.A VGND.t4 sg13_lv_nmos ad=0.2516p pd=2.16u as=0.2516p ps=2.16u w=0.74u l=0.13u
X780 VGND.t621 sg13cmos5l_inv_1_61.A sg13cmos5l_inv_1_61.Y VGND.t844 sg13_lv_nmos ad=0.2516p pd=2.16u as=0.2516p ps=2.16u w=0.74u l=0.13u
X781 sg13cmos5l_inv_1_112.A sg13cmos5l_inv_1_113.Y VGND.t267 VGND.t885 sg13_lv_nmos ad=0.2516p pd=2.16u as=0.2516p ps=2.16u w=0.74u l=0.13u
X782 VGND.t133 sg13cmos5l_a22oi_1_0.A2 a_8654_12608# VGND.t1648 sg13_lv_nmos ad=0.2516p pd=2.16u as=96.2f ps=1u w=0.74u l=0.13u
X783 VGND.t147 sg13cmos5l_inv_1_520.A sg13cmos5l_inv_1_518.A VGND.t556 sg13_lv_nmos ad=0.2516p pd=2.16u as=0.2516p ps=2.16u w=0.74u l=0.13u
X784 VGND.t117 sg13cmos5l_inv_1_427.A sg13cmos5l_inv_1_427.Y VGND.t11 sg13_lv_nmos ad=0.2516p pd=2.16u as=0.2516p ps=2.16u w=0.74u l=0.13u
X785 a_6858_8434# sg13cmos5l_mux4_1_4.A2 VGND.t162 VGND.t453 sg13_lv_nmos ad=80f pd=0.89u as=0.1824p ps=1.21u w=0.64u l=0.13u
X786 VPWR.t61 VGND.t508 VPWR.t60 VPWR.t29 sg13_lv_pmos ad=0.19p pd=1.38u as=0 ps=0 w=1u l=1u
X787 sg13cmos5l_inv_1_756.Y sg13cmos5l_inv_1_748.Y VPWR.t1502 VPWR.t2 sg13_lv_pmos ad=0.3808p pd=2.92u as=0.3808p ps=2.92u w=1.12u l=0.13u
X788 VPWR.t1320 sg13cmos5l_inv_1_430.A sg13cmos5l_inv_1_429.A VPWR.t49 sg13_lv_pmos ad=0.3808p pd=2.92u as=0.3808p ps=2.92u w=1.12u l=0.13u
X789 sg13cmos5l_inv_1_490.A sg13cmos5l_inv_1_498.A VGND.t269 VGND.t268 sg13_lv_nmos ad=0.2516p pd=2.16u as=0.2516p ps=2.16u w=0.74u l=0.13u
X790 sg13cmos5l_inv_1_118.A sg13cmos5l_inv_1_140.Y VGND.t514 VGND.t1051 sg13_lv_nmos ad=0.2516p pd=2.16u as=0.2516p ps=2.16u w=0.74u l=0.13u
X791 VGND.t610 sg13cmos5l_inv_1_331.A sg13cmos5l_inv_1_301.A VGND.t1180 sg13_lv_nmos ad=0.2516p pd=2.16u as=0.2516p ps=2.16u w=0.74u l=0.13u
X792 VGND.t92 sg13cmos5l_inv_1_912.A sg13cmos5l_inv_1_911.A VGND.t167 sg13_lv_nmos ad=0.2516p pd=2.16u as=0.2516p ps=2.16u w=0.74u l=0.13u
X793 sg13cmos5l_inv_1_892.A sg13cmos5l_mux4_1_14.A3 VGND.t92 VGND.t421 sg13_lv_nmos ad=0.2516p pd=2.16u as=0.2516p ps=2.16u w=0.74u l=0.13u
X794 sg13cmos5l_inv_1_799.A sg13cmos5l_inv_1_995.Y VGND.t1227 VGND.t1226 sg13_lv_nmos ad=0.2516p pd=2.16u as=0.2516p ps=2.16u w=0.74u l=0.13u
X795 VPWR.t1308 sg13cmos5l_inv_1_485.Y sg13cmos5l_inv_1_496.A VPWR.t2 sg13_lv_pmos ad=0.3808p pd=2.92u as=0.3808p ps=2.92u w=1.12u l=0.13u
X796 VGND.t44 sg13cmos5l_mux4_1_8.A1 sg13cmos5l_inv_1_628.Y VGND.t22 sg13_lv_nmos ad=0.2516p pd=2.16u as=0.2516p ps=2.16u w=0.74u l=0.13u
X797 a_8654_12608# sg13cmos5l_a22oi_1_0.A1 sg13cmos5l_a21oi_1_0.A2 VGND.t1238 sg13_lv_nmos ad=96.2f pd=1u as=0.2664p ps=1.46u w=0.74u l=0.13u
X798 VGND.t162 sg13cmos5l_inv_1_402.A sg13cmos5l_inv_1_412.A VGND.t221 sg13_lv_nmos ad=0.2516p pd=2.16u as=0.2516p ps=2.16u w=0.74u l=0.13u
X799 sg13cmos5l_inv_1_650.Y sg13cmos5l_inv_1_650.A VGND.t250 VGND.t304 sg13_lv_nmos ad=0.2516p pd=2.16u as=0.2516p ps=2.16u w=0.74u l=0.13u
X800 a_14036_3534# sg13cmos5l_inv_1_95.A VGND.t78 VGND.t82 sg13_lv_nmos ad=76.8f pd=0.88u as=0.1872p ps=1.225u w=0.64u l=0.13u
X801 sg13cmos5l_inv_1_241.Y sg13cmos5l_inv_1_241.A VGND.t111 VGND.t662 sg13_lv_nmos ad=0.2516p pd=2.16u as=0.2516p ps=2.16u w=0.74u l=0.13u
X802 sg13cmos5l_inv_1_132.Y sg13cmos5l_inv_1_1004.Y VPWR.t1102 VPWR.t14 sg13_lv_pmos ad=0.3808p pd=2.92u as=0.3808p ps=2.92u w=1.12u l=0.13u
X803 a_8919_10240# sg13cmos5l_nor3_1_1.B a_8805_10240# VPWR.t5 sg13_lv_pmos ad=0.2128p pd=1.5u as=0.2464p ps=1.56u w=1.12u l=0.13u
X804 VPWR.t254 sg13cmos5l_inv_1_882.A sg13cmos5l_inv_1_882.Y VPWR.t21 sg13_lv_pmos ad=0.3808p pd=2.92u as=0.3808p ps=2.92u w=1.12u l=0.13u
X805 VPWR.t143 sg13cmos5l_inv_1_298.A sg13cmos5l_inv_1_298.Y VPWR.t11 sg13_lv_pmos ad=0.3808p pd=2.92u as=0.3808p ps=2.92u w=1.12u l=0.13u
X806 VPWR.t963 sg13cmos5l_inv_1_525.A sg13cmos5l_inv_1_526.A VPWR.t2 sg13_lv_pmos ad=0.3808p pd=2.92u as=0.3808p ps=2.92u w=1.12u l=0.13u
X807 VGND.t501 sg13cmos5l_inv_1_292.Y sg13cmos5l_inv_1_274.Y VGND.t500 sg13_lv_nmos ad=0.2516p pd=2.16u as=0.2516p ps=2.16u w=0.74u l=0.13u
X808 sg13cmos5l_inv_1_317.Y sg13cmos5l_inv_1_314.Y VPWR.t1168 VPWR.t49 sg13_lv_pmos ad=0.3808p pd=2.92u as=0.3808p ps=2.92u w=1.12u l=0.13u
X809 sg13cmos5l_inv_1_392.A sg13cmos5l_inv_1_389.Y VPWR.t571 VPWR.t14 sg13_lv_pmos ad=0.3808p pd=2.92u as=0.3808p ps=2.92u w=1.12u l=0.13u
X810 sg13cmos5l_inv_1_404.Y sg13cmos5l_inv_1_393.Y VGND.t107 VGND.t120 sg13_lv_nmos ad=0.2516p pd=2.16u as=0.2516p ps=2.16u w=0.74u l=0.13u
X811 sg13cmos5l_mux4_1_10.A3 sg13cmos5l_inv_1_560.Y VPWR.t1455 VPWR.t42 sg13_lv_pmos ad=0.3808p pd=2.92u as=0.3808p ps=2.92u w=1.12u l=0.13u
X812 VGND.t250 sg13cmos5l_inv_1_692.A sg13cmos5l_inv_1_690.A VGND.t1146 sg13_lv_nmos ad=0.2516p pd=2.16u as=0.2516p ps=2.16u w=0.74u l=0.13u
X813 VGND.t621 sg13cmos5l_inv_1_59.A sg13cmos5l_inv_1_59.Y VGND.t620 sg13_lv_nmos ad=0.2516p pd=2.16u as=0.2516p ps=2.16u w=0.74u l=0.13u
X814 VPWR.t1300 sg13cmos5l_inv_1_216.Y a_14125_4165# VPWR.t49 sg13_lv_pmos ad=0.29275p pd=1.785u as=0.16p ps=1.32u w=1u l=0.13u
X815 sg13cmos5l_inv_1_402.A sg13cmos5l_inv_1_403.Y VGND.t162 VGND.t339 sg13_lv_nmos ad=0.2516p pd=2.16u as=0.2516p ps=2.16u w=0.74u l=0.13u
X816 VGND.t866 sg13cmos5l_nor3_1_2.B a_4475_13008# VGND.t1475 sg13_lv_nmos ad=0.18945p pd=1.27u as=0.187p ps=1.78u w=0.55u l=0.13u
X817 VPWR.t745 sg13cmos5l_inv_1_321.A sg13cmos5l_inv_1_320.A VPWR.t8 sg13_lv_pmos ad=0.3808p pd=2.92u as=0.3808p ps=2.92u w=1.12u l=0.13u
X818 a_14422_3898# sg13cmos5l_mux4_1_5.S1.t4 a_14341_4165# VPWR.t49 sg13_lv_pmos ad=0.4425p pd=1.885u as=0.20762p ps=1.605u w=1u l=0.13u
X819 sg13cmos5l_inv_1_872.A sg13cmos5l_inv_1_850.Y VGND.t116 VGND.t22 sg13_lv_nmos ad=0.2516p pd=2.16u as=0.2516p ps=2.16u w=0.74u l=0.13u
X820 VPWR.t57 VGND.t5 VPWR.t56 VPWR.t5 sg13_lv_pmos ad=0.34p pd=2.68u as=0 ps=0 w=1u l=1u
X821 sg13cmos5l_inv_1_145.Y sg13cmos5l_inv_1_144.Y VGND.t335 VGND.t1345 sg13_lv_nmos ad=0.2516p pd=2.16u as=0.2516p ps=2.16u w=0.74u l=0.13u
X822 sg13cmos5l_inv_1_608.A sg13cmos5l_inv_1_606.Y VGND.t325 VGND.t387 sg13_lv_nmos ad=0.2516p pd=2.16u as=0.2516p ps=2.16u w=0.74u l=0.13u
X823 sg13cmos5l_inv_1_920.A sg13cmos5l_inv_1_868.A VGND.t59 VGND.t58 sg13_lv_nmos ad=0.2516p pd=2.16u as=0.2516p ps=2.16u w=0.74u l=0.13u
X824 VGND.t123 sg13cmos5l_inv_1_67.A sg13cmos5l_inv_1_67.Y VGND.t1268 sg13_lv_nmos ad=0.2516p pd=2.16u as=0.2516p ps=2.16u w=0.74u l=0.13u
X825 VGND.t1 sg13cmos5l_inv_1_149.A sg13cmos5l_inv_1_149.Y VGND.t1402 sg13_lv_nmos ad=0.2516p pd=2.16u as=0.2516p ps=2.16u w=0.74u l=0.13u
X826 sg13cmos5l_inv_1_513.A sg13cmos5l_inv_1_527.A VPWR.t1002 VPWR.t2 sg13_lv_pmos ad=0.3808p pd=2.92u as=0.3808p ps=2.92u w=1.12u l=0.13u
X827 VGND.t244 sg13cmos5l_inv_1_945.Y sg13cmos5l_inv_1_238.A VGND.t1144 sg13_lv_nmos ad=0.2516p pd=2.16u as=0.2516p ps=2.16u w=0.74u l=0.13u
X828 VGND.t437 sg13cmos5l_inv_1_683.A sg13cmos5l_inv_1_683.Y VGND.t438 sg13_lv_nmos ad=0.2516p pd=2.16u as=0.2516p ps=2.16u w=0.74u l=0.13u
X829 sg13cmos5l_inv_1_129.A sg13cmos5l_inv_1_122.Y VPWR.t1019 VPWR.t14 sg13_lv_pmos ad=0.3808p pd=2.92u as=0.3808p ps=2.92u w=1.12u l=0.13u
X830 a_14559_3898# sg13cmos5l_mux4_1_5.S1.t4 a_14422_3898# VGND.t83 sg13_lv_nmos ad=76.8f pd=0.88u as=0.1776p ps=1.195u w=0.64u l=0.13u
X831 VGND.t315 sg13cmos5l_inv_1_728.Y sg13cmos5l_inv_1_706.A VGND.t1066 sg13_lv_nmos ad=0.2516p pd=2.16u as=0.2516p ps=2.16u w=0.74u l=0.13u
X832 sg13cmos5l_inv_1_729.Y sg13cmos5l_inv_1_730.Y VGND.t39 VGND.t382 sg13_lv_nmos ad=0.2516p pd=2.16u as=0.2516p ps=2.16u w=0.74u l=0.13u
X833 sg13cmos5l_inv_1_720.Y sg13cmos5l_inv_1_723.Y VPWR.t1198 VPWR.t2 sg13_lv_pmos ad=0.3808p pd=2.92u as=0.3808p ps=2.92u w=1.12u l=0.13u
X834 a_1228_15240# a_1006_15296# VPWR.t866 VPWR.t21 sg13_lv_pmos ad=0.1176p pd=1.33u as=0.2618p ps=1.63u w=1.12u l=0.13u
X835 a_14773_11771# sg13cmos5l_mux4_1_11.A3 VPWR.t612 VPWR.t2 sg13_lv_pmos ad=0.135p pd=1.27u as=0.34p ps=2.68u w=1u l=0.13u
X836 VGND.t117 sg13cmos5l_inv_1_423.A sg13cmos5l_inv_1_422.A VGND.t11 sg13_lv_nmos ad=0.2516p pd=2.16u as=0.2516p ps=2.16u w=0.74u l=0.13u
X837 sg13cmos5l_inv_1_728.Y sg13cmos5l_inv_1_715.Y VPWR.t1465 VPWR.t2 sg13_lv_pmos ad=0.3808p pd=2.92u as=0.3808p ps=2.92u w=1.12u l=0.13u
X838 sg13cmos5l_inv_1_18.Y sg13cmos5l_inv_1_18.A VPWR.t767 VPWR.t11 sg13_lv_pmos ad=0.3808p pd=2.92u as=0.3808p ps=2.92u w=1.12u l=0.13u
X839 a_14407_9243# sg13cmos5l_inv_1_113.A VPWR.t303 VPWR.t29 sg13_lv_pmos ad=0.415p pd=1.83u as=0.22315p ps=1.555u w=1u l=0.13u
X840 VGND.t8 sg13cmos5l_inv_1_938.A sg13cmos5l_inv_1_938.Y VGND.t190 sg13_lv_nmos ad=0.2516p pd=2.16u as=0.2516p ps=2.16u w=0.74u l=0.13u
X841 sg13cmos5l_inv_1_206.A sg13cmos5l_inv_1_148.Y VGND.t1 VGND.t189 sg13_lv_nmos ad=0.2516p pd=2.16u as=0.2516p ps=2.16u w=0.74u l=0.13u
X842 a_4661_12221# a_3623_12606# a_4438_12606# VPWR.t2 sg13_lv_pmos ad=0.135p pd=1.27u as=0.4425p ps=1.885u w=1u l=0.13u
X843 sg13cmos5l_inv_1_111.Y sg13cmos5l_inv_1_111.A VPWR.t1181 VPWR.t0 sg13_lv_pmos ad=0.3808p pd=2.92u as=0.3808p ps=2.92u w=1.12u l=0.13u
X844 a_4362_8070# sg13cmos5l_mux4_1_6.A2 VGND.t342 VGND.t1404 sg13_lv_nmos ad=80f pd=0.89u as=0.1824p ps=1.21u w=0.64u l=0.13u
X845 VPWR.t352 sg13cmos5l_inv_1_411.Y sg13cmos5l_inv_1_357.A VPWR.t29 sg13_lv_pmos ad=0.3808p pd=2.92u as=0.3808p ps=2.92u w=1.12u l=0.13u
X846 sg13cmos5l_inv_1_861.A sg13cmos5l_inv_1_890.A VGND.t23 VGND.t22 sg13_lv_nmos ad=0.2516p pd=2.16u as=0.2516p ps=2.16u w=0.74u l=0.13u
X847 VGND.t21 sg13cmos5l_inv_1_46.A sg13cmos5l_inv_1_46.Y VGND.t633 sg13_lv_nmos ad=0.2516p pd=2.16u as=0.2516p ps=2.16u w=0.74u l=0.13u
X848 sg13cmos5l_inv_1_295.A sg13cmos5l_inv_1_300.Y VPWR.t143 VPWR.t11 sg13_lv_pmos ad=0.3808p pd=2.92u as=0.3808p ps=2.92u w=1.12u l=0.13u
X849 a_6853_8701# sg13cmos5l_mux4_1_4.A2 VPWR.t543 VPWR.t29 sg13_lv_pmos ad=0.20762p pd=1.605u as=0.29275p ps=1.785u w=1u l=0.13u
X850 VPWR.t357 sg13cmos5l_inv_1_977.A sg13cmos5l_inv_1_976.A VPWR.t29 sg13_lv_pmos ad=0.3808p pd=2.92u as=0.3808p ps=2.92u w=1.12u l=0.13u
X851 VPWR.t674 sg13cmos5l_inv_1_609.A sg13cmos5l_inv_1_610.A VPWR.t42 sg13_lv_pmos ad=0.3808p pd=2.92u as=0.3808p ps=2.92u w=1.12u l=0.13u
X852 sg13cmos5l_inv_1_298.A sg13cmos5l_inv_1_308.Y VGND.t246 VGND.t532 sg13_lv_nmos ad=0.2516p pd=2.16u as=0.2516p ps=2.16u w=0.74u l=0.13u
X853 VPWR.t659 sg13cmos5l_inv_1_6.Y sg13cmos5l_inv_1_38.Y VPWR.t8 sg13_lv_pmos ad=0.3808p pd=2.92u as=0.3808p ps=2.92u w=1.12u l=0.13u
X854 VPWR.t139 sg13cmos5l_inv_1_306.A sg13cmos5l_inv_1_306.Y VPWR.t11 sg13_lv_pmos ad=0.3808p pd=2.92u as=0.3808p ps=2.92u w=1.12u l=0.13u
X855 VPWR.t1331 sg13cmos5l_inv_1_838.Y sg13cmos5l_inv_1_830.A VPWR.t39 sg13_lv_pmos ad=0.3808p pd=2.92u as=0.3808p ps=2.92u w=1.12u l=0.13u
X856 VPWR.t397 sg13cmos5l_inv_1_744.Y a_18664_13004# VPWR.t26 sg13_lv_pmos ad=0.2114p pd=1.54u as=0.2856p ps=2.36u w=0.84u l=0.13u
X857 VPWR.t615 sg13cmos5l_inv_1_747.Y sg13cmos5l_inv_1_750.Y VPWR.t2 sg13_lv_pmos ad=0.3808p pd=2.92u as=0.3808p ps=2.92u w=1.12u l=0.13u
X858 sg13cmos5l_inv_1_90.Y sg13cmos5l_inv_1_86.Y VPWR.t1509 VPWR.t8 sg13_lv_pmos ad=0.3808p pd=2.92u as=0.3808p ps=2.92u w=1.12u l=0.13u
X859 VPWR.t1438 sg13cmos5l_inv_1_492.A sg13cmos5l_inv_1_491.A VPWR.t2 sg13_lv_pmos ad=0.3808p pd=2.92u as=0.3808p ps=2.92u w=1.12u l=0.13u
X860 sg13cmos5l_inv_1_442.A sg13cmos5l_inv_1_453.Y VGND.t246 VGND.t401 sg13_lv_nmos ad=0.2516p pd=2.16u as=0.2516p ps=2.16u w=0.74u l=0.13u
X861 VGND.t396 sg13cmos5l_inv_1_82.A sg13cmos5l_inv_1_82.Y VGND.t1641 sg13_lv_nmos ad=0.2516p pd=2.16u as=0.2516p ps=2.16u w=0.74u l=0.13u
X862 a_15637_8028# sg13cmos5l_buf_1_8.A.t2 a_16540_8070# VGND.t664 sg13_lv_nmos ad=0.1472p pd=1.1u as=0.2304p ps=1.36u w=0.64u l=0.13u
X863 a_6548_8434# sg13cmos5l_mux4_1_5.S0.t5 a_6430_8434# VGND.t857 sg13_lv_nmos ad=0.2304p pd=1.36u as=0.1472p ps=1.1u w=0.64u l=0.13u
X864 sg13cmos5l_inv_1_708.A sg13cmos5l_inv_1_725.Y VGND.t155 VGND.t1017 sg13_lv_nmos ad=0.2516p pd=2.16u as=0.2516p ps=2.16u w=0.74u l=0.13u
X865 VPWR.t262 sg13cmos5l_inv_1_184.A sg13cmos5l_inv_1_184.Y VPWR.t49 sg13_lv_pmos ad=0.3808p pd=2.92u as=0.3808p ps=2.92u w=1.12u l=0.13u
X866 VPWR.t1273 sg13cmos5l_mux4_1_5.S0.t8 a_3623_15994# VPWR.t42 sg13_lv_pmos ad=0.22315p pd=1.555u as=0.34p ps=2.68u w=1u l=0.13u
X867 VPWR.t533 sg13cmos5l_buf_1_6.A a_18280_5444# VPWR.t0 sg13_lv_pmos ad=0.2114p pd=1.54u as=0.2856p ps=2.36u w=0.84u l=0.13u
X868 sg13cmos5l_inv_1_648.Y sg13cmos5l_inv_1_649.Y VGND.t250 VGND.t1167 sg13_lv_nmos ad=0.2516p pd=2.16u as=0.2516p ps=2.16u w=0.74u l=0.13u
X869 VPWR.t910 sg13cmos5l_inv_1_828.Y sg13cmos5l_mux4_1_8.A0 VPWR.t39 sg13_lv_pmos ad=0.3808p pd=2.92u as=0.3808p ps=2.92u w=1.12u l=0.13u
X870 VPWR.t627 sg13cmos5l_inv_1_482.Y sg13cmos5l_inv_1_478.A VPWR.t26 sg13_lv_pmos ad=0.3808p pd=2.92u as=0.3808p ps=2.92u w=1.12u l=0.13u
X871 VPWR.t1206 sg13cmos5l_inv_1_490.A sg13cmos5l_inv_1_489.A VPWR.t2 sg13_lv_pmos ad=0.3808p pd=2.92u as=0.3808p ps=2.92u w=1.12u l=0.13u
X872 sg13cmos5l_inv_1_260.A sg13cmos5l_inv_1_250.Y VPWR.t411 VPWR.t11 sg13_lv_pmos ad=0.3808p pd=2.92u as=0.3808p ps=2.92u w=1.12u l=0.13u
X873 VGND.t130 a_15275_7644# sg13cmos5l_mux2_1_3.A0 VGND.t1176 sg13_lv_nmos ad=0.1543p pd=1.18u as=0.2516p ps=2.16u w=0.74u l=0.13u
X874 sg13cmos5l_inv_1_344.Y sg13cmos5l_inv_1_344.A VPWR.t380 VPWR.t0 sg13_lv_pmos ad=0.3808p pd=2.92u as=0.3808p ps=2.92u w=1.12u l=0.13u
X875 VPWR.t574 sg13cmos5l_inv_1_677.A sg13cmos5l_inv_1_677.Y VPWR.t2 sg13_lv_pmos ad=0.3808p pd=2.92u as=0.3808p ps=2.92u w=1.12u l=0.13u
X876 VPWR.t16 VGND.t754 VPWR.t15 VPWR.t14 sg13_lv_pmos ad=0.34p pd=2.68u as=0 ps=0 w=1u l=1u
X877 sg13cmos5l_inv_1_601.Y sg13cmos5l_inv_1_604.Y VGND.t310 VGND.t1389 sg13_lv_nmos ad=0.2516p pd=2.16u as=0.2516p ps=2.16u w=0.74u l=0.13u
X878 VPWR.t10 VGND.t1628 VPWR.t9 VPWR.t8 sg13_lv_pmos ad=0.34p pd=2.68u as=0 ps=0 w=1u l=1u
X879 VPWR.t186 VGND.t335 VPWR.t118 VPWR.t14 sg13_lv_pmos ad=0.19p pd=1.38u as=0 ps=0 w=1u l=1u
X880 sg13cmos5l_inv_1_45.Y sg13cmos5l_inv_1_53.Y VPWR.t1159 VPWR.t8 sg13_lv_pmos ad=0.3808p pd=2.92u as=0.3808p ps=2.92u w=1.12u l=0.13u
X881 sg13cmos5l_a21oi_1_1.A1 sg13cmos5l_nor3_1_1.A VGND.t188 VGND.t1070 sg13_lv_nmos ad=0.1406p pd=1.12u as=0.2516p ps=2.16u w=0.74u l=0.13u
X882 VPWR.t835 sg13cmos5l_inv_1_394.A a_7157_8747# VPWR.t29 sg13_lv_pmos ad=0.34p pd=2.68u as=0.135p ps=1.27u w=1u l=0.13u
X883 sg13cmos5l_inv_1_362.Y sg13cmos5l_inv_1_362.A VPWR.t654 VPWR.t14 sg13_lv_pmos ad=0.3808p pd=2.92u as=0.3808p ps=2.92u w=1.12u l=0.13u
X884 a_8560_8434# sg13cmos5l_mux4_1_4.X a_8446_8434# VGND.t1467 sg13_lv_nmos ad=0.3367p pd=1.65u as=0.1628p ps=1.18u w=0.74u l=0.13u
X885 VGND.t3 sg13cmos5l_inv_1_693.A sg13cmos5l_inv_1_644.A VGND.t845 sg13_lv_nmos ad=0.2516p pd=2.16u as=0.2516p ps=2.16u w=0.74u l=0.13u
X886 VPWR.t1167 sg13cmos5l_inv_1_7.A sg13cmos5l_inv_1_7.Y VPWR.t11 sg13_lv_pmos ad=0.3808p pd=2.92u as=0.3808p ps=2.92u w=1.12u l=0.13u
X887 VGND.t102 sg13cmos5l_inv_1_483.Y sg13cmos5l_inv_1_486.Y VGND.t1115 sg13_lv_nmos ad=0.2516p pd=2.16u as=0.2516p ps=2.16u w=0.74u l=0.13u
X888 VPWR.t1457 sg13cmos5l_inv_1_323.A sg13cmos5l_inv_1_327.A VPWR.t8 sg13_lv_pmos ad=0.3808p pd=2.92u as=0.3808p ps=2.92u w=1.12u l=0.13u
X889 sg13cmos5l_mux4_1_10.A3 sg13cmos5l_inv_1_560.Y VGND.t100 VGND.t22 sg13_lv_nmos ad=0.2516p pd=2.16u as=0.2516p ps=2.16u w=0.74u l=0.13u
X890 VPWR.t356 sg13cmos5l_inv_1_912.A sg13cmos5l_inv_1_911.A VPWR.t26 sg13_lv_pmos ad=0.3808p pd=2.92u as=0.3808p ps=2.92u w=1.12u l=0.13u
X891 sg13cmos5l_inv_1_287.A sg13cmos5l_inv_1_286.Y VGND.t43 VGND.t406 sg13_lv_nmos ad=0.2516p pd=2.16u as=0.2516p ps=2.16u w=0.74u l=0.13u
X892 VGND.t1274 sg13cmos5l_mux4_1_2.A2 sg13cmos5l_inv_1_25.Y VGND.t1293 sg13_lv_nmos ad=0.2516p pd=2.16u as=0.2516p ps=2.16u w=0.74u l=0.13u
X893 sg13cmos5l_inv_1_650.Y sg13cmos5l_inv_1_650.A VPWR.t461 VPWR.t26 sg13_lv_pmos ad=0.3808p pd=2.92u as=0.3808p ps=2.92u w=1.12u l=0.13u
X894 sg13cmos5l_inv_1_84.Y sg13cmos5l_inv_1_84.A VGND.t123 VGND.t283 sg13_lv_nmos ad=0.2516p pd=2.16u as=0.2516p ps=2.16u w=0.74u l=0.13u
X895 sg13cmos5l_inv_1_920.A sg13cmos5l_inv_1_868.A VPWR.t290 VPWR.t21 sg13_lv_pmos ad=0.3808p pd=2.92u as=0.3808p ps=2.92u w=1.12u l=0.13u
X896 a_4438_15994# a_5005_16000# a_4929_16036# VPWR.t42 sg13_lv_pmos ad=0.34p pd=2.68u as=0.2225p ps=1.445u w=1u l=0.13u
X897 VPWR.t761 a_15275_7644# sg13cmos5l_mux2_1_3.A0 VPWR.t14 sg13_lv_pmos ad=0.34367p pd=1.775u as=0.3808p ps=2.92u w=1.12u l=0.13u
X898 VPWR.t821 sg13cmos5l_buf_1_18.A a_18280_12216# VPWR.t2 sg13_lv_pmos ad=0.2114p pd=1.54u as=0.2856p ps=2.36u w=0.84u l=0.13u
X899 VPWR.t413 sg13cmos5l_inv_1_240.A sg13cmos5l_inv_1_240.Y VPWR.t11 sg13_lv_pmos ad=0.3808p pd=2.92u as=0.3808p ps=2.92u w=1.12u l=0.13u
X900 sg13cmos5l_inv_1_791.A sg13cmos5l_inv_1_608.Y VPWR.t1249 VPWR.t39 sg13_lv_pmos ad=0.3808p pd=2.92u as=0.3808p ps=2.92u w=1.12u l=0.13u
X901 VPWR.t1203 sg13cmos5l_inv_1_44.A sg13cmos5l_mux4_1_1.A3 VPWR.t8 sg13_lv_pmos ad=0.3808p pd=2.92u as=0.3808p ps=2.92u w=1.12u l=0.13u
X902 sg13cmos5l_inv_1_191.Y sg13cmos5l_inv_1_191.A VPWR.t889 VPWR.t0 sg13_lv_pmos ad=0.3808p pd=2.92u as=0.3808p ps=2.92u w=1.12u l=0.13u
X903 a_3934_8070# a_3623_8070# a_3860_8070# VGND.t466 sg13_lv_nmos ad=0.1472p pd=1.1u as=76.8f ps=0.88u w=0.64u l=0.13u
X904 osc a_18856_1632# VPWR.t329 VPWR.t11 sg13_lv_pmos ad=0.42p pd=2.99u as=0.2114p ps=1.54u w=1.12u l=0.13u
X905 a_15768_4088# sg13cmos5l_buf_1_8.A.t1 VGND.t435 VGND.t1431 sg13_lv_nmos ad=0.187p pd=1.78u as=0.18945p ps=1.27u w=0.55u l=0.13u
X906 sg13cmos5l_inv_1_129.A sg13cmos5l_inv_1_122.Y VGND.t267 VGND.t965 sg13_lv_nmos ad=0.2516p pd=2.16u as=0.2516p ps=2.16u w=0.74u l=0.13u
X907 VPWR.t150 VGND.t46 VPWR.t149 VPWR.t21 sg13_lv_pmos ad=0.34p pd=2.68u as=0 ps=0 w=1u l=1u
X908 a_4929_12564# sg13cmos5l_buf_1_10.A a_3934_12606# VPWR.t2 sg13_lv_pmos ad=0.2225p pd=1.445u as=0.34p ps=2.68u w=1u l=0.13u
X909 VPWR.t139 VGND.t260 VPWR.t139 VPWR.t11 sg13_lv_pmos ad=0.34p pd=2.68u as=0 ps=0 w=1u l=1u
X910 VPWR.t1253 sg13cmos5l_inv_1_206.A sg13cmos5l_inv_1_206.Y VPWR.t0 sg13_lv_pmos ad=0.3808p pd=2.92u as=0.3808p ps=2.92u w=1.12u l=0.13u
X911 VGND.t160 sg13cmos5l_inv_1_531.A sg13cmos5l_inv_1_527.A VGND.t515 sg13_lv_nmos ad=0.2516p pd=2.16u as=0.2516p ps=2.16u w=0.74u l=0.13u
X912 a_4362_12606# sg13cmos5l_inv_1_523.Y VGND.t866 VGND.t1048 sg13_lv_nmos ad=80f pd=0.89u as=0.1824p ps=1.21u w=0.64u l=0.13u
X913 sg13cmos5l_inv_1_318.Y sg13cmos5l_inv_1_319.Y VPWR.t1420 VPWR.t49 sg13_lv_pmos ad=0.3808p pd=2.92u as=0.3808p ps=2.92u w=1.12u l=0.13u
X914 VPWR.t228 VGND.t612 VPWR.t227 VPWR.t2 sg13_lv_pmos ad=0.34p pd=2.68u as=0 ps=0 w=1u l=1u
X915 VGND.t54 sg13cmos5l_buf_1_7.X a_2920_3932# VGND.t780 sg13_lv_nmos ad=0.14875p pd=1.16u as=0.187p ps=1.78u w=0.55u l=0.13u
X916 a_8309_3149# a_7271_3534# a_8086_3534# VPWR.t8 sg13_lv_pmos ad=0.135p pd=1.27u as=0.4425p ps=1.885u w=1u l=0.13u
X917 VPWR.t997 sg13cmos5l_inv_1_345.A sg13cmos5l_inv_1_345.Y VPWR.t0 sg13_lv_pmos ad=0.3808p pd=2.92u as=0.3808p ps=2.92u w=1.12u l=0.13u
X918 a_14494_9582# a_15565_9466# a_15489_9540# VGND.t945 sg13_lv_nmos ad=0.2176p pd=1.96u as=0.1216p ps=1.02u w=0.64u l=0.13u
X919 VGND.t116 sg13cmos5l_inv_1_824.A sg13cmos5l_inv_1_825.A VGND.t22 sg13_lv_nmos ad=0.2516p pd=2.16u as=0.2516p ps=2.16u w=0.74u l=0.13u
X920 VPWR.t353 sg13cmos5l_inv_1_173.Y sg13cmos5l_inv_1_106.A VPWR.t14 sg13_lv_pmos ad=0.3808p pd=2.92u as=0.3808p ps=2.92u w=1.12u l=0.13u
X921 sg13cmos5l_inv_1_185.A sg13cmos5l_inv_1_227.A VPWR.t317 VPWR.t0 sg13_lv_pmos ad=0.3808p pd=2.92u as=0.3808p ps=2.92u w=1.12u l=0.13u
X922 sg13cmos5l_inv_1_171.A sg13cmos5l_inv_1_161.Y VGND.t128 VGND.t359 sg13_lv_nmos ad=0.2516p pd=2.16u as=0.2516p ps=2.16u w=0.74u l=0.13u
X923 VGND.t90 sg13cmos5l_inv_1_800.A sg13cmos5l_inv_1_800.Y VGND.t1184 sg13_lv_nmos ad=0.2516p pd=2.16u as=0.2516p ps=2.16u w=0.74u l=0.13u
X924 VGND.t44 sg13cmos5l_inv_1_609.A sg13cmos5l_inv_1_610.A VGND.t22 sg13_lv_nmos ad=0.2516p pd=2.16u as=0.2516p ps=2.16u w=0.74u l=0.13u
X925 VPWR.t156 VGND.t322 VPWR.t155 VPWR.t2 sg13_lv_pmos ad=0.34p pd=2.68u as=0 ps=0 w=1u l=1u
X926 sg13cmos5l_inv_1_161.Y sg13cmos5l_inv_1_163.Y VPWR.t595 VPWR.t29 sg13_lv_pmos ad=0.3808p pd=2.92u as=0.3808p ps=2.92u w=1.12u l=0.13u
X927 VGND.t267 VPWR.t1552 VGND.t267 VGND.t1580 sg13_lv_nmos ad=0.1428p pd=1.52u as=0 ps=0 w=0.42u l=1u
X928 a_4052_8070# sg13cmos5l_mux4_1_5.S0.t4 a_3934_8070# VGND.t863 sg13_lv_nmos ad=0.2304p pd=1.36u as=0.1472p ps=1.1u w=0.64u l=0.13u
X929 VPWR.t298 sg13cmos5l_inv_1_835.A sg13cmos5l_inv_1_823.A VPWR.t39 sg13_lv_pmos ad=0.3808p pd=2.92u as=0.3808p ps=2.92u w=1.12u l=0.13u
X930 VPWR.t351 invsel[4] a_808_13004# VPWR.t26 sg13_lv_pmos ad=0.2114p pd=1.54u as=0.2856p ps=2.36u w=0.84u l=0.13u
X931 a_13831_14749# sg13cmos5l_mux4_1_14.A0 VPWR.t734 VPWR.t21 sg13_lv_pmos ad=0.415p pd=1.83u as=0.22315p ps=1.555u w=1u l=0.13u
X932 VGND.t288 sg13cmos5l_buf_1_9.A a_4072_3932# VGND.t287 sg13_lv_nmos ad=0.14875p pd=1.16u as=0.187p ps=1.78u w=0.55u l=0.13u
X933 a_7582_15994# sg13cmos5l_mux4_1_5.S0.t7 a_7495_16261# VPWR.t42 sg13_lv_pmos ad=0.19p pd=1.38u as=0.415p ps=1.83u w=1u l=0.13u
X934 a_7333_13237# sg13cmos5l_mux4_1_7.A2 VPWR.t548 VPWR.t26 sg13_lv_pmos ad=0.20762p pd=1.605u as=0.29275p ps=1.785u w=1u l=0.13u
X935 a_14913_12564# sg13cmos5l_mux2_1_4.S.t3 a_13918_12606# VPWR.t2 sg13_lv_pmos ad=0.2225p pd=1.445u as=0.34p ps=2.68u w=1u l=0.13u
X936 sg13cmos5l_inv_1_272.A sg13cmos5l_inv_1_284.A VPWR.t1398 VPWR.t8 sg13_lv_pmos ad=0.3808p pd=2.92u as=0.3808p ps=2.92u w=1.12u l=0.13u
X937 sg13cmos5l_inv_1_120.A a_9996_11500# VPWR.t1131 VPWR.t2 sg13_lv_pmos ad=0.3808p pd=2.92u as=0.3808p ps=2.92u w=1.12u l=0.13u
X938 VPWR.t1302 sg13cmos5l_inv_1_17.A sg13cmos5l_inv_1_17.Y VPWR.t11 sg13_lv_pmos ad=0.3808p pd=2.92u as=0.3808p ps=2.92u w=1.12u l=0.13u
X939 VPWR.t41 VGND.t56 VPWR.t40 VPWR.t39 sg13_lv_pmos ad=0.34p pd=2.68u as=0 ps=0 w=1u l=1u
X940 a_7414_12970# a_6599_12970# a_7338_12970# VGND.t750 sg13_lv_nmos ad=0.1776p pd=1.195u as=80f ps=0.89u w=0.64u l=0.13u
X941 a_18764_12180# sg13cmos5l_buf_1_19.A VPWR.t812 VPWR.t2 sg13_lv_pmos ad=0.2856p pd=2.36u as=0.2114p ps=1.54u w=0.84u l=0.13u
X942 VGND.t147 VPWR.t1576 VGND.t147 VGND.t1547 sg13_lv_nmos ad=0.1428p pd=1.52u as=0 ps=0 w=0.42u l=1u
X943 sg13cmos5l_inv_1_797.Y sg13cmos5l_inv_1_797.A VGND.t98 VGND.t97 sg13_lv_nmos ad=0.2516p pd=2.16u as=0.2516p ps=2.16u w=0.74u l=0.13u
X944 VGND.t134 sg13cmos5l_inv_1_415.A sg13cmos5l_inv_1_416.A VGND.t11 sg13_lv_nmos ad=0.2516p pd=2.16u as=0.2516p ps=2.16u w=0.74u l=0.13u
X945 a_14346_12606# sg13cmos5l_inv_1_762.Y VGND.t478 VGND.t477 sg13_lv_nmos ad=80f pd=0.89u as=0.1824p ps=1.21u w=0.64u l=0.13u
X946 VGND.t1546 VPWR.t1577 VGND.t854 VGND.t1545 sg13_lv_nmos ad=0.1428p pd=1.52u as=0 ps=0 w=0.42u l=1u
X947 VPWR.t392 sg13cmos5l_inv_1_403.A sg13cmos5l_inv_1_403.Y VPWR.t14 sg13_lv_pmos ad=0.3808p pd=2.92u as=0.3808p ps=2.92u w=1.12u l=0.13u
X948 a_13918_14482# a_13607_14482# a_13844_14482# VGND.t1083 sg13_lv_nmos ad=0.1472p pd=1.1u as=76.8f ps=0.88u w=0.64u l=0.13u
X949 sg13cmos5l_inv_1_173.Y sg13cmos5l_inv_1_149.Y VGND.t1 VGND.t189 sg13_lv_nmos ad=0.2516p pd=2.16u as=0.2516p ps=2.16u w=0.74u l=0.13u
X950 VGND.t128 sg13cmos5l_inv_1_152.Y a_16324_8070# VGND.t1021 sg13_lv_nmos ad=0.1824p pd=1.21u as=80f ps=0.89u w=0.64u l=0.13u
X951 VPWR.t1261 sg13cmos5l_inv_1_168.A sg13cmos5l_inv_1_176.A VPWR.t14 sg13_lv_pmos ad=0.3808p pd=2.92u as=0.3808p ps=2.92u w=1.12u l=0.13u
X952 VGND.t145 sg13cmos5l_inv_1_507.A sg13cmos5l_inv_1_507.Y VGND.t969 sg13_lv_nmos ad=0.2516p pd=2.16u as=0.2516p ps=2.16u w=0.74u l=0.13u
X953 VPWR.t1037 sg13cmos5l_inv_1_983.Y sg13cmos5l_inv_1_921.Y VPWR.t5 sg13_lv_pmos ad=0.3808p pd=2.92u as=0.3808p ps=2.92u w=1.12u l=0.13u
X954 sg13cmos5l_inv_1_346.Y sg13cmos5l_inv_1_345.Y VGND.t614 VGND.t613 sg13_lv_nmos ad=0.2516p pd=2.16u as=0.2516p ps=2.16u w=0.74u l=0.13u
X955 VGND.t133 sg13cmos5l_inv_1_491.A sg13cmos5l_inv_1_485.A VGND.t375 sg13_lv_nmos ad=0.2516p pd=2.16u as=0.2516p ps=2.16u w=0.74u l=0.13u
X956 a_14533_3195# sg13cmos5l_inv_1_45.Y VPWR.t1145 VPWR.t8 sg13_lv_pmos ad=0.20762p pd=1.605u as=0.29275p ps=1.785u w=1u l=0.13u
X957 sg13cmos5l_nor3_1_0.Y sg13cmos5l_mux2_1_3.S VGND.t191 VGND.t4 sg13_lv_nmos ad=0.1694p pd=1.21u as=0.1463p ps=1.15u w=0.77u l=0.13u
X958 VPWR.t118 VGND.t1 VPWR.t117 VPWR.t14 sg13_lv_pmos ad=0.34p pd=2.68u as=0 ps=0 w=1u l=1u
X959 a_8446_8434# sg13cmos5l_mux4_1_4.X a_8349_8728# VPWR.t29 sg13_lv_pmos ad=0.2225p pd=1.445u as=0.3325p ps=1.665u w=1u l=0.13u
X960 sg13cmos5l_inv_1_770.A sg13cmos5l_inv_1_769.Y VPWR.t1334 VPWR.t39 sg13_lv_pmos ad=0.3808p pd=2.92u as=0.3808p ps=2.92u w=1.12u l=0.13u
X961 VGND.t28 sg13cmos5l_inv_1_28.A sg13cmos5l_inv_1_76.A VGND.t237 sg13_lv_nmos ad=0.2516p pd=2.16u as=0.2516p ps=2.16u w=0.74u l=0.13u
X962 a_14710_15630# a_13895_15630# a_14634_15630# VGND.t730 sg13_lv_nmos ad=0.1776p pd=1.195u as=80f ps=0.89u w=0.64u l=0.13u
X963 sg13cmos5l_inv_1_648.Y sg13cmos5l_inv_1_649.Y VPWR.t1192 VPWR.t26 sg13_lv_pmos ad=0.3808p pd=2.92u as=0.3808p ps=2.92u w=1.12u l=0.13u
X964 VGND.t315 sg13cmos5l_inv_1_722.Y sg13cmos5l_inv_1_730.A VGND.t1112 sg13_lv_nmos ad=0.2516p pd=2.16u as=0.2516p ps=2.16u w=0.74u l=0.13u
X965 a_3934_8070# a_5005_7954# a_4929_8028# VGND.t1010 sg13_lv_nmos ad=0.2176p pd=1.96u as=0.1216p ps=1.02u w=0.64u l=0.13u
X966 sg13cmos5l_inv_1_155.Y sg13cmos5l_mux4_1_0.A0 VGND.t130 VGND.t129 sg13_lv_nmos ad=0.2516p pd=2.16u as=0.2516p ps=2.16u w=0.74u l=0.13u
X967 a_4975_13264# sg13cmos5l_mux4_1_9.X a_4798_12970# VPWR.t26 sg13_lv_pmos ad=0.2975p pd=1.595u as=0.2225p ps=1.445u w=1u l=0.13u
X968 sg13cmos5l_inv_1_866.Y sg13cmos5l_inv_1_815.Y VGND.t35 VGND.t819 sg13_lv_nmos ad=0.2516p pd=2.16u as=0.2516p ps=2.16u w=0.74u l=0.13u
X969 a_7028_12970# sg13cmos5l_mux4_1_5.S0.t6 a_6910_12970# VGND.t1250 sg13_lv_nmos ad=0.2304p pd=1.36u as=0.1472p ps=1.1u w=0.64u l=0.13u
X970 sg13cmos5l_inv_1_1012.Y sg13cmos5l_inv_1_947.Y VPWR.t719 VPWR.t5 sg13_lv_pmos ad=0.3808p pd=2.92u as=0.3808p ps=2.92u w=1.12u l=0.13u
X971 a_14494_9582# a_14183_9582# a_14420_9582# VGND.t441 sg13_lv_nmos ad=0.1472p pd=1.1u as=76.8f ps=0.88u w=0.64u l=0.13u
X972 a_10437_10240# sg13cmos5l_nand2_1_1.B VPWR.t823 VPWR.t5 sg13_lv_pmos ad=0.2464p pd=1.56u as=0.3808p ps=2.92u w=1.12u l=0.13u
X973 sg13cmos5l_mux4_1_0.A0 sg13cmos5l_inv_1_159.Y VPWR.t585 VPWR.t29 sg13_lv_pmos ad=0.3808p pd=2.92u as=0.3808p ps=2.92u w=1.12u l=0.13u
X974 sg13cmos5l_inv_1_612.A sg13cmos5l_mux4_1_8.A2 VPWR.t289 VPWR.t42 sg13_lv_pmos ad=0.3808p pd=2.92u as=0.3808p ps=2.92u w=1.12u l=0.13u
X975 a_14629_15291# sg13cmos5l_inv_1_874.Y VPWR.t703 VPWR.t21 sg13_lv_pmos ad=0.20762p pd=1.605u as=0.29275p ps=1.785u w=1u l=0.13u
X976 VPWR.t700 sg13cmos5l_mux4_1_1.A3 a_14837_3149# VPWR.t8 sg13_lv_pmos ad=0.34p pd=2.68u as=0.135p ps=1.27u w=1u l=0.13u
X977 VGND.t325 sg13cmos5l_inv_1_772.A sg13cmos5l_inv_1_606.A VGND.t386 sg13_lv_nmos ad=0.2516p pd=2.16u as=0.2516p ps=2.16u w=0.74u l=0.13u
X978 VPWR.t20 VGND.t134 VPWR.t247 VPWR.t0 sg13_lv_pmos ad=0.34p pd=2.68u as=0 ps=0 w=1u l=1u
X979 sg13cmos5l_inv_1_403.A sg13cmos5l_inv_1_401.Y VPWR.t641 VPWR.t14 sg13_lv_pmos ad=0.3808p pd=2.92u as=0.3808p ps=2.92u w=1.12u l=0.13u
X980 VPWR.t717 sg13cmos5l_mux4_1_5.S1.t6 a_5005_7954# VPWR.t14 sg13_lv_pmos ad=0.34367p pd=1.775u as=0.34p ps=2.68u w=1u l=0.13u
X981 VGND.t15 sg13cmos5l_inv_1_351.Y sg13cmos5l_inv_1_370.A VGND.t1148 sg13_lv_nmos ad=0.2516p pd=2.16u as=0.2516p ps=2.16u w=0.74u l=0.13u
X982 sg13cmos5l_inv_1_804.A sg13cmos5l_inv_1_775.Y VGND.t197 VGND.t22 sg13_lv_nmos ad=0.2516p pd=2.16u as=0.2516p ps=2.16u w=0.74u l=0.13u
X983 VPWR.t1129 sg13cmos5l_inv_1_514.A sg13cmos5l_inv_1_514.Y VPWR.t2 sg13_lv_pmos ad=0.3808p pd=2.92u as=0.3808p ps=2.92u w=1.12u l=0.13u
X984 VPWR.t1018 sg13cmos5l_inv_1_370.Y sg13cmos5l_inv_1_369.A VPWR.t29 sg13_lv_pmos ad=0.3808p pd=2.92u as=0.3808p ps=2.92u w=1.12u l=0.13u
X985 sg13cmos5l_inv_1_855.A sg13cmos5l_inv_1_863.Y VPWR.t362 VPWR.t42 sg13_lv_pmos ad=0.3808p pd=2.92u as=0.3808p ps=2.92u w=1.12u l=0.13u
X986 a_9498_3168# a_9432_3406# VPWR.t355 VPWR.t8 sg13_lv_pmos ad=0.2975p pd=1.595u as=0.2198p ps=1.52u w=1u l=0.13u
X987 sg13cmos5l_inv_1_211.Y sg13cmos5l_inv_1_207.Y VPWR.t604 VPWR.t0 sg13_lv_pmos ad=0.3808p pd=2.92u as=0.3808p ps=2.92u w=1.12u l=0.13u
X988 VGND.t478 VPWR.t1582 VGND.t478 VGND.t1539 sg13_lv_nmos ad=0.1428p pd=1.52u as=0 ps=0 w=0.42u l=1u
X989 sg13cmos5l_inv_1_410.Y sg13cmos5l_inv_1_318.Y VGND.t19 VGND.t505 sg13_lv_nmos ad=0.2516p pd=2.16u as=0.2516p ps=2.16u w=0.74u l=0.13u
X990 VGND.t76 sg13cmos5l_mux2_1_3.S a_8123_8472# VGND.t1039 sg13_lv_nmos ad=0.18945p pd=1.27u as=0.187p ps=1.78u w=0.55u l=0.13u
X991 sg13cmos5l_inv_1_857.Y sg13cmos5l_inv_1_857.A VGND.t285 VGND.t286 sg13_lv_nmos ad=0.2516p pd=2.16u as=0.2516p ps=2.16u w=0.74u l=0.13u
X992 VPWR.t739 sg13cmos5l_inv_1_103.A sg13cmos5l_inv_1_59.A VPWR.t8 sg13_lv_pmos ad=0.3808p pd=2.92u as=0.3808p ps=2.92u w=1.12u l=0.13u
X993 sg13cmos5l_inv_1_216.Y sg13cmos5l_inv_1_97.Y VPWR.t1358 VPWR.t8 sg13_lv_pmos ad=0.3808p pd=2.92u as=0.3808p ps=2.92u w=1.12u l=0.13u
X994 VGND.t3 sg13cmos5l_inv_1_898.Y sg13cmos5l_inv_1_886.Y VGND.t961 sg13_lv_nmos ad=0.2516p pd=2.16u as=0.2516p ps=2.16u w=0.74u l=0.13u
X995 sg13cmos5l_inv_1_142.A sg13cmos5l_inv_1_186.Y VPWR.t1254 VPWR.t0 sg13_lv_pmos ad=0.3808p pd=2.92u as=0.3808p ps=2.92u w=1.12u l=0.13u
X996 a_8349_8434# sg13cmos5l_mux2_1_3.S VGND.t76 VGND.t1038 sg13_lv_nmos ad=0.13135p pd=1.095u as=0.18945p ps=1.27u w=0.74u l=0.13u
X997 VPWR.t136 VGND.t430 VPWR.t135 VPWR.t14 sg13_lv_pmos ad=0.34p pd=2.68u as=0 ps=0 w=1u l=1u
X998 a_4438_8070# a_5005_7954# a_4929_8028# VPWR.t14 sg13_lv_pmos ad=0.34p pd=2.68u as=0.2225p ps=1.445u w=1u l=0.13u
X999 VGND.t29 VPWR.t1610 VGND.t29 VGND.t22 sg13_lv_nmos ad=0.1428p pd=1.52u as=0 ps=0 w=0.42u l=1u
X1000 VPWR.t831 sg13cmos5l_inv_1_631.A sg13cmos5l_inv_1_631.Y VPWR.t21 sg13_lv_pmos ad=0.3808p pd=2.92u as=0.3808p ps=2.92u w=1.12u l=0.13u
X1001 VGND.t987 sg13cmos5l_inv_1_664.A sg13cmos5l_inv_1_665.A VGND.t986 sg13_lv_nmos ad=0.2516p pd=2.16u as=0.2516p ps=2.16u w=0.74u l=0.13u
X1002 VGND.t596 sg13cmos5l_inv_1_17.A sg13cmos5l_inv_1_17.Y VGND.t1295 sg13_lv_nmos ad=0.2516p pd=2.16u as=0.2516p ps=2.16u w=0.74u l=0.13u
X1003 sg13cmos5l_inv_1_2.A sg13cmos5l_inv_1_7.Y VPWR.t460 VPWR.t11 sg13_lv_pmos ad=0.3808p pd=2.92u as=0.3808p ps=2.92u w=1.12u l=0.13u
X1004 sg13cmos5l_mux4_1_14.A0 sg13cmos5l_inv_1_786.Y VGND.t96 VGND.t1339 sg13_lv_nmos ad=0.2516p pd=2.16u as=0.2516p ps=2.16u w=0.74u l=0.13u
X1005 VPWR.t203 VGND.t260 VPWR.t202 VPWR.t8 sg13_lv_pmos ad=0.34p pd=2.68u as=0 ps=0 w=1u l=1u
X1006 VGND.t107 sg13cmos5l_inv_1_393.A sg13cmos5l_inv_1_393.Y VGND.t1045 sg13_lv_nmos ad=0.2516p pd=2.16u as=0.2516p ps=2.16u w=0.74u l=0.13u
X1007 a_14422_3898# a_14989_3904# a_14913_3940# VPWR.t49 sg13_lv_pmos ad=0.34p pd=2.68u as=0.2225p ps=1.445u w=1u l=0.13u
X1008 VGND.t162 sg13cmos5l_inv_1_403.A sg13cmos5l_inv_1_403.Y VGND.t216 sg13_lv_nmos ad=0.2516p pd=2.16u as=0.2516p ps=2.16u w=0.74u l=0.13u
X1009 VGND.t1378 sg13cmos5l_inv_1_332.A sg13cmos5l_inv_1_307.A VGND.t1377 sg13_lv_nmos ad=0.2516p pd=2.16u as=0.2516p ps=2.16u w=0.74u l=0.13u
X1010 a_8756_6558# sg13cmos5l_mux4_1_5.S0.t3 a_8638_6558# VGND.t860 sg13_lv_nmos ad=0.2304p pd=1.36u as=0.1472p ps=1.1u w=0.64u l=0.13u
X1011 sg13cmos5l_inv_1_838.Y sg13cmos5l_inv_1_823.Y VPWR.t1330 VPWR.t39 sg13_lv_pmos ad=0.3808p pd=2.92u as=0.3808p ps=2.92u w=1.12u l=0.13u
X1012 VPWR.t995 sg13cmos5l_inv_1_446.A sg13cmos5l_inv_1_441.A VPWR.t49 sg13_lv_pmos ad=0.3808p pd=2.92u as=0.3808p ps=2.92u w=1.12u l=0.13u
X1013 sg13cmos5l_inv_1_124.Y sg13cmos5l_inv_1_124.A VPWR.t942 VPWR.t14 sg13_lv_pmos ad=0.3808p pd=2.92u as=0.3808p ps=2.92u w=1.12u l=0.13u
X1014 sg13cmos5l_inv_1_311.Y sg13cmos5l_inv_1_311.A VPWR.t139 VPWR.t11 sg13_lv_pmos ad=0.3808p pd=2.92u as=0.3808p ps=2.92u w=1.12u l=0.13u
X1015 VGND.t46 VPWR.t1601 VGND.t46 VGND.t1210 sg13_lv_nmos ad=0.1428p pd=1.52u as=0 ps=0 w=0.42u l=1u
X1016 VGND.t1094 sg13cmos5l_inv_1_168.A sg13cmos5l_inv_1_176.A VGND.t481 sg13_lv_nmos ad=0.2516p pd=2.16u as=0.2516p ps=2.16u w=0.74u l=0.13u
X1017 sg13cmos5l_inv_1_548.Y sg13cmos5l_inv_1_545.Y VPWR.t474 VPWR.t39 sg13_lv_pmos ad=0.3808p pd=2.92u as=0.3808p ps=2.92u w=1.12u l=0.13u
X1018 VGND.t174 sg13cmos5l_inv_1_987.A sg13cmos5l_inv_1_493.A VGND.t1019 sg13_lv_nmos ad=0.2516p pd=2.16u as=0.2516p ps=2.16u w=0.74u l=0.13u
X1019 sg13cmos5l_inv_1_112.A sg13cmos5l_inv_1_113.Y VPWR.t943 VPWR.t29 sg13_lv_pmos ad=0.3808p pd=2.92u as=0.3808p ps=2.92u w=1.12u l=0.13u
X1020 VPWR.t666 sg13cmos5l_inv_1_520.A sg13cmos5l_inv_1_518.A VPWR.t2 sg13_lv_pmos ad=0.3808p pd=2.92u as=0.3808p ps=2.92u w=1.12u l=0.13u
X1021 sg13cmos5l_inv_1_969.Y sg13cmos5l_inv_1_984.Y VGND.t143 VGND.t4 sg13_lv_nmos ad=0.2516p pd=2.16u as=0.2516p ps=2.16u w=0.74u l=0.13u
X1022 sg13cmos5l_inv_1_329.A sg13cmos5l_inv_1_336.A VGND.t119 VGND.t118 sg13_lv_nmos ad=0.2516p pd=2.16u as=0.2516p ps=2.16u w=0.74u l=0.13u
X1023 sg13cmos5l_inv_1_490.A sg13cmos5l_inv_1_498.A VPWR.t430 VPWR.t2 sg13_lv_pmos ad=0.3808p pd=2.92u as=0.3808p ps=2.92u w=1.12u l=0.13u
X1024 VPWR.t548 sg13cmos5l_mux4_1_7.A1 a_7117_13237# VPWR.t26 sg13_lv_pmos ad=0.29275p pd=1.785u as=0.16p ps=1.32u w=1u l=0.13u
X1025 a_8810_10704# sg13cmos5l_nor3_1_1.A VPWR.t1108 VPWR.t5 sg13_lv_pmos ad=0.1176p pd=1.33u as=0.4032p ps=2.96u w=1.12u l=0.13u
X1026 VPWR.t1099 sg13cmos5l_inv_1_947.A sg13cmos5l_inv_1_947.Y VPWR.t5 sg13_lv_pmos ad=0.3808p pd=2.92u as=0.3808p ps=2.92u w=1.12u l=0.13u
X1027 VPWR.t105 VGND.t267 VPWR.t104 VPWR.t29 sg13_lv_pmos ad=0.34p pd=2.68u as=0 ps=0 w=1u l=1u
X1028 a_14998_9582# a_14183_9582# a_14922_9582# VGND.t442 sg13_lv_nmos ad=0.1776p pd=1.195u as=80f ps=0.89u w=0.64u l=0.13u
X1029 VPWR.t1205 sg13cmos5l_inv_1_331.A sg13cmos5l_inv_1_301.A VPWR.t8 sg13_lv_pmos ad=0.3808p pd=2.92u as=0.3808p ps=2.92u w=1.12u l=0.13u
X1030 sg13cmos5l_inv_1_205.A sg13cmos5l_inv_1_145.Y VGND.t335 VGND.t1340 sg13_lv_nmos ad=0.2516p pd=2.16u as=0.2516p ps=2.16u w=0.74u l=0.13u
X1031 VGND.t23 sg13cmos5l_inv_1_819.A sg13cmos5l_inv_1_819.Y VGND.t22 sg13_lv_nmos ad=0.2516p pd=2.16u as=0.2516p ps=2.16u w=0.74u l=0.13u
X1032 a_4052_15994# sg13cmos5l_mux4_1_5.S0.t8 a_3934_15994# VGND.t1256 sg13_lv_nmos ad=0.2304p pd=1.36u as=0.1472p ps=1.1u w=0.64u l=0.13u
X1033 sg13cmos5l_inv_1_645.A sg13cmos5l_inv_1_684.Y VPWR.t907 VPWR.t21 sg13_lv_pmos ad=0.3808p pd=2.92u as=0.3808p ps=2.92u w=1.12u l=0.13u
X1034 sg13cmos5l_inv_1_876.A sg13cmos5l_inv_1_873.A VPWR.t587 VPWR.t21 sg13_lv_pmos ad=0.3808p pd=2.92u as=0.3808p ps=2.92u w=1.12u l=0.13u
X1035 sg13cmos5l_inv_1_480.Y sg13cmos5l_inv_1_480.A VPWR.t993 VPWR.t26 sg13_lv_pmos ad=0.3808p pd=2.92u as=0.3808p ps=2.92u w=1.12u l=0.13u
X1036 VGND.t54 sg13cmos5l_mux4_1_5.S0.t2 a_3623_3534# VGND.t1252 sg13_lv_nmos ad=0.1872p pd=1.225u as=0.2176p ps=1.96u w=0.64u l=0.13u
X1037 sg13cmos5l_inv_1_222.Y sg13cmos5l_inv_1_184.Y VGND.t16 VGND.t11 sg13_lv_nmos ad=0.2516p pd=2.16u as=0.2516p ps=2.16u w=0.74u l=0.13u
X1038 VPWR.t1245 sg13cmos5l_inv_1_575.A sg13cmos5l_inv_1_575.Y VPWR.t42 sg13_lv_pmos ad=0.3808p pd=2.92u as=0.3808p ps=2.92u w=1.12u l=0.13u
X1039 VPWR.t184 VGND.t587 VPWR.t183 VPWR.t21 sg13_lv_pmos ad=0.34p pd=2.68u as=0 ps=0 w=1u l=1u
X1040 sg13cmos5l_inv_1_612.A sg13cmos5l_mux4_1_8.A2 VGND.t56 VGND.t22 sg13_lv_nmos ad=0.2516p pd=2.16u as=0.2516p ps=2.16u w=0.74u l=0.13u
X1041 VPWR.t1023 sg13cmos5l_inv_1_507.A sg13cmos5l_inv_1_507.Y VPWR.t5 sg13_lv_pmos ad=0.3808p pd=2.92u as=0.3808p ps=2.92u w=1.12u l=0.13u
X1042 sg13cmos5l_inv_1_585.A sg13cmos5l_inv_1_592.Y VGND.t558 VGND.t563 sg13_lv_nmos ad=0.2516p pd=2.16u as=0.2516p ps=2.16u w=0.74u l=0.13u
X1043 VPWR.t291 sg13cmos5l_inv_1_566.A sg13cmos5l_inv_1_533.A VPWR.t42 sg13_lv_pmos ad=0.3808p pd=2.92u as=0.3808p ps=2.92u w=1.12u l=0.13u
X1044 VPWR.t471 sg13cmos5l_inv_1_834.Y sg13cmos5l_inv_1_824.A VPWR.t39 sg13_lv_pmos ad=0.3808p pd=2.92u as=0.3808p ps=2.92u w=1.12u l=0.13u
X1045 VPWR.t166 VGND.t23 VPWR.t164 VPWR.t39 sg13_lv_pmos ad=0.19p pd=1.38u as=0 ps=0 w=1u l=1u
X1046 VGND.t478 sg13cmos5l_buf_1_9.A.t2 a_13607_12606# VGND.t712 sg13_lv_nmos ad=0.1872p pd=1.225u as=0.2176p ps=1.96u w=0.64u l=0.13u
X1047 sg13cmos5l_inv_1_109.Y sg13cmos5l_inv_1_108.Y VPWR.t1017 VPWR.t0 sg13_lv_pmos ad=0.3808p pd=2.92u as=0.3808p ps=2.92u w=1.12u l=0.13u
X1048 sg13cmos5l_inv_1_403.A sg13cmos5l_inv_1_401.Y VGND.t162 VGND.t524 sg13_lv_nmos ad=0.2516p pd=2.16u as=0.2516p ps=2.16u w=0.74u l=0.13u
X1049 VGND.t971 VPWR.t1554 VGND.t105 VGND.t1577 sg13_lv_nmos ad=0.1428p pd=1.52u as=0 ps=0 w=0.42u l=1u
X1050 sg13cmos5l_a21oi_1_0.Y sg13cmos5l_a21oi_1_0.B1 VGND.t188 VGND.t590 sg13_lv_nmos ad=0.1406p pd=1.12u as=0.2516p ps=2.16u w=0.74u l=0.13u
X1051 VPWR.t1362 sg13cmos5l_inv_1_937.Y sg13cmos5l_inv_1_938.A VPWR.t5 sg13_lv_pmos ad=0.3808p pd=2.92u as=0.3808p ps=2.92u w=1.12u l=0.13u
X1052 VPWR.t620 sg13cmos5l_inv_1_292.Y sg13cmos5l_inv_1_274.Y VPWR.t8 sg13_lv_pmos ad=0.3808p pd=2.92u as=0.3808p ps=2.92u w=1.12u l=0.13u
X1053 VPWR.t1410 a_14027_11654# sg13cmos5l_or2_1_0.B VPWR.t2 sg13_lv_pmos ad=0.34367p pd=1.775u as=0.3808p ps=2.92u w=1.12u l=0.13u
X1054 VPWR.t284 sg13cmos5l_inv_1_553.Y sg13cmos5l_inv_1_543.Y VPWR.t39 sg13_lv_pmos ad=0.3808p pd=2.92u as=0.3808p ps=2.92u w=1.12u l=0.13u
X1055 sg13cmos5l_inv_1_855.A sg13cmos5l_inv_1_863.Y VGND.t23 VGND.t22 sg13_lv_nmos ad=0.2516p pd=2.16u as=0.2516p ps=2.16u w=0.74u l=0.13u
X1056 a_14389_11500# sg13cmos5l_buf_1_8.A.t3 a_14027_11654# VPWR.t2 sg13_lv_pmos ad=0.34p pd=2.68u as=0.2225p ps=1.445u w=1u l=0.13u
X1057 VGND.t126 VPWR.t1579 VGND.t126 VGND.t1534 sg13_lv_nmos ad=0.1428p pd=1.52u as=0 ps=0 w=0.42u l=1u
X1058 VGND.t46 sg13cmos5l_inv_1_582.A a_8223_15994# VGND.t744 sg13_lv_nmos ad=0.2176p pd=1.96u as=76.8f ps=0.88u w=0.64u l=0.13u
X1059 sg13cmos5l_inv_1_5.Y sg13cmos5l_inv_1_43.Y VGND.t492 VGND.t1130 sg13_lv_nmos ad=0.2516p pd=2.16u as=0.2516p ps=2.16u w=0.74u l=0.13u
X1060 sg13cmos5l_inv_1_818.A sg13cmos5l_inv_1_858.Y VGND.t59 VGND.t279 sg13_lv_nmos ad=0.2516p pd=2.16u as=0.2516p ps=2.16u w=0.74u l=0.13u
X1061 VGND.t6 VPWR.t1558 VGND.t6 VGND.t4 sg13_lv_nmos ad=0.1428p pd=1.52u as=0 ps=0 w=0.42u l=1u
X1062 sg13cmos5l_inv_1_281.Y sg13cmos5l_inv_1_285.Y VGND.t617 VGND.t1299 sg13_lv_nmos ad=0.2516p pd=2.16u as=0.2516p ps=2.16u w=0.74u l=0.13u
X1063 a_3934_3534# sg13cmos5l_mux4_1_5.S0.t2 a_3847_3195# VPWR.t8 sg13_lv_pmos ad=0.19p pd=1.38u as=0.415p ps=1.83u w=1u l=0.13u
X1064 VPWR.t63 VGND.t536 VPWR.t62 VPWR.t11 sg13_lv_pmos ad=0.34p pd=2.68u as=0 ps=0 w=1u l=1u
X1065 VGND.t1632 VPWR.t139 VGND.t1632 VGND.t1631 sg13_lv_nmos ad=0.1428p pd=1.52u as=0 ps=0 w=0.42u l=1u
X1066 VPWR.t1152 sg13cmos5l_mux2_1_4.S.t4 a_14989_14488# VPWR.t21 sg13_lv_pmos ad=0.34367p pd=1.775u as=0.34p ps=2.68u w=1u l=0.13u
X1067 VGND.t939 VPWR.t1533 VGND.t134 VGND.t11 sg13_lv_nmos ad=0.1428p pd=1.52u as=0 ps=0 w=0.42u l=1u
X1068 a_4438_12606# sg13cmos5l_buf_1_8.A.t4 a_4357_12267# VPWR.t2 sg13_lv_pmos ad=0.4425p pd=1.885u as=0.20762p ps=1.605u w=1u l=0.13u
X1069 a_15283_11725# sg13cmos5l_mux4_1_11.A1 VPWR.t370 VPWR.t2 sg13_lv_pmos ad=0.16p pd=1.32u as=0.29275p ps=1.785u w=1u l=0.13u
X1070 a_9326_3410# sg13cmos5l_mux4_1_3.X a_9498_3168# VPWR.t8 sg13_lv_pmos ad=0.2225p pd=1.445u as=0.2975p ps=1.595u w=1u l=0.13u
X1071 sg13cmos5l_inv_1_224.A sg13cmos5l_inv_1_228.Y VGND.t16 VGND.t11 sg13_lv_nmos ad=0.2516p pd=2.16u as=0.2516p ps=2.16u w=0.74u l=0.13u
X1072 sg13cmos5l_inv_1_930.A sg13cmos5l_inv_1_961.Y VGND.t10 VGND.t1421 sg13_lv_nmos ad=0.2516p pd=2.16u as=0.2516p ps=2.16u w=0.74u l=0.13u
X1073 VPWR.t406 sg13cmos5l_inv_1_876.A sg13cmos5l_inv_1_876.Y VPWR.t21 sg13_lv_pmos ad=0.3808p pd=2.92u as=0.3808p ps=2.92u w=1.12u l=0.13u
X1074 sg13cmos5l_inv_1_729.Y sg13cmos5l_inv_1_730.Y VPWR.t523 VPWR.t2 sg13_lv_pmos ad=0.3808p pd=2.92u as=0.3808p ps=2.92u w=1.12u l=0.13u
X1075 VGND.t117 sg13cmos5l_inv_1_424.A sg13cmos5l_inv_1_423.A VGND.t11 sg13_lv_nmos ad=0.2516p pd=2.16u as=0.2516p ps=2.16u w=0.74u l=0.13u
X1076 VPWR.t563 sg13cmos5l_buf_1_2.X a_18856_3932# VPWR.t49 sg13_lv_pmos ad=0.2114p pd=1.54u as=0.2856p ps=2.36u w=0.84u l=0.13u
X1077 sg13cmos5l_inv_1_2.A sg13cmos5l_inv_1_7.Y VGND.t21 VGND.t303 sg13_lv_nmos ad=0.2516p pd=2.16u as=0.2516p ps=2.16u w=0.74u l=0.13u
X1078 VGND.t116 sg13cmos5l_inv_1_836.A sg13cmos5l_inv_1_836.Y VGND.t22 sg13_lv_nmos ad=0.2516p pd=2.16u as=0.2516p ps=2.16u w=0.74u l=0.13u
X1079 VGND.t8 sg13cmos5l_inv_1_937.Y sg13cmos5l_inv_1_938.A VGND.t190 sg13_lv_nmos ad=0.2516p pd=2.16u as=0.2516p ps=2.16u w=0.74u l=0.13u
X1080 VGND.t478 VPWR.t1584 VGND.t478 VGND.t1536 sg13_lv_nmos ad=79.8f pd=0.8u as=0 ps=0 w=0.42u l=1u
X1081 a_15201_15588# sg13cmos5l_mux2_1_4.S.t5 a_14206_15630# VPWR.t21 sg13_lv_pmos ad=0.2225p pd=1.445u as=0.34p ps=2.68u w=1u l=0.13u
X1082 VPWR.t514 sg13cmos5l_inv_1_55.Y sg13cmos5l_inv_1_42.A VPWR.t8 sg13_lv_pmos ad=0.3808p pd=2.92u as=0.3808p ps=2.92u w=1.12u l=0.13u
X1083 VGND.t162 VPWR.t1549 VGND.t162 VGND.t1583 sg13_lv_nmos ad=0.1428p pd=1.52u as=0 ps=0 w=0.42u l=1u
X1084 sg13cmos5l_inv_1_509.Y sg13cmos5l_inv_1_509.A VGND.t322 VGND.t1120 sg13_lv_nmos ad=0.2516p pd=2.16u as=0.2516p ps=2.16u w=0.74u l=0.13u
X1085 sg13cmos5l_inv_1_311.Y sg13cmos5l_inv_1_311.A VGND.t119 VGND.t118 sg13_lv_nmos ad=0.2516p pd=2.16u as=0.2516p ps=2.16u w=0.74u l=0.13u
X1086 VGND.t5 sg13cmos5l_inv_1_947.A sg13cmos5l_inv_1_947.Y VGND.t190 sg13_lv_nmos ad=0.2516p pd=2.16u as=0.2516p ps=2.16u w=0.74u l=0.13u
X1087 VGND.t123 sg13cmos5l_inv_1_72.Y sg13cmos5l_inv_1_84.A VGND.t538 sg13_lv_nmos ad=0.2516p pd=2.16u as=0.2516p ps=2.16u w=0.74u l=0.13u
X1088 a_8551_6219# sg13cmos5l_inv_1_382.A VPWR.t923 VPWR.t0 sg13_lv_pmos ad=0.415p pd=1.83u as=0.22315p ps=1.555u w=1u l=0.13u
X1089 sg13cmos5l_inv_1_542.A sg13cmos5l_inv_1_548.Y VPWR.t1212 VPWR.t39 sg13_lv_pmos ad=0.3808p pd=2.92u as=0.3808p ps=2.92u w=1.12u l=0.13u
X1090 VPWR.t734 sg13cmos5l_buf_1_9.A.t4 a_13607_14482# VPWR.t21 sg13_lv_pmos ad=0.22315p pd=1.555u as=0.34p ps=2.68u w=1u l=0.13u
X1091 VPWR.t732 sg13cmos5l_inv_1_46.A sg13cmos5l_inv_1_46.Y VPWR.t8 sg13_lv_pmos ad=0.3808p pd=2.92u as=0.3808p ps=2.92u w=1.12u l=0.13u
X1092 sg13cmos5l_inv_1_133.Y sg13cmos5l_inv_1_132.Y VGND.t354 VGND.t901 sg13_lv_nmos ad=0.2516p pd=2.16u as=0.2516p ps=2.16u w=0.74u l=0.13u
X1093 VPWR.t234 VGND.t612 VPWR.t232 VPWR.t5 sg13_lv_pmos ad=0.19p pd=1.38u as=0 ps=0 w=1u l=1u
X1094 a_7582_3534# a_8653_3418# a_8577_3492# VGND.t1454 sg13_lv_nmos ad=0.2176p pd=1.96u as=0.1216p ps=1.02u w=0.64u l=0.13u
X1095 VPWR.t60 VGND.t1565 VPWR.t114 VPWR.t29 sg13_lv_pmos ad=0.34p pd=2.68u as=0 ps=0 w=1u l=1u
X1096 osc a_18856_1632# VGND.t64 VGND.t1139 sg13_lv_nmos ad=0.2886p pd=2.26u as=0.14875p ps=1.16u w=0.74u l=0.13u
X1097 sg13cmos5l_inv_1_969.Y sg13cmos5l_inv_1_984.Y VPWR.t340 VPWR.t29 sg13_lv_pmos ad=0.3808p pd=2.92u as=0.3808p ps=2.92u w=1.12u l=0.13u
X1098 sg13cmos5l_inv_1_570.A sg13cmos5l_inv_1_544.Y VGND.t29 VGND.t22 sg13_lv_nmos ad=0.2516p pd=2.16u as=0.2516p ps=2.16u w=0.74u l=0.13u
X1099 sg13cmos5l_mux4_1_5.X a_4929_3492# VGND.t19 VGND.t1280 sg13_lv_nmos ad=0.2516p pd=2.16u as=0.1543p ps=1.18u w=0.74u l=0.13u
X1100 VPWR.t686 sg13cmos5l_mux4_1_14.A1 sg13cmos5l_inv_1_779.A VPWR.t39 sg13_lv_pmos ad=0.3808p pd=2.92u as=0.3808p ps=2.92u w=1.12u l=0.13u
X1101 sg13cmos5l_inv_1_874.A sg13cmos5l_inv_1_861.A VPWR.t1225 VPWR.t42 sg13_lv_pmos ad=0.3808p pd=2.92u as=0.3808p ps=2.92u w=1.12u l=0.13u
X1102 a_14422_12606# a_14989_12490# a_14913_12564# VPWR.t2 sg13_lv_pmos ad=0.34p pd=2.68u as=0.2225p ps=1.445u w=1u l=0.13u
X1103 VPWR.t148 VGND.t41 VPWR.t147 VPWR.t5 sg13_lv_pmos ad=0.34p pd=2.68u as=0 ps=0 w=1u l=1u
X1104 VGND.t54 sg13cmos5l_buf_1_8.A a_2248_3932# VGND.t988 sg13_lv_nmos ad=0.14875p pd=1.16u as=0.187p ps=1.78u w=0.55u l=0.13u
X1105 VPWR.t827 sg13cmos5l_nand2_1_1.B a_9443_9192# VPWR.t29 sg13_lv_pmos ad=0.3808p pd=2.92u as=0.2464p ps=1.56u w=1.12u l=0.13u
X1106 VPWR.t1038 sg13cmos5l_inv_1_664.A sg13cmos5l_inv_1_665.A VPWR.t26 sg13_lv_pmos ad=0.3808p pd=2.92u as=0.3808p ps=2.92u w=1.12u l=0.13u
X1107 VGND.t347 sg13cmos5l_inv_1_731.A sg13cmos5l_inv_1_731.Y VGND.t912 sg13_lv_nmos ad=0.2516p pd=2.16u as=0.2516p ps=2.16u w=0.74u l=0.13u
X1108 VPWR.t656 sg13cmos5l_inv_1_433.A sg13cmos5l_inv_1_433.Y VPWR.t0 sg13_lv_pmos ad=0.3808p pd=2.92u as=0.3808p ps=2.92u w=1.12u l=0.13u
X1109 a_14110_3534# a_15181_3418# a_15105_3492# VGND.t408 sg13_lv_nmos ad=0.2176p pd=1.96u as=0.1216p ps=1.02u w=0.64u l=0.13u
X1110 a_3934_12606# a_5005_12490# a_4929_12564# VGND.t1118 sg13_lv_nmos ad=0.2176p pd=1.96u as=0.1216p ps=1.02u w=0.64u l=0.13u
X1111 a_3847_12267# sg13cmos5l_mux4_1_9.A0 VPWR.t965 VPWR.t2 sg13_lv_pmos ad=0.415p pd=1.83u as=0.22315p ps=1.555u w=1u l=0.13u
X1112 a_3934_15994# a_5005_16000# a_4929_16036# VGND.t588 sg13_lv_nmos ad=0.2176p pd=1.96u as=0.1216p ps=1.02u w=0.64u l=0.13u
X1113 sg13cmos5l_mux4_1_11.A3 a_15201_15588# VGND.t66 VGND.t1383 sg13_lv_nmos ad=0.2516p pd=2.16u as=0.1543p ps=1.18u w=0.74u l=0.13u
X1114 VGND.t987 sg13cmos5l_inv_1_682.A sg13cmos5l_inv_1_681.A VGND.t986 sg13_lv_nmos ad=0.2516p pd=2.16u as=0.2516p ps=2.16u w=0.74u l=0.13u
X1115 sg13cmos5l_inv_1_195.Y sg13cmos5l_inv_1_205.Y VPWR.t850 VPWR.t0 sg13_lv_pmos ad=0.3808p pd=2.92u as=0.3808p ps=2.92u w=1.12u l=0.13u
X1116 VPWR.t781 sg13cmos5l_inv_1_218.A sg13cmos5l_inv_1_110.A VPWR.t0 sg13_lv_pmos ad=0.3808p pd=2.92u as=0.3808p ps=2.92u w=1.12u l=0.13u
X1117 sg13cmos5l_mux4_1_11.A1 a_14913_14524# VGND.t92 VGND.t1125 sg13_lv_nmos ad=0.2516p pd=2.16u as=0.1543p ps=1.18u w=0.74u l=0.13u
X1118 sg13cmos5l_inv_1_997.A sg13cmos5l_inv_1_944.Y VGND.t5 VGND.t190 sg13_lv_nmos ad=0.2516p pd=2.16u as=0.2516p ps=2.16u w=0.74u l=0.13u
X1119 VGND.t194 sg13cmos5l_inv_1_770.A sg13cmos5l_inv_1_772.A VGND.t193 sg13_lv_nmos ad=0.2516p pd=2.16u as=0.2516p ps=2.16u w=0.74u l=0.13u
X1120 sg13cmos5l_inv_1_481.Y sg13cmos5l_inv_1_486.Y VGND.t102 VGND.t1121 sg13_lv_nmos ad=0.2516p pd=2.16u as=0.2516p ps=2.16u w=0.74u l=0.13u
X1121 sg13cmos5l_inv_1_990.A sg13cmos5l_inv_1_997.A VPWR.t1047 VPWR.t5 sg13_lv_pmos ad=0.3808p pd=2.92u as=0.3808p ps=2.92u w=1.12u l=0.13u
X1122 VGND.t225 VPWR.t1527 VGND.t225 VGND.t11 sg13_lv_nmos ad=0.1428p pd=1.52u as=0 ps=0 w=0.42u l=1u
X1123 VGND.t29 sg13cmos5l_inv_1_566.A sg13cmos5l_inv_1_533.A VGND.t22 sg13_lv_nmos ad=0.2516p pd=2.16u as=0.2516p ps=2.16u w=0.74u l=0.13u
X1124 sg13cmos5l_inv_1_459.Y sg13cmos5l_inv_1_459.A VPWR.t710 VPWR.t0 sg13_lv_pmos ad=0.3808p pd=2.92u as=0.3808p ps=2.92u w=1.12u l=0.13u
X1125 sg13cmos5l_inv_1_813.Y sg13cmos5l_inv_1_876.Y VGND.t35 VGND.t795 sg13_lv_nmos ad=0.2516p pd=2.16u as=0.2516p ps=2.16u w=0.74u l=0.13u
X1126 VPWR.t1035 sg13cmos5l_inv_1_936.A sg13cmos5l_inv_1_937.A VPWR.t5 sg13_lv_pmos ad=0.3808p pd=2.92u as=0.3808p ps=2.92u w=1.12u l=0.13u
X1127 VPWR.t1284 sg13cmos5l_inv_1_74.A sg13cmos5l_inv_1_70.A VPWR.t11 sg13_lv_pmos ad=0.3808p pd=2.92u as=0.3808p ps=2.92u w=1.12u l=0.13u
X1128 VPWR.t287 sg13cmos5l_inv_1_322.A sg13cmos5l_inv_1_323.A VPWR.t8 sg13_lv_pmos ad=0.3808p pd=2.92u as=0.3808p ps=2.92u w=1.12u l=0.13u
X1129 VPWR.t1144 sg13cmos5l_inv_1_483.Y sg13cmos5l_inv_1_486.Y VPWR.t2 sg13_lv_pmos ad=0.3808p pd=2.92u as=0.3808p ps=2.92u w=1.12u l=0.13u
X1130 VGND.t6 sg13cmos5l_inv_1_941.A sg13cmos5l_inv_1_959.A VGND.t190 sg13_lv_nmos ad=0.2516p pd=2.16u as=0.2516p ps=2.16u w=0.74u l=0.13u
X1131 VGND.t54 VPWR.t1523 VGND.t54 VGND.t1616 sg13_lv_nmos ad=0.1428p pd=1.52u as=0 ps=0 w=0.42u l=1u
X1132 a_6934_8434# a_6119_8434# a_6858_8434# VGND.t380 sg13_lv_nmos ad=0.1776p pd=1.195u as=80f ps=0.89u w=0.64u l=0.13u
X1133 sg13cmos5l_inv_1_700.Y sg13cmos5l_mux4_1_15.A3 VGND.t184 VGND.t1032 sg13_lv_nmos ad=0.2516p pd=2.16u as=0.2516p ps=2.16u w=0.74u l=0.13u
X1134 sg13cmos5l_mux4_1_5.X a_4929_3492# VPWR.t742 VPWR.t8 sg13_lv_pmos ad=0.3808p pd=2.92u as=0.34367p ps=1.775u w=1.12u l=0.13u
X1135 sg13cmos5l_inv_1_128.Y sg13cmos5l_inv_1_111.Y VGND.t754 VGND.t1407 sg13_lv_nmos ad=0.2516p pd=2.16u as=0.2516p ps=2.16u w=0.74u l=0.13u
X1136 sg13cmos5l_inv_1_596.Y sg13cmos5l_inv_1_585.Y VPWR.t671 VPWR.t39 sg13_lv_pmos ad=0.3808p pd=2.92u as=0.3808p ps=2.92u w=1.12u l=0.13u
X1137 a_4357_16261# sg13cmos5l_mux4_1_10.A2 VPWR.t1211 VPWR.t42 sg13_lv_pmos ad=0.20762p pd=1.605u as=0.29275p ps=1.785u w=1u l=0.13u
X1138 sg13cmos5l_inv_1_734.Y sg13cmos5l_inv_1_734.A VGND.t444 VGND.t935 sg13_lv_nmos ad=0.2516p pd=2.16u as=0.2516p ps=2.16u w=0.74u l=0.13u
X1139 VPWR.t962 sg13cmos5l_inv_1_940.A sg13cmos5l_inv_1_998.A VPWR.t5 sg13_lv_pmos ad=0.3808p pd=2.92u as=0.3808p ps=2.92u w=1.12u l=0.13u
X1140 sg13cmos5l_inv_1_84.Y sg13cmos5l_inv_1_84.A VPWR.t443 VPWR.t8 sg13_lv_pmos ad=0.3808p pd=2.92u as=0.3808p ps=2.92u w=1.12u l=0.13u
X1141 sg13cmos5l_inv_1_292.Y sg13cmos5l_inv_1_259.Y VPWR.t411 VPWR.t11 sg13_lv_pmos ad=0.3808p pd=2.92u as=0.3808p ps=2.92u w=1.12u l=0.13u
X1142 VPWR.t764 sg13cmos5l_inv_1_239.A sg13cmos5l_inv_1_240.A VPWR.t11 sg13_lv_pmos ad=0.3808p pd=2.92u as=0.3808p ps=2.92u w=1.12u l=0.13u
X1143 VPWR.t170 VGND.t478 VPWR.t168 VPWR.t26 sg13_lv_pmos ad=0.19p pd=1.38u as=0 ps=0 w=1u l=1u
X1144 sg13cmos5l_inv_1_192.Y sg13cmos5l_inv_1_191.Y VPWR.t917 VPWR.t0 sg13_lv_pmos ad=0.3808p pd=2.92u as=0.3808p ps=2.92u w=1.12u l=0.13u
X1145 sg13cmos5l_buf_1_12.X a_808_6956# VPWR.t978 VPWR.t14 sg13_lv_pmos ad=0.42p pd=2.99u as=0.2114p ps=1.54u w=1.12u l=0.13u
X1146 sg13cmos5l_inv_1_4.Y sg13cmos5l_inv_1_8.Y VPWR.t1496 VPWR.t11 sg13_lv_pmos ad=0.3808p pd=2.92u as=0.3808p ps=2.92u w=1.12u l=0.13u
X1147 VGND.t155 VPWR.t1578 VGND.t155 VGND.t1544 sg13_lv_nmos ad=0.1428p pd=1.52u as=0 ps=0 w=0.42u l=1u
X1148 a_9982_8050# sg13cmos5l_mux4_1_16.X a_9885_8050# VGND.t196 sg13_lv_nmos ad=0.1628p pd=1.18u as=0.13135p ps=1.095u w=0.74u l=0.13u
X1149 sg13cmos5l_a21oi_1_0.A1 sg13cmos5l_nor3_1_1.B VGND.t188 VGND.t1004 sg13_lv_nmos ad=0.1406p pd=1.12u as=0.2516p ps=2.16u w=0.74u l=0.13u
X1150 VPWR.t923 sg13cmos5l_mux4_1_5.S0.t3 a_8327_6558# VPWR.t0 sg13_lv_pmos ad=0.22315p pd=1.555u as=0.34p ps=2.68u w=1u l=0.13u
X1151 sg13cmos5l_inv_1_401.Y sg13cmos5l_inv_1_386.Y VGND.t107 VGND.t224 sg13_lv_nmos ad=0.2516p pd=2.16u as=0.2516p ps=2.16u w=0.74u l=0.13u
X1152 VGND.t5 sg13cmos5l_inv_1_991.A sg13cmos5l_mux4_1_6.A2 VGND.t4 sg13_lv_nmos ad=0.2516p pd=2.16u as=0.2516p ps=2.16u w=0.74u l=0.13u
X1153 VPWR.t632 sg13cmos5l_inv_1_531.A sg13cmos5l_inv_1_527.A VPWR.t2 sg13_lv_pmos ad=0.3808p pd=2.92u as=0.3808p ps=2.92u w=1.12u l=0.13u
X1154 sg13cmos5l_inv_1_237.A sg13cmos5l_inv_1_69.A VGND.t536 VGND.t535 sg13_lv_nmos ad=0.2516p pd=2.16u as=0.2516p ps=2.16u w=0.74u l=0.13u
X1155 VPWR.t730 VGND.t1225 VPWR.t729 VPWR.t21 sg13_lv_pmos ad=0.19p pd=1.38u as=0 ps=0 w=1u l=1u
X1156 a_14110_3534# sg13cmos5l_mux4_1_5.S1.t1 a_14023_3195# VPWR.t8 sg13_lv_pmos ad=0.19p pd=1.38u as=0.415p ps=1.83u w=1u l=0.13u
X1157 sg13cmos5l_inv_1_321.A sg13cmos5l_inv_1_334.A VPWR.t496 VPWR.t8 sg13_lv_pmos ad=0.3808p pd=2.92u as=0.3808p ps=2.92u w=1.12u l=0.13u
X1158 VGND.t529 sg13cmos5l_mux4_1_9.A0 sg13cmos5l_inv_1_666.Y VGND.t783 sg13_lv_nmos ad=0.2516p pd=2.16u as=0.2516p ps=2.16u w=0.74u l=0.13u
X1159 sg13cmos5l_mux4_1_5.S1.t0 a_4072_3932# VPWR.t446 VPWR.t49 sg13_lv_pmos ad=0.42p pd=2.99u as=0.2114p ps=1.54u w=1.12u l=0.13u
X1160 sg13cmos5l_inv_1_550.Y sg13cmos5l_inv_1_551.Y VPWR.t751 VPWR.t39 sg13_lv_pmos ad=0.3808p pd=2.92u as=0.3808p ps=2.92u w=1.12u l=0.13u
X1161 VGND.t233 VPWR.t1526 VGND.t212 VGND.t11 sg13_lv_nmos ad=0.1428p pd=1.52u as=0 ps=0 w=0.42u l=1u
X1162 sg13cmos5l_buf_1_7.X a_808_1632# VPWR.t662 VPWR.t11 sg13_lv_pmos ad=0.42p pd=2.99u as=0.2114p ps=1.54u w=1.12u l=0.13u
X1163 a_16075_7649# sg13cmos5l_buf_1_8.A.t2 VPWR.t331 VPWR.t14 sg13_lv_pmos ad=0.34p pd=2.68u as=0.22315p ps=1.555u w=1u l=0.13u
X1164 VPWR.t323 sg13cmos5l_inv_1_824.A sg13cmos5l_inv_1_825.A VPWR.t39 sg13_lv_pmos ad=0.3808p pd=2.92u as=0.3808p ps=2.92u w=1.12u l=0.13u
X1165 sg13cmos5l_inv_1_171.A sg13cmos5l_inv_1_161.Y VPWR.t1185 VPWR.t29 sg13_lv_pmos ad=0.3808p pd=2.92u as=0.3808p ps=2.92u w=1.12u l=0.13u
X1166 sg13cmos5l_inv_1_972.Y sg13cmos5l_inv_1_971.Y VGND.t143 VGND.t4 sg13_lv_nmos ad=0.2516p pd=2.16u as=0.2516p ps=2.16u w=0.74u l=0.13u
X1167 VPWR.t630 sg13cmos5l_mux4_1_7.A3 sg13cmos5l_inv_1_637.A VPWR.t21 sg13_lv_pmos ad=0.3808p pd=2.92u as=0.3808p ps=2.92u w=1.12u l=0.13u
X1168 a_14171_11488# sg13cmos5l_buf_1_8.A.t3 VGND.t444 VGND.t1433 sg13_lv_nmos ad=0.2304p pd=2u as=0.1543p ps=1.18u w=0.64u l=0.13u
X1169 sg13cmos5l_buf_1_17.X a_18664_13004# VPWR.t397 VPWR.t26 sg13_lv_pmos ad=0.42p pd=2.99u as=0.2114p ps=1.54u w=1.12u l=0.13u
X1170 sg13cmos5l_buf_1_10.A a_808_4656# VGND.t699 VGND.t11 sg13_lv_nmos ad=0.2886p pd=2.26u as=0.14875p ps=1.16u w=0.74u l=0.13u
X1171 a_8638_6558# a_9709_6442# a_9633_6516# VGND.t271 sg13_lv_nmos ad=0.2176p pd=1.96u as=0.1216p ps=1.02u w=0.64u l=0.13u
X1172 sg13cmos5l_inv_1_796.Y sg13cmos5l_mux4_1_14.A0 VGND.t171 VGND.t802 sg13_lv_nmos ad=0.2516p pd=2.16u as=0.2516p ps=2.16u w=0.74u l=0.13u
X1173 sg13cmos5l_inv_1_98.Y sg13cmos5l_inv_1_101.Y VGND.t396 VGND.t1151 sg13_lv_nmos ad=0.2516p pd=2.16u as=0.2516p ps=2.16u w=0.74u l=0.13u
X1174 a_15608_7680# a_16075_7649# a_16021_7685# VPWR.t14 sg13_lv_pmos ad=0.4425p pd=1.885u as=0.135p ps=1.27u w=1u l=0.13u
X1175 VPWR.t1342 sg13cmos5l_inv_1_627.A sg13cmos5l_mux4_1_8.A1 VPWR.t42 sg13_lv_pmos ad=0.3808p pd=2.92u as=0.3808p ps=2.92u w=1.12u l=0.13u
X1176 sg13cmos5l_inv_1_417.Y sg13cmos5l_inv_1_452.Y VGND.t440 VGND.t11 sg13_lv_nmos ad=0.2516p pd=2.16u as=0.2516p ps=2.16u w=0.74u l=0.13u
X1177 VGND.t1194 sg13cmos5l_inv_1_830.A sg13cmos5l_inv_1_820.A VGND.t1461 sg13_lv_nmos ad=0.2516p pd=2.16u as=0.2516p ps=2.16u w=0.74u l=0.13u
X1178 VGND.t23 sg13cmos5l_inv_1_779.A sg13cmos5l_inv_1_779.Y VGND.t22 sg13_lv_nmos ad=0.2516p pd=2.16u as=0.2516p ps=2.16u w=0.74u l=0.13u
X1179 sg13cmos5l_inv_1_189.Y sg13cmos5l_inv_1_194.Y VGND.t113 VGND.t11 sg13_lv_nmos ad=0.2516p pd=2.16u as=0.2516p ps=2.16u w=0.74u l=0.13u
X1180 VGND.t90 VPWR.t1597 VGND.t90 VGND.t1517 sg13_lv_nmos ad=0.1428p pd=1.52u as=0 ps=0 w=0.42u l=1u
X1181 sg13cmos5l_inv_1_799.A sg13cmos5l_inv_1_995.Y VPWR.t1248 VPWR.t42 sg13_lv_pmos ad=0.3808p pd=2.92u as=0.3808p ps=2.92u w=1.12u l=0.13u
X1182 VGND.t28 sg13cmos5l_inv_1_36.Y sg13cmos5l_inv_1_44.A VGND.t1410 sg13_lv_nmos ad=0.2516p pd=2.16u as=0.2516p ps=2.16u w=0.74u l=0.13u
X1183 sg13cmos5l_inv_1_105.A sg13cmos5l_inv_1_215.Y VPWR.t537 VPWR.t14 sg13_lv_pmos ad=0.3808p pd=2.92u as=0.3808p ps=2.92u w=1.12u l=0.13u
X1184 VGND.t567 sg13cmos5l_inv_1_809.Y sg13cmos5l_inv_1_806.Y VGND.t22 sg13_lv_nmos ad=0.2516p pd=2.16u as=0.2516p ps=2.16u w=0.74u l=0.13u
X1185 sg13cmos5l_inv_1_780.A sg13cmos5l_inv_1_779.Y VPWR.t688 VPWR.t39 sg13_lv_pmos ad=0.3808p pd=2.92u as=0.3808p ps=2.92u w=1.12u l=0.13u
X1186 VPWR.t160 VGND.t29 VPWR.t159 VPWR.t39 sg13_lv_pmos ad=0.34p pd=2.68u as=0 ps=0 w=1u l=1u
X1187 VGND.t285 sg13cmos5l_inv_1_818.A sg13cmos5l_inv_1_818.Y VGND.t1341 sg13_lv_nmos ad=0.2516p pd=2.16u as=0.2516p ps=2.16u w=0.74u l=0.13u
X1188 a_14998_9582# sg13cmos5l_mux4_1_5.S1.t8 a_14917_9243# VPWR.t29 sg13_lv_pmos ad=0.4425p pd=1.885u as=0.20762p ps=1.605u w=1u l=0.13u
X1189 VPWR.t886 a_4475_13008# a_4975_13264# VPWR.t26 sg13_lv_pmos ad=0.2198p pd=1.52u as=0.2975p ps=1.595u w=1u l=0.13u
X1190 VPWR.t518 sg13cmos5l_inv_1_491.A sg13cmos5l_inv_1_485.A VPWR.t2 sg13_lv_pmos ad=0.3808p pd=2.92u as=0.3808p ps=2.92u w=1.12u l=0.13u
X1191 VGND.t1156 sg13cmos5l_inv_1_421.A sg13cmos5l_inv_1_421.Y VGND.t11 sg13_lv_nmos ad=0.2516p pd=2.16u as=0.2516p ps=2.16u w=0.74u l=0.13u
X1192 VGND.t5 VPWR.t1560 VGND.t5 VGND.t4 sg13_lv_nmos ad=0.1428p pd=1.52u as=0 ps=0 w=0.42u l=1u
X1193 a_8005_16261# sg13cmos5l_mux4_1_8.A2 VPWR.t281 VPWR.t42 sg13_lv_pmos ad=0.20762p pd=1.605u as=0.29275p ps=1.785u w=1u l=0.13u
X1194 VPWR.t224 VGND.t78 VPWR.t223 VPWR.t8 sg13_lv_pmos ad=0.34p pd=2.68u as=0 ps=0 w=1u l=1u
X1195 VGND.t28 sg13cmos5l_inv_1_37.Y sg13cmos5l_inv_1_28.A VGND.t830 sg13_lv_nmos ad=0.2516p pd=2.16u as=0.2516p ps=2.16u w=0.74u l=0.13u
X1196 VPWR.t969 sg13cmos5l_inv_1_731.A sg13cmos5l_inv_1_731.Y VPWR.t5 sg13_lv_pmos ad=0.3808p pd=2.92u as=0.3808p ps=2.92u w=1.12u l=0.13u
X1197 sg13cmos5l_inv_1_813.Y sg13cmos5l_inv_1_876.Y VPWR.t856 VPWR.t21 sg13_lv_pmos ad=0.3808p pd=2.92u as=0.3808p ps=2.92u w=1.12u l=0.13u
X1198 VPWR.t738 sg13cmos5l_inv_1_247.A sg13cmos5l_inv_1_247.Y VPWR.t11 sg13_lv_pmos ad=0.3808p pd=2.92u as=0.3808p ps=2.92u w=1.12u l=0.13u
X1199 a_9820_3514# sg13cmos5l_mux4_1_3.X a_9326_3410# VGND.t608 sg13_lv_nmos ad=0.13135p pd=1.095u as=0.1628p ps=1.18u w=0.74u l=0.13u
X1200 VGND.t214 sg13cmos5l_inv_1_186.A sg13cmos5l_inv_1_186.Y VGND.t11 sg13_lv_nmos ad=0.2516p pd=2.16u as=0.2516p ps=2.16u w=0.74u l=0.13u
X1201 a_13918_12606# a_14989_12490# a_14913_12564# VGND.t1012 sg13_lv_nmos ad=0.2176p pd=1.96u as=0.1216p ps=1.02u w=0.64u l=0.13u
X1202 VPWR.t1141 sg13cmos5l_inv_1_722.Y sg13cmos5l_inv_1_730.A VPWR.t2 sg13_lv_pmos ad=0.3808p pd=2.92u as=0.3808p ps=2.92u w=1.12u l=0.13u
X1203 VGND.t8 sg13cmos5l_inv_1_202.Y a_14612_9582# VGND.t993 sg13_lv_nmos ad=0.1824p pd=1.21u as=0.2304p ps=1.36u w=0.64u l=0.13u
X1204 sg13cmos5l_inv_1_292.Y sg13cmos5l_inv_1_259.Y VGND.t617 VGND.t781 sg13_lv_nmos ad=0.2516p pd=2.16u as=0.2516p ps=2.16u w=0.74u l=0.13u
X1205 sg13cmos5l_inv_1_155.Y sg13cmos5l_mux4_1_0.A0 VPWR.t332 VPWR.t29 sg13_lv_pmos ad=0.3808p pd=2.92u as=0.3808p ps=2.92u w=1.12u l=0.13u
X1206 VPWR.t111 VGND.t269 VPWR.t110 VPWR.t2 sg13_lv_pmos ad=0.34p pd=2.68u as=0 ps=0 w=1u l=1u
X1207 sg13cmos5l_inv_1_30.Y sg13cmos5l_inv_1_30.A VGND.t28 VGND.t1422 sg13_lv_nmos ad=0.2516p pd=2.16u as=0.2516p ps=2.16u w=0.74u l=0.13u
X1208 VGND.t343 sg13cmos5l_inv_1_440.A sg13cmos5l_inv_1_430.A VGND.t11 sg13_lv_nmos ad=0.2516p pd=2.16u as=0.2516p ps=2.16u w=0.74u l=0.13u
X1209 VGND.t41 sg13cmos5l_inv_1_737.A sg13cmos5l_inv_1_1002.A VGND.t1031 sg13_lv_nmos ad=0.2516p pd=2.16u as=0.2516p ps=2.16u w=0.74u l=0.13u
X1210 VPWR.t891 sg13cmos5l_inv_1_991.A sg13cmos5l_mux4_1_6.A2 VPWR.t29 sg13_lv_pmos ad=0.3808p pd=2.92u as=0.3808p ps=2.92u w=1.12u l=0.13u
X1211 a_1594_15610# sg13cmos5l_nor2b_1_0.B_N VGND.t94 VGND.t804 sg13_lv_nmos ad=0.1406p pd=1.12u as=0.2516p ps=2.16u w=0.74u l=0.13u
X1212 VPWR.t1162 sg13cmos5l_inv_1_95.A sg13cmos5l_inv_1_67.A VPWR.t11 sg13_lv_pmos ad=0.3808p pd=2.92u as=0.3808p ps=2.92u w=1.12u l=0.13u
X1213 a_4661_7685# a_3623_8070# a_4438_8070# VPWR.t14 sg13_lv_pmos ad=0.135p pd=1.27u as=0.4425p ps=1.885u w=1u l=0.13u
X1214 VPWR.t212 VGND.t162 VPWR.t211 VPWR.t14 sg13_lv_pmos ad=0.34p pd=2.68u as=0 ps=0 w=1u l=1u
X1215 VPWR.t1175 sg13cmos5l_inv_1_351.Y sg13cmos5l_inv_1_370.A VPWR.t29 sg13_lv_pmos ad=0.3808p pd=2.92u as=0.3808p ps=2.92u w=1.12u l=0.13u
X1216 sg13cmos5l_inv_1_700.Y sg13cmos5l_mux4_1_15.A3 VPWR.t1075 VPWR.t5 sg13_lv_pmos ad=0.3808p pd=2.92u as=0.3808p ps=2.92u w=1.12u l=0.13u
X1217 VGND.t552 sg13cmos5l_buf_1_17.X a_18856_14516# VGND.t1000 sg13_lv_nmos ad=0.14875p pd=1.16u as=0.187p ps=1.78u w=0.55u l=0.13u
X1218 sg13cmos5l_inv_1_688.A sg13cmos5l_inv_1_556.Y VPWR.t667 VPWR.t39 sg13_lv_pmos ad=0.3808p pd=2.92u as=0.3808p ps=2.92u w=1.12u l=0.13u
X1219 sg13cmos5l_inv_1_804.A sg13cmos5l_inv_1_775.Y VPWR.t1217 VPWR.t39 sg13_lv_pmos ad=0.3808p pd=2.92u as=0.3808p ps=2.92u w=1.12u l=0.13u
X1220 a_15292_11458# sg13cmos5l_mux4_1_11.A1 VGND.t184 VGND.t183 sg13_lv_nmos ad=0.2304p pd=1.36u as=0.1824p ps=1.21u w=0.64u l=0.13u
X1221 VGND.t143 sg13cmos5l_inv_1_921.Y sg13cmos5l_inv_1_926.A VGND.t190 sg13_lv_nmos ad=0.2516p pd=2.16u as=0.2516p ps=2.16u w=0.74u l=0.13u
X1222 a_8417_11480# sg13cmos5l_a21oi_1_0.A1 sg13cmos5l_a21oi_1_0.Y VGND.t1171 sg13_lv_nmos ad=0.1406p pd=1.12u as=0.1406p ps=1.12u w=0.74u l=0.13u
X1223 sg13cmos5l_inv_1_734.Y sg13cmos5l_inv_1_734.A VPWR.t991 VPWR.t5 sg13_lv_pmos ad=0.3808p pd=2.92u as=0.3808p ps=2.92u w=1.12u l=0.13u
X1224 sg13cmos5l_inv_1_209.Y sg13cmos5l_inv_1_212.Y VPWR.t403 VPWR.t0 sg13_lv_pmos ad=0.3808p pd=2.92u as=0.3808p ps=2.92u w=1.12u l=0.13u
X1225 sg13cmos5l_inv_1_284.A sg13cmos5l_inv_1_410.Y VGND.t19 VGND.t1275 sg13_lv_nmos ad=0.2516p pd=2.16u as=0.2516p ps=2.16u w=0.74u l=0.13u
X1226 VPWR.t606 sg13cmos5l_inv_1_640.A sg13cmos5l_inv_1_639.A VPWR.t21 sg13_lv_pmos ad=0.3808p pd=2.92u as=0.3808p ps=2.92u w=1.12u l=0.13u
X1227 sg13cmos5l_inv_1_1003.Y sg13cmos5l_inv_1_480.Y VGND.t174 VGND.t1172 sg13_lv_nmos ad=0.2516p pd=2.16u as=0.2516p ps=2.16u w=0.74u l=0.13u
X1228 sg13cmos5l_nor3_1_2.B.t0 a_808_13004# VPWR.t351 VPWR.t26 sg13_lv_pmos ad=0.42p pd=2.99u as=0.2114p ps=1.54u w=1.12u l=0.13u
X1229 VGND.t420 VPWR.t1528 VGND.t1611 VGND.t11 sg13_lv_nmos ad=0.1428p pd=1.52u as=0 ps=0 w=0.42u l=1u
X1230 sg13cmos5l_inv_1_972.Y sg13cmos5l_inv_1_971.Y VPWR.t1051 VPWR.t29 sg13_lv_pmos ad=0.3808p pd=2.92u as=0.3808p ps=2.92u w=1.12u l=0.13u
X1231 VGND.t78 sg13cmos5l_mux4_1_5.S1.t4 a_13607_3898# VGND.t77 sg13_lv_nmos ad=0.1872p pd=1.225u as=0.2176p ps=1.96u w=0.64u l=0.13u
X1232 sg13cmos5l_mux4_1_1.X a_15105_3492# VPWR.t568 VPWR.t8 sg13_lv_pmos ad=0.3808p pd=2.92u as=0.34367p ps=1.775u w=1.12u l=0.13u
X1233 VGND.t56 sg13cmos5l_inv_1_627.A sg13cmos5l_mux4_1_8.A1 VGND.t22 sg13_lv_nmos ad=0.2516p pd=2.16u as=0.2516p ps=2.16u w=0.74u l=0.13u
X1234 VPWR.t383 a_9260_9906# sg13cmos5l_nor3_1_1.A VPWR.t5 sg13_lv_pmos ad=0.2114p pd=1.54u as=0.42p ps=2.99u w=1.12u l=0.13u
X1235 sg13cmos5l_inv_1_541.Y sg13cmos5l_inv_1_541.A VGND.t29 VGND.t22 sg13_lv_nmos ad=0.2516p pd=2.16u as=0.2516p ps=2.16u w=0.74u l=0.13u
X1236 sg13cmos5l_o21ai_1_0.Y sg13cmos5l_o21ai_1_0.B1 VPWR.t1332 VPWR.t29 sg13_lv_pmos ad=0.2128p pd=1.5u as=0.3808p ps=2.92u w=1.12u l=0.15u
X1237 VGND.t335 sg13cmos5l_inv_1_142.A sg13cmos5l_inv_1_141.A VGND.t1315 sg13_lv_nmos ad=0.2516p pd=2.16u as=0.2516p ps=2.16u w=0.74u l=0.13u
X1238 VPWR.t966 sg13cmos5l_mux4_1_9.A0 sg13cmos5l_inv_1_666.Y VPWR.t26 sg13_lv_pmos ad=0.3808p pd=2.92u as=0.3808p ps=2.92u w=1.12u l=0.13u
X1239 VGND.t92 sg13cmos5l_inv_1_909.A sg13cmos5l_inv_1_745.A VGND.t1243 sg13_lv_nmos ad=0.2516p pd=2.16u as=0.2516p ps=2.16u w=0.74u l=0.13u
X1240 VPWR.t282 sg13cmos5l_inv_1_628.Y sg13cmos5l_inv_1_630.A VPWR.t42 sg13_lv_pmos ad=0.3808p pd=2.92u as=0.3808p ps=2.92u w=1.12u l=0.13u
X1241 sg13cmos5l_inv_1_228.A sg13cmos5l_inv_1_83.Y VGND.t233 VGND.t11 sg13_lv_nmos ad=0.2516p pd=2.16u as=0.2516p ps=2.16u w=0.74u l=0.13u
X1242 VGND.t117 sg13cmos5l_inv_1_416.Y sg13cmos5l_inv_1_427.A VGND.t11 sg13_lv_nmos ad=0.2516p pd=2.16u as=0.2516p ps=2.16u w=0.74u l=0.13u
X1243 a_4438_15994# a_3623_15994# a_4362_15994# VGND.t1324 sg13_lv_nmos ad=0.1776p pd=1.195u as=80f ps=0.89u w=0.64u l=0.13u
X1244 VGND.t529 sg13cmos5l_inv_1_510.Y sg13cmos5l_inv_1_685.Y VGND.t783 sg13_lv_nmos ad=0.2516p pd=2.16u as=0.2516p ps=2.16u w=0.74u l=0.13u
X1245 VPWR.t833 sg13cmos5l_inv_1_745.A sg13cmos5l_mux4_1_12.A3 VPWR.t26 sg13_lv_pmos ad=0.3808p pd=2.92u as=0.3808p ps=2.92u w=1.12u l=0.13u
X1246 VGND.t184 sg13cmos5l_mux4_1_15.X a_15580_11458# VGND.t1247 sg13_lv_nmos ad=0.1872p pd=1.225u as=76.8f ps=0.88u w=0.64u l=0.13u
X1247 osc_tap[0] a_18856_3932# VGND.t428 VGND.t427 sg13_lv_nmos ad=0.2886p pd=2.26u as=0.14875p ps=1.16u w=0.74u l=0.13u
X1248 VPWR.t1064 sg13cmos5l_inv_1_987.A sg13cmos5l_inv_1_493.A VPWR.t2 sg13_lv_pmos ad=0.3808p pd=2.92u as=0.3808p ps=2.92u w=1.12u l=0.13u
X1249 VPWR.t1346 sg13cmos5l_inv_1_818.A sg13cmos5l_inv_1_818.Y VPWR.t21 sg13_lv_pmos ad=0.3808p pd=2.92u as=0.3808p ps=2.92u w=1.12u l=0.13u
X1250 sg13cmos5l_inv_1_998.Y sg13cmos5l_inv_1_998.A VGND.t6 VGND.t190 sg13_lv_nmos ad=0.2516p pd=2.16u as=0.2516p ps=2.16u w=0.74u l=0.13u
X1251 a_8315_11752# sg13cmos5l_a21oi_1_0.A2 VPWR.t373 VPWR.t2 sg13_lv_pmos ad=0.3808p pd=2.92u as=0.2128p ps=1.5u w=1.12u l=0.13u
X1252 VPWR.t69 VGND.t73 VPWR.t67 VPWR.t49 sg13_lv_pmos ad=0.19p pd=1.38u as=0 ps=0 w=1u l=1u
X1253 sg13cmos5l_inv_1_329.A sg13cmos5l_inv_1_336.A VPWR.t1301 VPWR.t8 sg13_lv_pmos ad=0.3808p pd=2.92u as=0.3808p ps=2.92u w=1.12u l=0.13u
X1254 VPWR.t1235 sg13cmos5l_inv_1_606.A sg13cmos5l_inv_1_606.Y VPWR.t39 sg13_lv_pmos ad=0.3808p pd=2.92u as=0.3808p ps=2.92u w=1.12u l=0.13u
X1255 sg13cmos5l_inv_1_619.A sg13cmos5l_inv_1_622.Y VGND.t207 VGND.t206 sg13_lv_nmos ad=0.2516p pd=2.16u as=0.2516p ps=2.16u w=0.74u l=0.13u
X1256 VGND.t39 sg13cmos5l_inv_1_696.A sg13cmos5l_inv_1_698.A VGND.t790 sg13_lv_nmos ad=0.2516p pd=2.16u as=0.2516p ps=2.16u w=0.74u l=0.13u
X1257 sg13cmos5l_inv_1_459.A sg13cmos5l_inv_1_433.Y VGND.t440 VGND.t11 sg13_lv_nmos ad=0.2516p pd=2.16u as=0.2516p ps=2.16u w=0.74u l=0.13u
X1258 VGND.t111 sg13cmos5l_inv_1_247.A sg13cmos5l_inv_1_247.Y VGND.t1419 sg13_lv_nmos ad=0.2516p pd=2.16u as=0.2516p ps=2.16u w=0.74u l=0.13u
X1259 VGND.t54 sg13cmos5l_inv_1_337.Y sg13cmos5l_inv_1_316.A VGND.t618 sg13_lv_nmos ad=0.2516p pd=2.16u as=0.2516p ps=2.16u w=0.74u l=0.13u
X1260 VPWR.t266 sg13cmos5l_inv_1_819.A sg13cmos5l_inv_1_819.Y VPWR.t39 sg13_lv_pmos ad=0.3808p pd=2.92u as=0.3808p ps=2.92u w=1.12u l=0.13u
X1261 VPWR.t1299 sg13cmos5l_mux4_1_2.A2 sg13cmos5l_inv_1_25.Y VPWR.t49 sg13_lv_pmos ad=0.3808p pd=2.92u as=0.3808p ps=2.92u w=1.12u l=0.13u
X1262 a_9341_9192# sg13cmos5l_mux2_1_4.X sg13cmos5l_nor3_1_0.Y VPWR.t29 sg13_lv_pmos ad=0.2128p pd=1.5u as=0.3808p ps=2.92u w=1.12u l=0.13u
X1263 sg13cmos5l_inv_1_132.Y sg13cmos5l_inv_1_1004.Y VGND.t354 VGND.t1063 sg13_lv_nmos ad=0.2516p pd=2.16u as=0.2516p ps=2.16u w=0.74u l=0.13u
X1264 sg13cmos5l_inv_1_231.Y sg13cmos5l_inv_1_222.Y VGND.t16 VGND.t11 sg13_lv_nmos ad=0.2516p pd=2.16u as=0.2516p ps=2.16u w=0.74u l=0.13u
X1265 VGND.t88 sg13cmos5l_inv_1_883.A sg13cmos5l_inv_1_883.Y VGND.t87 sg13_lv_nmos ad=0.2516p pd=2.16u as=0.2516p ps=2.16u w=0.74u l=0.13u
X1266 VGND.t478 sg13cmos5l_mux4_1_12.A3 a_14559_12606# VGND.t978 sg13_lv_nmos ad=0.2176p pd=1.96u as=76.8f ps=0.88u w=0.64u l=0.13u
X1267 sg13cmos5l_inv_1_335.Y sg13cmos5l_inv_1_324.Y VGND.t52 VGND.t630 sg13_lv_nmos ad=0.2516p pd=2.16u as=0.2516p ps=2.16u w=0.74u l=0.13u
X1268 VPWR.t487 sg13cmos5l_inv_1_106.A sg13cmos5l_inv_1_106.Y VPWR.t0 sg13_lv_pmos ad=0.3808p pd=2.92u as=0.3808p ps=2.92u w=1.12u l=0.13u
X1269 sg13cmos5l_inv_1_905.Y sg13cmos5l_inv_1_905.A VGND.t3 VGND.t581 sg13_lv_nmos ad=0.2516p pd=2.16u as=0.2516p ps=2.16u w=0.74u l=0.13u
X1270 sg13cmos5l_inv_1_409.Y sg13cmos5l_inv_1_387.Y VPWR.t1061 VPWR.t14 sg13_lv_pmos ad=0.3808p pd=2.92u as=0.3808p ps=2.92u w=1.12u l=0.13u
X1271 VPWR.t1053 sg13cmos5l_inv_1_635.A sg13cmos5l_inv_1_634.A VPWR.t21 sg13_lv_pmos ad=0.3808p pd=2.92u as=0.3808p ps=2.92u w=1.12u l=0.13u
X1272 a_13918_14482# sg13cmos5l_buf_1_9.A.t4 a_13831_14749# VPWR.t21 sg13_lv_pmos ad=0.19p pd=1.38u as=0.415p ps=1.83u w=1u l=0.13u
X1273 VGND.t260 sg13cmos5l_inv_1_328.A sg13cmos5l_inv_1_328.Y VGND.t642 sg13_lv_nmos ad=0.2516p pd=2.16u as=0.2516p ps=2.16u w=0.74u l=0.13u
X1274 sg13cmos5l_inv_1_392.A sg13cmos5l_inv_1_389.Y VGND.t107 VGND.t439 sg13_lv_nmos ad=0.2516p pd=2.16u as=0.2516p ps=2.16u w=0.74u l=0.13u
X1275 sg13cmos5l_inv_1_378.Y sg13cmos5l_inv_1_377.Y VPWR.t261 VPWR.t14 sg13_lv_pmos ad=0.3808p pd=2.92u as=0.3808p ps=2.92u w=1.12u l=0.13u
X1276 VGND.t100 sg13cmos5l_inv_1_688.A sg13cmos5l_inv_1_562.A VGND.t22 sg13_lv_nmos ad=0.2516p pd=2.16u as=0.2516p ps=2.16u w=0.74u l=0.13u
X1277 sg13cmos5l_inv_1_998.Y sg13cmos5l_inv_1_998.A VPWR.t780 VPWR.t5 sg13_lv_pmos ad=0.3808p pd=2.92u as=0.3808p ps=2.92u w=1.12u l=0.13u
X1278 VGND.t123 sg13cmos5l_inv_1_95.A sg13cmos5l_inv_1_67.A VGND.t1135 sg13_lv_nmos ad=0.2516p pd=2.16u as=0.2516p ps=2.16u w=0.74u l=0.13u
X1279 VGND.t1 sg13cmos5l_inv_1_148.A sg13cmos5l_inv_1_148.Y VGND.t163 sg13_lv_nmos ad=0.2516p pd=2.16u as=0.2516p ps=2.16u w=0.74u l=0.13u
X1280 a_14027_11654# a_14171_11488# a_14360_11776# VPWR.t2 sg13_lv_pmos ad=0.2225p pd=1.445u as=0.34p ps=2.68u w=1u l=0.13u
X1281 VPWR.t795 sg13cmos5l_inv_1_941.A sg13cmos5l_inv_1_959.A VPWR.t5 sg13_lv_pmos ad=0.3808p pd=2.92u as=0.3808p ps=2.92u w=1.12u l=0.13u
X1282 sg13cmos5l_inv_1_235.A sg13cmos5l_inv_1_236.Y VPWR.t624 VPWR.t49 sg13_lv_pmos ad=0.3808p pd=2.92u as=0.3808p ps=2.92u w=1.12u l=0.13u
X1283 a_3934_15994# a_3623_15994# a_3860_15994# VGND.t1323 sg13_lv_nmos ad=0.1472p pd=1.1u as=76.8f ps=0.88u w=0.64u l=0.13u
X1284 VPWR.t765 sg13cmos5l_inv_1_643.A sg13cmos5l_inv_1_641.A VPWR.t21 sg13_lv_pmos ad=0.3808p pd=2.92u as=0.3808p ps=2.92u w=1.12u l=0.13u
X1285 VGND.t269 VPWR.t1575 VGND.t269 VGND.t1548 sg13_lv_nmos ad=0.1428p pd=1.52u as=0 ps=0 w=0.42u l=1u
X1286 VGND.t191 sg13cmos5l_nor3_1_2.B.t1 sg13cmos5l_nor4_1_0.A VGND.t190 sg13_lv_nmos ad=0.1463p pd=1.15u as=0.1694p ps=1.21u w=0.77u l=0.13u
X1287 sg13cmos5l_inv_1_277.A sg13cmos5l_inv_1_281.Y VGND.t111 VGND.t238 sg13_lv_nmos ad=0.2516p pd=2.16u as=0.2516p ps=2.16u w=0.74u l=0.13u
X1288 VPWR.t1209 sg13cmos5l_inv_1_800.A sg13cmos5l_inv_1_800.Y VPWR.t42 sg13_lv_pmos ad=0.3808p pd=2.92u as=0.3808p ps=2.92u w=1.12u l=0.13u
X1289 sg13cmos5l_inv_1_281.Y sg13cmos5l_inv_1_285.Y VPWR.t1306 VPWR.t8 sg13_lv_pmos ad=0.3808p pd=2.92u as=0.3808p ps=2.92u w=1.12u l=0.13u
X1290 VGND.t107 VPWR.t1538 VGND.t107 VGND.t1597 sg13_lv_nmos ad=79.8f pd=0.8u as=0 ps=0 w=0.42u l=1u
X1291 VGND.t612 sg13cmos5l_inv_1_736.Y sg13cmos5l_inv_1_748.A VGND.t877 sg13_lv_nmos ad=0.2516p pd=2.16u as=0.2516p ps=2.16u w=0.74u l=0.13u
X1292 VGND.t8 sg13cmos5l_inv_1_933.A sg13cmos5l_inv_1_933.Y VGND.t181 sg13_lv_nmos ad=0.2516p pd=2.16u as=0.2516p ps=2.16u w=0.74u l=0.13u
X1293 VPWR.t1218 sg13cmos5l_inv_1_821.A sg13cmos5l_inv_1_821.Y VPWR.t39 sg13_lv_pmos ad=0.3808p pd=2.92u as=0.3808p ps=2.92u w=1.12u l=0.13u
X1294 VPWR.t1074 sg13cmos5l_inv_1_737.A sg13cmos5l_inv_1_1002.A VPWR.t5 sg13_lv_pmos ad=0.3808p pd=2.92u as=0.3808p ps=2.92u w=1.12u l=0.13u
X1295 sg13cmos5l_inv_1_217.A sg13cmos5l_inv_1_107.Y VPWR.t539 VPWR.t0 sg13_lv_pmos ad=0.3808p pd=2.92u as=0.3808p ps=2.92u w=1.12u l=0.13u
X1296 sg13cmos5l_inv_1_190.A sg13cmos5l_inv_1_224.Y VGND.t16 VGND.t11 sg13_lv_nmos ad=0.2516p pd=2.16u as=0.2516p ps=2.16u w=0.74u l=0.13u
X1297 VGND.t145 sg13cmos5l_inv_1_950.Y sg13cmos5l_inv_1_503.Y VGND.t1362 sg13_lv_nmos ad=0.2516p pd=2.16u as=0.2516p ps=2.16u w=0.74u l=0.13u
X1298 VGND.t242 sg13cmos5l_inv_1_75.Y sg13cmos5l_inv_1_271.A VGND.t241 sg13_lv_nmos ad=0.2516p pd=2.16u as=0.2516p ps=2.16u w=0.74u l=0.13u
X1299 VGND.t117 sg13cmos5l_inv_1_425.A sg13cmos5l_inv_1_424.A VGND.t11 sg13_lv_nmos ad=0.2516p pd=2.16u as=0.2516p ps=2.16u w=0.74u l=0.13u
X1300 VGND.t116 sg13cmos5l_inv_1_823.A sg13cmos5l_inv_1_823.Y VGND.t22 sg13_lv_nmos ad=0.2516p pd=2.16u as=0.2516p ps=2.16u w=0.74u l=0.13u
X1301 a_8897_11480# sg13cmos5l_a21oi_1_1.A1 sg13cmos5l_a21oi_1_0.A1 VGND.t895 sg13_lv_nmos ad=0.1406p pd=1.12u as=0.1406p ps=1.12u w=0.74u l=0.13u
X1302 sg13cmos5l_mux4_1_9.X a_4929_12564# VPWR.t661 VPWR.t2 sg13_lv_pmos ad=0.3808p pd=2.92u as=0.34367p ps=1.775u w=1.12u l=0.13u
X1303 sg13cmos5l_inv_1_348.Y sg13cmos5l_inv_1_348.A VPWR.t564 VPWR.t0 sg13_lv_pmos ad=0.3808p pd=2.92u as=0.3808p ps=2.92u w=1.12u l=0.13u
X1304 VPWR.t1385 sg13cmos5l_inv_1_836.A sg13cmos5l_inv_1_836.Y VPWR.t39 sg13_lv_pmos ad=0.3808p pd=2.92u as=0.3808p ps=2.92u w=1.12u l=0.13u
X1305 VGND.t44 sg13cmos5l_inv_1_628.Y sg13cmos5l_inv_1_630.A VGND.t22 sg13_lv_nmos ad=0.2516p pd=2.16u as=0.2516p ps=2.16u w=0.74u l=0.13u
X1306 sg13cmos5l_inv_1_135.Y sg13cmos5l_inv_1_134.Y VPWR.t1001 VPWR.t14 sg13_lv_pmos ad=0.3808p pd=2.92u as=0.3808p ps=2.92u w=1.12u l=0.13u
X1307 a_15637_8028# a_16075_7649# a_16531_7731# VPWR.t14 sg13_lv_pmos ad=0.19p pd=1.38u as=0.16p ps=1.32u w=1u l=0.13u
X1308 VPWR.t139 sg13cmos5l_inv_1_305.A sg13cmos5l_inv_1_305.Y VPWR.t11 sg13_lv_pmos ad=0.3808p pd=2.92u as=0.3808p ps=2.92u w=1.12u l=0.13u
X1309 sg13cmos5l_mux4_1_5.S0.t0 a_2248_3932# VPWR.t358 VPWR.t49 sg13_lv_pmos ad=0.42p pd=2.99u as=0.2114p ps=1.54u w=1.12u l=0.13u
X1310 sg13cmos5l_inv_1_797.Y sg13cmos5l_inv_1_797.A VPWR.t309 VPWR.t42 sg13_lv_pmos ad=0.3808p pd=2.92u as=0.3808p ps=2.92u w=1.12u l=0.13u
X1311 VGND.t1599 VPWR.t1537 VGND.t354 VGND.t1598 sg13_lv_nmos ad=0.1428p pd=1.52u as=0 ps=0 w=0.42u l=1u
X1312 VGND.t263 sg13cmos5l_inv_1_683.Y sg13cmos5l_inv_1_682.A VGND.t417 sg13_lv_nmos ad=0.2516p pd=2.16u as=0.2516p ps=2.16u w=0.74u l=0.13u
X1313 sg13cmos5l_inv_1_484.Y sg13cmos5l_inv_1_472.Y VGND.t269 VGND.t967 sg13_lv_nmos ad=0.2516p pd=2.16u as=0.2516p ps=2.16u w=0.74u l=0.13u
X1314 VPWR.t652 sg13cmos5l_inv_1_72.Y sg13cmos5l_inv_1_84.A VPWR.t8 sg13_lv_pmos ad=0.3808p pd=2.92u as=0.3808p ps=2.92u w=1.12u l=0.13u
X1315 VGND.t430 sg13cmos5l_inv_1_349.A sg13cmos5l_inv_1_348.A VGND.t1236 sg13_lv_nmos ad=0.2516p pd=2.16u as=0.2516p ps=2.16u w=0.74u l=0.13u
X1316 VGND.t621 VPWR.t1513 VGND.t1628 VGND.t1630 sg13_lv_nmos ad=0.1428p pd=1.52u as=0 ps=0 w=0.42u l=1u
X1317 sg13cmos5l_inv_1_8.Y sg13cmos5l_inv_1_8.A VPWR.t419 VPWR.t11 sg13_lv_pmos ad=0.3808p pd=2.92u as=0.3808p ps=2.92u w=1.12u l=0.13u
X1318 VPWR.t515 sg13cmos5l_inv_1_931.Y sg13cmos5l_inv_1_933.A VPWR.t5 sg13_lv_pmos ad=0.3808p pd=2.92u as=0.3808p ps=2.92u w=1.12u l=0.13u
X1319 sg13cmos5l_inv_1_570.A sg13cmos5l_inv_1_544.Y VPWR.t338 VPWR.t39 sg13_lv_pmos ad=0.3808p pd=2.92u as=0.3808p ps=2.92u w=1.12u l=0.13u
X1320 VPWR.t38 VGND.t902 VPWR.t37 VPWR.t5 sg13_lv_pmos ad=0.34p pd=2.68u as=0 ps=0 w=1u l=1u
X1321 sg13cmos5l_inv_1_57.Y sg13cmos5l_inv_1_66.Y VGND.t33 VGND.t1164 sg13_lv_nmos ad=0.2516p pd=2.16u as=0.2516p ps=2.16u w=0.74u l=0.13u
X1322 VPWR.t195 VGND.t212 VPWR.t194 VPWR.t0 sg13_lv_pmos ad=0.34p pd=2.68u as=0 ps=0 w=1u l=1u
X1323 VGND.t322 VPWR.t1580 VGND.t322 VGND.t1542 sg13_lv_nmos ad=0.1428p pd=1.52u as=0 ps=0 w=0.42u l=1u
X1324 VPWR.t1265 sg13cmos5l_inv_1_909.A sg13cmos5l_inv_1_745.A VPWR.t26 sg13_lv_pmos ad=0.3808p pd=2.92u as=0.3808p ps=2.92u w=1.12u l=0.13u
X1325 sg13cmos5l_inv_1_381.Y sg13cmos5l_inv_1_383.Y VPWR.t315 VPWR.t0 sg13_lv_pmos ad=0.3808p pd=2.92u as=0.3808p ps=2.92u w=1.12u l=0.13u
X1326 VGND.t1369 sg13cmos5l_inv_1_780.Y sg13cmos5l_inv_1_783.A VGND.t1368 sg13_lv_nmos ad=0.2516p pd=2.16u as=0.2516p ps=2.16u w=0.74u l=0.13u
X1327 VGND.t162 sg13cmos5l_mux4_1_5.S1.t6 a_5005_7954# VGND.t651 sg13_lv_nmos ad=0.1543p pd=1.18u as=0.2304p ps=2u w=0.64u l=0.13u
X1328 a_8577_3492# sg13cmos5l_mux4_1_5.S1.t2 a_7582_3534# VPWR.t8 sg13_lv_pmos ad=0.2225p pd=1.445u as=0.34p ps=2.68u w=1u l=0.13u
X1329 VPWR.t409 sg13cmos5l_inv_1_28.A sg13cmos5l_inv_1_76.A VPWR.t49 sg13_lv_pmos ad=0.3808p pd=2.92u as=0.3808p ps=2.92u w=1.12u l=0.13u
X1330 VPWR.t1011 sg13cmos5l_inv_1_177.Y sg13cmos5l_inv_1_182.A VPWR.t14 sg13_lv_pmos ad=0.3808p pd=2.92u as=0.3808p ps=2.92u w=1.12u l=0.13u
X1331 VPWR.t253 VGND.t6 VPWR.t252 VPWR.t29 sg13_lv_pmos ad=0.34p pd=2.68u as=0 ps=0 w=1u l=1u
X1332 VGND.t102 sg13cmos5l_inv_1_482.Y sg13cmos5l_inv_1_478.A VGND.t509 sg13_lv_nmos ad=0.2516p pd=2.16u as=0.2516p ps=2.16u w=0.74u l=0.13u
X1333 VGND.t143 sg13cmos5l_inv_1_972.Y sg13cmos5l_inv_1_924.Y VGND.t190 sg13_lv_nmos ad=0.2516p pd=2.16u as=0.2516p ps=2.16u w=0.74u l=0.13u
X1334 sg13cmos5l_inv_1_213.A sg13cmos5l_inv_1_195.Y VPWR.t614 VPWR.t0 sg13_lv_pmos ad=0.3808p pd=2.92u as=0.3808p ps=2.92u w=1.12u l=0.13u
X1335 VPWR.t756 sg13cmos5l_inv_1_217.A sg13cmos5l_inv_1_218.A VPWR.t0 sg13_lv_pmos ad=0.3808p pd=2.92u as=0.3808p ps=2.92u w=1.12u l=0.13u
X1336 sg13cmos5l_buf_1_7.X a_808_1632# VGND.t119 VGND.t550 sg13_lv_nmos ad=0.2886p pd=2.26u as=0.14875p ps=1.16u w=0.74u l=0.13u
X1337 a_8795_11752# sg13cmos5l_a21oi_1_1.A2 VPWR.t550 VPWR.t2 sg13_lv_pmos ad=0.3808p pd=2.92u as=0.2128p ps=1.5u w=1.12u l=0.13u
X1338 a_14413_15291# a_13895_15630# a_14206_15630# VPWR.t21 sg13_lv_pmos ad=0.16p pd=1.32u as=0.19p ps=1.38u w=1u l=0.13u
X1339 sg13cmos5l_inv_1_481.Y sg13cmos5l_inv_1_486.Y VPWR.t1149 VPWR.t2 sg13_lv_pmos ad=0.3808p pd=2.92u as=0.3808p ps=2.92u w=1.12u l=0.13u
X1340 sg13cmos5l_inv_1_723.A sg13cmos5l_inv_1_694.Y VGND.t1163 VGND.t1162 sg13_lv_nmos ad=0.2516p pd=2.16u as=0.2516p ps=2.16u w=0.74u l=0.13u
X1341 a_15105_3492# sg13cmos5l_mux2_1_4.S.t1 a_14110_3534# VPWR.t8 sg13_lv_pmos ad=0.2225p pd=1.445u as=0.34p ps=2.68u w=1u l=0.13u
X1342 sg13cmos5l_inv_1_866.Y sg13cmos5l_inv_1_815.Y VPWR.t879 VPWR.t42 sg13_lv_pmos ad=0.3808p pd=2.92u as=0.3808p ps=2.92u w=1.12u l=0.13u
X1343 sg13cmos5l_inv_1_904.Y sg13cmos5l_inv_1_904.A VGND.t88 VGND.t1169 sg13_lv_nmos ad=0.2516p pd=2.16u as=0.2516p ps=2.16u w=0.74u l=0.13u
X1344 sg13cmos5l_inv_1_460.Y sg13cmos5l_inv_1_459.Y VPWR.t777 VPWR.t0 sg13_lv_pmos ad=0.3808p pd=2.92u as=0.3808p ps=2.92u w=1.12u l=0.13u
X1345 VGND.t19 sg13cmos5l_inv_1_293.Y sg13cmos5l_inv_1_282.Y VGND.t1284 sg13_lv_nmos ad=0.2516p pd=2.16u as=0.2516p ps=2.16u w=0.74u l=0.13u
X1346 sg13cmos5l_inv_1_409.Y sg13cmos5l_inv_1_387.Y VGND.t162 VGND.t1015 sg13_lv_nmos ad=0.2516p pd=2.16u as=0.2516p ps=2.16u w=0.74u l=0.13u
X1347 sg13cmos5l_inv_1_362.Y sg13cmos5l_inv_1_362.A VGND.t430 VGND.t541 sg13_lv_nmos ad=0.2516p pd=2.16u as=0.2516p ps=2.16u w=0.74u l=0.13u
X1348 sg13cmos5l_inv_1_378.Y sg13cmos5l_inv_1_377.Y VGND.t15 VGND.t14 sg13_lv_nmos ad=0.2516p pd=2.16u as=0.2516p ps=2.16u w=0.74u l=0.13u
X1349 VPWR.t434 sg13cmos5l_inv_1_68.A sg13cmos5l_inv_1_74.A VPWR.t11 sg13_lv_pmos ad=0.3808p pd=2.92u as=0.3808p ps=2.92u w=1.12u l=0.13u
X1350 VPWR.t1317 sg13cmos5l_inv_1_437.A sg13cmos5l_inv_1_436.A VPWR.t0 sg13_lv_pmos ad=0.3808p pd=2.92u as=0.3808p ps=2.92u w=1.12u l=0.13u
X1351 VPWR.t980 sg13cmos5l_inv_1_696.A sg13cmos5l_inv_1_698.A VPWR.t5 sg13_lv_pmos ad=0.3808p pd=2.92u as=0.3808p ps=2.92u w=1.12u l=0.13u
X1352 VGND.t43 sg13cmos5l_mux4_1_5.S0.t1 a_7271_3534# VGND.t1258 sg13_lv_nmos ad=0.1872p pd=1.225u as=0.2176p ps=1.96u w=0.64u l=0.13u
X1353 sg13cmos5l_inv_1_975.A sg13cmos5l_inv_1_791.A VPWR.t378 VPWR.t42 sg13_lv_pmos ad=0.3808p pd=2.92u as=0.3808p ps=2.92u w=1.12u l=0.13u
X1354 VGND.t73 sg13cmos5l_inv_1_274.Y a_8223_3534# VGND.t1425 sg13_lv_nmos ad=0.2176p pd=1.96u as=76.8f ps=0.88u w=0.64u l=0.13u
X1355 a_13844_14482# sg13cmos5l_mux4_1_14.A0 VGND.t92 VGND.t803 sg13_lv_nmos ad=76.8f pd=0.88u as=0.1872p ps=1.225u w=0.64u l=0.13u
X1356 sg13cmos5l_inv_1_236.A sg13cmos5l_inv_1_192.Y VPWR.t1364 VPWR.t0 sg13_lv_pmos ad=0.3808p pd=2.92u as=0.3808p ps=2.92u w=1.12u l=0.13u
X1357 VGND.t207 sg13cmos5l_inv_1_581.A sg13cmos5l_inv_1_583.A VGND.t1188 sg13_lv_nmos ad=0.2516p pd=2.16u as=0.2516p ps=2.16u w=0.74u l=0.13u
X1358 a_8383_12192# sg13cmos5l_nor3_1_1.A sg13cmos5l_a21oi_1_0.A2 VPWR.t2 sg13_lv_pmos ad=0.2744p pd=1.61u as=0.2128p ps=1.5u w=1.12u l=0.13u
X1359 sg13cmos5l_inv_1_6.Y sg13cmos5l_inv_1_4.Y VPWR.t1394 VPWR.t11 sg13_lv_pmos ad=0.3808p pd=2.92u as=0.3808p ps=2.92u w=1.12u l=0.13u
X1360 VGND.t754 VPWR.t1542 VGND.t754 VGND.t1591 sg13_lv_nmos ad=0.1428p pd=1.52u as=0 ps=0 w=0.42u l=1u
X1361 sg13cmos5l_inv_1_410.Y sg13cmos5l_inv_1_318.Y VPWR.t623 VPWR.t49 sg13_lv_pmos ad=0.3808p pd=2.92u as=0.3808p ps=2.92u w=1.12u l=0.13u
X1362 sg13cmos5l_inv_1_857.Y sg13cmos5l_inv_1_857.A VPWR.t445 VPWR.t42 sg13_lv_pmos ad=0.3808p pd=2.92u as=0.3808p ps=2.92u w=1.12u l=0.13u
X1363 sg13cmos5l_inv_1_905.Y sg13cmos5l_inv_1_905.A VPWR.t976 VPWR.t26 sg13_lv_pmos ad=0.3808p pd=2.92u as=0.3808p ps=2.92u w=1.12u l=0.13u
X1364 VPWR.t251 VGND.t6 VPWR.t35 VPWR.t5 sg13_lv_pmos ad=0.34p pd=2.68u as=0 ps=0 w=1u l=1u
X1365 sg13cmos5l_mux2_1_3.X a_9982_8050# VPWR.t314 VPWR.t14 sg13_lv_pmos ad=0.6048p pd=3.32u as=0.2198p ps=1.52u w=1.12u l=0.13u
X1366 sg13cmos5l_inv_1_882.A sg13cmos5l_inv_1_916.A VGND.t3 VGND.t581 sg13_lv_nmos ad=0.2516p pd=2.16u as=0.2516p ps=2.16u w=0.74u l=0.13u
X1367 VPWR.t94 VGND.t98 VPWR.t193 VPWR.t21 sg13_lv_pmos ad=0.34p pd=2.68u as=0 ps=0 w=1u l=1u
X1368 a_16075_7649# sg13cmos5l_buf_1_8.A.t2 VGND.t128 VGND.t665 sg13_lv_nmos ad=0.2176p pd=1.96u as=0.1872p ps=1.225u w=0.64u l=0.13u
X1369 a_3860_12606# sg13cmos5l_mux4_1_9.A0 VGND.t866 VGND.t908 sg13_lv_nmos ad=76.8f pd=0.88u as=0.1872p ps=1.225u w=0.64u l=0.13u
X1370 sg13cmos5l_nand2_1_1.Y sg13cmos5l_mux2_1_4.S a_10042_8434# VGND.t770 sg13_lv_nmos ad=0.2516p pd=2.16u as=0.1406p ps=1.12u w=0.74u l=0.13u
X1371 sg13cmos5l_mux4_1_14.A0 sg13cmos5l_inv_1_786.Y VPWR.t1344 VPWR.t42 sg13_lv_pmos ad=0.3808p pd=2.92u as=0.3808p ps=2.92u w=1.12u l=0.13u
X1372 sg13cmos5l_a21oi_1_0.B1 sg13cmos5l_nor2b_1_0.A a_1594_15610# VGND.t804 sg13_lv_nmos ad=0.2516p pd=2.16u as=0.1406p ps=1.12u w=0.74u l=0.13u
X1373 VGND.t39 sg13cmos5l_inv_1_1000.Y sg13cmos5l_inv_1_694.A VGND.t1109 sg13_lv_nmos ad=0.2516p pd=2.16u as=0.2516p ps=2.16u w=0.74u l=0.13u
X1374 VGND.t1 sg13cmos5l_inv_1_173.Y sg13cmos5l_inv_1_106.A VGND.t163 sg13_lv_nmos ad=0.2516p pd=2.16u as=0.2516p ps=2.16u w=0.74u l=0.13u
X1375 VGND.t12 sg13cmos5l_inv_1_439.A sg13cmos5l_inv_1_439.Y VGND.t11 sg13_lv_nmos ad=0.2516p pd=2.16u as=0.2516p ps=2.16u w=0.74u l=0.13u
X1376 VGND.t263 sg13cmos5l_inv_1_535.A sg13cmos5l_inv_1_535.Y VGND.t799 sg13_lv_nmos ad=0.2516p pd=2.16u as=0.2516p ps=2.16u w=0.74u l=0.13u
X1377 sg13cmos5l_inv_1_922.A sg13cmos5l_inv_1_494.Y VGND.t188 VGND.t882 sg13_lv_nmos ad=0.2516p pd=2.16u as=0.2516p ps=2.16u w=0.74u l=0.13u
X1378 VPWR.t553 sg13cmos5l_inv_1_683.Y sg13cmos5l_inv_1_682.A VPWR.t21 sg13_lv_pmos ad=0.3808p pd=2.92u as=0.3808p ps=2.92u w=1.12u l=0.13u
X1379 VPWR.t908 sg13cmos5l_inv_1_633.A sg13cmos5l_inv_1_632.A VPWR.t21 sg13_lv_pmos ad=0.3808p pd=2.92u as=0.3808p ps=2.92u w=1.12u l=0.13u
X1380 sg13cmos5l_inv_1_576.A sg13cmos5l_inv_1_546.Y VGND.t49 VGND.t318 sg13_lv_nmos ad=0.2516p pd=2.16u as=0.2516p ps=2.16u w=0.74u l=0.13u
X1381 a_15419_8040# sg13cmos5l_buf_1_9.A.t1 VPWR.t761 VPWR.t14 sg13_lv_pmos ad=0.34p pd=2.68u as=0.34367p ps=1.775u w=1u l=0.13u
X1382 VPWR.t344 sg13cmos5l_inv_1_930.A sg13cmos5l_inv_1_931.A VPWR.t5 sg13_lv_pmos ad=0.3808p pd=2.92u as=0.3808p ps=2.92u w=1.12u l=0.13u
X1383 sg13cmos5l_inv_1_8.Y sg13cmos5l_inv_1_8.A VGND.t21 VGND.t253 sg13_lv_nmos ad=0.2516p pd=2.16u as=0.2516p ps=2.16u w=0.74u l=0.13u
X1384 VPWR.t1503 sg13cmos5l_inv_1_185.A sg13cmos5l_inv_1_185.Y VPWR.t49 sg13_lv_pmos ad=0.3808p pd=2.92u as=0.3808p ps=2.92u w=1.12u l=0.13u
X1385 sg13cmos5l_inv_1_616.A sg13cmos5l_inv_1_579.Y VGND.t136 VGND.t135 sg13_lv_nmos ad=0.2516p pd=2.16u as=0.2516p ps=2.16u w=0.74u l=0.13u
X1386 VGND.t184 sg13cmos5l_mux4_1_11.A2 a_15076_11458# VGND.t680 sg13_lv_nmos ad=0.1824p pd=1.21u as=80f ps=0.89u w=0.64u l=0.13u
X1387 VPWR.t1367 sg13cmos5l_inv_1_950.Y sg13cmos5l_inv_1_503.Y VPWR.t5 sg13_lv_pmos ad=0.3808p pd=2.92u as=0.3808p ps=2.92u w=1.12u l=0.13u
X1388 VPWR.t1291 sg13cmos5l_inv_1_14.A sg13cmos5l_inv_1_17.A VPWR.t11 sg13_lv_pmos ad=0.3808p pd=2.92u as=0.3808p ps=2.92u w=1.12u l=0.13u
X1389 VPWR.t915 sg13cmos5l_inv_1_434.A sg13cmos5l_inv_1_419.A VPWR.t0 sg13_lv_pmos ad=0.3808p pd=2.92u as=0.3808p ps=2.92u w=1.12u l=0.13u
X1390 VGND.t191 sg13cmos5l_o21ai_1_0.Y sg13cmos5l_nor4_1_0.Y VGND.t190 sg13_lv_nmos ad=0.23757p pd=2.16u as=0.1406p ps=1.12u w=0.74u l=0.13u
X1391 a_9360_11832# sg13cmos5l_or2_1_0.B VGND.t414 VGND.t1024 sg13_lv_nmos ad=0.1045p pd=0.93u as=0.187p ps=1.78u w=0.55u l=0.13u
X1392 a_10162_9570# sg13cmos5l_o21ai_1_0.B1 sg13cmos5l_o21ai_1_0.Y VGND.t4 sg13_lv_nmos ad=0.1406p pd=1.12u as=0.2516p ps=2.16u w=0.74u l=0.15u
X1393 sg13cmos5l_inv_1_49.A sg13cmos5l_mux4_1_1.A3 VPWR.t699 VPWR.t8 sg13_lv_pmos ad=0.3808p pd=2.92u as=0.3808p ps=2.92u w=1.12u l=0.13u
X1394 sg13cmos5l_inv_1_198.Y sg13cmos5l_inv_1_189.Y VGND.t113 VGND.t11 sg13_lv_nmos ad=0.2516p pd=2.16u as=0.2516p ps=2.16u w=0.74u l=0.13u
X1395 VPWR.t520 sg13cmos5l_inv_1_138.A sg13cmos5l_inv_1_138.Y VPWR.t14 sg13_lv_pmos ad=0.3808p pd=2.92u as=0.3808p ps=2.92u w=1.12u l=0.13u
X1396 VGND.t128 sg13cmos5l_inv_1_177.Y sg13cmos5l_inv_1_182.A VGND.t481 sg13_lv_nmos ad=0.2516p pd=2.16u as=0.2516p ps=2.16u w=0.74u l=0.13u
X1397 sg13cmos5l_inv_1_624.Y sg13cmos5l_inv_1_658.Y VGND.t263 VGND.t628 sg13_lv_nmos ad=0.2516p pd=2.16u as=0.2516p ps=2.16u w=0.74u l=0.13u
X1398 VGND.t39 sg13cmos5l_inv_1_716.A sg13cmos5l_inv_1_701.A VGND.t1104 sg13_lv_nmos ad=0.2516p pd=2.16u as=0.2516p ps=2.16u w=0.74u l=0.13u
X1399 VGND.t244 sg13cmos5l_inv_1_240.Y sg13cmos5l_inv_1_243.A VGND.t643 sg13_lv_nmos ad=0.2516p pd=2.16u as=0.2516p ps=2.16u w=0.74u l=0.13u
X1400 VGND.t428 sg13cmos5l_buf_1_2.X a_18856_3932# VGND.t1126 sg13_lv_nmos ad=0.14875p pd=1.16u as=0.187p ps=1.78u w=0.55u l=0.13u
X1401 VPWR.t122 VGND.t233 VPWR.t121 VPWR.t49 sg13_lv_pmos ad=0.34p pd=2.68u as=0 ps=0 w=1u l=1u
X1402 sg13cmos5l_inv_1_234.A sg13cmos5l_inv_1_235.Y VGND.t225 VGND.t11 sg13_lv_nmos ad=0.2516p pd=2.16u as=0.2516p ps=2.16u w=0.74u l=0.13u
X1403 VPWR.t267 sg13cmos5l_inv_1_779.A sg13cmos5l_inv_1_779.Y VPWR.t39 sg13_lv_pmos ad=0.3808p pd=2.92u as=0.3808p ps=2.92u w=1.12u l=0.13u
X1404 VGND.t1072 invsel[3] a_808_9980# VGND.t190 sg13_lv_nmos ad=0.14875p pd=1.16u as=0.187p ps=1.78u w=0.55u l=0.13u
X1405 a_4661_16307# a_3623_15994# a_4438_15994# VPWR.t42 sg13_lv_pmos ad=0.135p pd=1.27u as=0.4425p ps=1.885u w=1u l=0.13u
X1406 VGND.t244 sg13cmos5l_inv_1_240.A sg13cmos5l_inv_1_240.Y VGND.t243 sg13_lv_nmos ad=0.2516p pd=2.16u as=0.2516p ps=2.16u w=0.74u l=0.13u
X1407 sg13cmos5l_inv_1_484.Y sg13cmos5l_inv_1_472.Y VPWR.t1021 VPWR.t5 sg13_lv_pmos ad=0.3808p pd=2.92u as=0.3808p ps=2.92u w=1.12u l=0.13u
X1408 VPWR.t1216 sg13cmos5l_inv_1_809.Y sg13cmos5l_inv_1_806.Y VPWR.t39 sg13_lv_pmos ad=0.3808p pd=2.92u as=0.3808p ps=2.92u w=1.12u l=0.13u
X1409 VGND.t244 sg13cmos5l_inv_1_239.A sg13cmos5l_inv_1_240.A VGND.t678 sg13_lv_nmos ad=0.2516p pd=2.16u as=0.2516p ps=2.16u w=0.74u l=0.13u
X1410 VGND.t3 sg13cmos5l_inv_1_882.A sg13cmos5l_inv_1_882.Y VGND.t2 sg13_lv_nmos ad=0.2516p pd=2.16u as=0.2516p ps=2.16u w=0.74u l=0.13u
X1411 VPWR.t1473 sg13cmos5l_nor3_1_2.B a_4475_13008# VPWR.t26 sg13_lv_pmos ad=0.253p pd=1.53u as=0.2856p ps=2.36u w=0.84u l=0.13u
X1412 a_9919_11500# sg13cmos5l_a21oi_1_0.Y VGND.t612 VGND.t934 sg13_lv_nmos ad=81.6f pd=0.895u as=0.2176p ps=1.96u w=0.64u l=0.13u
X1413 sg13cmos5l_inv_1_156.Y sg13cmos5l_inv_1_155.Y VGND.t130 VGND.t1013 sg13_lv_nmos ad=0.2516p pd=2.16u as=0.2516p ps=2.16u w=0.74u l=0.13u
X1414 a_15221_9197# a_14183_9582# a_14998_9582# VPWR.t29 sg13_lv_pmos ad=0.135p pd=1.27u as=0.4425p ps=1.885u w=1u l=0.13u
X1415 VGND.t88 VPWR.t1593 VGND.t88 VGND.t1522 sg13_lv_nmos ad=0.1428p pd=1.52u as=0 ps=0 w=0.42u l=1u
X1416 a_7551_12970# sg13cmos5l_mux4_1_5.S0.t6 a_7414_12970# VGND.t1251 sg13_lv_nmos ad=76.8f pd=0.88u as=0.1776p ps=1.195u w=0.64u l=0.13u
X1417 VPWR.t1280 sg13cmos5l_inv_1_245.A sg13cmos5l_inv_1_247.A VPWR.t11 sg13_lv_pmos ad=0.3808p pd=2.92u as=0.3808p ps=2.92u w=1.12u l=0.13u
X1418 VGND.t514 sg13cmos5l_inv_1_115.A sg13cmos5l_inv_1_115.Y VGND.t918 sg13_lv_nmos ad=0.2516p pd=2.16u as=0.2516p ps=2.16u w=0.74u l=0.13u
X1419 sg13cmos5l_inv_1_689.A sg13cmos5l_inv_1_563.Y VGND.t94 VGND.t804 sg13_lv_nmos ad=0.2516p pd=2.16u as=0.2516p ps=2.16u w=0.74u l=0.13u
X1420 sg13cmos5l_inv_1_975.A sg13cmos5l_inv_1_791.A VGND.t197 VGND.t22 sg13_lv_nmos ad=0.2516p pd=2.16u as=0.2516p ps=2.16u w=0.74u l=0.13u
X1421 VPWR.t534 sg13cmos5l_inv_1_690.A sg13cmos5l_inv_1_642.A VPWR.t21 sg13_lv_pmos ad=0.3808p pd=2.92u as=0.3808p ps=2.92u w=1.12u l=0.13u
X1422 VPWR.t93 VGND.t107 VPWR.t91 VPWR.t0 sg13_lv_pmos ad=0.19p pd=1.38u as=0 ps=0 w=1u l=1u
X1423 sg13cmos5l_inv_1_846.Y sg13cmos5l_inv_1_845.Y VGND.t66 VGND.t1331 sg13_lv_nmos ad=0.2516p pd=2.16u as=0.2516p ps=2.16u w=0.74u l=0.13u
X1424 sg13cmos5l_inv_1_3.Y sg13cmos5l_inv_1_16.Y VPWR.t1158 VPWR.t11 sg13_lv_pmos ad=0.3808p pd=2.92u as=0.3808p ps=2.92u w=1.12u l=0.13u
X1425 VPWR.t1213 sg13cmos5l_inv_1_581.A sg13cmos5l_inv_1_583.A VPWR.t21 sg13_lv_pmos ad=0.3808p pd=2.92u as=0.3808p ps=2.92u w=1.12u l=0.13u
X1426 VGND.t15 sg13cmos5l_inv_1_351.A sg13cmos5l_inv_1_351.Y VGND.t960 sg13_lv_nmos ad=0.2516p pd=2.16u as=0.2516p ps=2.16u w=0.74u l=0.13u
X1427 sg13cmos5l_inv_1_723.A sg13cmos5l_inv_1_694.Y VPWR.t1188 VPWR.t5 sg13_lv_pmos ad=0.3808p pd=2.92u as=0.3808p ps=2.92u w=1.12u l=0.13u
X1428 sg13cmos5l_inv_1_818.A sg13cmos5l_inv_1_858.Y VPWR.t439 VPWR.t42 sg13_lv_pmos ad=0.3808p pd=2.92u as=0.3808p ps=2.92u w=1.12u l=0.13u
X1429 sg13cmos5l_inv_1_904.Y sg13cmos5l_inv_1_904.A VPWR.t1194 VPWR.t26 sg13_lv_pmos ad=0.3808p pd=2.92u as=0.3808p ps=2.92u w=1.12u l=0.13u
X1430 sg13cmos5l_inv_1_29.A sg13cmos5l_inv_1_30.Y VGND.t28 VGND.t131 sg13_lv_nmos ad=0.2516p pd=2.16u as=0.2516p ps=2.16u w=0.74u l=0.13u
X1431 VPWR.t314 a_9659_7736# a_10159_7704# VPWR.t14 sg13_lv_pmos ad=0.2198p pd=1.52u as=0.2975p ps=1.595u w=1u l=0.13u
X1432 sg13cmos5l_inv_1_300.Y sg13cmos5l_inv_1_298.Y VGND.t246 VGND.t602 sg13_lv_nmos ad=0.2516p pd=2.16u as=0.2516p ps=2.16u w=0.74u l=0.13u
X1433 VGND.t12 sg13cmos5l_inv_1_317.Y sg13cmos5l_inv_1_450.Y VGND.t11 sg13_lv_nmos ad=0.2516p pd=2.16u as=0.2516p ps=2.16u w=0.74u l=0.13u
X1434 sg13cmos5l_a21oi_1_1.A2 a_8577_16036# VPWR.t336 VPWR.t42 sg13_lv_pmos ad=0.3808p pd=2.92u as=0.34367p ps=1.775u w=1.12u l=0.13u
X1435 sg13cmos5l_inv_1_295.A sg13cmos5l_inv_1_300.Y VGND.t246 VGND.t1636 sg13_lv_nmos ad=0.2516p pd=2.16u as=0.2516p ps=2.16u w=0.74u l=0.13u
X1436 a_4929_16036# sg13cmos5l_buf_1_9.A.t7 a_3934_15994# VPWR.t42 sg13_lv_pmos ad=0.2225p pd=1.445u as=0.34p ps=2.68u w=1u l=0.13u
X1437 VPWR.t268 sg13cmos5l_inv_1_720.Y sg13cmos5l_buf_1_19.A VPWR.t26 sg13_lv_pmos ad=0.3808p pd=2.92u as=0.3808p ps=2.92u w=1.12u l=0.13u
X1438 VGND.t6 sg13cmos5l_inv_1_940.A sg13cmos5l_inv_1_998.A VGND.t190 sg13_lv_nmos ad=0.2516p pd=2.16u as=0.2516p ps=2.16u w=0.74u l=0.13u
X1439 VGND.t587 VPWR.t1604 VGND.t587 VGND.t804 sg13_lv_nmos ad=0.1428p pd=1.52u as=0 ps=0 w=0.42u l=1u
X1440 VGND.t92 sg13cmos5l_inv_1_915.A sg13cmos5l_inv_1_912.A VGND.t888 sg13_lv_nmos ad=0.2516p pd=2.16u as=0.2516p ps=2.16u w=0.74u l=0.13u
X1441 VGND.t322 sg13cmos5l_inv_1_532.A sg13cmos5l_inv_1_532.Y VGND.t756 sg13_lv_nmos ad=0.2516p pd=2.16u as=0.2516p ps=2.16u w=0.74u l=0.13u
X1442 VGND.t191 a_9260_9906# sg13cmos5l_nor3_1_1.A VGND.t190 sg13_lv_nmos ad=0.14875p pd=1.16u as=0.2886p ps=2.26u w=0.74u l=0.13u
X1443 VGND.t1626 VPWR.t139 VGND.t260 VGND.t1629 sg13_lv_nmos ad=0.1428p pd=1.52u as=0 ps=0 w=0.42u l=1u
X1444 sg13cmos5l_inv_1_60.Y sg13cmos5l_inv_1_57.Y VGND.t33 VGND.t32 sg13_lv_nmos ad=0.2516p pd=2.16u as=0.2516p ps=2.16u w=0.74u l=0.13u
X1445 a_14847_15630# sg13cmos5l_buf_1_9.A.t5 a_14710_15630# VGND.t709 sg13_lv_nmos ad=76.8f pd=0.88u as=0.1776p ps=1.195u w=0.64u l=0.13u
X1446 sg13cmos5l_inv_1_207.A sg13cmos5l_inv_1_209.Y VPWR.t776 VPWR.t0 sg13_lv_pmos ad=0.3808p pd=2.92u as=0.3808p ps=2.92u w=1.12u l=0.13u
X1447 sg13cmos5l_inv_1_56.Y sg13cmos5l_inv_1_60.Y VGND.t256 VGND.t1128 sg13_lv_nmos ad=0.2516p pd=2.16u as=0.2516p ps=2.16u w=0.74u l=0.13u
X1448 VPWR.t24 VGND.t354 VPWR.t198 VPWR.t0 sg13_lv_pmos ad=0.34p pd=2.68u as=0 ps=0 w=1u l=1u
X1449 VGND.t1156 VPWR.t1535 VGND.t12 VGND.t11 sg13_lv_nmos ad=0.1428p pd=1.52u as=0 ps=0 w=0.42u l=1u
X1450 VGND.t363 sg13cmos5l_inv_1_782.A sg13cmos5l_inv_1_771.A VGND.t362 sg13_lv_nmos ad=0.2516p pd=2.16u as=0.2516p ps=2.16u w=0.74u l=0.13u
X1451 sg13cmos5l_inv_1_551.Y sg13cmos5l_inv_1_552.Y VGND.t503 VGND.t661 sg13_lv_nmos ad=0.2516p pd=2.16u as=0.2516p ps=2.16u w=0.74u l=0.13u
X1452 VGND.t126 sg13cmos5l_inv_1_752.A sg13cmos5l_inv_1_751.A VGND.t1405 sg13_lv_nmos ad=0.2516p pd=2.16u as=0.2516p ps=2.16u w=0.74u l=0.13u
X1453 VPWR.t968 sg13cmos5l_inv_1_921.Y sg13cmos5l_inv_1_926.A VPWR.t5 sg13_lv_pmos ad=0.3808p pd=2.92u as=0.3808p ps=2.92u w=1.12u l=0.13u
X1454 a_4929_3492# sg13cmos5l_mux4_1_5.S1.t3 a_4438_3534# VGND.t648 sg13_lv_nmos ad=0.1216p pd=1.02u as=0.54188p ps=3.42u w=0.64u l=0.13u
X1455 VGND.t143 sg13cmos5l_inv_1_969.Y sg13cmos5l_inv_1_983.Y VGND.t4 sg13_lv_nmos ad=0.2516p pd=2.16u as=0.2516p ps=2.16u w=0.74u l=0.13u
X1456 VPWR.t1126 sg13cmos5l_inv_1_986.Y sg13cmos5l_inv_1_942.Y VPWR.t5 sg13_lv_pmos ad=0.3808p pd=2.92u as=0.3808p ps=2.92u w=1.12u l=0.13u
X1457 VPWR.t860 sg13cmos5l_inv_1_535.A sg13cmos5l_inv_1_535.Y VPWR.t21 sg13_lv_pmos ad=0.3808p pd=2.92u as=0.3808p ps=2.92u w=1.12u l=0.13u
X1458 sg13cmos5l_inv_1_511.A sg13cmos5l_inv_1_668.Y VGND.t527 VGND.t1114 sg13_lv_nmos ad=0.2516p pd=2.16u as=0.2516p ps=2.16u w=0.74u l=0.13u
X1459 a_8623_8728# sg13cmos5l_mux4_1_6.X a_8446_8434# VPWR.t29 sg13_lv_pmos ad=0.2975p pd=1.595u as=0.2225p ps=1.445u w=1u l=0.13u
X1460 VPWR.t59 VGND.t5 VPWR.t58 VPWR.t29 sg13_lv_pmos ad=0.34p pd=2.68u as=0 ps=0 w=1u l=1u
X1461 a_14206_15630# a_15277_15514# a_15201_15588# VGND.t1384 sg13_lv_nmos ad=0.2176p pd=1.96u as=0.1216p ps=1.02u w=0.64u l=0.13u
X1462 VGND.t191 sg13cmos5l_nor3_1_1.B sg13cmos5l_nor3_1_1.Y VGND.t190 sg13_lv_nmos ad=0.1463p pd=1.15u as=0.1694p ps=1.21u w=0.77u l=0.13u
X1463 a_14341_14749# sg13cmos5l_inv_1_884.Y VPWR.t306 VPWR.t21 sg13_lv_pmos ad=0.20762p pd=1.605u as=0.29275p ps=1.785u w=1u l=0.13u
X1464 VGND.t547 sg13cmos5l_inv_1_14.A sg13cmos5l_inv_1_17.A VGND.t1283 sg13_lv_nmos ad=0.2516p pd=2.16u as=0.2516p ps=2.16u w=0.74u l=0.13u
X1465 VPWR.t644 sg13cmos5l_inv_1_685.Y sg13cmos5l_inv_1_680.A VPWR.t21 sg13_lv_pmos ad=0.3808p pd=2.92u as=0.3808p ps=2.92u w=1.12u l=0.13u
X1466 VPWR.t428 sg13cmos5l_inv_1_973.Y sg13cmos5l_inv_1_944.Y VPWR.t5 sg13_lv_pmos ad=0.3808p pd=2.92u as=0.3808p ps=2.92u w=1.12u l=0.13u
X1467 sg13cmos5l_inv_1_116.Y sg13cmos5l_inv_1_115.Y VGND.t165 VGND.t235 sg13_lv_nmos ad=0.2516p pd=2.16u as=0.2516p ps=2.16u w=0.74u l=0.13u
X1468 VGND.t6 sg13cmos5l_inv_1_112.Y sg13cmos5l_inv_1_978.A VGND.t4 sg13_lv_nmos ad=0.2516p pd=2.16u as=0.2516p ps=2.16u w=0.74u l=0.13u
X1469 sg13cmos5l_inv_1_541.Y sg13cmos5l_inv_1_541.A VPWR.t468 VPWR.t39 sg13_lv_pmos ad=0.3808p pd=2.92u as=0.3808p ps=2.92u w=1.12u l=0.13u
X1470 a_15135_9582# sg13cmos5l_mux4_1_5.S1.t8 a_14998_9582# VGND.t86 sg13_lv_nmos ad=76.8f pd=0.88u as=0.1776p ps=1.195u w=0.64u l=0.13u
X1471 a_4362_3534# sg13cmos5l_inv_1_326.Y VGND.t288 VGND.t1150 sg13_lv_nmos ad=80f pd=0.89u as=0.1824p ps=1.21u w=0.64u l=0.13u
X1472 a_6430_8434# a_7501_8440# a_7425_8476# VGND.t1023 sg13_lv_nmos ad=0.2176p pd=1.96u as=0.1216p ps=1.02u w=0.64u l=0.13u
X1473 sg13cmos5l_inv_1_533.Y sg13cmos5l_inv_1_533.A VGND.t263 VGND.t262 sg13_lv_nmos ad=0.2516p pd=2.16u as=0.2516p ps=2.16u w=0.74u l=0.13u
X1474 VGND.t267 sg13cmos5l_inv_1_113.A sg13cmos5l_inv_1_113.Y VGND.t297 sg13_lv_nmos ad=0.2516p pd=2.16u as=0.2516p ps=2.16u w=0.74u l=0.13u
X1475 sg13cmos5l_inv_1_892.Y sg13cmos5l_inv_1_892.A VGND.t92 VGND.t624 sg13_lv_nmos ad=0.2516p pd=2.16u as=0.2516p ps=2.16u w=0.74u l=0.13u
X1476 VPWR.t1138 sg13cmos5l_inv_1_1000.Y sg13cmos5l_inv_1_694.A VPWR.t5 sg13_lv_pmos ad=0.3808p pd=2.92u as=0.3808p ps=2.92u w=1.12u l=0.13u
X1477 VPWR.t329 sg13cmos5l_buf_1_0.A a_18856_1632# VPWR.t11 sg13_lv_pmos ad=0.2114p pd=1.54u as=0.2856p ps=2.36u w=0.84u l=0.13u
X1478 sg13cmos5l_buf_1_2.X a_18664_3144# VPWR.t741 VPWR.t8 sg13_lv_pmos ad=0.42p pd=2.99u as=0.2114p ps=1.54u w=1.12u l=0.13u
X1479 VPWR.t648 sg13cmos5l_inv_1_441.A sg13cmos5l_inv_1_440.A VPWR.t49 sg13_lv_pmos ad=0.3808p pd=2.92u as=0.3808p ps=2.92u w=1.12u l=0.13u
X1480 VGND.t107 sg13cmos5l_inv_1_382.A sg13cmos5l_inv_1_382.Y VGND.t1304 sg13_lv_nmos ad=0.2516p pd=2.16u as=0.2516p ps=2.16u w=0.74u l=0.13u
X1481 sg13cmos5l_inv_1_124.Y sg13cmos5l_inv_1_124.A VGND.t354 VGND.t884 sg13_lv_nmos ad=0.2516p pd=2.16u as=0.2516p ps=2.16u w=0.74u l=0.13u
X1482 a_8086_3534# a_7271_3534# a_8010_3534# VGND.t1282 sg13_lv_nmos ad=0.1776p pd=1.195u as=80f ps=0.89u w=0.64u l=0.13u
X1483 VPWR.t872 sg13cmos5l_inv_1_794.A sg13cmos5l_inv_1_800.A VPWR.t42 sg13_lv_pmos ad=0.3808p pd=2.92u as=0.3808p ps=2.92u w=1.12u l=0.13u
X1484 VGND.t3 VPWR.t1590 VGND.t3 VGND.t1525 sg13_lv_nmos ad=0.1428p pd=1.52u as=0 ps=0 w=0.42u l=1u
X1485 VPWR.t589 sg13cmos5l_inv_1_740.A sg13cmos5l_inv_1_753.A VPWR.t26 sg13_lv_pmos ad=0.3808p pd=2.92u as=0.3808p ps=2.92u w=1.12u l=0.13u
X1486 sg13cmos5l_inv_1_922.A sg13cmos5l_inv_1_494.Y VPWR.t940 VPWR.t5 sg13_lv_pmos ad=0.3808p pd=2.92u as=0.3808p ps=2.92u w=1.12u l=0.13u
X1487 VPWR.t1066 sg13cmos5l_inv_1_152.Y a_16304_7685# VPWR.t14 sg13_lv_pmos ad=0.29275p pd=1.785u as=0.20762p ps=1.605u w=1u l=0.13u
X1488 a_4575_15994# sg13cmos5l_mux4_1_5.S0.t8 a_4438_15994# VGND.t1257 sg13_lv_nmos ad=76.8f pd=0.88u as=0.1776p ps=1.195u w=0.64u l=0.13u
X1489 VGND.t96 VPWR.t1598 VGND.t98 VGND.t1515 sg13_lv_nmos ad=0.1428p pd=1.52u as=0 ps=0 w=0.42u l=1u
X1490 sg13cmos5l_inv_1_761.A sg13cmos5l_inv_1_750.Y VGND.t126 VGND.t264 sg13_lv_nmos ad=0.2516p pd=2.16u as=0.2516p ps=2.16u w=0.74u l=0.13u
X1491 a_15637_8028# sg13cmos5l_buf_1_9.A.t1 a_15275_7644# VPWR.t14 sg13_lv_pmos ad=0.34p pd=2.68u as=0.2225p ps=1.445u w=1u l=0.13u
X1492 VPWR.t941 sg13cmos5l_inv_1_176.A sg13cmos5l_inv_1_177.A VPWR.t14 sg13_lv_pmos ad=0.3808p pd=2.92u as=0.3808p ps=2.92u w=1.12u l=0.13u
X1493 VGND.t430 VPWR.t1545 VGND.t1588 VGND.t1587 sg13_lv_nmos ad=0.1428p pd=1.52u as=0 ps=0 w=0.42u l=1u
X1494 VGND.t414 VPWR.t1571 VGND.t414 VGND.t1553 sg13_lv_nmos ad=0.1428p pd=1.52u as=0 ps=0 w=0.42u l=1u
X1495 VGND.t111 sg13cmos5l_inv_1_245.A sg13cmos5l_inv_1_247.A VGND.t1267 sg13_lv_nmos ad=0.2516p pd=2.16u as=0.2516p ps=2.16u w=0.74u l=0.13u
X1496 VPWR.t467 sg13cmos5l_inv_1_599.Y sg13cmos5l_inv_1_588.A VPWR.t39 sg13_lv_pmos ad=0.3808p pd=2.92u as=0.3808p ps=2.92u w=1.12u l=0.13u
X1497 sg13cmos5l_inv_1_743.Y sg13cmos5l_inv_1_741.Y VPWR.t1124 VPWR.t26 sg13_lv_pmos ad=0.3808p pd=2.92u as=0.3808p ps=2.92u w=1.12u l=0.13u
X1498 VGND.t76 sg13cmos5l_mux2_1_3.S a_9659_7736# VGND.t1042 sg13_lv_nmos ad=0.18945p pd=1.27u as=0.187p ps=1.78u w=0.55u l=0.13u
X1499 sg13cmos5l_inv_1_862.A sg13cmos5l_inv_1_872.A VGND.t35 VGND.t560 sg13_lv_nmos ad=0.2516p pd=2.16u as=0.2516p ps=2.16u w=0.74u l=0.13u
X1500 sg13cmos5l_inv_1_689.A sg13cmos5l_inv_1_563.Y VPWR.t876 VPWR.t21 sg13_lv_pmos ad=0.3808p pd=2.92u as=0.3808p ps=2.92u w=1.12u l=0.13u
X1501 VPWR.t1134 sg13cmos5l_inv_1_716.A sg13cmos5l_inv_1_701.A VPWR.t5 sg13_lv_pmos ad=0.3808p pd=2.92u as=0.3808p ps=2.92u w=1.12u l=0.13u
X1502 VPWR.t768 sg13cmos5l_inv_1_644.A sg13cmos5l_inv_1_692.A VPWR.t21 sg13_lv_pmos ad=0.3808p pd=2.92u as=0.3808p ps=2.92u w=1.12u l=0.13u
X1503 sg13cmos5l_inv_1_480.Y sg13cmos5l_inv_1_480.A VGND.t174 VGND.t937 sg13_lv_nmos ad=0.2516p pd=2.16u as=0.2516p ps=2.16u w=0.74u l=0.13u
X1504 a_14389_11500# a_14827_11673# a_15283_11725# VPWR.t2 sg13_lv_pmos ad=0.19p pd=1.38u as=0.16p ps=1.32u w=1u l=0.13u
X1505 sg13cmos5l_inv_1_39.A sg13cmos5l_inv_1_51.A VGND.t28 VGND.t131 sg13_lv_nmos ad=0.2516p pd=2.16u as=0.2516p ps=2.16u w=0.74u l=0.13u
X1506 sg13cmos5l_inv_1_100.A sg13cmos5l_inv_1_231.Y VGND.t16 VGND.t11 sg13_lv_nmos ad=0.2516p pd=2.16u as=0.2516p ps=2.16u w=0.74u l=0.13u
X1507 a_7508_3534# sg13cmos5l_inv_1_287.A VGND.t43 VGND.t615 sg13_lv_nmos ad=76.8f pd=0.88u as=0.1872p ps=1.225u w=0.64u l=0.13u
X1508 sg13cmos5l_inv_1_144.Y sg13cmos5l_inv_1_181.Y VPWR.t1422 VPWR.t0 sg13_lv_pmos ad=0.3808p pd=2.92u as=0.3808p ps=2.92u w=1.12u l=0.13u
X1509 sg13cmos5l_inv_1_338.Y sg13cmos5l_inv_1_335.Y VGND.t52 VGND.t727 sg13_lv_nmos ad=0.2516p pd=2.16u as=0.2516p ps=2.16u w=0.74u l=0.13u
X1510 sg13cmos5l_inv_1_191.Y sg13cmos5l_inv_1_191.A VGND.t225 VGND.t11 sg13_lv_nmos ad=0.2516p pd=2.16u as=0.2516p ps=2.16u w=0.74u l=0.13u
X1511 VPWR.t1032 sg13cmos5l_inv_1_443.Y sg13cmos5l_inv_1_445.A VPWR.t0 sg13_lv_pmos ad=0.3808p pd=2.92u as=0.3808p ps=2.92u w=1.12u l=0.13u
X1512 VPWR.t873 sg13cmos5l_inv_1_557.Y sg13cmos5l_inv_1_564.A VPWR.t39 sg13_lv_pmos ad=0.3808p pd=2.92u as=0.3808p ps=2.92u w=1.12u l=0.13u
X1513 VGND.t73 VPWR.t1522 VGND.t73 VGND.t1617 sg13_lv_nmos ad=0.1428p pd=1.52u as=0 ps=0 w=0.42u l=1u
X1514 sg13cmos5l_inv_1_335.Y sg13cmos5l_inv_1_324.Y VPWR.t728 VPWR.t8 sg13_lv_pmos ad=0.3808p pd=2.92u as=0.3808p ps=2.92u w=1.12u l=0.13u
X1515 VGND.t16 sg13cmos5l_inv_1_206.A sg13cmos5l_inv_1_206.Y VGND.t11 sg13_lv_nmos ad=0.2516p pd=2.16u as=0.2516p ps=2.16u w=0.74u l=0.13u
X1516 sg13cmos5l_inv_1_407.A sg13cmos5l_inv_1_409.Y VPWR.t561 VPWR.t14 sg13_lv_pmos ad=0.3808p pd=2.92u as=0.3808p ps=2.92u w=1.12u l=0.13u
X1517 VPWR.t300 sg13cmos5l_mux4_1_5.S1.t7 a_7501_8440# VPWR.t29 sg13_lv_pmos ad=0.34367p pd=1.775u as=0.34p ps=2.68u w=1u l=0.13u
X1518 sg13cmos5l_inv_1_594.Y sg13cmos5l_inv_1_595.Y VPWR.t1451 VPWR.t39 sg13_lv_pmos ad=0.3808p pd=2.92u as=0.3808p ps=2.92u w=1.12u l=0.13u
X1519 VPWR.t737 sg13cmos5l_inv_1_328.A sg13cmos5l_inv_1_328.Y VPWR.t8 sg13_lv_pmos ad=0.3808p pd=2.92u as=0.3808p ps=2.92u w=1.12u l=0.13u
X1520 VGND.t133 VPWR.t1587 VGND.t174 VGND.t1532 sg13_lv_nmos ad=79.8f pd=0.8u as=0 ps=0 w=0.42u l=1u
X1521 VPWR.t1370 sg13cmos5l_inv_1_688.A sg13cmos5l_inv_1_562.A VPWR.t39 sg13_lv_pmos ad=0.3808p pd=2.92u as=0.3808p ps=2.92u w=1.12u l=0.13u
X1522 VGND.t214 a_18764_5370# sg13cmos5l_buf_1_6.A VGND.t11 sg13_lv_nmos ad=0.14875p pd=1.16u as=0.2886p ps=2.26u w=0.74u l=0.13u
X1523 VGND.t435 sg13cmos5l_inv_1_216.Y a_14036_3898# VGND.t1395 sg13_lv_nmos ad=0.1824p pd=1.21u as=0.2304p ps=1.36u w=0.64u l=0.13u
X1524 VPWR.t502 sg13cmos5l_inv_1_418.Y sg13cmos5l_inv_1_383.Y VPWR.t0 sg13_lv_pmos ad=0.3808p pd=2.92u as=0.3808p ps=2.92u w=1.12u l=0.13u
X1525 osc_tap[4] a_18280_12216# VGND.t26 VGND.t755 sg13_lv_nmos ad=0.2886p pd=2.26u as=0.14875p ps=1.16u w=0.74u l=0.13u
X1526 VGND.t420 VPWR.t1534 VGND.t420 VGND.t11 sg13_lv_nmos ad=0.1428p pd=1.52u as=0 ps=0 w=0.42u l=1u
X1527 sg13cmos5l_inv_1_834.Y sg13cmos5l_inv_1_843.Y VGND.t37 VGND.t22 sg13_lv_nmos ad=0.2516p pd=2.16u as=0.2516p ps=2.16u w=0.74u l=0.13u
X1528 sg13cmos5l_buf_1_2.X a_18664_3144# VGND.t428 VGND.t647 sg13_lv_nmos ad=0.2886p pd=2.26u as=0.14875p ps=1.16u w=0.74u l=0.13u
X1529 VGND.t1272 sg13cmos5l_inv_1_74.A sg13cmos5l_inv_1_70.A VGND.t1271 sg13_lv_nmos ad=0.2516p pd=2.16u as=0.2516p ps=2.16u w=0.74u l=0.13u
X1530 a_3934_3534# a_3623_3534# a_3860_3534# VGND.t683 sg13_lv_nmos ad=0.1472p pd=1.1u as=76.8f ps=0.88u w=0.64u l=0.13u
X1531 sg13cmos5l_inv_1_277.Y sg13cmos5l_inv_1_277.A VGND.t111 VGND.t817 sg13_lv_nmos ad=0.2516p pd=2.16u as=0.2516p ps=2.16u w=0.74u l=0.13u
X1532 sg13cmos5l_inv_1_185.A sg13cmos5l_inv_1_227.A VGND.t16 VGND.t11 sg13_lv_nmos ad=0.2516p pd=2.16u as=0.2516p ps=2.16u w=0.74u l=0.13u
X1533 sg13cmos5l_inv_1_546.Y sg13cmos5l_inv_1_543.Y VPWR.t283 VPWR.t39 sg13_lv_pmos ad=0.3808p pd=2.92u as=0.3808p ps=2.92u w=1.12u l=0.13u
X1534 VGND.t33 sg13cmos5l_inv_1_68.A sg13cmos5l_inv_1_74.A VGND.t274 sg13_lv_nmos ad=0.2516p pd=2.16u as=0.2516p ps=2.16u w=0.74u l=0.13u
X1535 VGND.t558 sg13cmos5l_inv_1_585.A sg13cmos5l_inv_1_585.Y VGND.t1364 sg13_lv_nmos ad=0.2516p pd=2.16u as=0.2516p ps=2.16u w=0.74u l=0.13u
X1536 a_4912_12970# sg13cmos5l_mux2_1_2.A0 a_4798_12970# VGND.t745 sg13_lv_nmos ad=0.3367p pd=1.65u as=0.1628p ps=1.18u w=0.74u l=0.13u
X1537 VGND.t133 sg13cmos5l_buf_1_9.A.t3 a_7981_12976# VGND.t711 sg13_lv_nmos ad=0.1543p pd=1.18u as=0.2304p ps=2u w=0.64u l=0.13u
X1538 sg13cmos5l_inv_1_277.A sg13cmos5l_inv_1_281.Y VPWR.t410 VPWR.t8 sg13_lv_pmos ad=0.3808p pd=2.92u as=0.3808p ps=2.92u w=1.12u l=0.13u
X1539 VPWR.t1507 sg13cmos5l_inv_1_969.Y sg13cmos5l_inv_1_983.Y VPWR.t29 sg13_lv_pmos ad=0.3808p pd=2.92u as=0.3808p ps=2.92u w=1.12u l=0.13u
X1540 sg13cmos5l_inv_1_19.A sg13cmos5l_inv_1_18.Y VPWR.t1499 VPWR.t11 sg13_lv_pmos ad=0.3808p pd=2.92u as=0.3808p ps=2.92u w=1.12u l=0.13u
X1541 VGND.t33 sg13cmos5l_inv_1_73.A sg13cmos5l_inv_1_68.A VGND.t1464 sg13_lv_nmos ad=0.2516p pd=2.16u as=0.2516p ps=2.16u w=0.74u l=0.13u
X1542 osc_tap[1] a_18280_5444# VGND.t113 VGND.t11 sg13_lv_nmos ad=0.2886p pd=2.26u as=0.14875p ps=1.16u w=0.74u l=0.13u
X1543 a_15275_7644# a_15419_8040# a_15637_8028# VGND.t553 sg13_lv_nmos ad=0.1216p pd=1.02u as=0.2176p ps=1.96u w=0.64u l=0.13u
X1544 VGND.t10 sg13cmos5l_inv_1_931.Y sg13cmos5l_inv_1_933.A VGND.t371 sg13_lv_nmos ad=0.2516p pd=2.16u as=0.2516p ps=2.16u w=0.74u l=0.13u
X1545 VPWR.t220 VGND.t140 VPWR.t219 VPWR.t42 sg13_lv_pmos ad=0.34p pd=2.68u as=0 ps=0 w=1u l=1u
X1546 VPWR.t1268 sg13cmos5l_inv_1_736.Y sg13cmos5l_inv_1_748.A VPWR.t2 sg13_lv_pmos ad=0.3808p pd=2.92u as=0.3808p ps=2.92u w=1.12u l=0.13u
X1547 sg13cmos5l_inv_1_796.Y sg13cmos5l_mux4_1_14.A0 VPWR.t863 VPWR.t42 sg13_lv_pmos ad=0.3808p pd=2.92u as=0.3808p ps=2.92u w=1.12u l=0.13u
X1548 VGND.t396 sg13cmos5l_inv_1_75.A sg13cmos5l_inv_1_75.Y VGND.t409 sg13_lv_nmos ad=0.2516p pd=2.16u as=0.2516p ps=2.16u w=0.74u l=0.13u
X1549 VGND.t117 sg13cmos5l_inv_1_426.A sg13cmos5l_inv_1_425.A VGND.t11 sg13_lv_nmos ad=0.2516p pd=2.16u as=0.2516p ps=2.16u w=0.74u l=0.13u
X1550 VPWR.t945 sg13cmos5l_inv_1_915.A sg13cmos5l_inv_1_912.A VPWR.t26 sg13_lv_pmos ad=0.3808p pd=2.92u as=0.3808p ps=2.92u w=1.12u l=0.13u
X1551 VPWR.t1437 sg13cmos5l_inv_1_112.Y sg13cmos5l_inv_1_978.A VPWR.t29 sg13_lv_pmos ad=0.3808p pd=2.92u as=0.3808p ps=2.92u w=1.12u l=0.13u
X1552 sg13cmos5l_inv_1_982.A sg13cmos5l_inv_1_925.Y VPWR.t1251 VPWR.t5 sg13_lv_pmos ad=0.3808p pd=2.92u as=0.3808p ps=2.92u w=1.12u l=0.13u
X1553 VGND.t21 sg13cmos5l_inv_1_2.Y sg13cmos5l_inv_1_46.A VGND.t586 sg13_lv_nmos ad=0.2516p pd=2.16u as=0.2516p ps=2.16u w=0.74u l=0.13u
X1554 sg13cmos5l_inv_1_298.A sg13cmos5l_inv_1_308.Y VPWR.t143 VPWR.t11 sg13_lv_pmos ad=0.3808p pd=2.92u as=0.3808p ps=2.92u w=1.12u l=0.13u
X1555 sg13cmos5l_inv_1_347.Y sg13cmos5l_inv_1_348.Y VPWR.t1100 VPWR.t0 sg13_lv_pmos ad=0.3808p pd=2.92u as=0.3808p ps=2.92u w=1.12u l=0.13u
X1556 VPWR.t472 sg13cmos5l_inv_1_823.A sg13cmos5l_inv_1_823.Y VPWR.t39 sg13_lv_pmos ad=0.3808p pd=2.92u as=0.3808p ps=2.92u w=1.12u l=0.13u
X1557 sg13cmos5l_inv_1_894.Y sg13cmos5l_inv_1_893.Y VGND.t229 VGND.t689 sg13_lv_nmos ad=0.2516p pd=2.16u as=0.2516p ps=2.16u w=0.74u l=0.13u
X1558 VGND.t612 VPWR.t1574 VGND.t612 VGND.t1550 sg13_lv_nmos ad=0.1428p pd=1.52u as=0 ps=0 w=0.42u l=1u
X1559 sg13cmos5l_inv_1_111.A sg13cmos5l_inv_1_135.Y VPWR.t1202 VPWR.t14 sg13_lv_pmos ad=0.3808p pd=2.92u as=0.3808p ps=2.92u w=1.12u l=0.13u
X1560 sg13cmos5l_inv_1_533.Y sg13cmos5l_inv_1_533.A VPWR.t426 VPWR.t21 sg13_lv_pmos ad=0.3808p pd=2.92u as=0.3808p ps=2.92u w=1.12u l=0.13u
X1561 VPWR.t665 sg13cmos5l_inv_1_90.Y sg13cmos5l_inv_1_89.Y VPWR.t8 sg13_lv_pmos ad=0.3808p pd=2.92u as=0.3808p ps=2.92u w=1.12u l=0.13u
X1562 a_4052_3534# sg13cmos5l_mux4_1_5.S0.t2 a_3934_3534# VGND.t1253 sg13_lv_nmos ad=0.2304p pd=1.36u as=0.1472p ps=1.1u w=0.64u l=0.13u
X1563 VGND.t197 sg13cmos5l_inv_1_790.Y sg13cmos5l_inv_1_773.Y VGND.t22 sg13_lv_nmos ad=0.2516p pd=2.16u as=0.2516p ps=2.16u w=0.74u l=0.13u
X1564 VGND.t197 sg13cmos5l_inv_1_794.A sg13cmos5l_inv_1_800.A VGND.t22 sg13_lv_nmos ad=0.2516p pd=2.16u as=0.2516p ps=2.16u w=0.74u l=0.13u
X1565 sg13cmos5l_inv_1_511.A sg13cmos5l_inv_1_668.Y VPWR.t1143 VPWR.t26 sg13_lv_pmos ad=0.3808p pd=2.92u as=0.3808p ps=2.92u w=1.12u l=0.13u
X1566 sg13cmos5l_inv_1_663.Y sg13cmos5l_inv_1_662.Y VGND.t147 VGND.t1074 sg13_lv_nmos ad=0.2516p pd=2.16u as=0.2516p ps=2.16u w=0.74u l=0.13u
X1567 sg13cmos5l_inv_1_863.A sg13cmos5l_inv_1_865.Y VPWR.t852 VPWR.t42 sg13_lv_pmos ad=0.3808p pd=2.92u as=0.3808p ps=2.92u w=1.12u l=0.13u
X1568 VGND.t133 sg13cmos5l_mux4_1_7.A1 a_7028_12970# VGND.t410 sg13_lv_nmos ad=0.1824p pd=1.21u as=0.2304p ps=1.36u w=0.64u l=0.13u
X1569 sg13cmos5l_inv_1_945.A sg13cmos5l_inv_1_981.Y VPWR.t1287 VPWR.t11 sg13_lv_pmos ad=0.3808p pd=2.92u as=0.3808p ps=2.92u w=1.12u l=0.13u
X1570 VPWR.t67 VGND.t73 VPWR.t66 VPWR.t49 sg13_lv_pmos ad=0.34p pd=2.68u as=0 ps=0 w=1u l=1u
X1571 sg13cmos5l_inv_1_168.A sg13cmos5l_inv_1_165.Y VGND.t360 VGND.t359 sg13_lv_nmos ad=0.2516p pd=2.16u as=0.2516p ps=2.16u w=0.74u l=0.13u
X1572 sg13cmos5l_inv_1_40.Y sg13cmos5l_inv_1_22.Y VPWR.t265 VPWR.t11 sg13_lv_pmos ad=0.3808p pd=2.92u as=0.3808p ps=2.92u w=1.12u l=0.13u
X1573 VPWR.t814 sg13cmos5l_inv_1_582.A a_8309_16307# VPWR.t42 sg13_lv_pmos ad=0.34p pd=2.68u as=0.135p ps=1.27u w=1u l=0.13u
X1574 sg13cmos5l_inv_1_296.A sg13cmos5l_inv_1_295.Y VGND.t246 VGND.t775 sg13_lv_nmos ad=0.2516p pd=2.16u as=0.2516p ps=2.16u w=0.74u l=0.13u
X1575 sg13cmos5l_inv_1_816.A sg13cmos5l_mux4_1_13.A3 VGND.t35 VGND.t560 sg13_lv_nmos ad=0.2516p pd=2.16u as=0.2516p ps=2.16u w=0.74u l=0.13u
X1576 osc_tap[5] a_18856_14516# VPWR.t663 VPWR.t21 sg13_lv_pmos ad=0.42p pd=2.99u as=0.2114p ps=1.54u w=1.12u l=0.13u
X1577 sg13cmos5l_inv_1_928.A sg13cmos5l_inv_1_994.Y VPWR.t929 VPWR.t5 sg13_lv_pmos ad=0.3808p pd=2.92u as=0.3808p ps=2.92u w=1.12u l=0.13u
X1578 VGND.t444 a_14027_11654# sg13cmos5l_or2_1_0.B VGND.t1408 sg13_lv_nmos ad=0.1543p pd=1.18u as=0.2516p ps=2.16u w=0.74u l=0.13u
X1579 VPWR.t126 VGND.t153 VPWR.t125 VPWR.t5 sg13_lv_pmos ad=0.34p pd=2.68u as=0 ps=0 w=1u l=1u
X1580 VPWR.t890 sg13cmos5l_inv_1_37.Y sg13cmos5l_inv_1_28.A VPWR.t49 sg13_lv_pmos ad=0.3808p pd=2.92u as=0.3808p ps=2.92u w=1.12u l=0.13u
X1581 VGND.t194 sg13cmos5l_inv_1_771.A sg13cmos5l_inv_1_771.Y VGND.t841 sg13_lv_nmos ad=0.2516p pd=2.16u as=0.2516p ps=2.16u w=0.74u l=0.13u
X1582 VGND.t56 VPWR.t1614 VGND.t56 VGND.t22 sg13_lv_nmos ad=0.1428p pd=1.52u as=0 ps=0 w=0.42u l=1u
X1583 sg13cmos5l_inv_1_892.Y sg13cmos5l_inv_1_892.A VPWR.t721 VPWR.t26 sg13_lv_pmos ad=0.3808p pd=2.92u as=0.3808p ps=2.92u w=1.12u l=0.13u
X1584 VPWR.t174 VGND.t478 VPWR.t172 VPWR.t26 sg13_lv_pmos ad=0.19p pd=1.38u as=0 ps=0 w=1u l=1u
X1585 VGND.t414 sg13cmos5l_nand2_1_1.B a_9360_11832# VGND.t761 sg13_lv_nmos ad=0.1469p pd=1.155u as=0.1045p ps=0.93u w=0.55u l=0.13u
X1586 sg13cmos5l_inv_1_99.Y sg13cmos5l_inv_1_98.Y VPWR.t1400 VPWR.t8 sg13_lv_pmos ad=0.3808p pd=2.92u as=0.3808p ps=2.92u w=1.12u l=0.13u
X1587 a_14913_3940# sg13cmos5l_mux2_1_4.S.t2 a_14422_3898# VGND.t773 sg13_lv_nmos ad=0.1216p pd=1.02u as=0.54188p ps=3.42u w=0.64u l=0.13u
X1588 sg13cmos5l_inv_1_107.Y sg13cmos5l_inv_1_128.Y VPWR.t349 VPWR.t0 sg13_lv_pmos ad=0.3808p pd=2.92u as=0.3808p ps=2.92u w=1.12u l=0.13u
X1589 VGND.t1274 sg13cmos5l_inv_1_31.A sg13cmos5l_inv_1_31.Y VGND.t1273 sg13_lv_nmos ad=0.2516p pd=2.16u as=0.2516p ps=2.16u w=0.74u l=0.13u
X1590 sg13cmos5l_inv_1_466.Y sg13cmos5l_inv_1_325.Y VGND.t52 VGND.t51 sg13_lv_nmos ad=0.2516p pd=2.16u as=0.2516p ps=2.16u w=0.74u l=0.13u
X1591 VGND.t201 sg13cmos5l_inv_1_237.Y sg13cmos5l_inv_1_248.A VGND.t953 sg13_lv_nmos ad=0.2516p pd=2.16u as=0.2516p ps=2.16u w=0.74u l=0.13u
X1592 osc_tap[7] a_18280_18264# VPWR.t858 VPWR.t39 sg13_lv_pmos ad=0.42p pd=2.99u as=0.2114p ps=1.54u w=1.12u l=0.13u
X1593 a_14538_3534# sg13cmos5l_inv_1_45.Y VGND.t435 VGND.t1355 sg13_lv_nmos ad=80f pd=0.89u as=0.1824p ps=1.21u w=0.64u l=0.13u
X1594 sg13cmos5l_inv_1_58.A sg13cmos5l_inv_1_56.Y VPWR.t1174 VPWR.t11 sg13_lv_pmos ad=0.3808p pd=2.92u as=0.3808p ps=2.92u w=1.12u l=0.13u
X1595 sg13cmos5l_inv_1_461.Y sg13cmos5l_inv_1_460.Y VPWR.t967 VPWR.t0 sg13_lv_pmos ad=0.3808p pd=2.92u as=0.3808p ps=2.92u w=1.12u l=0.13u
X1596 sg13cmos5l_inv_1_370.Y sg13cmos5l_inv_1_370.A VPWR.t504 VPWR.t14 sg13_lv_pmos ad=0.3808p pd=2.92u as=0.3808p ps=2.92u w=1.12u l=0.13u
X1597 sg13cmos5l_inv_1_407.A sg13cmos5l_inv_1_409.Y VGND.t76 VGND.t425 sg13_lv_nmos ad=0.2516p pd=2.16u as=0.2516p ps=2.16u w=0.74u l=0.13u
X1598 a_3934_15994# sg13cmos5l_mux4_1_5.S0.t8 a_3847_16261# VPWR.t42 sg13_lv_pmos ad=0.19p pd=1.38u as=0.415p ps=1.83u w=1u l=0.13u
X1599 VPWR.t1462 sg13cmos5l_inv_1_73.A sg13cmos5l_inv_1_68.A VPWR.t11 sg13_lv_pmos ad=0.3808p pd=2.92u as=0.3808p ps=2.92u w=1.12u l=0.13u
X1600 sg13cmos5l_inv_1_961.Y sg13cmos5l_mux4_1_15.A2 VGND.t10 VGND.t1245 sg13_lv_nmos ad=0.2516p pd=2.16u as=0.2516p ps=2.16u w=0.74u l=0.13u
X1601 a_14645_12221# a_13607_12606# a_14422_12606# VPWR.t2 sg13_lv_pmos ad=0.135p pd=1.27u as=0.4425p ps=1.885u w=1u l=0.13u
X1602 a_4357_3195# sg13cmos5l_inv_1_326.Y VPWR.t1176 VPWR.t8 sg13_lv_pmos ad=0.20762p pd=1.605u as=0.29275p ps=1.785u w=1u l=0.13u
X1603 sg13cmos5l_inv_1_30.Y sg13cmos5l_inv_1_30.A VPWR.t1424 VPWR.t49 sg13_lv_pmos ad=0.3808p pd=2.92u as=0.3808p ps=2.92u w=1.12u l=0.13u
X1604 VPWR.t663 sg13cmos5l_buf_1_17.X a_18856_14516# VPWR.t21 sg13_lv_pmos ad=0.2114p pd=1.54u as=0.2856p ps=2.36u w=0.84u l=0.13u
X1605 sg13cmos5l_inv_1_82.A sg13cmos5l_inv_1_89.Y VPWR.t610 VPWR.t8 sg13_lv_pmos ad=0.3808p pd=2.92u as=0.3808p ps=2.92u w=1.12u l=0.13u
X1606 VGND.t596 sg13cmos5l_inv_1_12.Y sg13cmos5l_inv_1_48.Y VGND.t595 sg13_lv_nmos ad=0.2516p pd=2.16u as=0.2516p ps=2.16u w=0.74u l=0.13u
X1607 VGND.t6 VPWR.t1562 VGND.t902 VGND.t190 sg13_lv_nmos ad=79.8f pd=0.8u as=0 ps=0 w=0.42u l=1u
X1608 sg13cmos5l_inv_1_254.Y sg13cmos5l_inv_1_442.Y VPWR.t414 VPWR.t11 sg13_lv_pmos ad=0.3808p pd=2.92u as=0.3808p ps=2.92u w=1.12u l=0.13u
X1609 VGND.t614 invsel[2] a_808_6956# VGND.t1263 sg13_lv_nmos ad=0.14875p pd=1.16u as=0.187p ps=1.78u w=0.55u l=0.13u
X1610 sg13cmos5l_inv_1_552.Y sg13cmos5l_inv_1_564.Y VPWR.t874 VPWR.t39 sg13_lv_pmos ad=0.3808p pd=2.92u as=0.3808p ps=2.92u w=1.12u l=0.13u
X1611 VGND.t78 VPWR.t1518 VGND.t78 VGND.t1620 sg13_lv_nmos ad=0.1428p pd=1.52u as=0 ps=0 w=0.42u l=1u
X1612 sg13cmos5l_inv_1_396.Y sg13cmos5l_inv_1_391.Y VPWR.t1069 VPWR.t14 sg13_lv_pmos ad=0.3808p pd=2.92u as=0.3808p ps=2.92u w=1.12u l=0.13u
X1613 sg13cmos5l_inv_1_211.Y sg13cmos5l_inv_1_207.Y VGND.t470 VGND.t11 sg13_lv_nmos ad=0.2516p pd=2.16u as=0.2516p ps=2.16u w=0.74u l=0.13u
X1614 VGND.t5 sg13cmos5l_inv_1_990.A sg13cmos5l_inv_1_990.Y VGND.t4 sg13_lv_nmos ad=0.2516p pd=2.16u as=0.2516p ps=2.16u w=0.74u l=0.13u
X1615 VPWR.t510 sg13cmos5l_inv_1_381.Y sg13cmos5l_inv_1_386.Y VPWR.t14 sg13_lv_pmos ad=0.3808p pd=2.92u as=0.3808p ps=2.92u w=1.12u l=0.13u
X1616 VGND.t329 sg13cmos5l_inv_1_672.A sg13cmos5l_inv_1_672.Y VGND.t942 sg13_lv_nmos ad=0.2516p pd=2.16u as=0.2516p ps=2.16u w=0.74u l=0.13u
X1617 VGND.t501 sg13cmos5l_inv_1_247.Y sg13cmos5l_inv_1_306.A VGND.t1469 sg13_lv_nmos ad=0.2516p pd=2.16u as=0.2516p ps=2.16u w=0.74u l=0.13u
X1618 sg13cmos5l_inv_1_284.A sg13cmos5l_inv_1_410.Y VPWR.t1286 VPWR.t49 sg13_lv_pmos ad=0.3808p pd=2.92u as=0.3808p ps=2.92u w=1.12u l=0.13u
X1619 a_10050_10240# sg13cmos5l_nor3_1_1.Y a_9948_10240# VPWR.t5 sg13_lv_pmos ad=0.2128p pd=1.5u as=0.2128p ps=1.5u w=1.12u l=0.13u
X1620 VGND.t440 sg13cmos5l_inv_1_266.Y sg13cmos5l_inv_1_452.Y VGND.t11 sg13_lv_nmos ad=0.2516p pd=2.16u as=0.2516p ps=2.16u w=0.74u l=0.13u
X1621 VPWR.t1113 sg13cmos5l_inv_1_174.A sg13cmos5l_inv_1_149.A VPWR.t14 sg13_lv_pmos ad=0.3808p pd=2.92u as=0.3808p ps=2.92u w=1.12u l=0.13u
X1622 VGND.t1194 sg13cmos5l_inv_1_821.Y sg13cmos5l_inv_1_819.A VGND.t1195 sg13_lv_nmos ad=0.2516p pd=2.16u as=0.2516p ps=2.16u w=0.74u l=0.13u
X1623 a_14422_14482# a_13607_14482# a_14346_14482# VGND.t1084 sg13_lv_nmos ad=0.1776p pd=1.195u as=80f ps=0.89u w=0.64u l=0.13u
X1624 VGND.t329 sg13cmos5l_inv_1_631.A sg13cmos5l_inv_1_631.Y VGND.t765 sg13_lv_nmos ad=0.2516p pd=2.16u as=0.2516p ps=2.16u w=0.74u l=0.13u
X1625 sg13cmos5l_inv_1_367.Y sg13cmos5l_inv_1_347.Y VPWR.t1003 VPWR.t0 sg13_lv_pmos ad=0.3808p pd=2.92u as=0.3808p ps=2.92u w=1.12u l=0.13u
X1626 VPWR.t1500 sg13cmos5l_inv_1_886.Y sg13cmos5l_inv_1_949.Y VPWR.t21 sg13_lv_pmos ad=0.3808p pd=2.92u as=0.3808p ps=2.92u w=1.12u l=0.13u
X1627 VPWR.t1060 sg13cmos5l_inv_1_922.Y sg13cmos5l_inv_1_923.Y VPWR.t5 sg13_lv_pmos ad=0.3808p pd=2.92u as=0.3808p ps=2.92u w=1.12u l=0.13u
X1628 VPWR.t139 sg13cmos5l_inv_1_332.A sg13cmos5l_inv_1_307.A VPWR.t11 sg13_lv_pmos ad=0.3808p pd=2.92u as=0.3808p ps=2.92u w=1.12u l=0.13u
X1629 sg13cmos5l_inv_1_199.Y sg13cmos5l_inv_1_198.Y VGND.t113 VGND.t11 sg13_lv_nmos ad=0.2516p pd=2.16u as=0.2516p ps=2.16u w=0.74u l=0.13u
X1630 VPWR.t394 sg13cmos5l_inv_1_423.A sg13cmos5l_inv_1_422.A VPWR.t49 sg13_lv_pmos ad=0.3808p pd=2.92u as=0.3808p ps=2.92u w=1.12u l=0.13u
X1631 VGND.t143 sg13cmos5l_inv_1_982.A sg13cmos5l_inv_1_970.A VGND.t4 sg13_lv_nmos ad=0.2516p pd=2.16u as=0.2516p ps=2.16u w=0.74u l=0.13u
X1632 VGND.t263 sg13cmos5l_inv_1_576.A a_4052_15994# VGND.t1185 sg13_lv_nmos ad=0.1824p pd=1.21u as=0.2304p ps=1.36u w=0.64u l=0.13u
X1633 sg13cmos5l_inv_1_88.A sg13cmos5l_inv_1_85.Y VGND.t78 VGND.t402 sg13_lv_nmos ad=0.2516p pd=2.16u as=0.2516p ps=2.16u w=0.74u l=0.13u
X1634 sg13cmos5l_inv_1_418.Y sg13cmos5l_inv_1_417.Y VGND.t440 VGND.t11 sg13_lv_nmos ad=0.2516p pd=2.16u as=0.2516p ps=2.16u w=0.74u l=0.13u
X1635 VGND.t69 sg13cmos5l_inv_1_837.Y sg13cmos5l_inv_1_835.A VGND.t68 sg13_lv_nmos ad=0.2516p pd=2.16u as=0.2516p ps=2.16u w=0.74u l=0.13u
X1636 osc_tap[7] a_18280_18264# VGND.t69 VGND.t1334 sg13_lv_nmos ad=0.2886p pd=2.26u as=0.14875p ps=1.16u w=0.74u l=0.13u
X1637 VPWR.t740 sg13cmos5l_inv_1_3.Y sg13cmos5l_inv_1_0.A VPWR.t11 sg13_lv_pmos ad=0.3808p pd=2.92u as=0.3808p ps=2.92u w=1.12u l=0.13u
X1638 VGND.t225 sg13cmos5l_inv_1_448.A sg13cmos5l_inv_1_448.Y VGND.t11 sg13_lv_nmos ad=0.2516p pd=2.16u as=0.2516p ps=2.16u w=0.74u l=0.13u
X1639 VGND.t92 sg13cmos5l_inv_1_911.A sg13cmos5l_inv_1_910.A VGND.t1237 sg13_lv_nmos ad=0.2516p pd=2.16u as=0.2516p ps=2.16u w=0.74u l=0.13u
X1640 sg13cmos5l_inv_1_863.A sg13cmos5l_inv_1_865.Y VGND.t23 VGND.t22 sg13_lv_nmos ad=0.2516p pd=2.16u as=0.2516p ps=2.16u w=0.74u l=0.13u
X1641 sg13cmos5l_inv_1_40.Y sg13cmos5l_inv_1_22.Y VGND.t21 VGND.t20 sg13_lv_nmos ad=0.2516p pd=2.16u as=0.2516p ps=2.16u w=0.74u l=0.13u
X1642 sg13cmos5l_inv_1_815.A sg13cmos5l_inv_1_816.Y VGND.t35 VGND.t34 sg13_lv_nmos ad=0.2516p pd=2.16u as=0.2516p ps=2.16u w=0.74u l=0.13u
X1643 VGND.t352 sg13cmos5l_inv_1_305.A sg13cmos5l_inv_1_305.Y VGND.t1478 sg13_lv_nmos ad=0.2516p pd=2.16u as=0.2516p ps=2.16u w=0.74u l=0.13u
X1644 sg13cmos5l_inv_1_816.A sg13cmos5l_mux4_1_13.A3 VPWR.t669 VPWR.t21 sg13_lv_pmos ad=0.3808p pd=2.92u as=0.3808p ps=2.92u w=1.12u l=0.13u
X1645 sg13cmos5l_inv_1_259.Y sg13cmos5l_inv_1_260.Y VPWR.t411 VPWR.t11 sg13_lv_pmos ad=0.3808p pd=2.92u as=0.3808p ps=2.92u w=1.12u l=0.13u
X1646 a_8086_3534# sg13cmos5l_mux4_1_5.S0.t1 a_8005_3195# VPWR.t8 sg13_lv_pmos ad=0.4425p pd=1.885u as=0.20762p ps=1.605u w=1u l=0.13u
X1647 VGND.t113 sg13cmos5l_inv_1_25.Y sg13cmos5l_inv_1_187.A VGND.t11 sg13_lv_nmos ad=0.2516p pd=2.16u as=0.2516p ps=2.16u w=0.74u l=0.13u
X1648 a_4929_8028# sg13cmos5l_mux4_1_5.S1.t6 a_3934_8070# VPWR.t14 sg13_lv_pmos ad=0.2225p pd=1.445u as=0.34p ps=2.68u w=1u l=0.13u
X1649 a_4438_15994# sg13cmos5l_mux4_1_5.S0.t8 a_4357_16261# VPWR.t42 sg13_lv_pmos ad=0.4425p pd=1.885u as=0.20762p ps=1.605u w=1u l=0.13u
X1650 sg13cmos5l_inv_1_894.Y sg13cmos5l_inv_1_893.Y VPWR.t773 VPWR.t26 sg13_lv_pmos ad=0.3808p pd=2.92u as=0.3808p ps=2.92u w=1.12u l=0.13u
X1651 a_4357_12267# sg13cmos5l_inv_1_523.Y VPWR.t964 VPWR.t2 sg13_lv_pmos ad=0.20762p pd=1.605u as=0.29275p ps=1.785u w=1u l=0.13u
X1652 VGND.t508 sg13cmos5l_inv_1_922.Y sg13cmos5l_inv_1_923.Y VGND.t190 sg13_lv_nmos ad=0.2516p pd=2.16u as=0.2516p ps=2.16u w=0.74u l=0.13u
X1653 VPWR.t974 sg13cmos5l_inv_1_130.A sg13cmos5l_inv_1_130.Y VPWR.t14 sg13_lv_pmos ad=0.3808p pd=2.92u as=0.3808p ps=2.92u w=1.12u l=0.13u
X1654 sg13cmos5l_inv_1_584.A sg13cmos5l_inv_1_626.Y VGND.t56 VGND.t22 sg13_lv_nmos ad=0.2516p pd=2.16u as=0.2516p ps=2.16u w=0.74u l=0.13u
X1655 VGND.t174 sg13cmos5l_inv_1_749.A sg13cmos5l_inv_1_759.A VGND.t173 sg13_lv_nmos ad=0.2516p pd=2.16u as=0.2516p ps=2.16u w=0.74u l=0.13u
X1656 sg13cmos5l_inv_1_645.A sg13cmos5l_inv_1_684.Y VGND.t329 VGND.t839 sg13_lv_nmos ad=0.2516p pd=2.16u as=0.2516p ps=2.16u w=0.74u l=0.13u
X1657 a_13918_14482# a_14989_14488# a_14913_14524# VGND.t1099 sg13_lv_nmos ad=0.2176p pd=1.96u as=0.1216p ps=1.02u w=0.64u l=0.13u
X1658 sg13cmos5l_inv_1_876.A sg13cmos5l_inv_1_873.A VGND.t229 VGND.t461 sg13_lv_nmos ad=0.2516p pd=2.16u as=0.2516p ps=2.16u w=0.74u l=0.13u
X1659 VGND.t41 VPWR.t1569 VGND.t41 VGND.t1551 sg13_lv_nmos ad=0.1428p pd=1.52u as=0 ps=0 w=0.42u l=1u
X1660 a_15768_4088# sg13cmos5l_buf_1_8.A.t1 VPWR.t1433 VPWR.t49 sg13_lv_pmos ad=0.2856p pd=2.36u as=0.253p ps=1.53u w=0.84u l=0.13u
X1661 sg13cmos5l_inv_1_105.A sg13cmos5l_inv_1_215.Y VGND.t1 VGND.t397 sg13_lv_nmos ad=0.2516p pd=2.16u as=0.2516p ps=2.16u w=0.74u l=0.13u
X1662 sg13cmos5l_inv_1_619.A sg13cmos5l_inv_1_622.Y VPWR.t385 VPWR.t42 sg13_lv_pmos ad=0.3808p pd=2.92u as=0.3808p ps=2.92u w=1.12u l=0.13u
X1663 sg13cmos5l_inv_1_889.Y sg13cmos5l_inv_1_889.A VGND.t92 VGND.t944 sg13_lv_nmos ad=0.2516p pd=2.16u as=0.2516p ps=2.16u w=0.74u l=0.13u
X1664 a_14036_14482# sg13cmos5l_buf_1_9.A.t4 a_13918_14482# VGND.t636 sg13_lv_nmos ad=0.2304p pd=1.36u as=0.1472p ps=1.1u w=0.64u l=0.13u
X1665 VPWR.t714 sg13cmos5l_mux4_1_5.S0.t1 a_7271_3534# VPWR.t8 sg13_lv_pmos ad=0.22315p pd=1.555u as=0.34p ps=2.68u w=1u l=0.13u
X1666 VPWR.t716 sg13cmos5l_inv_1_337.Y sg13cmos5l_inv_1_316.A VPWR.t49 sg13_lv_pmos ad=0.3808p pd=2.92u as=0.3808p ps=2.92u w=1.12u l=0.13u
X1667 VGND.t267 VPWR.t1547 VGND.t267 VGND.t1585 sg13_lv_nmos ad=0.1428p pd=1.52u as=0 ps=0 w=0.42u l=1u
X1668 VPWR.t138 VGND.t430 VPWR.t137 VPWR.t0 sg13_lv_pmos ad=0.34p pd=2.68u as=0 ps=0 w=1u l=1u
X1669 sg13cmos5l_inv_1_663.Y sg13cmos5l_inv_1_662.Y VPWR.t1111 VPWR.t5 sg13_lv_pmos ad=0.3808p pd=2.92u as=0.3808p ps=2.92u w=1.12u l=0.13u
X1670 VGND.t153 VPWR.t1565 VGND.t153 VGND.t190 sg13_lv_nmos ad=0.1428p pd=1.52u as=0 ps=0 w=0.42u l=1u
X1671 sg13cmos5l_inv_1_370.Y sg13cmos5l_inv_1_370.A VGND.t15 VGND.t358 sg13_lv_nmos ad=0.2516p pd=2.16u as=0.2516p ps=2.16u w=0.74u l=0.13u
X1672 sg13cmos5l_inv_1_961.Y sg13cmos5l_mux4_1_15.A2 VPWR.t1267 VPWR.t29 sg13_lv_pmos ad=0.3808p pd=2.92u as=0.3808p ps=2.92u w=1.12u l=0.13u
X1673 sg13cmos5l_inv_1_980.A sg13cmos5l_inv_1_923.Y VGND.t508 VGND.t190 sg13_lv_nmos ad=0.2516p pd=2.16u as=0.2516p ps=2.16u w=0.74u l=0.13u
X1674 sg13cmos5l_inv_1_598.A sg13cmos5l_inv_1_602.Y VGND.t325 VGND.t324 sg13_lv_nmos ad=0.2516p pd=2.16u as=0.2516p ps=2.16u w=0.74u l=0.13u
X1675 a_8005_3195# sg13cmos5l_inv_1_258.A VPWR.t318 VPWR.t8 sg13_lv_pmos ad=0.20762p pd=1.605u as=0.29275p ps=1.785u w=1u l=0.13u
X1676 sg13cmos5l_inv_1_157.Y sg13cmos5l_inv_1_156.Y VGND.t128 VGND.t1090 sg13_lv_nmos ad=0.2516p pd=2.16u as=0.2516p ps=2.16u w=0.74u l=0.13u
X1677 a_14228_3534# sg13cmos5l_mux4_1_5.S1.t1 a_14110_3534# VGND.t79 sg13_lv_nmos ad=0.2304p pd=1.36u as=0.1472p ps=1.1u w=0.64u l=0.13u
X1678 sg13cmos5l_inv_1_156.Y sg13cmos5l_inv_1_155.Y VPWR.t1059 VPWR.t29 sg13_lv_pmos ad=0.3808p pd=2.92u as=0.3808p ps=2.92u w=1.12u l=0.13u
X1679 VGND.t267 VPWR.t1553 VGND.t267 VGND.t1579 sg13_lv_nmos ad=0.1428p pd=1.52u as=0 ps=0 w=0.42u l=1u
X1680 VPWR.t783 invsel[1] a_808_4656# VPWR.t49 sg13_lv_pmos ad=0.2114p pd=1.54u as=0.2856p ps=2.36u w=0.84u l=0.13u
X1681 VPWR.t975 sg13cmos5l_inv_1_115.A sg13cmos5l_inv_1_115.Y VPWR.t29 sg13_lv_pmos ad=0.3808p pd=2.92u as=0.3808p ps=2.92u w=1.12u l=0.13u
X1682 VGND.t64 sg13cmos5l_buf_1_0.A a_18856_1632# VGND.t124 sg13_lv_nmos ad=0.14875p pd=1.16u as=0.187p ps=1.78u w=0.55u l=0.13u
X1683 VGND.t248 sg13cmos5l_inv_1_320.Y sg13cmos5l_inv_1_314.Y VGND.t247 sg13_lv_nmos ad=0.2516p pd=2.16u as=0.2516p ps=2.16u w=0.74u l=0.13u
X1684 VPWR.t1375 sg13cmos5l_inv_1_637.A sg13cmos5l_inv_1_636.A VPWR.t21 sg13_lv_pmos ad=0.3808p pd=2.92u as=0.3808p ps=2.92u w=1.12u l=0.13u
X1685 VPWR.t664 sg13cmos5l_inv_1_990.A sg13cmos5l_inv_1_990.Y VPWR.t29 sg13_lv_pmos ad=0.3808p pd=2.92u as=0.3808p ps=2.92u w=1.12u l=0.13u
X1686 VPWR.t867 enable a_808_18264# VPWR.t39 sg13_lv_pmos ad=0.2114p pd=1.54u as=0.2856p ps=2.36u w=0.84u l=0.13u
X1687 VGND.t15 sg13cmos5l_mux4_1_6.A2 sg13cmos5l_inv_1_351.A VGND.t1403 sg13_lv_nmos ad=0.2516p pd=2.16u as=0.2516p ps=2.16u w=0.74u l=0.13u
X1688 VGND.t10 sg13cmos5l_inv_1_929.A sg13cmos5l_inv_1_988.A VGND.t13 sg13_lv_nmos ad=0.2516p pd=2.16u as=0.2516p ps=2.16u w=0.74u l=0.13u
X1689 VGND.t44 sg13cmos5l_inv_1_592.A sg13cmos5l_inv_1_592.Y VGND.t22 sg13_lv_nmos ad=0.2516p pd=2.16u as=0.2516p ps=2.16u w=0.74u l=0.13u
X1690 sg13cmos5l_inv_1_699.A sg13cmos5l_inv_1_704.Y VGND.t184 VGND.t626 sg13_lv_nmos ad=0.2516p pd=2.16u as=0.2516p ps=2.16u w=0.74u l=0.13u
X1691 a_8223_3534# sg13cmos5l_mux4_1_5.S0.t1 a_8086_3534# VGND.t1260 sg13_lv_nmos ad=76.8f pd=0.88u as=0.1776p ps=1.195u w=0.64u l=0.13u
X1692 VGND.t12 sg13cmos5l_inv_1_420.A sg13cmos5l_inv_1_334.A VGND.t11 sg13_lv_nmos ad=0.2516p pd=2.16u as=0.2516p ps=2.16u w=0.74u l=0.13u
X1693 VPWR.t1014 sg13cmos5l_inv_1_351.A sg13cmos5l_inv_1_351.Y VPWR.t29 sg13_lv_pmos ad=0.3808p pd=2.92u as=0.3808p ps=2.92u w=1.12u l=0.13u
X1694 VPWR.t1510 sg13cmos5l_inv_1_140.A sg13cmos5l_inv_1_140.Y VPWR.t14 sg13_lv_pmos ad=0.3808p pd=2.92u as=0.3808p ps=2.92u w=1.12u l=0.13u
X1695 VGND.t149 sg13cmos5l_inv_1_166.Y sg13cmos5l_inv_1_986.Y VGND.t1110 sg13_lv_nmos ad=0.2516p pd=2.16u as=0.2516p ps=2.16u w=0.74u l=0.13u
X1696 VGND.t1194 sg13cmos5l_inv_1_820.A sg13cmos5l_inv_1_821.A VGND.t1462 sg13_lv_nmos ad=0.2516p pd=2.16u as=0.2516p ps=2.16u w=0.74u l=0.13u
X1697 sg13cmos5l_inv_1_137.A sg13cmos5l_inv_1_105.Y VPWR.t832 VPWR.t14 sg13_lv_pmos ad=0.3808p pd=2.92u as=0.3808p ps=2.92u w=1.12u l=0.13u
X1698 VGND.t229 sg13cmos5l_inv_1_876.A sg13cmos5l_inv_1_876.Y VGND.t234 sg13_lv_nmos ad=0.2516p pd=2.16u as=0.2516p ps=2.16u w=0.74u l=0.13u
X1699 VPWR.t822 sg13cmos5l_inv_1_532.A sg13cmos5l_inv_1_532.Y VPWR.t2 sg13_lv_pmos ad=0.3808p pd=2.92u as=0.3808p ps=2.92u w=1.12u l=0.13u
X1700 sg13cmos5l_inv_1_19.A sg13cmos5l_inv_1_18.Y VGND.t256 VGND.t1646 sg13_lv_nmos ad=0.2516p pd=2.16u as=0.2516p ps=2.16u w=0.74u l=0.13u
X1701 VPWR.t412 sg13cmos5l_inv_1_75.Y sg13cmos5l_inv_1_271.A VPWR.t49 sg13_lv_pmos ad=0.3808p pd=2.92u as=0.3808p ps=2.92u w=1.12u l=0.13u
X1702 sg13cmos5l_inv_1_891.Y sg13cmos5l_inv_1_895.Y VGND.t229 VGND.t378 sg13_lv_nmos ad=0.2516p pd=2.16u as=0.2516p ps=2.16u w=0.74u l=0.13u
X1703 sg13cmos5l_inv_1_85.A sg13cmos5l_inv_1_82.Y VGND.t78 VGND.t402 sg13_lv_nmos ad=0.2516p pd=2.16u as=0.2516p ps=2.16u w=0.74u l=0.13u
X1704 sg13cmos5l_inv_1_43.Y sg13cmos5l_inv_1_40.Y VGND.t1203 VGND.t1202 sg13_lv_nmos ad=0.2516p pd=2.16u as=0.2516p ps=2.16u w=0.74u l=0.13u
X1705 sg13cmos5l_inv_1_431.A sg13cmos5l_inv_1_362.Y VPWR.t653 VPWR.t14 sg13_lv_pmos ad=0.3808p pd=2.92u as=0.3808p ps=2.92u w=1.12u l=0.13u
X1706 sg13cmos5l_inv_1_724.Y sg13cmos5l_mux4_1_12.A1 VGND.t155 VGND.t518 sg13_lv_nmos ad=0.2516p pd=2.16u as=0.2516p ps=2.16u w=0.74u l=0.13u
X1707 sg13cmos5l_nor3_1_1.Y sg13cmos5l_mux2_1_1.X a_8919_10240# VPWR.t5 sg13_lv_pmos ad=0.3808p pd=2.92u as=0.2128p ps=1.5u w=1.12u l=0.13u
X1708 VPWR.t977 sg13cmos5l_inv_1_982.A sg13cmos5l_inv_1_970.A VPWR.t29 sg13_lv_pmos ad=0.3808p pd=2.92u as=0.3808p ps=2.92u w=1.12u l=0.13u
X1709 sg13cmos5l_inv_1_962.Y sg13cmos5l_inv_1_985.Y VGND.t153 VGND.t4 sg13_lv_nmos ad=0.2516p pd=2.16u as=0.2516p ps=2.16u w=0.74u l=0.13u
X1710 VPWR.t998 sg13cmos5l_inv_1_672.A sg13cmos5l_inv_1_672.Y VPWR.t26 sg13_lv_pmos ad=0.3808p pd=2.92u as=0.3808p ps=2.92u w=1.12u l=0.13u
X1711 sg13cmos5l_inv_1_643.A sg13cmos5l_inv_1_642.Y VGND.t46 VGND.t731 sg13_lv_nmos ad=0.2516p pd=2.16u as=0.2516p ps=2.16u w=0.74u l=0.13u
X1712 sg13cmos5l_inv_1_826.Y sg13cmos5l_inv_1_819.Y VGND.t1194 VGND.t1218 sg13_lv_nmos ad=0.2516p pd=2.16u as=0.2516p ps=2.16u w=0.74u l=0.13u
X1713 VPWR.t1407 sg13cmos5l_inv_1_752.A sg13cmos5l_inv_1_751.A VPWR.t2 sg13_lv_pmos ad=0.3808p pd=2.92u as=0.3808p ps=2.92u w=1.12u l=0.13u
X1714 sg13cmos5l_inv_1_475.Y sg13cmos5l_inv_1_473.Y VGND.t199 VGND.t205 sg13_lv_nmos ad=0.2516p pd=2.16u as=0.2516p ps=2.16u w=0.74u l=0.13u
X1715 sg13cmos5l_inv_1_510.Y sg13cmos5l_inv_1_510.A VPWR.t529 VPWR.t26 sg13_lv_pmos ad=0.3808p pd=2.92u as=0.3808p ps=2.92u w=1.12u l=0.13u
X1716 VPWR.t27 VGND.t1528 VPWR.t32 VPWR.t26 sg13_lv_pmos ad=0.34p pd=2.68u as=0 ps=0 w=1u l=1u
X1717 sg13cmos5l_a21oi_1_1.A1 sg13cmos5l_mux2_1_3.S a_8810_10704# VPWR.t5 sg13_lv_pmos ad=0.3808p pd=2.92u as=0.1176p ps=1.33u w=1.12u l=0.13u
X1718 VGND.t64 sg13cmos5l_inv_1_37.A sg13cmos5l_inv_1_37.Y VGND.t1653 sg13_lv_nmos ad=0.2516p pd=2.16u as=0.2516p ps=2.16u w=0.74u l=0.13u
X1719 a_14494_9582# sg13cmos5l_mux4_1_5.S1.t8 a_14407_9243# VPWR.t29 sg13_lv_pmos ad=0.19p pd=1.38u as=0.415p ps=1.83u w=1u l=0.13u
X1720 a_13918_12606# a_13607_12606# a_13844_12606# VGND.t451 sg13_lv_nmos ad=0.1472p pd=1.1u as=76.8f ps=0.88u w=0.64u l=0.13u
X1721 sg13cmos5l_inv_1_520.A sg13cmos5l_inv_1_500.Y VGND.t147 VGND.t898 sg13_lv_nmos ad=0.2516p pd=2.16u as=0.2516p ps=2.16u w=0.74u l=0.13u
X1722 VGND.t514 sg13cmos5l_inv_1_114.A sg13cmos5l_inv_1_114.Y VGND.t513 sg13_lv_nmos ad=0.2516p pd=2.16u as=0.2516p ps=2.16u w=0.74u l=0.13u
X1723 sg13cmos5l_inv_1_815.A sg13cmos5l_inv_1_816.Y VPWR.t274 VPWR.t21 sg13_lv_pmos ad=0.3808p pd=2.92u as=0.3808p ps=2.92u w=1.12u l=0.13u
X1724 sg13cmos5l_inv_1_258.A sg13cmos5l_inv_1_249.Y VPWR.t411 VPWR.t11 sg13_lv_pmos ad=0.3808p pd=2.92u as=0.3808p ps=2.92u w=1.12u l=0.13u
X1725 sg13cmos5l_inv_1_202.Y sg13cmos5l_inv_1_116.Y VGND.t165 VGND.t1059 sg13_lv_nmos ad=0.2516p pd=2.16u as=0.2516p ps=2.16u w=0.74u l=0.13u
X1726 VGND.t102 a_4475_13008# a_4912_12970# VGND.t1007 sg13_lv_nmos ad=0.148p pd=1.14u as=0.3367p ps=1.65u w=0.74u l=0.13u
X1727 sg13cmos5l_inv_1_259.Y sg13cmos5l_inv_1_260.Y VGND.t501 VGND.t1465 sg13_lv_nmos ad=0.2516p pd=2.16u as=0.2516p ps=2.16u w=0.74u l=0.13u
X1728 VGND.t440 sg13cmos5l_inv_1_433.A sg13cmos5l_inv_1_433.Y VGND.t11 sg13_lv_nmos ad=0.2516p pd=2.16u as=0.2516p ps=2.16u w=0.74u l=0.13u
X1729 sg13cmos5l_inv_1_116.Y sg13cmos5l_inv_1_115.Y VPWR.t921 VPWR.t29 sg13_lv_pmos ad=0.3808p pd=2.92u as=0.3808p ps=2.92u w=1.12u l=0.13u
X1730 VGND.t267 sg13cmos5l_inv_1_112.A sg13cmos5l_inv_1_112.Y VGND.t823 sg13_lv_nmos ad=0.2516p pd=2.16u as=0.2516p ps=2.16u w=0.74u l=0.13u
X1731 VPWR.t102 VGND.t207 VPWR.t144 VPWR.t21 sg13_lv_pmos ad=0.34p pd=2.68u as=0 ps=0 w=1u l=1u
X1732 sg13cmos5l_inv_1_1009.Y sg13cmos5l_inv_1_1012.Y VPWR.t1220 VPWR.t5 sg13_lv_pmos ad=0.3808p pd=2.92u as=0.3808p ps=2.92u w=1.12u l=0.13u
X1733 VGND.t107 sg13cmos5l_inv_1_389.A sg13cmos5l_inv_1_389.Y VGND.t1077 sg13_lv_nmos ad=0.2516p pd=2.16u as=0.2516p ps=2.16u w=0.74u l=0.13u
X1734 VPWR.t334 sg13cmos5l_inv_1_415.A sg13cmos5l_inv_1_416.A VPWR.t49 sg13_lv_pmos ad=0.3808p pd=2.92u as=0.3808p ps=2.92u w=1.12u l=0.13u
X1735 VPWR.t453 sg13cmos5l_inv_1_113.A sg13cmos5l_inv_1_113.Y VPWR.t29 sg13_lv_pmos ad=0.3808p pd=2.92u as=0.3808p ps=2.92u w=1.12u l=0.13u
X1736 a_9260_9906# sg13cmos5l_buf_1_12.X VPWR.t383 VPWR.t5 sg13_lv_pmos ad=0.2856p pd=2.36u as=0.2114p ps=1.54u w=0.84u l=0.13u
X1737 VGND.t478 sg13cmos5l_inv_1_745.A sg13cmos5l_mux4_1_12.A3 VGND.t767 sg13_lv_nmos ad=0.2516p pd=2.16u as=0.2516p ps=2.16u w=0.74u l=0.13u
X1738 sg13cmos5l_inv_1_195.Y sg13cmos5l_inv_1_205.Y VGND.t113 VGND.t11 sg13_lv_nmos ad=0.2516p pd=2.16u as=0.2516p ps=2.16u w=0.74u l=0.13u
X1739 VGND.t212 sg13cmos5l_inv_1_218.A sg13cmos5l_inv_1_110.A VGND.t11 sg13_lv_nmos ad=0.2516p pd=2.16u as=0.2516p ps=2.16u w=0.74u l=0.13u
X1740 VGND.t807 enable a_808_18264# VGND.t1484 sg13_lv_nmos ad=0.14875p pd=1.16u as=0.187p ps=1.78u w=0.55u l=0.13u
X1741 VGND.t133 sg13cmos5l_mux4_1_7.A3 a_7551_12970# VGND.t511 sg13_lv_nmos ad=0.2176p pd=1.96u as=76.8f ps=0.88u w=0.64u l=0.13u
X1742 VGND.t128 sg13cmos5l_mux4_1_0.A0 a_16828_8070# VGND.t127 sg13_lv_nmos ad=0.1872p pd=1.225u as=76.8f ps=0.88u w=0.64u l=0.13u
X1743 VPWR.t1259 sg13cmos5l_inv_1_911.A sg13cmos5l_inv_1_910.A VPWR.t26 sg13_lv_pmos ad=0.3808p pd=2.92u as=0.3808p ps=2.92u w=1.12u l=0.13u
X1744 sg13cmos5l_inv_1_249.Y sg13cmos5l_inv_1_273.Y VGND.t240 VGND.t239 sg13_lv_nmos ad=0.2516p pd=2.16u as=0.2516p ps=2.16u w=0.74u l=0.13u
X1745 sg13cmos5l_inv_1_337.Y sg13cmos5l_inv_1_337.A VGND.t54 VGND.t897 sg13_lv_nmos ad=0.2516p pd=2.16u as=0.2516p ps=2.16u w=0.74u l=0.13u
X1746 VGND.t76 sg13cmos5l_mux4_1_5.S1.t7 a_7501_8440# VGND.t75 sg13_lv_nmos ad=0.1543p pd=1.18u as=0.2304p ps=2u w=0.64u l=0.13u
X1747 VGND.t197 VPWR.t1613 VGND.t197 VGND.t22 sg13_lv_nmos ad=79.8f pd=0.8u as=0 ps=0 w=0.42u l=1u
X1748 sg13cmos5l_inv_1_459.Y sg13cmos5l_inv_1_459.A VGND.t440 VGND.t11 sg13_lv_nmos ad=0.2516p pd=2.16u as=0.2516p ps=2.16u w=0.74u l=0.13u
X1749 sg13cmos5l_inv_1_761.A sg13cmos5l_inv_1_750.Y VPWR.t427 VPWR.t2 sg13_lv_pmos ad=0.3808p pd=2.92u as=0.3808p ps=2.92u w=1.12u l=0.13u
X1750 sg13cmos5l_nor4_1_0.Y sg13cmos5l_nor4_1_0.A VGND.t191 VGND.t190 sg13_lv_nmos ad=0.1406p pd=1.12u as=0.2516p ps=2.16u w=0.74u l=0.13u
X1751 sg13cmos5l_inv_1_294.Y sg13cmos5l_inv_1_296.Y VPWR.t143 VPWR.t11 sg13_lv_pmos ad=0.3808p pd=2.92u as=0.3808p ps=2.92u w=1.12u l=0.13u
X1752 VGND.t16 sg13cmos5l_inv_1_225.A sg13cmos5l_inv_1_225.Y VGND.t11 sg13_lv_nmos ad=0.2516p pd=2.16u as=0.2516p ps=2.16u w=0.74u l=0.13u
X1753 a_6934_8434# sg13cmos5l_mux4_1_5.S0.t5 a_6853_8701# VPWR.t29 sg13_lv_pmos ad=0.4425p pd=1.885u as=0.20762p ps=1.605u w=1u l=0.13u
X1754 sg13cmos5l_inv_1_889.Y sg13cmos5l_inv_1_889.A VPWR.t1000 VPWR.t26 sg13_lv_pmos ad=0.3808p pd=2.92u as=0.3808p ps=2.92u w=1.12u l=0.13u
X1755 VPWR.t7 VGND.t1546 VPWR.t6 VPWR.t5 sg13_lv_pmos ad=0.34p pd=2.68u as=0 ps=0 w=1u l=1u
X1756 sg13cmos5l_inv_1_608.A sg13cmos5l_inv_1_606.Y VPWR.t528 VPWR.t39 sg13_lv_pmos ad=0.3808p pd=2.92u as=0.3808p ps=2.92u w=1.12u l=0.13u
X1757 VGND.t56 sg13cmos5l_inv_1_612.Y sg13cmos5l_inv_1_599.Y VGND.t22 sg13_lv_nmos ad=0.2516p pd=2.16u as=0.2516p ps=2.16u w=0.74u l=0.13u
X1758 sg13cmos5l_inv_1_479.Y sg13cmos5l_inv_1_478.Y VPWR.t1077 VPWR.t26 sg13_lv_pmos ad=0.3808p pd=2.92u as=0.3808p ps=2.92u w=1.12u l=0.13u
X1759 sg13cmos5l_inv_1_145.Y sg13cmos5l_inv_1_144.Y VPWR.t1350 VPWR.t0 sg13_lv_pmos ad=0.3808p pd=2.92u as=0.3808p ps=2.92u w=1.12u l=0.13u
X1760 VGND.t342 sg13cmos5l_inv_1_366.A sg13cmos5l_inv_1_366.Y VGND.t389 sg13_lv_nmos ad=0.2516p pd=2.16u as=0.2516p ps=2.16u w=0.74u l=0.13u
X1761 sg13cmos5l_inv_1_363.Y sg13cmos5l_inv_1_375.Y VPWR.t577 VPWR.t14 sg13_lv_pmos ad=0.3808p pd=2.92u as=0.3808p ps=2.92u w=1.12u l=0.13u
X1762 sg13cmos5l_inv_1_192.Y sg13cmos5l_inv_1_191.Y VGND.t849 VGND.t11 sg13_lv_nmos ad=0.2516p pd=2.16u as=0.2516p ps=2.16u w=0.74u l=0.13u
X1763 VGND.t29 sg13cmos5l_inv_1_545.A sg13cmos5l_inv_1_545.Y VGND.t22 sg13_lv_nmos ad=0.2516p pd=2.16u as=0.2516p ps=2.16u w=0.74u l=0.13u
X1764 VPWR.t857 sg13cmos5l_inv_1_448.Y sg13cmos5l_inv_1_443.Y VPWR.t0 sg13_lv_pmos ad=0.3808p pd=2.92u as=0.3808p ps=2.92u w=1.12u l=0.13u
X1765 VPWR.t1403 sg13cmos5l_inv_1_149.A sg13cmos5l_inv_1_149.Y VPWR.t0 sg13_lv_pmos ad=0.3808p pd=2.92u as=0.3808p ps=2.92u w=1.12u l=0.13u
X1766 VGND.t171 sg13cmos5l_mux4_1_13.A3 a_14847_15630# VGND.t561 sg13_lv_nmos ad=0.2176p pd=1.96u as=76.8f ps=0.88u w=0.64u l=0.13u
X1767 VPWR.t1030 sg13cmos5l_mux4_1_12.A3 a_14645_12221# VPWR.t2 sg13_lv_pmos ad=0.34p pd=2.68u as=0.135p ps=1.27u w=1u l=0.13u
X1768 sg13cmos5l_inv_1_338.Y sg13cmos5l_inv_1_335.Y VPWR.t803 VPWR.t8 sg13_lv_pmos ad=0.3808p pd=2.92u as=0.3808p ps=2.92u w=1.12u l=0.13u
X1769 VPWR.t742 sg13cmos5l_mux4_1_5.S1.t3 a_5005_3418# VPWR.t8 sg13_lv_pmos ad=0.34367p pd=1.775u as=0.34p ps=2.68u w=1u l=0.13u
X1770 VPWR.t1139 sg13cmos5l_inv_1_166.Y sg13cmos5l_inv_1_986.Y VPWR.t29 sg13_lv_pmos ad=0.3808p pd=2.92u as=0.3808p ps=2.92u w=1.12u l=0.13u
X1771 sg13cmos5l_inv_1_260.A sg13cmos5l_inv_1_250.Y VGND.t240 VGND.t531 sg13_lv_nmos ad=0.2516p pd=2.16u as=0.2516p ps=2.16u w=0.74u l=0.13u
X1772 VGND.t116 sg13cmos5l_inv_1_825.A sg13cmos5l_inv_1_827.A VGND.t22 sg13_lv_nmos ad=0.2516p pd=2.16u as=0.2516p ps=2.16u w=0.74u l=0.13u
X1773 a_8010_15994# sg13cmos5l_mux4_1_8.A2 VGND.t46 VGND.t45 sg13_lv_nmos ad=80f pd=0.89u as=0.1824p ps=1.21u w=0.64u l=0.13u
X1774 sg13cmos5l_inv_1_887.Y sg13cmos5l_inv_1_896.Y VGND.t229 VGND.t385 sg13_lv_nmos ad=0.2516p pd=2.16u as=0.2516p ps=2.16u w=0.74u l=0.13u
X1775 VPWR.t1078 sg13cmos5l_inv_1_972.Y sg13cmos5l_inv_1_924.Y VPWR.t5 sg13_lv_pmos ad=0.3808p pd=2.92u as=0.3808p ps=2.92u w=1.12u l=0.13u
X1776 sg13cmos5l_a22oi_1_0.B1 a_4798_12970# VPWR.t886 VPWR.t26 sg13_lv_pmos ad=0.6048p pd=3.32u as=0.2198p ps=1.52u w=1.12u l=0.13u
X1777 VGND.t256 sg13cmos5l_inv_1_58.A sg13cmos5l_inv_1_58.Y VGND.t601 sg13_lv_nmos ad=0.2516p pd=2.16u as=0.2516p ps=2.16u w=0.74u l=0.13u
X1778 a_4141_3195# a_3623_3534# a_3934_3534# VPWR.t8 sg13_lv_pmos ad=0.16p pd=1.32u as=0.19p ps=1.38u w=1u l=0.13u
X1779 VGND.t88 VPWR.t1589 VGND.t88 VGND.t1526 sg13_lv_nmos ad=0.1428p pd=1.52u as=0 ps=0 w=0.42u l=1u
X1780 sg13cmos5l_inv_1_206.A sg13cmos5l_inv_1_148.Y VPWR.t374 VPWR.t0 sg13_lv_pmos ad=0.3808p pd=2.92u as=0.3808p ps=2.92u w=1.12u l=0.13u
X1781 a_6637_8701# a_6119_8434# a_6430_8434# VPWR.t29 sg13_lv_pmos ad=0.16p pd=1.32u as=0.19p ps=1.38u w=1u l=0.13u
X1782 sg13cmos5l_inv_1_962.Y sg13cmos5l_inv_1_985.Y VPWR.t1270 VPWR.t29 sg13_lv_pmos ad=0.3808p pd=2.92u as=0.3808p ps=2.92u w=1.12u l=0.13u
X1783 sg13cmos5l_inv_1_279.Y sg13cmos5l_inv_1_277.Y VGND.t111 VGND.t734 sg13_lv_nmos ad=0.2516p pd=2.16u as=0.2516p ps=2.16u w=0.74u l=0.13u
X1784 sg13cmos5l_inv_1_834.Y sg13cmos5l_inv_1_843.Y VPWR.t418 VPWR.t39 sg13_lv_pmos ad=0.3808p pd=2.92u as=0.3808p ps=2.92u w=1.12u l=0.13u
X1785 sg13cmos5l_inv_1_726.A sg13cmos5l_inv_1_708.A VPWR.t785 VPWR.t26 sg13_lv_pmos ad=0.3808p pd=2.92u as=0.3808p ps=2.92u w=1.12u l=0.13u
X1786 sg13cmos5l_inv_1_515.A sg13cmos5l_inv_1_504.Y VGND.t322 VGND.t930 sg13_lv_nmos ad=0.2516p pd=2.16u as=0.2516p ps=2.16u w=0.74u l=0.13u
X1787 sg13cmos5l_inv_1_643.A sg13cmos5l_inv_1_642.Y VPWR.t805 VPWR.t21 sg13_lv_pmos ad=0.3808p pd=2.92u as=0.3808p ps=2.92u w=1.12u l=0.13u
X1788 VGND.t414 sg13cmos5l_mux2_1_3.S sg13cmos5l_a21oi_1_1.A1 VGND.t1040 sg13_lv_nmos ad=0.2516p pd=2.16u as=0.1406p ps=1.12u w=0.74u l=0.13u
X1789 VPWR.t182 VGND.t587 VPWR.t181 VPWR.t42 sg13_lv_pmos ad=0.34p pd=2.68u as=0 ps=0 w=1u l=1u
X1790 VGND.t412 sg13cmos5l_mux4_1_7.A3 sg13cmos5l_inv_1_637.A VGND.t512 sg13_lv_nmos ad=0.2516p pd=2.16u as=0.2516p ps=2.16u w=0.74u l=0.13u
X1791 sg13cmos5l_mux4_1_9.A0 sg13cmos5l_inv_1_522.A VPWR.t989 VPWR.t26 sg13_lv_pmos ad=0.3808p pd=2.92u as=0.3808p ps=2.92u w=1.12u l=0.13u
X1792 sg13cmos5l_inv_1_277.Y sg13cmos5l_inv_1_277.A VPWR.t877 VPWR.t8 sg13_lv_pmos ad=0.3808p pd=2.92u as=0.3808p ps=2.92u w=1.12u l=0.13u
X1793 sg13cmos5l_inv_1_43.Y sg13cmos5l_inv_1_40.Y VPWR.t1226 VPWR.t11 sg13_lv_pmos ad=0.3808p pd=2.92u as=0.3808p ps=2.92u w=1.12u l=0.13u
X1794 sg13cmos5l_inv_1_854.Y sg13cmos5l_inv_1_855.Y VPWR.t447 VPWR.t42 sg13_lv_pmos ad=0.3808p pd=2.92u as=0.3808p ps=2.92u w=1.12u l=0.13u
X1795 sg13cmos5l_inv_1_903.Y sg13cmos5l_inv_1_904.Y VGND.t88 VGND.t177 sg13_lv_nmos ad=0.2516p pd=2.16u as=0.2516p ps=2.16u w=0.74u l=0.13u
X1796 VGND.t256 sg13cmos5l_inv_1_15.Y sg13cmos5l_inv_1_20.Y VGND.t384 sg13_lv_nmos ad=0.2516p pd=2.16u as=0.2516p ps=2.16u w=0.74u l=0.13u
X1797 sg13cmos5l_inv_1_147.A sg13cmos5l_inv_1_150.A VGND.t1 VGND.t215 sg13_lv_nmos ad=0.2516p pd=2.16u as=0.2516p ps=2.16u w=0.74u l=0.13u
X1798 VGND.t10 sg13cmos5l_inv_1_931.A sg13cmos5l_inv_1_931.Y VGND.t376 sg13_lv_nmos ad=0.2516p pd=2.16u as=0.2516p ps=2.16u w=0.74u l=0.13u
X1799 VGND.t1521 VPWR.t1594 VGND.t1521 VGND.t1520 sg13_lv_nmos ad=0.1428p pd=1.52u as=0 ps=0 w=0.42u l=1u
X1800 VGND.t478 VPWR.t1583 VGND.t478 VGND.t1538 sg13_lv_nmos ad=79.8f pd=0.8u as=0 ps=0 w=0.42u l=1u
X1801 sg13cmos5l_inv_1_605.Y sg13cmos5l_inv_1_588.Y VGND.t310 VGND.t309 sg13_lv_nmos ad=0.2516p pd=2.16u as=0.2516p ps=2.16u w=0.74u l=0.13u
X1802 a_4438_3534# a_5005_3418# a_4929_3492# VPWR.t8 sg13_lv_pmos ad=0.34p pd=2.68u as=0.2225p ps=1.445u w=1u l=0.13u
X1803 sg13cmos5l_mux4_1_2.X a_14913_3940# VPWR.t798 VPWR.t49 sg13_lv_pmos ad=0.3808p pd=2.92u as=0.34367p ps=1.775u w=1.12u l=0.13u
X1804 sg13cmos5l_inv_1_748.Y sg13cmos5l_inv_1_748.A VGND.t612 VGND.t611 sg13_lv_nmos ad=0.2516p pd=2.16u as=0.2516p ps=2.16u w=0.74u l=0.13u
X1805 sg13cmos5l_inv_1_258.A sg13cmos5l_inv_1_249.Y VGND.t617 VGND.t763 sg13_lv_nmos ad=0.2516p pd=2.16u as=0.2516p ps=2.16u w=0.74u l=0.13u
X1806 sg13cmos5l_inv_1_622.Y sg13cmos5l_inv_1_623.Y VGND.t207 VGND.t208 sg13_lv_nmos ad=0.2516p pd=2.16u as=0.2516p ps=2.16u w=0.74u l=0.13u
X1807 sg13cmos5l_inv_1_616.A sg13cmos5l_inv_1_579.Y VPWR.t335 VPWR.t42 sg13_lv_pmos ad=0.3808p pd=2.92u as=0.3808p ps=2.92u w=1.12u l=0.13u
X1808 VPWR.t703 sg13cmos5l_inv_1_787.Y a_14413_15291# VPWR.t21 sg13_lv_pmos ad=0.29275p pd=1.785u as=0.16p ps=1.32u w=1u l=0.13u
X1809 sg13cmos5l_inv_1_891.Y sg13cmos5l_inv_1_895.Y VPWR.t521 VPWR.t26 sg13_lv_pmos ad=0.3808p pd=2.92u as=0.3808p ps=2.92u w=1.12u l=0.13u
X1810 sg13cmos5l_inv_1_964.Y sg13cmos5l_inv_1_964.A VGND.t508 VGND.t4 sg13_lv_nmos ad=0.2516p pd=2.16u as=0.2516p ps=2.16u w=0.74u l=0.13u
X1811 VPWR.t694 sg13cmos5l_inv_1_2.Y sg13cmos5l_inv_1_46.A VPWR.t8 sg13_lv_pmos ad=0.3808p pd=2.92u as=0.3808p ps=2.92u w=1.12u l=0.13u
X1812 VPWR.t1494 sg13cmos5l_inv_1_82.A sg13cmos5l_inv_1_82.Y VPWR.t8 sg13_lv_pmos ad=0.3808p pd=2.92u as=0.3808p ps=2.92u w=1.12u l=0.13u
X1813 sg13cmos5l_inv_1_135.Y sg13cmos5l_inv_1_134.Y VGND.t947 VGND.t946 sg13_lv_nmos ad=0.2516p pd=2.16u as=0.2516p ps=2.16u w=0.74u l=0.13u
X1814 VGND.t225 sg13cmos5l_inv_1_233.A sg13cmos5l_inv_1_989.A VGND.t11 sg13_lv_nmos ad=0.2516p pd=2.16u as=0.2516p ps=2.16u w=0.74u l=0.13u
X1815 VPWR.t109 VGND.t267 VPWR.t108 VPWR.t14 sg13_lv_pmos ad=0.34p pd=2.68u as=0 ps=0 w=1u l=1u
X1816 sg13cmos5l_inv_1_624.Y sg13cmos5l_inv_1_658.Y VPWR.t725 VPWR.t42 sg13_lv_pmos ad=0.3808p pd=2.92u as=0.3808p ps=2.92u w=1.12u l=0.13u
X1817 sg13cmos5l_inv_1_995.Y sg13cmos5l_inv_1_616.Y VGND.t670 VGND.t669 sg13_lv_nmos ad=0.2516p pd=2.16u as=0.2516p ps=2.16u w=0.74u l=0.13u
X1818 sg13cmos5l_inv_1_78.A sg13cmos5l_inv_1_77.Y VGND.t396 VGND.t1400 sg13_lv_nmos ad=0.2516p pd=2.16u as=0.2516p ps=2.16u w=0.74u l=0.13u
X1819 sg13cmos5l_inv_1_475.Y sg13cmos5l_inv_1_473.Y VPWR.t384 VPWR.t5 sg13_lv_pmos ad=0.3808p pd=2.92u as=0.3808p ps=2.92u w=1.12u l=0.13u
X1820 VPWR.t1244 sg13cmos5l_inv_1_790.Y sg13cmos5l_inv_1_773.Y VPWR.t39 sg13_lv_pmos ad=0.3808p pd=2.92u as=0.3808p ps=2.92u w=1.12u l=0.13u
X1821 VPWR.t1109 invsel[3] a_808_9980# VPWR.t5 sg13_lv_pmos ad=0.2114p pd=1.54u as=0.2856p ps=2.36u w=0.84u l=0.13u
X1822 sg13cmos5l_inv_1_601.Y sg13cmos5l_inv_1_604.Y VPWR.t1391 VPWR.t39 sg13_lv_pmos ad=0.3808p pd=2.92u as=0.3808p ps=2.92u w=1.12u l=0.13u
X1823 sg13cmos5l_inv_1_520.A sg13cmos5l_inv_1_500.Y VPWR.t955 VPWR.t5 sg13_lv_pmos ad=0.3808p pd=2.92u as=0.3808p ps=2.92u w=1.12u l=0.13u
X1824 sg13cmos5l_inv_1_168.A sg13cmos5l_inv_1_165.Y VPWR.t505 VPWR.t29 sg13_lv_pmos ad=0.3808p pd=2.92u as=0.3808p ps=2.92u w=1.12u l=0.13u
X1825 a_6430_8434# a_6119_8434# a_6356_8434# VGND.t379 sg13_lv_nmos ad=0.1472p pd=1.1u as=76.8f ps=0.88u w=0.64u l=0.13u
X1826 VPWR.t1379 sg13cmos5l_mux4_1_10.A2 sg13cmos5l_inv_1_568.A VPWR.t42 sg13_lv_pmos ad=0.3808p pd=2.92u as=0.3808p ps=2.92u w=1.12u l=0.13u
X1827 sg13cmos5l_inv_1_789.Y sg13cmos5l_inv_1_788.Y VPWR.t692 VPWR.t42 sg13_lv_pmos ad=0.3808p pd=2.92u as=0.3808p ps=2.92u w=1.12u l=0.13u
X1828 sg13cmos5l_inv_1_1009.Y sg13cmos5l_inv_1_1012.Y VGND.t153 VGND.t190 sg13_lv_nmos ad=0.2516p pd=2.16u as=0.2516p ps=2.16u w=0.74u l=0.13u
X1829 VPWR.t30 VGND.t105 VPWR.t246 VPWR.t29 sg13_lv_pmos ad=0.34p pd=2.68u as=0 ps=0 w=1u l=1u
X1830 VGND.t263 sg13cmos5l_mux4_1_5.S0.t8 a_3623_15994# VGND.t93 sg13_lv_nmos ad=0.1872p pd=1.225u as=0.2176p ps=1.96u w=0.64u l=0.13u
X1831 sg13cmos5l_inv_1_294.Y sg13cmos5l_inv_1_296.Y VGND.t52 VGND.t1270 sg13_lv_nmos ad=0.2516p pd=2.16u as=0.2516p ps=2.16u w=0.74u l=0.13u
X1832 sg13cmos5l_inv_1_287.A sg13cmos5l_inv_1_286.Y VPWR.t545 VPWR.t8 sg13_lv_pmos ad=0.3808p pd=2.92u as=0.3808p ps=2.92u w=1.12u l=0.13u
X1833 VGND.t342 sg13cmos5l_inv_1_340.Y a_4575_8070# VGND.t915 sg13_lv_nmos ad=0.2176p pd=1.96u as=76.8f ps=0.88u w=0.64u l=0.13u
X1834 VPWR.t65 VGND.t540 VPWR.t64 VPWR.t14 sg13_lv_pmos ad=0.34p pd=2.68u as=0 ps=0 w=1u l=1u
X1835 VPWR.t432 sg13cmos5l_inv_1_159.A a_18664_9192# VPWR.t29 sg13_lv_pmos ad=0.2114p pd=1.54u as=0.2856p ps=2.36u w=0.84u l=0.13u
X1836 VGND.t310 sg13cmos5l_inv_1_588.A sg13cmos5l_inv_1_588.Y VGND.t574 sg13_lv_nmos ad=0.2516p pd=2.16u as=0.2516p ps=2.16u w=0.74u l=0.13u
X1837 VGND.t28 sg13cmos5l_inv_1_42.A sg13cmos5l_inv_1_31.A VGND.t257 sg13_lv_nmos ad=0.2516p pd=2.16u as=0.2516p ps=2.16u w=0.74u l=0.13u
X1838 a_14422_12606# sg13cmos5l_buf_1_9.A.t2 a_14341_12267# VPWR.t2 sg13_lv_pmos ad=0.4425p pd=1.885u as=0.20762p ps=1.605u w=1u l=0.13u
X1839 sg13cmos5l_inv_1_466.Y sg13cmos5l_inv_1_325.Y VPWR.t285 VPWR.t8 sg13_lv_pmos ad=0.3808p pd=2.92u as=0.3808p ps=2.92u w=1.12u l=0.13u
X1840 a_7789_16261# a_7271_15994# a_7582_15994# VPWR.t42 sg13_lv_pmos ad=0.16p pd=1.32u as=0.19p ps=1.38u w=1u l=0.13u
X1841 sg13cmos5l_inv_1_846.Y sg13cmos5l_inv_1_845.Y VPWR.t1336 VPWR.t42 sg13_lv_pmos ad=0.3808p pd=2.92u as=0.3808p ps=2.92u w=1.12u l=0.13u
X1842 sg13cmos5l_inv_1_222.Y sg13cmos5l_inv_1_184.Y VPWR.t1033 VPWR.t49 sg13_lv_pmos ad=0.3808p pd=2.92u as=0.3808p ps=2.92u w=1.12u l=0.13u
X1843 VGND.t29 VPWR.t1616 VGND.t29 VGND.t22 sg13_lv_nmos ad=0.1428p pd=1.52u as=0 ps=0 w=0.42u l=1u
X1844 VGND.t100 sg13cmos5l_inv_1_553.A sg13cmos5l_inv_1_553.Y VGND.t22 sg13_lv_nmos ad=0.2516p pd=2.16u as=0.2516p ps=2.16u w=0.74u l=0.13u
X1845 sg13cmos5l_inv_1_134.Y sg13cmos5l_inv_1_133.Y VPWR.t1487 VPWR.t14 sg13_lv_pmos ad=0.3808p pd=2.92u as=0.3808p ps=2.92u w=1.12u l=0.13u
X1846 VGND.t162 VPWR.t1555 VGND.t162 VGND.t1576 sg13_lv_nmos ad=79.8f pd=0.8u as=0 ps=0 w=0.42u l=1u
X1847 sg13cmos5l_inv_1_655.Y sg13cmos5l_inv_1_654.Y VGND.t412 VGND.t925 sg13_lv_nmos ad=0.2516p pd=2.16u as=0.2516p ps=2.16u w=0.74u l=0.13u
X1848 sg13cmos5l_inv_1_29.A sg13cmos5l_inv_1_30.Y VPWR.t1486 VPWR.t49 sg13_lv_pmos ad=0.3808p pd=2.92u as=0.3808p ps=2.92u w=1.12u l=0.13u
X1849 VGND.t947 sg13cmos5l_inv_1_110.A sg13cmos5l_mux4_1_16.A2 VGND.t1111 sg13_lv_nmos ad=0.2516p pd=2.16u as=0.2516p ps=2.16u w=0.74u l=0.13u
X1850 VGND.t1505 VPWR.t1602 VGND.t207 VGND.t1504 sg13_lv_nmos ad=0.1428p pd=1.52u as=0 ps=0 w=0.42u l=1u
X1851 VPWR.t846 sg13cmos5l_inv_1_76.A a_14645_4211# VPWR.t49 sg13_lv_pmos ad=0.34p pd=2.68u as=0.135p ps=1.27u w=1u l=0.13u
X1852 a_16540_8070# sg13cmos5l_inv_1_179.A VGND.t128 VGND.t1053 sg13_lv_nmos ad=0.2304p pd=1.36u as=0.1824p ps=1.21u w=0.64u l=0.13u
X1853 sg13cmos5l_inv_1_626.Y sg13cmos5l_inv_1_593.Y VGND.t44 VGND.t22 sg13_lv_nmos ad=0.2516p pd=2.16u as=0.2516p ps=2.16u w=0.74u l=0.13u
X1854 sg13cmos5l_a21oi_1_1.A2 a_8577_16036# VGND.t46 VGND.t137 sg13_lv_nmos ad=0.2516p pd=2.16u as=0.1543p ps=1.18u w=0.74u l=0.13u
X1855 VPWR.t1352 sg13cmos5l_inv_1_565.Y sg13cmos5l_inv_1_566.A VPWR.t42 sg13_lv_pmos ad=0.3808p pd=2.92u as=0.3808p ps=2.92u w=1.12u l=0.13u
X1856 sg13cmos5l_inv_1_595.Y sg13cmos5l_inv_1_596.Y VGND.t558 VGND.t1453 sg13_lv_nmos ad=0.2516p pd=2.16u as=0.2516p ps=2.16u w=0.74u l=0.13u
X1857 VPWR.t701 sg13cmos5l_inv_1_12.Y sg13cmos5l_inv_1_48.Y VPWR.t8 sg13_lv_pmos ad=0.3808p pd=2.92u as=0.3808p ps=2.92u w=1.12u l=0.13u
X1858 sg13cmos5l_inv_1_397.Y sg13cmos5l_inv_1_396.Y VPWR.t513 VPWR.t14 sg13_lv_pmos ad=0.3808p pd=2.92u as=0.3808p ps=2.92u w=1.12u l=0.13u
X1859 sg13cmos5l_inv_1_209.Y sg13cmos5l_inv_1_212.Y VGND.t113 VGND.t11 sg13_lv_nmos ad=0.2516p pd=2.16u as=0.2516p ps=2.16u w=0.74u l=0.13u
X1860 sg13cmos5l_or2_1_0.X a_9360_11832# VPWR.t826 VPWR.t2 sg13_lv_pmos ad=0.3976p pd=2.95u as=0.2226p ps=1.535u w=1.12u l=0.13u
X1861 VGND.t412 sg13cmos5l_inv_1_640.A sg13cmos5l_inv_1_639.A VGND.t484 sg13_lv_nmos ad=0.2516p pd=2.16u as=0.2516p ps=2.16u w=0.74u l=0.13u
X1862 VGND.t102 sg13cmos5l_buf_1_10.A a_5005_12490# VGND.t1106 sg13_lv_nmos ad=0.1543p pd=1.18u as=0.2304p ps=2u w=0.64u l=0.13u
X1863 sg13cmos5l_inv_1_5.Y sg13cmos5l_inv_1_43.Y VPWR.t1157 VPWR.t11 sg13_lv_pmos ad=0.3808p pd=2.92u as=0.3808p ps=2.92u w=1.12u l=0.13u
X1864 sg13cmos5l_inv_1_3.Y sg13cmos5l_inv_1_16.Y VGND.t646 VGND.t1131 sg13_lv_nmos ad=0.2516p pd=2.16u as=0.2516p ps=2.16u w=0.74u l=0.13u
X1865 VGND.t92 sg13cmos5l_inv_1_914.A sg13cmos5l_inv_1_913.A VGND.t381 sg13_lv_nmos ad=0.2516p pd=2.16u as=0.2516p ps=2.16u w=0.74u l=0.13u
X1866 sg13cmos5l_inv_1_854.Y sg13cmos5l_inv_1_855.Y VGND.t116 VGND.t22 sg13_lv_nmos ad=0.2516p pd=2.16u as=0.2516p ps=2.16u w=0.74u l=0.13u
X1867 VPWR.t1470 sg13cmos5l_inv_1_247.Y sg13cmos5l_inv_1_306.A VPWR.t8 sg13_lv_pmos ad=0.3808p pd=2.92u as=0.3808p ps=2.92u w=1.12u l=0.13u
X1868 a_13918_3898# sg13cmos5l_mux4_1_5.S1.t4 a_13831_4165# VPWR.t49 sg13_lv_pmos ad=0.19p pd=1.38u as=0.415p ps=1.83u w=1u l=0.13u
X1869 sg13cmos5l_inv_1_22.A sg13cmos5l_inv_1_45.Y VGND.t547 VGND.t1354 sg13_lv_nmos ad=0.2516p pd=2.16u as=0.2516p ps=2.16u w=0.74u l=0.13u
X1870 sg13cmos5l_inv_1_509.A sg13cmos5l_inv_1_511.A VPWR.t1195 VPWR.t26 sg13_lv_pmos ad=0.3808p pd=2.92u as=0.3808p ps=2.92u w=1.12u l=0.13u
X1871 VPWR.t486 sg13cmos5l_inv_1_175.A sg13cmos5l_inv_1_174.A VPWR.t14 sg13_lv_pmos ad=0.3808p pd=2.92u as=0.3808p ps=2.92u w=1.12u l=0.13u
X1872 a_14125_14749# a_13607_14482# a_13918_14482# VPWR.t21 sg13_lv_pmos ad=0.16p pd=1.32u as=0.19p ps=1.38u w=1u l=0.13u
X1873 a_13831_12267# sg13cmos5l_inv_1_747.Y VPWR.t616 VPWR.t2 sg13_lv_pmos ad=0.415p pd=1.83u as=0.22315p ps=1.555u w=1u l=0.13u
X1874 VPWR.t299 sg13cmos5l_mux4_1_5.S1.t2 a_8653_3418# VPWR.t8 sg13_lv_pmos ad=0.34367p pd=1.775u as=0.34p ps=2.68u w=1u l=0.13u
X1875 a_15076_11458# a_14827_11673# a_14360_11776# VGND.t1085 sg13_lv_nmos ad=80f pd=0.89u as=0.1776p ps=1.195u w=0.64u l=0.13u
X1876 VGND.t354 sg13cmos5l_mux4_1_5.S1.t5 a_9709_6442# VGND.t653 sg13_lv_nmos ad=0.1543p pd=1.18u as=0.2304p ps=2u w=0.64u l=0.13u
X1877 sg13cmos5l_inv_1_887.Y sg13cmos5l_inv_1_896.Y VPWR.t526 VPWR.t26 sg13_lv_pmos ad=0.3808p pd=2.92u as=0.3808p ps=2.92u w=1.12u l=0.13u
X1878 a_15489_9540# sg13cmos5l_mux2_1_4.S a_14494_9582# VPWR.t29 sg13_lv_pmos ad=0.2225p pd=1.445u as=0.34p ps=2.68u w=1u l=0.13u
X1879 sg13cmos5l_inv_1_30.A sg13cmos5l_inv_1_199.Y VGND.t113 VGND.t11 sg13_lv_nmos ad=0.2516p pd=2.16u as=0.2516p ps=2.16u w=0.74u l=0.13u
X1880 VGND.t212 sg13cmos5l_inv_1_228.A sg13cmos5l_inv_1_228.Y VGND.t11 sg13_lv_nmos ad=0.2516p pd=2.16u as=0.2516p ps=2.16u w=0.74u l=0.13u
X1881 VPWR.t988 sg13cmos5l_inv_1_424.A sg13cmos5l_inv_1_423.A VPWR.t49 sg13_lv_pmos ad=0.3808p pd=2.92u as=0.3808p ps=2.92u w=1.12u l=0.13u
X1882 VGND.t201 sg13cmos5l_inv_1_267.Y sg13cmos5l_inv_1_283.A VGND.t1055 sg13_lv_nmos ad=0.2516p pd=2.16u as=0.2516p ps=2.16u w=0.74u l=0.13u
X1883 sg13cmos5l_inv_1_556.Y sg13cmos5l_inv_1_550.Y VGND.t558 VGND.t559 sg13_lv_nmos ad=0.2516p pd=2.16u as=0.2516p ps=2.16u w=0.74u l=0.13u
X1884 sg13cmos5l_inv_1_964.Y sg13cmos5l_inv_1_964.A VPWR.t1056 VPWR.t29 sg13_lv_pmos ad=0.3808p pd=2.92u as=0.3808p ps=2.92u w=1.12u l=0.13u
X1885 VPWR.t568 sg13cmos5l_mux2_1_4.S.t1 a_15181_3418# VPWR.t8 sg13_lv_pmos ad=0.34367p pd=1.775u as=0.34p ps=2.68u w=1u l=0.13u
X1886 VGND.t260 sg13cmos5l_inv_1_327.A sg13cmos5l_inv_1_328.A VGND.t632 sg13_lv_nmos ad=0.2516p pd=2.16u as=0.2516p ps=2.16u w=0.74u l=0.13u
X1887 VGND.t149 sg13cmos5l_inv_1_159.A a_18664_9192# VGND.t868 sg13_lv_nmos ad=0.14875p pd=1.16u as=0.187p ps=1.78u w=0.55u l=0.13u
X1888 VPWR.t772 sg13cmos5l_buf_1_12.X a_10504_9192# VPWR.t29 sg13_lv_pmos ad=0.2114p pd=1.54u as=0.2856p ps=2.36u w=0.84u l=0.13u
X1889 VPWR.t778 sg13cmos5l_inv_1_421.Y sg13cmos5l_inv_1_434.A VPWR.t0 sg13_lv_pmos ad=0.3808p pd=2.92u as=0.3808p ps=2.92u w=1.12u l=0.13u
X1890 sg13cmos5l_inv_1_903.Y sg13cmos5l_inv_1_904.Y VPWR.t364 VPWR.t26 sg13_lv_pmos ad=0.3808p pd=2.92u as=0.3808p ps=2.92u w=1.12u l=0.13u
X1891 VGND.t269 sg13cmos5l_inv_1_489.A sg13cmos5l_inv_1_488.A VGND.t706 sg13_lv_nmos ad=0.2516p pd=2.16u as=0.2516p ps=2.16u w=0.74u l=0.13u
X1892 sg13cmos5l_mux4_1_4.X a_7425_8476# VGND.t76 VGND.t1360 sg13_lv_nmos ad=0.2516p pd=2.16u as=0.1543p ps=1.18u w=0.74u l=0.13u
X1893 VGND.t478 sg13cmos5l_mux2_1_4.S.t3 a_14989_12490# VGND.t1638 sg13_lv_nmos ad=0.1543p pd=1.18u as=0.2304p ps=2u w=0.64u l=0.13u
X1894 a_10268_9172# sg13cmos5l_mux2_1_3.X sg13cmos5l_o21ai_1_0.Y VPWR.t29 sg13_lv_pmos ad=0.2128p pd=1.5u as=0.2128p ps=1.5u w=1.12u l=0.15u
X1895 sg13cmos5l_inv_1_346.Y sg13cmos5l_inv_1_345.Y VPWR.t713 VPWR.t0 sg13_lv_pmos ad=0.3808p pd=2.92u as=0.3808p ps=2.92u w=1.12u l=0.13u
X1896 VPWR.t411 sg13cmos5l_inv_1_273.A sg13cmos5l_inv_1_273.Y VPWR.t11 sg13_lv_pmos ad=0.3808p pd=2.92u as=0.3808p ps=2.92u w=1.12u l=0.13u
X1897 VGND.t100 sg13cmos5l_mux4_1_10.A2 sg13cmos5l_inv_1_568.A VGND.t22 sg13_lv_nmos ad=0.2516p pd=2.16u as=0.2516p ps=2.16u w=0.74u l=0.13u
X1898 sg13cmos5l_inv_1_789.Y sg13cmos5l_inv_1_788.Y VGND.t197 VGND.t22 sg13_lv_nmos ad=0.2516p pd=2.16u as=0.2516p ps=2.16u w=0.74u l=0.13u
X1899 VGND.t246 sg13cmos5l_inv_1_442.A sg13cmos5l_inv_1_442.Y VGND.t245 sg13_lv_nmos ad=0.2516p pd=2.16u as=0.2516p ps=2.16u w=0.74u l=0.13u
X1900 a_7582_3534# sg13cmos5l_mux4_1_5.S0.t1 a_7495_3195# VPWR.t8 sg13_lv_pmos ad=0.19p pd=1.38u as=0.415p ps=1.83u w=1u l=0.13u
X1901 sg13cmos5l_inv_1_945.A sg13cmos5l_inv_1_981.Y VGND.t536 VGND.t1276 sg13_lv_nmos ad=0.2516p pd=2.16u as=0.2516p ps=2.16u w=0.74u l=0.13u
X1902 VGND.t43 sg13cmos5l_inv_1_268.A sg13cmos5l_inv_1_264.A VGND.t1480 sg13_lv_nmos ad=0.2516p pd=2.16u as=0.2516p ps=2.16u w=0.74u l=0.13u
X1903 sg13cmos5l_inv_1_341.Y sg13cmos5l_inv_1_367.Y VGND.t449 VGND.t822 sg13_lv_nmos ad=0.2516p pd=2.16u as=0.2516p ps=2.16u w=0.74u l=0.13u
X1904 VGND.t157 sg13cmos5l_inv_1_138.A sg13cmos5l_inv_1_138.Y VGND.t377 sg13_lv_nmos ad=0.2516p pd=2.16u as=0.2516p ps=2.16u w=0.74u l=0.13u
X1905 sg13cmos5l_inv_1_169.Y sg13cmos5l_inv_1_130.Y VPWR.t387 VPWR.t14 sg13_lv_pmos ad=0.3808p pd=2.92u as=0.3808p ps=2.92u w=1.12u l=0.13u
X1906 VGND.t8 sg13cmos5l_mux4_1_15.A3 a_15135_9582# VGND.t1033 sg13_lv_nmos ad=0.2176p pd=1.96u as=76.8f ps=0.88u w=0.64u l=0.13u
X1907 VPWR.t361 sg13cmos5l_inv_1_749.A sg13cmos5l_inv_1_759.A VPWR.t2 sg13_lv_pmos ad=0.3808p pd=2.92u as=0.3808p ps=2.92u w=1.12u l=0.13u
X1908 a_14614_3534# a_15181_3418# a_15105_3492# VPWR.t8 sg13_lv_pmos ad=0.34p pd=2.68u as=0.2225p ps=1.445u w=1u l=0.13u
X1909 sg13cmos5l_inv_1_584.A sg13cmos5l_inv_1_626.Y VPWR.t750 VPWR.t39 sg13_lv_pmos ad=0.3808p pd=2.92u as=0.3808p ps=2.92u w=1.12u l=0.13u
X1910 VPWR.t1419 sg13cmos5l_inv_1_881.A sg13cmos5l_inv_1_880.A VPWR.t21 sg13_lv_pmos ad=0.3808p pd=2.92u as=0.3808p ps=2.92u w=1.12u l=0.13u
X1911 sg13cmos5l_inv_1_862.A sg13cmos5l_inv_1_872.A VPWR.t1388 VPWR.t42 sg13_lv_pmos ad=0.3808p pd=2.92u as=0.3808p ps=2.92u w=1.12u l=0.13u
X1912 VPWR.t812 a_18764_12180# sg13cmos5l_buf_1_18.A VPWR.t2 sg13_lv_pmos ad=0.2114p pd=1.54u as=0.42p ps=2.99u w=1.12u l=0.13u
X1913 VGND.t39 sg13cmos5l_inv_1_721.A sg13cmos5l_inv_1_713.A VGND.t301 sg13_lv_nmos ad=0.2516p pd=2.16u as=0.2516p ps=2.16u w=0.74u l=0.13u
X1914 VPWR.t527 sg13cmos5l_inv_1_772.A sg13cmos5l_inv_1_606.A VPWR.t39 sg13_lv_pmos ad=0.3808p pd=2.92u as=0.3808p ps=2.92u w=1.12u l=0.13u
X1915 VPWR.t859 sg13cmos5l_inv_1_562.A sg13cmos5l_inv_1_562.Y VPWR.t42 sg13_lv_pmos ad=0.3808p pd=2.92u as=0.3808p ps=2.92u w=1.12u l=0.13u
X1916 VGND.t723 sg13cmos5l_inv_1_635.A sg13cmos5l_inv_1_634.A VGND.t1005 sg13_lv_nmos ad=0.2516p pd=2.16u as=0.2516p ps=2.16u w=0.74u l=0.13u
X1917 sg13cmos5l_inv_1_162.A sg13cmos5l_inv_1_157.Y VGND.t128 VGND.t1009 sg13_lv_nmos ad=0.2516p pd=2.16u as=0.2516p ps=2.16u w=0.74u l=0.13u
X1918 sg13cmos5l_inv_1_225.A sg13cmos5l_inv_1_190.A VPWR.t477 VPWR.t0 sg13_lv_pmos ad=0.3808p pd=2.92u as=0.3808p ps=2.92u w=1.12u l=0.13u
X1919 a_9066_6558# sg13cmos5l_mux4_1_16.A2 VGND.t354 VGND.t355 sg13_lv_nmos ad=80f pd=0.89u as=0.1824p ps=1.21u w=0.64u l=0.13u
X1920 sg13cmos5l_inv_1_589.A sg13cmos5l_inv_1_594.Y VGND.t310 VGND.t575 sg13_lv_nmos ad=0.2516p pd=2.16u as=0.2516p ps=2.16u w=0.74u l=0.13u
X1921 VPWR.t44 VGND.t56 VPWR.t43 VPWR.t42 sg13_lv_pmos ad=0.34p pd=2.68u as=0 ps=0 w=1u l=1u
X1922 sg13cmos5l_inv_1_157.Y sg13cmos5l_inv_1_156.Y VPWR.t1123 VPWR.t29 sg13_lv_pmos ad=0.3808p pd=2.92u as=0.3808p ps=2.92u w=1.12u l=0.13u
X1923 VGND.t29 sg13cmos5l_inv_1_565.Y sg13cmos5l_inv_1_566.A VGND.t22 sg13_lv_nmos ad=0.2516p pd=2.16u as=0.2516p ps=2.16u w=0.74u l=0.13u
X1924 VGND.t1529 VPWR.t1588 VGND.t1528 VGND.t1527 sg13_lv_nmos ad=0.1428p pd=1.52u as=0 ps=0 w=0.42u l=1u
X1925 VGND.t19 a_4556_3858# sg13cmos5l_buf_1_9.A VGND.t1290 sg13_lv_nmos ad=0.14875p pd=1.16u as=0.2886p ps=2.26u w=0.74u l=0.13u
X1926 sg13cmos5l_inv_1_592.A sg13cmos5l_inv_1_610.Y VGND.t44 VGND.t22 sg13_lv_nmos ad=0.2516p pd=2.16u as=0.2516p ps=2.16u w=0.74u l=0.13u
X1927 VGND.t5 sg13cmos5l_inv_1_359.Y sg13cmos5l_inv_1_985.Y VGND.t4 sg13_lv_nmos ad=0.2516p pd=2.16u as=0.2516p ps=2.16u w=0.74u l=0.13u
X1928 sg13cmos5l_buf_1_4.X a_18664_6956# VPWR.t936 VPWR.t14 sg13_lv_pmos ad=0.42p pd=2.99u as=0.2114p ps=1.54u w=1.12u l=0.13u
X1929 sg13cmos5l_inv_1_535.A sg13cmos5l_inv_1_533.Y VGND.t100 VGND.t22 sg13_lv_nmos ad=0.2516p pd=2.16u as=0.2516p ps=2.16u w=0.74u l=0.13u
X1930 VPWR.t257 sg13cmos5l_inv_1_933.Y sg13cmos5l_inv_1_935.A VPWR.t5 sg13_lv_pmos ad=0.3808p pd=2.92u as=0.3808p ps=2.92u w=1.12u l=0.13u
X1931 VGND.t191 sg13cmos5l_buf_1_12.X a_10504_9192# VGND.t4 sg13_lv_nmos ad=0.14875p pd=1.16u as=0.187p ps=1.78u w=0.55u l=0.13u
X1932 VGND.t250 sg13cmos5l_inv_1_643.A sg13cmos5l_inv_1_641.A VGND.t679 sg13_lv_nmos ad=0.2516p pd=2.16u as=0.2516p ps=2.16u w=0.74u l=0.13u
X1933 VPWR.t124 VGND.t153 VPWR.t123 VPWR.t5 sg13_lv_pmos ad=0.34p pd=2.68u as=0 ps=0 w=1u l=1u
X1934 VGND.t10 sg13cmos5l_inv_1_928.A sg13cmos5l_inv_1_929.A VGND.t1168 sg13_lv_nmos ad=0.2516p pd=2.16u as=0.2516p ps=2.16u w=0.74u l=0.13u
X1935 sg13cmos5l_inv_1_521.Y sg13cmos5l_inv_1_523.Y VGND.t145 VGND.t1047 sg13_lv_nmos ad=0.2516p pd=2.16u as=0.2516p ps=2.16u w=0.74u l=0.13u
X1936 VPWR.t1390 sg13cmos5l_inv_1_58.Y sg13cmos5l_inv_1_61.A VPWR.t11 sg13_lv_pmos ad=0.3808p pd=2.92u as=0.3808p ps=2.92u w=1.12u l=0.13u
X1937 a_7508_15994# sg13cmos5l_mux4_1_8.A0 VGND.t1204 VGND.t45 sg13_lv_nmos ad=76.8f pd=0.88u as=0.1872p ps=1.225u w=0.64u l=0.13u
X1938 VGND.t46 sg13cmos5l_buf_1_9.A.t6 a_8653_16000# VGND.t639 sg13_lv_nmos ad=0.1543p pd=1.18u as=0.2304p ps=2u w=0.64u l=0.13u
X1939 VGND.t12 sg13cmos5l_inv_1_419.A sg13cmos5l_inv_1_420.A VGND.t11 sg13_lv_nmos ad=0.2516p pd=2.16u as=0.2516p ps=2.16u w=0.74u l=0.13u
X1940 a_9885_7704# sg13cmos5l_mux2_1_3.S VPWR.t1081 VPWR.t14 sg13_lv_pmos ad=0.3325p pd=1.665u as=0.253p ps=1.53u w=1u l=0.13u
X1941 VPWR.t1406 sg13cmos5l_mux4_1_6.A2 sg13cmos5l_inv_1_351.A VPWR.t29 sg13_lv_pmos ad=0.3808p pd=2.92u as=0.3808p ps=2.92u w=1.12u l=0.13u
X1942 VPWR.t310 sg13cmos5l_inv_1_592.A sg13cmos5l_inv_1_592.Y VPWR.t39 sg13_lv_pmos ad=0.3808p pd=2.92u as=0.3808p ps=2.92u w=1.12u l=0.13u
X1943 sg13cmos5l_inv_1_525.A sg13cmos5l_inv_1_509.Y VPWR.t476 VPWR.t26 sg13_lv_pmos ad=0.3808p pd=2.92u as=0.3808p ps=2.92u w=1.12u l=0.13u
X1944 sg13cmos5l_inv_1_699.A sg13cmos5l_inv_1_704.Y VPWR.t1504 VPWR.t2 sg13_lv_pmos ad=0.3808p pd=2.92u as=0.3808p ps=2.92u w=1.12u l=0.13u
X1945 sg13cmos5l_inv_1_655.Y sg13cmos5l_inv_1_654.Y VPWR.t981 VPWR.t26 sg13_lv_pmos ad=0.3808p pd=2.92u as=0.3808p ps=2.92u w=1.12u l=0.13u
X1946 VGND.t19 sg13cmos5l_inv_1_266.A sg13cmos5l_inv_1_266.Y VGND.t178 sg13_lv_nmos ad=0.2516p pd=2.16u as=0.2516p ps=2.16u w=0.74u l=0.13u
X1947 VPWR.t470 sg13cmos5l_inv_1_706.A sg13cmos5l_inv_1_707.A VPWR.t26 sg13_lv_pmos ad=0.3808p pd=2.92u as=0.3808p ps=2.92u w=1.12u l=0.13u
X1948 VGND.t26 sg13cmos5l_inv_1_720.Y sg13cmos5l_buf_1_19.A VGND.t25 sg13_lv_nmos ad=0.2516p pd=2.16u as=0.2516p ps=2.16u w=0.74u l=0.13u
X1949 VPWR.t222 VGND.t78 VPWR.t221 VPWR.t49 sg13_lv_pmos ad=0.34p pd=2.68u as=0 ps=0 w=1u l=1u
X1950 VPWR.t594 sg13cmos5l_inv_1_207.A sg13cmos5l_inv_1_207.Y VPWR.t0 sg13_lv_pmos ad=0.3808p pd=2.92u as=0.3808p ps=2.92u w=1.12u l=0.13u
X1951 a_14913_14524# sg13cmos5l_mux2_1_4.S.t4 a_13918_14482# VPWR.t21 sg13_lv_pmos ad=0.2225p pd=1.445u as=0.34p ps=2.68u w=1u l=0.13u
X1952 VPWR.t547 sg13cmos5l_inv_1_75.A sg13cmos5l_inv_1_75.Y VPWR.t49 sg13_lv_pmos ad=0.3808p pd=2.92u as=0.3808p ps=2.92u w=1.12u l=0.13u
X1953 VPWR.t1176 sg13cmos5l_inv_1_305.A a_4141_3195# VPWR.t8 sg13_lv_pmos ad=0.29275p pd=1.785u as=0.16p ps=1.32u w=1u l=0.13u
X1954 VPWR.t543 sg13cmos5l_inv_1_467.Y a_6637_8701# VPWR.t29 sg13_lv_pmos ad=0.29275p pd=1.785u as=0.16p ps=1.32u w=1u l=0.13u
X1955 VPWR.t1476 VGND.t567 VPWR.t1475 VPWR.t39 sg13_lv_pmos ad=0.34p pd=2.68u as=0 ps=0 w=1u l=1u
X1956 a_4438_8070# a_3623_8070# a_4362_8070# VGND.t467 sg13_lv_nmos ad=0.1776p pd=1.195u as=80f ps=0.89u w=0.64u l=0.13u
X1957 sg13cmos5l_inv_1_963.Y sg13cmos5l_inv_1_962.Y VGND.t153 VGND.t4 sg13_lv_nmos ad=0.2516p pd=2.16u as=0.2516p ps=2.16u w=0.74u l=0.13u
X1958 sg13cmos5l_inv_1_724.Y sg13cmos5l_mux4_1_12.A1 VPWR.t635 VPWR.t2 sg13_lv_pmos ad=0.3808p pd=2.92u as=0.3808p ps=2.92u w=1.12u l=0.13u
X1959 VPWR.t425 sg13cmos5l_inv_1_0.A sg13cmos5l_inv_1_0.Y VPWR.t11 sg13_lv_pmos ad=0.3808p pd=2.92u as=0.3808p ps=2.92u w=1.12u l=0.13u
X1960 VPWR.t1426 sg13cmos5l_inv_1_274.Y a_8309_3149# VPWR.t8 sg13_lv_pmos ad=0.34p pd=2.68u as=0.135p ps=1.27u w=1u l=0.13u
X1961 VPWR.t522 sg13cmos5l_inv_1_914.A sg13cmos5l_inv_1_913.A VPWR.t26 sg13_lv_pmos ad=0.3808p pd=2.92u as=0.3808p ps=2.92u w=1.12u l=0.13u
X1962 VGND.t64 sg13cmos5l_inv_1_36.A sg13cmos5l_inv_1_36.Y VGND.t261 sg13_lv_nmos ad=0.2516p pd=2.16u as=0.2516p ps=2.16u w=0.74u l=0.13u
X1963 sg13cmos5l_inv_1_809.Y sg13cmos5l_inv_1_810.Y VPWR.t675 VPWR.t42 sg13_lv_pmos ad=0.3808p pd=2.92u as=0.3808p ps=2.92u w=1.12u l=0.13u
X1964 VGND.t46 sg13cmos5l_mux4_1_8.A1 a_7700_15994# VGND.t45 sg13_lv_nmos ad=0.1824p pd=1.21u as=0.2304p ps=1.36u w=0.64u l=0.13u
X1965 VPWR.t866 sg13cmos5l_nor2b_1_0.B_N a_1006_15296# VPWR.t21 sg13_lv_pmos ad=0.2618p pd=1.63u as=0.2856p ps=2.36u w=0.84u l=0.13u
X1966 a_4438_8070# sg13cmos5l_mux4_1_5.S0.t4 a_4357_7731# VPWR.t14 sg13_lv_pmos ad=0.4425p pd=1.885u as=0.20762p ps=1.605u w=1u l=0.13u
X1967 VPWR.t1506 sg13cmos5l_inv_1_37.A sg13cmos5l_inv_1_37.Y VPWR.t8 sg13_lv_pmos ad=0.3808p pd=2.92u as=0.3808p ps=2.92u w=1.12u l=0.13u
X1968 VPWR.t1042 sg13cmos5l_inv_1_114.A sg13cmos5l_inv_1_114.Y VPWR.t29 sg13_lv_pmos ad=0.3808p pd=2.92u as=0.3808p ps=2.92u w=1.12u l=0.13u
X1969 sg13cmos5l_inv_1_417.Y sg13cmos5l_inv_1_452.Y VPWR.t1439 VPWR.t49 sg13_lv_pmos ad=0.3808p pd=2.92u as=0.3808p ps=2.92u w=1.12u l=0.13u
X1970 a_8638_6558# sg13cmos5l_mux4_1_5.S0.t3 a_8551_6219# VPWR.t0 sg13_lv_pmos ad=0.19p pd=1.38u as=0.415p ps=1.83u w=1u l=0.13u
X1971 sg13cmos5l_inv_1_202.Y sg13cmos5l_inv_1_116.Y VPWR.t1098 VPWR.t29 sg13_lv_pmos ad=0.3808p pd=2.92u as=0.3808p ps=2.92u w=1.12u l=0.13u
X1972 sg13cmos5l_inv_1_121.Y sg13cmos5l_inv_1_124.Y VPWR.t1024 VPWR.t14 sg13_lv_pmos ad=0.3808p pd=2.92u as=0.3808p ps=2.92u w=1.12u l=0.13u
X1973 sg13cmos5l_inv_1_169.Y sg13cmos5l_inv_1_130.Y VGND.t130 VGND.t209 sg13_lv_nmos ad=0.2516p pd=2.16u as=0.2516p ps=2.16u w=0.74u l=0.13u
X1974 VPWR.t883 sg13cmos5l_inv_1_112.A sg13cmos5l_inv_1_112.Y VPWR.t29 sg13_lv_pmos ad=0.3808p pd=2.92u as=0.3808p ps=2.92u w=1.12u l=0.13u
X1975 VGND.t56 sg13cmos5l_inv_1_600.A sg13cmos5l_inv_1_617.A VGND.t22 sg13_lv_nmos ad=0.2516p pd=2.16u as=0.2516p ps=2.16u w=0.74u l=0.13u
X1976 sg13cmos5l_inv_1_205.A sg13cmos5l_inv_1_145.Y VPWR.t1345 VPWR.t0 sg13_lv_pmos ad=0.3808p pd=2.92u as=0.3808p ps=2.92u w=1.12u l=0.13u
X1977 a_8638_6558# a_8327_6558# a_8564_6558# VGND.t138 sg13_lv_nmos ad=0.1472p pd=1.1u as=76.8f ps=0.88u w=0.64u l=0.13u
X1978 a_3860_8070# sg13cmos5l_inv_1_421.A VGND.t342 VGND.t1157 sg13_lv_nmos ad=76.8f pd=0.88u as=0.1872p ps=1.225u w=0.64u l=0.13u
X1979 sg13cmos5l_inv_1_189.Y sg13cmos5l_inv_1_194.Y VPWR.t511 VPWR.t49 sg13_lv_pmos ad=0.3808p pd=2.92u as=0.3808p ps=2.92u w=1.12u l=0.13u
X1980 sg13cmos5l_inv_1_213.A sg13cmos5l_inv_1_195.Y VGND.t113 VGND.t11 sg13_lv_nmos ad=0.2516p pd=2.16u as=0.2516p ps=2.16u w=0.74u l=0.13u
X1981 VGND.t212 sg13cmos5l_inv_1_217.A sg13cmos5l_inv_1_218.A VGND.t11 sg13_lv_nmos ad=0.2516p pd=2.16u as=0.2516p ps=2.16u w=0.74u l=0.13u
X1982 VGND.t126 sg13cmos5l_inv_1_740.A sg13cmos5l_inv_1_753.A VGND.t463 sg13_lv_nmos ad=0.2516p pd=2.16u as=0.2516p ps=2.16u w=0.74u l=0.13u
X1983 VGND.t939 sg13cmos5l_inv_1_447.A sg13cmos5l_inv_1_446.A VGND.t11 sg13_lv_nmos ad=0.2516p pd=2.16u as=0.2516p ps=2.16u w=0.74u l=0.13u
X1984 VGND.t492 sg13cmos5l_inv_1_7.A sg13cmos5l_inv_1_7.Y VGND.t1140 sg13_lv_nmos ad=0.2516p pd=2.16u as=0.2516p ps=2.16u w=0.74u l=0.13u
X1985 VGND.t16 VPWR.t1525 VGND.t233 VGND.t11 sg13_lv_nmos ad=0.1428p pd=1.52u as=0 ps=0 w=0.42u l=1u
X1986 sg13cmos5l_inv_1_8.A sg13cmos5l_inv_1_49.A VGND.t21 VGND.t431 sg13_lv_nmos ad=0.2516p pd=2.16u as=0.2516p ps=2.16u w=0.74u l=0.13u
X1987 sg13cmos5l_inv_1_460.Y sg13cmos5l_inv_1_459.Y VGND.t693 VGND.t11 sg13_lv_nmos ad=0.2516p pd=2.16u as=0.2516p ps=2.16u w=0.74u l=0.13u
X1988 VPWR.t1118 sg13cmos5l_buf_1_19.A sg13cmos5l_inv_1_711.Y VPWR.t26 sg13_lv_pmos ad=0.3808p pd=2.92u as=0.3808p ps=2.92u w=1.12u l=0.13u
X1989 sg13cmos5l_inv_1_585.A sg13cmos5l_inv_1_592.Y VPWR.t672 VPWR.t39 sg13_lv_pmos ad=0.3808p pd=2.92u as=0.3808p ps=2.92u w=1.12u l=0.13u
X1990 VGND.t100 sg13cmos5l_inv_1_562.A sg13cmos5l_inv_1_562.Y VGND.t22 sg13_lv_nmos ad=0.2516p pd=2.16u as=0.2516p ps=2.16u w=0.74u l=0.13u
X1991 a_14360_11776# a_14827_11673# a_14773_11771# VPWR.t2 sg13_lv_pmos ad=0.4425p pd=1.885u as=0.135p ps=1.27u w=1u l=0.13u
X1992 VGND.t19 sg13cmos5l_mux4_1_5.S1.t3 a_5005_3418# VGND.t649 sg13_lv_nmos ad=0.1543p pd=1.18u as=0.2304p ps=2u w=0.64u l=0.13u
X1993 VPWR.t1183 sg13cmos5l_inv_1_421.A sg13cmos5l_inv_1_421.Y VPWR.t49 sg13_lv_pmos ad=0.3808p pd=2.92u as=0.3808p ps=2.92u w=1.12u l=0.13u
X1994 VGND.t117 sg13cmos5l_inv_1_437.A sg13cmos5l_inv_1_436.A VGND.t11 sg13_lv_nmos ad=0.2516p pd=2.16u as=0.2516p ps=2.16u w=0.74u l=0.13u
X1995 VGND.t335 sg13cmos5l_inv_1_176.A sg13cmos5l_inv_1_177.A VGND.t883 sg13_lv_nmos ad=0.2516p pd=2.16u as=0.2516p ps=2.16u w=0.74u l=0.13u
X1996 VGND.t1564 VPWR.t1559 VGND.t508 VGND.t4 sg13_lv_nmos ad=79.8f pd=0.8u as=0 ps=0 w=0.42u l=1u
X1997 a_9443_9192# sg13cmos5l_mux2_1_3.S a_9341_9192# VPWR.t29 sg13_lv_pmos ad=0.2464p pd=1.56u as=0.2128p ps=1.5u w=1.12u l=0.13u
X1998 VGND.t143 sg13cmos5l_inv_1_467.Y sg13cmos5l_inv_1_984.Y VGND.t4 sg13_lv_nmos ad=0.2516p pd=2.16u as=0.2516p ps=2.16u w=0.74u l=0.13u
X1999 sg13cmos5l_inv_1_593.Y sg13cmos5l_inv_1_535.Y VGND.t44 VGND.t22 sg13_lv_nmos ad=0.2516p pd=2.16u as=0.2516p ps=2.16u w=0.74u l=0.13u
X2000 sg13cmos5l_inv_1_743.Y sg13cmos5l_inv_1_741.Y VGND.t174 VGND.t1091 sg13_lv_nmos ad=0.2516p pd=2.16u as=0.2516p ps=2.16u w=0.74u l=0.13u
X2001 VGND.t1513 VPWR.t1599 VGND.t1225 VGND.t1514 sg13_lv_nmos ad=79.8f pd=0.8u as=0 ps=0 w=0.42u l=1u
X2002 VPWR.t1263 sg13cmos5l_inv_1_532.Y a_4661_12221# VPWR.t2 sg13_lv_pmos ad=0.34p pd=2.68u as=0.135p ps=1.27u w=1u l=0.13u
X2003 sg13cmos5l_inv_1_350.Y sg13cmos5l_inv_1_350.A VGND.t984 VGND.t983 sg13_lv_nmos ad=0.2516p pd=2.16u as=0.2516p ps=2.16u w=0.74u l=0.13u
X2004 sg13cmos5l_inv_1_519.Y sg13cmos5l_inv_1_518.Y VGND.t147 VGND.t1175 sg13_lv_nmos ad=0.2516p pd=2.16u as=0.2516p ps=2.16u w=0.74u l=0.13u
X2005 VPWR.t1008 sg13cmos5l_inv_1_392.A sg13cmos5l_inv_1_393.A VPWR.t14 sg13_lv_pmos ad=0.3808p pd=2.92u as=0.3808p ps=2.92u w=1.12u l=0.13u
X2006 VGND.t162 sg13cmos5l_inv_1_394.A a_7071_8434# VGND.t769 sg13_lv_nmos ad=0.2176p pd=1.96u as=76.8f ps=0.88u w=0.64u l=0.13u
X2007 VPWR.t660 sg13cmos5l_inv_1_359.Y sg13cmos5l_inv_1_985.Y VPWR.t29 sg13_lv_pmos ad=0.3808p pd=2.92u as=0.3808p ps=2.92u w=1.12u l=0.13u
X2008 VGND.t52 sg13cmos5l_inv_1_326.Y sg13cmos5l_inv_1_331.A VGND.t1149 sg13_lv_nmos ad=0.2516p pd=2.16u as=0.2516p ps=2.16u w=0.74u l=0.13u
X2009 VPWR.t676 sg13cmos5l_inv_1_811.Y sg13cmos5l_inv_1_810.Y VPWR.t42 sg13_lv_pmos ad=0.3808p pd=2.92u as=0.3808p ps=2.92u w=1.12u l=0.13u
X2010 VPWR.t709 sg13cmos5l_inv_1_186.A sg13cmos5l_inv_1_186.Y VPWR.t49 sg13_lv_pmos ad=0.3808p pd=2.92u as=0.3808p ps=2.92u w=1.12u l=0.13u
X2011 sg13cmos5l_inv_1_236.A sg13cmos5l_inv_1_192.Y VGND.t212 VGND.t11 sg13_lv_nmos ad=0.2516p pd=2.16u as=0.2516p ps=2.16u w=0.74u l=0.13u
X2012 VPWR.t1429 sg13cmos5l_inv_1_612.Y sg13cmos5l_inv_1_599.Y VPWR.t39 sg13_lv_pmos ad=0.3808p pd=2.92u as=0.3808p ps=2.92u w=1.12u l=0.13u
X2013 VGND.t292 sg13cmos5l_inv_1_58.Y sg13cmos5l_inv_1_61.A VGND.t1388 sg13_lv_nmos ad=0.2516p pd=2.16u as=0.2516p ps=2.16u w=0.74u l=0.13u
X2014 VGND.t352 sg13cmos5l_inv_1_308.A sg13cmos5l_inv_1_308.Y VGND.t597 sg13_lv_nmos ad=0.2516p pd=2.16u as=0.2516p ps=2.16u w=0.74u l=0.13u
X2015 VPWR.t530 sg13cmos5l_inv_1_366.A sg13cmos5l_inv_1_366.Y VPWR.t29 sg13_lv_pmos ad=0.3808p pd=2.92u as=0.3808p ps=2.92u w=1.12u l=0.13u
X2016 VGND.t1599 VPWR.t1537 VGND.t947 VGND.t1600 sg13_lv_nmos ad=79.8f pd=0.8u as=0 ps=0 w=0.42u l=1u
X2017 VPWR.t271 sg13cmos5l_inv_1_545.A sg13cmos5l_inv_1_545.Y VPWR.t39 sg13_lv_pmos ad=0.3808p pd=2.92u as=0.3808p ps=2.92u w=1.12u l=0.13u
X2018 VGND.t529 sg13cmos5l_inv_1_666.Y sg13cmos5l_inv_1_510.A VGND.t528 sg13_lv_nmos ad=0.2516p pd=2.16u as=0.2516p ps=2.16u w=0.74u l=0.13u
X2019 VPWR.t970 sg13cmos5l_inv_1_440.A sg13cmos5l_inv_1_430.A VPWR.t49 sg13_lv_pmos ad=0.3808p pd=2.92u as=0.3808p ps=2.92u w=1.12u l=0.13u
X2020 a_4661_3149# a_3623_3534# a_4438_3534# VPWR.t8 sg13_lv_pmos ad=0.135p pd=1.27u as=0.4425p ps=1.885u w=1u l=0.13u
X2021 VPWR.t811 sg13cmos5l_inv_1_825.A sg13cmos5l_inv_1_827.A VPWR.t39 sg13_lv_pmos ad=0.3808p pd=2.92u as=0.3808p ps=2.92u w=1.12u l=0.13u
X2022 VGND.t35 sg13cmos5l_inv_1_862.A sg13cmos5l_mux4_1_13.A0 VGND.t277 sg13_lv_nmos ad=0.2516p pd=2.16u as=0.2516p ps=2.16u w=0.74u l=0.13u
X2023 a_14119_15291# sg13cmos5l_mux4_1_13.A0 VPWR.t359 VPWR.t21 sg13_lv_pmos ad=0.415p pd=1.83u as=0.22315p ps=1.555u w=1u l=0.13u
X2024 sg13cmos5l_nor4_1_0.A sg13cmos5l_mux2_1_0.X VGND.t191 VGND.t190 sg13_lv_nmos ad=0.2618p pd=2.22u as=0.1463p ps=1.15u w=0.77u l=0.13u
X2025 VPWR.t226 VGND.t78 VPWR.t225 VPWR.t8 sg13_lv_pmos ad=0.34p pd=2.68u as=0 ps=0 w=1u l=1u
X2026 sg13cmos5l_inv_1_963.Y sg13cmos5l_inv_1_962.Y VPWR.t1005 VPWR.t29 sg13_lv_pmos ad=0.3808p pd=2.92u as=0.3808p ps=2.92u w=1.12u l=0.13u
X2027 VGND.t64 sg13cmos5l_inv_1_0.A sg13cmos5l_inv_1_0.Y VGND.t261 sg13_lv_nmos ad=0.2516p pd=2.16u as=0.2516p ps=2.16u w=0.74u l=0.13u
X2028 sg13cmos5l_inv_1_908.A sg13cmos5l_inv_1_882.Y VPWR.t637 VPWR.t21 sg13_lv_pmos ad=0.3808p pd=2.92u as=0.3808p ps=2.92u w=1.12u l=0.13u
X2029 VGND.t396 sg13cmos5l_inv_1_88.A sg13cmos5l_inv_1_88.Y VGND.t1350 sg13_lv_nmos ad=0.2516p pd=2.16u as=0.2516p ps=2.16u w=0.74u l=0.13u
X2030 VGND.t90 sg13cmos5l_inv_1_767.A sg13cmos5l_inv_1_766.A VGND.t294 sg13_lv_nmos ad=0.2516p pd=2.16u as=0.2516p ps=2.16u w=0.74u l=0.13u
X2031 sg13cmos5l_inv_1_515.A sg13cmos5l_inv_1_504.Y VPWR.t986 VPWR.t2 sg13_lv_pmos ad=0.3808p pd=2.92u as=0.3808p ps=2.92u w=1.12u l=0.13u
X2032 sg13cmos5l_inv_1_279.Y sg13cmos5l_inv_1_277.Y VPWR.t808 VPWR.t8 sg13_lv_pmos ad=0.3808p pd=2.92u as=0.3808p ps=2.92u w=1.12u l=0.13u
X2033 VPWR.t904 VGND.t225 VPWR.t903 VPWR.t0 sg13_lv_pmos ad=0.34p pd=2.68u as=0 ps=0 w=1u l=1u
X2034 VPWR.t848 sg13cmos5l_inv_1_177.A sg13cmos5l_inv_1_177.Y VPWR.t14 sg13_lv_pmos ad=0.3808p pd=2.92u as=0.3808p ps=2.92u w=1.12u l=0.13u
X2035 VPWR.t924 sg13cmos5l_mux4_1_5.S0.t4 a_3623_8070# VPWR.t14 sg13_lv_pmos ad=0.22315p pd=1.555u as=0.34p ps=2.68u w=1u l=0.13u
X2036 sg13cmos5l_inv_1_152.Y sg13cmos5l_inv_1_211.Y VGND.t335 VGND.t1303 sg13_lv_nmos ad=0.2516p pd=2.16u as=0.2516p ps=2.16u w=0.74u l=0.13u
X2037 VGND.t329 sg13cmos5l_inv_1_633.A sg13cmos5l_inv_1_632.A VGND.t840 sg13_lv_nmos ad=0.2516p pd=2.16u as=0.2516p ps=2.16u w=0.74u l=0.13u
X2038 sg13cmos5l_inv_1_88.A sg13cmos5l_inv_1_85.Y VPWR.t1497 VPWR.t49 sg13_lv_pmos ad=0.3808p pd=2.92u as=0.3808p ps=2.92u w=1.12u l=0.13u
X2039 sg13cmos5l_inv_1_807.Y sg13cmos5l_inv_1_807.A VPWR.t475 VPWR.t42 sg13_lv_pmos ad=0.3808p pd=2.92u as=0.3808p ps=2.92u w=1.12u l=0.13u
X2040 sg13cmos5l_inv_1_809.Y sg13cmos5l_inv_1_810.Y VGND.t23 VGND.t22 sg13_lv_nmos ad=0.2516p pd=2.16u as=0.2516p ps=2.16u w=0.74u l=0.13u
X2041 VGND.t1 sg13cmos5l_inv_1_105.A sg13cmos5l_inv_1_105.Y VGND.t686 sg13_lv_nmos ad=0.2516p pd=2.16u as=0.2516p ps=2.16u w=0.74u l=0.13u
X2042 sg13cmos5l_inv_1_442.A sg13cmos5l_inv_1_453.Y VPWR.t414 VPWR.t11 sg13_lv_pmos ad=0.3808p pd=2.92u as=0.3808p ps=2.92u w=1.12u l=0.13u
X2043 VGND.t12 sg13cmos5l_inv_1_434.A sg13cmos5l_inv_1_419.A VGND.t11 sg13_lv_nmos ad=0.2516p pd=2.16u as=0.2516p ps=2.16u w=0.74u l=0.13u
X2044 sg13cmos5l_inv_1_844.Y sg13cmos5l_inv_1_874.Y VGND.t171 VGND.t599 sg13_lv_nmos ad=0.2516p pd=2.16u as=0.2516p ps=2.16u w=0.74u l=0.13u
X2045 a_16723_7731# sg13cmos5l_buf_1_8.A.t2 a_15637_8028# VPWR.t14 sg13_lv_pmos ad=0.415p pd=1.83u as=0.19p ps=1.38u w=1u l=0.13u
X2046 sg13cmos5l_inv_1_122.A sg13cmos5l_inv_1_121.Y VPWR.t1103 VPWR.t14 sg13_lv_pmos ad=0.3808p pd=2.92u as=0.3808p ps=2.92u w=1.12u l=0.13u
X2047 sg13cmos5l_inv_1_394.A sg13cmos5l_inv_1_964.Y VGND.t191 VGND.t4 sg13_lv_nmos ad=0.2516p pd=2.16u as=0.2516p ps=2.16u w=0.74u l=0.13u
X2048 sg13cmos5l_inv_1_748.Y sg13cmos5l_inv_1_748.A VPWR.t712 VPWR.t2 sg13_lv_pmos ad=0.3808p pd=2.92u as=0.3808p ps=2.92u w=1.12u l=0.13u
X2049 VPWR.t1442 sg13cmos5l_inv_1_445.A sg13cmos5l_inv_1_447.A VPWR.t0 sg13_lv_pmos ad=0.3808p pd=2.92u as=0.3808p ps=2.92u w=1.12u l=0.13u
X2050 sg13cmos5l_inv_1_111.A sg13cmos5l_inv_1_135.Y VGND.t947 VGND.t1177 sg13_lv_nmos ad=0.2516p pd=2.16u as=0.2516p ps=2.16u w=0.74u l=0.13u
X2051 sg13cmos5l_inv_1_121.Y sg13cmos5l_inv_1_124.Y VGND.t971 VGND.t970 sg13_lv_nmos ad=0.2516p pd=2.16u as=0.2516p ps=2.16u w=0.74u l=0.13u
X2052 a_14420_9582# sg13cmos5l_inv_1_113.A VGND.t8 VGND.t296 sg13_lv_nmos ad=76.8f pd=0.88u as=0.1872p ps=1.225u w=0.64u l=0.13u
X2053 sg13cmos5l_inv_1_228.A sg13cmos5l_inv_1_83.Y VPWR.t463 VPWR.t49 sg13_lv_pmos ad=0.3808p pd=2.92u as=0.3808p ps=2.92u w=1.12u l=0.13u
X2054 VGND.t105 a_9659_7736# a_10096_8050# VGND.t928 sg13_lv_nmos ad=0.148p pd=1.14u as=0.3367p ps=1.65u w=0.74u l=0.13u
X2055 sg13cmos5l_inv_1_108.Y sg13cmos5l_mux4_1_16.A2 VGND.t354 VGND.t353 sg13_lv_nmos ad=0.2516p pd=2.16u as=0.2516p ps=2.16u w=0.74u l=0.13u
X2056 sg13cmos5l_inv_1_650.A sg13cmos5l_inv_1_651.Y VGND.t250 VGND.t426 sg13_lv_nmos ad=0.2516p pd=2.16u as=0.2516p ps=2.16u w=0.74u l=0.13u
X2057 VGND.t244 sg13cmos5l_inv_1_243.A sg13cmos5l_inv_1_273.A VGND.t537 sg13_lv_nmos ad=0.2516p pd=2.16u as=0.2516p ps=2.16u w=0.74u l=0.13u
X2058 a_16021_7685# sg13cmos5l_inv_1_149.A VPWR.t1404 VPWR.t14 sg13_lv_pmos ad=0.135p pd=1.27u as=0.34p ps=2.68u w=1u l=0.13u
X2059 VPWR.t376 sg13cmos5l_inv_1_770.A sg13cmos5l_inv_1_772.A VPWR.t39 sg13_lv_pmos ad=0.3808p pd=2.92u as=0.3808p ps=2.92u w=1.12u l=0.13u
X2060 VGND.t263 sg13cmos5l_mux4_1_10.A3 a_4575_15994# VGND.t1449 sg13_lv_nmos ad=0.2176p pd=1.96u as=76.8f ps=0.88u w=0.64u l=0.13u
X2061 VGND.t529 VPWR.t1592 VGND.t987 VGND.t1519 sg13_lv_nmos ad=0.1428p pd=1.52u as=0 ps=0 w=0.42u l=1u
X2062 a_7637_13283# a_6599_12970# a_7414_12970# VPWR.t26 sg13_lv_pmos ad=0.135p pd=1.27u as=0.4425p ps=1.885u w=1u l=0.13u
X2063 VGND.t191 sg13cmos5l_mux2_1_3.X a_10162_9570# VGND.t4 sg13_lv_nmos ad=0.1406p pd=1.12u as=0.1406p ps=1.12u w=0.74u l=0.15u
X2064 VPWR.t542 sg13cmos5l_inv_1_467.Y sg13cmos5l_inv_1_984.Y VPWR.t29 sg13_lv_pmos ad=0.3808p pd=2.92u as=0.3808p ps=2.92u w=1.12u l=0.13u
X2065 sg13cmos5l_inv_1_721.A sg13cmos5l_inv_1_712.A VGND.t39 VGND.t38 sg13_lv_nmos ad=0.2516p pd=2.16u as=0.2516p ps=2.16u w=0.74u l=0.13u
X2066 sg13cmos5l_inv_1_128.Y sg13cmos5l_inv_1_111.Y VPWR.t1409 VPWR.t0 sg13_lv_pmos ad=0.3808p pd=2.92u as=0.3808p ps=2.92u w=1.12u l=0.13u
X2067 VGND.t250 sg13cmos5l_inv_1_690.A sg13cmos5l_inv_1_642.A VGND.t393 sg13_lv_nmos ad=0.2516p pd=2.16u as=0.2516p ps=2.16u w=0.74u l=0.13u
X2068 VGND.t567 sg13cmos5l_inv_1_811.Y sg13cmos5l_inv_1_810.Y VGND.t22 sg13_lv_nmos ad=0.2516p pd=2.16u as=0.2516p ps=2.16u w=0.74u l=0.13u
X2069 VGND.t437 sg13cmos5l_inv_1_675.A sg13cmos5l_inv_1_669.A VGND.t1159 sg13_lv_nmos ad=0.2516p pd=2.16u as=0.2516p ps=2.16u w=0.74u l=0.13u
X2070 VGND.t612 sg13cmos5l_inv_1_735.Y sg13cmos5l_inv_1_736.Y VGND.t877 sg13_lv_nmos ad=0.2516p pd=2.16u as=0.2516p ps=2.16u w=0.74u l=0.13u
X2071 VPWR.t415 sg13cmos5l_inv_1_320.Y sg13cmos5l_inv_1_314.Y VPWR.t49 sg13_lv_pmos ad=0.3808p pd=2.92u as=0.3808p ps=2.92u w=1.12u l=0.13u
X2072 sg13cmos5l_inv_1_231.Y sg13cmos5l_inv_1_222.Y VPWR.t797 VPWR.t49 sg13_lv_pmos ad=0.3808p pd=2.92u as=0.3808p ps=2.92u w=1.12u l=0.13u
X2073 sg13cmos5l_inv_1_215.Y sg13cmos5l_inv_1_106.Y VGND.t1 VGND.t0 sg13_lv_nmos ad=0.2516p pd=2.16u as=0.2516p ps=2.16u w=0.74u l=0.13u
X2074 sg13cmos5l_inv_1_514.A sg13cmos5l_inv_1_513.A VGND.t145 VGND.t943 sg13_lv_nmos ad=0.2516p pd=2.16u as=0.2516p ps=2.16u w=0.74u l=0.13u
X2075 VPWR.t744 sg13cmos5l_mux4_1_5.S1.t5 a_9709_6442# VPWR.t0 sg13_lv_pmos ad=0.34367p pd=1.775u as=0.34p ps=2.68u w=1u l=0.13u
X2076 sg13cmos5l_inv_1_95.A sg13cmos5l_buf_1_0.A VGND.t123 VGND.t122 sg13_lv_nmos ad=0.2516p pd=2.16u as=0.2516p ps=2.16u w=0.74u l=0.13u
X2077 sg13cmos5l_mux4_1_11.A2 a_14913_12564# VPWR.t1006 VPWR.t2 sg13_lv_pmos ad=0.3808p pd=2.92u as=0.34367p ps=1.775u w=1.12u l=0.13u
X2078 VPWR.t1231 sg13cmos5l_inv_1_553.A sg13cmos5l_inv_1_553.Y VPWR.t39 sg13_lv_pmos ad=0.3808p pd=2.92u as=0.3808p ps=2.92u w=1.12u l=0.13u
X2079 VGND.t35 sg13cmos5l_inv_1_815.A sg13cmos5l_inv_1_815.Y VGND.t277 sg13_lv_nmos ad=0.2516p pd=2.16u as=0.2516p ps=2.16u w=0.74u l=0.13u
X2080 a_14027_11654# a_14171_11488# a_14389_11500# VGND.t1100 sg13_lv_nmos ad=0.1216p pd=1.02u as=0.2176p ps=1.96u w=0.64u l=0.13u
X2081 VPWR.t1171 sg13cmos5l_inv_1_945.Y sg13cmos5l_inv_1_238.A VPWR.t11 sg13_lv_pmos ad=0.3808p pd=2.92u as=0.3808p ps=2.92u w=1.12u l=0.13u
X2082 a_16828_8070# a_16075_7649# a_15637_8028# VGND.t719 sg13_lv_nmos ad=76.8f pd=0.88u as=0.1472p ps=1.1u w=0.64u l=0.13u
X2083 VPWR.t77 VGND.t126 VPWR.t76 VPWR.t26 sg13_lv_pmos ad=0.34p pd=2.68u as=0 ps=0 w=1u l=1u
X2084 sg13cmos5l_inv_1_626.Y sg13cmos5l_inv_1_593.Y VPWR.t1430 VPWR.t39 sg13_lv_pmos ad=0.3808p pd=2.92u as=0.3808p ps=2.92u w=1.12u l=0.13u
X2085 sg13cmos5l_inv_1_730.Y sg13cmos5l_inv_1_730.A VGND.t184 VGND.t927 sg13_lv_nmos ad=0.2516p pd=2.16u as=0.2516p ps=2.16u w=0.74u l=0.13u
X2086 sg13cmos5l_inv_1_396.Y sg13cmos5l_inv_1_391.Y VGND.t354 VGND.t1026 sg13_lv_nmos ad=0.2516p pd=2.16u as=0.2516p ps=2.16u w=0.74u l=0.13u
X2087 sg13cmos5l_inv_1_207.A sg13cmos5l_inv_1_209.Y VGND.t113 VGND.t11 sg13_lv_nmos ad=0.2516p pd=2.16u as=0.2516p ps=2.16u w=0.74u l=0.13u
X2088 sg13cmos5l_inv_1_22.Y sg13cmos5l_inv_1_22.A VPWR.t1348 VPWR.t11 sg13_lv_pmos ad=0.3808p pd=2.92u as=0.3808p ps=2.92u w=1.12u l=0.13u
X2089 VPWR.t152 VGND.t46 VPWR.t150 VPWR.t21 sg13_lv_pmos ad=0.19p pd=1.38u as=0 ps=0 w=1u l=1u
X2090 VGND.t90 sg13cmos5l_inv_1_787.Y sg13cmos5l_inv_1_768.A VGND.t801 sg13_lv_nmos ad=0.2516p pd=2.16u as=0.2516p ps=2.16u w=0.74u l=0.13u
X2091 VGND.t107 sg13cmos5l_inv_1_381.Y sg13cmos5l_inv_1_386.Y VGND.t366 sg13_lv_nmos ad=0.2516p pd=2.16u as=0.2516p ps=2.16u w=0.74u l=0.13u
X2092 VPWR.t451 sg13cmos5l_inv_1_767.A sg13cmos5l_inv_1_766.A VPWR.t21 sg13_lv_pmos ad=0.3808p pd=2.92u as=0.3808p ps=2.92u w=1.12u l=0.13u
X2093 VPWR.t1264 sg13cmos5l_inv_1_666.Y sg13cmos5l_inv_1_510.A VPWR.t26 sg13_lv_pmos ad=0.3808p pd=2.92u as=0.3808p ps=2.92u w=1.12u l=0.13u
X2094 a_14614_3534# sg13cmos5l_mux4_1_5.S1.t1 a_14533_3195# VPWR.t8 sg13_lv_pmos ad=0.4425p pd=1.885u as=0.20762p ps=1.605u w=1u l=0.13u
X2095 sg13cmos5l_inv_1_807.Y sg13cmos5l_inv_1_807.A VGND.t23 VGND.t22 sg13_lv_nmos ad=0.2516p pd=2.16u as=0.2516p ps=2.16u w=0.74u l=0.13u
X2096 VPWR.t1045 sg13cmos5l_inv_1_141.Y sg13cmos5l_inv_1_175.A VPWR.t14 sg13_lv_pmos ad=0.3808p pd=2.92u as=0.3808p ps=2.92u w=1.12u l=0.13u
X2097 sg13cmos5l_inv_1_22.A sg13cmos5l_inv_1_45.Y VPWR.t1360 VPWR.t8 sg13_lv_pmos ad=0.3808p pd=2.92u as=0.3808p ps=2.92u w=1.12u l=0.13u
X2098 VGND.t335 sg13cmos5l_inv_1_174.A sg13cmos5l_inv_1_149.A VGND.t1076 sg13_lv_nmos ad=0.2516p pd=2.16u as=0.2516p ps=2.16u w=0.74u l=0.13u
X2099 sg13cmos5l_inv_1_737.A sg13cmos5l_inv_1_738.Y VGND.t41 VGND.t1049 sg13_lv_nmos ad=0.2516p pd=2.16u as=0.2516p ps=2.16u w=0.74u l=0.13u
X2100 sg13cmos5l_inv_1_98.Y sg13cmos5l_inv_1_101.Y VPWR.t1178 VPWR.t8 sg13_lv_pmos ad=0.3808p pd=2.92u as=0.3808p ps=2.92u w=1.12u l=0.13u
X2101 VGND.t529 sg13cmos5l_inv_1_685.Y sg13cmos5l_inv_1_680.A VGND.t528 sg13_lv_nmos ad=0.2516p pd=2.16u as=0.2516p ps=2.16u w=0.74u l=0.13u
X2102 VGND.t435 sg13cmos5l_inv_1_38.Y sg13cmos5l_inv_1_16.A VGND.t1485 sg13_lv_nmos ad=0.2516p pd=2.16u as=0.2516p ps=2.16u w=0.74u l=0.13u
X2103 a_14422_14482# a_14989_14488# a_14913_14524# VPWR.t21 sg13_lv_pmos ad=0.34p pd=2.68u as=0.2225p ps=1.445u w=1u l=0.13u
X2104 VPWR.t1315 sg13cmos5l_inv_1_425.A sg13cmos5l_inv_1_424.A VPWR.t49 sg13_lv_pmos ad=0.3808p pd=2.92u as=0.3808p ps=2.92u w=1.12u l=0.13u
X2105 sg13cmos5l_inv_1_122.A sg13cmos5l_inv_1_121.Y VGND.t267 VGND.t1064 sg13_lv_nmos ad=0.2516p pd=2.16u as=0.2516p ps=2.16u w=0.74u l=0.13u
X2106 sg13cmos5l_mux2_1_2.A0 a_4929_16036# VGND.t263 VGND.t1211 sg13_lv_nmos ad=0.2516p pd=2.16u as=0.1543p ps=1.18u w=0.74u l=0.13u
X2107 sg13cmos5l_inv_1_394.A sg13cmos5l_inv_1_964.Y VPWR.t809 VPWR.t29 sg13_lv_pmos ad=0.3808p pd=2.92u as=0.3808p ps=2.92u w=1.12u l=0.13u
X2108 VPWR.t1459 sg13cmos5l_inv_1_830.A sg13cmos5l_inv_1_820.A VPWR.t39 sg13_lv_pmos ad=0.3808p pd=2.92u as=0.3808p ps=2.92u w=1.12u l=0.13u
X2109 a_3847_3195# sg13cmos5l_inv_1_322.A VPWR.t286 VPWR.t8 sg13_lv_pmos ad=0.415p pd=1.83u as=0.22315p ps=1.555u w=1u l=0.13u
X2110 sg13cmos5l_inv_1_376.A sg13cmos5l_inv_1_369.A VPWR.t1020 VPWR.t14 sg13_lv_pmos ad=0.3808p pd=2.92u as=0.3808p ps=2.92u w=1.12u l=0.13u
X2111 VGND.t140 VPWR.t1609 VGND.t140 VGND.t22 sg13_lv_nmos ad=0.1428p pd=1.52u as=0 ps=0 w=0.42u l=1u
X2112 sg13cmos5l_a21oi_1_0.A2 sg13cmos5l_nor3_1_1.A a_8383_12608# VGND.t1068 sg13_lv_nmos ad=0.2664p pd=1.46u as=0.13875p ps=1.115u w=0.74u l=0.13u
X2113 VGND.t723 sg13cmos5l_inv_1_479.Y sg13cmos5l_inv_1_676.Y VGND.t1062 sg13_lv_nmos ad=0.2516p pd=2.16u as=0.2516p ps=2.16u w=0.74u l=0.13u
X2114 VPWR.t206 VGND.t414 VPWR.t205 VPWR.t5 sg13_lv_pmos ad=0.34p pd=2.68u as=0 ps=0 w=1u l=1u
X2115 a_14837_3149# a_13799_3534# a_14614_3534# VPWR.t8 sg13_lv_pmos ad=0.135p pd=1.27u as=0.4425p ps=1.885u w=1u l=0.13u
X2116 VPWR.t731 sg13cmos5l_inv_1_327.A sg13cmos5l_inv_1_328.A VPWR.t8 sg13_lv_pmos ad=0.3808p pd=2.92u as=0.3808p ps=2.92u w=1.12u l=0.13u
X2117 osc_tap[6] a_18856_16752# VPWR.t276 VPWR.t42 sg13_lv_pmos ad=0.42p pd=2.99u as=0.2114p ps=1.54u w=1.12u l=0.13u
X2118 VPWR.t600 sg13cmos5l_inv_1_431.A sg13cmos5l_inv_1_349.A VPWR.t0 sg13_lv_pmos ad=0.3808p pd=2.92u as=0.3808p ps=2.92u w=1.12u l=0.13u
X2119 a_3934_12606# sg13cmos5l_buf_1_8.A.t4 a_3847_12267# VPWR.t2 sg13_lv_pmos ad=0.19p pd=1.38u as=0.415p ps=1.83u w=1u l=0.13u
X2120 a_14865_11458# sg13cmos5l_mux4_1_11.A3 VGND.t444 VGND.t490 sg13_lv_nmos ad=76.8f pd=0.88u as=0.2176p ps=1.96u w=0.64u l=0.13u
X2121 VPWR.t1412 sg13cmos5l_inv_1_36.Y sg13cmos5l_inv_1_44.A VPWR.t8 sg13_lv_pmos ad=0.3808p pd=2.92u as=0.3808p ps=2.92u w=1.12u l=0.13u
X2122 sg13cmos5l_buf_1_8.A.t0 a_2920_3932# VPWR.t657 VPWR.t49 sg13_lv_pmos ad=0.42p pd=2.99u as=0.2114p ps=1.54u w=1.12u l=0.13u
X2123 VPWR.t1092 sg13cmos5l_inv_1_179.A sg13cmos5l_inv_1_150.A VPWR.t14 sg13_lv_pmos ad=0.3808p pd=2.92u as=0.3808p ps=2.92u w=1.12u l=0.13u
X2124 VPWR.t790 sg13cmos5l_inv_1_489.A sg13cmos5l_inv_1_488.A VPWR.t2 sg13_lv_pmos ad=0.3808p pd=2.92u as=0.3808p ps=2.92u w=1.12u l=0.13u
X2125 sg13cmos5l_inv_1_600.A sg13cmos5l_inv_1_598.A VGND.t56 VGND.t22 sg13_lv_nmos ad=0.2516p pd=2.16u as=0.2516p ps=2.16u w=0.74u l=0.13u
X2126 sg13cmos5l_inv_1_604.Y sg13cmos5l_inv_1_605.Y VGND.t310 VGND.t1390 sg13_lv_nmos ad=0.2516p pd=2.16u as=0.2516p ps=2.16u w=0.74u l=0.13u
X2127 VGND.t188 sg13cmos5l_a21oi_1_0.A2 a_8417_11480# VGND.t187 sg13_lv_nmos ad=0.2516p pd=2.16u as=0.1406p ps=1.12u w=0.74u l=0.13u
X2128 sg13cmos5l_inv_1_309.Y sg13cmos5l_inv_1_304.Y VPWR.t139 VPWR.t11 sg13_lv_pmos ad=0.3808p pd=2.92u as=0.3808p ps=2.92u w=1.12u l=0.13u
X2129 a_14559_14482# sg13cmos5l_buf_1_9.A.t4 a_14422_14482# VGND.t637 sg13_lv_nmos ad=76.8f pd=0.88u as=0.1776p ps=1.195u w=0.64u l=0.13u
X2130 sg13cmos5l_inv_1_340.Y sg13cmos5l_inv_1_341.Y VGND.t449 VGND.t448 sg13_lv_nmos ad=0.2516p pd=2.16u as=0.2516p ps=2.16u w=0.74u l=0.13u
X2131 VGND.t1 sg13cmos5l_inv_1_130.A sg13cmos5l_inv_1_130.Y VGND.t686 sg13_lv_nmos ad=0.2516p pd=2.16u as=0.2516p ps=2.16u w=0.74u l=0.13u
X2132 VPWR.t978 invsel[2] a_808_6956# VPWR.t14 sg13_lv_pmos ad=0.2114p pd=1.54u as=0.2856p ps=2.36u w=0.84u l=0.13u
X2133 sg13cmos5l_inv_1_787.Y sg13cmos5l_inv_1_800.Y VGND.t90 VGND.t1338 sg13_lv_nmos ad=0.2516p pd=2.16u as=0.2516p ps=2.16u w=0.74u l=0.13u
X2134 VGND.t133 sg13cmos5l_inv_1_496.A sg13cmos5l_inv_1_495.A VGND.t545 sg13_lv_nmos ad=0.2516p pd=2.16u as=0.2516p ps=2.16u w=0.74u l=0.13u
X2135 VGND.t250 sg13cmos5l_inv_1_644.A sg13cmos5l_inv_1_692.A VGND.t682 sg13_lv_nmos ad=0.2516p pd=2.16u as=0.2516p ps=2.16u w=0.74u l=0.13u
X2136 VPWR.t25 VGND.t947 VPWR.t24 VPWR.t0 sg13_lv_pmos ad=0.19p pd=1.38u as=0 ps=0 w=1u l=1u
X2137 VGND.t354 sg13cmos5l_inv_1_445.A a_9279_6558# VGND.t1442 sg13_lv_nmos ad=0.2176p pd=1.96u as=76.8f ps=0.88u w=0.64u l=0.13u
X2138 a_4575_8070# sg13cmos5l_mux4_1_5.S0.t4 a_4438_8070# VGND.t864 sg13_lv_nmos ad=76.8f pd=0.88u as=0.1776p ps=1.195u w=0.64u l=0.13u
X2139 VGND.t225 sg13cmos5l_inv_1_443.Y sg13cmos5l_inv_1_445.A VGND.t11 sg13_lv_nmos ad=0.2516p pd=2.16u as=0.2516p ps=2.16u w=0.74u l=0.13u
X2140 sg13cmos5l_inv_1_957.Y sg13cmos5l_inv_1_956.Y VGND.t10 VGND.t698 sg13_lv_nmos ad=0.2516p pd=2.16u as=0.2516p ps=2.16u w=0.74u l=0.13u
X2141 sg13cmos5l_inv_1_650.A sg13cmos5l_inv_1_651.Y VPWR.t562 VPWR.t26 sg13_lv_pmos ad=0.3808p pd=2.92u as=0.3808p ps=2.92u w=1.12u l=0.13u
X2142 a_15662_4084# sg13cmos5l_mux4_1_2.X a_15834_4192# VPWR.t49 sg13_lv_pmos ad=0.2225p pd=1.445u as=0.2975p ps=1.595u w=1u l=0.13u
X2143 VPWR.t214 VGND.t188 VPWR.t111 VPWR.t2 sg13_lv_pmos ad=0.19p pd=1.38u as=0 ps=0 w=1u l=1u
X2144 VPWR.t458 sg13cmos5l_inv_1_721.A sg13cmos5l_inv_1_713.A VPWR.t2 sg13_lv_pmos ad=0.3808p pd=2.92u as=0.3808p ps=2.92u w=1.12u l=0.13u
X2145 VPWR.t405 sg13cmos5l_inv_1_224.A sg13cmos5l_inv_1_224.Y VPWR.t0 sg13_lv_pmos ad=0.3808p pd=2.92u as=0.3808p ps=2.92u w=1.12u l=0.13u
X2146 VGND.t162 VPWR.t1555 VGND.t162 VGND.t1575 sg13_lv_nmos ad=0.1428p pd=1.52u as=0 ps=0 w=0.42u l=1u
X2147 VGND.t322 sg13cmos5l_inv_1_526.A sg13cmos5l_inv_1_526.Y VGND.t455 sg13_lv_nmos ad=0.2516p pd=2.16u as=0.2516p ps=2.16u w=0.74u l=0.13u
X2148 a_13844_12606# sg13cmos5l_inv_1_747.Y VGND.t478 VGND.t495 sg13_lv_nmos ad=76.8f pd=0.88u as=0.1872p ps=1.225u w=0.64u l=0.13u
X2149 VPWR.t23 VGND.t1503 VPWR.t22 VPWR.t21 sg13_lv_pmos ad=0.34p pd=2.68u as=0 ps=0 w=1u l=1u
X2150 VPWR.t1416 sg13cmos5l_inv_1_815.A sg13cmos5l_inv_1_815.Y VPWR.t21 sg13_lv_pmos ad=0.3808p pd=2.92u as=0.3808p ps=2.92u w=1.12u l=0.13u
X2151 sg13cmos5l_inv_1_184.A sg13cmos5l_inv_1_225.Y VPWR.t389 VPWR.t0 sg13_lv_pmos ad=0.3808p pd=2.92u as=0.3808p ps=2.92u w=1.12u l=0.13u
X2152 sg13cmos5l_mux4_1_3.X a_8577_3492# VGND.t73 VGND.t226 sg13_lv_nmos ad=0.2516p pd=2.16u as=0.1543p ps=1.18u w=0.74u l=0.13u
X2153 sg13cmos5l_inv_1_162.A sg13cmos5l_inv_1_157.Y VPWR.t1057 VPWR.t29 sg13_lv_pmos ad=0.3808p pd=2.92u as=0.3808p ps=2.92u w=1.12u l=0.13u
X2154 sg13cmos5l_inv_1_974.Y sg13cmos5l_inv_1_974.A VGND.t5 VGND.t4 sg13_lv_nmos ad=0.2516p pd=2.16u as=0.2516p ps=2.16u w=0.74u l=0.13u
X2155 VPWR.t370 sg13cmos5l_mux4_1_11.A2 a_15056_11771# VPWR.t2 sg13_lv_pmos ad=0.29275p pd=1.785u as=0.20762p ps=1.605u w=1u l=0.13u
X2156 sg13cmos5l_inv_1_290.Y sg13cmos5l_inv_1_466.Y VGND.t399 VGND.t623 sg13_lv_nmos ad=0.2516p pd=2.16u as=0.2516p ps=2.16u w=0.74u l=0.13u
X2157 sg13cmos5l_inv_1_871.Y sg13cmos5l_inv_1_866.Y VPWR.t1387 VPWR.t42 sg13_lv_pmos ad=0.3808p pd=2.92u as=0.3808p ps=2.92u w=1.12u l=0.13u
X2158 VGND.t134 sg13cmos5l_inv_1_414.A sg13cmos5l_inv_1_415.A VGND.t11 sg13_lv_nmos ad=0.2516p pd=2.16u as=0.2516p ps=2.16u w=0.74u l=0.13u
X2159 sg13cmos5l_inv_1_592.A sg13cmos5l_inv_1_610.Y VPWR.t893 VPWR.t39 sg13_lv_pmos ad=0.3808p pd=2.92u as=0.3808p ps=2.92u w=1.12u l=0.13u
X2160 sg13cmos5l_inv_1_22.Y sg13cmos5l_inv_1_22.A VGND.t547 VGND.t1343 sg13_lv_nmos ad=0.2516p pd=2.16u as=0.2516p ps=2.16u w=0.74u l=0.13u
X2161 VGND.t28 sg13cmos5l_inv_1_29.A sg13cmos5l_inv_1_51.A VGND.t1477 sg13_lv_nmos ad=0.2516p pd=2.16u as=0.2516p ps=2.16u w=0.74u l=0.13u
X2162 VPWR.t800 sg13cmos5l_inv_1_220.A sg13cmos5l_inv_1_220.Y VPWR.t11 sg13_lv_pmos ad=0.3808p pd=2.92u as=0.3808p ps=2.92u w=1.12u l=0.13u
X2163 sg13cmos5l_inv_1_535.A sg13cmos5l_inv_1_533.Y VPWR.t1232 VPWR.t39 sg13_lv_pmos ad=0.3808p pd=2.92u as=0.3808p ps=2.92u w=1.12u l=0.13u
X2164 VPWR.t861 sg13cmos5l_inv_1_787.Y sg13cmos5l_inv_1_768.A VPWR.t21 sg13_lv_pmos ad=0.3808p pd=2.92u as=0.3808p ps=2.92u w=1.12u l=0.13u
X2165 VPWR.t1186 sg13cmos5l_inv_1_675.A sg13cmos5l_inv_1_669.A VPWR.t26 sg13_lv_pmos ad=0.3808p pd=2.92u as=0.3808p ps=2.92u w=1.12u l=0.13u
X2166 VPWR.t935 sg13cmos5l_inv_1_735.Y sg13cmos5l_inv_1_736.Y VPWR.t5 sg13_lv_pmos ad=0.3808p pd=2.92u as=0.3808p ps=2.92u w=1.12u l=0.13u
X2167 sg13cmos5l_inv_1_521.Y sg13cmos5l_inv_1_523.Y VPWR.t1088 VPWR.t2 sg13_lv_pmos ad=0.3808p pd=2.92u as=0.3808p ps=2.92u w=1.12u l=0.13u
X2168 VPWR.t115 VGND.t136 VPWR.t201 VPWR.t21 sg13_lv_pmos ad=0.34p pd=2.68u as=0 ps=0 w=1u l=1u
X2169 sg13cmos5l_inv_1_888.Y sg13cmos5l_inv_1_887.Y VGND.t345 VGND.t344 sg13_lv_nmos ad=0.2516p pd=2.16u as=0.2516p ps=2.16u w=0.74u l=0.13u
X2170 VGND.t19 sg13cmos5l_inv_1_265.A sg13cmos5l_inv_1_266.A VGND.t18 sg13_lv_nmos ad=0.2516p pd=2.16u as=0.2516p ps=2.16u w=0.74u l=0.13u
X2171 VPWR.t18 VGND.t754 VPWR.t17 VPWR.t0 sg13_lv_pmos ad=0.34p pd=2.68u as=0 ps=0 w=1u l=1u
X2172 VGND.t157 sg13cmos5l_inv_1_140.A sg13cmos5l_inv_1_140.Y VGND.t1657 sg13_lv_nmos ad=0.2516p pd=2.16u as=0.2516p ps=2.16u w=0.74u l=0.13u
X2173 VPWR.t820 sg13cmos5l_inv_1_129.A sg13cmos5l_inv_1_129.Y VPWR.t14 sg13_lv_pmos ad=0.3808p pd=2.92u as=0.3808p ps=2.92u w=1.12u l=0.13u
X2174 sg13cmos5l_inv_1_136.Y sg13cmos5l_inv_1_138.Y VPWR.t407 VPWR.t14 sg13_lv_pmos ad=0.3808p pd=2.92u as=0.3808p ps=2.92u w=1.12u l=0.13u
X2175 a_4929_8028# sg13cmos5l_mux4_1_5.S1.t6 a_4438_8070# VGND.t650 sg13_lv_nmos ad=0.1216p pd=1.02u as=0.54188p ps=3.42u w=0.64u l=0.13u
X2176 sg13cmos5l_inv_1_137.A sg13cmos5l_inv_1_105.Y VGND.t1 VGND.t0 sg13_lv_nmos ad=0.2516p pd=2.16u as=0.2516p ps=2.16u w=0.74u l=0.13u
X2177 sg13cmos5l_inv_1_186.A sg13cmos5l_inv_1_213.Y VGND.t214 VGND.t11 sg13_lv_nmos ad=0.2516p pd=2.16u as=0.2516p ps=2.16u w=0.74u l=0.13u
X2178 sg13cmos5l_inv_1_124.A sg13cmos5l_inv_1_384.Y VGND.t76 VGND.t899 sg13_lv_nmos ad=0.2516p pd=2.16u as=0.2516p ps=2.16u w=0.74u l=0.13u
X2179 sg13cmos5l_inv_1_941.A sg13cmos5l_inv_1_1002.A VPWR.t382 VPWR.t5 sg13_lv_pmos ad=0.3808p pd=2.92u as=0.3808p ps=2.92u w=1.12u l=0.13u
X2180 VPWR.t1321 sg13cmos5l_inv_1_142.A sg13cmos5l_inv_1_141.A VPWR.t0 sg13_lv_pmos ad=0.3808p pd=2.92u as=0.3808p ps=2.92u w=1.12u l=0.13u
X2181 sg13cmos5l_inv_1_852.Y sg13cmos5l_inv_1_853.Y VPWR.t818 VPWR.t42 sg13_lv_pmos ad=0.3808p pd=2.92u as=0.3808p ps=2.92u w=1.12u l=0.13u
X2182 sg13cmos5l_inv_1_431.A sg13cmos5l_inv_1_362.Y VGND.t540 VGND.t539 sg13_lv_nmos ad=0.2516p pd=2.16u as=0.2516p ps=2.16u w=0.74u l=0.13u
X2183 sg13cmos5l_inv_1_376.A sg13cmos5l_inv_1_369.A VGND.t15 VGND.t966 sg13_lv_nmos ad=0.2516p pd=2.16u as=0.2516p ps=2.16u w=0.74u l=0.13u
X2184 sg13cmos5l_inv_1_622.Y sg13cmos5l_inv_1_623.Y VPWR.t386 VPWR.t42 sg13_lv_pmos ad=0.3808p pd=2.92u as=0.3808p ps=2.92u w=1.12u l=0.13u
X2185 VPWR.t1314 sg13cmos5l_inv_1_436.A sg13cmos5l_inv_1_451.A VPWR.t0 sg13_lv_pmos ad=0.3808p pd=2.92u as=0.3808p ps=2.92u w=1.12u l=0.13u
X2186 sg13cmos5l_nor3_1_1.Y sg13cmos5l_mux2_1_1.X VGND.t191 VGND.t190 sg13_lv_nmos ad=0.2618p pd=2.22u as=0.1463p ps=1.15u w=0.77u l=0.13u
X2187 sg13cmos5l_inv_1_797.A sg13cmos5l_inv_1_799.A VGND.t1225 VGND.t1224 sg13_lv_nmos ad=0.2516p pd=2.16u as=0.2516p ps=2.16u w=0.74u l=0.13u
X2188 sg13cmos5l_inv_1_510.Y sg13cmos5l_inv_1_510.A VGND.t322 VGND.t388 sg13_lv_nmos ad=0.2516p pd=2.16u as=0.2516p ps=2.16u w=0.74u l=0.13u
X2189 a_14023_3195# sg13cmos5l_inv_1_95.A VPWR.t301 VPWR.t8 sg13_lv_pmos ad=0.415p pd=1.83u as=0.22315p ps=1.555u w=1u l=0.13u
X2190 VGND.t1 VPWR.t1541 VGND.t1 VGND.t1592 sg13_lv_nmos ad=0.1428p pd=1.52u as=0 ps=0 w=0.42u l=1u
X2191 sg13cmos5l_inv_1_995.Y sg13cmos5l_inv_1_616.Y VPWR.t758 VPWR.t42 sg13_lv_pmos ad=0.3808p pd=2.92u as=0.3808p ps=2.92u w=1.12u l=0.13u
X2192 sg13cmos5l_inv_1_78.A sg13cmos5l_inv_1_77.Y VPWR.t1402 VPWR.t49 sg13_lv_pmos ad=0.3808p pd=2.92u as=0.3808p ps=2.92u w=1.12u l=0.13u
X2193 sg13cmos5l_inv_1_737.A sg13cmos5l_inv_1_738.Y VPWR.t1090 VPWR.t5 sg13_lv_pmos ad=0.3808p pd=2.92u as=0.3808p ps=2.92u w=1.12u l=0.13u
X2194 sg13cmos5l_inv_1_63.A sg13cmos5l_inv_1_102.Y VGND.t621 VGND.t676 sg13_lv_nmos ad=0.2516p pd=2.16u as=0.2516p ps=2.16u w=0.74u l=0.13u
X2195 VPWR.t457 sg13cmos5l_inv_1_36.A sg13cmos5l_inv_1_36.Y VPWR.t8 sg13_lv_pmos ad=0.3808p pd=2.92u as=0.3808p ps=2.92u w=1.12u l=0.13u
X2196 sg13cmos5l_inv_1_267.Y sg13cmos5l_inv_1_311.Y VGND.t19 VGND.t1136 sg13_lv_nmos ad=0.2516p pd=2.16u as=0.2516p ps=2.16u w=0.74u l=0.13u
X2197 a_14933_15245# a_13895_15630# a_14710_15630# VPWR.t21 sg13_lv_pmos ad=0.135p pd=1.27u as=0.4425p ps=1.885u w=1u l=0.13u
X2198 VGND.t612 VPWR.t1570 VGND.t612 VGND.t1555 sg13_lv_nmos ad=0.1428p pd=1.52u as=0 ps=0 w=0.42u l=1u
X2199 sg13cmos5l_inv_1_309.Y sg13cmos5l_inv_1_304.Y VGND.t260 VGND.t1397 sg13_lv_nmos ad=0.2516p pd=2.16u as=0.2516p ps=2.16u w=0.74u l=0.13u
X2200 VGND.t43 sg13cmos5l_inv_1_274.Y sg13cmos5l_inv_1_276.A VGND.t1424 sg13_lv_nmos ad=0.2516p pd=2.16u as=0.2516p ps=2.16u w=0.74u l=0.13u
X2201 VGND.t133 sg13cmos5l_inv_1_485.A sg13cmos5l_inv_1_485.Y VGND.t282 sg13_lv_nmos ad=0.2516p pd=2.16u as=0.2516p ps=2.16u w=0.74u l=0.13u
X2202 a_14171_11488# sg13cmos5l_buf_1_8.A.t3 VPWR.t1410 VPWR.t2 sg13_lv_pmos ad=0.34p pd=2.68u as=0.34367p ps=1.775u w=1u l=0.13u
X2203 sg13cmos5l_inv_1_305.A sg13cmos5l_inv_1_312.Y VGND.t260 VGND.t498 sg13_lv_nmos ad=0.2516p pd=2.16u as=0.2516p ps=2.16u w=0.74u l=0.13u
X2204 VGND.t354 sg13cmos5l_mux4_1_16.A1 a_8756_6558# VGND.t1036 sg13_lv_nmos ad=0.1824p pd=1.21u as=0.2304p ps=1.36u w=0.64u l=0.13u
X2205 sg13cmos5l_inv_1_198.Y sg13cmos5l_inv_1_189.Y VPWR.t320 VPWR.t49 sg13_lv_pmos ad=0.3808p pd=2.92u as=0.3808p ps=2.92u w=1.12u l=0.13u
X2206 VPWR.t1101 sg13cmos5l_inv_1_479.Y sg13cmos5l_inv_1_676.Y VPWR.t26 sg13_lv_pmos ad=0.3808p pd=2.92u as=0.3808p ps=2.92u w=1.12u l=0.13u
X2207 VPWR.t1250 sg13cmos5l_inv_1_600.A sg13cmos5l_inv_1_617.A VPWR.t39 sg13_lv_pmos ad=0.3808p pd=2.92u as=0.3808p ps=2.92u w=1.12u l=0.13u
X2208 sg13cmos5l_inv_1_234.A sg13cmos5l_inv_1_235.Y VPWR.t1481 VPWR.t49 sg13_lv_pmos ad=0.3808p pd=2.92u as=0.3808p ps=2.92u w=1.12u l=0.13u
X2209 VGND.t1194 sg13cmos5l_inv_1_826.Y sg13cmos5l_mux4_1_14.A1 VGND.t1219 sg13_lv_nmos ad=0.2516p pd=2.16u as=0.2516p ps=2.16u w=0.74u l=0.13u
X2210 sg13cmos5l_a21oi_1_0.B1 sg13cmos5l_nor2b_1_0.B_N VPWR.t865 VPWR.t21 sg13_lv_pmos ad=0.2128p pd=1.5u as=0.3808p ps=2.92u w=1.12u l=0.13u
X2211 VPWR.t661 sg13cmos5l_buf_1_10.A a_5005_12490# VPWR.t2 sg13_lv_pmos ad=0.34367p pd=1.775u as=0.34p ps=2.68u w=1u l=0.13u
X2212 sg13cmos5l_or2_1_0.X a_9360_11832# VGND.t414 VGND.t1020 sg13_lv_nmos ad=0.2516p pd=2.16u as=0.1469p ps=1.155u w=0.74u l=0.13u
X2213 sg13cmos5l_inv_1_461.Y sg13cmos5l_inv_1_460.Y VGND.t343 VGND.t11 sg13_lv_nmos ad=0.2516p pd=2.16u as=0.2516p ps=2.16u w=0.74u l=0.13u
X2214 sg13cmos5l_inv_1_957.Y sg13cmos5l_inv_1_956.Y VPWR.t782 VPWR.t29 sg13_lv_pmos ad=0.3808p pd=2.92u as=0.3808p ps=2.92u w=1.12u l=0.13u
X2215 VPWR.t629 sg13cmos5l_mux4_1_7.A3 a_7637_13283# VPWR.t26 sg13_lv_pmos ad=0.34p pd=2.68u as=0.135p ps=1.27u w=1u l=0.13u
X2216 VGND.t414 sg13cmos5l_a21oi_1_1.A2 a_8897_11480# VGND.t413 sg13_lv_nmos ad=0.2516p pd=2.16u as=0.1406p ps=1.12u w=0.74u l=0.13u
X2217 a_13918_12606# sg13cmos5l_buf_1_9.A.t2 a_13831_12267# VPWR.t2 sg13_lv_pmos ad=0.19p pd=1.38u as=0.415p ps=1.83u w=1u l=0.13u
X2218 osc_tap[3] a_18856_9980# VGND.t149 VGND.t148 sg13_lv_nmos ad=0.2886p pd=2.26u as=0.14875p ps=1.16u w=0.74u l=0.13u
X2219 sg13cmos5l_inv_1_645.Y sg13cmos5l_inv_1_645.A VGND.t723 VGND.t722 sg13_lv_nmos ad=0.2516p pd=2.16u as=0.2516p ps=2.16u w=0.74u l=0.13u
X2220 VGND.t621 VPWR.t1514 VGND.t1628 VGND.t1627 sg13_lv_nmos ad=0.1428p pd=1.52u as=0 ps=0 w=0.42u l=1u
X2221 sg13cmos5l_inv_1_8.A sg13cmos5l_inv_1_49.A VPWR.t565 VPWR.t8 sg13_lv_pmos ad=0.3808p pd=2.92u as=0.3808p ps=2.92u w=1.12u l=0.13u
X2222 VPWR.t143 sg13cmos5l_inv_1_295.A sg13cmos5l_inv_1_295.Y VPWR.t11 sg13_lv_pmos ad=0.3808p pd=2.92u as=0.3808p ps=2.92u w=1.12u l=0.13u
X2223 sg13cmos5l_mux4_1_8.A2 sg13cmos5l_inv_1_614.A VPWR.t678 VPWR.t42 sg13_lv_pmos ad=0.3808p pd=2.92u as=0.3808p ps=2.92u w=1.12u l=0.13u
X2224 sg13cmos5l_inv_1_974.Y sg13cmos5l_inv_1_974.A VPWR.t255 VPWR.t29 sg13_lv_pmos ad=0.3808p pd=2.92u as=0.3808p ps=2.92u w=1.12u l=0.13u
X2225 sg13cmos5l_inv_1_368.Y sg13cmos5l_inv_1_363.Y VPWR.t503 VPWR.t14 sg13_lv_pmos ad=0.3808p pd=2.92u as=0.3808p ps=2.92u w=1.12u l=0.13u
X2226 VGND.t347 sg13cmos5l_inv_1_938.Y sg13cmos5l_inv_1_731.A VGND.t346 sg13_lv_nmos ad=0.2516p pd=2.16u as=0.2516p ps=2.16u w=0.74u l=0.13u
X2227 VPWR.t682 sg13cmos5l_inv_1_148.A sg13cmos5l_inv_1_148.Y VPWR.t0 sg13_lv_pmos ad=0.3808p pd=2.92u as=0.3808p ps=2.92u w=1.12u l=0.13u
X2228 sg13cmos5l_inv_1_593.Y sg13cmos5l_inv_1_535.Y VPWR.t322 VPWR.t39 sg13_lv_pmos ad=0.3808p pd=2.92u as=0.3808p ps=2.92u w=1.12u l=0.13u
X2229 sg13cmos5l_inv_1_871.Y sg13cmos5l_inv_1_866.Y VGND.t37 VGND.t22 sg13_lv_nmos ad=0.2516p pd=2.16u as=0.2516p ps=2.16u w=0.74u l=0.13u
X2230 VGND.t52 sg13cmos5l_inv_1_297.Y sg13cmos5l_inv_1_324.Y VGND.t258 sg13_lv_nmos ad=0.2516p pd=2.16u as=0.2516p ps=2.16u w=0.74u l=0.13u
X2231 VPWR.t1110 sg13cmos5l_inv_1_373.A sg13cmos5l_inv_1_372.A VPWR.t14 sg13_lv_pmos ad=0.3808p pd=2.92u as=0.3808p ps=2.92u w=1.12u l=0.13u
X2232 sg13cmos5l_inv_1_350.Y sg13cmos5l_inv_1_350.A VPWR.t1036 VPWR.t29 sg13_lv_pmos ad=0.3808p pd=2.92u as=0.3808p ps=2.92u w=1.12u l=0.13u
X2233 sg13cmos5l_inv_1_479.Y sg13cmos5l_inv_1_478.Y VGND.t102 VGND.t1034 sg13_lv_nmos ad=0.2516p pd=2.16u as=0.2516p ps=2.16u w=0.74u l=0.13u
X2234 sg13cmos5l_inv_1_519.Y sg13cmos5l_inv_1_518.Y VPWR.t1200 VPWR.t2 sg13_lv_pmos ad=0.3808p pd=2.92u as=0.3808p ps=2.92u w=1.12u l=0.13u
X2235 sg13cmos5l_inv_1_363.Y sg13cmos5l_inv_1_375.Y VGND.t449 VGND.t448 sg13_lv_nmos ad=0.2516p pd=2.16u as=0.2516p ps=2.16u w=0.74u l=0.13u
X2236 VGND.t292 sg13cmos5l_inv_1_220.A sg13cmos5l_inv_1_220.Y VGND.t724 sg13_lv_nmos ad=0.2516p pd=2.16u as=0.2516p ps=2.16u w=0.74u l=0.13u
X2237 VGND.t113 VPWR.t1529 VGND.t113 VGND.t11 sg13_lv_nmos ad=0.1428p pd=1.52u as=0 ps=0 w=0.42u l=1u
X2238 sg13cmos5l_inv_1_652.Y sg13cmos5l_inv_1_656.Y VGND.t250 VGND.t1078 sg13_lv_nmos ad=0.2516p pd=2.16u as=0.2516p ps=2.16u w=0.74u l=0.13u
X2239 VPWR.t1177 sg13cmos5l_inv_1_326.Y sg13cmos5l_inv_1_331.A VPWR.t8 sg13_lv_pmos ad=0.3808p pd=2.92u as=0.3808p ps=2.92u w=1.12u l=0.13u
X2240 VPWR.t81 VGND.t529 VPWR.t80 VPWR.t21 sg13_lv_pmos ad=0.34p pd=2.68u as=0 ps=0 w=1u l=1u
X2241 VPWR.t303 sg13cmos5l_mux4_1_5.S1.t8 a_14183_9582# VPWR.t29 sg13_lv_pmos ad=0.22315p pd=1.555u as=0.34p ps=2.68u w=1u l=0.13u
X2242 sg13cmos5l_inv_1_863.Y sg13cmos5l_inv_1_863.A VPWR.t363 VPWR.t42 sg13_lv_pmos ad=0.3808p pd=2.92u as=0.3808p ps=2.92u w=1.12u l=0.13u
X2243 a_14827_11673# sg13cmos5l_nor3_1_2.B.t2 VPWR.t840 VPWR.t2 sg13_lv_pmos ad=0.34p pd=2.68u as=0.22315p ps=1.555u w=1u l=0.13u
X2244 VPWR.t1006 sg13cmos5l_mux2_1_4.S.t3 a_14989_12490# VPWR.t2 sg13_lv_pmos ad=0.34367p pd=1.775u as=0.34p ps=2.68u w=1u l=0.13u
X2245 VGND.t73 a_9326_3410# sg13cmos5l_mux2_1_4.X VGND.t166 sg13_lv_nmos ad=0.148p pd=1.14u as=0.4033p ps=2.57u w=0.74u l=0.13u
X2246 sg13cmos5l_inv_1_136.Y sg13cmos5l_inv_1_138.Y VGND.t165 VGND.t235 sg13_lv_nmos ad=0.2516p pd=2.16u as=0.2516p ps=2.16u w=0.74u l=0.13u
X2247 VPWR.t1467 VGND.t3 VPWR.t1466 VPWR.t26 sg13_lv_pmos ad=0.34p pd=2.68u as=0 ps=0 w=1u l=1u
X2248 VPWR.t697 sg13cmos5l_inv_1_317.Y sg13cmos5l_inv_1_450.Y VPWR.t49 sg13_lv_pmos ad=0.3808p pd=2.92u as=0.3808p ps=2.92u w=1.12u l=0.13u
X2249 sg13cmos5l_inv_1_565.Y sg13cmos5l_inv_1_537.Y VGND.t587 VGND.t93 sg13_lv_nmos ad=0.2516p pd=2.16u as=0.2516p ps=2.16u w=0.74u l=0.13u
X2250 sg13cmos5l_inv_1_857.A sg13cmos5l_inv_1_847.Y VGND.t66 VGND.t65 sg13_lv_nmos ad=0.2516p pd=2.16u as=0.2516p ps=2.16u w=0.74u l=0.13u
X2251 VGND.t352 sg13cmos5l_inv_1_307.A sg13cmos5l_inv_1_308.A VGND.t351 sg13_lv_nmos ad=0.2516p pd=2.16u as=0.2516p ps=2.16u w=0.74u l=0.13u
X2252 a_14917_9243# sg13cmos5l_mux4_1_15.A2 VPWR.t1043 VPWR.t29 sg13_lv_pmos ad=0.20762p pd=1.605u as=0.29275p ps=1.785u w=1u l=0.13u
X2253 VGND.t3 sg13cmos5l_inv_1_886.Y sg13cmos5l_inv_1_949.Y VGND.t1647 sg13_lv_nmos ad=0.2516p pd=2.16u as=0.2516p ps=2.16u w=0.74u l=0.13u
X2254 VPWR.t972 sg13cmos5l_inv_1_340.Y a_4661_7685# VPWR.t14 sg13_lv_pmos ad=0.34p pd=2.68u as=0.135p ps=1.27u w=1u l=0.13u
X2255 sg13cmos5l_inv_1_850.Y sg13cmos5l_inv_1_851.Y VPWR.t869 VPWR.t42 sg13_lv_pmos ad=0.3808p pd=2.92u as=0.3808p ps=2.92u w=1.12u l=0.13u
X2256 VPWR.t95 VGND.t96 VPWR.t94 VPWR.t21 sg13_lv_pmos ad=0.19p pd=1.38u as=0 ps=0 w=1u l=1u
X2257 VGND.t352 sg13cmos5l_inv_1_304.A sg13cmos5l_inv_1_304.Y VGND.t1143 sg13_lv_nmos ad=0.2516p pd=2.16u as=0.2516p ps=2.16u w=0.74u l=0.13u
X2258 VGND.t396 sg13cmos5l_inv_1_92.A sg13cmos5l_inv_1_1011.A VGND.t1142 sg13_lv_nmos ad=0.2516p pd=2.16u as=0.2516p ps=2.16u w=0.74u l=0.13u
X2259 sg13cmos5l_inv_1_852.Y sg13cmos5l_inv_1_853.Y VGND.t116 VGND.t22 sg13_lv_nmos ad=0.2516p pd=2.16u as=0.2516p ps=2.16u w=0.74u l=0.13u
X2260 VPWR.t569 sg13cmos5l_inv_1_631.Y sg13cmos5l_inv_1_683.A VPWR.t21 sg13_lv_pmos ad=0.3808p pd=2.92u as=0.3808p ps=2.92u w=1.12u l=0.13u
X2261 sg13cmos5l_inv_1_726.A sg13cmos5l_inv_1_708.A VGND.t155 VGND.t701 sg13_lv_nmos ad=0.2516p pd=2.16u as=0.2516p ps=2.16u w=0.74u l=0.13u
X2262 sg13cmos5l_inv_1_703.Y sg13cmos5l_inv_1_901.Y VGND.t444 VGND.t1165 sg13_lv_nmos ad=0.2516p pd=2.16u as=0.2516p ps=2.16u w=0.74u l=0.13u
X2263 VGND.t352 sg13cmos5l_inv_1_306.A sg13cmos5l_inv_1_306.Y VGND.t658 sg13_lv_nmos ad=0.2516p pd=2.16u as=0.2516p ps=2.16u w=0.74u l=0.13u
X2264 VPWR.t75 VGND.t197 VPWR.t73 VPWR.t39 sg13_lv_pmos ad=0.19p pd=1.38u as=0 ps=0 w=1u l=1u
X2265 VPWR.t456 sg13cmos5l_inv_1_618.A sg13cmos5l_inv_1_618.Y VPWR.t42 sg13_lv_pmos ad=0.3808p pd=2.92u as=0.3808p ps=2.92u w=1.12u l=0.13u
X2266 sg13cmos5l_inv_1_786.Y sg13cmos5l_inv_1_797.Y VGND.t96 VGND.t95 sg13_lv_nmos ad=0.2516p pd=2.16u as=0.2516p ps=2.16u w=0.74u l=0.13u
X2267 a_9142_6558# a_8327_6558# a_9066_6558# VGND.t139 sg13_lv_nmos ad=0.1776p pd=1.195u as=80f ps=0.89u w=0.64u l=0.13u
X2268 a_15608_7680# sg13cmos5l_buf_1_9.A.t1 a_15275_7644# VGND.t675 sg13_lv_nmos ad=0.54188p pd=3.42u as=0.1216p ps=1.02u w=0.64u l=0.13u
X2269 sg13cmos5l_mux4_1_9.A0 sg13cmos5l_inv_1_522.A VGND.t322 VGND.t933 sg13_lv_nmos ad=0.2516p pd=2.16u as=0.2516p ps=2.16u w=0.74u l=0.13u
X2270 VGND.t143 sg13cmos5l_inv_1_925.A sg13cmos5l_inv_1_925.Y VGND.t190 sg13_lv_nmos ad=0.2516p pd=2.16u as=0.2516p ps=2.16u w=0.74u l=0.13u
X2271 sg13cmos5l_inv_1_181.Y sg13cmos5l_inv_1_152.Y VGND.t335 VGND.t1022 sg13_lv_nmos ad=0.2516p pd=2.16u as=0.2516p ps=2.16u w=0.74u l=0.13u
X2272 VGND.t92 sg13cmos5l_mux4_1_14.A1 a_14036_14482# VGND.t579 sg13_lv_nmos ad=0.1824p pd=1.21u as=0.2304p ps=1.36u w=0.64u l=0.13u
X2273 sg13cmos5l_inv_1_888.Y sg13cmos5l_inv_1_887.Y VPWR.t494 VPWR.t26 sg13_lv_pmos ad=0.3808p pd=2.92u as=0.3808p ps=2.92u w=1.12u l=0.13u
X2274 sg13cmos5l_inv_1_326.Y sg13cmos5l_inv_1_310.Y VPWR.t139 VPWR.t11 sg13_lv_pmos ad=0.3808p pd=2.92u as=0.3808p ps=2.92u w=1.12u l=0.13u
X2275 VPWR.t1258 sg13cmos5l_inv_1_349.A sg13cmos5l_inv_1_348.A VPWR.t0 sg13_lv_pmos ad=0.3808p pd=2.92u as=0.3808p ps=2.92u w=1.12u l=0.13u
X2276 a_9982_8050# sg13cmos5l_mux2_1_3.A0 a_9885_7704# VPWR.t14 sg13_lv_pmos ad=0.2225p pd=1.445u as=0.3325p ps=1.665u w=1u l=0.13u
X2277 VGND.t174 sg13cmos5l_inv_1_493.A sg13cmos5l_inv_1_492.A VGND.t715 sg13_lv_nmos ad=0.2516p pd=2.16u as=0.2516p ps=2.16u w=0.74u l=0.13u
X2278 VGND.t54 sg13cmos5l_inv_1_338.Y sg13cmos5l_inv_1_319.Y VGND.t1297 sg13_lv_nmos ad=0.2516p pd=2.16u as=0.2516p ps=2.16u w=0.74u l=0.13u
X2279 sg13cmos5l_inv_1_462.Y sg13cmos5l_inv_1_462.A VGND.t201 VGND.t361 sg13_lv_nmos ad=0.2516p pd=2.16u as=0.2516p ps=2.16u w=0.74u l=0.13u
X2280 VPWR.t48 VGND.t174 VPWR.t47 VPWR.t26 sg13_lv_pmos ad=0.34p pd=2.68u as=0 ps=0 w=1u l=1u
X2281 sg13cmos5l_inv_1_122.Y sg13cmos5l_inv_1_122.A VPWR.t885 VPWR.t14 sg13_lv_pmos ad=0.3808p pd=2.92u as=0.3808p ps=2.92u w=1.12u l=0.13u
X2282 VPWR.t281 sg13cmos5l_mux4_1_8.A1 a_7789_16261# VPWR.t42 sg13_lv_pmos ad=0.29275p pd=1.785u as=0.16p ps=1.32u w=1u l=0.13u
X2283 VPWR.t1373 sg13cmos5l_inv_1_780.Y sg13cmos5l_inv_1_783.A VPWR.t39 sg13_lv_pmos ad=0.3808p pd=2.92u as=0.3808p ps=2.92u w=1.12u l=0.13u
X2284 a_9996_11500# sg13cmos5l_or2_1_0.X a_9919_11500# VGND.t447 sg13_lv_nmos ad=0.1216p pd=1.02u as=81.6f ps=0.895u w=0.64u l=0.13u
X2285 VPWR.t1485 sg13cmos5l_inv_1_268.A sg13cmos5l_inv_1_264.A VPWR.t49 sg13_lv_pmos ad=0.3808p pd=2.92u as=0.3808p ps=2.92u w=1.12u l=0.13u
X2286 VPWR.t843 sg13cmos5l_inv_1_681.A sg13cmos5l_inv_1_681.Y VPWR.t21 sg13_lv_pmos ad=0.3808p pd=2.92u as=0.3808p ps=2.92u w=1.12u l=0.13u
X2287 VGND.t119 sg13cmos5l_inv_1_329.A sg13cmos5l_inv_1_311.A VGND.t1391 sg13_lv_nmos ad=0.2516p pd=2.16u as=0.2516p ps=2.16u w=0.74u l=0.13u
X2288 VGND.t1510 VPWR.t1600 VGND.t136 VGND.t1509 sg13_lv_nmos ad=0.1428p pd=1.52u as=0 ps=0 w=0.42u l=1u
X2289 VGND.t39 sg13cmos5l_inv_1_723.A sg13cmos5l_inv_1_723.Y VGND.t1046 sg13_lv_nmos ad=0.2516p pd=2.16u as=0.2516p ps=2.16u w=0.74u l=0.13u
X2290 sg13cmos5l_nand2_1_1.B a_808_9980# VPWR.t1109 VPWR.t5 sg13_lv_pmos ad=0.42p pd=2.99u as=0.2114p ps=1.54u w=1.12u l=0.13u
X2291 a_8564_6558# sg13cmos5l_inv_1_382.A VGND.t354 VGND.t1305 sg13_lv_nmos ad=76.8f pd=0.88u as=0.1872p ps=1.225u w=0.64u l=0.13u
X2292 VGND.t263 sg13cmos5l_inv_1_584.A sg13cmos5l_inv_1_534.A VGND.t568 sg13_lv_nmos ad=0.2516p pd=2.16u as=0.2516p ps=2.16u w=0.74u l=0.13u
X2293 VPWR.t218 VGND.t140 VPWR.t217 VPWR.t39 sg13_lv_pmos ad=0.34p pd=2.68u as=0 ps=0 w=1u l=1u
X2294 VGND.t145 sg13cmos5l_inv_1_515.A sg13cmos5l_inv_1_515.Y VGND.t700 sg13_lv_nmos ad=0.2516p pd=2.16u as=0.2516p ps=2.16u w=0.74u l=0.13u
X2295 a_7425_8476# sg13cmos5l_mux4_1_5.S1.t7 a_6430_8434# VPWR.t29 sg13_lv_pmos ad=0.2225p pd=1.445u as=0.34p ps=2.68u w=1u l=0.13u
X2296 sg13cmos5l_inv_1_612.Y sg13cmos5l_inv_1_612.A VPWR.t1356 VPWR.t42 sg13_lv_pmos ad=0.3808p pd=2.92u as=0.3808p ps=2.92u w=1.12u l=0.13u
X2297 VPWR.t330 sg13cmos5l_inv_1_758.A sg13cmos5l_inv_1_739.A VPWR.t26 sg13_lv_pmos ad=0.3808p pd=2.92u as=0.3808p ps=2.92u w=1.12u l=0.13u
X2298 VGND.t52 sg13cmos5l_inv_1_295.A sg13cmos5l_inv_1_295.Y VGND.t258 sg13_lv_nmos ad=0.2516p pd=2.16u as=0.2516p ps=2.16u w=0.74u l=0.13u
X2299 sg13cmos5l_inv_1_24.Y sg13cmos5l_inv_1_13.Y VGND.t256 VGND.t656 sg13_lv_nmos ad=0.2516p pd=2.16u as=0.2516p ps=2.16u w=0.74u l=0.13u
X2300 VPWR.t1292 sg13cmos5l_inv_1_293.Y sg13cmos5l_inv_1_282.Y VPWR.t8 sg13_lv_pmos ad=0.3808p pd=2.92u as=0.3808p ps=2.92u w=1.12u l=0.13u
X2301 VGND.t1564 VPWR.t1559 VGND.t1565 VGND.t4 sg13_lv_nmos ad=0.1428p pd=1.52u as=0 ps=0 w=0.42u l=1u
X2302 VPWR.t1193 sg13cmos5l_inv_1_928.A sg13cmos5l_inv_1_929.A VPWR.t5 sg13_lv_pmos ad=0.3808p pd=2.92u as=0.3808p ps=2.92u w=1.12u l=0.13u
X2303 sg13cmos5l_mux4_1_8.A2 sg13cmos5l_inv_1_614.A VGND.t44 VGND.t22 sg13_lv_nmos ad=0.2516p pd=2.16u as=0.2516p ps=2.16u w=0.74u l=0.13u
X2304 VPWR.t292 sg13cmos5l_inv_1_573.A sg13cmos5l_inv_1_572.A VPWR.t42 sg13_lv_pmos ad=0.3808p pd=2.92u as=0.3808p ps=2.92u w=1.12u l=0.13u
X2305 a_13918_3898# a_14989_3904# a_14913_3940# VGND.t1279 sg13_lv_nmos ad=0.2176p pd=1.96u as=0.1216p ps=1.02u w=0.64u l=0.13u
X2306 sg13cmos5l_inv_1_18.A sg13cmos5l_inv_1_24.Y VGND.t256 VGND.t255 sg13_lv_nmos ad=0.2516p pd=2.16u as=0.2516p ps=2.16u w=0.74u l=0.13u
X2307 a_6823_13237# sg13cmos5l_inv_1_495.A VPWR.t313 VPWR.t26 sg13_lv_pmos ad=0.415p pd=1.83u as=0.22315p ps=1.555u w=1u l=0.13u
X2308 VPWR.t576 sg13cmos5l_a21oi_1_0.Y a_9825_11776# VPWR.t2 sg13_lv_pmos ad=0.19p pd=1.38u as=0.34p ps=2.68u w=1u l=0.13u
X2309 VGND.t8 sg13cmos5l_inv_1_937.A sg13cmos5l_inv_1_937.Y VGND.t190 sg13_lv_nmos ad=0.2516p pd=2.16u as=0.2516p ps=2.16u w=0.74u l=0.13u
X2310 sg13cmos5l_inv_1_13.Y sg13cmos5l_inv_1_20.Y VPWR.t436 VPWR.t11 sg13_lv_pmos ad=0.3808p pd=2.92u as=0.3808p ps=2.92u w=1.12u l=0.13u
X2311 VPWR.t139 VGND.t1632 VPWR.t139 VPWR.t11 sg13_lv_pmos ad=0.34p pd=2.68u as=0 ps=0 w=1u l=1u
X2312 VPWR.t306 sg13cmos5l_mux4_1_14.A1 a_14125_14749# VPWR.t21 sg13_lv_pmos ad=0.29275p pd=1.785u as=0.16p ps=1.32u w=1u l=0.13u
X2313 sg13cmos5l_inv_1_721.A sg13cmos5l_inv_1_712.A VPWR.t277 VPWR.t2 sg13_lv_pmos ad=0.3808p pd=2.92u as=0.3808p ps=2.92u w=1.12u l=0.13u
X2314 sg13cmos5l_inv_1_18.Y sg13cmos5l_inv_1_18.A VGND.t256 VGND.t681 sg13_lv_nmos ad=0.2516p pd=2.16u as=0.2516p ps=2.16u w=0.74u l=0.13u
X2315 VGND.t587 sg13cmos5l_inv_1_576.A sg13cmos5l_inv_1_575.A VGND.t93 sg13_lv_nmos ad=0.2516p pd=2.16u as=0.2516p ps=2.16u w=0.74u l=0.13u
X2316 VPWR.t1094 sg13cmos5l_inv_1_938.A sg13cmos5l_inv_1_938.Y VPWR.t5 sg13_lv_pmos ad=0.3808p pd=2.92u as=0.3808p ps=2.92u w=1.12u l=0.13u
X2317 VPWR.t950 sg13cmos5l_inv_1_376.A sg13cmos5l_inv_1_362.A VPWR.t14 sg13_lv_pmos ad=0.3808p pd=2.92u as=0.3808p ps=2.92u w=1.12u l=0.13u
X2318 VGND.t412 sg13cmos5l_inv_1_637.A sg13cmos5l_inv_1_636.A VGND.t1371 sg13_lv_nmos ad=0.2516p pd=2.16u as=0.2516p ps=2.16u w=0.74u l=0.13u
X2319 VPWR.t249 VGND.t194 VPWR.t248 VPWR.t39 sg13_lv_pmos ad=0.34p pd=2.68u as=0 ps=0 w=1u l=1u
X2320 osc_tap[6] a_18856_16752# VGND.t37 VGND.t22 sg13_lv_nmos ad=0.2886p pd=2.26u as=0.14875p ps=1.16u w=0.74u l=0.13u
X2321 sg13cmos5l_a22oi_1_0.B1 a_4798_12970# VGND.t102 VGND.t826 sg13_lv_nmos ad=0.4033p pd=2.57u as=0.148p ps=1.14u w=0.74u l=0.13u
X2322 sg13cmos5l_inv_1_100.A sg13cmos5l_inv_1_231.Y VPWR.t440 VPWR.t49 sg13_lv_pmos ad=0.3808p pd=2.92u as=0.3808p ps=2.92u w=1.12u l=0.13u
X2323 sg13cmos5l_inv_1_537.A sg13cmos5l_inv_1_681.Y VGND.t587 VGND.t804 sg13_lv_nmos ad=0.2516p pd=2.16u as=0.2516p ps=2.16u w=0.74u l=0.13u
X2324 VPWR.t408 sg13cmos5l_inv_1_889.Y sg13cmos5l_inv_1_884.Y VPWR.t21 sg13_lv_pmos ad=0.3808p pd=2.92u as=0.3808p ps=2.92u w=1.12u l=0.13u
X2325 sg13cmos5l_inv_1_863.Y sg13cmos5l_inv_1_863.A VGND.t23 VGND.t22 sg13_lv_nmos ad=0.2516p pd=2.16u as=0.2516p ps=2.16u w=0.74u l=0.13u
X2326 a_8010_3534# sg13cmos5l_inv_1_258.A VGND.t43 VGND.t1450 sg13_lv_nmos ad=80f pd=0.89u as=0.1824p ps=1.21u w=0.64u l=0.13u
X2327 sg13cmos5l_inv_1_134.Y sg13cmos5l_inv_1_133.Y VGND.t354 VGND.t1482 sg13_lv_nmos ad=0.2516p pd=2.16u as=0.2516p ps=2.16u w=0.74u l=0.13u
X2328 VPWR.t45 VGND.t133 VPWR.t237 VPWR.t26 sg13_lv_pmos ad=0.34p pd=2.68u as=0 ps=0 w=1u l=1u
X2329 sg13cmos5l_inv_1_514.A sg13cmos5l_inv_1_513.A VPWR.t999 VPWR.t2 sg13_lv_pmos ad=0.3808p pd=2.92u as=0.3808p ps=2.92u w=1.12u l=0.13u
X2330 VGND.t1546 VPWR.t1572 VGND.t854 VGND.t1545 sg13_lv_nmos ad=0.1428p pd=1.52u as=0 ps=0 w=0.42u l=1u
X2331 sg13cmos5l_inv_1_212.Y sg13cmos5l_inv_1_185.Y VGND.t16 VGND.t11 sg13_lv_nmos ad=0.2516p pd=2.16u as=0.2516p ps=2.16u w=0.74u l=0.13u
X2332 VGND.t225 sg13cmos5l_inv_1_989.A sg13cmos5l_inv_1_448.A VGND.t11 sg13_lv_nmos ad=0.2516p pd=2.16u as=0.2516p ps=2.16u w=0.74u l=0.13u
X2333 VPWR.t1316 sg13cmos5l_inv_1_205.A sg13cmos5l_inv_1_205.Y VPWR.t0 sg13_lv_pmos ad=0.3808p pd=2.92u as=0.3808p ps=2.92u w=1.12u l=0.13u
X2334 sg13cmos5l_inv_1_645.Y sg13cmos5l_inv_1_645.A VPWR.t799 VPWR.t26 sg13_lv_pmos ad=0.3808p pd=2.92u as=0.3808p ps=2.92u w=1.12u l=0.13u
X2335 sg13cmos5l_inv_1_398.Y sg13cmos5l_mux4_1_16.A1 VPWR.t1080 VPWR.t14 sg13_lv_pmos ad=0.3808p pd=2.92u as=0.3808p ps=2.92u w=1.12u l=0.13u
X2336 VPWR.t787 a_8123_8472# a_8623_8728# VPWR.t29 sg13_lv_pmos ad=0.2198p pd=1.52u as=0.2975p ps=1.595u w=1u l=0.13u
X2337 sg13cmos5l_inv_1_95.A sg13cmos5l_buf_1_0.A VPWR.t328 VPWR.t8 sg13_lv_pmos ad=0.3808p pd=2.92u as=0.3808p ps=2.92u w=1.12u l=0.13u
X2338 VPWR.t230 VGND.t612 VPWR.t206 VPWR.t5 sg13_lv_pmos ad=0.19p pd=1.38u as=0 ps=0 w=1u l=1u
X2339 VPWR.t365 sg13cmos5l_inv_1_266.A sg13cmos5l_inv_1_266.Y VPWR.t49 sg13_lv_pmos ad=0.3808p pd=2.92u as=0.3808p ps=2.92u w=1.12u l=0.13u
X2340 VPWR.t495 sg13cmos5l_inv_1_938.Y sg13cmos5l_inv_1_731.A VPWR.t5 sg13_lv_pmos ad=0.3808p pd=2.92u as=0.3808p ps=2.92u w=1.12u l=0.13u
X2341 VGND.t78 sg13cmos5l_inv_1_85.A sg13cmos5l_inv_1_85.Y VGND.t1266 sg13_lv_nmos ad=0.2516p pd=2.16u as=0.2516p ps=2.16u w=0.74u l=0.13u
X2342 VGND.t149 sg13cmos5l_inv_1_986.Y sg13cmos5l_inv_1_942.Y VGND.t1093 sg13_lv_nmos ad=0.2516p pd=2.16u as=0.2516p ps=2.16u w=0.74u l=0.13u
X2343 sg13cmos5l_inv_1_397.Y sg13cmos5l_inv_1_396.Y VGND.t354 VGND.t369 sg13_lv_nmos ad=0.2516p pd=2.16u as=0.2516p ps=2.16u w=0.74u l=0.13u
X2344 sg13cmos5l_inv_1_850.Y sg13cmos5l_inv_1_851.Y VGND.t116 VGND.t22 sg13_lv_nmos ad=0.2516p pd=2.16u as=0.2516p ps=2.16u w=0.74u l=0.13u
X2345 sg13cmos5l_inv_1_898.A sg13cmos5l_mux4_1_7.A2 VGND.t3 VGND.t821 sg13_lv_nmos ad=0.2516p pd=2.16u as=0.2516p ps=2.16u w=0.74u l=0.13u
X2346 sg13cmos5l_inv_1_120.A a_9996_11500# VGND.t612 VGND.t1101 sg13_lv_nmos ad=0.2351p pd=2.16u as=0.15745p ps=1.175u w=0.74u l=0.13u
X2347 VGND.t171 sg13cmos5l_inv_1_787.Y a_14324_15630# VGND.t800 sg13_lv_nmos ad=0.1824p pd=1.21u as=0.2304p ps=1.36u w=0.64u l=0.13u
X2348 sg13cmos5l_inv_1_730.Y sg13cmos5l_inv_1_730.A VPWR.t983 VPWR.t2 sg13_lv_pmos ad=0.3808p pd=2.92u as=0.3808p ps=2.92u w=1.12u l=0.13u
X2349 VGND.t540 VPWR.t1544 VGND.t540 VGND.t1589 sg13_lv_nmos ad=0.1428p pd=1.52u as=0 ps=0 w=0.42u l=1u
X2350 VGND.t35 sg13cmos5l_inv_1_862.A a_18664_16028# VGND.t278 sg13_lv_nmos ad=0.14875p pd=1.16u as=0.187p ps=1.78u w=0.55u l=0.13u
X2351 sg13cmos5l_inv_1_288.Y sg13cmos5l_inv_1_282.Y VGND.t19 VGND.t1423 sg13_lv_nmos ad=0.2516p pd=2.16u as=0.2516p ps=2.16u w=0.74u l=0.13u
X2352 VGND.t56 sg13cmos5l_inv_1_618.A sg13cmos5l_inv_1_618.Y VGND.t22 sg13_lv_nmos ad=0.2516p pd=2.16u as=0.2516p ps=2.16u w=0.74u l=0.13u
X2353 sg13cmos5l_inv_1_652.Y sg13cmos5l_inv_1_656.Y VPWR.t1115 VPWR.t26 sg13_lv_pmos ad=0.3808p pd=2.92u as=0.3808p ps=2.92u w=1.12u l=0.13u
X2354 a_10551_10240# sg13cmos5l_nor3_1_2.B.t1 a_10437_10240# VPWR.t5 sg13_lv_pmos ad=0.2128p pd=1.5u as=0.2464p ps=1.56u w=1.12u l=0.13u
X2355 VGND.t90 sg13cmos5l_inv_1_798.A sg13cmos5l_inv_1_798.Y VGND.t415 sg13_lv_nmos ad=0.2516p pd=2.16u as=0.2516p ps=2.16u w=0.74u l=0.13u
X2356 VPWR.t192 VGND.t66 VPWR.t191 VPWR.t21 sg13_lv_pmos ad=0.34p pd=2.68u as=0 ps=0 w=1u l=1u
X2357 sg13cmos5l_inv_1_990.A sg13cmos5l_inv_1_997.A VGND.t5 VGND.t190 sg13_lv_nmos ad=0.2516p pd=2.16u as=0.2516p ps=2.16u w=0.74u l=0.13u
X2358 sg13cmos5l_inv_1_509.A sg13cmos5l_inv_1_511.A VGND.t322 VGND.t1170 sg13_lv_nmos ad=0.2516p pd=2.16u as=0.2516p ps=2.16u w=0.74u l=0.13u
X2359 VGND.t335 sg13cmos5l_inv_1_175.A sg13cmos5l_inv_1_174.A VGND.t334 sg13_lv_nmos ad=0.2516p pd=2.16u as=0.2516p ps=2.16u w=0.74u l=0.13u
X2360 sg13cmos5l_inv_1_326.Y sg13cmos5l_inv_1_310.Y VGND.t610 VGND.t609 sg13_lv_nmos ad=0.2516p pd=2.16u as=0.2516p ps=2.16u w=0.74u l=0.13u
X2361 a_6343_8701# sg13cmos5l_inv_1_402.A VPWR.t396 VPWR.t29 sg13_lv_pmos ad=0.415p pd=1.83u as=0.22315p ps=1.555u w=1u l=0.13u
X2362 sg13cmos5l_inv_1_576.A sg13cmos5l_inv_1_546.Y VPWR.t473 VPWR.t39 sg13_lv_pmos ad=0.3808p pd=2.92u as=0.3808p ps=2.92u w=1.12u l=0.13u
X2363 sg13cmos5l_inv_1_788.Y sg13cmos5l_mux4_1_8.A0 VPWR.t1228 VPWR.t42 sg13_lv_pmos ad=0.3808p pd=2.92u as=0.3808p ps=2.92u w=1.12u l=0.13u
X2364 VGND.t143 VPWR.t1564 VGND.t143 VGND.t190 sg13_lv_nmos ad=0.1428p pd=1.52u as=0 ps=0 w=0.42u l=1u
X2365 a_9758_3168# sg13cmos5l_mux4_1_5.X a_9326_3410# VPWR.t8 sg13_lv_pmos ad=0.3325p pd=1.665u as=0.2225p ps=1.445u w=1u l=0.13u
X2366 VPWR.t324 sg13cmos5l_inv_1_426.A sg13cmos5l_inv_1_425.A VPWR.t49 sg13_lv_pmos ad=0.3808p pd=2.92u as=0.3808p ps=2.92u w=1.12u l=0.13u
X2367 sg13cmos5l_inv_1_122.Y sg13cmos5l_inv_1_122.A VGND.t267 VGND.t825 sg13_lv_nmos ad=0.2516p pd=2.16u as=0.2516p ps=2.16u w=0.74u l=0.13u
X2368 VGND.t1272 VPWR.t1512 VGND.t536 VGND.t1634 sg13_lv_nmos ad=0.1428p pd=1.52u as=0 ps=0 w=0.42u l=1u
X2369 sg13cmos5l_inv_1_241.A sg13cmos5l_inv_1_344.Y VPWR.t1034 VPWR.t0 sg13_lv_pmos ad=0.3808p pd=2.92u as=0.3808p ps=2.92u w=1.12u l=0.13u
X2370 sg13cmos5l_inv_1_703.Y sg13cmos5l_inv_1_901.Y VPWR.t1190 VPWR.t5 sg13_lv_pmos ad=0.3808p pd=2.92u as=0.3808p ps=2.92u w=1.12u l=0.13u
X2371 VGND.t1626 VPWR.t1515 VGND.t260 VGND.t1625 sg13_lv_nmos ad=0.1428p pd=1.52u as=0 ps=0 w=0.42u l=1u
X2372 VGND.t23 sg13cmos5l_inv_1_827.Y sg13cmos5l_inv_1_828.Y VGND.t22 sg13_lv_nmos ad=0.2516p pd=2.16u as=0.2516p ps=2.16u w=0.74u l=0.13u
X2373 VPWR.t1498 sg13cmos5l_inv_1_244.A sg13cmos5l_inv_1_239.A VPWR.t11 sg13_lv_pmos ad=0.3808p pd=2.92u as=0.3808p ps=2.92u w=1.12u l=0.13u
X2374 VGND.t147 sg13cmos5l_inv_1_518.A sg13cmos5l_inv_1_518.Y VGND.t1027 sg13_lv_nmos ad=0.2516p pd=2.16u as=0.2516p ps=2.16u w=0.74u l=0.13u
X2375 VPWR.t670 sg13cmos5l_mux4_1_13.A3 a_14933_15245# VPWR.t21 sg13_lv_pmos ad=0.34p pd=2.68u as=0.135p ps=1.27u w=1u l=0.13u
X2376 VPWR.t677 sg13cmos5l_inv_1_584.A sg13cmos5l_inv_1_534.A VPWR.t21 sg13_lv_pmos ad=0.3808p pd=2.92u as=0.3808p ps=2.92u w=1.12u l=0.13u
X2377 VPWR.t414 sg13cmos5l_inv_1_453.A sg13cmos5l_inv_1_453.Y VPWR.t11 sg13_lv_pmos ad=0.3808p pd=2.92u as=0.3808p ps=2.92u w=1.12u l=0.13u
X2378 sg13cmos5l_nor3_1_1.Y sg13cmos5l_nor3_1_1.A VGND.t191 VGND.t190 sg13_lv_nmos ad=0.1694p pd=1.21u as=0.2618p ps=2.22u w=0.77u l=0.13u
X2379 sg13cmos5l_inv_1_600.A sg13cmos5l_inv_1_598.A VPWR.t1236 VPWR.t39 sg13_lv_pmos ad=0.3808p pd=2.92u as=0.3808p ps=2.92u w=1.12u l=0.13u
X2380 sg13cmos5l_inv_1_612.Y sg13cmos5l_inv_1_612.A VGND.t56 VGND.t22 sg13_lv_nmos ad=0.2516p pd=2.16u as=0.2516p ps=2.16u w=0.74u l=0.13u
X2381 VGND.t96 VPWR.t1598 VGND.t96 VGND.t1516 sg13_lv_nmos ad=79.8f pd=0.8u as=0 ps=0 w=0.42u l=1u
X2382 VGND.t225 sg13cmos5l_inv_1_235.A sg13cmos5l_inv_1_235.Y VGND.t11 sg13_lv_nmos ad=0.2516p pd=2.16u as=0.2516p ps=2.16u w=0.74u l=0.13u
X2383 VPWR.t354 sg13cmos5l_inv_1_136.Y sg13cmos5l_inv_1_140.A VPWR.t14 sg13_lv_pmos ad=0.3808p pd=2.92u as=0.3808p ps=2.92u w=1.12u l=0.13u
X2384 sg13cmos5l_inv_1_252.A sg13cmos5l_inv_1_254.Y VGND.t240 VGND.t1133 sg13_lv_nmos ad=0.2516p pd=2.16u as=0.2516p ps=2.16u w=0.74u l=0.13u
X2385 VGND.t587 sg13cmos5l_inv_1_537.A sg13cmos5l_inv_1_537.Y VGND.t804 sg13_lv_nmos ad=0.2516p pd=2.16u as=0.2516p ps=2.16u w=0.74u l=0.13u
X2386 VGND.t29 sg13cmos5l_inv_1_573.A sg13cmos5l_inv_1_572.A VGND.t22 sg13_lv_nmos ad=0.2516p pd=2.16u as=0.2516p ps=2.16u w=0.74u l=0.13u
X2387 VGND.t107 VPWR.t1538 VGND.t107 VGND.t1596 sg13_lv_nmos ad=0.1428p pd=1.52u as=0 ps=0 w=0.42u l=1u
X2388 VPWR.t143 VGND.t1378 VPWR.t139 VPWR.t11 sg13_lv_pmos ad=0.34p pd=2.68u as=0 ps=0 w=1u l=1u
X2389 sg13cmos5l_inv_1_252.Y sg13cmos5l_inv_1_252.A VGND.t240 VGND.t603 sg13_lv_nmos ad=0.2516p pd=2.16u as=0.2516p ps=2.16u w=0.74u l=0.13u
X2390 VPWR.t658 sg13cmos5l_inv_1_496.A sg13cmos5l_inv_1_495.A VPWR.t2 sg13_lv_pmos ad=0.3808p pd=2.92u as=0.3808p ps=2.92u w=1.12u l=0.13u
X2391 a_7338_12970# sg13cmos5l_mux4_1_7.A2 VGND.t133 VGND.t820 sg13_lv_nmos ad=80f pd=0.89u as=0.1824p ps=1.21u w=0.64u l=0.13u
X2392 sg13cmos5l_inv_1_658.Y sg13cmos5l_mux4_1_10.A3 VGND.t263 VGND.t1448 sg13_lv_nmos ad=0.2516p pd=2.16u as=0.2516p ps=2.16u w=0.74u l=0.13u
X2393 VPWR.t1150 sg13cmos5l_inv_1_937.A sg13cmos5l_inv_1_937.Y VPWR.t5 sg13_lv_pmos ad=0.3808p pd=2.92u as=0.3808p ps=2.92u w=1.12u l=0.13u
X2394 sg13cmos5l_inv_1_250.Y sg13cmos5l_inv_1_252.Y VGND.t240 VGND.t1289 sg13_lv_nmos ad=0.2516p pd=2.16u as=0.2516p ps=2.16u w=0.74u l=0.13u
X2395 VGND.t15 sg13cmos5l_inv_1_376.A sg13cmos5l_inv_1_362.A VGND.t893 sg13_lv_nmos ad=0.2516p pd=2.16u as=0.2516p ps=2.16u w=0.74u l=0.13u
X2396 VGND.t225 sg13cmos5l_inv_1_448.Y sg13cmos5l_inv_1_443.Y VGND.t11 sg13_lv_nmos ad=0.2516p pd=2.16u as=0.2516p ps=2.16u w=0.74u l=0.13u
X2397 sg13cmos5l_inv_1_537.A sg13cmos5l_inv_1_681.Y VPWR.t1329 VPWR.t21 sg13_lv_pmos ad=0.3808p pd=2.92u as=0.3808p ps=2.92u w=1.12u l=0.13u
X2398 sg13cmos5l_inv_1_881.A sg13cmos5l_inv_1_920.A VPWR.t1417 VPWR.t21 sg13_lv_pmos ad=0.3808p pd=2.92u as=0.3808p ps=2.92u w=1.12u l=0.13u
X2399 sg13cmos5l_a22oi_1_0.A1 a_7905_13012# VPWR.t792 VPWR.t26 sg13_lv_pmos ad=0.3808p pd=2.92u as=0.34367p ps=1.775u w=1.12u l=0.13u
X2400 VPWR.t1495 sg13cmos5l_inv_1_237.A sg13cmos5l_inv_1_237.Y VPWR.t11 sg13_lv_pmos ad=0.3808p pd=2.92u as=0.3808p ps=2.92u w=1.12u l=0.13u
X2401 VPWR.t258 sg13cmos5l_mux2_1_4.S a_15565_9466# VPWR.t29 sg13_lv_pmos ad=0.34367p pd=1.775u as=0.34p ps=2.68u w=1u l=0.13u
X2402 VPWR.t1340 sg13cmos5l_nor2b_1_0.A sg13cmos5l_a21oi_1_0.B1 VPWR.t21 sg13_lv_pmos ad=0.3808p pd=2.92u as=0.2128p ps=1.5u w=1.12u l=0.13u
X2403 VPWR.t581 sg13cmos5l_inv_1_526.A sg13cmos5l_inv_1_526.Y VPWR.t2 sg13_lv_pmos ad=0.3808p pd=2.92u as=0.3808p ps=2.92u w=1.12u l=0.13u
X2404 VGND.t128 VPWR.t1546 VGND.t128 VGND.t481 sg13_lv_nmos ad=0.1428p pd=1.52u as=0 ps=0 w=0.42u l=1u
X2405 sg13cmos5l_inv_1_973.Y sg13cmos5l_inv_1_974.Y VGND.t5 VGND.t4 sg13_lv_nmos ad=0.2516p pd=2.16u as=0.2516p ps=2.16u w=0.74u l=0.13u
X2406 VGND.t66 sg13cmos5l_mux2_1_4.S.t5 a_15277_15514# VGND.t1640 sg13_lv_nmos ad=0.1543p pd=1.18u as=0.2304p ps=2u w=0.64u l=0.13u
X2407 a_7700_3534# sg13cmos5l_mux4_1_5.S0.t1 a_7582_3534# VGND.t1259 sg13_lv_nmos ad=0.2304p pd=1.36u as=0.1472p ps=1.1u w=0.64u l=0.13u
X2408 VGND.t335 sg13cmos5l_inv_1_78.A a_18664_6956# VGND.t878 sg13_lv_nmos ad=0.14875p pd=1.16u as=0.187p ps=1.78u w=0.55u l=0.13u
X2409 sg13cmos5l_inv_1_848.Y sg13cmos5l_mux4_1_13.A0 VPWR.t360 VPWR.t42 sg13_lv_pmos ad=0.3808p pd=2.92u as=0.3808p ps=2.92u w=1.12u l=0.13u
X2410 VGND.t335 sg13cmos5l_inv_1_141.A sg13cmos5l_inv_1_141.Y VGND.t464 sg13_lv_nmos ad=0.2516p pd=2.16u as=0.2516p ps=2.16u w=0.74u l=0.13u
X2411 sg13cmos5l_inv_1_72.Y sg13cmos5l_inv_1_70.Y VPWR.t1413 VPWR.t11 sg13_lv_pmos ad=0.3808p pd=2.92u as=0.3808p ps=2.92u w=1.12u l=0.13u
X2412 VGND.t12 sg13cmos5l_inv_1_449.A sg13cmos5l_inv_1_337.A VGND.t11 sg13_lv_nmos ad=0.2516p pd=2.16u as=0.2516p ps=2.16u w=0.74u l=0.13u
X2413 sg13cmos5l_inv_1_290.Y sg13cmos5l_inv_1_466.Y VPWR.t720 VPWR.t8 sg13_lv_pmos ad=0.3808p pd=2.92u as=0.3808p ps=2.92u w=1.12u l=0.13u
X2414 VGND.t94 invsel[5] a_808_16028# VGND.t93 sg13_lv_nmos ad=0.14875p pd=1.16u as=0.187p ps=1.78u w=0.55u l=0.13u
X2415 VGND.t171 sg13cmos5l_inv_1_874.A sg13cmos5l_inv_1_874.Y VGND.t600 sg13_lv_nmos ad=0.2516p pd=2.16u as=0.2516p ps=2.16u w=0.74u l=0.13u
X2416 VPWR.t437 sg13cmos5l_inv_1_862.A sg13cmos5l_mux4_1_13.A0 VPWR.t42 sg13_lv_pmos ad=0.3808p pd=2.92u as=0.3808p ps=2.92u w=1.12u l=0.13u
X2417 sg13cmos5l_inv_1_868.A sg13cmos5l_inv_1_818.Y VGND.t285 VGND.t489 sg13_lv_nmos ad=0.2516p pd=2.16u as=0.2516p ps=2.16u w=0.74u l=0.13u
X2418 a_14422_12606# a_13607_12606# a_14346_12606# VGND.t452 sg13_lv_nmos ad=0.1776p pd=1.195u as=80f ps=0.89u w=0.64u l=0.13u
X2419 VGND.t199 sg13cmos5l_inv_1_488.A sg13cmos5l_inv_1_487.A VGND.t419 sg13_lv_nmos ad=0.2516p pd=2.16u as=0.2516p ps=2.16u w=0.74u l=0.13u
X2420 VPWR.t507 sg13cmos5l_inv_1_782.A sg13cmos5l_inv_1_771.A VPWR.t39 sg13_lv_pmos ad=0.3808p pd=2.92u as=0.3808p ps=2.92u w=1.12u l=0.13u
X2421 VGND.t94 sg13cmos5l_nor2b_1_0.B_N a_1006_15296# VGND.t804 sg13_lv_nmos ad=0.17255p pd=1.25u as=0.187p ps=1.78u w=0.55u l=0.13u
X2422 VPWR.t1355 sg13cmos5l_inv_1_88.A sg13cmos5l_inv_1_88.Y VPWR.t49 sg13_lv_pmos ad=0.3808p pd=2.92u as=0.3808p ps=2.92u w=1.12u l=0.13u
X2423 VPWR.t631 sg13cmos5l_inv_1_118.A sg13cmos5l_inv_1_118.Y VPWR.t14 sg13_lv_pmos ad=0.3808p pd=2.92u as=0.3808p ps=2.92u w=1.12u l=0.13u
X2424 sg13cmos5l_inv_1_551.Y sg13cmos5l_inv_1_552.Y VPWR.t752 VPWR.t39 sg13_lv_pmos ad=0.3808p pd=2.92u as=0.3808p ps=2.92u w=1.12u l=0.13u
X2425 sg13cmos5l_inv_1_525.A sg13cmos5l_inv_1_509.Y VGND.t322 VGND.t321 sg13_lv_nmos ad=0.2516p pd=2.16u as=0.2516p ps=2.16u w=0.74u l=0.13u
X2426 a_4052_12606# sg13cmos5l_buf_1_8.A.t4 a_3934_12606# VGND.t1436 sg13_lv_nmos ad=0.2304p pd=1.36u as=0.1472p ps=1.1u w=0.64u l=0.13u
X2427 VGND.t43 sg13cmos5l_inv_1_264.A sg13cmos5l_inv_1_265.A VGND.t42 sg13_lv_nmos ad=0.2516p pd=2.16u as=0.2516p ps=2.16u w=0.74u l=0.13u
X2428 sg13cmos5l_inv_1_245.A sg13cmos5l_inv_1_248.A VPWR.t948 VPWR.t11 sg13_lv_pmos ad=0.3808p pd=2.92u as=0.3808p ps=2.92u w=1.12u l=0.13u
X2429 VGND.t248 sg13cmos5l_inv_1_328.Y sg13cmos5l_inv_1_336.A VGND.t677 sg13_lv_nmos ad=0.2516p pd=2.16u as=0.2516p ps=2.16u w=0.74u l=0.13u
X2430 sg13cmos5l_inv_1_130.A sg13cmos5l_inv_1_129.Y VPWR.t1262 VPWR.t14 sg13_lv_pmos ad=0.3808p pd=2.92u as=0.3808p ps=2.92u w=1.12u l=0.13u
X2431 a_14913_3940# sg13cmos5l_mux2_1_4.S.t2 a_13918_3898# VPWR.t49 sg13_lv_pmos ad=0.2225p pd=1.445u as=0.34p ps=2.68u w=1u l=0.13u
X2432 VGND.t315 sg13cmos5l_inv_1_706.A sg13cmos5l_inv_1_707.A VGND.t314 sg13_lv_nmos ad=0.2516p pd=2.16u as=0.2516p ps=2.16u w=0.74u l=0.13u
X2433 a_14341_12267# sg13cmos5l_inv_1_762.Y VPWR.t601 VPWR.t2 sg13_lv_pmos ad=0.20762p pd=1.605u as=0.29275p ps=1.785u w=1u l=0.13u
X2434 VPWR.t1207 sg13cmos5l_inv_1_266.Y sg13cmos5l_inv_1_452.Y VPWR.t49 sg13_lv_pmos ad=0.3808p pd=2.92u as=0.3808p ps=2.92u w=1.12u l=0.13u
X2435 sg13cmos5l_inv_1_966.Y sg13cmos5l_inv_1_963.Y VGND.t153 VGND.t4 sg13_lv_nmos ad=0.2516p pd=2.16u as=0.2516p ps=2.16u w=0.74u l=0.13u
X2436 sg13cmos5l_inv_1_788.Y sg13cmos5l_mux4_1_8.A0 VGND.t197 VGND.t22 sg13_lv_nmos ad=0.2516p pd=2.16u as=0.2516p ps=2.16u w=0.74u l=0.13u
X2437 sg13cmos5l_inv_1_811.Y sg13cmos5l_inv_1_798.Y VGND.t90 VGND.t275 sg13_lv_nmos ad=0.2516p pd=2.16u as=0.2516p ps=2.16u w=0.74u l=0.13u
X2438 a_15475_11725# sg13cmos5l_nor3_1_2.B.t2 a_14389_11500# VPWR.t2 sg13_lv_pmos ad=0.415p pd=1.83u as=0.19p ps=1.38u w=1u l=0.13u
X2439 sg13cmos5l_inv_1_344.A sg13cmos5l_inv_1_305.Y VPWR.t1112 VPWR.t14 sg13_lv_pmos ad=0.3808p pd=2.92u as=0.3808p ps=2.92u w=1.12u l=0.13u
X2440 sg13cmos5l_inv_1_345.A sg13cmos5l_inv_1_439.Y VPWR.t957 VPWR.t0 sg13_lv_pmos ad=0.3808p pd=2.92u as=0.3808p ps=2.92u w=1.12u l=0.13u
X2441 sg13cmos5l_inv_1_844.Y sg13cmos5l_inv_1_874.Y VPWR.t704 VPWR.t42 sg13_lv_pmos ad=0.3808p pd=2.92u as=0.3808p ps=2.92u w=1.12u l=0.13u
X2442 sg13cmos5l_inv_1_898.A sg13cmos5l_mux4_1_7.A2 VPWR.t881 VPWR.t26 sg13_lv_pmos ad=0.3808p pd=2.92u as=0.3808p ps=2.92u w=1.12u l=0.13u
X2443 sg13cmos5l_inv_1_124.A sg13cmos5l_inv_1_384.Y VPWR.t956 VPWR.t29 sg13_lv_pmos ad=0.3808p pd=2.92u as=0.3808p ps=2.92u w=1.12u l=0.13u
X2444 sg13cmos5l_inv_1_199.Y sg13cmos5l_inv_1_198.Y VPWR.t567 VPWR.t49 sg13_lv_pmos ad=0.3808p pd=2.92u as=0.3808p ps=2.92u w=1.12u l=0.13u
X2445 VGND.t503 sg13cmos5l_inv_1_564.A sg13cmos5l_inv_1_564.Y VGND.t502 sg13_lv_nmos ad=0.2516p pd=2.16u as=0.2516p ps=2.16u w=0.74u l=0.13u
X2446 sg13cmos5l_inv_1_159.A sg13cmos5l_inv_1_158.Y VGND.t130 VGND.t158 sg13_lv_nmos ad=0.2516p pd=2.16u as=0.2516p ps=2.16u w=0.74u l=0.13u
X2447 VPWR.t1311 sg13cmos5l_inv_1_382.A sg13cmos5l_inv_1_382.Y VPWR.t0 sg13_lv_pmos ad=0.3808p pd=2.92u as=0.3808p ps=2.92u w=1.12u l=0.13u
X2448 a_14701_9243# a_14183_9582# a_14494_9582# VPWR.t29 sg13_lv_pmos ad=0.16p pd=1.32u as=0.19p ps=1.38u w=1u l=0.13u
X2449 a_14710_15630# sg13cmos5l_buf_1_9.A.t5 a_14629_15291# VPWR.t21 sg13_lv_pmos ad=0.4425p pd=1.885u as=0.20762p ps=1.605u w=1u l=0.13u
X2450 VGND.t15 VPWR.t1551 VGND.t15 VGND.t1581 sg13_lv_nmos ad=0.1428p pd=1.52u as=0 ps=0 w=0.42u l=1u
X2451 VPWR.t1446 sg13cmos5l_inv_1_610.A sg13cmos5l_inv_1_610.Y VPWR.t42 sg13_lv_pmos ad=0.3808p pd=2.92u as=0.3808p ps=2.92u w=1.12u l=0.13u
X2452 VGND.t73 sg13cmos5l_inv_1_270.A sg13cmos5l_inv_1_270.Y VGND.t733 sg13_lv_nmos ad=0.2516p pd=2.16u as=0.2516p ps=2.16u w=0.74u l=0.13u
X2453 sg13cmos5l_inv_1_418.Y sg13cmos5l_inv_1_417.Y VPWR.t572 VPWR.t49 sg13_lv_pmos ad=0.3808p pd=2.92u as=0.3808p ps=2.92u w=1.12u l=0.13u
X2454 VGND.t23 sg13cmos5l_inv_1_807.Y sg13cmos5l_inv_1_890.A VGND.t22 sg13_lv_nmos ad=0.2516p pd=2.16u as=0.2516p ps=2.16u w=0.74u l=0.13u
X2455 VPWR.t987 sg13cmos5l_inv_1_902.Y sg13cmos5l_inv_1_889.A VPWR.t21 sg13_lv_pmos ad=0.3808p pd=2.92u as=0.3808p ps=2.92u w=1.12u l=0.13u
X2456 VGND.t78 VPWR.t1517 VGND.t78 VGND.t1623 sg13_lv_nmos ad=0.1428p pd=1.52u as=0 ps=0 w=0.42u l=1u
X2457 VGND.t587 VPWR.t1606 VGND.t587 VGND.t93 sg13_lv_nmos ad=0.1428p pd=1.52u as=0 ps=0 w=0.42u l=1u
X2458 VPWR.t1305 sg13cmos5l_inv_1_448.A sg13cmos5l_inv_1_448.Y VPWR.t49 sg13_lv_pmos ad=0.3808p pd=2.92u as=0.3808p ps=2.92u w=1.12u l=0.13u
X2459 VGND.t52 sg13cmos5l_inv_1_453.A sg13cmos5l_inv_1_453.Y VGND.t534 sg13_lv_nmos ad=0.2516p pd=2.16u as=0.2516p ps=2.16u w=0.74u l=0.13u
X2460 a_14346_3898# sg13cmos5l_mux4_1_2.A2 VGND.t435 VGND.t1292 sg13_lv_nmos ad=80f pd=0.89u as=0.1824p ps=1.21u w=0.64u l=0.13u
X2461 a_14036_12606# sg13cmos5l_buf_1_9.A.t2 a_13918_12606# VGND.t713 sg13_lv_nmos ad=0.2304p pd=1.36u as=0.1472p ps=1.1u w=0.64u l=0.13u
X2462 VGND.t212 sg13cmos5l_inv_1_236.A sg13cmos5l_inv_1_236.Y VGND.t11 sg13_lv_nmos ad=0.2516p pd=2.16u as=0.2516p ps=2.16u w=0.74u l=0.13u
X2463 sg13cmos5l_inv_1_482.Y sg13cmos5l_inv_1_481.Y VGND.t102 VGND.t486 sg13_lv_nmos ad=0.2516p pd=2.16u as=0.2516p ps=2.16u w=0.74u l=0.13u
X2464 a_4929_3492# sg13cmos5l_mux4_1_5.S1.t3 a_3934_3534# VPWR.t8 sg13_lv_pmos ad=0.2225p pd=1.445u as=0.34p ps=2.68u w=1u l=0.13u
X2465 VPWR.t1347 sg13cmos5l_inv_1_411.A sg13cmos5l_inv_1_411.Y VPWR.t14 sg13_lv_pmos ad=0.3808p pd=2.92u as=0.3808p ps=2.92u w=1.12u l=0.13u
X2466 VGND.t194 sg13cmos5l_inv_1_774.Y sg13cmos5l_inv_1_769.Y VGND.t1330 sg13_lv_nmos ad=0.2516p pd=2.16u as=0.2516p ps=2.16u w=0.74u l=0.13u
X2467 a_4362_15994# sg13cmos5l_mux4_1_10.A2 VGND.t263 VGND.t1374 sg13_lv_nmos ad=80f pd=0.89u as=0.1824p ps=1.21u w=0.64u l=0.13u
X2468 a_8577_16036# sg13cmos5l_buf_1_9.A.t6 a_8086_15994# VGND.t638 sg13_lv_nmos ad=0.1216p pd=1.02u as=0.54188p ps=3.42u w=0.64u l=0.13u
X2469 VGND.t145 sg13cmos5l_inv_1_504.A sg13cmos5l_inv_1_504.Y VGND.t1361 sg13_lv_nmos ad=0.2516p pd=2.16u as=0.2516p ps=2.16u w=0.74u l=0.13u
X2470 sg13cmos5l_inv_1_63.A sg13cmos5l_inv_1_102.Y VPWR.t762 VPWR.t8 sg13_lv_pmos ad=0.3808p pd=2.92u as=0.3808p ps=2.92u w=1.12u l=0.13u
X2471 VGND.t165 sg13cmos5l_inv_1_136.Y sg13cmos5l_inv_1_140.A VGND.t164 sg13_lv_nmos ad=0.2516p pd=2.16u as=0.2516p ps=2.16u w=0.74u l=0.13u
X2472 VGND.t78 VPWR.t1520 VGND.t78 VGND.t1620 sg13_lv_nmos ad=0.1428p pd=1.52u as=0 ps=0 w=0.42u l=1u
X2473 VPWR.t1333 sg13cmos5l_inv_1_537.A sg13cmos5l_inv_1_537.Y VPWR.t21 sg13_lv_pmos ad=0.3808p pd=2.92u as=0.3808p ps=2.92u w=1.12u l=0.13u
X2474 VGND.t414 VPWR.t1571 VGND.t612 VGND.t1554 sg13_lv_nmos ad=79.8f pd=0.8u as=0 ps=0 w=0.42u l=1u
X2475 VPWR.t1289 sg13cmos5l_inv_1_25.Y sg13cmos5l_inv_1_187.A VPWR.t49 sg13_lv_pmos ad=0.3808p pd=2.92u as=0.3808p ps=2.92u w=1.12u l=0.13u
X2476 sg13cmos5l_mux4_1_15.X a_15489_9540# VGND.t10 VGND.t9 sg13_lv_nmos ad=0.2516p pd=2.16u as=0.1543p ps=1.18u w=0.74u l=0.13u
X2477 VPWR.t442 sg13cmos5l_inv_1_485.A sg13cmos5l_inv_1_485.Y VPWR.t2 sg13_lv_pmos ad=0.3808p pd=2.92u as=0.3808p ps=2.92u w=1.12u l=0.13u
X2478 sg13cmos5l_inv_1_507.A sg13cmos5l_inv_1_521.Y VGND.t854 VGND.t853 sg13_lv_nmos ad=0.2516p pd=2.16u as=0.2516p ps=2.16u w=0.74u l=0.13u
X2479 sg13cmos5l_mux2_1_2.A0 a_4929_16036# VPWR.t760 VPWR.t42 sg13_lv_pmos ad=0.3808p pd=2.92u as=0.34367p ps=1.775u w=1.12u l=0.13u
X2480 sg13cmos5l_inv_1_305.A sg13cmos5l_inv_1_312.Y VPWR.t619 VPWR.t8 sg13_lv_pmos ad=0.3808p pd=2.92u as=0.3808p ps=2.92u w=1.12u l=0.13u
X2481 VPWR.t1224 sg13cmos5l_inv_1_571.A sg13cmos5l_inv_1_571.Y VPWR.t42 sg13_lv_pmos ad=0.3808p pd=2.92u as=0.3808p ps=2.92u w=1.12u l=0.13u
X2482 sg13cmos5l_inv_1_658.Y sg13cmos5l_mux4_1_10.A3 VPWR.t1447 VPWR.t21 sg13_lv_pmos ad=0.3808p pd=2.92u as=0.3808p ps=2.92u w=1.12u l=0.13u
X2483 sg13cmos5l_inv_1_649.Y sg13cmos5l_inv_1_650.Y VGND.t250 VGND.t249 sg13_lv_nmos ad=0.2516p pd=2.16u as=0.2516p ps=2.16u w=0.74u l=0.13u
X2484 a_16156_3898# sg13cmos5l_mux4_1_2.X a_15662_4084# VGND.t1160 sg13_lv_nmos ad=0.13135p pd=1.095u as=0.1628p ps=1.18u w=0.74u l=0.13u
X2485 sg13cmos5l_inv_1_702.Y sg13cmos5l_inv_1_700.Y VGND.t184 VGND.t626 sg13_lv_nmos ad=0.2516p pd=2.16u as=0.2516p ps=2.16u w=0.74u l=0.13u
X2486 VGND.t94 sg13cmos5l_inv_1_680.Y sg13cmos5l_inv_1_563.A VGND.t93 sg13_lv_nmos ad=0.2516p pd=2.16u as=0.2516p ps=2.16u w=0.74u l=0.13u
X2487 sg13cmos5l_inv_1_213.Y sg13cmos5l_inv_1_213.A VGND.t113 VGND.t11 sg13_lv_nmos ad=0.2516p pd=2.16u as=0.2516p ps=2.16u w=0.74u l=0.13u
X2488 sg13cmos5l_inv_1_774.Y sg13cmos5l_inv_1_773.Y VGND.t197 VGND.t22 sg13_lv_nmos ad=0.2516p pd=2.16u as=0.2516p ps=2.16u w=0.74u l=0.13u
X2489 sg13cmos5l_inv_1_39.A sg13cmos5l_inv_1_51.A VPWR.t333 VPWR.t8 sg13_lv_pmos ad=0.3808p pd=2.92u as=0.3808p ps=2.92u w=1.12u l=0.13u
X2490 VGND.t191 sg13cmos5l_nor3_1_0.Y sg13cmos5l_nor4_1_0.Y VGND.t190 sg13_lv_nmos ad=0.1406p pd=1.12u as=0.1406p ps=1.12u w=0.74u l=0.13u
X2491 VGND.t90 sg13cmos5l_inv_1_802.A sg13cmos5l_inv_1_798.A VGND.t89 sg13_lv_nmos ad=0.2516p pd=2.16u as=0.2516p ps=2.16u w=0.74u l=0.13u
X2492 VGND.t111 sg13cmos5l_inv_1_237.A sg13cmos5l_inv_1_237.Y VGND.t1642 sg13_lv_nmos ad=0.2516p pd=2.16u as=0.2516p ps=2.16u w=0.74u l=0.13u
X2493 VGND.t26 sg13cmos5l_buf_1_19.A sg13cmos5l_inv_1_711.Y VGND.t1081 sg13_lv_nmos ad=0.2516p pd=2.16u as=0.2516p ps=2.16u w=0.74u l=0.13u
X2494 sg13cmos5l_inv_1_364.A sg13cmos5l_inv_1_368.Y VPWR.t381 VPWR.t14 sg13_lv_pmos ad=0.3808p pd=2.92u as=0.3808p ps=2.92u w=1.12u l=0.13u
X2495 sg13cmos5l_inv_1_973.Y sg13cmos5l_inv_1_974.Y VPWR.t393 VPWR.t29 sg13_lv_pmos ad=0.3808p pd=2.92u as=0.3808p ps=2.92u w=1.12u l=0.13u
X2496 VGND.t19 sg13cmos5l_inv_1_324.Y a_4575_3534# VGND.t631 sg13_lv_nmos ad=0.2176p pd=1.96u as=76.8f ps=0.88u w=0.64u l=0.13u
X2497 sg13cmos5l_inv_1_560.A sg13cmos5l_inv_1_562.Y VPWR.t1453 VPWR.t42 sg13_lv_pmos ad=0.3808p pd=2.92u as=0.3808p ps=2.92u w=1.12u l=0.13u
X2498 VPWR.t949 sg13cmos5l_inv_1_404.Y sg13cmos5l_inv_1_387.Y VPWR.t14 sg13_lv_pmos ad=0.3808p pd=2.92u as=0.3808p ps=2.92u w=1.12u l=0.13u
X2499 sg13cmos5l_inv_1_848.Y sg13cmos5l_mux4_1_13.A0 VGND.t172 VGND.t22 sg13_lv_nmos ad=0.2516p pd=2.16u as=0.2516p ps=2.16u w=0.74u l=0.13u
X2500 VPWR.t1076 sg13cmos5l_mux4_1_15.A3 a_15221_9197# VPWR.t29 sg13_lv_pmos ad=0.34p pd=2.68u as=0.135p ps=1.27u w=1u l=0.13u
X2501 VGND.t41 sg13cmos5l_inv_1_738.A sg13cmos5l_inv_1_738.Y VGND.t151 sg13_lv_nmos ad=0.2516p pd=2.16u as=0.2516p ps=2.16u w=0.74u l=0.13u
X2502 VGND.t107 sg13cmos5l_inv_1_392.A sg13cmos5l_inv_1_393.A VGND.t954 sg13_lv_nmos ad=0.2516p pd=2.16u as=0.2516p ps=2.16u w=0.74u l=0.13u
X2503 VPWR.t1073 sg13cmos5l_inv_1_346.Y sg13cmos5l_inv_1_373.A VPWR.t14 sg13_lv_pmos ad=0.3808p pd=2.92u as=0.3808p ps=2.92u w=1.12u l=0.13u
X2504 sg13cmos5l_inv_1_775.A sg13cmos5l_inv_1_771.Y VGND.t194 VGND.t332 sg13_lv_nmos ad=0.2516p pd=2.16u as=0.2516p ps=2.16u w=0.74u l=0.13u
X2505 sg13cmos5l_inv_1_72.Y sg13cmos5l_inv_1_70.Y VGND.t123 VGND.t1411 sg13_lv_nmos ad=0.2516p pd=2.16u as=0.2516p ps=2.16u w=0.74u l=0.13u
X2506 VPWR.t423 sg13cmos5l_inv_1_297.Y sg13cmos5l_inv_1_324.Y VPWR.t8 sg13_lv_pmos ad=0.3808p pd=2.92u as=0.3808p ps=2.92u w=1.12u l=0.13u
X2507 sg13cmos5l_inv_1_958.Y sg13cmos5l_inv_1_957.Y VGND.t149 VGND.t423 sg13_lv_nmos ad=0.2516p pd=2.16u as=0.2516p ps=2.16u w=0.74u l=0.13u
X2508 VGND.t56 VPWR.t1608 VGND.t56 VGND.t22 sg13_lv_nmos ad=0.1428p pd=1.52u as=0 ps=0 w=0.42u l=1u
X2509 sg13cmos5l_inv_1_868.A sg13cmos5l_inv_1_818.Y VPWR.t611 VPWR.t21 sg13_lv_pmos ad=0.3808p pd=2.92u as=0.3808p ps=2.92u w=1.12u l=0.13u
X2510 sg13cmos5l_mux4_1_15.X a_15489_9540# VPWR.t258 VPWR.t29 sg13_lv_pmos ad=0.3808p pd=2.92u as=0.34367p ps=1.775u w=1.12u l=0.13u
X2511 a_9846_10240# sg13cmos5l_nor4_1_0.A VPWR.t1041 VPWR.t5 sg13_lv_pmos ad=0.2128p pd=1.5u as=0.3808p ps=2.92u w=1.12u l=0.13u
X2512 sg13cmos5l_nand2_1_1.B a_808_9980# VGND.t1072 VGND.t190 sg13_lv_nmos ad=0.2886p pd=2.26u as=0.14875p ps=1.16u w=0.74u l=0.13u
X2513 a_4556_3858# sg13cmos5l_buf_1_10.A VPWR.t1136 VPWR.t49 sg13_lv_pmos ad=0.2856p pd=2.36u as=0.2114p ps=1.54u w=0.84u l=0.13u
X2514 VGND.t514 sg13cmos5l_inv_1_118.A sg13cmos5l_inv_1_118.Y VGND.t513 sg13_lv_nmos ad=0.2516p pd=2.16u as=0.2516p ps=2.16u w=0.74u l=0.13u
X2515 sg13cmos5l_inv_1_802.A sg13cmos5l_inv_1_883.Y VGND.t90 VGND.t275 sg13_lv_nmos ad=0.2516p pd=2.16u as=0.2516p ps=2.16u w=0.74u l=0.13u
X2516 sg13cmos5l_inv_1_245.A sg13cmos5l_inv_1_248.A VGND.t111 VGND.t891 sg13_lv_nmos ad=0.2516p pd=2.16u as=0.2516p ps=2.16u w=0.74u l=0.13u
X2517 sg13cmos5l_inv_1_130.A sg13cmos5l_inv_1_129.Y VGND.t165 VGND.t1059 sg13_lv_nmos ad=0.2516p pd=2.16u as=0.2516p ps=2.16u w=0.74u l=0.13u
X2518 VPWR.t1369 sg13cmos5l_inv_1_585.A sg13cmos5l_inv_1_585.Y VPWR.t39 sg13_lv_pmos ad=0.3808p pd=2.92u as=0.3808p ps=2.92u w=1.12u l=0.13u
X2519 VPWR.t789 sg13cmos5l_inv_1_420.A sg13cmos5l_inv_1_334.A VPWR.t49 sg13_lv_pmos ad=0.3808p pd=2.92u as=0.3808p ps=2.92u w=1.12u l=0.13u
X2520 VPWR.t628 sg13cmos5l_inv_1_639.A sg13cmos5l_mux4_1_7.A3 VPWR.t21 sg13_lv_pmos ad=0.3808p pd=2.92u as=0.3808p ps=2.92u w=1.12u l=0.13u
X2521 VPWR.t101 VGND.t470 VPWR.t100 VPWR.t49 sg13_lv_pmos ad=0.34p pd=2.68u as=0 ps=0 w=1u l=1u
X2522 a_3934_8070# sg13cmos5l_mux4_1_5.S0.t4 a_3847_7731# VPWR.t14 sg13_lv_pmos ad=0.19p pd=1.38u as=0.415p ps=1.83u w=1u l=0.13u
X2523 sg13cmos5l_inv_1_966.Y sg13cmos5l_inv_1_963.Y VPWR.t1444 VPWR.t29 sg13_lv_pmos ad=0.3808p pd=2.92u as=0.3808p ps=2.92u w=1.12u l=0.13u
X2524 sg13cmos5l_inv_1_792.Y sg13cmos5l_inv_1_796.Y VGND.t171 VGND.t496 sg13_lv_nmos ad=0.2516p pd=2.16u as=0.2516p ps=2.16u w=0.74u l=0.13u
X2525 VGND.t102 sg13cmos5l_mux4_1_5.S0.t6 a_6599_12970# VGND.t1249 sg13_lv_nmos ad=0.1872p pd=1.225u as=0.2176p ps=1.96u w=0.64u l=0.13u
X2526 sg13cmos5l_mux4_1_9.X a_4929_12564# VGND.t102 VGND.t549 sg13_lv_nmos ad=0.2516p pd=2.16u as=0.1543p ps=1.18u w=0.74u l=0.13u
X2527 sg13cmos5l_inv_1_278.Y sg13cmos5l_inv_1_280.Y VGND.t111 VGND.t432 sg13_lv_nmos ad=0.2516p pd=2.16u as=0.2516p ps=2.16u w=0.74u l=0.13u
X2528 sg13cmos5l_inv_1_344.A sg13cmos5l_inv_1_305.Y VGND.t15 VGND.t1075 sg13_lv_nmos ad=0.2516p pd=2.16u as=0.2516p ps=2.16u w=0.74u l=0.13u
X2529 sg13cmos5l_inv_1_421.A sg13cmos5l_inv_1_451.A VGND.t420 VGND.t11 sg13_lv_nmos ad=0.2516p pd=2.16u as=0.2516p ps=2.16u w=0.74u l=0.13u
X2530 sg13cmos5l_inv_1_4.Y sg13cmos5l_inv_1_8.Y VGND.t492 VGND.t1643 sg13_lv_nmos ad=0.2516p pd=2.16u as=0.2516p ps=2.16u w=0.74u l=0.13u
X2531 VGND.t269 VPWR.t1575 VGND.t188 VGND.t1549 sg13_lv_nmos ad=79.8f pd=0.8u as=0 ps=0 w=0.42u l=1u
X2532 sg13cmos5l_inv_1_6.Y sg13cmos5l_inv_1_4.Y VGND.t492 VGND.t1392 sg13_lv_nmos ad=0.2516p pd=2.16u as=0.2516p ps=2.16u w=0.74u l=0.13u
X2533 VGND.t1 sg13cmos5l_inv_1_147.Y sg13cmos5l_inv_1_148.A VGND.t31 sg13_lv_nmos ad=0.2516p pd=2.16u as=0.2516p ps=2.16u w=0.74u l=0.13u
X2534 VGND.t23 VPWR.t1611 VGND.t23 VGND.t22 sg13_lv_nmos ad=0.1428p pd=1.52u as=0 ps=0 w=0.42u l=1u
X2535 VGND.t335 sg13cmos5l_inv_1_177.A sg13cmos5l_inv_1_177.Y VGND.t464 sg13_lv_nmos ad=0.2516p pd=2.16u as=0.2516p ps=2.16u w=0.74u l=0.13u
X2536 a_4141_16261# a_3623_15994# a_3934_15994# VPWR.t42 sg13_lv_pmos ad=0.16p pd=1.32u as=0.19p ps=1.38u w=1u l=0.13u
X2537 VGND.t12 sg13cmos5l_inv_1_421.Y sg13cmos5l_inv_1_434.A VGND.t11 sg13_lv_nmos ad=0.2516p pd=2.16u as=0.2516p ps=2.16u w=0.74u l=0.13u
X2538 VPWR.t673 sg13cmos5l_inv_1_630.A sg13cmos5l_inv_1_609.A VPWR.t42 sg13_lv_pmos ad=0.3808p pd=2.92u as=0.3808p ps=2.92u w=1.12u l=0.13u
X2539 VGND.t44 sg13cmos5l_inv_1_610.A sg13cmos5l_inv_1_610.Y VGND.t22 sg13_lv_nmos ad=0.2516p pd=2.16u as=0.2516p ps=2.16u w=0.74u l=0.13u
X2540 VGND.t435 a_15662_4084# sg13cmos5l_mux2_1_0.X VGND.t824 sg13_lv_nmos ad=0.148p pd=1.14u as=0.4033p ps=2.57u w=0.74u l=0.13u
X2541 sg13cmos5l_buf_1_23.X a_18664_16028# VGND.t35 VGND.t307 sg13_lv_nmos ad=0.2886p pd=2.26u as=0.14875p ps=1.16u w=0.74u l=0.13u
X2542 VGND.t41 sg13cmos5l_inv_1_761.A sg13cmos5l_inv_1_738.A VGND.t108 sg13_lv_nmos ad=0.2516p pd=2.16u as=0.2516p ps=2.16u w=0.74u l=0.13u
X2543 VGND.t26 sg13cmos5l_buf_1_18.A a_18280_12216# VGND.t835 sg13_lv_nmos ad=0.14875p pd=1.16u as=0.187p ps=1.78u w=0.55u l=0.13u
X2544 sg13cmos5l_inv_1_433.A sg13cmos5l_inv_1_462.Y VGND.t201 VGND.t1426 sg13_lv_nmos ad=0.2516p pd=2.16u as=0.2516p ps=2.16u w=0.74u l=0.13u
X2545 VGND.t184 sg13cmos5l_inv_1_699.A sg13cmos5l_inv_1_699.Y VGND.t1376 sg13_lv_nmos ad=0.2516p pd=2.16u as=0.2516p ps=2.16u w=0.74u l=0.13u
X2546 VPWR.t91 VGND.t107 VPWR.t90 VPWR.t0 sg13_lv_pmos ad=0.34p pd=2.68u as=0 ps=0 w=1u l=1u
X2547 VPWR.t794 sg13cmos5l_inv_1_493.A sg13cmos5l_inv_1_492.A VPWR.t2 sg13_lv_pmos ad=0.3808p pd=2.92u as=0.3808p ps=2.92u w=1.12u l=0.13u
X2548 sg13cmos5l_inv_1_483.Y sg13cmos5l_inv_1_677.Y VGND.t199 VGND.t198 sg13_lv_nmos ad=0.2516p pd=2.16u as=0.2516p ps=2.16u w=0.74u l=0.13u
X2549 VGND.t171 sg13cmos5l_buf_1_9.A.t5 a_13895_15630# VGND.t707 sg13_lv_nmos ad=0.1872p pd=1.225u as=0.2176p ps=1.96u w=0.64u l=0.13u
X2550 sg13cmos5l_inv_1_668.A sg13cmos5l_inv_1_689.Y VPWR.t1431 VPWR.t21 sg13_lv_pmos ad=0.3808p pd=2.92u as=0.3808p ps=2.92u w=1.12u l=0.13u
X2551 a_14036_3898# sg13cmos5l_mux4_1_5.S1.t4 a_13918_3898# VGND.t82 sg13_lv_nmos ad=0.2304p pd=1.36u as=0.1472p ps=1.1u w=0.64u l=0.13u
X2552 VGND.t133 VPWR.t1587 VGND.t133 VGND.t1531 sg13_lv_nmos ad=0.1428p pd=1.52u as=0 ps=0 w=0.42u l=1u
X2553 VGND.t396 sg13cmos5l_inv_1_78.A sg13cmos5l_inv_1_92.A VGND.t879 sg13_lv_nmos ad=0.2516p pd=2.16u as=0.2516p ps=2.16u w=0.74u l=0.13u
X2554 sg13cmos5l_nor4_1_0.Y sg13cmos5l_o21ai_1_0.Y a_10050_10240# VPWR.t5 sg13_lv_pmos ad=0.4368p pd=3.02u as=0.2128p ps=1.5u w=1.12u l=0.13u
X2555 VPWR.t909 sg13cmos5l_inv_1_771.A sg13cmos5l_inv_1_771.Y VPWR.t39 sg13_lv_pmos ad=0.3808p pd=2.92u as=0.3808p ps=2.92u w=1.12u l=0.13u
X2556 VGND.t29 sg13cmos5l_inv_1_571.A sg13cmos5l_inv_1_571.Y VGND.t22 sg13_lv_nmos ad=0.2516p pd=2.16u as=0.2516p ps=2.16u w=0.74u l=0.13u
X2557 sg13cmos5l_inv_1_787.Y sg13cmos5l_inv_1_800.Y VPWR.t1343 VPWR.t42 sg13_lv_pmos ad=0.3808p pd=2.92u as=0.3808p ps=2.92u w=1.12u l=0.13u
X2558 VGND.t90 sg13cmos5l_inv_1_884.Y sg13cmos5l_inv_1_883.A VGND.t89 sg13_lv_nmos ad=0.2516p pd=2.16u as=0.2516p ps=2.16u w=0.74u l=0.13u
X2559 VGND.t229 sg13cmos5l_inv_1_881.A sg13cmos5l_inv_1_880.A VGND.t1417 sg13_lv_nmos ad=0.2516p pd=2.16u as=0.2516p ps=2.16u w=0.74u l=0.13u
X2560 a_9885_8050# sg13cmos5l_mux2_1_3.S VGND.t76 VGND.t1043 sg13_lv_nmos ad=0.13135p pd=1.095u as=0.18945p ps=1.27u w=0.74u l=0.13u
X2561 VGND.t39 sg13cmos5l_inv_1_698.A sg13cmos5l_inv_1_994.A VGND.t180 sg13_lv_nmos ad=0.2516p pd=2.16u as=0.2516p ps=2.16u w=0.74u l=0.13u
X2562 VPWR.t1393 sg13cmos5l_inv_1_329.A sg13cmos5l_inv_1_311.A VPWR.t8 sg13_lv_pmos ad=0.3808p pd=2.92u as=0.3808p ps=2.92u w=1.12u l=0.13u
X2563 a_8446_8434# sg13cmos5l_mux4_1_6.X a_8349_8434# VGND.t1018 sg13_lv_nmos ad=0.1628p pd=1.18u as=0.13135p ps=1.095u w=0.74u l=0.13u
X2564 sg13cmos5l_inv_1_602.Y sg13cmos5l_inv_1_601.Y VGND.t325 VGND.t326 sg13_lv_nmos ad=0.2516p pd=2.16u as=0.2516p ps=2.16u w=0.74u l=0.13u
X2565 VPWR.t1087 sg13cmos5l_inv_1_723.A sg13cmos5l_inv_1_723.Y VPWR.t2 sg13_lv_pmos ad=0.3808p pd=2.92u as=0.3808p ps=2.92u w=1.12u l=0.13u
X2566 VPWR.t176 VGND.t478 VPWR.t175 VPWR.t26 sg13_lv_pmos ad=0.34p pd=2.68u as=0 ps=0 w=1u l=1u
X2567 sg13cmos5l_inv_1_505.Y sg13cmos5l_inv_1_503.Y VGND.t145 VGND.t962 sg13_lv_nmos ad=0.2516p pd=2.16u as=0.2516p ps=2.16u w=0.74u l=0.13u
X2568 VPWR.t1285 sg13cmos5l_inv_1_31.A sg13cmos5l_inv_1_31.Y VPWR.t8 sg13_lv_pmos ad=0.3808p pd=2.92u as=0.3808p ps=2.92u w=1.12u l=0.13u
X2569 VPWR.t1007 sg13cmos5l_inv_1_237.Y sg13cmos5l_inv_1_248.A VPWR.t0 sg13_lv_pmos ad=0.3808p pd=2.92u as=0.3808p ps=2.92u w=1.12u l=0.13u
X2570 VPWR.t1480 VGND.t128 VPWR.t1479 VPWR.t14 sg13_lv_pmos ad=0.34p pd=2.68u as=0 ps=0 w=1u l=1u
X2571 VPWR.t784 sg13cmos5l_inv_1_515.A sg13cmos5l_inv_1_515.Y VPWR.t2 sg13_lv_pmos ad=0.3808p pd=2.92u as=0.3808p ps=2.92u w=1.12u l=0.13u
X2572 VPWR.t1366 sg13cmos5l_inv_1_504.A sg13cmos5l_inv_1_504.Y VPWR.t5 sg13_lv_pmos ad=0.3808p pd=2.92u as=0.3808p ps=2.92u w=1.12u l=0.13u
X2573 sg13cmos5l_inv_1_287.Y sg13cmos5l_inv_1_287.A VGND.t617 VGND.t616 sg13_lv_nmos ad=0.2516p pd=2.16u as=0.2516p ps=2.16u w=0.74u l=0.13u
X2574 sg13cmos5l_inv_1_225.A sg13cmos5l_inv_1_190.A VGND.t16 VGND.t11 sg13_lv_nmos ad=0.2516p pd=2.16u as=0.2516p ps=2.16u w=0.74u l=0.13u
X2575 VPWR.t616 sg13cmos5l_buf_1_9.A.t2 a_13607_12606# VPWR.t2 sg13_lv_pmos ad=0.22315p pd=1.555u as=0.34p ps=2.68u w=1u l=0.13u
X2576 VPWR.t146 VGND.t41 VPWR.t145 VPWR.t2 sg13_lv_pmos ad=0.34p pd=2.68u as=0 ps=0 w=1u l=1u
X2577 sg13cmos5l_inv_1_560.A sg13cmos5l_inv_1_562.Y VGND.t100 VGND.t22 sg13_lv_nmos ad=0.2516p pd=2.16u as=0.2516p ps=2.16u w=0.74u l=0.13u
X2578 VGND.t52 sg13cmos5l_inv_1_325.A sg13cmos5l_inv_1_325.Y VGND.t1456 sg13_lv_nmos ad=0.2516p pd=2.16u as=0.2516p ps=2.16u w=0.74u l=0.13u
X2579 VGND.t162 sg13cmos5l_inv_1_404.Y sg13cmos5l_inv_1_387.Y VGND.t892 sg13_lv_nmos ad=0.2516p pd=2.16u as=0.2516p ps=2.16u w=0.74u l=0.13u
X2580 a_15105_3492# sg13cmos5l_mux2_1_4.S.t1 a_14614_3534# VGND.t771 sg13_lv_nmos ad=0.1216p pd=1.02u as=0.54188p ps=3.42u w=0.64u l=0.13u
X2581 sg13cmos5l_inv_1_237.A sg13cmos5l_inv_1_69.A VPWR.t650 VPWR.t11 sg13_lv_pmos ad=0.3808p pd=2.92u as=0.3808p ps=2.92u w=1.12u l=0.13u
X2582 sg13cmos5l_inv_1_454.Y sg13cmos5l_inv_1_464.Y VPWR.t1323 VPWR.t0 sg13_lv_pmos ad=0.3808p pd=2.92u as=0.3808p ps=2.92u w=1.12u l=0.13u
X2583 VGND.t8 sg13cmos5l_inv_1_936.A sg13cmos5l_inv_1_937.A VGND.t982 sg13_lv_nmos ad=0.2516p pd=2.16u as=0.2516p ps=2.16u w=0.74u l=0.13u
X2584 VGND.t1204 sg13cmos5l_mux4_1_5.S0.t7 a_7271_15994# VGND.t1210 sg13_lv_nmos ad=0.1872p pd=1.225u as=0.2176p ps=1.96u w=0.64u l=0.13u
X2585 VPWR.t239 VGND.t90 VPWR.t238 VPWR.t42 sg13_lv_pmos ad=0.34p pd=2.68u as=0 ps=0 w=1u l=1u
X2586 sg13cmos5l_inv_1_649.Y sg13cmos5l_inv_1_650.Y VPWR.t416 VPWR.t26 sg13_lv_pmos ad=0.3808p pd=2.92u as=0.3808p ps=2.92u w=1.12u l=0.13u
X2587 VGND.t248 sg13cmos5l_inv_1_320.A sg13cmos5l_inv_1_320.Y VGND.t1412 sg13_lv_nmos ad=0.2516p pd=2.16u as=0.2516p ps=2.16u w=0.74u l=0.13u
X2588 VPWR.t1508 sg13cmos5l_inv_1_225.A sg13cmos5l_inv_1_225.Y VPWR.t49 sg13_lv_pmos ad=0.3808p pd=2.92u as=0.3808p ps=2.92u w=1.12u l=0.13u
X2589 VGND.t96 sg13cmos5l_inv_1_766.A sg13cmos5l_inv_1_916.A VGND.t295 sg13_lv_nmos ad=0.2516p pd=2.16u as=0.2516p ps=2.16u w=0.74u l=0.13u
X2590 a_18764_12180# sg13cmos5l_buf_1_19.A VGND.t26 VGND.t1080 sg13_lv_nmos ad=0.187p pd=1.78u as=0.14875p ps=1.16u w=0.55u l=0.13u
X2591 sg13cmos5l_inv_1_702.Y sg13cmos5l_inv_1_700.Y VPWR.t723 VPWR.t5 sg13_lv_pmos ad=0.3808p pd=2.92u as=0.3808p ps=2.92u w=1.12u l=0.13u
X2592 sg13cmos5l_inv_1_958.Y sg13cmos5l_inv_1_957.Y VPWR.t559 VPWR.t29 sg13_lv_pmos ad=0.3808p pd=2.92u as=0.3808p ps=2.92u w=1.12u l=0.13u
X2593 a_9365_6173# a_8327_6558# a_9142_6558# VPWR.t0 sg13_lv_pmos ad=0.135p pd=1.27u as=0.4425p ps=1.885u w=1u l=0.13u
X2594 VPWR.t1482 sg13cmos5l_inv_1_29.A sg13cmos5l_inv_1_51.A VPWR.t49 sg13_lv_pmos ad=0.3808p pd=2.92u as=0.3808p ps=2.92u w=1.12u l=0.13u
X2595 a_15608_7680# sg13cmos5l_buf_1_8.A.t2 a_16113_8070# VGND.t663 sg13_lv_nmos ad=0.1776p pd=1.195u as=76.8f ps=0.88u w=0.64u l=0.13u
X2596 VGND.t435 sg13cmos5l_mux4_1_1.A3 a_14751_3534# VGND.t594 sg13_lv_nmos ad=0.2176p pd=1.96u as=76.8f ps=0.88u w=0.64u l=0.13u
X2597 sg13cmos5l_inv_1_120.Y sg13cmos5l_inv_1_120.A VPWR.t498 VPWR.t14 sg13_lv_pmos ad=0.3808p pd=2.92u as=0.3808p ps=2.92u w=1.12u l=0.13u
X2598 sg13cmos5l_inv_1_802.A sg13cmos5l_inv_1_883.Y VPWR.t1374 VPWR.t21 sg13_lv_pmos ad=0.3808p pd=2.92u as=0.3808p ps=2.92u w=1.12u l=0.13u
X2599 sg13cmos5l_inv_1_399.Y sg13cmos5l_inv_1_398.Y VPWR.t944 VPWR.t14 sg13_lv_pmos ad=0.3808p pd=2.92u as=0.3808p ps=2.92u w=1.12u l=0.13u
X2600 sg13cmos5l_inv_1_735.Y sg13cmos5l_inv_1_998.Y VGND.t612 VGND.t611 sg13_lv_nmos ad=0.2516p pd=2.16u as=0.2516p ps=2.16u w=0.74u l=0.13u
X2601 VGND.t225 sg13cmos5l_inv_1_270.Y sg13cmos5l_inv_1_414.A VGND.t11 sg13_lv_nmos ad=0.2516p pd=2.16u as=0.2516p ps=2.16u w=0.74u l=0.13u
X2602 sg13cmos5l_inv_1_467.Y sg13cmos5l_inv_1_467.A VGND.t162 VGND.t182 sg13_lv_nmos ad=0.2516p pd=2.16u as=0.2516p ps=2.16u w=0.74u l=0.13u
X2603 VPWR.t264 sg13cmos5l_inv_1_265.A sg13cmos5l_inv_1_266.A VPWR.t49 sg13_lv_pmos ad=0.3808p pd=2.92u as=0.3808p ps=2.92u w=1.12u l=0.13u
X2604 VGND.t470 sg13cmos5l_inv_1_207.A sg13cmos5l_inv_1_207.Y VGND.t11 sg13_lv_nmos ad=0.2516p pd=2.16u as=0.2516p ps=2.16u w=0.74u l=0.13u
X2605 VPWR.t858 sg13cmos5l_buf_1_21.A a_18280_18264# VPWR.t39 sg13_lv_pmos ad=0.2114p pd=1.54u as=0.2856p ps=2.36u w=0.84u l=0.13u
X2606 a_14710_15630# a_15277_15514# a_15201_15588# VPWR.t21 sg13_lv_pmos ad=0.34p pd=2.68u as=0.2225p ps=1.445u w=1u l=0.13u
X2607 VPWR.t1219 sg13cmos5l_inv_1_821.Y sg13cmos5l_inv_1_819.A VPWR.t39 sg13_lv_pmos ad=0.3808p pd=2.92u as=0.3808p ps=2.92u w=1.12u l=0.13u
X2608 VPWR.t345 sg13cmos5l_inv_1_738.A sg13cmos5l_inv_1_738.Y VPWR.t5 sg13_lv_pmos ad=0.3808p pd=2.92u as=0.3808p ps=2.92u w=1.12u l=0.13u
X2609 VGND.t1503 VPWR.t1603 VGND.t1503 VGND.t804 sg13_lv_nmos ad=0.1428p pd=1.52u as=0 ps=0 w=0.42u l=1u
X2610 osc_tap[2] a_18856_7680# VPWR.t638 VPWR.t14 sg13_lv_pmos ad=0.42p pd=2.99u as=0.2114p ps=1.54u w=1.12u l=0.13u
X2611 VPWR.t99 VGND.t15 VPWR.t98 VPWR.t14 sg13_lv_pmos ad=0.34p pd=2.68u as=0 ps=0 w=1u l=1u
X2612 VGND.t116 sg13cmos5l_inv_1_852.Y sg13cmos5l_inv_1_851.A VGND.t22 sg13_lv_nmos ad=0.2516p pd=2.16u as=0.2516p ps=2.16u w=0.74u l=0.13u
X2613 sg13cmos5l_inv_1_286.Y sg13cmos5l_inv_1_288.Y VGND.t43 VGND.t1288 sg13_lv_nmos ad=0.2516p pd=2.16u as=0.2516p ps=2.16u w=0.74u l=0.13u
X2614 VPWR.t1448 sg13cmos5l_mux4_1_10.A3 a_4661_16307# VPWR.t42 sg13_lv_pmos ad=0.34p pd=2.68u as=0.135p ps=1.27u w=1u l=0.13u
X2615 VPWR.t36 VGND.t902 VPWR.t35 VPWR.t5 sg13_lv_pmos ad=0.19p pd=1.38u as=0 ps=0 w=1u l=1u
X2616 VGND.t44 sg13cmos5l_inv_1_630.A sg13cmos5l_inv_1_609.A VGND.t22 sg13_lv_nmos ad=0.2516p pd=2.16u as=0.2516p ps=2.16u w=0.74u l=0.13u
X2617 sg13cmos5l_nor2b_1_0.A a_808_16028# VGND.t94 VGND.t93 sg13_lv_nmos ad=0.2886p pd=2.26u as=0.14875p ps=1.16u w=0.74u l=0.13u
X2618 sg13cmos5l_a22oi_1_0.A2 sg13cmos5l_nor3_1_2.B VGND.t133 VGND.t1470 sg13_lv_nmos ad=0.1406p pd=1.12u as=0.2516p ps=2.16u w=0.74u l=0.13u
X2619 VPWR.t297 sg13cmos5l_inv_1_837.Y sg13cmos5l_inv_1_835.A VPWR.t39 sg13_lv_pmos ad=0.3808p pd=2.92u as=0.3808p ps=2.92u w=1.12u l=0.13u
X2620 sg13cmos5l_inv_1_797.A sg13cmos5l_inv_1_799.A VPWR.t1247 VPWR.t42 sg13_lv_pmos ad=0.3808p pd=2.92u as=0.3808p ps=2.92u w=1.12u l=0.13u
X2621 VGND.t335 sg13cmos5l_inv_1_141.Y sg13cmos5l_inv_1_175.A VGND.t995 sg13_lv_nmos ad=0.2516p pd=2.16u as=0.2516p ps=2.16u w=0.74u l=0.13u
X2622 sg13cmos5l_inv_1_384.Y sg13cmos5l_inv_1_394.Y VGND.t76 VGND.t227 sg13_lv_nmos ad=0.2516p pd=2.16u as=0.2516p ps=2.16u w=0.74u l=0.13u
X2623 sg13cmos5l_inv_1_191.A sg13cmos5l_inv_1_109.Y VPWR.t994 VPWR.t0 sg13_lv_pmos ad=0.3808p pd=2.92u as=0.3808p ps=2.92u w=1.12u l=0.13u
X2624 a_8383_12192# sg13cmos5l_a22oi_1_0.A1 VPWR.t1260 VPWR.t2 sg13_lv_pmos ad=0.2716p pd=1.605u as=0.3808p ps=2.92u w=1.12u l=0.13u
X2625 sg13cmos5l_inv_1_472.Y sg13cmos5l_inv_1_471.Y VGND.t269 VGND.t990 sg13_lv_nmos ad=0.2516p pd=2.16u as=0.2516p ps=2.16u w=0.74u l=0.13u
X2626 sg13cmos5l_inv_1_267.Y sg13cmos5l_inv_1_311.Y VPWR.t1163 VPWR.t49 sg13_lv_pmos ad=0.3808p pd=2.92u as=0.3808p ps=2.92u w=1.12u l=0.13u
X2627 VPWR.t1319 sg13cmos5l_inv_1_438.A sg13cmos5l_inv_1_437.A VPWR.t0 sg13_lv_pmos ad=0.3808p pd=2.92u as=0.3808p ps=2.92u w=1.12u l=0.13u
X2628 a_4438_3534# a_3623_3534# a_4362_3534# VGND.t684 sg13_lv_nmos ad=0.1776p pd=1.195u as=80f ps=0.89u w=0.64u l=0.13u
X2629 VPWR.t1427 sg13cmos5l_inv_1_274.Y sg13cmos5l_inv_1_276.A VPWR.t49 sg13_lv_pmos ad=0.3808p pd=2.92u as=0.3808p ps=2.92u w=1.12u l=0.13u
X2630 VPWR.t588 sg13cmos5l_inv_1_878.A sg13cmos5l_mux4_1_14.A3 VPWR.t21 sg13_lv_pmos ad=0.3808p pd=2.92u as=0.3808p ps=2.92u w=1.12u l=0.13u
X2631 VPWR.t368 sg13cmos5l_inv_1_933.A sg13cmos5l_inv_1_933.Y VPWR.t5 sg13_lv_pmos ad=0.3808p pd=2.92u as=0.3808p ps=2.92u w=1.12u l=0.13u
X2632 a_9996_11500# sg13cmos5l_nor4_1_0.Y a_9825_11776# VPWR.t2 sg13_lv_pmos ad=0.35p pd=2.7u as=0.2125p ps=1.425u w=1u l=0.13u
X2633 VPWR.t1043 sg13cmos5l_inv_1_202.Y a_14701_9243# VPWR.t29 sg13_lv_pmos ad=0.29275p pd=1.785u as=0.16p ps=1.32u w=1u l=0.13u
X2634 VGND.t567 VPWR.t1612 VGND.t567 VGND.t22 sg13_lv_nmos ad=0.1428p pd=1.52u as=0 ps=0 w=0.42u l=1u
X2635 VPWR.t1318 sg13cmos5l_inv_1_233.A sg13cmos5l_inv_1_989.A VPWR.t49 sg13_lv_pmos ad=0.3808p pd=2.92u as=0.3808p ps=2.92u w=1.12u l=0.13u
X2636 VPWR.t305 sg13cmos5l_inv_1_884.Y sg13cmos5l_inv_1_883.A VPWR.t21 sg13_lv_pmos ad=0.3808p pd=2.92u as=0.3808p ps=2.92u w=1.12u l=0.13u
X2637 VGND.t363 sg13cmos5l_inv_1_783.A sg13cmos5l_inv_1_782.A VGND.t1409 sg13_lv_nmos ad=0.2516p pd=2.16u as=0.2516p ps=2.16u w=0.74u l=0.13u
X2638 VGND.t263 sg13cmos5l_buf_1_9.A.t7 a_5005_16000# VGND.t673 sg13_lv_nmos ad=0.1543p pd=1.18u as=0.2304p ps=2u w=0.64u l=0.13u
X2639 VPWR.t1361 sg13cmos5l_inv_1_238.A sg13cmos5l_inv_1_244.A VPWR.t11 sg13_lv_pmos ad=0.3808p pd=2.92u as=0.3808p ps=2.92u w=1.12u l=0.13u
X2640 VPWR.t681 sg13cmos5l_inv_1_827.Y sg13cmos5l_inv_1_828.Y VPWR.t39 sg13_lv_pmos ad=0.3808p pd=2.92u as=0.3808p ps=2.92u w=1.12u l=0.13u
X2641 a_18764_18228# sg13cmos5l_inv_1_828.Y VPWR.t911 VPWR.t39 sg13_lv_pmos ad=0.2856p pd=2.36u as=0.2114p ps=1.54u w=0.84u l=0.13u
X2642 VGND.t1 sg13cmos5l_inv_1_179.A sg13cmos5l_inv_1_150.A VGND.t31 sg13_lv_nmos ad=0.2516p pd=2.16u as=0.2516p ps=2.16u w=0.74u l=0.13u
X2643 VPWR.t1070 sg13cmos5l_inv_1_518.A sg13cmos5l_inv_1_518.Y VPWR.t2 sg13_lv_pmos ad=0.3808p pd=2.92u as=0.3808p ps=2.92u w=1.12u l=0.13u
X2644 VPWR.t414 sg13cmos5l_inv_1_251.A sg13cmos5l_inv_1_453.A VPWR.t11 sg13_lv_pmos ad=0.3808p pd=2.92u as=0.3808p ps=2.92u w=1.12u l=0.13u
X2645 a_7789_3195# a_7271_3534# a_7582_3534# VPWR.t8 sg13_lv_pmos ad=0.16p pd=1.32u as=0.19p ps=1.38u w=1u l=0.13u
X2646 VPWR.t1380 sg13cmos5l_inv_1_699.A sg13cmos5l_inv_1_699.Y VPWR.t5 sg13_lv_pmos ad=0.3808p pd=2.92u as=0.3808p ps=2.92u w=1.12u l=0.13u
X2647 VPWR.t210 VGND.t162 VPWR.t208 VPWR.t29 sg13_lv_pmos ad=0.19p pd=1.38u as=0 ps=0 w=1u l=1u
X2648 sg13cmos5l_inv_1_694.Y sg13cmos5l_inv_1_694.A VGND.t39 VGND.t852 sg13_lv_nmos ad=0.2516p pd=2.16u as=0.2516p ps=2.16u w=0.74u l=0.13u
X2649 VGND.t69 sg13cmos5l_buf_1_21.A a_18280_18264# VGND.t797 sg13_lv_nmos ad=0.14875p pd=1.16u as=0.187p ps=1.78u w=0.55u l=0.13u
X2650 sg13cmos5l_inv_1_904.A sg13cmos5l_inv_1_905.Y VGND.t876 VGND.t875 sg13_lv_nmos ad=0.2516p pd=2.16u as=0.2516p ps=2.16u w=0.74u l=0.13u
X2651 sg13cmos5l_inv_1_598.A sg13cmos5l_inv_1_602.Y VPWR.t478 VPWR.t39 sg13_lv_pmos ad=0.3808p pd=2.92u as=0.3808p ps=2.92u w=1.12u l=0.13u
X2652 a_3860_3534# sg13cmos5l_inv_1_322.A VGND.t54 VGND.t53 sg13_lv_nmos ad=76.8f pd=0.88u as=0.1872p ps=1.225u w=0.64u l=0.13u
X2653 sg13cmos5l_mux4_1_2.A2 sg13cmos5l_inv_1_31.Y VGND.t28 VGND.t27 sg13_lv_nmos ad=0.2516p pd=2.16u as=0.2516p ps=2.16u w=0.74u l=0.13u
X2654 a_14317_3195# a_13799_3534# a_14110_3534# VPWR.t8 sg13_lv_pmos ad=0.16p pd=1.32u as=0.19p ps=1.38u w=1u l=0.13u
X2655 VGND.t256 sg13cmos5l_inv_1_19.A sg13cmos5l_inv_1_14.A VGND.t522 sg13_lv_nmos ad=0.2516p pd=2.16u as=0.2516p ps=2.16u w=0.74u l=0.13u
X2656 a_8086_3534# a_8653_3418# a_8577_3492# VPWR.t8 sg13_lv_pmos ad=0.34p pd=2.68u as=0.2225p ps=1.445u w=1u l=0.13u
X2657 VPWR.t452 sg13cmos5l_inv_1_766.A sg13cmos5l_inv_1_916.A VPWR.t21 sg13_lv_pmos ad=0.3808p pd=2.92u as=0.3808p ps=2.92u w=1.12u l=0.13u
X2658 sg13cmos5l_mux4_1_13.A3 sg13cmos5l_inv_1_875.Y VGND.t35 VGND.t818 sg13_lv_nmos ad=0.2516p pd=2.16u as=0.2516p ps=2.16u w=0.74u l=0.13u
X2659 VPWR.t367 sg13cmos5l_inv_1_698.A sg13cmos5l_inv_1_994.A VPWR.t5 sg13_lv_pmos ad=0.3808p pd=2.92u as=0.3808p ps=2.92u w=1.12u l=0.13u
X2660 sg13cmos5l_inv_1_505.Y sg13cmos5l_inv_1_503.Y VPWR.t1016 VPWR.t5 sg13_lv_pmos ad=0.3808p pd=2.92u as=0.3808p ps=2.92u w=1.12u l=0.13u
X2661 sg13cmos5l_inv_1_930.A sg13cmos5l_inv_1_961.Y VPWR.t1423 VPWR.t5 sg13_lv_pmos ad=0.3808p pd=2.92u as=0.3808p ps=2.92u w=1.12u l=0.13u
X2662 sg13cmos5l_inv_1_187.Y sg13cmos5l_inv_1_187.A VGND.t113 VGND.t11 sg13_lv_nmos ad=0.2516p pd=2.16u as=0.2516p ps=2.16u w=0.74u l=0.13u
X2663 sg13cmos5l_inv_1_120.Y sg13cmos5l_inv_1_120.A VGND.t267 VGND.t350 sg13_lv_nmos ad=0.2516p pd=2.16u as=0.2516p ps=2.16u w=0.74u l=0.13u
X2664 sg13cmos5l_inv_1_293.Y sg13cmos5l_inv_1_290.Y VGND.t399 VGND.t1463 sg13_lv_nmos ad=0.2516p pd=2.16u as=0.2516p ps=2.16u w=0.74u l=0.13u
X2665 a_4438_12606# a_3623_12606# a_4362_12606# VGND.t211 sg13_lv_nmos ad=0.1776p pd=1.195u as=80f ps=0.89u w=0.64u l=0.13u
X2666 osc_tap[0] a_18856_3932# VPWR.t563 VPWR.t49 sg13_lv_pmos ad=0.42p pd=2.99u as=0.2114p ps=1.54u w=1.12u l=0.13u
X2667 VPWR.t1460 sg13cmos5l_inv_1_820.A sg13cmos5l_inv_1_821.A VPWR.t39 sg13_lv_pmos ad=0.3808p pd=2.92u as=0.3808p ps=2.92u w=1.12u l=0.13u
X2668 sg13cmos5l_inv_1_565.Y sg13cmos5l_inv_1_537.Y VPWR.t695 VPWR.t42 sg13_lv_pmos ad=0.3808p pd=2.92u as=0.3808p ps=2.92u w=1.12u l=0.13u
X2669 sg13cmos5l_inv_1_857.A sg13cmos5l_inv_1_847.Y VPWR.t295 VPWR.t42 sg13_lv_pmos ad=0.3808p pd=2.92u as=0.3808p ps=2.92u w=1.12u l=0.13u
X2670 VGND.t37 sg13cmos5l_inv_1_871.Y sg13cmos5l_inv_1_841.Y VGND.t22 sg13_lv_nmos ad=0.2516p pd=2.16u as=0.2516p ps=2.16u w=0.74u l=0.13u
X2671 sg13cmos5l_inv_1_855.Y sg13cmos5l_inv_1_855.A VPWR.t448 VPWR.t42 sg13_lv_pmos ad=0.3808p pd=2.92u as=0.3808p ps=2.92u w=1.12u l=0.13u
X2672 VGND.t12 sg13cmos5l_inv_1_422.A sg13cmos5l_inv_1_449.A VGND.t11 sg13_lv_nmos ad=0.2516p pd=2.16u as=0.2516p ps=2.16u w=0.74u l=0.13u
X2673 sg13cmos5l_inv_1_85.A sg13cmos5l_inv_1_82.Y VPWR.t541 VPWR.t8 sg13_lv_pmos ad=0.3808p pd=2.92u as=0.3808p ps=2.92u w=1.12u l=0.13u
X2674 VPWR.t1408 sg13cmos5l_inv_1_948.A sg13cmos5l_inv_1_693.A VPWR.t21 sg13_lv_pmos ad=0.3808p pd=2.92u as=0.3808p ps=2.92u w=1.12u l=0.13u
X2675 sg13cmos5l_inv_1_908.A sg13cmos5l_inv_1_882.Y VGND.t3 VGND.t520 sg13_lv_nmos ad=0.2516p pd=2.16u as=0.2516p ps=2.16u w=0.74u l=0.13u
X2676 VGND.t8 sg13cmos5l_mux4_1_5.S1.t8 a_14183_9582# VGND.t4 sg13_lv_nmos ad=0.1872p pd=1.225u as=0.2176p ps=1.96u w=0.64u l=0.13u
X2677 sg13cmos5l_inv_1_858.Y sg13cmos5l_inv_1_857.Y VGND.t285 VGND.t284 sg13_lv_nmos ad=0.2516p pd=2.16u as=0.2516p ps=2.16u w=0.74u l=0.13u
X2678 sg13cmos5l_inv_1_1012.Y sg13cmos5l_inv_1_947.Y VGND.t5 VGND.t190 sg13_lv_nmos ad=0.2516p pd=2.16u as=0.2516p ps=2.16u w=0.74u l=0.13u
X2679 a_18764_18228# sg13cmos5l_inv_1_828.Y VGND.t69 VGND.t843 sg13_lv_nmos ad=0.187p pd=1.78u as=0.14875p ps=1.16u w=0.55u l=0.13u
X2680 sg13cmos5l_inv_1_786.Y sg13cmos5l_inv_1_797.Y VPWR.t308 VPWR.t42 sg13_lv_pmos ad=0.3808p pd=2.92u as=0.3808p ps=2.92u w=1.12u l=0.13u
X2681 VPWR.t555 sg13cmos5l_inv_1_488.A sg13cmos5l_inv_1_487.A VPWR.t2 sg13_lv_pmos ad=0.3808p pd=2.92u as=0.3808p ps=2.92u w=1.12u l=0.13u
X2682 VGND.t754 sg13cmos5l_inv_1_129.A sg13cmos5l_inv_1_129.Y VGND.t753 sg13_lv_nmos ad=0.2516p pd=2.16u as=0.2516p ps=2.16u w=0.74u l=0.13u
X2683 a_14341_4165# sg13cmos5l_mux4_1_2.A2 VPWR.t1300 VPWR.t49 sg13_lv_pmos ad=0.20762p pd=1.605u as=0.29275p ps=1.785u w=1u l=0.13u
X2684 sg13cmos5l_inv_1_826.Y sg13cmos5l_inv_1_819.Y VPWR.t1241 VPWR.t39 sg13_lv_pmos ad=0.3808p pd=2.92u as=0.3808p ps=2.92u w=1.12u l=0.13u
X2685 sg13cmos5l_inv_1_735.Y sg13cmos5l_inv_1_998.Y VPWR.t933 VPWR.t5 sg13_lv_pmos ad=0.3808p pd=2.92u as=0.3808p ps=2.92u w=1.12u l=0.13u
X2686 sg13cmos5l_inv_1_967.Y sg13cmos5l_inv_1_966.Y VGND.t153 VGND.t4 sg13_lv_nmos ad=0.2516p pd=2.16u as=0.2516p ps=2.16u w=0.74u l=0.13u
X2687 VPWR.t830 sg13cmos5l_inv_1_632.A sg13cmos5l_inv_1_631.A VPWR.t21 sg13_lv_pmos ad=0.3808p pd=2.92u as=0.3808p ps=2.92u w=1.12u l=0.13u
X2688 VPWR.t1351 sg13cmos5l_inv_1_875.A sg13cmos5l_inv_1_875.Y VPWR.t21 sg13_lv_pmos ad=0.3808p pd=2.92u as=0.3808p ps=2.92u w=1.12u l=0.13u
X2689 VPWR.t1327 sg13cmos5l_inv_1_617.A sg13cmos5l_inv_1_618.A VPWR.t42 sg13_lv_pmos ad=0.3808p pd=2.92u as=0.3808p ps=2.92u w=1.12u l=0.13u
X2690 sg13cmos5l_inv_1_12.Y sg13cmos5l_inv_1_17.Y VPWR.t757 VPWR.t11 sg13_lv_pmos ad=0.3808p pd=2.92u as=0.3808p ps=2.92u w=1.12u l=0.13u
X2691 VPWR.t1304 sg13cmos5l_inv_1_338.Y sg13cmos5l_inv_1_319.Y VPWR.t49 sg13_lv_pmos ad=0.3808p pd=2.92u as=0.3808p ps=2.92u w=1.12u l=0.13u
X2692 VGND.t343 sg13cmos5l_inv_1_429.A sg13cmos5l_inv_1_426.A VGND.t11 sg13_lv_nmos ad=0.2516p pd=2.16u as=0.2516p ps=2.16u w=0.74u l=0.13u
X2693 sg13cmos5l_inv_1_439.A sg13cmos5l_inv_1_450.Y VPWR.t259 VPWR.t0 sg13_lv_pmos ad=0.3808p pd=2.92u as=0.3808p ps=2.92u w=1.12u l=0.13u
X2694 VGND.t102 sg13cmos5l_inv_1_495.A sg13cmos5l_inv_1_498.A VGND.t101 sg13_lv_nmos ad=0.2516p pd=2.16u as=0.2516p ps=2.16u w=0.74u l=0.13u
X2695 VGND.t225 sg13cmos5l_inv_1_445.A sg13cmos5l_inv_1_447.A VGND.t11 sg13_lv_nmos ad=0.2516p pd=2.16u as=0.2516p ps=2.16u w=0.74u l=0.13u
X2696 VPWR.t1022 sg13cmos5l_inv_1_879.A sg13cmos5l_inv_1_878.A VPWR.t21 sg13_lv_pmos ad=0.3808p pd=2.92u as=0.3808p ps=2.92u w=1.12u l=0.13u
X2697 sg13cmos5l_inv_1_30.A sg13cmos5l_inv_1_199.Y VPWR.t459 VPWR.t49 sg13_lv_pmos ad=0.3808p pd=2.92u as=0.3808p ps=2.92u w=1.12u l=0.13u
X2698 VPWR.t388 sg13cmos5l_inv_1_228.A sg13cmos5l_inv_1_228.Y VPWR.t49 sg13_lv_pmos ad=0.3808p pd=2.92u as=0.3808p ps=2.92u w=1.12u l=0.13u
X2699 sg13cmos5l_inv_1_1007.Y sg13cmos5l_inv_1_924.Y VPWR.t930 VPWR.t5 sg13_lv_pmos ad=0.3808p pd=2.92u as=0.3808p ps=2.92u w=1.12u l=0.13u
X2700 VGND.t435 sg13cmos5l_inv_1_76.A a_14559_3898# VGND.t784 sg13_lv_nmos ad=0.2176p pd=1.96u as=76.8f ps=0.88u w=0.64u l=0.13u
X2701 VPWR.t1114 sg13cmos5l_inv_1_389.A sg13cmos5l_inv_1_389.Y VPWR.t0 sg13_lv_pmos ad=0.3808p pd=2.92u as=0.3808p ps=2.92u w=1.12u l=0.13u
X2702 VGND.t578 sg13cmos5l_inv_1_780.A sg13cmos5l_inv_1_780.Y VGND.t1367 sg13_lv_nmos ad=0.2516p pd=2.16u as=0.2516p ps=2.16u w=0.74u l=0.13u
X2703 VGND.t147 sg13cmos5l_inv_1_926.Y sg13cmos5l_inv_1_499.Y VGND.t836 sg13_lv_nmos ad=0.2516p pd=2.16u as=0.2516p ps=2.16u w=0.74u l=0.13u
X2704 sg13cmos5l_buf_1_12.X a_808_6956# VGND.t614 VGND.t921 sg13_lv_nmos ad=0.2886p pd=2.26u as=0.14875p ps=1.16u w=0.74u l=0.13u
X2705 a_14614_3534# a_13799_3534# a_14538_3534# VGND.t741 sg13_lv_nmos ad=0.1776p pd=1.195u as=80f ps=0.89u w=0.64u l=0.13u
X2706 VGND.t73 sg13cmos5l_inv_1_271.A sg13cmos5l_inv_1_270.A VGND.t748 sg13_lv_nmos ad=0.2516p pd=2.16u as=0.2516p ps=2.16u w=0.74u l=0.13u
X2707 sg13cmos5l_inv_1_159.A sg13cmos5l_inv_1_158.Y VPWR.t350 VPWR.t29 sg13_lv_pmos ad=0.3808p pd=2.92u as=0.3808p ps=2.92u w=1.12u l=0.13u
X2708 VGND.t6 VPWR.t1562 VGND.t6 VGND.t190 sg13_lv_nmos ad=0.1428p pd=1.52u as=0 ps=0 w=0.42u l=1u
X2709 VPWR.t97 VGND.t15 VPWR.t96 VPWR.t29 sg13_lv_pmos ad=0.34p pd=2.68u as=0 ps=0 w=1u l=1u
X2710 VPWR.t1377 sg13cmos5l_inv_1_568.A sg13cmos5l_inv_1_568.Y VPWR.t42 sg13_lv_pmos ad=0.3808p pd=2.92u as=0.3808p ps=2.92u w=1.12u l=0.13u
X2711 a_14360_11776# sg13cmos5l_nor3_1_2.B.t2 a_14865_11458# VGND.t777 sg13_lv_nmos ad=0.1776p pd=1.195u as=76.8f ps=0.88u w=0.64u l=0.13u
X2712 VGND.t184 sg13cmos5l_inv_1_701.A sg13cmos5l_mux4_1_15.A3 VGND.t1098 sg13_lv_nmos ad=0.2516p pd=2.16u as=0.2516p ps=2.16u w=0.74u l=0.13u
X2713 VGND.t197 sg13cmos5l_inv_1_775.A sg13cmos5l_inv_1_775.Y VGND.t22 sg13_lv_nmos ad=0.2516p pd=2.16u as=0.2516p ps=2.16u w=0.74u l=0.13u
X2714 a_3934_12606# a_3623_12606# a_3860_12606# VGND.t210 sg13_lv_nmos ad=0.1472p pd=1.1u as=76.8f ps=0.88u w=0.64u l=0.13u
X2715 VGND.t399 sg13cmos5l_inv_1_251.A sg13cmos5l_inv_1_453.A VGND.t398 sg13_lv_nmos ad=0.2516p pd=2.16u as=0.2516p ps=2.16u w=0.74u l=0.13u
X2716 VPWR.t849 sg13cmos5l_inv_1_807.Y sg13cmos5l_inv_1_890.A VPWR.t39 sg13_lv_pmos ad=0.3808p pd=2.92u as=0.3808p ps=2.92u w=1.12u l=0.13u
X2717 a_8845_6219# a_8327_6558# a_8638_6558# VPWR.t0 sg13_lv_pmos ad=0.16p pd=1.32u as=0.19p ps=1.38u w=1u l=0.13u
X2718 VPWR.t583 sg13cmos5l_inv_1_412.A sg13cmos5l_inv_1_411.A VPWR.t14 sg13_lv_pmos ad=0.3808p pd=2.92u as=0.3808p ps=2.92u w=1.12u l=0.13u
X2719 sg13cmos5l_inv_1_482.Y sg13cmos5l_inv_1_481.Y VPWR.t608 VPWR.t2 sg13_lv_pmos ad=0.3808p pd=2.92u as=0.3808p ps=2.92u w=1.12u l=0.13u
X2720 a_9454_11832# sg13cmos5l_or2_1_0.B a_9360_11832# VPWR.t2 sg13_lv_pmos ad=0.1596p pd=1.22u as=0.2856p ps=2.36u w=0.84u l=0.13u
X2721 sg13cmos5l_inv_1_472.Y sg13cmos5l_inv_1_471.Y VPWR.t1040 VPWR.t5 sg13_lv_pmos ad=0.3808p pd=2.92u as=0.3808p ps=2.92u w=1.12u l=0.13u
X2722 sg13cmos5l_inv_1_337.Y sg13cmos5l_inv_1_337.A VPWR.t954 VPWR.t8 sg13_lv_pmos ad=0.3808p pd=2.92u as=0.3808p ps=2.92u w=1.12u l=0.13u
X2723 sg13cmos5l_mux4_1_5.S1 a_4072_3932# VGND.t288 VGND.t1399 sg13_lv_nmos ad=0.2886p pd=2.26u as=0.14875p ps=1.16u w=0.74u l=0.13u
X2724 sg13cmos5l_inv_1_1000.Y sg13cmos5l_inv_1_942.Y VPWR.t1026 VPWR.t5 sg13_lv_pmos ad=0.3808p pd=2.92u as=0.3808p ps=2.92u w=1.12u l=0.13u
X2725 sg13cmos5l_inv_1_507.A sg13cmos5l_inv_1_521.Y VPWR.t920 VPWR.t2 sg13_lv_pmos ad=0.3808p pd=2.92u as=0.3808p ps=2.92u w=1.12u l=0.13u
X2726 VPWR.t1210 sg13cmos5l_inv_1_576.A sg13cmos5l_inv_1_575.A VPWR.t42 sg13_lv_pmos ad=0.3808p pd=2.92u as=0.3808p ps=2.92u w=1.12u l=0.13u
X2727 sg13cmos5l_buf_1_17.X a_18664_13004# VGND.t26 VGND.t223 sg13_lv_nmos ad=0.2886p pd=2.26u as=0.14875p ps=1.16u w=0.74u l=0.13u
X2728 sg13cmos5l_inv_1_774.Y sg13cmos5l_inv_1_773.Y VPWR.t1243 VPWR.t39 sg13_lv_pmos ad=0.3808p pd=2.92u as=0.3808p ps=2.92u w=1.12u l=0.13u
X2729 sg13cmos5l_inv_1_997.A sg13cmos5l_inv_1_944.Y VPWR.t1326 VPWR.t5 sg13_lv_pmos ad=0.3808p pd=2.92u as=0.3808p ps=2.92u w=1.12u l=0.13u
X2730 VPWR.t535 sg13cmos5l_inv_1_642.A sg13cmos5l_inv_1_642.Y VPWR.t21 sg13_lv_pmos ad=0.3808p pd=2.92u as=0.3808p ps=2.92u w=1.12u l=0.13u
X2731 VGND.t435 sg13cmos5l_mux2_1_4.S.t2 a_14989_3904# VGND.t774 sg13_lv_nmos ad=0.1543p pd=1.18u as=0.2304p ps=2u w=0.64u l=0.13u
X2732 sg13cmos5l_inv_1_389.A sg13cmos5l_inv_1_382.Y VGND.t107 VGND.t142 sg13_lv_nmos ad=0.2516p pd=2.16u as=0.2516p ps=2.16u w=0.74u l=0.13u
X2733 sg13cmos5l_inv_1_845.Y sg13cmos5l_inv_1_844.Y VGND.t171 VGND.t1332 sg13_lv_nmos ad=0.2516p pd=2.16u as=0.2516p ps=2.16u w=0.74u l=0.13u
X2734 sg13cmos5l_inv_1_694.Y sg13cmos5l_inv_1_694.A VPWR.t919 VPWR.t5 sg13_lv_pmos ad=0.3808p pd=2.92u as=0.3808p ps=2.92u w=1.12u l=0.13u
X2735 VPWR.t71 VGND.t73 VPWR.t70 VPWR.t49 sg13_lv_pmos ad=0.34p pd=2.68u as=0 ps=0 w=1u l=1u
X2736 sg13cmos5l_inv_1_462.A sg13cmos5l_inv_1_364.A VPWR.t918 VPWR.t14 sg13_lv_pmos ad=0.3808p pd=2.92u as=0.3808p ps=2.92u w=1.12u l=0.13u
X2737 sg13cmos5l_inv_1_368.Y sg13cmos5l_inv_1_363.Y VGND.t201 VGND.t357 sg13_lv_nmos ad=0.2516p pd=2.16u as=0.2516p ps=2.16u w=0.74u l=0.13u
X2738 sg13cmos5l_inv_1_904.A sg13cmos5l_inv_1_905.Y VPWR.t934 VPWR.t26 sg13_lv_pmos ad=0.3808p pd=2.92u as=0.3808p ps=2.92u w=1.12u l=0.13u
X2739 sg13cmos5l_inv_1_855.Y sg13cmos5l_inv_1_855.A VGND.t116 VGND.t22 sg13_lv_nmos ad=0.2516p pd=2.16u as=0.2516p ps=2.16u w=0.74u l=0.13u
X2740 VPWR.t438 sg13cmos5l_inv_1_862.A a_18664_16028# VPWR.t42 sg13_lv_pmos ad=0.2114p pd=1.54u as=0.2856p ps=2.36u w=0.84u l=0.13u
X2741 VGND.t614 sg13cmos5l_inv_1_373.A sg13cmos5l_inv_1_372.A VGND.t1073 sg13_lv_nmos ad=0.2516p pd=2.16u as=0.2516p ps=2.16u w=0.74u l=0.13u
X2742 sg13cmos5l_inv_1_734.A sg13cmos5l_inv_1_733.A VGND.t347 VGND.t1123 sg13_lv_nmos ad=0.2516p pd=2.16u as=0.2516p ps=2.16u w=0.74u l=0.13u
X2743 sg13cmos5l_inv_1_741.Y sg13cmos5l_inv_1_1003.Y VPWR.t593 VPWR.t26 sg13_lv_pmos ad=0.3808p pd=2.92u as=0.3808p ps=2.92u w=1.12u l=0.13u
X2744 VPWR.t53 VGND.t54 VPWR.t52 VPWR.t8 sg13_lv_pmos ad=0.34p pd=2.68u as=0 ps=0 w=1u l=1u
X2745 VGND.t43 sg13cmos5l_inv_1_276.A sg13cmos5l_inv_1_268.A VGND.t570 sg13_lv_nmos ad=0.2516p pd=2.16u as=0.2516p ps=2.16u w=0.74u l=0.13u
X2746 VPWR.t551 sg13cmos5l_inv_1_798.A sg13cmos5l_inv_1_798.Y VPWR.t42 sg13_lv_pmos ad=0.3808p pd=2.92u as=0.3808p ps=2.92u w=1.12u l=0.13u
X2747 VGND.t329 sg13cmos5l_inv_1_645.Y sg13cmos5l_inv_1_671.A VGND.t998 sg13_lv_nmos ad=0.2516p pd=2.16u as=0.2516p ps=2.16u w=0.74u l=0.13u
X2748 VGND.t5 VPWR.t1567 VGND.t5 VGND.t190 sg13_lv_nmos ad=0.1428p pd=1.52u as=0 ps=0 w=0.42u l=1u
X2749 VPWR.t916 sg13cmos5l_inv_1_419.A sg13cmos5l_inv_1_420.A VPWR.t49 sg13_lv_pmos ad=0.3808p pd=2.92u as=0.3808p ps=2.92u w=1.12u l=0.13u
X2750 sg13cmos5l_inv_1_147.A sg13cmos5l_inv_1_150.A VPWR.t391 VPWR.t0 sg13_lv_pmos ad=0.3808p pd=2.92u as=0.3808p ps=2.92u w=1.12u l=0.13u
X2751 sg13cmos5l_inv_1_407.Y sg13cmos5l_inv_1_407.A VPWR.t870 VPWR.t14 sg13_lv_pmos ad=0.3808p pd=2.92u as=0.3808p ps=2.92u w=1.12u l=0.13u
X2752 VGND.t194 VPWR.t1617 VGND.t194 VGND.t1487 sg13_lv_nmos ad=0.1428p pd=1.52u as=0 ps=0 w=0.42u l=1u
X2753 sg13cmos5l_inv_1_65.A sg13cmos5l_inv_1_1011.A VGND.t111 VGND.t110 sg13_lv_nmos ad=0.2516p pd=2.16u as=0.2516p ps=2.16u w=0.74u l=0.13u
X2754 sg13cmos5l_inv_1_967.Y sg13cmos5l_inv_1_966.Y VPWR.t347 VPWR.t29 sg13_lv_pmos ad=0.3808p pd=2.92u as=0.3808p ps=2.92u w=1.12u l=0.13u
X2755 sg13cmos5l_inv_1_605.Y sg13cmos5l_inv_1_588.Y VPWR.t466 VPWR.t39 sg13_lv_pmos ad=0.3808p pd=2.92u as=0.3808p ps=2.92u w=1.12u l=0.13u
X2756 VPWR.t481 sg13cmos5l_inv_1_684.A sg13cmos5l_inv_1_684.Y VPWR.t21 sg13_lv_pmos ad=0.3808p pd=2.92u as=0.3808p ps=2.92u w=1.12u l=0.13u
X2757 VPWR.t485 sg13cmos5l_inv_1_888.Y sg13cmos5l_inv_1_873.A VPWR.t21 sg13_lv_pmos ad=0.3808p pd=2.92u as=0.3808p ps=2.92u w=1.12u l=0.13u
X2758 VGND.t73 sg13cmos5l_mux2_1_4.S a_9820_3514# VGND.t1214 sg13_lv_nmos ad=0.18945p pd=1.27u as=0.13135p ps=1.095u w=0.74u l=0.13u
X2759 sg13cmos5l_inv_1_278.Y sg13cmos5l_inv_1_280.Y VPWR.t566 VPWR.t8 sg13_lv_pmos ad=0.3808p pd=2.92u as=0.3808p ps=2.92u w=1.12u l=0.13u
X2760 VGND.t116 sg13cmos5l_inv_1_848.Y sg13cmos5l_inv_1_836.A VGND.t22 sg13_lv_nmos ad=0.2516p pd=2.16u as=0.2516p ps=2.16u w=0.74u l=0.13u
X2761 VGND.t56 sg13cmos5l_inv_1_617.A sg13cmos5l_inv_1_618.A VGND.t22 sg13_lv_nmos ad=0.2516p pd=2.16u as=0.2516p ps=2.16u w=0.74u l=0.13u
X2762 sg13cmos5l_inv_1_12.Y sg13cmos5l_inv_1_17.Y VGND.t596 VGND.t668 sg13_lv_nmos ad=0.2516p pd=2.16u as=0.2516p ps=2.16u w=0.74u l=0.13u
X2763 VPWR.t662 invsel[0] a_808_1632# VPWR.t11 sg13_lv_pmos ad=0.2114p pd=1.54u as=0.2856p ps=2.36u w=0.84u l=0.13u
X2764 VPWR.t902 VGND.t225 VPWR.t900 VPWR.t0 sg13_lv_pmos ad=0.19p pd=1.38u as=0 ps=0 w=1u l=1u
X2765 VPWR.t141 VGND.t39 VPWR.t140 VPWR.t5 sg13_lv_pmos ad=0.34p pd=2.68u as=0 ps=0 w=1u l=1u
X2766 VPWR.t302 sg13cmos5l_mux4_1_5.S1.t4 a_13607_3898# VPWR.t49 sg13_lv_pmos ad=0.22315p pd=1.555u as=0.34p ps=2.68u w=1u l=0.13u
X2767 VGND.t1 sg13cmos5l_inv_1_147.A sg13cmos5l_inv_1_147.Y VGND.t17 sg13_lv_nmos ad=0.2516p pd=2.16u as=0.2516p ps=2.16u w=0.74u l=0.13u
X2768 VPWR.t645 sg13cmos5l_inv_1_680.A sg13cmos5l_inv_1_680.Y VPWR.t21 sg13_lv_pmos ad=0.3808p pd=2.92u as=0.3808p ps=2.92u w=1.12u l=0.13u
X2769 VPWR.t748 sg13cmos5l_inv_1_950.A sg13cmos5l_inv_1_950.Y VPWR.t5 sg13_lv_pmos ad=0.3808p pd=2.92u as=0.3808p ps=2.92u w=1.12u l=0.13u
X2770 VGND.t699 invsel[1] a_808_4656# VGND.t11 sg13_lv_nmos ad=0.14875p pd=1.16u as=0.187p ps=1.78u w=0.55u l=0.13u
X2771 VGND.t12 sg13cmos5l_inv_1_431.A sg13cmos5l_inv_1_349.A VGND.t11 sg13_lv_nmos ad=0.2516p pd=2.16u as=0.2516p ps=2.16u w=0.74u l=0.13u
X2772 VPWR.t178 VGND.t342 VPWR.t177 VPWR.t29 sg13_lv_pmos ad=0.34p pd=2.68u as=0 ps=0 w=1u l=1u
X2773 sg13cmos5l_inv_1_914.A sg13cmos5l_inv_1_707.Y VGND.t92 VGND.t179 sg13_lv_nmos ad=0.2516p pd=2.16u as=0.2516p ps=2.16u w=0.74u l=0.13u
X2774 a_4438_3534# sg13cmos5l_mux4_1_5.S0.t2 a_4357_3195# VPWR.t8 sg13_lv_pmos ad=0.4425p pd=1.885u as=0.20762p ps=1.605u w=1u l=0.13u
X2775 VGND.t100 sg13cmos5l_inv_1_568.A sg13cmos5l_inv_1_568.Y VGND.t22 sg13_lv_nmos ad=0.2516p pd=2.16u as=0.2516p ps=2.16u w=0.74u l=0.13u
X2776 sg13cmos5l_inv_1_580.A sg13cmos5l_inv_1_618.Y VPWR.t455 VPWR.t42 sg13_lv_pmos ad=0.3808p pd=2.92u as=0.3808p ps=2.92u w=1.12u l=0.13u
X2777 VPWR.t985 sg13cmos5l_inv_1_372.A sg13cmos5l_inv_1_372.Y VPWR.t14 sg13_lv_pmos ad=0.3808p pd=2.92u as=0.3808p ps=2.92u w=1.12u l=0.13u
X2778 a_16324_8070# a_16075_7649# a_15608_7680# VGND.t718 sg13_lv_nmos ad=80f pd=0.89u as=0.1776p ps=1.195u w=0.64u l=0.13u
X2779 sg13cmos5l_o21ai_1_0.B1 a_1006_15296# VGND.t94 VGND.t804 sg13_lv_nmos ad=0.1406p pd=1.12u as=0.17255p ps=1.25u w=0.74u l=0.13u
X2780 VPWR.t634 sg13cmos5l_inv_1_744.Y sg13cmos5l_mux4_1_7.A2 VPWR.t26 sg13_lv_pmos ad=0.3808p pd=2.92u as=0.3808p ps=2.92u w=1.12u l=0.13u
X2781 VPWR.t316 sg13cmos5l_inv_1_761.A sg13cmos5l_inv_1_738.A VPWR.t2 sg13_lv_pmos ad=0.3808p pd=2.92u as=0.3808p ps=2.92u w=1.12u l=0.13u
X2782 sg13cmos5l_inv_1_625.Y sg13cmos5l_inv_1_619.Y VGND.t1204 VGND.t1210 sg13_lv_nmos ad=0.2516p pd=2.16u as=0.2516p ps=2.16u w=0.74u l=0.13u
X2783 VGND.t66 VPWR.t1596 VGND.t66 VGND.t1518 sg13_lv_nmos ad=0.1428p pd=1.52u as=0 ps=0 w=0.42u l=1u
X2784 VPWR.t804 sg13cmos5l_inv_1_880.A sg13cmos5l_inv_1_879.A VPWR.t21 sg13_lv_pmos ad=0.3808p pd=2.92u as=0.3808p ps=2.92u w=1.12u l=0.13u
X2785 sg13cmos5l_inv_1_65.Y sg13cmos5l_inv_1_65.A VPWR.t531 VPWR.t11 sg13_lv_pmos ad=0.3808p pd=2.92u as=0.3808p ps=2.92u w=1.12u l=0.13u
X2786 VPWR.t693 sg13cmos5l_inv_1_945.A sg13cmos5l_inv_1_945.Y VPWR.t11 sg13_lv_pmos ad=0.3808p pd=2.92u as=0.3808p ps=2.92u w=1.12u l=0.13u
X2787 a_7157_8747# a_6119_8434# a_6934_8434# VPWR.t29 sg13_lv_pmos ad=0.135p pd=1.27u as=0.4425p ps=1.885u w=1u l=0.13u
X2788 sg13cmos5l_inv_1_483.Y sg13cmos5l_inv_1_677.Y VPWR.t379 VPWR.t2 sg13_lv_pmos ad=0.3808p pd=2.92u as=0.3808p ps=2.92u w=1.12u l=0.13u
X2789 VGND.t396 sg13cmos5l_inv_1_99.Y sg13cmos5l_inv_1_77.Y VGND.t395 sg13_lv_nmos ad=0.2516p pd=2.16u as=0.2516p ps=2.16u w=0.74u l=0.13u
X2790 sg13cmos5l_inv_1_517.A sg13cmos5l_inv_1_507.Y VGND.t145 VGND.t383 sg13_lv_nmos ad=0.2516p pd=2.16u as=0.2516p ps=2.16u w=0.74u l=0.13u
X2791 osc_tap[2] a_18856_7680# VGND.t360 VGND.t481 sg13_lv_nmos ad=0.2886p pd=2.26u as=0.14875p ps=1.16u w=0.74u l=0.13u
X2792 VPWR.t896 sg13cmos5l_inv_1_926.Y sg13cmos5l_inv_1_499.Y VPWR.t5 sg13_lv_pmos ad=0.3808p pd=2.92u as=0.3808p ps=2.92u w=1.12u l=0.13u
X2793 VPWR.t411 sg13cmos5l_inv_1_257.A sg13cmos5l_inv_1_256.A VPWR.t11 sg13_lv_pmos ad=0.3808p pd=2.92u as=0.3808p ps=2.92u w=1.12u l=0.13u
X2794 VPWR.t390 a_18764_5370# sg13cmos5l_buf_1_6.A VPWR.t0 sg13_lv_pmos ad=0.2114p pd=1.54u as=0.42p ps=2.99u w=1.12u l=0.13u
X2795 VPWR.t965 sg13cmos5l_buf_1_8.A.t4 a_3623_12606# VPWR.t2 sg13_lv_pmos ad=0.22315p pd=1.555u as=0.34p ps=2.68u w=1u l=0.13u
X2796 sg13cmos5l_nor3_1_2.B a_808_13004# VGND.t160 VGND.t159 sg13_lv_nmos ad=0.2886p pd=2.26u as=0.14875p ps=1.16u w=0.74u l=0.13u
X2797 VPWR.t1324 sg13cmos5l_inv_1_447.A sg13cmos5l_inv_1_446.A VPWR.t49 sg13_lv_pmos ad=0.3808p pd=2.92u as=0.3808p ps=2.92u w=1.12u l=0.13u
X2798 VPWR.t683 sg13cmos5l_inv_1_588.A sg13cmos5l_inv_1_588.Y VPWR.t39 sg13_lv_pmos ad=0.3808p pd=2.92u as=0.3808p ps=2.92u w=1.12u l=0.13u
X2799 VPWR.t1130 sg13cmos5l_inv_1_701.A sg13cmos5l_mux4_1_15.A3 VPWR.t5 sg13_lv_pmos ad=0.3808p pd=2.92u as=0.3808p ps=2.92u w=1.12u l=0.13u
X2800 VPWR.t422 sg13cmos5l_inv_1_42.A sg13cmos5l_inv_1_31.A VPWR.t8 sg13_lv_pmos ad=0.3808p pd=2.92u as=0.3808p ps=2.92u w=1.12u l=0.13u
X2801 VPWR.t318 sg13cmos5l_inv_1_1011.A a_7789_3195# VPWR.t8 sg13_lv_pmos ad=0.29275p pd=1.785u as=0.16p ps=1.32u w=1u l=0.13u
X2802 VGND.t225 sg13cmos5l_inv_1_234.A sg13cmos5l_inv_1_233.A VGND.t11 sg13_lv_nmos ad=0.2516p pd=2.16u as=0.2516p ps=2.16u w=0.74u l=0.13u
X2803 sg13cmos5l_inv_1_714.A sg13cmos5l_inv_1_726.A VGND.t155 VGND.t281 sg13_lv_nmos ad=0.2516p pd=2.16u as=0.2516p ps=2.16u w=0.74u l=0.13u
X2804 VGND.t233 sg13cmos5l_inv_1_224.A sg13cmos5l_inv_1_224.Y VGND.t11 sg13_lv_nmos ad=0.2516p pd=2.16u as=0.2516p ps=2.16u w=0.74u l=0.13u
X2805 VGND.t126 sg13cmos5l_inv_1_758.A sg13cmos5l_inv_1_739.A VGND.t125 sg13_lv_nmos ad=0.2516p pd=2.16u as=0.2516p ps=2.16u w=0.74u l=0.13u
X2806 sg13cmos5l_inv_1_285.Y sg13cmos5l_inv_1_287.Y VGND.t617 VGND.t786 sg13_lv_nmos ad=0.2516p pd=2.16u as=0.2516p ps=2.16u w=0.74u l=0.13u
X2807 VGND.t240 sg13cmos5l_inv_1_273.A sg13cmos5l_inv_1_273.Y VGND.t629 sg13_lv_nmos ad=0.2516p pd=2.16u as=0.2516p ps=2.16u w=0.74u l=0.13u
X2808 sg13cmos5l_inv_1_184.A sg13cmos5l_inv_1_225.Y VGND.t16 VGND.t11 sg13_lv_nmos ad=0.2516p pd=2.16u as=0.2516p ps=2.16u w=0.74u l=0.13u
X2809 VPWR.t433 sg13cmos5l_inv_1_935.A sg13cmos5l_inv_1_936.A VPWR.t5 sg13_lv_pmos ad=0.3808p pd=2.92u as=0.3808p ps=2.92u w=1.12u l=0.13u
X2810 VPWR.t706 sg13cmos5l_inv_1_58.A sg13cmos5l_inv_1_58.Y VPWR.t11 sg13_lv_pmos ad=0.3808p pd=2.92u as=0.3808p ps=2.92u w=1.12u l=0.13u
X2811 VGND.t117 sg13cmos5l_inv_1_416.A sg13cmos5l_inv_1_416.Y VGND.t11 sg13_lv_nmos ad=0.2516p pd=2.16u as=0.2516p ps=2.16u w=0.74u l=0.13u
X2812 sg13cmos5l_inv_1_875.A sg13cmos5l_inv_1_813.Y VGND.t35 VGND.t794 sg13_lv_nmos ad=0.2516p pd=2.16u as=0.2516p ps=2.16u w=0.74u l=0.13u
X2813 osc_tap[1] a_18280_5444# VPWR.t533 VPWR.t0 sg13_lv_pmos ad=0.42p pd=2.99u as=0.2114p ps=1.54u w=1.12u l=0.13u
X2814 VPWR.t1140 sg13cmos5l_inv_1_110.A sg13cmos5l_mux4_1_16.A2 VPWR.t0 sg13_lv_pmos ad=0.3808p pd=2.92u as=0.3808p ps=2.92u w=1.12u l=0.13u
X2815 VPWR.t1145 sg13cmos5l_inv_1_100.A a_14317_3195# VPWR.t8 sg13_lv_pmos ad=0.29275p pd=1.785u as=0.16p ps=1.32u w=1u l=0.13u
X2816 sg13cmos5l_inv_1_287.Y sg13cmos5l_inv_1_287.A VPWR.t715 VPWR.t8 sg13_lv_pmos ad=0.3808p pd=2.92u as=0.3808p ps=2.92u w=1.12u l=0.13u
X2817 VGND.t8 sg13cmos5l_inv_1_935.A sg13cmos5l_inv_1_936.A VGND.t273 sg13_lv_nmos ad=0.2516p pd=2.16u as=0.2516p ps=2.16u w=0.74u l=0.13u
X2818 VPWR.t307 invsel[5] a_808_16028# VPWR.t42 sg13_lv_pmos ad=0.2114p pd=1.54u as=0.2856p ps=2.36u w=0.84u l=0.13u
X2819 sg13cmos5l_inv_1_382.A sg13cmos5l_inv_1_454.Y VPWR.t779 VPWR.t0 sg13_lv_pmos ad=0.3808p pd=2.92u as=0.3808p ps=2.92u w=1.12u l=0.13u
X2820 sg13cmos5l_mux4_1_4.X a_7425_8476# VPWR.t300 VPWR.t29 sg13_lv_pmos ad=0.3808p pd=2.92u as=0.34367p ps=1.775u w=1.12u l=0.13u
X2821 sg13cmos5l_inv_1_948.A sg13cmos5l_inv_1_949.Y VPWR.t375 VPWR.t21 sg13_lv_pmos ad=0.3808p pd=2.92u as=0.3808p ps=2.92u w=1.12u l=0.13u
X2822 VPWR.t1454 sg13cmos5l_inv_1_325.A sg13cmos5l_inv_1_325.Y VPWR.t8 sg13_lv_pmos ad=0.3808p pd=2.92u as=0.3808p ps=2.92u w=1.12u l=0.13u
X2823 sg13cmos5l_inv_1_595.Y sg13cmos5l_inv_1_596.Y VPWR.t1452 VPWR.t39 sg13_lv_pmos ad=0.3808p pd=2.92u as=0.3808p ps=2.92u w=1.12u l=0.13u
X2824 sg13cmos5l_inv_1_901.Y sg13cmos5l_inv_1_734.Y VGND.t444 VGND.t443 sg13_lv_nmos ad=0.2516p pd=2.16u as=0.2516p ps=2.16u w=0.74u l=0.13u
X2825 VGND.t54 sg13cmos5l_inv_1_321.A sg13cmos5l_inv_1_320.A VGND.t654 sg13_lv_nmos ad=0.2516p pd=2.16u as=0.2516p ps=2.16u w=0.74u l=0.13u
X2826 a_4575_3534# sg13cmos5l_mux4_1_5.S0.t2 a_4438_3534# VGND.t1254 sg13_lv_nmos ad=76.8f pd=0.88u as=0.1776p ps=1.195u w=0.64u l=0.13u
X2827 VGND.t162 sg13cmos5l_inv_1_467.Y a_6548_8434# VGND.t404 sg13_lv_nmos ad=0.1824p pd=1.21u as=0.2304p ps=1.36u w=0.64u l=0.13u
X2828 VPWR.t705 sg13cmos5l_inv_1_874.A sg13cmos5l_inv_1_874.Y VPWR.t42 sg13_lv_pmos ad=0.3808p pd=2.92u as=0.3808p ps=2.92u w=1.12u l=0.13u
X2829 VPWR.t786 sg13cmos5l_inv_1_391.A sg13cmos5l_inv_1_391.Y VPWR.t14 sg13_lv_pmos ad=0.3808p pd=2.92u as=0.3808p ps=2.92u w=1.12u l=0.13u
X2830 VGND.t153 VPWR.t1566 VGND.t153 VGND.t190 sg13_lv_nmos ad=0.1428p pd=1.52u as=0 ps=0 w=0.42u l=1u
X2831 sg13cmos5l_inv_1_400.Y sg13cmos5l_inv_1_399.Y VPWR.t979 VPWR.t14 sg13_lv_pmos ad=0.3808p pd=2.92u as=0.3808p ps=2.92u w=1.12u l=0.13u
X2832 VGND.t342 sg13cmos5l_inv_1_356.Y sg13cmos5l_inv_1_366.A VGND.t341 sg13_lv_nmos ad=0.2516p pd=2.16u as=0.2516p ps=2.16u w=0.74u l=0.13u
X2833 VPWR.t760 sg13cmos5l_buf_1_9.A.t7 a_5005_16000# VPWR.t42 sg13_lv_pmos ad=0.34367p pd=1.775u as=0.34p ps=2.68u w=1u l=0.13u
X2834 sg13cmos5l_inv_1_398.Y sg13cmos5l_mux4_1_16.A1 VGND.t354 VGND.t1037 sg13_lv_nmos ad=0.2516p pd=2.16u as=0.2516p ps=2.16u w=0.74u l=0.13u
X2835 a_14125_12267# a_13607_12606# a_13918_12606# VPWR.t2 sg13_lv_pmos ad=0.16p pd=1.32u as=0.19p ps=1.38u w=1u l=0.13u
X2836 VPWR.t279 sg13cmos5l_inv_1_264.A sg13cmos5l_inv_1_265.A VPWR.t49 sg13_lv_pmos ad=0.3808p pd=2.92u as=0.3808p ps=2.92u w=1.12u l=0.13u
X2837 sg13cmos5l_inv_1_407.Y sg13cmos5l_inv_1_407.A VGND.t76 VGND.t810 sg13_lv_nmos ad=0.2516p pd=2.16u as=0.2516p ps=2.16u w=0.74u l=0.13u
X2838 sg13cmos5l_inv_1_60.Y sg13cmos5l_inv_1_57.Y VPWR.t273 VPWR.t11 sg13_lv_pmos ad=0.3808p pd=2.92u as=0.3808p ps=2.92u w=1.12u l=0.13u
X2839 sg13cmos5l_inv_1_467.Y sg13cmos5l_inv_1_467.A VPWR.t369 VPWR.t29 sg13_lv_pmos ad=0.3808p pd=2.92u as=0.3808p ps=2.92u w=1.12u l=0.13u
X2840 VGND.t529 sg13cmos5l_inv_1_665.A sg13cmos5l_inv_1_522.A VGND.t782 sg13_lv_nmos ad=0.2516p pd=2.16u as=0.2516p ps=2.16u w=0.74u l=0.13u
X2841 sg13cmos5l_inv_1_55.Y sg13cmos5l_inv_1_46.Y VGND.t21 VGND.t576 sg13_lv_nmos ad=0.2516p pd=2.16u as=0.2516p ps=2.16u w=0.74u l=0.13u
X2842 sg13cmos5l_inv_1_811.Y sg13cmos5l_inv_1_798.Y VPWR.t435 VPWR.t42 sg13_lv_pmos ad=0.3808p pd=2.92u as=0.3808p ps=2.92u w=1.12u l=0.13u
X2843 VPWR.t232 VGND.t612 VPWR.t231 VPWR.t5 sg13_lv_pmos ad=0.34p pd=2.68u as=0 ps=0 w=1u l=1u
X2844 VPWR.t1095 sg13cmos5l_inv_1_267.Y sg13cmos5l_inv_1_283.A VPWR.t0 sg13_lv_pmos ad=0.3808p pd=2.92u as=0.3808p ps=2.92u w=1.12u l=0.13u
X2845 sg13cmos5l_inv_1_556.Y sg13cmos5l_inv_1_550.Y VPWR.t668 VPWR.t39 sg13_lv_pmos ad=0.3808p pd=2.92u as=0.3808p ps=2.92u w=1.12u l=0.13u
X2846 sg13cmos5l_inv_1_734.A sg13cmos5l_inv_1_733.A VPWR.t1151 VPWR.t5 sg13_lv_pmos ad=0.3808p pd=2.92u as=0.3808p ps=2.92u w=1.12u l=0.13u
X2847 sg13cmos5l_inv_1_73.A sg13cmos5l_inv_1_67.Y VGND.t33 VGND.t1269 sg13_lv_nmos ad=0.2516p pd=2.16u as=0.2516p ps=2.16u w=0.74u l=0.13u
X2848 a_13844_3898# sg13cmos5l_inv_1_85.A VGND.t78 VGND.t1265 sg13_lv_nmos ad=76.8f pd=0.88u as=0.1872p ps=1.225u w=0.64u l=0.13u
X2849 VGND.t1156 sg13cmos5l_inv_1_436.A sg13cmos5l_inv_1_451.A VGND.t11 sg13_lv_nmos ad=0.2516p pd=2.16u as=0.2516p ps=2.16u w=0.74u l=0.13u
X2850 VGND.t5 sg13cmos5l_inv_1_950.A sg13cmos5l_inv_1_950.Y VGND.t190 sg13_lv_nmos ad=0.2516p pd=2.16u as=0.2516p ps=2.16u w=0.74u l=0.13u
X2851 sg13cmos5l_inv_1_111.Y sg13cmos5l_inv_1_111.A VGND.t947 VGND.t1154 sg13_lv_nmos ad=0.2516p pd=2.16u as=0.2516p ps=2.16u w=0.74u l=0.13u
X2852 VPWR.t810 sg13cmos5l_inv_1_852.Y sg13cmos5l_inv_1_851.A VPWR.t39 sg13_lv_pmos ad=0.3808p pd=2.92u as=0.3808p ps=2.92u w=1.12u l=0.13u
X2853 VPWR.t87 VGND.t33 VPWR.t86 VPWR.t11 sg13_lv_pmos ad=0.34p pd=2.68u as=0 ps=0 w=1u l=1u
X2854 VGND.t73 sg13cmos5l_mux4_1_5.S1.t2 a_8653_3418# VGND.t72 sg13_lv_nmos ad=0.1543p pd=1.18u as=0.2304p ps=2u w=0.64u l=0.13u
X2855 VPWR.t1004 sg13cmos5l_inv_1_182.A sg13cmos5l_inv_1_179.A VPWR.t14 sg13_lv_pmos ad=0.3808p pd=2.92u as=0.3808p ps=2.92u w=1.12u l=0.13u
X2856 a_14389_11500# sg13cmos5l_nor3_1_2.B.t2 a_15292_11458# VGND.t778 sg13_lv_nmos ad=0.1472p pd=1.1u as=0.2304p ps=1.36u w=0.64u l=0.13u
X2857 VGND.t147 sg13cmos5l_inv_1_1009.Y sg13cmos5l_inv_1_502.Y VGND.t958 sg13_lv_nmos ad=0.2516p pd=2.16u as=0.2516p ps=2.16u w=0.74u l=0.13u
X2858 sg13cmos5l_inv_1_580.A sg13cmos5l_inv_1_618.Y VGND.t56 VGND.t22 sg13_lv_nmos ad=0.2516p pd=2.16u as=0.2516p ps=2.16u w=0.74u l=0.13u
X2859 VPWR.t1048 sg13cmos5l_inv_1_645.Y sg13cmos5l_inv_1_671.A VPWR.t26 sg13_lv_pmos ad=0.3808p pd=2.92u as=0.3808p ps=2.92u w=1.12u l=0.13u
X2860 sg13cmos5l_inv_1_463.Y sg13cmos5l_inv_1_461.Y VPWR.t946 VPWR.t0 sg13_lv_pmos ad=0.3808p pd=2.92u as=0.3808p ps=2.92u w=1.12u l=0.13u
X2861 VPWR.t807 sg13cmos5l_inv_1_270.A sg13cmos5l_inv_1_270.Y VPWR.t49 sg13_lv_pmos ad=0.3808p pd=2.92u as=0.3808p ps=2.92u w=1.12u l=0.13u
X2862 VPWR.t871 sg13cmos5l_inv_1_793.A sg13cmos5l_inv_1_794.A VPWR.t42 sg13_lv_pmos ad=0.3808p pd=2.92u as=0.3808p ps=2.92u w=1.12u l=0.13u
X2863 VGND.t435 sg13cmos5l_mux2_1_4.S.t1 a_15181_3418# VGND.t772 sg13_lv_nmos ad=0.1543p pd=1.18u as=0.2304p ps=2u w=0.64u l=0.13u
X2864 sg13cmos5l_inv_1_7.A sg13cmos5l_inv_1_5.Y VPWR.t613 VPWR.t11 sg13_lv_pmos ad=0.3808p pd=2.92u as=0.3808p ps=2.92u w=1.12u l=0.13u
X2865 a_4556_3858# sg13cmos5l_buf_1_10.A VGND.t19 VGND.t1107 sg13_lv_nmos ad=0.187p pd=1.78u as=0.14875p ps=1.16u w=0.55u l=0.13u
X2866 sg13cmos5l_inv_1_384.Y sg13cmos5l_inv_1_394.Y VPWR.t401 VPWR.t29 sg13_lv_pmos ad=0.3808p pd=2.92u as=0.3808p ps=2.92u w=1.12u l=0.13u
X2867 VGND.t69 sg13cmos5l_inv_1_838.Y sg13cmos5l_inv_1_830.A VGND.t1327 sg13_lv_nmos ad=0.2516p pd=2.16u as=0.2516p ps=2.16u w=0.74u l=0.13u
X2868 VPWR.t774 sg13cmos5l_inv_1_427.Y sg13cmos5l_inv_1_438.A VPWR.t0 sg13_lv_pmos ad=0.3808p pd=2.92u as=0.3808p ps=2.92u w=1.12u l=0.13u
X2869 sg13cmos5l_inv_1_625.Y sg13cmos5l_inv_1_619.Y VPWR.t1233 VPWR.t21 sg13_lv_pmos ad=0.3808p pd=2.92u as=0.3808p ps=2.92u w=1.12u l=0.13u
X2870 sg13cmos5l_inv_1_662.Y sg13cmos5l_inv_1_499.Y VGND.t147 VGND.t460 sg13_lv_nmos ad=0.2516p pd=2.16u as=0.2516p ps=2.16u w=0.74u l=0.13u
X2871 sg13cmos5l_inv_1_65.Y sg13cmos5l_inv_1_65.A VGND.t373 VGND.t390 sg13_lv_nmos ad=0.2516p pd=2.16u as=0.2516p ps=2.16u w=0.74u l=0.13u
X2872 VGND.t396 sg13cmos5l_inv_1_76.A sg13cmos5l_inv_1_75.A VGND.t785 sg13_lv_nmos ad=0.2516p pd=2.16u as=0.2516p ps=2.16u w=0.74u l=0.13u
X2873 sg13cmos5l_inv_1_252.A sg13cmos5l_inv_1_254.Y VPWR.t414 VPWR.t11 sg13_lv_pmos ad=0.3808p pd=2.92u as=0.3808p ps=2.92u w=1.12u l=0.13u
X2874 VGND.t225 VPWR.t1532 VGND.t225 VGND.t11 sg13_lv_nmos ad=79.8f pd=0.8u as=0 ps=0 w=0.42u l=1u
X2875 osc_tap[4] a_18280_12216# VPWR.t821 VPWR.t2 sg13_lv_pmos ad=0.42p pd=2.99u as=0.2114p ps=1.54u w=1.12u l=0.13u
X2876 VPWR.t411 sg13cmos5l_inv_1_260.A sg13cmos5l_inv_1_260.Y VPWR.t11 sg13_lv_pmos ad=0.3808p pd=2.92u as=0.3808p ps=2.92u w=1.12u l=0.13u
X2877 sg13cmos5l_inv_1_341.Y sg13cmos5l_inv_1_367.Y VPWR.t882 VPWR.t0 sg13_lv_pmos ad=0.3808p pd=2.92u as=0.3808p ps=2.92u w=1.12u l=0.13u
X2878 VGND.t501 sg13cmos5l_inv_1_257.A sg13cmos5l_inv_1_256.A VGND.t739 sg13_lv_nmos ad=0.2516p pd=2.16u as=0.2516p ps=2.16u w=0.74u l=0.13u
X2879 a_14922_9582# sg13cmos5l_mux4_1_15.A2 VGND.t8 VGND.t1244 sg13_lv_nmos ad=80f pd=0.89u as=0.1824p ps=1.21u w=0.64u l=0.13u
X2880 sg13cmos5l_inv_1_994.Y sg13cmos5l_inv_1_994.A VPWR.t1097 VPWR.t5 sg13_lv_pmos ad=0.3808p pd=2.92u as=0.3808p ps=2.92u w=1.12u l=0.13u
X2881 VPWR.t696 sg13cmos5l_inv_1_689.A sg13cmos5l_inv_1_689.Y VPWR.t21 sg13_lv_pmos ad=0.3808p pd=2.92u as=0.3808p ps=2.92u w=1.12u l=0.13u
X2882 sg13cmos5l_inv_1_744.Y sg13cmos5l_inv_1_743.Y VPWR.t597 VPWR.t26 sg13_lv_pmos ad=0.3808p pd=2.92u as=0.3808p ps=2.92u w=1.12u l=0.13u
X2883 sg13cmos5l_inv_1_312.Y sg13cmos5l_inv_1_313.Y VPWR.t139 VPWR.t11 sg13_lv_pmos ad=0.3808p pd=2.92u as=0.3808p ps=2.92u w=1.12u l=0.13u
X2884 VGND.t194 sg13cmos5l_inv_1_828.Y sg13cmos5l_mux4_1_8.A0 VGND.t842 sg13_lv_nmos ad=0.2516p pd=2.16u as=0.2516p ps=2.16u w=0.74u l=0.13u
X2885 sg13cmos5l_inv_1_914.A sg13cmos5l_inv_1_707.Y VPWR.t366 VPWR.t26 sg13_lv_pmos ad=0.3808p pd=2.92u as=0.3808p ps=2.92u w=1.12u l=0.13u
X2886 VPWR.t642 a_15662_4084# sg13cmos5l_mux2_1_0.X VPWR.t49 sg13_lv_pmos ad=0.2198p pd=1.52u as=0.6048p ps=3.32u w=1.12u l=0.13u
X2887 sg13cmos5l_mux4_1_2.X a_14913_3940# VGND.t435 VGND.t721 sg13_lv_nmos ad=0.2516p pd=2.16u as=0.1543p ps=1.18u w=0.74u l=0.13u
X2888 VPWR.t1229 sg13cmos5l_inv_1_680.Y sg13cmos5l_inv_1_563.A VPWR.t42 sg13_lv_pmos ad=0.3808p pd=2.92u as=0.3808p ps=2.92u w=1.12u l=0.13u
X2889 VPWR.t500 sg13cmos5l_mux4_1_16.A1 a_8845_6219# VPWR.t0 sg13_lv_pmos ad=0.29275p pd=1.785u as=0.16p ps=1.32u w=1u l=0.13u
X2890 sg13cmos5l_inv_1_344.Y sg13cmos5l_inv_1_344.A VGND.t201 VGND.t200 sg13_lv_nmos ad=0.2516p pd=2.16u as=0.2516p ps=2.16u w=0.74u l=0.13u
X2891 VPWR.t1386 sg13cmos5l_mux2_1_4.S.t5 a_15277_15514# VPWR.t21 sg13_lv_pmos ad=0.34367p pd=1.775u as=0.34p ps=2.68u w=1u l=0.13u
X2892 VPWR.t618 sg13cmos5l_inv_1_802.A sg13cmos5l_inv_1_798.A VPWR.t42 sg13_lv_pmos ad=0.3808p pd=2.92u as=0.3808p ps=2.92u w=1.12u l=0.13u
X2893 a_9326_3410# sg13cmos5l_mux4_1_5.X a_9498_3514# VGND.t217 sg13_lv_nmos ad=0.1628p pd=1.18u as=0.3367p ps=1.65u w=0.74u l=0.13u
X2894 sg13cmos5l_inv_1_875.A sg13cmos5l_inv_1_813.Y VPWR.t855 VPWR.t21 sg13_lv_pmos ad=0.3808p pd=2.92u as=0.3808p ps=2.92u w=1.12u l=0.13u
X2895 VGND.t342 sg13cmos5l_inv_1_346.Y a_4052_8070# VGND.t1029 sg13_lv_nmos ad=0.1824p pd=1.21u as=0.2304p ps=1.36u w=0.64u l=0.13u
X2896 sg13cmos5l_inv_1_589.A sg13cmos5l_inv_1_594.Y VPWR.t684 VPWR.t39 sg13_lv_pmos ad=0.3808p pd=2.92u as=0.3808p ps=2.92u w=1.12u l=0.13u
X2897 VPWR.t826 sg13cmos5l_nand2_1_1.B a_9454_11832# VPWR.t2 sg13_lv_pmos ad=0.2226p pd=1.535u as=0.1596p ps=1.22u w=0.84u l=0.13u
X2898 sg13cmos5l_inv_1_517.A sg13cmos5l_inv_1_507.Y VPWR.t524 VPWR.t5 sg13_lv_pmos ad=0.3808p pd=2.92u as=0.3808p ps=2.92u w=1.12u l=0.13u
X2899 VGND.t54 sg13cmos5l_inv_1_323.A sg13cmos5l_inv_1_327.A VGND.t1459 sg13_lv_nmos ad=0.2516p pd=2.16u as=0.2516p ps=2.16u w=0.74u l=0.13u
X2900 VGND.t233 VPWR.t1530 VGND.t212 VGND.t11 sg13_lv_nmos ad=0.1428p pd=1.52u as=0 ps=0 w=0.42u l=1u
X2901 a_14206_15630# a_13895_15630# a_14132_15630# VGND.t729 sg13_lv_nmos ad=0.1472p pd=1.1u as=76.8f ps=0.88u w=0.64u l=0.13u
X2902 sg13cmos5l_mux4_1_5.S0 a_2248_3932# VGND.t54 VGND.t169 sg13_lv_nmos ad=0.2886p pd=2.26u as=0.14875p ps=1.16u w=0.74u l=0.13u
X2903 VPWR.t925 sg13cmos5l_inv_1_519.Y sg13cmos5l_inv_1_532.A VPWR.t26 sg13_lv_pmos ad=0.3808p pd=2.92u as=0.3808p ps=2.92u w=1.12u l=0.13u
X2904 a_6836_12970# sg13cmos5l_inv_1_495.A VGND.t102 VGND.t103 sg13_lv_nmos ad=76.8f pd=0.88u as=0.1872p ps=1.225u w=0.64u l=0.13u
X2905 sg13cmos5l_inv_1_227.A sg13cmos5l_inv_1_206.Y VPWR.t796 VPWR.t0 sg13_lv_pmos ad=0.3808p pd=2.92u as=0.3808p ps=2.92u w=1.12u l=0.13u
X2906 VPWR.t120 VGND.t12 VPWR.t119 VPWR.t0 sg13_lv_pmos ad=0.34p pd=2.68u as=0 ps=0 w=1u l=1u
X2907 VPWR.t729 VGND.t1227 VPWR.t1256 VPWR.t21 sg13_lv_pmos ad=0.34p pd=2.68u as=0 ps=0 w=1u l=1u
X2908 sg13cmos5l_inv_1_194.Y sg13cmos5l_inv_1_187.Y VGND.t113 VGND.t11 sg13_lv_nmos ad=0.2516p pd=2.16u as=0.2516p ps=2.16u w=0.74u l=0.13u
X2909 VGND.t29 sg13cmos5l_inv_1_549.A sg13cmos5l_inv_1_545.A VGND.t22 sg13_lv_nmos ad=0.2516p pd=2.16u as=0.2516p ps=2.16u w=0.74u l=0.13u
X2910 VGND.t28 sg13cmos5l_inv_1_44.A sg13cmos5l_mux4_1_1.A3 VGND.t1178 sg13_lv_nmos ad=0.2516p pd=2.16u as=0.2516p ps=2.16u w=0.74u l=0.13u
X2911 sg13cmos5l_inv_1_304.A sg13cmos5l_inv_1_283.A VGND.t501 VGND.t1088 sg13_lv_nmos ad=0.2516p pd=2.16u as=0.2516p ps=2.16u w=0.74u l=0.13u
X2912 a_9633_6516# sg13cmos5l_mux4_1_5.S1.t5 a_8638_6558# VPWR.t0 sg13_lv_pmos ad=0.2225p pd=1.445u as=0.34p ps=2.68u w=1u l=0.13u
X2913 VGND.t1 VPWR.t1541 VGND.t335 VGND.t1593 sg13_lv_nmos ad=79.8f pd=0.8u as=0 ps=0 w=0.42u l=1u
X2914 a_16113_8070# sg13cmos5l_inv_1_149.A VGND.t130 VGND.t1401 sg13_lv_nmos ad=76.8f pd=0.88u as=0.2176p ps=1.96u w=0.64u l=0.13u
X2915 VGND.t329 sg13cmos5l_inv_1_672.Y sg13cmos5l_inv_1_674.A VGND.t1179 sg13_lv_nmos ad=0.2516p pd=2.16u as=0.2516p ps=2.16u w=0.74u l=0.13u
X2916 VPWR.t1054 sg13cmos5l_inv_1_634.A sg13cmos5l_inv_1_633.A VPWR.t21 sg13_lv_pmos ad=0.3808p pd=2.92u as=0.3808p ps=2.92u w=1.12u l=0.13u
X2917 sg13cmos5l_inv_1_293.Y sg13cmos5l_inv_1_290.Y VPWR.t1461 VPWR.t8 sg13_lv_pmos ad=0.3808p pd=2.92u as=0.3808p ps=2.92u w=1.12u l=0.13u
X2918 VPWR.t449 sg13cmos5l_inv_1_16.A sg13cmos5l_inv_1_16.Y VPWR.t11 sg13_lv_pmos ad=0.3808p pd=2.92u as=0.3808p ps=2.92u w=1.12u l=0.13u
X2919 sg13cmos5l_inv_1_792.Y sg13cmos5l_inv_1_796.Y VPWR.t617 VPWR.t42 sg13_lv_pmos ad=0.3808p pd=2.92u as=0.3808p ps=2.92u w=1.12u l=0.13u
X2920 a_15580_11458# a_14827_11673# a_14389_11500# VGND.t1086 sg13_lv_nmos ad=76.8f pd=0.88u as=0.1472p ps=1.1u w=0.64u l=0.13u
X2921 VGND.t508 sg13cmos5l_inv_1_922.A sg13cmos5l_inv_1_922.Y VGND.t190 sg13_lv_nmos ad=0.2516p pd=2.16u as=0.2516p ps=2.16u w=0.74u l=0.13u
X2922 VPWR.t431 sg13cmos5l_inv_1_137.A sg13cmos5l_inv_1_138.A VPWR.t14 sg13_lv_pmos ad=0.3808p pd=2.92u as=0.3808p ps=2.92u w=1.12u l=0.13u
X2923 VPWR.t1383 sg13cmos5l_inv_1_871.Y sg13cmos5l_inv_1_841.Y VPWR.t39 sg13_lv_pmos ad=0.3808p pd=2.92u as=0.3808p ps=2.92u w=1.12u l=0.13u
X2924 a_4575_12606# sg13cmos5l_buf_1_8.A.t4 a_4438_12606# VGND.t1437 sg13_lv_nmos ad=76.8f pd=0.88u as=0.1776p ps=1.195u w=0.64u l=0.13u
X2925 sg13cmos5l_inv_1_901.Y sg13cmos5l_inv_1_734.Y VPWR.t573 VPWR.t5 sg13_lv_pmos ad=0.3808p pd=2.92u as=0.3808p ps=2.92u w=1.12u l=0.13u
X2926 VGND.t437 sg13cmos5l_inv_1_631.Y sg13cmos5l_inv_1_683.A VGND.t436 sg13_lv_nmos ad=0.2516p pd=2.16u as=0.2516p ps=2.16u w=0.74u l=0.13u
X2927 VPWR.t605 sg13cmos5l_inv_1_641.A sg13cmos5l_inv_1_640.A VPWR.t21 sg13_lv_pmos ad=0.3808p pd=2.92u as=0.3808p ps=2.92u w=1.12u l=0.13u
X2928 VGND.t614 sg13cmos5l_inv_1_345.A sg13cmos5l_inv_1_345.Y VGND.t941 sg13_lv_nmos ad=0.2516p pd=2.16u as=0.2516p ps=2.16u w=0.74u l=0.13u
X2929 VGND.t128 sg13cmos5l_inv_1_182.A sg13cmos5l_inv_1_179.A VGND.t481 sg13_lv_nmos ad=0.2516p pd=2.16u as=0.2516p ps=2.16u w=0.74u l=0.13u
X2930 sg13cmos5l_inv_1_717.A sg13cmos5l_inv_1_729.Y VGND.t39 VGND.t691 sg13_lv_nmos ad=0.2516p pd=2.16u as=0.2516p ps=2.16u w=0.74u l=0.13u
X2931 a_15419_8040# sg13cmos5l_buf_1_9.A.t1 VGND.t130 VGND.t674 sg13_lv_nmos ad=0.2304p pd=2u as=0.1543p ps=1.18u w=0.64u l=0.13u
X2932 a_6356_8434# sg13cmos5l_inv_1_402.A VGND.t162 VGND.t222 sg13_lv_nmos ad=76.8f pd=0.88u as=0.1872p ps=1.225u w=0.64u l=0.13u
X2933 sg13cmos5l_inv_1_467.A sg13cmos5l_inv_1_967.Y VGND.t153 VGND.t4 sg13_lv_nmos ad=0.2516p pd=2.16u as=0.2516p ps=2.16u w=0.74u l=0.13u
X2934 VGND.t971 VPWR.t1554 VGND.t971 VGND.t1578 sg13_lv_nmos ad=79.8f pd=0.8u as=0 ps=0 w=0.42u l=1u
X2935 VGND.t567 sg13cmos5l_inv_1_793.A sg13cmos5l_inv_1_794.A VGND.t22 sg13_lv_nmos ad=0.2516p pd=2.16u as=0.2516p ps=2.16u w=0.74u l=0.13u
X2936 a_14751_3534# sg13cmos5l_mux4_1_5.S1.t1 a_14614_3534# VGND.t80 sg13_lv_nmos ad=76.8f pd=0.88u as=0.1776p ps=1.195u w=0.64u l=0.13u
X2937 VGND.t69 sg13cmos5l_inv_1_835.A sg13cmos5l_inv_1_823.A VGND.t70 sg13_lv_nmos ad=0.2516p pd=2.16u as=0.2516p ps=2.16u w=0.74u l=0.13u
X2938 sg13cmos5l_inv_1_544.Y sg13cmos5l_inv_1_541.Y VGND.t29 VGND.t22 sg13_lv_nmos ad=0.2516p pd=2.16u as=0.2516p ps=2.16u w=0.74u l=0.13u
X2939 VPWR.t85 VGND.t49 VPWR.t84 VPWR.t39 sg13_lv_pmos ad=0.34p pd=2.68u as=0 ps=0 w=1u l=1u
X2940 VGND.t343 sg13cmos5l_inv_1_430.A sg13cmos5l_inv_1_429.A VGND.t11 sg13_lv_nmos ad=0.2516p pd=2.16u as=0.2516p ps=2.16u w=0.74u l=0.13u
X2941 VPWR.t1122 sg13cmos5l_inv_1_665.A sg13cmos5l_inv_1_522.A VPWR.t26 sg13_lv_pmos ad=0.3808p pd=2.92u as=0.3808p ps=2.92u w=1.12u l=0.13u
X2942 VGND.t92 sg13cmos5l_inv_1_910.A sg13cmos5l_inv_1_909.A VGND.t793 sg13_lv_nmos ad=0.2516p pd=2.16u as=0.2516p ps=2.16u w=0.74u l=0.13u
X2943 VPWR.t312 sg13cmos5l_inv_1_495.A sg13cmos5l_inv_1_498.A VPWR.t2 sg13_lv_pmos ad=0.3808p pd=2.92u as=0.3808p ps=2.92u w=1.12u l=0.13u
X2944 sg13cmos5l_inv_1_272.A sg13cmos5l_inv_1_284.A VGND.t19 VGND.t1396 sg13_lv_nmos ad=0.2516p pd=2.16u as=0.2516p ps=2.16u w=0.74u l=0.13u
X2945 sg13cmos5l_inv_1_816.Y sg13cmos5l_inv_1_816.A VGND.t35 VGND.t36 sg13_lv_nmos ad=0.2516p pd=2.16u as=0.2516p ps=2.16u w=0.74u l=0.13u
X2946 sg13cmos5l_inv_1_619.Y sg13cmos5l_inv_1_619.A VGND.t747 VGND.t746 sg13_lv_nmos ad=0.2516p pd=2.16u as=0.2516p ps=2.16u w=0.74u l=0.13u
X2947 VGND.t501 sg13cmos5l_inv_1_260.A sg13cmos5l_inv_1_260.Y VGND.t1264 sg13_lv_nmos ad=0.2516p pd=2.16u as=0.2516p ps=2.16u w=0.74u l=0.13u
X2948 VGND.t529 sg13cmos5l_inv_1_681.A sg13cmos5l_inv_1_681.Y VGND.t782 sg13_lv_nmos ad=0.2516p pd=2.16u as=0.2516p ps=2.16u w=0.74u l=0.13u
X2949 VPWR.t28 VGND.t866 VPWR.t27 VPWR.t26 sg13_lv_pmos ad=0.19p pd=1.38u as=0 ps=0 w=1u l=1u
X2950 a_14559_12606# sg13cmos5l_buf_1_9.A.t2 a_14422_12606# VGND.t714 sg13_lv_nmos ad=76.8f pd=0.88u as=0.1776p ps=1.195u w=0.64u l=0.13u
X2951 VPWR.t937 sg13cmos5l_inv_1_78.A sg13cmos5l_inv_1_92.A VPWR.t49 sg13_lv_pmos ad=0.3808p pd=2.92u as=0.3808p ps=2.92u w=1.12u l=0.13u
X2952 VGND.t143 sg13cmos5l_inv_1_926.A sg13cmos5l_inv_1_926.Y VGND.t190 sg13_lv_nmos ad=0.2516p pd=2.16u as=0.2516p ps=2.16u w=0.74u l=0.13u
X2953 sg13cmos5l_inv_1_312.Y sg13cmos5l_inv_1_313.Y VGND.t260 VGND.t1296 sg13_lv_nmos ad=0.2516p pd=2.16u as=0.2516p ps=2.16u w=0.74u l=0.13u
X2954 VPWR.t1012 sg13cmos5l_inv_1_1009.Y sg13cmos5l_inv_1_502.Y VPWR.t5 sg13_lv_pmos ad=0.3808p pd=2.92u as=0.3808p ps=2.92u w=1.12u l=0.13u
X2955 VPWR.t331 sg13cmos5l_mux4_1_0.A0 a_16723_7731# VPWR.t14 sg13_lv_pmos ad=0.22315p pd=1.555u as=0.415p ps=1.83u w=1u l=0.13u
X2956 sg13cmos5l_nand2_1_1.Y sg13cmos5l_nand2_1_1.B VPWR.t824 VPWR.t29 sg13_lv_pmos ad=0.2128p pd=1.5u as=0.3808p ps=2.92u w=1.12u l=0.13u
X2957 VGND.t174 sg13cmos5l_inv_1_759.A sg13cmos5l_inv_1_987.A VGND.t894 sg13_lv_nmos ad=0.2516p pd=2.16u as=0.2516p ps=2.16u w=0.74u l=0.13u
X2958 VGND.t939 VPWR.t1533 VGND.t939 VGND.t11 sg13_lv_nmos ad=79.8f pd=0.8u as=0 ps=0 w=0.42u l=1u
X2959 sg13cmos5l_inv_1_902.Y sg13cmos5l_inv_1_903.Y VGND.t92 VGND.t1235 sg13_lv_nmos ad=0.2516p pd=2.16u as=0.2516p ps=2.16u w=0.74u l=0.13u
X2960 a_14612_9582# sg13cmos5l_mux4_1_5.S1.t8 a_14494_9582# VGND.t85 sg13_lv_nmos ad=0.2304p pd=1.36u as=0.1472p ps=1.1u w=0.64u l=0.13u
X2961 VPWR.t508 sg13cmos5l_inv_1_775.A sg13cmos5l_inv_1_775.Y VPWR.t39 sg13_lv_pmos ad=0.3808p pd=2.92u as=0.3808p ps=2.92u w=1.12u l=0.13u
X2962 VPWR.t103 VGND.t747 VPWR.t102 VPWR.t21 sg13_lv_pmos ad=0.19p pd=1.38u as=0 ps=0 w=1u l=1u
X2963 VGND.t201 sg13cmos5l_inv_1_411.A sg13cmos5l_inv_1_411.Y VGND.t1342 sg13_lv_nmos ad=0.2516p pd=2.16u as=0.2516p ps=2.16u w=0.74u l=0.13u
X2964 VPWR.t208 VGND.t162 VPWR.t207 VPWR.t29 sg13_lv_pmos ad=0.34p pd=2.68u as=0 ps=0 w=1u l=1u
X2965 sg13cmos5l_inv_1_1.Y sg13cmos5l_inv_1_0.Y VPWR.t1298 VPWR.t11 sg13_lv_pmos ad=0.3808p pd=2.92u as=0.3808p ps=2.92u w=1.12u l=0.13u
X2966 VPWR.t936 sg13cmos5l_inv_1_78.A a_18664_6956# VPWR.t14 sg13_lv_pmos ad=0.2114p pd=1.54u as=0.2856p ps=2.36u w=0.84u l=0.13u
X2967 sg13cmos5l_inv_1_662.Y sg13cmos5l_inv_1_499.Y VPWR.t586 VPWR.t5 sg13_lv_pmos ad=0.3808p pd=2.92u as=0.3808p ps=2.92u w=1.12u l=0.13u
X2968 sg13cmos5l_inv_1_747.Y sg13cmos5l_inv_1_756.Y VGND.t41 VGND.t40 sg13_lv_nmos ad=0.2516p pd=2.16u as=0.2516p ps=2.16u w=0.74u l=0.13u
X2969 a_3860_15994# sg13cmos5l_inv_1_565.Y VGND.t263 VGND.t1348 sg13_lv_nmos ad=76.8f pd=0.88u as=0.1872p ps=1.225u w=0.64u l=0.13u
X2970 sg13cmos5l_inv_1_770.A sg13cmos5l_inv_1_769.Y VGND.t194 VGND.t1329 sg13_lv_nmos ad=0.2516p pd=2.16u as=0.2516p ps=2.16u w=0.74u l=0.13u
X2971 sg13cmos5l_inv_1_504.A sg13cmos5l_inv_1_505.Y VGND.t145 VGND.t144 sg13_lv_nmos ad=0.2516p pd=2.16u as=0.2516p ps=2.16u w=0.74u l=0.13u
X2972 sg13cmos5l_inv_1_36.A sg13cmos5l_inv_1_39.A VGND.t64 VGND.t407 sg13_lv_nmos ad=0.2516p pd=2.16u as=0.2516p ps=2.16u w=0.74u l=0.13u
X2973 VGND.t119 invsel[0] a_808_1632# VGND.t1366 sg13_lv_nmos ad=0.14875p pd=1.16u as=0.187p ps=1.78u w=0.55u l=0.13u
X2974 VGND.t536 sg13cmos5l_inv_1_945.A sg13cmos5l_inv_1_945.Y VGND.t585 sg13_lv_nmos ad=0.2516p pd=2.16u as=0.2516p ps=2.16u w=0.74u l=0.13u
X2975 VPWR.t200 VGND.t420 VPWR.t199 VPWR.t0 sg13_lv_pmos ad=0.34p pd=2.68u as=0 ps=0 w=1u l=1u
X2976 VPWR.t143 sg13cmos5l_inv_1_294.Y sg13cmos5l_inv_1_297.Y VPWR.t11 sg13_lv_pmos ad=0.3808p pd=2.92u as=0.3808p ps=2.92u w=1.12u l=0.13u
X2977 VGND.t88 sg13cmos5l_inv_1_889.Y sg13cmos5l_inv_1_884.Y VGND.t236 sg13_lv_nmos ad=0.2516p pd=2.16u as=0.2516p ps=2.16u w=0.74u l=0.13u
X2978 VGND.t46 VPWR.t1601 VGND.t46 VGND.t1210 sg13_lv_nmos ad=79.8f pd=0.8u as=0 ps=0 w=0.42u l=1u
X2979 sg13cmos5l_inv_1_563.Y sg13cmos5l_inv_1_563.A VGND.t94 VGND.t93 sg13_lv_nmos ad=0.2516p pd=2.16u as=0.2516p ps=2.16u w=0.74u l=0.13u
X2980 VGND.t113 sg13cmos5l_inv_1_205.A sg13cmos5l_inv_1_205.Y VGND.t11 sg13_lv_nmos ad=0.2516p pd=2.16u as=0.2516p ps=2.16u w=0.74u l=0.13u
X2981 VPWR.t971 sg13cmos5l_inv_1_340.Y sg13cmos5l_inv_1_375.Y VPWR.t14 sg13_lv_pmos ad=0.3808p pd=2.92u as=0.3808p ps=2.92u w=1.12u l=0.13u
X2982 VGND.t44 sg13cmos5l_inv_1_589.A sg13cmos5l_inv_1_589.Y VGND.t22 sg13_lv_nmos ad=0.2516p pd=2.16u as=0.2516p ps=2.16u w=0.74u l=0.13u
X2983 VPWR.t1376 sg13cmos5l_inv_1_636.A sg13cmos5l_inv_1_635.A VPWR.t21 sg13_lv_pmos ad=0.3808p pd=2.92u as=0.3808p ps=2.92u w=1.12u l=0.13u
X2984 VPWR.t1458 sg13cmos5l_inv_1_2.A sg13cmos5l_inv_1_2.Y VPWR.t11 sg13_lv_pmos ad=0.3808p pd=2.92u as=0.3808p ps=2.92u w=1.12u l=0.13u
X2985 sg13cmos5l_mux4_1_3.X a_8577_3492# VPWR.t299 VPWR.t8 sg13_lv_pmos ad=0.3808p pd=2.92u as=0.34367p ps=1.775u w=1.12u l=0.13u
X2986 VGND.t140 VPWR.t1615 VGND.t140 VGND.t22 sg13_lv_nmos ad=0.1428p pd=1.52u as=0 ps=0 w=0.42u l=1u
X2987 sg13cmos5l_inv_1_364.A sg13cmos5l_inv_1_368.Y VGND.t201 VGND.t200 sg13_lv_nmos ad=0.2516p pd=2.16u as=0.2516p ps=2.16u w=0.74u l=0.13u
X2988 VGND.t100 sg13cmos5l_inv_1_679.A sg13cmos5l_inv_1_553.A VGND.t22 sg13_lv_nmos ad=0.2516p pd=2.16u as=0.2516p ps=2.16u w=0.74u l=0.13u
X2989 VPWR.t1211 sg13cmos5l_inv_1_576.A a_4141_16261# VPWR.t42 sg13_lv_pmos ad=0.29275p pd=1.785u as=0.16p ps=1.32u w=1u l=0.13u
X2990 VGND.t292 sg13cmos5l_inv_1_16.A sg13cmos5l_inv_1_16.Y VGND.t291 sg13_lv_nmos ad=0.2516p pd=2.16u as=0.2516p ps=2.16u w=0.74u l=0.13u
X2991 VGND.t430 VPWR.t1539 VGND.t540 VGND.t1595 sg13_lv_nmos ad=0.1428p pd=1.52u as=0 ps=0 w=0.42u l=1u
X2992 sg13cmos5l_inv_1_166.A sg13cmos5l_inv_1_958.Y VGND.t149 VGND.t472 sg13_lv_nmos ad=0.2516p pd=2.16u as=0.2516p ps=2.16u w=0.74u l=0.13u
X2993 VGND.t430 sg13cmos5l_inv_1_346.Y sg13cmos5l_inv_1_373.A VGND.t1030 sg13_lv_nmos ad=0.2516p pd=2.16u as=0.2516p ps=2.16u w=0.74u l=0.13u
X2994 sg13cmos5l_nor4_1_0.A sg13cmos5l_nand2_1_1.B VGND.t191 VGND.t190 sg13_lv_nmos ad=0.1694p pd=1.21u as=0.2618p ps=2.22u w=0.77u l=0.13u
X2995 VPWR.t1082 sg13cmos5l_mux2_1_3.S a_8123_8472# VPWR.t29 sg13_lv_pmos ad=0.253p pd=1.53u as=0.2856p ps=2.36u w=0.84u l=0.13u
X2996 VGND.t269 sg13cmos5l_inv_1_1007.Y sg13cmos5l_inv_1_474.Y VGND.t1153 sg13_lv_nmos ad=0.2516p pd=2.16u as=0.2516p ps=2.16u w=0.74u l=0.13u
X2997 VPWR.t337 sg13cmos5l_inv_1_570.A sg13cmos5l_mux4_1_10.A2 VPWR.t42 sg13_lv_pmos ad=0.3808p pd=2.92u as=0.3808p ps=2.92u w=1.12u l=0.13u
X2998 VPWR.t575 sg13cmos5l_inv_1_414.A sg13cmos5l_inv_1_415.A VPWR.t49 sg13_lv_pmos ad=0.3808p pd=2.92u as=0.3808p ps=2.92u w=1.12u l=0.13u
X2999 VPWR.t1133 sg13cmos5l_inv_1_922.A sg13cmos5l_inv_1_922.Y VPWR.t5 sg13_lv_pmos ad=0.3808p pd=2.92u as=0.3808p ps=2.92u w=1.12u l=0.13u
X3000 VGND.t54 sg13cmos5l_inv_1_316.A sg13cmos5l_inv_1_322.A VGND.t1287 sg13_lv_nmos ad=0.2516p pd=2.16u as=0.2516p ps=2.16u w=0.74u l=0.13u
X3001 VGND.t207 sg13cmos5l_inv_1_583.A sg13cmos5l_inv_1_684.A VGND.t1189 sg13_lv_nmos ad=0.2516p pd=2.16u as=0.2516p ps=2.16u w=0.74u l=0.13u
X3002 sg13cmos5l_mux2_1_3.S sg13cmos5l_nor3_1_2.B VGND.t414 VGND.t1471 sg13_lv_nmos ad=0.2516p pd=2.16u as=0.2516p ps=2.16u w=0.74u l=0.13u
X3003 sg13cmos5l_inv_1_837.Y sg13cmos5l_inv_1_836.Y VGND.t116 VGND.t22 sg13_lv_nmos ad=0.2516p pd=2.16u as=0.2516p ps=2.16u w=0.74u l=0.13u
X3004 sg13cmos5l_mux2_1_1.X a_8446_8434# VPWR.t787 VPWR.t29 sg13_lv_pmos ad=0.6048p pd=3.32u as=0.2198p ps=1.52u w=1.12u l=0.13u
X3005 sg13cmos5l_inv_1_152.Y sg13cmos5l_inv_1_211.Y VPWR.t1310 VPWR.t0 sg13_lv_pmos ad=0.3808p pd=2.92u as=0.3808p ps=2.92u w=1.12u l=0.13u
X3006 VPWR.t89 VGND.t107 VPWR.t88 VPWR.t14 sg13_lv_pmos ad=0.34p pd=2.68u as=0 ps=0 w=1u l=1u
X3007 sg13cmos5l_inv_1_391.A sg13cmos5l_inv_1_407.Y VPWR.t1199 VPWR.t14 sg13_lv_pmos ad=0.3808p pd=2.92u as=0.3808p ps=2.92u w=1.12u l=0.13u
X3008 sg13cmos5l_inv_1_467.A sg13cmos5l_inv_1_967.Y VPWR.t1049 VPWR.t29 sg13_lv_pmos ad=0.3808p pd=2.92u as=0.3808p ps=2.92u w=1.12u l=0.13u
X3009 VPWR.t1204 sg13cmos5l_inv_1_672.Y sg13cmos5l_inv_1_674.A VPWR.t26 sg13_lv_pmos ad=0.3808p pd=2.92u as=0.3808p ps=2.92u w=1.12u l=0.13u
R0 VPWR.n1584 VPWR.t978 17.2931
R1 VPWR.n106 VPWR.t1109 17.5741
R2 VPWR.n703 VPWR.t351 17.2931
R3 VPWR.n1634 VPWR.t638 17.278
R4 VPWR.n367 VPWR.t1237 17.2755
R5 VPWR.t49 VPWR.t1433 17.2755
R6 VPWR.n1551 VPWR.t1081 17.2755
R7 VPWR.n626 VPWR.t1082 17.2755
R8 VPWR.n1202 VPWR.t1473 17.2755
R9 VPWR.n603 VPWR.t772 17.2506
R10 VPWR.n1762 VPWR.t783 17.2503
R11 VPWR.n730 VPWR.t307 17.2503
R12 VPWR.n915 VPWR.t867 17.2503
R13 VPWR.n1854 VPWR.t563 17.2403
R14 VPWR.n1457 VPWR.t343 17.2403
R15 VPWR.n179 VPWR.t329 17.2247
R16 VPWR.n51 VPWR.t741 17.2247
R17 VPWR.n91 VPWR.t657 17.2247
R18 VPWR.n1771 VPWR.t358 17.2247
R19 VPWR.n1784 VPWR.t1136 17.2247
R20 VPWR.n1781 VPWR.t446 17.2247
R21 VPWR.n173 VPWR.t390 17.2247
R22 VPWR.n464 VPWR.t533 17.2247
R23 VPWR.n1635 VPWR.t936 17.2247
R24 VPWR.n517 VPWR.t432 17.2247
R25 VPWR.n175 VPWR.t383 17.2247
R26 VPWR.n1342 VPWR.t821 17.2247
R27 VPWR.n1338 VPWR.t812 17.2247
R28 VPWR.n1283 VPWR.t550 17.2247
R29 VPWR.n1279 VPWR.t373 17.2247
R30 VPWR.n194 VPWR.t397 17.2247
R31 VPWR.n222 VPWR.t663 17.2403
R32 VPWR.n993 VPWR.t438 17.2247
R33 VPWR.n223 VPWR.t276 17.278
R34 VPWR.n935 VPWR.t858 17.2247
R35 VPWR.n929 VPWR.t911 17.2247
R36 VPWR.n148 VPWR.t1176 17.212
R37 VPWR.n355 VPWR.t318 17.212
R38 VPWR.n417 VPWR.t1145 17.212
R39 VPWR.n1860 VPWR.t1300 17.212
R40 VPWR.n1706 VPWR.t500 17.212
R41 VPWR.n77 VPWR.t1072 17.212
R42 VPWR.n10 VPWR.t1066 17.212
R43 VPWR.n558 VPWR.t1043 17.212
R44 VPWR.n23 VPWR.t543 17.212
R45 VPWR.n1328 VPWR.t370 17.212
R46 VPWR.n686 VPWR.t601 17.212
R47 VPWR.n1264 VPWR.t964 17.212
R48 VPWR.n80 VPWR.t548 17.212
R49 VPWR.n1172 VPWR.t306 17.212
R50 VPWR.n1170 VPWR.t703 17.212
R51 VPWR.n801 VPWR.t281 17.212
R52 VPWR.n777 VPWR.t1211 17.212
R53 VPWR.n328 VPWR.t727 17.1888
R54 VPWR.n316 VPWR.t1426 17.1888
R55 VPWR.n412 VPWR.t700 17.1888
R56 VPWR.n1855 VPWR.t846 17.1888
R57 VPWR.n1712 VPWR.t1441 17.1888
R58 VPWR.n10 VPWR.t1404 17.1888
R59 VPWR.n1626 VPWR.t972 17.1888
R60 VPWR.n553 VPWR.t1076 17.1888
R61 VPWR.n144 VPWR.t835 17.1888
R62 VPWR.n1324 VPWR.t612 17.1888
R63 VPWR.n1326 VPWR.t1030 17.1888
R64 VPWR.n1270 VPWR.t1263 17.1888
R65 VPWR.n1226 VPWR.t629 17.1888
R66 VPWR.n1168 VPWR.t557 17.1888
R67 VPWR.n1166 VPWR.t670 17.1888
R68 VPWR.n763 VPWR.t814 17.1888
R69 VPWR.n779 VPWR.t1448 17.1888
R70 VPWR.t11 VPWR.n1932 17.0005
R71 VPWR.t11 VPWR.n1927 17.0005
R72 VPWR.t11 VPWR.n242 17.0005
R73 VPWR.t11 VPWR.n1917 17.0005
R74 VPWR.t11 VPWR.n243 17.0005
R75 VPWR.t11 VPWR.n244 17.0005
R76 VPWR.t11 VPWR.n247 17.0005
R77 VPWR.t11 VPWR.n1906 17.0005
R78 VPWR.t11 VPWR.n250 17.0005
R79 VPWR.t11 VPWR.n1901 17.0005
R80 VPWR.t11 VPWR.n1899 17.0005
R81 VPWR.t11 VPWR.n256 17.0005
R82 VPWR.t11 VPWR.n257 17.0005
R83 VPWR.t11 VPWR.n262 17.0005
R84 VPWR.t11 VPWR.n291 17.0005
R85 VPWR.t11 VPWR.n264 17.0005
R86 VPWR.t11 VPWR.n288 17.0005
R87 VPWR.t11 VPWR.n282 17.0005
R88 VPWR.t11 VPWR.n61 2.04349
R89 VPWR.t11 VPWR.n266 17.0005
R90 VPWR.t11 VPWR.n275 17.0005
R91 VPWR.t11 VPWR.n269 17.0005
R92 VPWR.t11 VPWR.n273 17.0005
R93 VPWR.t8 VPWR.n374 17.0005
R94 VPWR.t8 VPWR.n431 17.0005
R95 VPWR.t8 VPWR.n52 1.38743
R96 VPWR.t8 VPWR.n378 17.0005
R97 VPWR.t8 VPWR.n382 17.0005
R98 VPWR.t8 VPWR.n388 17.0005
R99 VPWR.t8 VPWR.n390 17.0005
R100 VPWR.t8 VPWR.n394 17.0005
R101 VPWR.t8 VPWR.n400 17.0005
R102 VPWR.t8 VPWR.n142 2.75325
R103 VPWR.t8 VPWR.n36 1.34358
R104 VPWR.t8 VPWR.n370 17.0005
R105 VPWR.t8 VPWR.n368 17.0005
R106 VPWR.t8 VPWR.n365 17.0005
R107 VPWR.t8 VPWR.n314 17.0005
R108 VPWR.t8 VPWR.n317 17.0005
R109 VPWR.t8 VPWR.n318 17.0005
R110 VPWR.n128 VPWR.n127 0.186173
R111 VPWR.t8 VPWR.n350 17.0005
R112 VPWR.t8 VPWR.n345 17.0005
R113 VPWR.t8 VPWR.n340 17.0005
R114 VPWR.n149 VPWR.n148 0.119859
R115 VPWR.t8 VPWR.n333 17.0005
R116 VPWR.t8 VPWR.n224 5.64741
R117 VPWR.t8 VPWR.n1874 17.0005
R118 VPWR.t8 VPWR.n1886 17.0005
R119 VPWR.t8 VPWR.n1877 17.0005
R120 VPWR.t8 VPWR.n1878 17.0005
R121 VPWR.t49 VPWR.n1868 17.0005
R122 VPWR.t49 VPWR.n1811 17.0005
R123 VPWR.t49 VPWR.n1815 17.0005
R124 VPWR.t49 VPWR.n1832 17.0005
R125 VPWR.t49 VPWR.n1818 17.0005
R126 VPWR.t49 VPWR.n1819 17.0005
R127 VPWR.t49 VPWR.n56 1.97671
R128 VPWR.n7 VPWR.t49 0.849746
R129 VPWR.t49 VPWR.n29 1.46762
R130 VPWR.t49 VPWR.n1827 17.0005
R131 VPWR.t49 VPWR.n1822 17.0005
R132 VPWR.n85 VPWR.n84 0.105507
R133 VPWR.n141 VPWR.n140 0.129619
R134 VPWR.t49 VPWR.n1735 17.0005
R135 VPWR.t49 VPWR.n1802 17.0005
R136 VPWR.t49 VPWR.n1738 17.0005
R137 VPWR.t49 VPWR.n1797 17.0005
R138 VPWR.t49 VPWR.n1741 17.0005
R139 VPWR.t49 VPWR.n1793 17.0005
R140 VPWR.t49 VPWR.n1746 17.0005
R141 VPWR.t49 VPWR.n1787 17.0005
R142 VPWR.t49 VPWR.n1749 17.0005
R143 VPWR.t49 VPWR.n1780 17.0005
R144 VPWR.t49 VPWR.n1778 17.0005
R145 VPWR.t49 VPWR.n1753 17.0005
R146 VPWR.t49 VPWR.n92 2.30287
R147 VPWR.t49 VPWR.n1772 17.0005
R148 VPWR.t49 VPWR.n1756 17.0005
R149 VPWR.t49 VPWR.n1767 17.0005
R150 VPWR.t49 VPWR.n1765 17.0005
R151 VPWR.n473 VPWR.t0 17.0005
R152 VPWR.n161 VPWR.n160 0.121145
R153 VPWR.t0 VPWR.n477 17.0005
R154 VPWR.t0 VPWR.n33 1.55832
R155 VPWR.n33 VPWR.n32 0.0702963
R156 VPWR.t0 VPWR.n484 17.0005
R157 VPWR.t0 VPWR.n492 17.0005
R158 VPWR.t0 VPWR.n496 17.0005
R159 VPWR.t0 VPWR.n502 17.0005
R160 VPWR.n15 VPWR.n12 0.0735443
R161 VPWR.n18 VPWR.n16 0.11557
R162 VPWR.n1726 VPWR.t0 17.0005
R163 VPWR.n1724 VPWR.t0 17.0005
R164 VPWR.n1711 VPWR.t0 17.0005
R165 VPWR.n1707 VPWR.t0 17.0005
R166 VPWR.n1694 VPWR.t0 17.0005
R167 VPWR.n1690 VPWR.t0 17.0005
R168 VPWR.n147 VPWR.n146 0.120692
R169 VPWR.n1683 VPWR.t0 17.0005
R170 VPWR.n1681 VPWR.t0 17.0005
R171 VPWR.n1675 VPWR.t0 17.0005
R172 VPWR.n1667 VPWR.t0 17.0005
R173 VPWR.n76 VPWR.n75 0.195698
R174 VPWR.n1664 VPWR.t0 17.0005
R175 VPWR.n1658 VPWR.t0 17.0005
R176 VPWR.n1730 VPWR.t0 17.0005
R177 VPWR.t0 VPWR.n459 17.0005
R178 VPWR.t0 VPWR.n445 17.0005
R179 VPWR.t0 VPWR.n450 17.0005
R180 VPWR.t0 VPWR.n446 17.0005
R181 VPWR.t14 VPWR.n1572 17.0005
R182 VPWR.t14 VPWR.n1578 17.0005
R183 VPWR.n1636 VPWR.t14 17.0005
R184 VPWR.n1642 VPWR.t14 17.0005
R185 VPWR.n34 VPWR.n166 0.469392
R186 VPWR.t14 VPWR.n1518 17.0005
R187 VPWR.t14 VPWR.n1519 17.0005
R188 VPWR.t14 VPWR.n1520 17.0005
R189 VPWR.t14 VPWR.n1543 17.0005
R190 VPWR.t14 VPWR.n1522 17.0005
R191 VPWR.t14 VPWR.n1538 17.0005
R192 VPWR.t14 VPWR.n1523 17.0005
R193 VPWR.t14 VPWR.n1526 17.0005
R194 VPWR.t14 VPWR.n1528 17.0005
R195 VPWR.t14 VPWR.n230 5.64741
R196 VPWR.n1600 VPWR.t14 17.0005
R197 VPWR.n1604 VPWR.t14 17.0005
R198 VPWR.n1606 VPWR.t14 17.0005
R199 VPWR.n1610 VPWR.t14 17.0005
R200 VPWR.n1612 VPWR.t14 17.0005
R201 VPWR.n1614 VPWR.t14 17.0005
R202 VPWR.n1620 VPWR.t14 17.0005
R203 VPWR.n77 VPWR.n78 0.19507
R204 VPWR.t14 VPWR.n1581 17.0005
R205 VPWR.t14 VPWR.n228 5.64741
R206 VPWR.n1592 VPWR.t14 17.0005
R207 VPWR.n73 VPWR.n72 0.195698
R208 VPWR.n1588 VPWR.t14 17.0005
R209 VPWR.n47 VPWR.n46 0.134935
R210 VPWR.t29 VPWR.n518 17.0005
R211 VPWR.t29 VPWR.n522 17.0005
R212 VPWR.t29 VPWR.n528 17.0005
R213 VPWR.t29 VPWR.n534 17.0005
R214 VPWR.t29 VPWR.n540 17.0005
R215 VPWR.t29 VPWR.n563 17.0005
R216 VPWR.t29 VPWR.n569 17.0005
R217 VPWR.t29 VPWR.n574 17.0005
R218 VPWR.t29 VPWR.n514 17.0005
R219 VPWR.t29 VPWR.n503 17.0005
R220 VPWR.t29 VPWR.n512 17.0005
R221 VPWR.t29 VPWR.n506 17.0005
R222 VPWR.n597 VPWR.t29 17.0005
R223 VPWR.n609 VPWR.t29 17.0005
R224 VPWR.n611 VPWR.t29 17.0005
R225 VPWR.n615 VPWR.t29 17.0005
R226 VPWR.n621 VPWR.t29 17.0005
R227 VPWR.n143 VPWR.t29 3.30696
R228 VPWR.n635 VPWR.t29 17.0005
R229 VPWR.n639 VPWR.t29 17.0005
R230 VPWR.n645 VPWR.t29 17.0005
R231 VPWR.n649 VPWR.t29 17.0005
R232 VPWR.n653 VPWR.t29 17.0005
R233 VPWR.n659 VPWR.t29 17.0005
R234 VPWR.n661 VPWR.t29 17.0005
R235 VPWR.t29 VPWR.n575 17.0005
R236 VPWR.t29 VPWR.n589 17.0005
R237 VPWR.t29 VPWR.n579 17.0005
R238 VPWR.t5 VPWR.n1456 17.0005
R239 VPWR.t5 VPWR.n1465 17.0005
R240 VPWR.t5 VPWR.n1470 17.0005
R241 VPWR.t5 VPWR.n1474 17.0005
R242 VPWR.t5 VPWR.n1483 17.0005
R243 VPWR.t5 VPWR.n1487 17.0005
R244 VPWR.t5 VPWR.n1491 17.0005
R245 VPWR.t5 VPWR.n1495 17.0005
R246 VPWR.t5 VPWR.n1499 17.0005
R247 VPWR.t5 VPWR.n24 1.14876
R248 VPWR.t5 VPWR.n1418 17.0005
R249 VPWR.t5 VPWR.n1421 17.0005
R250 VPWR.t5 VPWR.n1437 17.0005
R251 VPWR.t5 VPWR.n1424 17.0005
R252 VPWR.t5 VPWR.n31 1.3745
R253 VPWR.n151 VPWR.n150 0.135681
R254 VPWR.t5 VPWR.n1416 17.0005
R255 VPWR.t5 VPWR.n1373 17.0005
R256 VPWR.t5 VPWR.n1414 17.0005
R257 VPWR.t5 VPWR.n1380 17.0005
R258 VPWR.t5 VPWR.n1381 17.0005
R259 VPWR.t5 VPWR.n201 8.47111
R260 VPWR.n201 VPWR.n200 0.060789
R261 VPWR.t5 VPWR.n1398 17.0005
R262 VPWR.t5 VPWR.n1384 17.0005
R263 VPWR.t5 VPWR.n219 17.0005
R264 VPWR.n1510 VPWR.t5 17.0005
R265 VPWR.t5 VPWR.n1390 17.0005
R266 VPWR.t5 VPWR.n1385 17.0005
R267 VPWR.t5 VPWR.n1388 17.0005
R268 VPWR.t2 VPWR.n1334 17.0005
R269 VPWR.t2 VPWR.n684 17.0005
R270 VPWR.t2 VPWR.n1325 17.0005
R271 VPWR.t2 VPWR.n691 17.0005
R272 VPWR.t2 VPWR.n220 4.31481
R273 VPWR.t2 VPWR.n1339 17.0005
R274 VPWR.t2 VPWR.n1349 17.0005
R275 VPWR.t2 VPWR.n1351 17.0005
R276 VPWR.t2 VPWR.n1355 17.0005
R277 VPWR.t2 VPWR.n1359 17.0005
R278 VPWR.t2 VPWR.n1361 17.0005
R279 VPWR.n207 VPWR.t2 5.64879
R280 VPWR.n1316 VPWR.t2 17.0005
R281 VPWR.n1312 VPWR.t2 17.0005
R282 VPWR.n1308 VPWR.t2 17.0005
R283 VPWR.n1290 VPWR.t2 17.0005
R284 VPWR.n1278 VPWR.t2 17.0005
R285 VPWR.n25 VPWR.n70 0.135613
R286 VPWR.n1274 VPWR.t2 17.0005
R287 VPWR.n1271 VPWR.t2 17.0005
R288 VPWR.n43 VPWR.t2 1.39068
R289 VPWR.n50 VPWR.n42 0.146352
R290 VPWR.n1367 VPWR.t2 17.0005
R291 VPWR.t2 VPWR.n678 17.0005
R292 VPWR.t2 VPWR.n59 2.04349
R293 VPWR.t2 VPWR.n671 17.0005
R294 VPWR.t26 VPWR.n701 17.0005
R295 VPWR.t26 VPWR.n101 1.77386
R296 VPWR.t26 VPWR.n1245 17.0005
R297 VPWR.n154 VPWR.n153 0.181824
R298 VPWR.t26 VPWR.n154 3.30648
R299 VPWR.t26 VPWR.n131 2.36217
R300 VPWR.n68 VPWR.n67 0.292564
R301 VPWR.n163 VPWR.n164 0.121145
R302 VPWR.n80 VPWR.n81 0.19507
R303 VPWR.n1219 VPWR.t26 17.0005
R304 VPWR.n1213 VPWR.t26 17.0005
R305 VPWR.n1211 VPWR.t26 17.0005
R306 VPWR.n1207 VPWR.t26 17.0005
R307 VPWR.n1196 VPWR.t26 17.0005
R308 VPWR.n117 VPWR.t26 2.01431
R309 VPWR.n1191 VPWR.t26 17.0005
R310 VPWR.n1189 VPWR.t26 17.0005
R311 VPWR.n723 VPWR.t26 17.0005
R312 VPWR.n719 VPWR.t26 17.0005
R313 VPWR.n713 VPWR.t26 17.0005
R314 VPWR.n707 VPWR.t26 17.0005
R315 VPWR.t21 VPWR.n89 2.29332
R316 VPWR.t21 VPWR.n1122 17.0005
R317 VPWR.t21 VPWR.n1161 17.0005
R318 VPWR.t21 VPWR.n1177 17.0005
R319 VPWR.t21 VPWR.n1128 17.0005
R320 VPWR.t21 VPWR.n1132 17.0005
R321 VPWR.t21 VPWR.n1136 17.0005
R322 VPWR.t21 VPWR.n1144 17.0005
R323 VPWR.t21 VPWR.n1148 17.0005
R324 VPWR.n89 VPWR.n88 0.196385
R325 VPWR.t21 VPWR.n1121 17.0005
R326 VPWR.t21 VPWR.n1119 17.0005
R327 VPWR.t21 VPWR.n1055 17.0005
R328 VPWR.n97 VPWR.n96 0.0776314
R329 VPWR.t21 VPWR.n126 2.01431
R330 VPWR.t21 VPWR.n1106 17.0005
R331 VPWR.t21 VPWR.n1058 17.0005
R332 VPWR.t21 VPWR.n1101 17.0005
R333 VPWR.t21 VPWR.n123 2.01431
R334 VPWR.t21 VPWR.n1097 17.0005
R335 VPWR.t21 VPWR.n157 3.36162
R336 VPWR.n157 VPWR.n156 0.0405269
R337 VPWR.t21 VPWR.n1063 17.0005
R338 VPWR.t21 VPWR.n1084 17.0005
R339 VPWR.t21 VPWR.n1068 17.0005
R340 VPWR.t21 VPWR.n1079 17.0005
R341 VPWR.n66 VPWR.n65 0.237193
R342 VPWR.n1076 VPWR.t21 17.0005
R343 VPWR.n1072 VPWR.t21 17.0005
R344 VPWR.n237 VPWR.t21 5.64741
R345 VPWR.n1184 VPWR.t21 17.0005
R346 VPWR.n39 VPWR.n38 0.259465
R347 VPWR.n139 VPWR.n138 0.18414
R348 VPWR.t42 VPWR.n1002 17.0005
R349 VPWR.t42 VPWR.n1004 17.0005
R350 VPWR.t42 VPWR.n1028 17.0005
R351 VPWR.t42 VPWR.n139 2.71952
R352 VPWR.t42 VPWR.n750 17.0005
R353 VPWR.t42 VPWR.n822 17.0005
R354 VPWR.t42 VPWR.n753 17.0005
R355 VPWR.t42 VPWR.n816 17.0005
R356 VPWR.t42 VPWR.n756 17.0005
R357 VPWR.t42 VPWR.n809 17.0005
R358 VPWR.t42 VPWR.n757 17.0005
R359 VPWR.t42 VPWR.n804 17.0005
R360 VPWR.t42 VPWR.n90 2.04695
R361 VPWR.t42 VPWR.n766 17.0005
R362 VPWR.t42 VPWR.n791 17.0005
R363 VPWR.t42 VPWR.n771 17.0005
R364 VPWR.t42 VPWR.n780 17.0005
R365 VPWR.n0 VPWR.t42 1.11302
R366 VPWR.n1041 VPWR.t42 17.0005
R367 VPWR.t42 VPWR.n737 17.0005
R368 VPWR.t42 VPWR.n729 17.0005
R369 VPWR.t39 VPWR.n930 17.0005
R370 VPWR.t39 VPWR.n934 17.0005
R371 VPWR.t39 VPWR.n938 17.0005
R372 VPWR.t39 VPWR.n942 17.0005
R373 VPWR.t39 VPWR.n948 17.0005
R374 VPWR.t39 VPWR.n954 17.0005
R375 VPWR.t39 VPWR.n958 17.0005
R376 VPWR.t39 VPWR.n962 17.0005
R377 VPWR.t39 VPWR.n966 17.0005
R378 VPWR.t39 VPWR.n972 17.0005
R379 VPWR.t39 VPWR.n974 17.0005
R380 VPWR.t39 VPWR.n978 17.0005
R381 VPWR.t39 VPWR.n93 2.39141
R382 VPWR.t39 VPWR.n987 17.0005
R383 VPWR.t39 VPWR.n829 17.0005
R384 VPWR.t39 VPWR.n903 17.0005
R385 VPWR.t39 VPWR.n830 17.0005
R386 VPWR.t39 VPWR.n901 17.0005
R387 VPWR.t39 VPWR.n833 17.0005
R388 VPWR.t39 VPWR.n839 17.0005
R389 VPWR.t39 VPWR.n895 17.0005
R390 VPWR.t39 VPWR.n134 3.31673
R391 VPWR.t39 VPWR.n54 1.97671
R392 VPWR.t39 VPWR.n887 17.0005
R393 VPWR.t39 VPWR.n844 17.0005
R394 VPWR.t39 VPWR.n882 17.0005
R395 VPWR.t39 VPWR.n845 17.0005
R396 VPWR.t39 VPWR.n880 17.0005
R397 VPWR.t39 VPWR.n877 17.0005
R398 VPWR.t39 VPWR.n849 17.0005
R399 VPWR.t39 VPWR.n869 17.0005
R400 VPWR.t39 VPWR.n850 17.0005
R401 VPWR.t39 VPWR.n867 17.0005
R402 VPWR.t39 VPWR.n864 17.0005
R403 VPWR.t39 VPWR.n856 17.0005
R404 VPWR.t39 VPWR.n238 5.64741
R405 VPWR.t39 VPWR.n912 17.0005
R406 VPWR.t39 VPWR.n922 17.0005
R407 VPWR.n301 VPWR.t1511 15.2621
R408 VPWR.n289 VPWR.t1512 15.2621
R409 VPWR.n142 VPWR.t1514 15.2621
R410 VPWR.n437 VPWR.t1515 15.2621
R411 VPWR.n1864 VPWR.t1520 15.2621
R412 VPWR.n1776 VPWR.t1523 15.2621
R413 VPWR.n83 VPWR.t1521 15.2621
R414 VPWR.n14 VPWR.t1530 15.2621
R415 VPWR.n441 VPWR.t1535 15.2621
R416 VPWR.n1656 VPWR.t1534 15.2621
R417 VPWR.n1652 VPWR.t1531 15.2621
R418 VPWR.n475 VPWR.t1529 15.2621
R419 VPWR.n8 VPWR.t1542 15.2621
R420 VPWR.n1583 VPWR.t1545 15.2621
R421 VPWR.n1632 VPWR.t1544 15.2621
R422 VPWR.n1597 VPWR.t1543 15.2621
R423 VPWR.n9 VPWR.t1540 15.2621
R424 VPWR.n45 VPWR.t1552 15.2621
R425 VPWR.n668 VPWR.t1557 15.2621
R426 VPWR.n593 VPWR.t1556 15.2621
R427 VPWR.n595 VPWR.t1553 15.2621
R428 VPWR.n1503 VPWR.t1561 15.2621
R429 VPWR.n1382 VPWR.t1567 15.2621
R430 VPWR.n1404 VPWR.t1566 15.2621
R431 VPWR.n1427 VPWR.t1564 15.2621
R432 VPWR.n1433 VPWR.t1563 15.2621
R433 VPWR.n49 VPWR.t1577 15.2621
R434 VPWR.n1259 VPWR.t1576 15.2621
R435 VPWR.n1258 VPWR.t1574 15.2621
R436 VPWR.n1257 VPWR.t1573 15.2621
R437 VPWR.n21 VPWR.t1585 15.2621
R438 VPWR.t26 VPWR.t1586 15.2621
R439 VPWR.n1241 VPWR.t1582 15.2621
R440 VPWR.n1181 VPWR.t1593 15.2621
R441 VPWR.n1045 VPWR.t1595 15.2621
R442 VPWR.n1070 VPWR.t1594 15.2621
R443 VPWR.n1038 VPWR.t1605 15.2621
R444 VPWR.n726 VPWR.t1606 15.2621
R445 VPWR.n823 VPWR.t1612 15.2621
R446 VPWR.n859 VPWR.t1616 15.2621
R447 VPWR.n837 VPWR.t1614 15.2621
R448 VPWR.n862 VPWR.t1615 15.2621
R449 VPWR.n300 VPWR.t1513 15.2617
R450 VPWR.n433 VPWR.t1518 15.2617
R451 VPWR.n425 VPWR.t1517 15.2617
R452 VPWR.n436 VPWR.t1519 15.2617
R453 VPWR.n401 VPWR.t1516 15.2617
R454 VPWR.n1863 VPWR.t1526 15.2617
R455 VPWR.n1773 VPWR.t1528 15.2617
R456 VPWR.n1824 VPWR.t1527 15.2617
R457 VPWR.n29 VPWR.t1525 15.2617
R458 VPWR.n5 VPWR.t1524 15.2617
R459 VPWR.n440 VPWR.t1539 15.2617
R460 VPWR.n13 VPWR.t1536 15.2617
R461 VPWR.n8 VPWR.t1547 15.2617
R462 VPWR.n1582 VPWR.t1551 15.2617
R463 VPWR.n1631 VPWR.t1550 15.2617
R464 VPWR.n1598 VPWR.t1549 15.2617
R465 VPWR.n1544 VPWR.t1548 15.2617
R466 VPWR.n1648 VPWR.t1546 15.2617
R467 VPWR.n44 VPWR.t1558 15.2617
R468 VPWR.n667 VPWR.t1560 15.2617
R469 VPWR.n57 VPWR.t1569 15.2617
R470 VPWR.n1402 VPWR.t1572 15.2617
R471 VPWR.n1463 VPWR.t1568 15.2617
R472 VPWR.n1362 VPWR.t1578 15.2617
R473 VPWR.n669 VPWR.t1580 15.2617
R474 VPWR.n693 VPWR.t1579 15.2617
R475 VPWR.n21 VPWR.t1589 15.2617
R476 VPWR.n702 VPWR.t1592 15.2617
R477 VPWR.t26 VPWR.t1591 15.2617
R478 VPWR.n1235 VPWR.t1590 15.2617
R479 VPWR.n87 VPWR.t1597 15.2617
R480 VPWR.n1154 VPWR.t1596 15.2617
R481 VPWR.n1044 VPWR.t1604 15.2617
R482 VPWR.n1069 VPWR.t1603 15.2617
R483 VPWR.n137 VPWR.t1607 15.2617
R484 VPWR.n725 VPWR.t1610 15.2617
R485 VPWR.n1 VPWR.t1609 15.2617
R486 VPWR.n63 VPWR.t1608 15.2617
R487 VPWR.n858 VPWR.t1618 15.2617
R488 VPWR.n825 VPWR.t1617 15.2617
R489 VPWR.n171 VPWR.n170 1.09959
R490 VPWR.n1718 VPWR.t744 8.79277
R491 VPWR.t49 VPWR.t798 8.76789
R492 VPWR.n630 VPWR.t300 8.76789
R493 VPWR.n688 VPWR.t1410 8.76789
R494 VPWR.n1232 VPWR.t792 8.76789
R495 VPWR.n1164 VPWR.t1152 8.76789
R496 VPWR.n64 VPWR.t336 8.76789
R497 VPWR.n785 VPWR.t760 8.76789
R498 VPWR.n322 VPWR.t742 8.76689
R499 VPWR.n313 VPWR.t299 8.76689
R500 VPWR.n407 VPWR.t568 8.76689
R501 VPWR.n94 VPWR.t761 8.76689
R502 VPWR.n1621 VPWR.t717 8.76689
R503 VPWR.n547 VPWR.t258 8.76689
R504 VPWR.n1330 VPWR.t1006 8.76689
R505 VPWR.n1275 VPWR.t661 8.76689
R506 VPWR.n1162 VPWR.t1386 8.76689
R507 VPWR.n1293 VPWR.t576 8.76207
R508 VPWR.n177 VPWR.t866 8.76107
R509 VPWR.n610 VPWR.t1332 8.71823
R510 VPWR.t21 VPWR.n222 5.70473
R511 VPWR.t42 VPWR.n223 4.24382
R512 VPWR.n180 VPWR.n179 0.0586747
R513 VPWR.n438 VPWR.n224 0.0317231
R514 VPWR.n159 VPWR.n227 0.0768462
R515 VPWR.t0 VPWR.n226 5.64741
R516 VPWR.t14 VPWR.n231 4.20591
R517 VPWR.n1599 VPWR.n230 0.0317231
R518 VPWR.t14 VPWR.n229 4.20591
R519 VPWR.n228 VPWR.n1593 0.0317231
R520 VPWR.n233 VPWR.t29 4.20591
R521 VPWR.t29 VPWR.n232 4.20591
R522 VPWR.n1464 VPWR.n234 0.0768462
R523 VPWR.n1428 VPWR.n37 0.171202
R524 VPWR.n207 VPWR.n1320 0.0296542
R525 VPWR.n218 VPWR.t2 5.64879
R526 VPWR.n235 VPWR.t2 4.20591
R527 VPWR.n42 VPWR.n43 0.0443859
R528 VPWR.n1368 VPWR.n50 0.161851
R529 VPWR.n1242 VPWR.n236 0.0768462
R530 VPWR.n237 VPWR.n1046 0.0317231
R531 VPWR.n0 VPWR.n4 0.124231
R532 VPWR.n216 VPWR.t39 5.64879
R533 VPWR.n860 VPWR.n238 0.0317231
R534 VPWR.t11 VPWR.n180 4.23852
R535 VPWR.t11 VPWR.n1936 8.47111
R536 VPWR.t11 VPWR.n1934 8.47111
R537 VPWR.t11 VPWR.n1930 8.47111
R538 VPWR.t11 VPWR.n1925 8.47111
R539 VPWR.t11 VPWR.n1920 8.47111
R540 VPWR.t11 VPWR.n245 8.47111
R541 VPWR.t11 VPWR.n1909 8.47111
R542 VPWR.t11 VPWR.n248 8.47111
R543 VPWR.t11 VPWR.n1904 8.47111
R544 VPWR.t11 VPWR.n251 8.47111
R545 VPWR.t11 VPWR.n254 8.47111
R546 VPWR.t11 VPWR.n260 8.47111
R547 VPWR.t11 VPWR.n299 8.47111
R548 VPWR.t11 VPWR.n294 8.47111
R549 VPWR.t11 VPWR.n285 8.47111
R550 VPWR.t11 VPWR.n280 8.47111
R551 VPWR.t11 VPWR.n277 8.47111
R552 VPWR.t11 VPWR.n267 8.47111
R553 VPWR.t8 VPWR.n435 8.47111
R554 VPWR.t8 VPWR.n429 8.47111
R555 VPWR.n52 VPWR.n51 0.176732
R556 VPWR.n51 VPWR.n107 0.128833
R557 VPWR.t8 VPWR.n384 8.47111
R558 VPWR.t8 VPWR.n386 8.47111
R559 VPWR.t8 VPWR.n392 8.47111
R560 VPWR.t8 VPWR.n396 8.47111
R561 VPWR.t8 VPWR.n398 8.47111
R562 VPWR.t8 VPWR.n403 8.47111
R563 VPWR.t8 VPWR.n409 8.47111
R564 VPWR.t8 VPWR.n413 8.47111
R565 VPWR.t8 VPWR.n423 8.47111
R566 VPWR.n135 VPWR.n304 0.173544
R567 VPWR.n136 VPWR.n135 0.137035
R568 VPWR.t8 VPWR.n136 2.72112
R569 VPWR.n36 VPWR.n35 0.0524632
R570 VPWR.n48 VPWR.n113 0.187597
R571 VPWR.t8 VPWR.n373 8.47111
R572 VPWR.t8 VPWR.n307 8.47111
R573 VPWR.t8 VPWR.n310 8.47111
R574 VPWR.t8 VPWR.n312 8.47111
R575 VPWR.t8 VPWR.n315 8.47111
R576 VPWR.t8 VPWR.n356 8.47111
R577 VPWR.t8 VPWR.n353 8.47111
R578 VPWR.t8 VPWR.n348 8.47111
R579 VPWR.t8 VPWR.n343 8.47111
R580 VPWR.t8 VPWR.n321 8.47111
R581 VPWR.t8 VPWR.n323 8.47111
R582 VPWR.t8 VPWR.n325 8.47111
R583 VPWR.t8 VPWR.n327 8.47111
R584 VPWR.n148 VPWR.n338 0.171724
R585 VPWR.t8 VPWR.n149 3.30696
R586 VPWR.t8 VPWR.n1889 8.47111
R587 VPWR.t8 VPWR.n1875 8.47111
R588 VPWR.t8 VPWR.n1881 8.47111
R589 VPWR.t8 VPWR.n115 2.0055
R590 VPWR.t49 VPWR.n1809 8.47111
R591 VPWR.t49 VPWR.n1845 8.47111
R592 VPWR.t49 VPWR.n1812 8.47111
R593 VPWR.t49 VPWR.n1840 8.47111
R594 VPWR.t49 VPWR.n1835 8.47111
R595 VPWR.t49 VPWR.n1816 8.47111
R596 VPWR.t49 VPWR.n1847 8.47111
R597 VPWR.n56 VPWR.n55 0.0597249
R598 VPWR.n55 VPWR.n112 0.128783
R599 VPWR.n6 VPWR.n1850 0.230687
R600 VPWR.n1856 VPWR.t49 8.47111
R601 VPWR.n1861 VPWR.t49 8.47111
R602 VPWR.t49 VPWR.n1821 8.47111
R603 VPWR.t49 VPWR.n85 1.57911
R604 VPWR.n140 VPWR.n82 0.146783
R605 VPWR.t49 VPWR.n141 2.72432
R606 VPWR.t49 VPWR.n1807 8.47111
R607 VPWR.t49 VPWR.n1804 8.47111
R608 VPWR.t49 VPWR.n1736 8.47111
R609 VPWR.t49 VPWR.n1800 8.47111
R610 VPWR.t49 VPWR.n1739 8.47111
R611 VPWR.t49 VPWR.n1742 8.47111
R612 VPWR.t49 VPWR.n1744 8.47111
R613 VPWR.t49 VPWR.n1790 8.47111
R614 VPWR.t49 VPWR.n1747 8.47111
R615 VPWR.t49 VPWR.n1785 8.47111
R616 VPWR.t49 VPWR.n1782 8.47111
R617 VPWR.t49 VPWR.n1750 8.47111
R618 VPWR.n92 VPWR.n91 0.129928
R619 VPWR.t49 VPWR.n1754 8.47111
R620 VPWR.t49 VPWR.n1770 8.47111
R621 VPWR.t49 VPWR.n1757 8.47111
R622 VPWR.t49 VPWR.n1760 8.47111
R623 VPWR.n172 VPWR.t0 2.86688
R624 VPWR.n463 VPWR.t0 8.47111
R625 VPWR.n465 VPWR.t0 8.47111
R626 VPWR.n471 VPWR.t0 8.47111
R627 VPWR.n227 VPWR.t0 4.20591
R628 VPWR.t0 VPWR.n161 4.17662
R629 VPWR.t0 VPWR.n479 8.47111
R630 VPWR.t0 VPWR.n482 8.47111
R631 VPWR.t0 VPWR.n486 8.47111
R632 VPWR.t0 VPWR.n490 8.47111
R633 VPWR.t0 VPWR.n494 8.47111
R634 VPWR.n1728 VPWR.t0 8.47111
R635 VPWR.n1722 VPWR.t0 8.47111
R636 VPWR.n1717 VPWR.t0 8.47111
R637 VPWR.n1715 VPWR.t0 8.47111
R638 VPWR.n1713 VPWR.t0 8.47111
R639 VPWR.n1703 VPWR.t0 8.47111
R640 VPWR.n1696 VPWR.t0 8.47111
R641 VPWR.n1692 VPWR.t0 8.47111
R642 VPWR.n1684 VPWR.n147 0.119672
R643 VPWR.n146 VPWR.t0 3.30696
R644 VPWR.n1679 VPWR.t0 8.47111
R645 VPWR.n1677 VPWR.t0 8.47111
R646 VPWR.n1671 VPWR.t0 8.47111
R647 VPWR.n1669 VPWR.t0 8.47111
R648 VPWR.n1662 VPWR.t0 8.47111
R649 VPWR.n1660 VPWR.t0 8.47111
R650 VPWR.t0 VPWR.n461 8.47111
R651 VPWR.t0 VPWR.n443 8.47111
R652 VPWR.t0 VPWR.n457 8.47111
R653 VPWR.t0 VPWR.n452 8.47111
R654 VPWR.t14 VPWR.n34 0.874897
R655 VPWR.n95 VPWR.n94 0.23201
R656 VPWR.t14 VPWR.n1570 8.47111
R657 VPWR.t14 VPWR.n1574 8.47111
R658 VPWR.n1638 VPWR.t14 8.47111
R659 VPWR.n1640 VPWR.t14 8.47111
R660 VPWR.n1644 VPWR.t14 8.47111
R661 VPWR.n1647 VPWR.n231 0.201868
R662 VPWR.n34 VPWR.n10 0.195429
R663 VPWR.t14 VPWR.n1557 8.47111
R664 VPWR.t14 VPWR.n1552 8.47111
R665 VPWR.t14 VPWR.n1547 8.47111
R666 VPWR.t14 VPWR.n1541 8.47111
R667 VPWR.t14 VPWR.n1536 8.47111
R668 VPWR.t14 VPWR.n1524 8.47111
R669 VPWR.t14 VPWR.n1531 8.47111
R670 VPWR.n1602 VPWR.t14 8.47111
R671 VPWR.n1608 VPWR.t14 8.47111
R672 VPWR.n1616 VPWR.t14 8.47111
R673 VPWR.n1622 VPWR.t14 8.47111
R674 VPWR.n1628 VPWR.t14 8.47111
R675 VPWR.n1630 VPWR.n229 0.201868
R676 VPWR.n1586 VPWR.t14 8.47111
R677 VPWR.t29 VPWR.n520 8.47111
R678 VPWR.t29 VPWR.n526 8.47111
R679 VPWR.t29 VPWR.n530 8.47111
R680 VPWR.t29 VPWR.n532 8.47111
R681 VPWR.t29 VPWR.n538 8.47111
R682 VPWR.t29 VPWR.n556 8.47111
R683 VPWR.t29 VPWR.n561 8.47111
R684 VPWR.t29 VPWR.n567 8.47111
R685 VPWR.t29 VPWR.n47 1.98935
R686 VPWR.t29 VPWR.n504 8.47111
R687 VPWR.t29 VPWR.n509 8.47111
R688 VPWR.n233 VPWR.n507 0.201868
R689 VPWR.n599 VPWR.t29 8.47111
R690 VPWR.n604 VPWR.t29 8.47111
R691 VPWR.n607 VPWR.t29 8.47111
R692 VPWR.n625 VPWR.t29 8.47111
R693 VPWR.n632 VPWR.n143 0.239864
R694 VPWR.n144 VPWR.n143 0.181452
R695 VPWR.n637 VPWR.t29 8.47111
R696 VPWR.n641 VPWR.t29 8.47111
R697 VPWR.n643 VPWR.t29 8.47111
R698 VPWR.n647 VPWR.t29 8.47111
R699 VPWR.n651 VPWR.t29 8.47111
R700 VPWR.n655 VPWR.t29 8.47111
R701 VPWR.n657 VPWR.t29 8.47111
R702 VPWR.n663 VPWR.t29 8.47111
R703 VPWR.n665 VPWR.t29 8.47111
R704 VPWR.n666 VPWR.n232 0.201868
R705 VPWR.t29 VPWR.n592 8.47111
R706 VPWR.t29 VPWR.n576 8.47111
R707 VPWR.t5 VPWR.n1508 8.47111
R708 VPWR.n57 VPWR.n1509 0.209855
R709 VPWR.n1461 VPWR.t5 8.47111
R710 VPWR.n234 VPWR.t5 4.20591
R711 VPWR.t5 VPWR.n1468 8.47111
R712 VPWR.t5 VPWR.n1472 8.47111
R713 VPWR.n104 VPWR.n103 0.18766
R714 VPWR.t5 VPWR.n1485 8.47111
R715 VPWR.t5 VPWR.n1489 8.47111
R716 VPWR.t5 VPWR.n1493 8.47111
R717 VPWR.t5 VPWR.n1497 8.47111
R718 VPWR.t5 VPWR.n1501 8.47111
R719 VPWR.t5 VPWR.n152 2.01742
R720 VPWR.t5 VPWR.n1455 8.47111
R721 VPWR.t5 VPWR.n1450 8.47111
R722 VPWR.t5 VPWR.n1419 8.47111
R723 VPWR.t5 VPWR.n1442 8.47111
R724 VPWR.t5 VPWR.n1439 8.47111
R725 VPWR.t5 VPWR.n1422 8.47111
R726 VPWR.t5 VPWR.n1435 8.47111
R727 VPWR.t5 VPWR.n1425 8.47111
R728 VPWR.n31 VPWR.n30 0.0583167
R729 VPWR.n30 VPWR.n37 0.129813
R730 VPWR.t5 VPWR.n151 3.30662
R731 VPWR.t5 VPWR.n1371 8.47111
R732 VPWR.t5 VPWR.n1375 8.47111
R733 VPWR.t5 VPWR.n1378 8.47111
R734 VPWR.t5 VPWR.n1401 8.47111
R735 VPWR.t5 VPWR.n1396 8.47111
R736 VPWR.t5 VPWR.n1392 8.47111
R737 VPWR.n106 VPWR.n105 0.222233
R738 VPWR.t2 VPWR.n1366 8.47111
R739 VPWR.t2 VPWR.n1337 8.47111
R740 VPWR.t2 VPWR.n682 8.47111
R741 VPWR.t2 VPWR.n1329 8.47111
R742 VPWR.t2 VPWR.n687 8.47111
R743 VPWR.t2 VPWR.n1343 8.47111
R744 VPWR.t2 VPWR.n1345 8.47111
R745 VPWR.t2 VPWR.n1347 8.47111
R746 VPWR.t2 VPWR.n1357 8.47111
R747 VPWR.n1318 VPWR.t2 8.47111
R748 VPWR.n1314 VPWR.t2 8.47111
R749 VPWR.n1306 VPWR.t2 8.47111
R750 VPWR.n1304 VPWR.t2 8.47111
R751 VPWR.n1288 VPWR.t2 8.47111
R752 VPWR.n1284 VPWR.t2 8.47111
R753 VPWR.n1282 VPWR.t2 8.47111
R754 VPWR.n26 VPWR.t2 1.45257
R755 VPWR.n70 VPWR.t2 1.98959
R756 VPWR.n40 VPWR.n41 0.139514
R757 VPWR.n41 VPWR.t2 1.73901
R758 VPWR.n1273 VPWR.n235 0.201868
R759 VPWR.n1266 VPWR.t2 8.47111
R760 VPWR.t2 VPWR.n680 8.47111
R761 VPWR.n131 VPWR.n130 0.0532884
R762 VPWR.n101 VPWR.n100 0.332257
R763 VPWR.t26 VPWR.n1247 8.47111
R764 VPWR.t26 VPWR.n1238 8.47111
R765 VPWR.t26 VPWR.n236 4.20591
R766 VPWR.t26 VPWR.n695 8.47111
R767 VPWR.n164 VPWR.t26 4.17662
R768 VPWR.n1236 VPWR.n2 0.227743
R769 VPWR.n1225 VPWR.t26 8.47111
R770 VPWR.n1221 VPWR.t26 8.47111
R771 VPWR.n1217 VPWR.t26 8.47111
R772 VPWR.n1215 VPWR.t26 8.47111
R773 VPWR.n1198 VPWR.t26 8.47111
R774 VPWR.n721 VPWR.t26 8.47111
R775 VPWR.n717 VPWR.t26 8.47111
R776 VPWR.n715 VPWR.t26 8.47111
R777 VPWR.n711 VPWR.t26 8.47111
R778 VPWR.n705 VPWR.t26 8.47111
R779 VPWR.t21 VPWR.n1159 8.47111
R780 VPWR.t21 VPWR.n1169 8.47111
R781 VPWR.t21 VPWR.n1126 8.47111
R782 VPWR.t21 VPWR.n1130 8.47111
R783 VPWR.t21 VPWR.n1134 8.47111
R784 VPWR.t21 VPWR.n1138 8.47111
R785 VPWR.t21 VPWR.n1142 8.47111
R786 VPWR.t21 VPWR.n1146 8.47111
R787 VPWR.t21 VPWR.n1150 8.47111
R788 VPWR.t21 VPWR.n1152 8.47111
R789 VPWR.t21 VPWR.n1053 8.47111
R790 VPWR.t21 VPWR.n1116 8.47111
R791 VPWR.t21 VPWR.n97 1.43002
R792 VPWR.t21 VPWR.n1056 8.47111
R793 VPWR.t21 VPWR.n1104 8.47111
R794 VPWR.t21 VPWR.n1060 8.47111
R795 VPWR.t21 VPWR.n1095 8.47111
R796 VPWR.t21 VPWR.n1087 8.47111
R797 VPWR.t21 VPWR.n1064 8.47111
R798 VPWR.t21 VPWR.n1066 8.47111
R799 VPWR.t21 VPWR.n1082 8.47111
R800 VPWR.t21 VPWR.n66 1.53036
R801 VPWR.n1074 VPWR.t21 8.47111
R802 VPWR.t21 VPWR.n1051 8.47111
R803 VPWR.t42 VPWR.n998 8.47111
R804 VPWR.t42 VPWR.n1000 8.47111
R805 VPWR.t42 VPWR.n1006 8.47111
R806 VPWR.t42 VPWR.n1026 8.47111
R807 VPWR.t42 VPWR.n746 8.47111
R808 VPWR.t42 VPWR.n748 8.47111
R809 VPWR.t42 VPWR.n819 8.47111
R810 VPWR.t42 VPWR.n754 8.47111
R811 VPWR.t42 VPWR.n814 8.47111
R812 VPWR.t42 VPWR.n811 8.47111
R813 VPWR.t42 VPWR.n807 8.47111
R814 VPWR.t42 VPWR.n758 8.47111
R815 VPWR.t42 VPWR.n62 8.47111
R816 VPWR.t42 VPWR.n761 8.47111
R817 VPWR.t42 VPWR.n794 8.47111
R818 VPWR.t42 VPWR.n767 8.47111
R819 VPWR.t42 VPWR.n769 8.47111
R820 VPWR.t42 VPWR.n789 8.47111
R821 VPWR.t42 VPWR.n783 8.47111
R822 VPWR.t42 VPWR.n773 8.47111
R823 VPWR.t42 VPWR.n778 8.47111
R824 VPWR.t42 VPWR.n744 8.47111
R825 VPWR.t42 VPWR.n740 8.47111
R826 VPWR.t42 VPWR.n735 8.47111
R827 VPWR.t39 VPWR.n221 4.23889
R828 VPWR.t39 VPWR.n932 8.47111
R829 VPWR.t39 VPWR.n936 8.47111
R830 VPWR.t39 VPWR.n944 8.47111
R831 VPWR.t39 VPWR.n950 8.47111
R832 VPWR.t39 VPWR.n952 8.47111
R833 VPWR.t39 VPWR.n956 8.47111
R834 VPWR.t39 VPWR.n960 8.47111
R835 VPWR.t39 VPWR.n964 8.47111
R836 VPWR.t39 VPWR.n968 8.47111
R837 VPWR.t39 VPWR.n970 8.47111
R838 VPWR.t39 VPWR.n976 8.47111
R839 VPWR.t39 VPWR.n980 8.47111
R840 VPWR.n93 VPWR.n981 0.200646
R841 VPWR.t39 VPWR.n827 8.47111
R842 VPWR.t39 VPWR.n908 8.47111
R843 VPWR.t39 VPWR.n831 8.47111
R844 VPWR.n204 VPWR.n832 0.173745
R845 VPWR.t39 VPWR.n834 8.47111
R846 VPWR.t39 VPWR.n108 1.58899
R847 VPWR.t39 VPWR.n836 8.47111
R848 VPWR.t39 VPWR.n840 8.47111
R849 VPWR.n134 VPWR.n133 0.0718655
R850 VPWR.t39 VPWR.n892 8.47111
R851 VPWR.n54 VPWR.n53 0.0597249
R852 VPWR.n53 VPWR.n111 0.128783
R853 VPWR.t39 VPWR.n890 8.47111
R854 VPWR.t39 VPWR.n842 8.47111
R855 VPWR.t39 VPWR.n885 8.47111
R856 VPWR.t39 VPWR.n846 8.47111
R857 VPWR.t39 VPWR.n872 8.47111
R858 VPWR.t39 VPWR.n852 8.47111
R859 VPWR.t39 VPWR.n854 8.47111
R860 VPWR.t39 VPWR.n925 8.47111
R861 VPWR.t39 VPWR.n920 8.47111
R862 VPWR.n1808 VPWR.t1522 7.62628
R863 VPWR.n1654 VPWR.t1533 7.62628
R864 VPWR.n1653 VPWR.t1532 7.62628
R865 VPWR.n10 VPWR.t1541 7.62628
R866 VPWR.n208 VPWR.t1555 7.62628
R867 VPWR.n602 VPWR.t1554 7.62628
R868 VPWR.n57 VPWR.t1562 7.62628
R869 VPWR.n1408 VPWR.t1565 7.62628
R870 VPWR.n26 VPWR.t1575 7.62628
R871 VPWR.n129 VPWR.t1584 7.62628
R872 VPWR.n118 VPWR.t1588 7.62628
R873 VPWR.t26 VPWR.t1587 7.62628
R874 VPWR.n699 VPWR.t1583 7.62628
R875 VPWR.n99 VPWR.t1581 7.62628
R876 VPWR.n214 VPWR.t1613 7.62628
R877 VPWR.n93 VPWR.t1611 7.62628
R878 VPWR.n1655 VPWR.t1538 7.62594
R879 VPWR.n18 VPWR.t1537 7.62594
R880 VPWR.n594 VPWR.t1559 7.62594
R881 VPWR.n1445 VPWR.t1571 7.62594
R882 VPWR.n211 VPWR.t1570 7.62594
R883 VPWR.n155 VPWR.t1602 7.62594
R884 VPWR.n121 VPWR.t1601 7.62594
R885 VPWR.n124 VPWR.t1600 7.62594
R886 VPWR.n96 VPWR.t1599 7.62594
R887 VPWR.n1110 VPWR.t1598 7.62594
R888 VPWR.t49 VPWR.t642 6.13684
R889 VPWR.n620 VPWR.t787 6.13684
R890 VPWR.n1206 VPWR.t886 6.13684
R891 VPWR.n364 VPWR.t355 6.1364
R892 VPWR.n1556 VPWR.t314 6.1364
R893 VPWR.n29 VPWR.t302 6.03136
R894 VPWR.n23 VPWR.t396 6.03136
R895 VPWR.n1331 VPWR.t840 6.03136
R896 VPWR.n1224 VPWR.t313 6.03136
R897 VPWR.n1176 VPWR.t734 6.03136
R898 VPWR.n796 VPWR.t1227 6.03136
R899 VPWR.n1 VPWR.t1273 6.03136
R900 VPWR.n335 VPWR.t286 6.03092
R901 VPWR.n127 VPWR.t714 6.03092
R902 VPWR.n421 VPWR.t301 6.03092
R903 VPWR.n1702 VPWR.t923 6.03092
R904 VPWR.n1629 VPWR.t924 6.03092
R905 VPWR.n10 VPWR.t331 6.03092
R906 VPWR.n562 VPWR.t303 6.03092
R907 VPWR.n690 VPWR.t616 6.03092
R908 VPWR.n1260 VPWR.t965 6.03092
R909 VPWR.n1174 VPWR.t359 6.03092
R910 VPWR.n176 VPWR.t696 6.02433
R911 VPWR.n516 VPWR.t505 6.02395
R912 VPWR.n1599 VPWR.t1086 5.99916
R913 VPWR.n1649 VPWR.t486 5.99916
R914 VPWR.t26 VPWR.t1197 5.99916
R915 VPWR.n162 VPWR.t597 5.99916
R916 VPWR.n159 VPWR.t1422 5.99872
R917 VPWR.n596 VPWR.t465 5.99872
R918 VPWR.n1428 VPWR.t384 5.99872
R919 VPWR.t26 VPWR.t1187 5.99872
R920 VPWR.n1242 VPWR.t945 5.99872
R921 VPWR.n1446 VPWR.t1041 5.99801
R922 VPWR.n15 VPWR.t195 5.99428
R923 VPWR.n990 VPWR.t1476 5.99428
R924 VPWR.n1684 VPWR.t967 5.99166
R925 VPWR.n18 VPWR.t889 5.99166
R926 VPWR.n122 VPWR.t605 5.99166
R927 VPWR.n125 VPWR.t913 5.99166
R928 VPWR.n82 VPWR.t995 5.99122
R929 VPWR.n209 VPWR.t340 5.99122
R930 VPWR.n1409 VPWR.t955 5.99122
R931 VPWR.n26 VPWR.t442 5.99122
R932 VPWR.t26 VPWR.t416 5.99122
R933 VPWR.n178 VPWR.t1259 5.99122
R934 VPWR.n100 VPWR.t578 5.99122
R935 VPWR.n93 VPWR.t688 5.99122
R936 VPWR.n608 VPWR.t836 5.98829
R937 VPWR.n612 VPWR.t824 5.98829
R938 VPWR.n38 VPWR.t865 5.98786
R939 VPWR.n38 VPWR.t1340 5.98786
R940 VPWR.n1296 VPWR.t1131 5.9846
R941 VPWR.n114 VPWR.t763 5.98427
R942 VPWR.n448 VPWR.t1325 5.98023
R943 VPWR.n203 VPWR.t1107 5.97212
R944 VPWR.n210 VPWR.t823 5.97212
R945 VPWR.n616 VPWR.t827 5.97169
R946 VPWR.n203 VPWR.t1108 5.97169
R947 VPWR.n1285 VPWR.t1106 5.97169
R948 VPWR.n140 VPWR.t66 5.97001
R949 VPWR.n84 VPWR.t69 5.97001
R950 VPWR.n1699 VPWR.t247 5.97001
R951 VPWR.n1716 VPWR.t899 5.97001
R952 VPWR.n1704 VPWR.t19 5.97001
R953 VPWR.n1721 VPWR.t902 5.97001
R954 VPWR.n10 VPWR.t117 5.97001
R955 VPWR.n10 VPWR.t186 5.97001
R956 VPWR.n636 VPWR.t207 5.97001
R957 VPWR.n206 VPWR.t210 5.97001
R958 VPWR.n606 VPWR.t246 5.97001
R959 VPWR.n600 VPWR.t31 5.97001
R960 VPWR.n1509 VPWR.t36 5.97001
R961 VPWR.n1377 VPWR.t125 5.97001
R962 VPWR.n1410 VPWR.t128 5.97001
R963 VPWR.n158 VPWR.t251 5.97001
R964 VPWR.n26 VPWR.t110 5.97001
R965 VPWR.n26 VPWR.t214 5.97001
R966 VPWR.n130 VPWR.t167 5.97001
R967 VPWR.n119 VPWR.t32 5.97001
R968 VPWR.n1234 VPWR.t237 5.97001
R969 VPWR.n1193 VPWR.t28 5.97001
R970 VPWR.t26 VPWR.t46 5.97001
R971 VPWR.n696 VPWR.t171 5.97001
R972 VPWR.n694 VPWR.t170 5.97001
R973 VPWR.n153 VPWR.t174 5.97001
R974 VPWR.n1248 VPWR.t129 5.97001
R975 VPWR.n100 VPWR.t132 5.97001
R976 VPWR.n897 VPWR.t72 5.97001
R977 VPWR.n205 VPWR.t75 5.97001
R978 VPWR.n93 VPWR.t163 5.97001
R979 VPWR.n981 VPWR.t166 5.97001
R980 VPWR.n147 VPWR.t90 5.96957
R981 VPWR.n1687 VPWR.t93 5.96957
R982 VPWR.n1729 VPWR.t198 5.96957
R983 VPWR.n18 VPWR.t25 5.96957
R984 VPWR.n144 VPWR.t114 5.96957
R985 VPWR.n629 VPWR.t61 5.96957
R986 VPWR.n1420 VPWR.t205 5.96957
R987 VPWR.n1448 VPWR.t230 5.96957
R988 VPWR.n1449 VPWR.t231 5.96957
R989 VPWR.n24 VPWR.t234 5.96957
R990 VPWR.n1094 VPWR.t144 5.96957
R991 VPWR.n1061 VPWR.t103 5.96957
R992 VPWR.n122 VPWR.t149 5.96957
R993 VPWR.n1099 VPWR.t152 5.96957
R994 VPWR.n125 VPWR.t201 5.96957
R995 VPWR.n1109 VPWR.t116 5.96957
R996 VPWR.n96 VPWR.t1256 5.96957
R997 VPWR.n96 VPWR.t730 5.96957
R998 VPWR.n96 VPWR.t193 5.96957
R999 VPWR.n1114 VPWR.t95 5.96957
R1000 VPWR.n179 VPWR.t1158 5.96578
R1001 VPWR.n1937 VPWR.t740 5.96578
R1002 VPWR.n1931 VPWR.t1394 5.96578
R1003 VPWR.n1929 VPWR.t1496 5.96578
R1004 VPWR.n1926 VPWR.t613 5.96578
R1005 VPWR.n1921 VPWR.t1226 5.96578
R1006 VPWR.n1918 VPWR.t1499 5.96578
R1007 VPWR.n1914 VPWR.t639 5.96578
R1008 VPWR.n1911 VPWR.t767 5.96578
R1009 VPWR.n1908 VPWR.t747 5.96578
R1010 VPWR.n1905 VPWR.t436 5.96578
R1011 VPWR.n249 VPWR.t525 5.96578
R1012 VPWR.n1900 VPWR.t1174 5.96578
R1013 VPWR.n1898 VPWR.t1155 5.96578
R1014 VPWR.n1895 VPWR.t273 5.96578
R1015 VPWR.n1892 VPWR.t1189 5.96578
R1016 VPWR.n252 VPWR.t706 5.96578
R1017 VPWR.n1910 VPWR.t421 5.96578
R1018 VPWR.n1923 VPWR.t1167 5.96578
R1019 VPWR.n1924 VPWR.t1157 5.96578
R1020 VPWR.n298 VPWR.t1282 5.96578
R1021 VPWR.n293 VPWR.t1284 5.96578
R1022 VPWR.n284 VPWR.t650 5.96578
R1023 VPWR.n281 VPWR.t1287 5.96578
R1024 VPWR.n61 VPWR.t693 5.96578
R1025 VPWR.n61 VPWR.t1171 5.96578
R1026 VPWR.n60 VPWR.t1361 5.96578
R1027 VPWR.n278 VPWR.t1498 5.96578
R1028 VPWR.n274 VPWR.t764 5.96578
R1029 VPWR.n272 VPWR.t413 5.96578
R1030 VPWR.n295 VPWR.t434 5.96578
R1031 VPWR.n297 VPWR.t1462 5.96578
R1032 VPWR.n430 VPWR.t739 5.96578
R1033 VPWR.n1885 VPWR.t619 5.96578
R1034 VPWR.n1883 VPWR.t731 5.96578
R1035 VPWR.n1880 VPWR.t737 5.96578
R1036 VPWR.n114 VPWR.t1301 5.96578
R1037 VPWR.n114 VPWR.t1393 5.96578
R1038 VPWR.n304 VPWR.t328 5.96578
R1039 VPWR.n135 VPWR.t497 5.96578
R1040 VPWR.n305 VPWR.t1509 5.96578
R1041 VPWR.n48 VPWR.t450 5.96578
R1042 VPWR.n113 VPWR.t443 5.96578
R1043 VPWR.n113 VPWR.t652 5.96578
R1044 VPWR.n371 VPWR.t560 5.96578
R1045 VPWR.n366 VPWR.t1221 5.96578
R1046 VPWR.n308 VPWR.t319 5.96578
R1047 VPWR.n363 VPWR.t566 5.96578
R1048 VPWR.n311 VPWR.t1440 5.96578
R1049 VPWR.n361 VPWR.t808 5.96578
R1050 VPWR.n360 VPWR.t877 5.96578
R1051 VPWR.n358 VPWR.t410 5.96578
R1052 VPWR.n357 VPWR.t1306 5.96578
R1053 VPWR.n354 VPWR.t847 5.96578
R1054 VPWR.n127 VPWR.t715 5.96578
R1055 VPWR.n127 VPWR.t620 5.96578
R1056 VPWR.n351 VPWR.t1470 5.96578
R1057 VPWR.n344 VPWR.t1461 5.96578
R1058 VPWR.n342 VPWR.t720 5.96578
R1059 VPWR.n339 VPWR.t625 5.96578
R1060 VPWR.n324 VPWR.t285 5.96578
R1061 VPWR.n326 VPWR.t1454 5.96578
R1062 VPWR.n338 VPWR.t803 5.96578
R1063 VPWR.n148 VPWR.t728 5.96578
R1064 VPWR.n330 VPWR.t423 5.96578
R1065 VPWR.n336 VPWR.t1177 5.96578
R1066 VPWR.n334 VPWR.t1205 5.96578
R1067 VPWR.n347 VPWR.t1121 5.96578
R1068 VPWR.n404 VPWR.t1159 5.96578
R1069 VPWR.n408 VPWR.t1432 5.96578
R1070 VPWR.n410 VPWR.t701 5.96578
R1071 VPWR.n414 VPWR.t1396 5.96578
R1072 VPWR.n416 VPWR.t1358 5.96578
R1073 VPWR.n419 VPWR.t1328 5.96578
R1074 VPWR.n422 VPWR.t762 5.96578
R1075 VPWR.n424 VPWR.t1146 5.96578
R1076 VPWR.n107 VPWR.t546 5.96578
R1077 VPWR.n107 VPWR.t457 5.96578
R1078 VPWR.n379 VPWR.t565 5.96578
R1079 VPWR.n383 VPWR.t694 5.96578
R1080 VPWR.n387 VPWR.t685 5.96578
R1081 VPWR.n391 VPWR.t732 5.96578
R1082 VPWR.n395 VPWR.t659 5.96578
R1083 VPWR.n399 VPWR.t1360 5.96578
R1084 VPWR.n375 VPWR.t1506 5.96578
R1085 VPWR.n1844 VPWR.t1293 5.96578
R1086 VPWR.n1843 VPWR.t1355 5.96578
R1087 VPWR.n1836 VPWR.t937 5.96578
R1088 VPWR.n1833 VPWR.t547 5.96578
R1089 VPWR.n1817 VPWR.t412 5.96578
R1090 VPWR.n1820 VPWR.t817 5.96578
R1091 VPWR.n1838 VPWR.t536 5.96578
R1092 VPWR.n1839 VPWR.t1402 5.96578
R1093 VPWR.n1813 VPWR.t845 5.96578
R1094 VPWR.n1769 VPWR.t716 5.96578
R1095 VPWR.n1766 VPWR.t1294 5.96578
R1096 VPWR.n1764 VPWR.t1168 5.96578
R1097 VPWR.n1761 VPWR.t415 5.96578
R1098 VPWR.n140 VPWR.t1427 5.96578
R1099 VPWR.n1806 VPWR.t679 5.96578
R1100 VPWR.n1803 VPWR.t1357 5.96578
R1101 VPWR.n1737 VPWR.t1485 5.96578
R1102 VPWR.n1798 VPWR.t279 5.96578
R1103 VPWR.n1740 VPWR.t264 5.96578
R1104 VPWR.n182 VPWR.t365 5.96578
R1105 VPWR.n1791 VPWR.t1163 5.96578
R1106 VPWR.n1743 VPWR.t1286 5.96578
R1107 VPWR.n1789 VPWR.t623 5.96578
R1108 VPWR.n1786 VPWR.t1420 5.96578
R1109 VPWR.n1751 VPWR.t1304 5.96578
R1110 VPWR.n1826 VPWR.t807 5.96578
R1111 VPWR.n28 VPWR.t1497 5.96578
R1112 VPWR.n1852 VPWR.t1486 5.96578
R1113 VPWR.n112 VPWR.t1424 5.96578
R1114 VPWR.n112 VPWR.t1482 5.96578
R1115 VPWR.n185 VPWR.t890 5.96578
R1116 VPWR.n184 VPWR.t409 5.96578
R1117 VPWR.n6 VPWR.t269 5.97548
R1118 VPWR.t49 VPWR.t1299 5.96578
R1119 VPWR.n460 VPWR.t600 5.96578
R1120 VPWR.n444 VPWR.t778 5.96578
R1121 VPWR.n453 VPWR.t259 5.96578
R1122 VPWR.n449 VPWR.t957 5.96578
R1123 VPWR.n455 VPWR.t915 5.96578
R1124 VPWR.n1659 VPWR.t1314 5.96578
R1125 VPWR.n147 VPWR.t777 5.96578
R1126 VPWR.n1682 VPWR.t710 5.96578
R1127 VPWR.n1678 VPWR.t875 5.96578
R1128 VPWR.n1676 VPWR.t656 5.96578
R1129 VPWR.n1670 VPWR.t1029 5.96578
R1130 VPWR.n1666 VPWR.t1208 5.96578
R1131 VPWR.n76 VPWR.t774 5.96578
R1132 VPWR.n76 VPWR.t1319 5.96578
R1133 VPWR.n74 VPWR.t1317 5.96578
R1134 VPWR.n1672 VPWR.t1034 5.96578
R1135 VPWR.n1693 VPWR.t1323 5.96578
R1136 VPWR.n1689 VPWR.t914 5.96578
R1137 VPWR.n1686 VPWR.t946 5.96578
R1138 VPWR.n1697 VPWR.t779 5.96578
R1139 VPWR.n1714 VPWR.t857 5.96578
R1140 VPWR.n1710 VPWR.t1032 5.96578
R1141 VPWR.n1708 VPWR.t1442 5.96578
R1142 VPWR.n17 VPWR.t994 5.96578
R1143 VPWR.n16 VPWR.t756 5.96578
R1144 VPWR.n18 VPWR.t781 5.96578
R1145 VPWR.n18 VPWR.t1364 5.96578
R1146 VPWR.n18 VPWR.t917 5.96578
R1147 VPWR.n476 VPWR.t776 5.96578
R1148 VPWR.n480 VPWR.t403 5.96578
R1149 VPWR.n32 VPWR.t604 5.96578
R1150 VPWR.n32 VPWR.t594 5.96578
R1151 VPWR.n485 VPWR.t796 5.96578
R1152 VPWR.n493 VPWR.t477 5.96578
R1153 VPWR.n497 VPWR.t1085 5.96578
R1154 VPWR.n501 VPWR.t405 5.96578
R1155 VPWR.n499 VPWR.t609 5.96578
R1156 VPWR.n489 VPWR.t389 5.96578
R1157 VPWR.n487 VPWR.t1253 5.96578
R1158 VPWR.n481 VPWR.t317 5.96578
R1159 VPWR.n468 VPWR.t614 5.96578
R1160 VPWR.n472 VPWR.t1316 5.96578
R1161 VPWR.n470 VPWR.t850 5.96578
R1162 VPWR.n10 VPWR.t1092 5.96578
R1163 VPWR.n94 VPWR.t591 5.96578
R1164 VPWR.n94 VPWR.t353 5.96578
R1165 VPWR.n1571 VPWR.t431 5.96578
R1166 VPWR.n1577 VPWR.t520 5.96578
R1167 VPWR.n8 VPWR.t1510 5.96578
R1168 VPWR.n1575 VPWR.t974 5.96578
R1169 VPWR.n1569 VPWR.t832 5.96578
R1170 VPWR.n1567 VPWR.t537 5.96578
R1171 VPWR.n73 VPWR.t1073 5.96578
R1172 VPWR.n73 VPWR.t1110 5.96578
R1173 VPWR.n71 VPWR.t985 5.96578
R1174 VPWR.n1589 VPWR.t654 5.96578
R1175 VPWR.n1594 VPWR.t653 5.96578
R1176 VPWR.n1611 VPWR.t398 5.96578
R1177 VPWR.n1615 VPWR.t510 5.96578
R1178 VPWR.n1619 VPWR.t583 5.96578
R1179 VPWR.n1623 VPWR.t1347 5.96578
R1180 VPWR.n1625 VPWR.t918 5.96578
R1181 VPWR.n77 VPWR.t381 5.96578
R1182 VPWR.n77 VPWR.t503 5.96578
R1183 VPWR.n1627 VPWR.t577 5.96578
R1184 VPWR.n1630 VPWR.t971 5.96578
R1185 VPWR.n1542 VPWR.t513 5.96578
R1186 VPWR.n1539 VPWR.t1069 5.96578
R1187 VPWR.n1535 VPWR.t786 5.96578
R1188 VPWR.n1525 VPWR.t1008 5.96578
R1189 VPWR.n1527 VPWR.t326 5.96578
R1190 VPWR.n1532 VPWR.t571 5.96578
R1191 VPWR.n8 VPWR.t820 5.96578
R1192 VPWR.n1561 VPWR.t958 5.96578
R1193 VPWR.n1558 VPWR.t942 5.96578
R1194 VPWR.n1555 VPWR.t1102 5.96578
R1195 VPWR.n1553 VPWR.t961 5.96578
R1196 VPWR.n1550 VPWR.t979 5.96578
R1197 VPWR.n1546 VPWR.t1080 5.96578
R1198 VPWR.n1548 VPWR.t944 5.96578
R1199 VPWR.n1562 VPWR.t1487 5.96578
R1200 VPWR.n1564 VPWR.t1001 5.96578
R1201 VPWR.n1565 VPWR.t1202 5.96578
R1202 VPWR.n166 VPWR.t1113 5.96578
R1203 VPWR.n1639 VPWR.t941 5.96578
R1204 VPWR.n1643 VPWR.t848 5.96578
R1205 VPWR.n1647 VPWR.t1045 5.96578
R1206 VPWR.n519 VPWR.t1127 5.96578
R1207 VPWR.n523 VPWR.t953 5.96578
R1208 VPWR.n527 VPWR.t1185 5.96578
R1209 VPWR.n531 VPWR.t595 5.96578
R1210 VPWR.n535 VPWR.t771 5.96578
R1211 VPWR.n541 VPWR.t1057 5.96578
R1212 VPWR.n543 VPWR.t1123 5.96578
R1213 VPWR.n548 VPWR.t332 5.96578
R1214 VPWR.n550 VPWR.t585 5.96578
R1215 VPWR.n552 VPWR.t928 5.96578
R1216 VPWR.n555 VPWR.t350 5.96578
R1217 VPWR.n557 VPWR.t1120 5.96578
R1218 VPWR.n560 VPWR.t1098 5.96578
R1219 VPWR.n564 VPWR.t921 5.96578
R1220 VPWR.n568 VPWR.t975 5.96578
R1221 VPWR.n572 VPWR.t1042 5.96578
R1222 VPWR.n566 VPWR.t488 5.96578
R1223 VPWR.n545 VPWR.t1059 5.96578
R1224 VPWR.n537 VPWR.t1389 5.96578
R1225 VPWR.n590 VPWR.t1406 5.96578
R1226 VPWR.n585 VPWR.t1018 5.96578
R1227 VPWR.n580 VPWR.t1062 5.96578
R1228 VPWR.n582 VPWR.t1036 5.96578
R1229 VPWR.n586 VPWR.t1175 5.96578
R1230 VPWR.n577 VPWR.t1014 5.96578
R1231 VPWR.n666 VPWR.t530 5.96578
R1232 VPWR.n640 VPWR.t369 5.96578
R1233 VPWR.n642 VPWR.t352 5.96578
R1234 VPWR.n646 VPWR.t592 5.96578
R1235 VPWR.n650 VPWR.t939 5.96578
R1236 VPWR.n654 VPWR.t492 5.96578
R1237 VPWR.n658 VPWR.t1013 5.96578
R1238 VPWR.n614 VPWR.t956 5.96578
R1239 VPWR.n618 VPWR.t401 5.96578
R1240 VPWR.n513 VPWR.t943 5.96578
R1241 VPWR.n511 VPWR.t883 5.96578
R1242 VPWR.n508 VPWR.t453 5.96578
R1243 VPWR.n1393 VPWR.t1047 5.96578
R1244 VPWR.n1389 VPWR.t1326 5.96578
R1245 VPWR.n1387 VPWR.t428 5.96578
R1246 VPWR.n105 VPWR.t748 5.96578
R1247 VPWR.n1395 VPWR.t1099 5.96578
R1248 VPWR.n1399 VPWR.t719 5.96578
R1249 VPWR.n1406 VPWR.t1220 5.96578
R1250 VPWR.n150 VPWR.t1037 5.96578
R1251 VPWR.n1415 VPWR.t968 5.96578
R1252 VPWR.n1412 VPWR.t1009 5.96578
R1253 VPWR.n1426 VPWR.t1078 5.96578
R1254 VPWR.n37 VPWR.t1251 5.96578
R1255 VPWR.n37 VPWR.t1128 5.96578
R1256 VPWR.n1429 VPWR.t930 5.96578
R1257 VPWR.n1441 VPWR.t746 5.96578
R1258 VPWR.n1440 VPWR.t1133 5.96578
R1259 VPWR.n1436 VPWR.t1060 5.96578
R1260 VPWR.n24 VPWR.t517 5.96578
R1261 VPWR.n24 VPWR.t780 5.96578
R1262 VPWR.n24 VPWR.t962 5.96578
R1263 VPWR.n1453 VPWR.t795 5.96578
R1264 VPWR.n1454 VPWR.t382 5.96578
R1265 VPWR.n1466 VPWR.t929 5.96578
R1266 VPWR.n1471 VPWR.t1097 5.96578
R1267 VPWR.n1475 VPWR.t1193 5.96578
R1268 VPWR.n103 VPWR.t1423 5.96578
R1269 VPWR.n103 VPWR.t344 5.96578
R1270 VPWR.n189 VPWR.t519 5.96578
R1271 VPWR.n188 VPWR.t515 5.96578
R1272 VPWR.n1482 VPWR.t257 5.96578
R1273 VPWR.n1486 VPWR.t433 5.96578
R1274 VPWR.n1490 VPWR.t1035 5.96578
R1275 VPWR.n1494 VPWR.t1150 5.96578
R1276 VPWR.n1498 VPWR.t1362 5.96578
R1277 VPWR.n1502 VPWR.t1094 5.96578
R1278 VPWR.n1480 VPWR.t368 5.96578
R1279 VPWR.n1477 VPWR.t260 5.96578
R1280 VPWR.n1462 VPWR.t1126 5.96578
R1281 VPWR.n1460 VPWR.t1026 5.96578
R1282 VPWR.n1365 VPWR.t983 5.96578
R1283 VPWR.n1333 VPWR.t1504 5.96578
R1284 VPWR.n1322 VPWR.t584 5.96578
R1285 VPWR.n1321 VPWR.t1058 5.96578
R1286 VPWR.n1336 VPWR.t1119 5.96578
R1287 VPWR.n220 VPWR.t1198 5.98023
R1288 VPWR.n1340 VPWR.t1087 5.96578
R1289 VPWR.n1344 VPWR.t277 5.96578
R1290 VPWR.n1346 VPWR.t458 5.96578
R1291 VPWR.n1350 VPWR.t851 5.96578
R1292 VPWR.n1356 VPWR.t775 5.96578
R1293 VPWR.n1360 VPWR.t523 5.96578
R1294 VPWR.n679 VPWR.t1088 5.96578
R1295 VPWR.n59 VPWR.t404 5.96578
R1296 VPWR.n59 VPWR.t784 5.96578
R1297 VPWR.n675 VPWR.t999 5.96578
R1298 VPWR.n672 VPWR.t1129 5.96578
R1299 VPWR.n674 VPWR.t1443 5.96578
R1300 VPWR.n50 VPWR.t491 5.96578
R1301 VPWR.n1267 VPWR.t1200 5.96578
R1302 VPWR.n1265 VPWR.t666 5.96578
R1303 VPWR.n1262 VPWR.t1070 5.96578
R1304 VPWR.n42 VPWR.t920 5.96578
R1305 VPWR.n25 VPWR.t430 5.96578
R1306 VPWR.n25 VPWR.t1206 5.96578
R1307 VPWR.n69 VPWR.t790 5.96578
R1308 VPWR.n190 VPWR.t555 5.96578
R1309 VPWR.n40 VPWR.t379 5.96578
R1310 VPWR.n40 VPWR.t1147 5.96578
R1311 VPWR.n1273 VPWR.t574 5.96578
R1312 VPWR.n1317 VPWR.t316 5.96578
R1313 VPWR.n1311 VPWR.t278 5.96578
R1314 VPWR.n1309 VPWR.t1502 5.96578
R1315 VPWR.n1305 VPWR.t712 5.96578
R1316 VPWR.n1303 VPWR.t1268 5.96578
R1317 VPWR.n700 VPWR.t833 5.96578
R1318 VPWR.n21 VPWR.t1031 5.96578
R1319 VPWR.n718 VPWR.t529 5.96578
R1320 VPWR.n714 VPWR.t476 5.96578
R1321 VPWR.n710 VPWR.t1148 5.96578
R1322 VPWR.n708 VPWR.t1195 5.96578
R1323 VPWR.n116 VPWR.t989 5.96578
R1324 VPWR.n1218 VPWR.t1077 5.96578
R1325 VPWR.n1216 VPWR.t627 5.96578
R1326 VPWR.n1212 VPWR.t607 5.96578
R1327 VPWR.n1197 VPWR.t925 5.96578
R1328 VPWR.t26 VPWR.t993 5.96578
R1329 VPWR.n163 VPWR.t1124 5.96578
R1330 VPWR.n2 VPWR.t593 5.97846
R1331 VPWR.n21 VPWR.t330 5.96578
R1332 VPWR.n21 VPWR.t1179 5.96578
R1333 VPWR.n67 VPWR.t589 5.96578
R1334 VPWR.n67 VPWR.t634 5.96578
R1335 VPWR.n1246 VPWR.t1105 5.96578
R1336 VPWR.n1243 VPWR.t1068 5.96578
R1337 VPWR.n1239 VPWR.t470 5.96578
R1338 VPWR.n193 VPWR.t268 5.96578
R1339 VPWR.n192 VPWR.t1118 5.96578
R1340 VPWR.n1249 VPWR.t1063 5.96578
R1341 VPWR.n1250 VPWR.t785 5.96578
R1342 VPWR.n1157 VPWR.t558 5.96578
R1343 VPWR.n1160 VPWR.t588 5.96578
R1344 VPWR.n1180 VPWR.t987 5.96578
R1345 VPWR.n1048 VPWR.t844 5.96578
R1346 VPWR.n38 VPWR.t644 5.96578
R1347 VPWR.n38 VPWR.t645 5.96578
R1348 VPWR.n177 VPWR.t1431 5.96578
R1349 VPWR.n1050 VPWR.t843 5.96578
R1350 VPWR.n1073 VPWR.t1222 5.96578
R1351 VPWR.n156 VPWR.t1375 5.96578
R1352 VPWR.n1086 VPWR.t907 5.96578
R1353 VPWR.n1085 VPWR.t481 5.96578
R1354 VPWR.n1065 VPWR.t908 5.96578
R1355 VPWR.n1081 VPWR.t830 5.96578
R1356 VPWR.n1078 VPWR.t831 5.96578
R1357 VPWR.n65 VPWR.t569 5.96578
R1358 VPWR.n65 VPWR.t570 5.96578
R1359 VPWR.n1089 VPWR.t1054 5.96578
R1360 VPWR.n1091 VPWR.t1053 5.96578
R1361 VPWR.n1093 VPWR.t1376 5.96578
R1362 VPWR.n122 VPWR.t606 5.96578
R1363 VPWR.n1096 VPWR.t628 5.96578
R1364 VPWR.n156 VPWR.t630 5.96578
R1365 VPWR.n125 VPWR.t768 5.96578
R1366 VPWR.n1105 VPWR.t1173 5.96578
R1367 VPWR.n1103 VPWR.t534 5.96578
R1368 VPWR.n1100 VPWR.t535 5.96578
R1369 VPWR.n120 VPWR.t765 5.96578
R1370 VPWR.n96 VPWR.t1500 5.96578
R1371 VPWR.n1108 VPWR.t1408 5.96578
R1372 VPWR.n96 VPWR.t375 5.96578
R1373 VPWR.n96 VPWR.t1015 5.96578
R1374 VPWR.n88 VPWR.t408 5.96578
R1375 VPWR.n86 VPWR.t304 5.96578
R1376 VPWR.n1118 VPWR.t689 5.96578
R1377 VPWR.n1115 VPWR.t637 5.96578
R1378 VPWR.n1113 VPWR.t254 5.96578
R1379 VPWR.n1127 VPWR.t485 5.96578
R1380 VPWR.n1131 VPWR.t406 5.96578
R1381 VPWR.n1135 VPWR.t1351 5.96578
R1382 VPWR.n1141 VPWR.t1417 5.96578
R1383 VPWR.n1143 VPWR.t1419 5.96578
R1384 VPWR.n1147 VPWR.t804 5.96578
R1385 VPWR.n1153 VPWR.t1022 5.96578
R1386 VPWR.n1125 VPWR.t587 5.96578
R1387 VPWR.n997 VPWR.t879 5.96578
R1388 VPWR.n1001 VPWR.t1388 5.96578
R1389 VPWR.n1005 VPWR.t437 5.96578
R1390 VPWR.n1027 VPWR.t705 5.96578
R1391 VPWR.n1037 VPWR.t618 5.96578
R1392 VPWR.n1035 VPWR.t435 5.96578
R1393 VPWR.n1033 VPWR.t863 5.96578
R1394 VPWR.n1031 VPWR.t617 5.96578
R1395 VPWR.n1025 VPWR.t1225 5.96578
R1396 VPWR.n1023 VPWR.t704 5.96578
R1397 VPWR.n1021 VPWR.t1337 5.96578
R1398 VPWR.n1019 VPWR.t1336 5.96578
R1399 VPWR.n1017 VPWR.t296 5.96578
R1400 VPWR.n1015 VPWR.t295 5.96578
R1401 VPWR.n1013 VPWR.t445 5.96578
R1402 VPWR.n1011 VPWR.t444 5.96578
R1403 VPWR.n1009 VPWR.t439 5.96578
R1404 VPWR.n995 VPWR.t878 5.96578
R1405 VPWR.n738 VPWR.t1246 5.96578
R1406 VPWR.n734 VPWR.t1229 5.96578
R1407 VPWR.n741 VPWR.t1245 5.96578
R1408 VPWR.n743 VPWR.t1210 5.96578
R1409 VPWR.n1 VPWR.t695 5.96578
R1410 VPWR.n64 VPWR.t335 5.96578
R1411 VPWR.n197 VPWR.t816 5.96578
R1412 VPWR.n793 VPWR.t385 5.96578
R1413 VPWR.n790 VPWR.t386 5.96578
R1414 VPWR.n770 VPWR.t724 5.96578
R1415 VPWR.n787 VPWR.t725 5.96578
R1416 VPWR.n138 VPWR.t551 5.96578
R1417 VPWR.n749 VPWR.t1343 5.96578
R1418 VPWR.n821 VPWR.t1209 5.96578
R1419 VPWR.n752 VPWR.t1344 5.96578
R1420 VPWR.n817 VPWR.t308 5.96578
R1421 VPWR.n755 VPWR.t309 5.96578
R1422 VPWR.n812 VPWR.t1247 5.96578
R1423 VPWR.n808 VPWR.t1248 5.96578
R1424 VPWR.n805 VPWR.t758 5.96578
R1425 VPWR.n759 VPWR.t759 5.96578
R1426 VPWR.n923 VPWR.t622 5.96578
R1427 VPWR.n916 VPWR.t271 5.96578
R1428 VPWR.n918 VPWR.t270 5.96578
R1429 VPWR.n919 VPWR.t469 5.96578
R1430 VPWR.n924 VPWR.t468 5.96578
R1431 VPWR.n926 VPWR.t1368 5.96578
R1432 VPWR.n857 VPWR.t338 5.96578
R1433 VPWR.n133 VPWR.t750 5.96578
R1434 VPWR.n133 VPWR.t1429 5.96578
R1435 VPWR.n891 VPWR.t1430 5.96578
R1436 VPWR.n111 VPWR.t321 5.96578
R1437 VPWR.n111 VPWR.t828 5.96578
R1438 VPWR.n888 VPWR.t322 5.96578
R1439 VPWR.n843 VPWR.t892 5.96578
R1440 VPWR.n883 VPWR.t893 5.96578
R1441 VPWR.n878 VPWR.t310 5.96578
R1442 VPWR.n847 VPWR.t311 5.96578
R1443 VPWR.n875 VPWR.t1370 5.96578
R1444 VPWR.n199 VPWR.t1231 5.96578
R1445 VPWR.n871 VPWR.t1232 5.96578
R1446 VPWR.n868 VPWR.t482 5.96578
R1447 VPWR.n866 VPWR.t483 5.96578
R1448 VPWR.n110 VPWR.t1236 5.96578
R1449 VPWR.n110 VPWR.t1250 5.96578
R1450 VPWR.n835 VPWR.t377 5.96578
R1451 VPWR.n896 VPWR.t1249 5.96578
R1452 VPWR.n826 VPWR.t1216 5.96578
R1453 VPWR.n907 VPWR.t1217 5.96578
R1454 VPWR.n902 VPWR.t1243 5.96578
R1455 VPWR.n900 VPWR.t1244 5.96578
R1456 VPWR.n906 VPWR.t508 5.96578
R1457 VPWR.n988 VPWR.t887 5.96578
R1458 VPWR.n984 VPWR.t849 5.96578
R1459 VPWR.n982 VPWR.t267 5.96578
R1460 VPWR.n221 VPWR.t418 6.02396
R1461 VPWR.n931 VPWR.t1382 5.96578
R1462 VPWR.n933 VPWR.t1383 5.96578
R1463 VPWR.n937 VPWR.t897 5.96578
R1464 VPWR.n943 VPWR.t898 5.96578
R1465 VPWR.n947 VPWR.t1385 5.96578
R1466 VPWR.n953 VPWR.t472 5.96578
R1467 VPWR.n957 VPWR.t810 5.96578
R1468 VPWR.n961 VPWR.t323 5.96578
R1469 VPWR.n965 VPWR.t811 5.96578
R1470 VPWR.n969 VPWR.t680 5.96578
R1471 VPWR.n973 VPWR.t681 5.96578
R1472 VPWR.n977 VPWR.t266 5.96578
R1473 VPWR.n945 VPWR.t1384 5.96578
R1474 VPWR.n1894 VPWR.t718 5.96534
R1475 VPWR.n255 VPWR.t1154 5.96534
R1476 VPWR.n1897 VPWR.t912 5.96534
R1477 VPWR.n252 VPWR.t1390 5.96534
R1478 VPWR.n1902 VPWR.t800 5.96534
R1479 VPWR.n1903 VPWR.t801 5.96534
R1480 VPWR.n1907 VPWR.t449 5.96534
R1481 VPWR.n246 VPWR.t1302 5.96534
R1482 VPWR.n1910 VPWR.t757 5.96534
R1483 VPWR.n1913 VPWR.t1291 5.96534
R1484 VPWR.n1916 VPWR.t1348 5.96534
R1485 VPWR.n1919 VPWR.t265 5.96534
R1486 VPWR.n1923 VPWR.t1458 5.96534
R1487 VPWR.n1924 VPWR.t460 5.96534
R1488 VPWR.n1928 VPWR.t419 5.96534
R1489 VPWR.n1933 VPWR.t425 5.96534
R1490 VPWR.n1935 VPWR.t1298 5.96534
R1491 VPWR.t738 VPWR.t1280 5.96534
R1492 VPWR.n268 VPWR.t948 5.96534
R1493 VPWR.n276 VPWR.t753 5.96534
R1494 VPWR.n279 VPWR.t1495 5.96534
R1495 VPWR.n61 VPWR.t516 5.96534
R1496 VPWR.n61 VPWR.t531 5.96534
R1497 VPWR.n283 VPWR.t733 5.96534
R1498 VPWR.n286 VPWR.t1164 5.96534
R1499 VPWR.n292 VPWR.t1413 5.96534
R1500 VPWR.n295 VPWR.t480 5.96534
R1501 VPWR.n297 VPWR.t1281 5.96534
R1502 VPWR.n261 VPWR.t1162 5.96534
R1503 VPWR.n432 VPWR.t541 5.96534
R1504 VPWR.n114 VPWR.t1414 5.96534
R1505 VPWR.n1879 VPWR.t745 5.96534
R1506 VPWR.n1882 VPWR.t496 5.96534
R1507 VPWR.n1876 VPWR.t1457 5.96534
R1508 VPWR.n1887 VPWR.t287 5.96534
R1509 VPWR.n332 VPWR.t954 5.96534
R1510 VPWR.n341 VPWR.t1398 5.96534
R1511 VPWR.n346 VPWR.t1292 5.96534
R1512 VPWR.n347 VPWR.t1425 5.96534
R1513 VPWR.n349 VPWR.t1295 5.96534
R1514 VPWR.n352 VPWR.t545 5.96534
R1515 VPWR.n369 VPWR.t1169 5.96534
R1516 VPWR.n372 VPWR.t1178 5.96534
R1517 VPWR.n113 VPWR.t1400 5.96534
R1518 VPWR.n35 VPWR.t665 5.96534
R1519 VPWR.n135 VPWR.t1494 5.96534
R1520 VPWR.n135 VPWR.t610 5.96534
R1521 VPWR.n142 VPWR.t1279 5.96534
R1522 VPWR.n397 VPWR.t1490 5.96534
R1523 VPWR.n393 VPWR.t1285 5.96534
R1524 VPWR.n389 VPWR.t422 5.96534
R1525 VPWR.n385 VPWR.t514 5.96534
R1526 VPWR.n381 VPWR.t699 5.96534
R1527 VPWR.n377 VPWR.t1203 5.96534
R1528 VPWR.n375 VPWR.t1412 5.96534
R1529 VPWR.n107 VPWR.t333 5.96534
R1530 VPWR.n1828 VPWR.t1305 5.96534
R1531 VPWR.n1829 VPWR.t1445 5.96534
R1532 VPWR.n1831 VPWR.t1318 5.96534
R1533 VPWR.n1834 VPWR.t1349 5.96534
R1534 VPWR.n1838 VPWR.t399 5.96534
R1535 VPWR.n1839 VPWR.t1481 5.96534
R1536 VPWR.n1813 VPWR.t1025 5.96534
R1537 VPWR.n1841 VPWR.t624 5.96534
R1538 VPWR.n1810 VPWR.t388 5.96534
R1539 VPWR.n1763 VPWR.t697 5.96534
R1540 VPWR.n1758 VPWR.t789 5.96534
R1541 VPWR.n1768 VPWR.t916 5.96534
R1542 VPWR.n1755 VPWR.t698 5.96534
R1543 VPWR.n1733 VPWR.t1322 5.96534
R1544 VPWR.n91 VPWR.t1183 5.96534
R1545 VPWR.n1775 VPWR.t556 5.96534
R1546 VPWR.n1779 VPWR.t394 5.96534
R1547 VPWR.n1783 VPWR.t988 5.96534
R1548 VPWR.n1748 VPWR.t1315 5.96534
R1549 VPWR.n1788 VPWR.t324 5.96534
R1550 VPWR.n1745 VPWR.t788 5.96534
R1551 VPWR.n1792 VPWR.t1207 5.96534
R1552 VPWR.n1794 VPWR.t1439 5.96534
R1553 VPWR.n182 VPWR.t572 5.96534
R1554 VPWR.n1796 VPWR.t493 5.96534
R1555 VPWR.n1799 VPWR.t1320 5.96534
R1556 VPWR.n1801 VPWR.t970 5.96534
R1557 VPWR.n1805 VPWR.t648 5.96534
R1558 VPWR.n1734 VPWR.t334 5.96534
R1559 VPWR.n140 VPWR.t575 5.96534
R1560 VPWR.n84 VPWR.t1324 5.96534
R1561 VPWR.n84 VPWR.t420 5.96534
R1562 VPWR.n28 VPWR.t463 5.96534
R1563 VPWR.n29 VPWR.t1508 5.96534
R1564 VPWR.n1862 VPWR.t262 5.96534
R1565 VPWR.n1859 VPWR.t1033 5.96534
R1566 VPWR.n1857 VPWR.t797 5.96534
R1567 VPWR.n7 VPWR.t440 5.96859
R1568 VPWR.t49 VPWR.t1503 5.96534
R1569 VPWR.t49 VPWR.t1046 5.96534
R1570 VPWR.t49 VPWR.t1289 5.96534
R1571 VPWR.t49 VPWR.t1239 5.96534
R1572 VPWR.t49 VPWR.t691 5.96534
R1573 VPWR.n1850 VPWR.t511 5.96534
R1574 VPWR.n184 VPWR.t320 5.96534
R1575 VPWR.n185 VPWR.t567 5.96534
R1576 VPWR.n112 VPWR.t459 5.96534
R1577 VPWR.n55 VPWR.t1252 5.96534
R1578 VPWR.n1848 VPWR.t709 5.96534
R1579 VPWR.n1853 VPWR.t512 5.96534
R1580 VPWR.n447 VPWR.t997 5.96534
R1581 VPWR.n451 VPWR.t713 5.96534
R1582 VPWR.n455 VPWR.t1258 5.96534
R1583 VPWR.n456 VPWR.t564 5.96534
R1584 VPWR.n458 VPWR.t1100 5.96534
R1585 VPWR.n1657 VPWR.t1003 5.96534
R1586 VPWR.n1665 VPWR.t882 5.96534
R1587 VPWR.n74 VPWR.t1363 5.96534
R1588 VPWR.n76 VPWR.t1095 5.96534
R1589 VPWR.n76 VPWR.t380 5.96534
R1590 VPWR.n1668 VPWR.t1007 5.96534
R1591 VPWR.n1672 VPWR.t506 5.96534
R1592 VPWR.n1674 VPWR.t1428 5.96534
R1593 VPWR.n1680 VPWR.t502 5.96534
R1594 VPWR.n145 VPWR.t315 5.96534
R1595 VPWR.n1691 VPWR.t1311 5.96534
R1596 VPWR.n1695 VPWR.t1114 5.96534
R1597 VPWR.n1697 VPWR.t339 5.96534
R1598 VPWR.n1720 VPWR.t501 5.96534
R1599 VPWR.n1725 VPWR.t1017 5.96534
R1600 VPWR.n18 VPWR.t1140 5.96534
R1601 VPWR.n18 VPWR.t1181 5.96534
R1602 VPWR.n18 VPWR.t1409 5.96534
R1603 VPWR.n11 VPWR.t349 5.96534
R1604 VPWR.n499 VPWR.t539 5.96534
R1605 VPWR.n495 VPWR.t770 5.96534
R1606 VPWR.n491 VPWR.t487 5.96534
R1607 VPWR.n489 VPWR.t1 5.96534
R1608 VPWR.n487 VPWR.t1403 5.96534
R1609 VPWR.n483 VPWR.t682 5.96534
R1610 VPWR.n481 VPWR.t374 5.96534
R1611 VPWR.n32 VPWR.t272 5.96534
R1612 VPWR.n32 VPWR.t263 5.96534
R1613 VPWR.n32 VPWR.t391 5.96534
R1614 VPWR.n478 VPWR.t1310 5.96534
R1615 VPWR.n160 VPWR.t1067 5.96534
R1616 VPWR.n474 VPWR.t1350 5.96534
R1617 VPWR.n470 VPWR.t1345 5.96534
R1618 VPWR.n466 VPWR.t590 5.96534
R1619 VPWR.n462 VPWR.t1321 5.96534
R1620 VPWR.n173 VPWR.t1254 5.96534
R1621 VPWR.n8 VPWR.t631 5.96534
R1622 VPWR.n1579 VPWR.t1091 5.96534
R1623 VPWR.n1575 VPWR.t354 5.96534
R1624 VPWR.n1573 VPWR.t407 5.96534
R1625 VPWR.n1569 VPWR.t1262 5.96534
R1626 VPWR.n1567 VPWR.t387 5.96534
R1627 VPWR.n1585 VPWR.t1255 5.96534
R1628 VPWR.n1587 VPWR.t261 5.96534
R1629 VPWR.n73 VPWR.t950 5.96534
R1630 VPWR.n73 VPWR.t1020 5.96534
R1631 VPWR.n1589 VPWR.t504 5.96534
R1632 VPWR.n1594 VPWR.t1112 5.96534
R1633 VPWR.n1617 VPWR.t395 5.96534
R1634 VPWR.n1613 VPWR.t392 5.96534
R1635 VPWR.n1609 VPWR.t490 5.96534
R1636 VPWR.n1605 VPWR.t641 5.96534
R1637 VPWR.n1529 VPWR.t949 5.96534
R1638 VPWR.n1530 VPWR.t1061 5.96534
R1639 VPWR.n1532 VPWR.t561 5.96534
R1640 VPWR.n1534 VPWR.t870 5.96534
R1641 VPWR.n1537 VPWR.t1199 5.96534
R1642 VPWR.n1546 VPWR.t834 5.96534
R1643 VPWR.n1548 VPWR.t1104 5.96534
R1644 VPWR.n1559 VPWR.t1024 5.96534
R1645 VPWR.n1562 VPWR.t498 5.96534
R1646 VPWR.n1564 VPWR.t1103 5.96534
R1647 VPWR.n1565 VPWR.t885 5.96534
R1648 VPWR.n8 VPWR.t429 5.96534
R1649 VPWR.n8 VPWR.t1019 5.96534
R1650 VPWR.n1647 VPWR.t1004 5.96534
R1651 VPWR.n1645 VPWR.t603 5.96534
R1652 VPWR.n1641 VPWR.t1011 5.96534
R1653 VPWR.n1637 VPWR.t1261 5.96534
R1654 VPWR.n573 VPWR.t959 5.96534
R1655 VPWR.n570 VPWR.t938 5.96534
R1656 VPWR.n566 VPWR.t532 5.96534
R1657 VPWR.n545 VPWR.t1267 5.96534
R1658 VPWR.n539 VPWR.t346 5.96534
R1659 VPWR.n537 VPWR.t1044 5.96534
R1660 VPWR.n533 VPWR.t782 5.96534
R1661 VPWR.n529 VPWR.t559 5.96534
R1662 VPWR.n525 VPWR.t596 5.96534
R1663 VPWR.n521 VPWR.t1139 5.96534
R1664 VPWR.n580 VPWR.t1191 5.96534
R1665 VPWR.n582 VPWR.t255 5.96534
R1666 VPWR.n583 VPWR.t393 5.96534
R1667 VPWR.n586 VPWR.t891 5.96534
R1668 VPWR.n577 VPWR.t664 5.96534
R1669 VPWR.n588 VPWR.t598 5.96534
R1670 VPWR.n666 VPWR.t660 5.96534
R1671 VPWR.n660 VPWR.t1270 5.96534
R1672 VPWR.n656 VPWR.t1005 5.96534
R1673 VPWR.n652 VPWR.t1444 5.96534
R1674 VPWR.n648 VPWR.t347 5.96534
R1675 VPWR.n644 VPWR.t1049 5.96534
R1676 VPWR.n638 VPWR.t542 5.96534
R1677 VPWR.n634 VPWR.t1507 5.96534
R1678 VPWR.n23 VPWR.t977 5.96534
R1679 VPWR.n23 VPWR.t1307 5.96534
R1680 VPWR.n23 VPWR.t580 5.96534
R1681 VPWR.n633 VPWR.t1051 5.96534
R1682 VPWR.n627 VPWR.t626 5.96534
R1683 VPWR.n624 VPWR.t1056 5.96534
R1684 VPWR.n622 VPWR.t809 5.96534
R1685 VPWR.n507 VPWR.t357 5.96534
R1686 VPWR.n505 VPWR.t256 5.96534
R1687 VPWR.n510 VPWR.t1437 5.96534
R1688 VPWR.n515 VPWR.t996 5.96534
R1689 VPWR.n1506 VPWR.t969 5.96534
R1690 VPWR.n105 VPWR.t1367 5.96534
R1691 VPWR.n105 VPWR.t1016 5.96534
R1692 VPWR.n1386 VPWR.t1366 5.96534
R1693 VPWR.n1391 VPWR.t341 5.96534
R1694 VPWR.n1395 VPWR.t1023 5.96534
R1695 VPWR.n1397 VPWR.t524 5.96534
R1696 VPWR.n1379 VPWR.t1012 5.96534
R1697 VPWR.n1376 VPWR.t342 5.96534
R1698 VPWR.n1413 VPWR.t896 5.96534
R1699 VPWR.n1372 VPWR.t586 5.96534
R1700 VPWR.n1417 VPWR.t1111 5.96534
R1701 VPWR.n150 VPWR.t640 5.96534
R1702 VPWR.n37 VPWR.t931 5.96534
R1703 VPWR.n37 VPWR.t1180 5.96534
R1704 VPWR.n30 VPWR.t960 5.96534
R1705 VPWR.n1429 VPWR.t1040 5.96534
R1706 VPWR.n1432 VPWR.t1021 5.96534
R1707 VPWR.n1423 VPWR.t926 5.96534
R1708 VPWR.n1438 VPWR.t940 5.96534
R1709 VPWR.n1443 VPWR.t825 5.96534
R1710 VPWR.n175 VPWR.t1471 5.96534
R1711 VPWR.n24 VPWR.t935 5.96534
R1712 VPWR.n24 VPWR.t933 5.96534
R1713 VPWR.n1451 VPWR.t345 5.96534
R1714 VPWR.n1453 VPWR.t1074 5.96534
R1715 VPWR.n1454 VPWR.t1090 5.96534
R1716 VPWR.n1502 VPWR.t495 5.96534
R1717 VPWR.n1500 VPWR.t1151 5.96534
R1718 VPWR.n1496 VPWR.t991 5.96534
R1719 VPWR.n1492 VPWR.t573 5.96534
R1720 VPWR.n1488 VPWR.t1190 5.96534
R1721 VPWR.n1484 VPWR.t509 5.96534
R1722 VPWR.n1480 VPWR.t1380 5.96534
R1723 VPWR.n188 VPWR.t1075 5.96534
R1724 VPWR.n189 VPWR.t723 5.96534
R1725 VPWR.n103 VPWR.t1130 5.96534
R1726 VPWR.n102 VPWR.t1134 5.96534
R1727 VPWR.n1477 VPWR.t327 5.96534
R1728 VPWR.n1473 VPWR.t367 5.96534
R1729 VPWR.n1469 VPWR.t980 5.96534
R1730 VPWR.n1462 VPWR.t1138 5.96534
R1731 VPWR.n1460 VPWR.t919 5.96534
R1732 VPWR.n1458 VPWR.t1188 5.96534
R1733 VPWR.n1321 VPWR.t602 5.96534
R1734 VPWR.n683 VPWR.t1141 5.96534
R1735 VPWR.n1335 VPWR.t722 5.96534
R1736 VPWR.n1336 VPWR.t1465 5.96534
R1737 VPWR.n1358 VPWR.t635 5.96534
R1738 VPWR.n1354 VPWR.t348 5.96534
R1739 VPWR.n1352 VPWR.t1071 5.96534
R1740 VPWR.n1348 VPWR.t441 5.96534
R1741 VPWR.n672 VPWR.t632 5.96534
R1742 VPWR.n674 VPWR.t1002 5.96534
R1743 VPWR.n58 VPWR.t599 5.96534
R1744 VPWR.n59 VPWR.t581 5.96534
R1745 VPWR.n59 VPWR.t963 5.96534
R1746 VPWR.n677 VPWR.t986 5.96534
R1747 VPWR.n50 VPWR.t822 5.96534
R1748 VPWR.n40 VPWR.t1144 5.96534
R1749 VPWR.n40 VPWR.t1149 5.96534
R1750 VPWR.n190 VPWR.t608 5.96534
R1751 VPWR.n25 VPWR.t312 5.96534
R1752 VPWR.n25 VPWR.t658 5.96534
R1753 VPWR.n26 VPWR.t1308 5.96534
R1754 VPWR.n26 VPWR.t518 5.96534
R1755 VPWR.n1287 VPWR.t1438 5.96534
R1756 VPWR.n1291 VPWR.t794 5.96534
R1757 VPWR.n1294 VPWR.t1064 5.96534
R1758 VPWR.n1296 VPWR.t951 5.96534
R1759 VPWR.n1299 VPWR.t361 5.96534
R1760 VPWR.n1301 VPWR.t1464 5.96534
R1761 VPWR.n1303 VPWR.t1407 5.96534
R1762 VPWR.n1307 VPWR.t1182 5.96534
R1763 VPWR.n1313 VPWR.t615 5.96534
R1764 VPWR.n1315 VPWR.t427 5.96534
R1765 VPWR.n21 VPWR.t364 5.96534
R1766 VPWR.n19 VPWR.t1257 5.96534
R1767 VPWR.n130 VPWR.t1000 5.96534
R1768 VPWR.n704 VPWR.t643 5.96534
R1769 VPWR.n706 VPWR.t1143 5.96534
R1770 VPWR.n712 VPWR.t1264 5.96534
R1771 VPWR.n716 VPWR.t966 5.96534
R1772 VPWR.n720 VPWR.t1122 5.96534
R1773 VPWR.n119 VPWR.t1038 5.96534
R1774 VPWR.n1192 VPWR.t973 5.96534
R1775 VPWR.n1195 VPWR.t1186 5.96534
R1776 VPWR.n1199 VPWR.t1096 5.96534
R1777 VPWR.n1201 VPWR.t1204 5.96534
R1778 VPWR.n1204 VPWR.t998 5.96534
R1779 VPWR.n1208 VPWR.t1125 5.96534
R1780 VPWR.n1210 VPWR.t1048 5.96534
R1781 VPWR.n1214 VPWR.t799 5.96534
R1782 VPWR.n1220 VPWR.t1101 5.96534
R1783 VPWR.n1222 VPWR.t1052 5.96534
R1784 VPWR.n79 VPWR.t549 5.96534
R1785 VPWR.n80 VPWR.t981 5.96534
R1786 VPWR.n80 VPWR.t1415 5.96534
R1787 VPWR.n1227 VPWR.t1115 5.96534
R1788 VPWR.n1229 VPWR.t1010 5.96534
R1789 VPWR.n1231 VPWR.t562 5.96534
R1790 VPWR.n3 VPWR.t461 5.96534
R1791 VPWR.t26 VPWR.t1192 5.96534
R1792 VPWR.t26 VPWR.t881 5.96534
R1793 VPWR.n1236 VPWR.t582 5.96534
R1794 VPWR.n67 VPWR.t992 5.96534
R1795 VPWR.n67 VPWR.t976 5.96534
R1796 VPWR.n21 VPWR.t934 5.96534
R1797 VPWR.n21 VPWR.t1194 5.96534
R1798 VPWR.n130 VPWR.t1265 5.96534
R1799 VPWR.n697 VPWR.t854 5.96534
R1800 VPWR.n153 VPWR.t356 5.96534
R1801 VPWR.n1243 VPWR.t1142 5.96534
R1802 VPWR.n1239 VPWR.t522 5.96534
R1803 VPWR.n1244 VPWR.t366 5.96534
R1804 VPWR.n98 VPWR.t721 5.96534
R1805 VPWR.n100 VPWR.t773 5.96534
R1806 VPWR.n1249 VPWR.t802 5.96534
R1807 VPWR.n1250 VPWR.t521 5.96534
R1808 VPWR.n1252 VPWR.t402 5.96534
R1809 VPWR.n192 VPWR.t526 5.96534
R1810 VPWR.n193 VPWR.t1137 5.96534
R1811 VPWR.n194 VPWR.t494 5.96534
R1812 VPWR.n1180 VPWR.t305 5.96534
R1813 VPWR.n1178 VPWR.t1374 5.96534
R1814 VPWR.n38 VPWR.t876 5.96534
R1815 VPWR.n1050 VPWR.t1333 5.96534
R1816 VPWR.n1071 VPWR.t1329 5.96534
R1817 VPWR.n65 VPWR.t553 5.96534
R1818 VPWR.n65 VPWR.t426 5.96534
R1819 VPWR.n1080 VPWR.t860 5.96534
R1820 VPWR.n1067 VPWR.t552 5.96534
R1821 VPWR.n1083 VPWR.t1447 5.96534
R1822 VPWR.n1088 VPWR.t677 5.96534
R1823 VPWR.n1089 VPWR.t1214 5.96534
R1824 VPWR.n1091 VPWR.t1213 5.96534
R1825 VPWR.n1093 VPWR.t815 5.96534
R1826 VPWR.n1098 VPWR.t1233 5.96534
R1827 VPWR.n1102 VPWR.t293 5.96534
R1828 VPWR.n1057 VPWR.t805 5.96534
R1829 VPWR.n1107 VPWR.t1215 5.96534
R1830 VPWR.n1054 VPWR.t452 5.96534
R1831 VPWR.n1117 VPWR.t451 5.96534
R1832 VPWR.n1120 VPWR.t690 5.96534
R1833 VPWR.n88 VPWR.t861 5.96534
R1834 VPWR.n1151 VPWR.t1346 5.96534
R1835 VPWR.n1149 VPWR.t611 5.96534
R1836 VPWR.n1145 VPWR.t290 5.96534
R1837 VPWR.n1139 VPWR.t1416 5.96534
R1838 VPWR.n1137 VPWR.t669 5.96534
R1839 VPWR.n1133 VPWR.t275 5.96534
R1840 VPWR.n1129 VPWR.t274 5.96534
R1841 VPWR.n1125 VPWR.t856 5.96534
R1842 VPWR.n1123 VPWR.t855 5.96534
R1843 VPWR.n1037 VPWR.t676 5.96534
R1844 VPWR.n1035 VPWR.t675 5.96534
R1845 VPWR.n1033 VPWR.t372 5.96534
R1846 VPWR.n1031 VPWR.t475 5.96534
R1847 VPWR.n1029 VPWR.t371 5.96534
R1848 VPWR.n1025 VPWR.t853 5.96534
R1849 VPWR.n1023 VPWR.t852 5.96534
R1850 VPWR.n1021 VPWR.t363 5.96534
R1851 VPWR.n1019 VPWR.t362 5.96534
R1852 VPWR.n1017 VPWR.t448 5.96534
R1853 VPWR.n1015 VPWR.t447 5.96534
R1854 VPWR.n1013 VPWR.t819 5.96534
R1855 VPWR.n1011 VPWR.t818 5.96534
R1856 VPWR.n1009 VPWR.t417 5.96534
R1857 VPWR.n1007 VPWR.t869 5.96534
R1858 VPWR.n1003 VPWR.t868 5.96534
R1859 VPWR.n999 VPWR.t360 5.96534
R1860 VPWR.n995 VPWR.t1387 5.96534
R1861 VPWR.n731 VPWR.t1224 5.96534
R1862 VPWR.n733 VPWR.t1223 5.96534
R1863 VPWR.n736 VPWR.t292 5.96534
R1864 VPWR.n739 VPWR.t291 5.96534
R1865 VPWR.n741 VPWR.t1354 5.96534
R1866 VPWR.n743 VPWR.t1352 5.96534
R1867 VPWR.n1 VPWR.t337 5.96534
R1868 VPWR.n1 VPWR.t1377 5.96534
R1869 VPWR.n776 VPWR.t1379 5.96534
R1870 VPWR.n774 VPWR.t859 5.96534
R1871 VPWR.n781 VPWR.t1456 5.96534
R1872 VPWR.n782 VPWR.t1455 5.96534
R1873 VPWR.n784 VPWR.t1453 5.96534
R1874 VPWR.n788 VPWR.t1446 5.96534
R1875 VPWR.n768 VPWR.t674 5.96534
R1876 VPWR.n792 VPWR.t673 5.96534
R1877 VPWR.n795 VPWR.t282 5.96534
R1878 VPWR.n197 VPWR.t280 5.96534
R1879 VPWR.n797 VPWR.t678 5.96534
R1880 VPWR.n799 VPWR.t289 5.96534
R1881 VPWR.n800 VPWR.t1356 5.96534
R1882 VPWR.n762 VPWR.t456 5.96534
R1883 VPWR.n760 VPWR.t455 5.96534
R1884 VPWR.n64 VPWR.t1327 5.96534
R1885 VPWR.n803 VPWR.t1342 5.96534
R1886 VPWR.n806 VPWR.t1341 5.96534
R1887 VPWR.n810 VPWR.t378 5.96534
R1888 VPWR.n813 VPWR.t1228 5.96534
R1889 VPWR.n815 VPWR.t692 5.96534
R1890 VPWR.n818 VPWR.t1309 5.96534
R1891 VPWR.n820 VPWR.t872 5.96534
R1892 VPWR.n747 VPWR.t871 5.96534
R1893 VPWR.n745 VPWR.t888 5.96534
R1894 VPWR.n918 VPWR.t284 5.96534
R1895 VPWR.n919 VPWR.t283 5.96534
R1896 VPWR.n921 VPWR.t474 5.96534
R1897 VPWR.n924 VPWR.t473 5.96534
R1898 VPWR.n926 VPWR.t1212 5.96534
R1899 VPWR.n855 VPWR.t621 5.96534
R1900 VPWR.n861 VPWR.t874 5.96534
R1901 VPWR.n865 VPWR.t873 5.96534
R1902 VPWR.n870 VPWR.t752 5.96534
R1903 VPWR.n873 VPWR.t751 5.96534
R1904 VPWR.n199 VPWR.t668 5.96534
R1905 VPWR.n876 VPWR.t667 5.96534
R1906 VPWR.n879 VPWR.t1369 5.96534
R1907 VPWR.n881 VPWR.t672 5.96534
R1908 VPWR.n884 VPWR.t671 5.96534
R1909 VPWR.n886 VPWR.t1452 5.96534
R1910 VPWR.n889 VPWR.t1451 5.96534
R1911 VPWR.n111 VPWR.t684 5.96534
R1912 VPWR.n53 VPWR.t683 5.96534
R1913 VPWR.n132 VPWR.t467 5.96534
R1914 VPWR.n133 VPWR.t466 5.96534
R1915 VPWR.n841 VPWR.t1392 5.96534
R1916 VPWR.n893 VPWR.t1391 5.96534
R1917 VPWR.n109 VPWR.t479 5.96534
R1918 VPWR.n110 VPWR.t478 5.96534
R1919 VPWR.n835 VPWR.t1235 5.96534
R1920 VPWR.n896 VPWR.t528 5.96534
R1921 VPWR.n213 VPWR.t527 5.96534
R1922 VPWR.n832 VPWR.t376 5.96534
R1923 VPWR.n899 VPWR.t1335 5.96534
R1924 VPWR.n904 VPWR.t1334 5.96534
R1925 VPWR.n906 VPWR.t910 5.96534
R1926 VPWR.n828 VPWR.t909 5.96534
R1927 VPWR.n909 VPWR.t484 5.96534
R1928 VPWR.n986 VPWR.t507 5.96534
R1929 VPWR.n984 VPWR.t1411 5.96534
R1930 VPWR.n982 VPWR.t1373 5.96534
R1931 VPWR.n93 VPWR.t1372 5.96534
R1932 VPWR.n979 VPWR.t686 5.96534
R1933 VPWR.n975 VPWR.t1242 5.96534
R1934 VPWR.n971 VPWR.t1241 5.96534
R1935 VPWR.n967 VPWR.t1219 5.96534
R1936 VPWR.n963 VPWR.t1218 5.96534
R1937 VPWR.n959 VPWR.t1460 5.96534
R1938 VPWR.n955 VPWR.t1459 5.96534
R1939 VPWR.n951 VPWR.t1331 5.96534
R1940 VPWR.n949 VPWR.t1330 5.96534
R1941 VPWR.n945 VPWR.t298 5.96534
R1942 VPWR.n941 VPWR.t297 5.96534
R1943 VPWR.n939 VPWR.t471 5.96534
R1944 VPWR.n287 VPWR.t63 5.96091
R1945 VPWR.n259 VPWR.t87 5.96091
R1946 VPWR.n1888 VPWR.t202 5.96091
R1947 VPWR.n142 VPWR.t10 5.96091
R1948 VPWR.n1867 VPWR.t221 5.96091
R1949 VPWR.n91 VPWR.t50 5.96091
R1950 VPWR.n84 VPWR.t70 5.96091
R1951 VPWR.n442 VPWR.t119 5.96091
R1952 VPWR.n1661 VPWR.t199 5.96091
R1953 VPWR.n1723 VPWR.t904 5.96091
R1954 VPWR.n160 VPWR.t235 5.96091
R1955 VPWR.n1591 VPWR.t135 5.96091
R1956 VPWR.n1595 VPWR.t64 5.96091
R1957 VPWR.n1607 VPWR.t89 5.96091
R1958 VPWR.n8 VPWR.t16 5.96091
R1959 VPWR.n10 VPWR.t187 5.96091
R1960 VPWR.n591 VPWR.t96 5.96091
R1961 VPWR.n664 VPWR.t177 5.96091
R1962 VPWR.n598 VPWR.t104 5.96091
R1963 VPWR.n46 VPWR.t107 5.96091
R1964 VPWR.n1507 VPWR.t37 5.96091
R1965 VPWR.n1370 VPWR.t56 5.96091
R1966 VPWR.n200 VPWR.t123 5.96091
R1967 VPWR.n150 VPWR.t189 5.96091
R1968 VPWR.n1431 VPWR.t112 5.96091
R1969 VPWR.n50 VPWR.t3 5.96091
R1970 VPWR.n1269 VPWR.t215 5.96091
R1971 VPWR.n1298 VPWR.t227 5.96091
R1972 VPWR.n1319 VPWR.t145 5.96091
R1973 VPWR.t26 VPWR.t47 5.96091
R1974 VPWR.n21 VPWR.t77 5.96091
R1975 VPWR.n153 VPWR.t175 5.96091
R1976 VPWR.n1047 VPWR.t80 5.96091
R1977 VPWR.n1075 VPWR.t33 5.96091
R1978 VPWR.n88 VPWR.t243 5.96091
R1979 VPWR.n727 VPWR.t181 5.96091
R1980 VPWR.n138 VPWR.t239 5.96091
R1981 VPWR.n927 VPWR.t159 5.96091
R1982 VPWR.n853 VPWR.t217 5.96091
R1983 VPWR.n894 VPWR.t41 5.96091
R1984 VPWR.n259 VPWR.t12 5.96047
R1985 VPWR.n428 VPWR.t225 5.96047
R1986 VPWR.n1888 VPWR.t52 5.96047
R1987 VPWR.n142 VPWR.t224 5.96047
R1988 VPWR.n405 VPWR.t157 5.96047
R1989 VPWR.n1867 VPWR.t196 5.96047
R1990 VPWR.n91 VPWR.t153 5.96047
R1991 VPWR.n1823 VPWR.t905 5.96047
R1992 VPWR.n29 VPWR.t121 5.96047
R1993 VPWR.t49 VPWR.t100 5.96047
R1994 VPWR.n442 VPWR.t137 5.96047
R1995 VPWR.n16 VPWR.t17 5.96047
R1996 VPWR.n1591 VPWR.t98 5.96047
R1997 VPWR.n1595 VPWR.t179 5.96047
R1998 VPWR.n1601 VPWR.t211 5.96047
R1999 VPWR.n1540 VPWR.t54 5.96047
R2000 VPWR.n8 VPWR.t109 5.96047
R2001 VPWR.n166 VPWR.t1479 5.96047
R2002 VPWR.n591 VPWR.t58 5.96047
R2003 VPWR.n46 VPWR.t253 5.96047
R2004 VPWR.n1400 VPWR.t6 5.96047
R2005 VPWR.n158 VPWR.t148 5.96047
R2006 VPWR.n1467 VPWR.t140 5.96047
R2007 VPWR.n1364 VPWR.t133 5.96047
R2008 VPWR.n670 VPWR.t155 5.96047
R2009 VPWR.n1319 VPWR.t78 5.96047
R2010 VPWR.n722 VPWR.t82 5.96047
R2011 VPWR.t26 VPWR.t1466 5.96047
R2012 VPWR.n163 VPWR.t1468 5.96047
R2013 VPWR.n21 VPWR.t245 5.96047
R2014 VPWR.n1158 VPWR.t191 5.96047
R2015 VPWR.n1047 VPWR.t183 5.96047
R2016 VPWR.n1075 VPWR.t22 5.96047
R2017 VPWR.n88 VPWR.t241 5.96047
R2018 VPWR.n727 VPWR.t161 5.96047
R2019 VPWR.n1 VPWR.t219 5.96047
R2020 VPWR.n64 VPWR.t43 5.96047
R2021 VPWR.n138 VPWR.t1478 5.96047
R2022 VPWR.n927 VPWR.t84 5.96047
R2023 VPWR.n910 VPWR.t248 5.96047
R2024 VPWR.n605 VPWR.t489 5.92938
R2025 VPWR.n1281 VPWR.t1501 5.92275
R2026 VPWR.n1289 VPWR.t826 5.9217
R2027 VPWR.n1277 VPWR.t1260 5.91335
R2028 VPWR.t49 VPWR.n1854 5.70407
R2029 VPWR.n1457 VPWR.t5 5.70407
R2030 VPWR.n115 VPWR.n114 0.269739
R2031 VPWR.t49 VPWR.n1762 5.68419
R2032 VPWR.t42 VPWR.n730 5.68419
R2033 VPWR.t39 VPWR.n915 5.68419
R2034 VPWR.n1808 VPWR.t67 5.65005
R2035 VPWR.n1655 VPWR.t91 5.65005
R2036 VPWR.n1654 VPWR.t20 5.65005
R2037 VPWR.n1653 VPWR.t900 5.65005
R2038 VPWR.n18 VPWR.t24 5.65005
R2039 VPWR.n10 VPWR.t118 5.65005
R2040 VPWR.n208 VPWR.t208 5.65005
R2041 VPWR.n594 VPWR.t60 5.65005
R2042 VPWR.n602 VPWR.t30 5.65005
R2043 VPWR.n57 VPWR.t35 5.65005
R2044 VPWR.n1408 VPWR.t126 5.65005
R2045 VPWR.n1445 VPWR.t206 5.65005
R2046 VPWR.n211 VPWR.t232 5.65005
R2047 VPWR.n26 VPWR.t111 5.65005
R2048 VPWR.n129 VPWR.t168 5.65005
R2049 VPWR.n118 VPWR.t27 5.65005
R2050 VPWR.t26 VPWR.t45 5.65005
R2051 VPWR.n699 VPWR.t172 5.65005
R2052 VPWR.n99 VPWR.t130 5.65005
R2053 VPWR.n155 VPWR.t102 5.65005
R2054 VPWR.n121 VPWR.t150 5.65005
R2055 VPWR.n124 VPWR.t115 5.65005
R2056 VPWR.n96 VPWR.t729 5.65005
R2057 VPWR.n1110 VPWR.t94 5.65005
R2058 VPWR.n214 VPWR.t73 5.65005
R2059 VPWR.n93 VPWR.t164 5.65005
R2060 VPWR.t11 VPWR.n258 5.64857
R2061 VPWR.t8 VPWR.n427 5.64719
R2062 VPWR.t49 VPWR.n1846 5.64719
R2063 VPWR.t0 VPWR.n12 0.529935
R2064 VPWR.t21 VPWR.n1156 5.64719
R2065 VPWR.t39 VPWR.n989 5.64719
R2066 VPWR.n300 VPWR.t13 5.64493
R2067 VPWR.n301 VPWR.t86 5.64493
R2068 VPWR.n289 VPWR.t62 5.64493
R2069 VPWR.n142 VPWR.t9 5.64493
R2070 VPWR.n433 VPWR.t223 5.64493
R2071 VPWR.n425 VPWR.t226 5.64493
R2072 VPWR.n436 VPWR.t53 5.64493
R2073 VPWR.n437 VPWR.t203 5.64493
R2074 VPWR.n401 VPWR.t158 5.64493
R2075 VPWR.n1863 VPWR.t197 5.64493
R2076 VPWR.n1864 VPWR.t222 5.64493
R2077 VPWR.n1776 VPWR.t51 5.64493
R2078 VPWR.n1773 VPWR.t154 5.64493
R2079 VPWR.n83 VPWR.t71 5.64493
R2080 VPWR.n1824 VPWR.t906 5.64493
R2081 VPWR.n29 VPWR.t122 5.64493
R2082 VPWR.n5 VPWR.t101 5.64493
R2083 VPWR.n14 VPWR.t194 5.64493
R2084 VPWR.n440 VPWR.t138 5.64493
R2085 VPWR.n441 VPWR.t120 5.64493
R2086 VPWR.n1656 VPWR.t200 5.64493
R2087 VPWR.n1652 VPWR.t903 5.64493
R2088 VPWR.n13 VPWR.t18 5.64493
R2089 VPWR.n475 VPWR.t236 5.64493
R2090 VPWR.n8 VPWR.t15 5.64493
R2091 VPWR.n8 VPWR.t108 5.64493
R2092 VPWR.n1582 VPWR.t99 5.64493
R2093 VPWR.n1583 VPWR.t136 5.64493
R2094 VPWR.n1631 VPWR.t180 5.64493
R2095 VPWR.n1632 VPWR.t65 5.64493
R2096 VPWR.n1597 VPWR.t88 5.64493
R2097 VPWR.n1598 VPWR.t212 5.64493
R2098 VPWR.n1544 VPWR.t55 5.64493
R2099 VPWR.n9 VPWR.t188 5.64493
R2100 VPWR.n1648 VPWR.t1480 5.64493
R2101 VPWR.n45 VPWR.t106 5.64493
R2102 VPWR.n44 VPWR.t252 5.64493
R2103 VPWR.n667 VPWR.t59 5.64493
R2104 VPWR.n668 VPWR.t97 5.64493
R2105 VPWR.n593 VPWR.t178 5.64493
R2106 VPWR.n595 VPWR.t105 5.64493
R2107 VPWR.n57 VPWR.t147 5.64493
R2108 VPWR.n1503 VPWR.t38 5.64493
R2109 VPWR.n1382 VPWR.t57 5.64493
R2110 VPWR.n1404 VPWR.t124 5.64493
R2111 VPWR.n1402 VPWR.t7 5.64493
R2112 VPWR.n1427 VPWR.t190 5.64493
R2113 VPWR.n1433 VPWR.t113 5.64493
R2114 VPWR.n1463 VPWR.t141 5.64493
R2115 VPWR.n1362 VPWR.t134 5.64493
R2116 VPWR.n669 VPWR.t156 5.64493
R2117 VPWR.n49 VPWR.t4 5.64493
R2118 VPWR.n1259 VPWR.t216 5.64493
R2119 VPWR.n1258 VPWR.t228 5.64493
R2120 VPWR.n693 VPWR.t79 5.64493
R2121 VPWR.n1257 VPWR.t146 5.64493
R2122 VPWR.n21 VPWR.t76 5.64493
R2123 VPWR.n21 VPWR.t244 5.64493
R2124 VPWR.n702 VPWR.t83 5.64493
R2125 VPWR.t26 VPWR.t48 5.64493
R2126 VPWR.t26 VPWR.t1467 5.64493
R2127 VPWR.n1235 VPWR.t1469 5.64493
R2128 VPWR.n1241 VPWR.t176 5.64493
R2129 VPWR.n1181 VPWR.t242 5.64493
R2130 VPWR.n87 VPWR.t240 5.64493
R2131 VPWR.n1154 VPWR.t192 5.64493
R2132 VPWR.n1044 VPWR.t184 5.64493
R2133 VPWR.n1045 VPWR.t81 5.64493
R2134 VPWR.n1069 VPWR.t23 5.64493
R2135 VPWR.n1070 VPWR.t34 5.64493
R2136 VPWR.n1038 VPWR.t238 5.64493
R2137 VPWR.n137 VPWR.t1477 5.64493
R2138 VPWR.n725 VPWR.t162 5.64493
R2139 VPWR.n726 VPWR.t182 5.64493
R2140 VPWR.n1 VPWR.t220 5.64493
R2141 VPWR.n63 VPWR.t44 5.64493
R2142 VPWR.n823 VPWR.t1475 5.64493
R2143 VPWR.n858 VPWR.t85 5.64493
R2144 VPWR.n859 VPWR.t160 5.64493
R2145 VPWR.n837 VPWR.t40 5.64493
R2146 VPWR.n862 VPWR.t218 5.64493
R2147 VPWR.n825 VPWR.t249 5.64493
R2148 VPWR.n1719 VPWR.t0 5.64096
R2149 VPWR.n1685 VPWR.t0 5.64096
R2150 VPWR.n601 VPWR.t29 5.64096
R2151 VPWR.n631 VPWR.t29 5.64096
R2152 VPWR.t5 VPWR.n1447 5.64096
R2153 VPWR.t5 VPWR.n1411 5.64096
R2154 VPWR.n119 VPWR.n117 0.236919
R2155 VPWR.t21 VPWR.n1112 5.64096
R2156 VPWR.n126 VPWR.n125 0.236919
R2157 VPWR.n123 VPWR.n122 0.236919
R2158 VPWR.t39 VPWR.n204 2.80505
R2159 VPWR.t26 VPWR.n698 5.64013
R2160 VPWR.t11 VPWR.n240 5.61485
R2161 VPWR.t11 VPWR.n241 5.61485
R2162 VPWR.t11 VPWR.n1915 5.61485
R2163 VPWR.t11 VPWR.n1912 5.61485
R2164 VPWR.t11 VPWR.n253 5.61485
R2165 VPWR.t11 VPWR.n1893 5.61485
R2166 VPWR.t11 VPWR.n296 5.61485
R2167 VPWR.t11 VPWR.n263 5.61485
R2168 VPWR.t11 VPWR.n265 5.61485
R2169 VPWR.t8 VPWR.n376 5.61485
R2170 VPWR.t8 VPWR.n380 5.61485
R2171 VPWR.t8 VPWR.n406 5.61485
R2172 VPWR.t8 VPWR.n415 5.61485
R2173 VPWR.t8 VPWR.n418 5.61485
R2174 VPWR.t8 VPWR.n420 5.61485
R2175 VPWR.n35 VPWR.n48 0.11083
R2176 VPWR.t8 VPWR.n306 5.61485
R2177 VPWR.t8 VPWR.n309 5.61485
R2178 VPWR.t8 VPWR.n362 5.61485
R2179 VPWR.t8 VPWR.n359 5.61485
R2180 VPWR.n127 VPWR.n354 0.248871
R2181 VPWR.t8 VPWR.n128 1.9766
R2182 VPWR.t8 VPWR.n319 5.61485
R2183 VPWR.t8 VPWR.n320 5.61485
R2184 VPWR.t8 VPWR.n329 5.61485
R2185 VPWR.t8 VPWR.n331 5.61485
R2186 VPWR.t8 VPWR.n1884 5.61485
R2187 VPWR.n115 VPWR.n1879 0.412852
R2188 VPWR.t49 VPWR.n1842 5.61485
R2189 VPWR.t49 VPWR.n1837 5.61485
R2190 VPWR.t49 VPWR.n1830 5.61485
R2191 VPWR.t49 VPWR.n1849 5.61485
R2192 VPWR.t49 VPWR.n1851 5.61485
R2193 VPWR.t49 VPWR.n183 5.61485
R2194 VPWR.n1858 VPWR.t49 5.61485
R2195 VPWR.n1862 VPWR.n29 0.284427
R2196 VPWR.t49 VPWR.n181 5.61485
R2197 VPWR.t49 VPWR.n1795 5.61485
R2198 VPWR.t49 VPWR.n1752 5.61485
R2199 VPWR.n1869 VPWR.t49 5.61485
R2200 VPWR.t49 VPWR.n1759 5.61485
R2201 VPWR.n467 VPWR.t0 5.61485
R2202 VPWR.n469 VPWR.t0 5.61485
R2203 VPWR.t0 VPWR.n498 5.61485
R2204 VPWR.n16 VPWR.n15 0.10128
R2205 VPWR.n1709 VPWR.t0 5.61485
R2206 VPWR.n1700 VPWR.t0 5.61485
R2207 VPWR.n1698 VPWR.t0 5.61485
R2208 VPWR.n1688 VPWR.t0 5.61485
R2209 VPWR.n1673 VPWR.t0 5.61485
R2210 VPWR.n1666 VPWR.n76 0.272588
R2211 VPWR.n75 VPWR.t0 1.7276
R2212 VPWR.n186 VPWR.t0 5.61485
R2213 VPWR.t14 VPWR.n1568 5.61485
R2214 VPWR.t14 VPWR.n1576 5.61485
R2215 VPWR.n1646 VPWR.t14 5.61485
R2216 VPWR.t14 VPWR.n27 0.957173
R2217 VPWR.t14 VPWR.n1566 5.61485
R2218 VPWR.t14 VPWR.n1517 5.61485
R2219 VPWR.t14 VPWR.n1563 5.61485
R2220 VPWR.t14 VPWR.n1560 5.61485
R2221 VPWR.t14 VPWR.n1554 5.61485
R2222 VPWR.t14 VPWR.n1549 5.61485
R2223 VPWR.t14 VPWR.n1521 5.61485
R2224 VPWR.t14 VPWR.n1533 5.61485
R2225 VPWR.n1618 VPWR.t14 5.61485
R2226 VPWR.n78 VPWR.t14 1.72371
R2227 VPWR.t14 VPWR.n1596 5.61485
R2228 VPWR.n1590 VPWR.t14 5.61485
R2229 VPWR.n1589 VPWR.n73 0.262588
R2230 VPWR.n72 VPWR.t14 1.7276
R2231 VPWR.t29 VPWR.n524 5.61485
R2232 VPWR.t29 VPWR.n536 5.61485
R2233 VPWR.t29 VPWR.n542 5.61485
R2234 VPWR.t29 VPWR.n544 5.61485
R2235 VPWR.t29 VPWR.n546 5.61485
R2236 VPWR.t29 VPWR.n549 5.61485
R2237 VPWR.t29 VPWR.n551 5.61485
R2238 VPWR.t29 VPWR.n554 5.61485
R2239 VPWR.t29 VPWR.n565 5.61485
R2240 VPWR.n613 VPWR.t29 5.61485
R2241 VPWR.n617 VPWR.t29 5.61485
R2242 VPWR.n623 VPWR.t29 5.61485
R2243 VPWR.n633 VPWR.n22 0.324167
R2244 VPWR.n22 VPWR.t29 0.978058
R2245 VPWR.t29 VPWR.n578 5.61485
R2246 VPWR.t29 VPWR.n587 5.61485
R2247 VPWR.t29 VPWR.n584 5.61485
R2248 VPWR.n1459 VPWR.t5 5.61485
R2249 VPWR.t5 VPWR.n1476 5.61485
R2250 VPWR.t5 VPWR.n1478 5.61485
R2251 VPWR.t5 VPWR.n104 1.97627
R2252 VPWR.t5 VPWR.n187 5.61485
R2253 VPWR.t5 VPWR.n1479 5.61485
R2254 VPWR.t5 VPWR.n1481 5.61485
R2255 VPWR.t5 VPWR.n1452 5.61485
R2256 VPWR.n24 VPWR.n1451 0.328713
R2257 VPWR.t5 VPWR.n174 5.61485
R2258 VPWR.t5 VPWR.n202 5.61485
R2259 VPWR.t5 VPWR.n1430 5.61485
R2260 VPWR.t5 VPWR.n1374 5.61485
R2261 VPWR.t5 VPWR.n1407 5.61485
R2262 VPWR.n105 VPWR.n1387 0.255012
R2263 VPWR.t2 VPWR.n681 5.61485
R2264 VPWR.t2 VPWR.n1341 5.61485
R2265 VPWR.n1310 VPWR.t2 5.61485
R2266 VPWR.n1302 VPWR.t2 5.61485
R2267 VPWR.n1297 VPWR.t2 5.61485
R2268 VPWR.n1295 VPWR.t2 5.61485
R2269 VPWR.n1292 VPWR.t2 5.61485
R2270 VPWR.n1286 VPWR.t2 5.61485
R2271 VPWR.n1280 VPWR.t2 5.61485
R2272 VPWR.n1276 VPWR.t2 5.61485
R2273 VPWR.n190 VPWR.n40 0.289962
R2274 VPWR.n1268 VPWR.t2 5.61485
R2275 VPWR.n1263 VPWR.t2 5.61485
R2276 VPWR.n1261 VPWR.t2 5.61485
R2277 VPWR.t2 VPWR.n676 5.61485
R2278 VPWR.t26 VPWR.n195 2.43181
R2279 VPWR.t26 VPWR.n191 5.61485
R2280 VPWR.t26 VPWR.n1253 5.61485
R2281 VPWR.t26 VPWR.n1237 5.61485
R2282 VPWR.t26 VPWR.n1251 5.61485
R2283 VPWR.n101 VPWR.n1249 0.372775
R2284 VPWR.t26 VPWR.n1240 5.61485
R2285 VPWR.t26 VPWR.n68 1.35573
R2286 VPWR.n1233 VPWR.t26 5.61485
R2287 VPWR.n1230 VPWR.t26 5.61485
R2288 VPWR.n1228 VPWR.t26 5.61485
R2289 VPWR.n81 VPWR.t26 1.72371
R2290 VPWR.n1223 VPWR.t26 5.61485
R2291 VPWR.n1209 VPWR.t26 5.61485
R2292 VPWR.n1205 VPWR.t26 5.61485
R2293 VPWR.n1203 VPWR.t26 5.61485
R2294 VPWR.n1200 VPWR.t26 5.61485
R2295 VPWR.n1194 VPWR.t26 5.61485
R2296 VPWR.n709 VPWR.t26 5.61485
R2297 VPWR.t21 VPWR.n1183 5.61485
R2298 VPWR.t21 VPWR.n1163 5.61485
R2299 VPWR.t21 VPWR.n1165 5.61485
R2300 VPWR.t21 VPWR.n1167 5.61485
R2301 VPWR.t21 VPWR.n1171 5.61485
R2302 VPWR.t21 VPWR.n1173 5.61485
R2303 VPWR.t21 VPWR.n1175 5.61485
R2304 VPWR.t21 VPWR.n1124 5.61485
R2305 VPWR.t21 VPWR.n1140 5.61485
R2306 VPWR.t21 VPWR.n1052 5.61485
R2307 VPWR.t21 VPWR.n1059 5.61485
R2308 VPWR.t21 VPWR.n1092 5.61485
R2309 VPWR.t21 VPWR.n1062 5.61485
R2310 VPWR.t21 VPWR.n1090 5.61485
R2311 VPWR.n65 VPWR.n1078 0.272588
R2312 VPWR.t21 VPWR.n1049 5.61485
R2313 VPWR.n38 VPWR.n1048 0.285315
R2314 VPWR.t42 VPWR.n1040 5.61485
R2315 VPWR.t42 VPWR.n996 5.61485
R2316 VPWR.t42 VPWR.n1008 5.61485
R2317 VPWR.t42 VPWR.n1010 5.61485
R2318 VPWR.t42 VPWR.n1012 5.61485
R2319 VPWR.t42 VPWR.n1014 5.61485
R2320 VPWR.t42 VPWR.n1016 5.61485
R2321 VPWR.t42 VPWR.n1018 5.61485
R2322 VPWR.t42 VPWR.n1020 5.61485
R2323 VPWR.t42 VPWR.n1022 5.61485
R2324 VPWR.t42 VPWR.n1024 5.61485
R2325 VPWR.t42 VPWR.n1030 5.61485
R2326 VPWR.t42 VPWR.n1032 5.61485
R2327 VPWR.t42 VPWR.n1034 5.61485
R2328 VPWR.t42 VPWR.n802 5.61485
R2329 VPWR.t42 VPWR.n765 5.61485
R2330 VPWR.t42 VPWR.n196 5.61485
R2331 VPWR.t42 VPWR.n786 5.61485
R2332 VPWR.t42 VPWR.n772 5.61485
R2333 VPWR.t42 VPWR.n775 5.61485
R2334 VPWR.n1 VPWR.n776 0.284427
R2335 VPWR.t42 VPWR.n742 5.61485
R2336 VPWR.t42 VPWR.n728 5.61485
R2337 VPWR.t42 VPWR.n732 5.61485
R2338 VPWR.t39 VPWR.n946 5.61485
R2339 VPWR.t39 VPWR.n983 5.61485
R2340 VPWR.t39 VPWR.n911 5.61485
R2341 VPWR.t39 VPWR.n898 5.61485
R2342 VPWR.t39 VPWR.n848 5.61485
R2343 VPWR.t39 VPWR.n198 5.61485
R2344 VPWR.t39 VPWR.n874 5.61485
R2345 VPWR.t39 VPWR.n851 5.61485
R2346 VPWR.t39 VPWR.n928 5.61485
R2347 VPWR.t39 VPWR.n913 5.61485
R2348 VPWR.t39 VPWR.n914 5.61485
R2349 VPWR.t39 VPWR.n917 5.61485
R2350 VPWR.n1043 VPWR.n724 5.16578
R2351 VPWR.n992 VPWR.n991 5.16578
R2352 VPWR.n1043 VPWR.n1042 4.5005
R2353 VPWR.n1186 VPWR.n1185 4.5005
R2354 VPWR.n1188 VPWR.n1187 4.5005
R2355 VPWR.n1369 VPWR.n1368 4.5005
R2356 VPWR.n1512 VPWR.n1511 4.5005
R2357 VPWR.n1514 VPWR.n1513 4.5005
R2358 VPWR.n1593 VPWR.n439 4.5005
R2359 VPWR.n1732 VPWR.n1731 4.5005
R2360 VPWR.n1871 VPWR.n1870 4.5005
R2361 VPWR.n1873 VPWR.n1872 4.5005
R2362 VPWR.n1938 VPWR.t139 4.5005
R2363 VPWR.n138 VPWR.n992 4.5005
R2364 VPWR.n88 VPWR.n217 4.5005
R2365 VPWR.n1254 VPWR.n21 4.5005
R2366 VPWR.n1256 VPWR.n1255 4.5005
R2367 VPWR.n57 VPWR.n165 4.5005
R2368 VPWR.n1516 VPWR.n46 4.5005
R2369 VPWR.n1650 VPWR.n8 4.5005
R2370 VPWR.n15 VPWR.n1651 4.5005
R2371 VPWR.n1866 VPWR.n303 4.5005
R2372 VPWR.n1890 VPWR.n142 4.5005
R2373 VPWR.n169 VPWR.n168 4.42062
R2374 VPWR.n1891 VPWR.n167 5.0495
R2375 VPWR.n167 VPWR.n170 3.30031
R2376 VPWR.n195 VPWR.n194 0.0767623
R2377 VPWR.n173 VPWR.n172 0.0467726
R2378 VPWR.t0 VPWR.n448 4.31399
R2379 VPWR.n1634 VPWR.t14 4.24345
R2380 VPWR.t2 VPWR.n673 4.2387
R2381 VPWR.t21 VPWR.n176 4.2387
R2382 VPWR.t29 VPWR.n516 4.23852
R2383 VPWR.n1584 VPWR.t14 4.22884
R2384 VPWR.t5 VPWR.n106 1.74191
R2385 VPWR.n703 VPWR.t26 4.22884
R2386 VPWR.n1705 VPWR.t0 4.17719
R2387 VPWR.t0 VPWR.n454 4.17719
R2388 VPWR.n1624 VPWR.t14 4.17719
R2389 VPWR.n628 VPWR.t29 4.17719
R2390 VPWR.t5 VPWR.n1394 4.17719
R2391 VPWR.t2 VPWR.n1332 4.17719
R2392 VPWR.t2 VPWR.n1327 4.17719
R2393 VPWR.t2 VPWR.n685 4.17719
R2394 VPWR.t2 VPWR.n689 4.17719
R2395 VPWR.t2 VPWR.n692 4.17719
R2396 VPWR.t21 VPWR.n39 1.3504
R2397 VPWR.t42 VPWR.n751 4.17719
R2398 VPWR.t42 VPWR.n798 4.17719
R2399 VPWR.t39 VPWR.n905 4.17719
R2400 VPWR.n32 VPWR.n481 0.377379
R2401 VPWR.t29 VPWR.n559 4.17712
R2402 VPWR.t42 VPWR.n994 4.17712
R2403 VPWR.t8 VPWR.n411 4.177
R2404 VPWR.t0 VPWR.n488 4.177
R2405 VPWR.t14 VPWR.n95 1.51787
R2406 VPWR.t2 VPWR.n1353 4.177
R2407 VPWR.t39 VPWR.n940 4.177
R2408 VPWR.t29 VPWR.n581 3.41565
R2409 VPWR.t5 VPWR.n1505 3.33205
R2410 VPWR.n1277 VPWR.n26 0.409192
R2411 VPWR.t0 VPWR.n500 3.31335
R2412 VPWR.t42 VPWR.n1036 3.31205
R2413 VPWR.t21 VPWR.n1179 3.31187
R2414 VPWR.t11 VPWR.n1922 3.30723
R2415 VPWR.t11 VPWR.n1896 3.30723
R2416 VPWR.t49 VPWR.n1814 3.30723
R2417 VPWR.n619 VPWR.t29 3.30723
R2418 VPWR.t2 VPWR.n1323 3.30723
R2419 VPWR.t42 VPWR.n764 3.30723
R2420 VPWR.n108 VPWR.n835 0.447655
R2421 VPWR.t29 VPWR.n571 3.30688
R2422 VPWR.t14 VPWR.n1580 3.30688
R2423 VPWR.t8 VPWR.n337 2.72442
R2424 VPWR.t5 VPWR.n1444 2.72142
R2425 VPWR.t39 VPWR.n985 2.72093
R2426 VPWR.t143 VPWR.t414 1.10665
R2427 VPWR.t414 VPWR.t411 1.09575
R2428 VPWR.t139 VPWR.n271 1.02283
R2429 VPWR.n271 VPWR.t143 1.01309
R2430 VPWR.n239 VPWR.t139 1.00787
R2431 VPWR.n270 VPWR.t738 0.849858
R2432 VPWR.t411 VPWR.n270 0.849259
R2433 VPWR.t11 VPWR.n270 0.800725
R2434 VPWR.n239 VPWR.t662 0.796041
R2435 VPWR.n162 VPWR.n68 0.477851
R2436 VPWR.n1872 VPWR.n1871 0.66578
R2437 VPWR.n1871 VPWR.n1732 0.66578
R2438 VPWR.n1732 VPWR.n439 0.66578
R2439 VPWR.n1513 VPWR.n439 0.66578
R2440 VPWR.n1513 VPWR.n1512 0.66578
R2441 VPWR.n1512 VPWR.n1369 0.66578
R2442 VPWR.n1187 VPWR.n1186 0.66578
R2443 VPWR.n1186 VPWR.n1043 0.66578
R2444 VPWR.n1890 VPWR.n303 0.66578
R2445 VPWR.n1651 VPWR.n303 0.66578
R2446 VPWR.n1651 VPWR.n1650 0.66578
R2447 VPWR.n1650 VPWR.n1516 0.66578
R2448 VPWR.n1516 VPWR.n165 0.66578
R2449 VPWR.n1255 VPWR.n165 0.66578
R2450 VPWR.n1254 VPWR.n217 0.66578
R2451 VPWR.n992 VPWR.n217 0.66578
R2452 VPWR.n61 VPWR.n281 0.654554
R2453 VPWR.n59 VPWR.n677 0.654554
R2454 VPWR.n152 VPWR.n57 0.619874
R2455 VPWR.n1077 VPWR.n66 0.435343
R2456 VPWR.n78 VPWR.n1626 0.543755
R2457 VPWR.n1226 VPWR.n81 0.543755
R2458 VPWR.n1567 VPWR.n95 0.596906
R2459 VPWR.n110 VPWR.n109 0.600241
R2460 VPWR.n90 VPWR.n64 0.593118
R2461 VPWR.n96 VPWR.n1111 0.583165
R2462 VPWR.n982 VPWR.n93 0.581991
R2463 VPWR.n1823 VPWR.n85 0.495629
R2464 VPWR.n434 VPWR.n142 0.554765
R2465 VPWR.n239 VPWR.t11 0.511572
R2466 VPWR.t11 VPWR.n271 0.504923
R2467 VPWR VPWR.n170 0.45106
R2468 VPWR.t11 VPWR.t414 0.387708
R2469 VPWR.n985 VPWR.n984 0.36053
R2470 VPWR.n337 VPWR.n336 0.359861
R2471 VPWR.n1938 VPWR 0.3525
R2472 VPWR.n337 VPWR.n334 0.351592
R2473 VPWR.n986 VPWR.n985 0.350888
R2474 VPWR.n1444 VPWR.n175 0.349861
R2475 VPWR.n1444 VPWR.n203 0.344092
R2476 VPWR.n620 VPWR.n619 0.326433
R2477 VPWR.n1187 VPWR.n168 0.37762
R2478 VPWR.n169 VPWR.n1254 0.377844
R2479 VPWR.n1922 VPWR.n1921 0.303933
R2480 VPWR.n1839 VPWR.n1814 0.303933
R2481 VPWR.n800 VPWR.n764 0.303933
R2482 VPWR.n110 VPWR.n108 0.146717
R2483 VPWR.n1923 VPWR.n1922 0.302695
R2484 VPWR.n1814 VPWR.n1813 0.302695
R2485 VPWR.n1896 VPWR.n1894 0.293933
R2486 VPWR.n1323 VPWR.n1321 0.293933
R2487 VPWR.n1037 VPWR.n1036 0.293618
R2488 VPWR.n500 VPWR.n499 0.293308
R2489 VPWR.n1580 VPWR.n8 0.293308
R2490 VPWR.n572 VPWR.n571 0.293308
R2491 VPWR.n1179 VPWR.n1178 0.293308
R2492 VPWR.n501 VPWR.n500 0.293299
R2493 VPWR.n1580 VPWR.n1579 0.293299
R2494 VPWR.n571 VPWR.n570 0.293299
R2495 VPWR.n20 VPWR.n19 0.970782
R2496 VPWR.n1180 VPWR.n1179 0.293299
R2497 VPWR.n1036 VPWR.n1035 0.292996
R2498 VPWR.n1896 VPWR.n1895 0.292695
R2499 VPWR.n619 VPWR.n618 0.292695
R2500 VPWR.n1323 VPWR.n1322 0.292695
R2501 VPWR.n686 VPWR.n685 0.28778
R2502 VPWR.n1328 VPWR.n1327 0.287011
R2503 VPWR.n1327 VPWR.n1326 0.27153
R2504 VPWR.n412 VPWR.n411 0.271144
R2505 VPWR.n1324 VPWR.n685 0.270761
R2506 VPWR.n1505 VPWR.n1502 0.269074
R2507 VPWR.n764 VPWR.n763 0.266445
R2508 VPWR.n454 VPWR.n453 0.24528
R2509 VPWR.n1625 VPWR.n1624 0.24528
R2510 VPWR.n1394 VPWR.n1393 0.24528
R2511 VPWR.n760 VPWR.n90 0.364607
R2512 VPWR.n752 VPWR.n751 0.24528
R2513 VPWR.n905 VPWR.n904 0.24528
R2514 VPWR.n560 VPWR.n559 0.245023
R2515 VPWR.n995 VPWR.n994 0.245023
R2516 VPWR.n411 VPWR.n410 0.244894
R2517 VPWR.n489 VPWR.n488 0.244894
R2518 VPWR.n488 VPWR.n487 0.244894
R2519 VPWR.n94 VPWR.n10 0.324571
R2520 VPWR.n1354 VPWR.n1353 0.244894
R2521 VPWR.n1353 VPWR.n1352 0.244894
R2522 VPWR.n940 VPWR.n939 0.244894
R2523 VPWR.n455 VPWR.n454 0.244511
R2524 VPWR.n1624 VPWR.n1623 0.244511
R2525 VPWR.n628 VPWR.n627 0.244511
R2526 VPWR.n1395 VPWR.n1394 0.244511
R2527 VPWR.n1321 VPWR.n692 0.244511
R2528 VPWR.n821 VPWR.n751 0.244511
R2529 VPWR.n906 VPWR.n905 0.244511
R2530 VPWR.n1256 VPWR.n692 0.24028
R2531 VPWR.n798 VPWR.n197 0.23528
R2532 VPWR.n941 VPWR.n940 0.234894
R2533 VPWR.n798 VPWR.n797 0.234511
R2534 VPWR.n1172 VPWR.n1171 0.228325
R2535 VPWR.n777 VPWR.n775 0.228325
R2536 VPWR.n39 VPWR.n177 0.680268
R2537 VPWR.n994 VPWR.n993 0.224761
R2538 VPWR.n1281 VPWR.n1280 0.222986
R2539 VPWR.n1700 VPWR.n1699 0.222075
R2540 VPWR.n1224 VPWR.n1223 0.219236
R2541 VPWR.n1175 VPWR.n1174 0.219236
R2542 VPWR.n1332 VPWR.n1330 0.21403
R2543 VPWR.n209 VPWR.n206 0.237831
R2544 VPWR.n205 VPWR.n215 0.237831
R2545 VPWR.n689 VPWR.n688 0.213261
R2546 VPWR.n1166 VPWR.n1165 0.212075
R2547 VPWR.n1168 VPWR.n1167 0.211736
R2548 VPWR.n1163 VPWR.n1162 0.207075
R2549 VPWR.n1165 VPWR.n1164 0.206736
R2550 VPWR.n690 VPWR.n689 0.20153
R2551 VPWR.n1870 VPWR.n91 0.266328
R2552 VPWR.n1332 VPWR.n1331 0.200761
R2553 VPWR.n1342 VPWR.n1341 0.195825
R2554 VPWR.n1286 VPWR.n1285 0.193325
R2555 VPWR.n517 VPWR.n516 0.19313
R2556 VPWR.n1585 VPWR.n1584 0.19261
R2557 VPWR.n704 VPWR.n703 0.19261
R2558 VPWR.n559 VPWR.n558 0.192261
R2559 VPWR.n1706 VPWR.n1705 0.192011
R2560 VPWR.n1705 VPWR.n1704 0.19153
R2561 VPWR.n629 VPWR.n628 0.19153
R2562 VPWR.n601 VPWR.n600 0.190118
R2563 VPWR.n1411 VPWR.n1410 0.190118
R2564 VPWR.n1448 VPWR.n1447 0.190118
R2565 VPWR.n1635 VPWR.n1634 0.188199
R2566 VPWR.n1912 VPWR.n1910 0.185825
R2567 VPWR.n1924 VPWR.n241 0.185825
R2568 VPWR.n1929 VPWR.n240 0.185825
R2569 VPWR.n284 VPWR.n265 0.185825
R2570 VPWR.n1884 VPWR.n1882 0.185825
R2571 VPWR.n338 VPWR.n329 0.185825
R2572 VPWR.n342 VPWR.n320 0.185825
R2573 VPWR.n347 VPWR.n319 0.185825
R2574 VPWR.n352 VPWR.n128 0.498157
R2575 VPWR.n359 VPWR.n357 0.185825
R2576 VPWR.n362 VPWR.n360 0.185825
R2577 VPWR.n363 VPWR.n309 0.185825
R2578 VPWR.n366 VPWR.n306 0.185825
R2579 VPWR.n372 VPWR.n113 0.25522
R2580 VPWR.n419 VPWR.n418 0.185825
R2581 VPWR.n381 VPWR.n380 0.185825
R2582 VPWR.n1842 VPWR.n1841 0.185825
R2583 VPWR.n1775 VPWR.n1752 0.185825
R2584 VPWR.n1795 VPWR.n1794 0.185825
R2585 VPWR.n1859 VPWR.n1858 0.185825
R2586 VPWR.n1850 VPWR.n183 0.185825
R2587 VPWR.n1852 VPWR.n1849 0.185825
R2588 VPWR.n186 VPWR.n1665 0.185825
R2589 VPWR.n1673 VPWR.n1672 0.185825
R2590 VPWR.n1698 VPWR.n1697 0.185825
R2591 VPWR.n470 VPWR.n469 0.185825
R2592 VPWR.n468 VPWR.n467 0.185825
R2593 VPWR.n1576 VPWR.n1575 0.185825
R2594 VPWR.n1590 VPWR.n1589 0.185825
R2595 VPWR.n1596 VPWR.n1594 0.185825
R2596 VPWR.n1627 VPWR.n77 0.272455
R2597 VPWR.n1533 VPWR.n1532 0.185825
R2598 VPWR.n1546 VPWR.n1521 0.185825
R2599 VPWR.n1549 VPWR.n1548 0.185825
R2600 VPWR.n1554 VPWR.n1553 0.185825
R2601 VPWR.n1560 VPWR.n1558 0.185825
R2602 VPWR.n1563 VPWR.n1561 0.185825
R2603 VPWR.n1562 VPWR.n1517 0.185825
R2604 VPWR.n1566 VPWR.n1564 0.185825
R2605 VPWR.n1565 VPWR.n27 0.855028
R2606 VPWR.n552 VPWR.n551 0.185825
R2607 VPWR.n543 VPWR.n542 0.185825
R2608 VPWR.n537 VPWR.n536 0.185825
R2609 VPWR.n584 VPWR.n582 0.185825
R2610 VPWR.n23 VPWR.n22 0.0332519
R2611 VPWR.n624 VPWR.n623 0.185825
R2612 VPWR.n618 VPWR.n617 0.185825
R2613 VPWR.n614 VPWR.n613 0.185825
R2614 VPWR.n1478 VPWR.n1477 0.185825
R2615 VPWR.n1430 VPWR.n1429 0.185825
R2616 VPWR.n202 VPWR.n1443 0.185825
R2617 VPWR.n1454 VPWR.n158 0.185825
R2618 VPWR.n1460 VPWR.n1459 0.185825
R2619 VPWR.n1336 VPWR.n681 0.185825
R2620 VPWR.n676 VPWR.n674 0.185825
R2621 VPWR.n1268 VPWR.n1267 0.185825
R2622 VPWR.n1310 VPWR.n1309 0.185825
R2623 VPWR.n709 VPWR.n708 0.185825
R2624 VPWR.n1223 VPWR.n1222 0.185825
R2625 VPWR.n80 VPWR.n79 0.272455
R2626 VPWR.n1228 VPWR.n1227 0.185825
R2627 VPWR.n1230 VPWR.n1229 0.185825
R2628 VPWR.n1251 VPWR.n1249 0.185825
R2629 VPWR.n1250 VPWR.n1237 0.185825
R2630 VPWR.n1253 VPWR.n1252 0.185825
R2631 VPWR.n1183 VPWR.n1180 0.185825
R2632 VPWR.n1140 VPWR.n1139 0.185825
R2633 VPWR.n1040 VPWR.n1037 0.185825
R2634 VPWR.n1033 VPWR.n1032 0.185825
R2635 VPWR.n1023 VPWR.n1022 0.185825
R2636 VPWR.n1019 VPWR.n1018 0.185825
R2637 VPWR.n1015 VPWR.n1014 0.185825
R2638 VPWR.n1011 VPWR.n1010 0.185825
R2639 VPWR.n997 VPWR.n996 0.185825
R2640 VPWR.n782 VPWR.n772 0.185825
R2641 VPWR.n802 VPWR.n799 0.185825
R2642 VPWR.n919 VPWR.n914 0.185825
R2643 VPWR.n924 VPWR.n913 0.185825
R2644 VPWR.n928 VPWR.n926 0.185825
R2645 VPWR.n861 VPWR.n851 0.185825
R2646 VPWR.n874 VPWR.n873 0.185825
R2647 VPWR.n889 VPWR.n111 0.25522
R2648 VPWR.n898 VPWR.n896 0.185825
R2649 VPWR.n911 VPWR.n909 0.185825
R2650 VPWR.n253 VPWR.n252 0.185486
R2651 VPWR.n1915 VPWR.n1914 0.185486
R2652 VPWR.n295 VPWR.n263 0.185486
R2653 VPWR.n297 VPWR.n296 0.185486
R2654 VPWR.n1884 VPWR.n1883 0.185486
R2655 VPWR.n331 VPWR.n330 0.185486
R2656 VPWR.n369 VPWR.n306 0.185486
R2657 VPWR.n416 VPWR.n415 0.185486
R2658 VPWR.n376 VPWR.n375 0.185486
R2659 VPWR.n1830 VPWR.n1829 0.185486
R2660 VPWR.n1838 VPWR.n1837 0.185486
R2661 VPWR.n1843 VPWR.n1842 0.185486
R2662 VPWR.n1759 VPWR.n1758 0.185486
R2663 VPWR.n1752 VPWR.n1751 0.185486
R2664 VPWR.n181 VPWR.n1740 0.185486
R2665 VPWR.n1849 VPWR.n1848 0.185486
R2666 VPWR.n1710 VPWR.n1709 0.185486
R2667 VPWR.n499 VPWR.n498 0.185486
R2668 VPWR.n467 VPWR.n466 0.185486
R2669 VPWR.n1569 VPWR.n1568 0.185486
R2670 VPWR.n1618 VPWR.n1617 0.185486
R2671 VPWR.n1646 VPWR.n1645 0.185486
R2672 VPWR.n566 VPWR.n565 0.185486
R2673 VPWR.n555 VPWR.n554 0.185486
R2674 VPWR.n550 VPWR.n549 0.185486
R2675 VPWR.n545 VPWR.n544 0.185486
R2676 VPWR.n525 VPWR.n524 0.185486
R2677 VPWR.n587 VPWR.n586 0.185486
R2678 VPWR.n578 VPWR.n577 0.185486
R2679 VPWR.n1413 VPWR.n1374 0.185486
R2680 VPWR.n1453 VPWR.n1452 0.185486
R2681 VPWR.n1481 VPWR.n1480 0.185486
R2682 VPWR.n103 VPWR.n102 0.255012
R2683 VPWR.n1476 VPWR.n1475 0.185486
R2684 VPWR.n1341 VPWR.n1340 0.185486
R2685 VPWR.n1262 VPWR.n1261 0.185486
R2686 VPWR.n69 VPWR.n1276 0.185486
R2687 VPWR.n1287 VPWR.n1286 0.185486
R2688 VPWR.n1296 VPWR.n1295 0.185486
R2689 VPWR.n1303 VPWR.n1302 0.185486
R2690 VPWR.n1195 VPWR.n1194 0.185486
R2691 VPWR.n1201 VPWR.n1200 0.185486
R2692 VPWR.n1204 VPWR.n1203 0.185486
R2693 VPWR.n1210 VPWR.n1209 0.185486
R2694 VPWR.n1240 VPWR.n1239 0.185486
R2695 VPWR.n1050 VPWR.n1049 0.185486
R2696 VPWR.n1090 VPWR.n1089 0.185486
R2697 VPWR.n1091 VPWR.n1062 0.185486
R2698 VPWR.n1093 VPWR.n1092 0.185486
R2699 VPWR.n1100 VPWR.n1059 0.185486
R2700 VPWR.n1120 VPWR.n1052 0.185486
R2701 VPWR.n1141 VPWR.n1140 0.185486
R2702 VPWR.n1125 VPWR.n1124 0.185486
R2703 VPWR.n1035 VPWR.n1034 0.185486
R2704 VPWR.n1031 VPWR.n1030 0.185486
R2705 VPWR.n1025 VPWR.n1024 0.185486
R2706 VPWR.n1021 VPWR.n1020 0.185486
R2707 VPWR.n1017 VPWR.n1016 0.185486
R2708 VPWR.n1013 VPWR.n1012 0.185486
R2709 VPWR.n1009 VPWR.n1008 0.185486
R2710 VPWR.n733 VPWR.n732 0.185486
R2711 VPWR.n741 VPWR.n728 0.185486
R2712 VPWR.n743 VPWR.n742 0.185486
R2713 VPWR.n775 VPWR.n774 0.185486
R2714 VPWR.n918 VPWR.n917 0.185486
R2715 VPWR.n866 VPWR.n851 0.185486
R2716 VPWR.n848 VPWR.n847 0.185486
R2717 VPWR.n983 VPWR.n982 0.185486
R2718 VPWR.n946 VPWR.n945 0.185486
R2719 VPWR.n1407 VPWR.n1405 0.184575
R2720 VPWR.n1183 VPWR.n1182 0.184236
R2721 VPWR.n1040 VPWR.n1039 0.184236
R2722 VPWR.n582 VPWR.n581 0.183779
R2723 VPWR.n1893 VPWR.n1891 0.180825
R2724 VPWR.n1897 VPWR.n253 0.175825
R2725 VPWR.n1915 VPWR.n1913 0.175825
R2726 VPWR.n61 VPWR.n60 0.290259
R2727 VPWR.n293 VPWR.n263 0.175825
R2728 VPWR.n296 VPWR.n295 0.175825
R2729 VPWR.n415 VPWR.n414 0.175825
R2730 VPWR.n420 VPWR.n419 0.175825
R2731 VPWR.n377 VPWR.n376 0.175825
R2732 VPWR.n1830 VPWR.n1828 0.175825
R2733 VPWR.n1837 VPWR.n1836 0.175825
R2734 VPWR.n1763 VPWR.n1759 0.175825
R2735 VPWR.n1869 VPWR.n1733 0.175825
R2736 VPWR.n182 VPWR.n181 0.175825
R2737 VPWR.n1851 VPWR.n184 0.175825
R2738 VPWR.n185 VPWR.n112 0.24522
R2739 VPWR.n498 VPWR.n497 0.175825
R2740 VPWR.n75 VPWR.n74 0.570297
R2741 VPWR.n1709 VPWR.n1708 0.175825
R2742 VPWR.n1568 VPWR.n1567 0.175825
R2743 VPWR.n72 VPWR.n71 0.570297
R2744 VPWR.n1619 VPWR.n1618 0.175825
R2745 VPWR.n1647 VPWR.n1646 0.175825
R2746 VPWR.n524 VPWR.n523 0.175825
R2747 VPWR.n544 VPWR.n543 0.175825
R2748 VPWR.n565 VPWR.n564 0.175825
R2749 VPWR.n573 VPWR.n46 0.26526
R2750 VPWR.n549 VPWR.n548 0.175825
R2751 VPWR.n587 VPWR.n585 0.175825
R2752 VPWR.n586 VPWR.n578 0.175825
R2753 VPWR.n1452 VPWR.n1451 0.175825
R2754 VPWR.n1482 VPWR.n1481 0.175825
R2755 VPWR.n188 VPWR.n187 0.175825
R2756 VPWR.n1477 VPWR.n1476 0.175825
R2757 VPWR.n59 VPWR.n58 0.290259
R2758 VPWR.n1263 VPWR.n1262 0.175825
R2759 VPWR.n1276 VPWR.n190 0.175825
R2760 VPWR.n1292 VPWR.n1291 0.175825
R2761 VPWR.n1295 VPWR.n1294 0.175825
R2762 VPWR.n1297 VPWR.n1296 0.175825
R2763 VPWR.n1302 VPWR.n1301 0.175825
R2764 VPWR.n1200 VPWR.n1199 0.175825
R2765 VPWR.n1205 VPWR.n1204 0.175825
R2766 VPWR.n1209 VPWR.n1208 0.175825
R2767 VPWR.n1243 VPWR.n1240 0.175825
R2768 VPWR.n192 VPWR.n191 0.175825
R2769 VPWR.n195 VPWR.n193 0.272549
R2770 VPWR.n1124 VPWR.n1123 0.175825
R2771 VPWR.n1049 VPWR.n1048 0.175825
R2772 VPWR.n1090 VPWR.n1088 0.175825
R2773 VPWR.n1089 VPWR.n1062 0.175825
R2774 VPWR.n1092 VPWR.n1091 0.175825
R2775 VPWR.n1117 VPWR.n1052 0.175825
R2776 VPWR.n1016 VPWR.n1015 0.175825
R2777 VPWR.n1024 VPWR.n1023 0.175825
R2778 VPWR.n1030 VPWR.n1029 0.175825
R2779 VPWR.n1034 VPWR.n1033 0.175825
R2780 VPWR.n1020 VPWR.n1019 0.175825
R2781 VPWR.n1012 VPWR.n1011 0.175825
R2782 VPWR.n1008 VPWR.n1007 0.175825
R2783 VPWR.n732 VPWR.n731 0.175825
R2784 VPWR.n739 VPWR.n728 0.175825
R2785 VPWR.n742 VPWR.n741 0.175825
R2786 VPWR.n196 VPWR.n795 0.175825
R2787 VPWR.n917 VPWR.n916 0.175825
R2788 VPWR.n199 VPWR.n198 0.175825
R2789 VPWR.n875 VPWR.n848 0.175825
R2790 VPWR.n984 VPWR.n983 0.175825
R2791 VPWR.n947 VPWR.n946 0.175825
R2792 VPWR.n1893 VPWR.n1892 0.175486
R2793 VPWR.n1912 VPWR.n1911 0.175486
R2794 VPWR.n1926 VPWR.n241 0.175486
R2795 VPWR.n1931 VPWR.n240 0.175486
R2796 VPWR.n344 VPWR.n320 0.175486
R2797 VPWR.n349 VPWR.n319 0.175486
R2798 VPWR.n359 VPWR.n358 0.175486
R2799 VPWR.n362 VPWR.n361 0.175486
R2800 VPWR.n309 VPWR.n308 0.175486
R2801 VPWR.n380 VPWR.n379 0.175486
R2802 VPWR.n375 VPWR.n107 0.245012
R2803 VPWR.n1858 VPWR.n1857 0.175486
R2804 VPWR.n1674 VPWR.n1673 0.175486
R2805 VPWR.n1689 VPWR.n1688 0.175486
R2806 VPWR.n469 VPWR.n468 0.175486
R2807 VPWR.n1577 VPWR.n1576 0.175486
R2808 VPWR.n1534 VPWR.n1533 0.175486
R2809 VPWR.n1548 VPWR.n1521 0.175486
R2810 VPWR.n1550 VPWR.n1549 0.175486
R2811 VPWR.n1555 VPWR.n1554 0.175486
R2812 VPWR.n1560 VPWR.n1559 0.175486
R2813 VPWR.n1563 VPWR.n1562 0.175486
R2814 VPWR.n1564 VPWR.n1517 0.175486
R2815 VPWR.n1566 VPWR.n1565 0.175486
R2816 VPWR.n551 VPWR.n550 0.175486
R2817 VPWR.n546 VPWR.n545 0.175486
R2818 VPWR.n542 VPWR.n541 0.175486
R2819 VPWR.n536 VPWR.n535 0.175486
R2820 VPWR.n584 VPWR.n583 0.175486
R2821 VPWR.n623 VPWR.n622 0.175486
R2822 VPWR.n1407 VPWR.n1406 0.175486
R2823 VPWR.n1480 VPWR.n1479 0.175486
R2824 VPWR.n189 VPWR.n104 0.490181
R2825 VPWR.n102 VPWR.n1478 0.175486
R2826 VPWR.n1459 VPWR.n1458 0.175486
R2827 VPWR.n676 VPWR.n675 0.175486
R2828 VPWR.n1311 VPWR.n1310 0.175486
R2829 VPWR.n710 VPWR.n709 0.175486
R2830 VPWR.n1229 VPWR.n1228 0.175486
R2831 VPWR.n1231 VPWR.n1230 0.175486
R2832 VPWR.n1251 VPWR.n1250 0.175486
R2833 VPWR.n1252 VPWR.n1237 0.175486
R2834 VPWR.n1032 VPWR.n1031 0.175486
R2835 VPWR.n1022 VPWR.n1021 0.175486
R2836 VPWR.n1018 VPWR.n1017 0.175486
R2837 VPWR.n1014 VPWR.n1013 0.175486
R2838 VPWR.n1010 VPWR.n1009 0.175486
R2839 VPWR.n996 VPWR.n995 0.175486
R2840 VPWR.n784 VPWR.n772 0.175486
R2841 VPWR.n787 VPWR.n786 0.175486
R2842 VPWR.n799 VPWR.n765 0.175486
R2843 VPWR.n921 VPWR.n914 0.175486
R2844 VPWR.n926 VPWR.n913 0.175486
R2845 VPWR.n876 VPWR.n198 0.175486
R2846 VPWR.n1662 VPWR.n1661 0.174539
R2847 VPWR.n664 VPWR.n663 0.174539
R2848 VPWR.n853 VPWR.n852 0.174539
R2849 VPWR.n617 VPWR.n616 0.174236
R2850 VPWR.n613 VPWR.n612 0.172986
R2851 VPWR.n674 VPWR.n673 0.17275
R2852 VPWR.n1280 VPWR.n1279 0.172075
R2853 VPWR.n259 VPWR.n258 0.172056
R2854 VPWR.n1704 VPWR.n1703 0.169539
R2855 VPWR.n1170 VPWR.n1169 0.168289
R2856 VPWR.n631 VPWR.n630 0.167618
R2857 VPWR.n302 VPWR.n300 0.16689
R2858 VPWR.n426 VPWR.n425 0.16689
R2859 VPWR.n438 VPWR.n436 0.16689
R2860 VPWR.n1865 VPWR.n1863 0.16689
R2861 VPWR.n225 VPWR.n440 0.16689
R2862 VPWR.n15 VPWR.n13 0.16689
R2863 VPWR.n1593 VPWR.n1582 0.16689
R2864 VPWR.n1633 VPWR.n1631 0.16689
R2865 VPWR.n1599 VPWR.n1598 0.16689
R2866 VPWR.n1649 VPWR.n1648 0.16689
R2867 VPWR.n1515 VPWR.n667 0.16689
R2868 VPWR.n1464 VPWR.n1463 0.16689
R2869 VPWR.n1368 VPWR.n669 0.16689
R2870 VPWR.n1320 VPWR.n693 0.16689
R2871 VPWR.n162 VPWR.n1235 0.16689
R2872 VPWR.n1155 VPWR.n1154 0.16689
R2873 VPWR.n1046 VPWR.n1044 0.16689
R2874 VPWR.n1077 VPWR.n1069 0.16689
R2875 VPWR.n4 VPWR.n725 0.16689
R2876 VPWR.n860 VPWR.n858 0.16689
R2877 VPWR.n990 VPWR.n825 0.16689
R2878 VPWR.n302 VPWR.n301 0.166554
R2879 VPWR.n438 VPWR.n437 0.166554
R2880 VPWR.n1865 VPWR.n1864 0.166554
R2881 VPWR.n84 VPWR.n83 0.166554
R2882 VPWR.n15 VPWR.n14 0.166554
R2883 VPWR.n225 VPWR.n441 0.166554
R2884 VPWR.n159 VPWR.n475 0.166554
R2885 VPWR.n1593 VPWR.n1583 0.166554
R2886 VPWR.n1633 VPWR.n1632 0.166554
R2887 VPWR.n1515 VPWR.n668 0.166554
R2888 VPWR.n596 VPWR.n595 0.166554
R2889 VPWR.n1504 VPWR.n1503 0.166554
R2890 VPWR.n1428 VPWR.n1427 0.166554
R2891 VPWR.n50 VPWR.n49 0.166554
R2892 VPWR.n1272 VPWR.n1259 0.166554
R2893 VPWR.n1300 VPWR.n1258 0.166554
R2894 VPWR.n1320 VPWR.n1257 0.166554
R2895 VPWR.n1242 VPWR.n1241 0.166554
R2896 VPWR.n1046 VPWR.n1045 0.166554
R2897 VPWR.n1077 VPWR.n1070 0.166554
R2898 VPWR.n4 VPWR.n726 0.166554
R2899 VPWR.n824 VPWR.n823 0.166554
R2900 VPWR.n860 VPWR.n859 0.166554
R2901 VPWR.n1717 VPWR.n1716 0.162039
R2902 VPWR.n1420 VPWR.n1419 0.162039
R2903 VPWR.n1870 VPWR.n1869 0.160486
R2904 VPWR.n1552 VPWR.n1551 0.157039
R2905 VPWR.n407 VPWR.n406 0.154575
R2906 VPWR.n547 VPWR.n546 0.154575
R2907 VPWR.n1233 VPWR.n1232 0.154575
R2908 VPWR.n786 VPWR.n785 0.154575
R2909 VPWR.n1164 VPWR.n1163 0.154236
R2910 VPWR.n227 VPWR.n474 0.191868
R2911 VPWR.n1633 VPWR.n229 0.0768462
R2912 VPWR.n1649 VPWR.n231 0.0768462
R2913 VPWR.n1515 VPWR.n232 0.0768462
R2914 VPWR.n596 VPWR.n233 0.0768462
R2915 VPWR.n234 VPWR.n1462 0.201868
R2916 VPWR.n235 VPWR.n1272 0.0768462
R2917 VPWR.n1243 VPWR.n236 0.201868
R2918 VPWR.n203 VPWR.n202 0.192986
R2919 VPWR.n177 VPWR.n176 0.19275
R2920 VPWR.n1206 VPWR.n1205 0.152986
R2921 VPWR.n328 VPWR.n327 0.152039
R2922 VPWR.n316 VPWR.n315 0.152039
R2923 VPWR.n1713 VPWR.n1712 0.152039
R2924 VPWR.n554 VPWR.n553 0.149575
R2925 VPWR.n1167 VPWR.n1166 0.149575
R2926 VPWR.n329 VPWR.n328 0.149236
R2927 VPWR.n364 VPWR.n310 0.148289
R2928 VPWR.n323 VPWR.n322 0.147039
R2929 VPWR.n1622 VPWR.n1621 0.147039
R2930 VPWR.n688 VPWR.n687 0.147039
R2931 VPWR.n1330 VPWR.n1329 0.147039
R2932 VPWR.n1293 VPWR.n1292 0.146736
R2933 VPWR.n1192 VPWR.n119 0.146368
R2934 VPWR.n122 VPWR.n120 0.146368
R2935 VPWR.n1108 VPWR.n125 0.146368
R2936 VPWR.n1113 VPWR.n1112 0.146368
R2937 VPWR.n1203 VPWR.n1202 0.144575
R2938 VPWR.n335 VPWR.n331 0.142075
R2939 VPWR.n1261 VPWR.n1260 0.142075
R2940 VPWR.n1176 VPWR.n1175 0.142075
R2941 VPWR.n796 VPWR.n765 0.142075
R2942 VPWR.n421 VPWR.n420 0.141736
R2943 VPWR.n1174 VPWR.n1173 0.141736
R2944 VPWR.n1699 VPWR.n1698 0.139236
R2945 VPWR.n174 VPWR.n1420 0.139236
R2946 VPWR.n1234 VPWR.n1233 0.139236
R2947 VPWR.n898 VPWR.n897 0.139236
R2948 VPWR.n698 VPWR.n697 0.137609
R2949 VPWR.n1686 VPWR.n1685 0.136368
R2950 VPWR.n1720 VPWR.n1719 0.136368
R2951 VPWR.n1782 VPWR.n1781 0.135789
R2952 VPWR.n1785 VPWR.n1784 0.135789
R2953 VPWR.n464 VPWR.n463 0.135789
R2954 VPWR.n993 VPWR.n223 0.188195
R2955 VPWR.n1479 VPWR.n188 0.185825
R2956 VPWR.n175 VPWR.n174 0.185825
R2957 VPWR.n874 VPWR.n199 0.185486
R2958 VPWR.n197 VPWR.n196 0.185486
R2959 VPWR.n193 VPWR.n191 0.185486
R2960 VPWR.n1253 VPWR.n192 0.185486
R2961 VPWR.n187 VPWR.n189 0.185486
R2962 VPWR.n74 VPWR.n186 0.185486
R2963 VPWR.n1851 VPWR.n185 0.185486
R2964 VPWR.n184 VPWR.n183 0.185486
R2965 VPWR.n1795 VPWR.n182 0.185486
R2966 VPWR.n434 VPWR.n433 0.13351
R2967 VPWR.n402 VPWR.n401 0.13351
R2968 VPWR.n1774 VPWR.n1773 0.13351
R2969 VPWR.n1825 VPWR.n1824 0.13351
R2970 VPWR.n1545 VPWR.n1544 0.13351
R2971 VPWR.n46 VPWR.n44 0.13351
R2972 VPWR.n1403 VPWR.n1402 0.13351
R2973 VPWR.n1363 VPWR.n1362 0.13351
R2974 VPWR.n1190 VPWR.n702 0.13351
R2975 VPWR.n88 VPWR.n87 0.13351
R2976 VPWR.n138 VPWR.n137 0.13351
R2977 VPWR.n64 VPWR.n63 0.13351
R2978 VPWR.n1173 VPWR.n1172 0.133325
R2979 VPWR.n290 VPWR.n289 0.133174
R2980 VPWR.n1777 VPWR.n1776 0.133174
R2981 VPWR.n1663 VPWR.n1656 0.133174
R2982 VPWR.n1727 VPWR.n1652 0.133174
R2983 VPWR.n1603 VPWR.n1597 0.133174
R2984 VPWR.n46 VPWR.n45 0.133174
R2985 VPWR.n662 VPWR.n593 0.133174
R2986 VPWR.n1383 VPWR.n1382 0.133174
R2987 VPWR.n1405 VPWR.n1404 0.133174
R2988 VPWR.n1434 VPWR.n1433 0.133174
R2989 VPWR.n1182 VPWR.n1181 0.133174
R2990 VPWR.n1039 VPWR.n1038 0.133174
R2991 VPWR.n838 VPWR.n837 0.133174
R2992 VPWR.n863 VPWR.n862 0.133174
R2993 VPWR.n418 VPWR.n417 0.132986
R2994 VPWR.n1264 VPWR.n1263 0.132986
R2995 VPWR.n1171 VPWR.n1170 0.132986
R2996 VPWR.n802 VPWR.n801 0.132986
R2997 VPWR.n1688 VPWR.n1687 0.132075
R2998 VPWR.n1410 VPWR.n1374 0.132075
R2999 VPWR.n1194 VPWR.n1193 0.132075
R3000 VPWR.n1099 VPWR.n1059 0.132075
R3001 VPWR.n1283 VPWR.n1282 0.129539
R3002 VPWR.n1684 VPWR.n1655 0.12922
R3003 VPWR.n632 VPWR.n594 0.12922
R3004 VPWR.n1446 VPWR.n1445 0.12922
R3005 VPWR.n212 VPWR.n211 0.12922
R3006 VPWR.n156 VPWR.n155 0.12922
R3007 VPWR.n122 VPWR.n121 0.12922
R3008 VPWR.n125 VPWR.n124 0.12922
R3009 VPWR.n1111 VPWR.n1110 0.12922
R3010 VPWR.n82 VPWR.n1808 0.128884
R3011 VPWR.n1718 VPWR.n1653 0.128884
R3012 VPWR.n209 VPWR.n208 0.128884
R3013 VPWR.n603 VPWR.n602 0.128884
R3014 VPWR.n1409 VPWR.n1408 0.128884
R3015 VPWR.n130 VPWR.n129 0.128884
R3016 VPWR.n119 VPWR.n118 0.128884
R3017 VPWR.n178 VPWR.n699 0.128884
R3018 VPWR.n100 VPWR.n99 0.128884
R3019 VPWR.n215 VPWR.n214 0.128884
R3020 VPWR.n1505 VPWR.n1504 0.127578
R3021 VPWR.n427 VPWR.n424 0.127444
R3022 VPWR.n1156 VPWR.n1153 0.127444
R3023 VPWR.n287 VPWR.n265 0.126736
R3024 VPWR.n406 VPWR.n405 0.126736
R3025 VPWR.n1591 VPWR.n1590 0.126736
R3026 VPWR.n1596 VPWR.n1595 0.126736
R3027 VPWR.n1431 VPWR.n1430 0.126736
R3028 VPWR.n1364 VPWR.n681 0.126736
R3029 VPWR.n1269 VPWR.n1268 0.126736
R3030 VPWR.n1298 VPWR.n1297 0.126736
R3031 VPWR.n928 VPWR.n927 0.126736
R3032 VPWR.n911 VPWR.n910 0.126736
R3033 VPWR.n1920 VPWR.n1918 0.125789
R3034 VPWR.n1930 VPWR.n1928 0.125789
R3035 VPWR.n1936 VPWR.n1935 0.125789
R3036 VPWR.n1937 VPWR.n1936 0.125789
R3037 VPWR.n268 VPWR.n267 0.125789
R3038 VPWR.n274 VPWR.n267 0.125789
R3039 VPWR.n277 VPWR.n276 0.125789
R3040 VPWR.n278 VPWR.n277 0.125789
R3041 VPWR.n280 VPWR.n279 0.125789
R3042 VPWR.n285 VPWR.n283 0.125789
R3043 VPWR.n294 VPWR.n292 0.125789
R3044 VPWR.n294 VPWR.n293 0.125789
R3045 VPWR.n1881 VPWR.n1880 0.125789
R3046 VPWR.n327 VPWR.n326 0.125789
R3047 VPWR.n324 VPWR.n323 0.125789
R3048 VPWR.n339 VPWR.n321 0.125789
R3049 VPWR.n343 VPWR.n341 0.125789
R3050 VPWR.n356 VPWR.n354 0.125789
R3051 VPWR.n311 VPWR.n310 0.125789
R3052 VPWR.n308 VPWR.n307 0.125789
R3053 VPWR.n373 VPWR.n371 0.125789
R3054 VPWR.n305 VPWR.n136 0.400178
R3055 VPWR.n304 VPWR.n142 0.297516
R3056 VPWR.n414 VPWR.n413 0.125789
R3057 VPWR.n404 VPWR.n403 0.125789
R3058 VPWR.n399 VPWR.n398 0.125789
R3059 VPWR.n398 VPWR.n397 0.125789
R3060 VPWR.n396 VPWR.n395 0.125789
R3061 VPWR.n392 VPWR.n391 0.125789
R3062 VPWR.n387 VPWR.n386 0.125789
R3063 VPWR.n386 VPWR.n385 0.125789
R3064 VPWR.n384 VPWR.n383 0.125789
R3065 VPWR.n1821 VPWR.n1820 0.125789
R3066 VPWR.n1831 VPWR.n1816 0.125789
R3067 VPWR.n1835 VPWR.n1834 0.125789
R3068 VPWR.n1766 VPWR.n1757 0.125789
R3069 VPWR.n1770 VPWR.n1769 0.125789
R3070 VPWR.n1779 VPWR.n1750 0.125789
R3071 VPWR.n1783 VPWR.n1782 0.125789
R3072 VPWR.n1743 VPWR.n1742 0.125789
R3073 VPWR.n1792 VPWR.n1742 0.125789
R3074 VPWR.n1796 VPWR.n1739 0.125789
R3075 VPWR.n1800 VPWR.n1799 0.125789
R3076 VPWR.n1801 VPWR.n1736 0.125789
R3077 VPWR.n1805 VPWR.n1804 0.125789
R3078 VPWR.n1807 VPWR.n1806 0.125789
R3079 VPWR.n1857 VPWR.n1856 0.125789
R3080 VPWR.n452 VPWR.n451 0.125789
R3081 VPWR.n1670 VPWR.n1669 0.125789
R3082 VPWR.n1679 VPWR.n1678 0.125789
R3083 VPWR.n1680 VPWR.n1679 0.125789
R3084 VPWR.n146 VPWR.n145 0.306741
R3085 VPWR.n1714 VPWR.n1713 0.125789
R3086 VPWR.n18 VPWR.n17 0.823797
R3087 VPWR.n480 VPWR.n479 0.125789
R3088 VPWR.n476 VPWR.n161 0.246412
R3089 VPWR.n463 VPWR.n462 0.125789
R3090 VPWR.n1616 VPWR.n1615 0.125789
R3091 VPWR.n1609 VPWR.n1608 0.125789
R3092 VPWR.n1536 VPWR.n1534 0.125789
R3093 VPWR.n1536 VPWR.n1535 0.125789
R3094 VPWR.n1541 VPWR.n1539 0.125789
R3095 VPWR.n1552 VPWR.n1550 0.125789
R3096 VPWR.n1557 VPWR.n1555 0.125789
R3097 VPWR.n1644 VPWR.n1643 0.125789
R3098 VPWR.n1640 VPWR.n1639 0.125789
R3099 VPWR.n1638 VPWR.n1637 0.125789
R3100 VPWR.n533 VPWR.n532 0.125789
R3101 VPWR.n531 VPWR.n530 0.125789
R3102 VPWR.n527 VPWR.n526 0.125789
R3103 VPWR.n658 VPWR.n657 0.125789
R3104 VPWR.n656 VPWR.n655 0.125789
R3105 VPWR.n655 VPWR.n654 0.125789
R3106 VPWR.n652 VPWR.n651 0.125789
R3107 VPWR.n651 VPWR.n650 0.125789
R3108 VPWR.n648 VPWR.n647 0.125789
R3109 VPWR.n647 VPWR.n646 0.125789
R3110 VPWR.n644 VPWR.n643 0.125789
R3111 VPWR.n643 VPWR.n642 0.125789
R3112 VPWR.n633 VPWR.n144 0.125789
R3113 VPWR.n509 VPWR.n508 0.125789
R3114 VPWR.n511 VPWR.n504 0.125789
R3115 VPWR.n47 VPWR.n515 0.535376
R3116 VPWR.n1392 VPWR.n1391 0.125789
R3117 VPWR.n1401 VPWR.n1399 0.125789
R3118 VPWR.n1376 VPWR.n1375 0.125789
R3119 VPWR.n1372 VPWR.n1371 0.125789
R3120 VPWR.n1415 VPWR.n1371 0.125789
R3121 VPWR.n151 VPWR.n1417 0.328488
R3122 VPWR.n1435 VPWR.n1432 0.125789
R3123 VPWR.n1423 VPWR.n1422 0.125789
R3124 VPWR.n1436 VPWR.n1422 0.125789
R3125 VPWR.n1439 VPWR.n1438 0.125789
R3126 VPWR.n1440 VPWR.n1439 0.125789
R3127 VPWR.n1366 VPWR.n1365 0.125789
R3128 VPWR.n1358 VPWR.n1357 0.125789
R3129 VPWR.n1348 VPWR.n1347 0.125789
R3130 VPWR.n1347 VPWR.n1346 0.125789
R3131 VPWR.n1344 VPWR.n1343 0.125789
R3132 VPWR.n680 VPWR.n679 0.125789
R3133 VPWR.n1306 VPWR.n1305 0.125789
R3134 VPWR.n1307 VPWR.n1306 0.125789
R3135 VPWR.n711 VPWR.n710 0.125789
R3136 VPWR.n712 VPWR.n711 0.125789
R3137 VPWR.n715 VPWR.n714 0.125789
R3138 VPWR.n716 VPWR.n715 0.125789
R3139 VPWR.n117 VPWR.n116 0.341512
R3140 VPWR.n1199 VPWR.n1198 0.125789
R3141 VPWR.n1215 VPWR.n1214 0.125789
R3142 VPWR.n1216 VPWR.n1215 0.125789
R3143 VPWR.t26 VPWR.n3 0.837041
R3144 VPWR.n1236 VPWR.n164 0.246412
R3145 VPWR.n100 VPWR.n98 0.125789
R3146 VPWR.n1082 VPWR.n1081 0.125789
R3147 VPWR.n1066 VPWR.n1065 0.125789
R3148 VPWR.n1096 VPWR.n1060 0.125789
R3149 VPWR.n123 VPWR.n1098 0.341512
R3150 VPWR.n1104 VPWR.n1103 0.125789
R3151 VPWR.n1057 VPWR.n1056 0.125789
R3152 VPWR.n1105 VPWR.n1056 0.125789
R3153 VPWR.n126 VPWR.n1107 0.341512
R3154 VPWR.n1152 VPWR.n1151 0.125789
R3155 VPWR.n1007 VPWR.n1006 0.125789
R3156 VPWR.n1006 VPWR.n1005 0.125789
R3157 VPWR.n1001 VPWR.n1000 0.125789
R3158 VPWR.n999 VPWR.n998 0.125789
R3159 VPWR.n735 VPWR.n734 0.125789
R3160 VPWR.n740 VPWR.n738 0.125789
R3161 VPWR.n740 VPWR.n739 0.125789
R3162 VPWR.n789 VPWR.n787 0.125789
R3163 VPWR.n789 VPWR.n788 0.125789
R3164 VPWR.n770 VPWR.n769 0.125789
R3165 VPWR.n769 VPWR.n768 0.125789
R3166 VPWR.n759 VPWR.n758 0.125789
R3167 VPWR.n803 VPWR.n758 0.125789
R3168 VPWR.n807 VPWR.n805 0.125789
R3169 VPWR.n807 VPWR.n806 0.125789
R3170 VPWR.n811 VPWR.n810 0.125789
R3171 VPWR.n814 VPWR.n812 0.125789
R3172 VPWR.n755 VPWR.n754 0.125789
R3173 VPWR.n819 VPWR.n817 0.125789
R3174 VPWR.n749 VPWR.n748 0.125789
R3175 VPWR.n748 VPWR.n747 0.125789
R3176 VPWR.n745 VPWR.n139 0.351785
R3177 VPWR.n872 VPWR.n870 0.125789
R3178 VPWR.n879 VPWR.n846 0.125789
R3179 VPWR.n885 VPWR.n883 0.125789
R3180 VPWR.n843 VPWR.n842 0.125789
R3181 VPWR.n890 VPWR.n888 0.125789
R3182 VPWR.n892 VPWR.n891 0.125789
R3183 VPWR.n132 VPWR.n892 0.125789
R3184 VPWR.n841 VPWR.n840 0.125789
R3185 VPWR.n900 VPWR.n831 0.125789
R3186 VPWR.n980 VPWR.n979 0.125789
R3187 VPWR.n976 VPWR.n975 0.125789
R3188 VPWR.n971 VPWR.n970 0.125789
R3189 VPWR.n970 VPWR.n969 0.125789
R3190 VPWR.n968 VPWR.n967 0.125789
R3191 VPWR.n964 VPWR.n963 0.125789
R3192 VPWR.n960 VPWR.n959 0.125789
R3193 VPWR.n956 VPWR.n955 0.125789
R3194 VPWR.n952 VPWR.n951 0.125789
R3195 VPWR.n435 VPWR.n434 0.124539
R3196 VPWR.n1825 VPWR.n1821 0.124539
R3197 VPWR.n1728 VPWR.n1727 0.124539
R3198 VPWR.n1603 VPWR.n1602 0.124539
R3199 VPWR.n1547 VPWR.n1545 0.124539
R3200 VPWR.n64 VPWR.n62 0.124539
R3201 VPWR.n838 VPWR.n836 0.124539
R3202 VPWR.n1701 VPWR.n1700 0.121736
R3203 VPWR.n1289 VPWR.n1288 0.118289
R3204 VPWR.n28 VPWR.n1846 0.117444
R3205 VPWR.n12 VPWR.n11 0.735195
R3206 VPWR.n989 VPWR.n988 0.117444
R3207 VPWR.n403 VPWR.n402 0.117039
R3208 VPWR.n1663 VPWR.n1662 0.117039
R3209 VPWR.n663 VPWR.n662 0.117039
R3210 VPWR.n152 VPWR.n158 0.223984
R3211 VPWR.n1435 VPWR.n1434 0.117039
R3212 VPWR.n1366 VPWR.n1363 0.117039
R3213 VPWR.n863 VPWR.n852 0.117039
R3214 VPWR.n255 VPWR.n254 0.115789
R3215 VPWR.n1898 VPWR.n254 0.115789
R3216 VPWR.n252 VPWR.n251 0.115789
R3217 VPWR.n1900 VPWR.n251 0.115789
R3218 VPWR.n1904 VPWR.n1902 0.115789
R3219 VPWR.n1904 VPWR.n1903 0.115789
R3220 VPWR.n249 VPWR.n248 0.115789
R3221 VPWR.n1905 VPWR.n248 0.115789
R3222 VPWR.n1909 VPWR.n1907 0.115789
R3223 VPWR.n1909 VPWR.n1908 0.115789
R3224 VPWR.n246 VPWR.n245 0.115789
R3225 VPWR.n1910 VPWR.n245 0.115789
R3226 VPWR.n1920 VPWR.n1919 0.115789
R3227 VPWR.n1925 VPWR.n1923 0.115789
R3228 VPWR.n1925 VPWR.n1924 0.115789
R3229 VPWR.n1930 VPWR.n1929 0.115789
R3230 VPWR.n1934 VPWR.n1933 0.115789
R3231 VPWR.n1935 VPWR.n1934 0.115789
R3232 VPWR.n180 VPWR.n1937 0.17313
R3233 VPWR.n280 VPWR.n278 0.115789
R3234 VPWR.n285 VPWR.n284 0.115789
R3235 VPWR.n299 VPWR.n297 0.115789
R3236 VPWR.n299 VPWR.n298 0.115789
R3237 VPWR.n261 VPWR.n260 0.115789
R3238 VPWR.n435 VPWR.n432 0.115789
R3239 VPWR.n430 VPWR.n429 0.115789
R3240 VPWR.n1881 VPWR.n1879 0.115789
R3241 VPWR.n1876 VPWR.n1875 0.115789
R3242 VPWR.n1885 VPWR.n1875 0.115789
R3243 VPWR.n1889 VPWR.n1887 0.115789
R3244 VPWR.n330 VPWR.n149 0.29553
R3245 VPWR.n326 VPWR.n325 0.115789
R3246 VPWR.n325 VPWR.n324 0.115789
R3247 VPWR.n343 VPWR.n342 0.115789
R3248 VPWR.n348 VPWR.n346 0.115789
R3249 VPWR.n348 VPWR.n347 0.115789
R3250 VPWR.n353 VPWR.n351 0.115789
R3251 VPWR.n353 VPWR.n352 0.115789
R3252 VPWR.n360 VPWR.n315 0.115789
R3253 VPWR.n312 VPWR.n311 0.115789
R3254 VPWR.n373 VPWR.n372 0.115789
R3255 VPWR.n424 VPWR.n423 0.115789
R3256 VPWR.n423 VPWR.n422 0.115789
R3257 VPWR.n410 VPWR.n409 0.115789
R3258 VPWR.n409 VPWR.n408 0.115789
R3259 VPWR.n397 VPWR.n396 0.115789
R3260 VPWR.n393 VPWR.n392 0.115789
R3261 VPWR.n385 VPWR.n384 0.115789
R3262 VPWR.n1817 VPWR.n1816 0.115789
R3263 VPWR.n1835 VPWR.n1833 0.115789
R3264 VPWR.n1840 VPWR.n1838 0.115789
R3265 VPWR.n1840 VPWR.n1839 0.115789
R3266 VPWR.n1813 VPWR.n1812 0.115789
R3267 VPWR.n1841 VPWR.n1812 0.115789
R3268 VPWR.n1845 VPWR.n1843 0.115789
R3269 VPWR.n1845 VPWR.n1844 0.115789
R3270 VPWR.n1810 VPWR.n1809 0.115789
R3271 VPWR.n1761 VPWR.n1760 0.115789
R3272 VPWR.n1764 VPWR.n1760 0.115789
R3273 VPWR.n1758 VPWR.n1757 0.115789
R3274 VPWR.n1770 VPWR.n1768 0.115789
R3275 VPWR.n1755 VPWR.n1754 0.115789
R3276 VPWR.n1751 VPWR.n1750 0.115789
R3277 VPWR.n1785 VPWR.n1783 0.115789
R3278 VPWR.n1748 VPWR.n1747 0.115789
R3279 VPWR.n1786 VPWR.n1747 0.115789
R3280 VPWR.n1790 VPWR.n1788 0.115789
R3281 VPWR.n1790 VPWR.n1789 0.115789
R3282 VPWR.n1745 VPWR.n1744 0.115789
R3283 VPWR.n1744 VPWR.n1743 0.115789
R3284 VPWR.n1740 VPWR.n1739 0.115789
R3285 VPWR.n1800 VPWR.n1798 0.115789
R3286 VPWR.n1737 VPWR.n1736 0.115789
R3287 VPWR.n1804 VPWR.n1803 0.115789
R3288 VPWR.n1807 VPWR.n1805 0.115789
R3289 VPWR.n1734 VPWR.n141 0.375484
R3290 VPWR.n1862 VPWR.n1861 0.115789
R3291 VPWR.n1848 VPWR.n1847 0.115789
R3292 VPWR.n1853 VPWR.n1847 0.115789
R3293 VPWR.n453 VPWR.n452 0.115789
R3294 VPWR.n457 VPWR.n455 0.115789
R3295 VPWR.n457 VPWR.n456 0.115789
R3296 VPWR.n444 VPWR.n443 0.115789
R3297 VPWR.n458 VPWR.n443 0.115789
R3298 VPWR.n461 VPWR.n460 0.115789
R3299 VPWR.n1660 VPWR.n1659 0.115789
R3300 VPWR.n1669 VPWR.n1668 0.115789
R3301 VPWR.n1671 VPWR.n1670 0.115789
R3302 VPWR.n1672 VPWR.n1671 0.115789
R3303 VPWR.n1677 VPWR.n1676 0.115789
R3304 VPWR.n1678 VPWR.n1677 0.115789
R3305 VPWR.n1692 VPWR.n1691 0.115789
R3306 VPWR.n1693 VPWR.n1692 0.115789
R3307 VPWR.n1696 VPWR.n1695 0.115789
R3308 VPWR.n1697 VPWR.n1696 0.115789
R3309 VPWR.n1715 VPWR.n1714 0.115789
R3310 VPWR.n495 VPWR.n494 0.115789
R3311 VPWR.n494 VPWR.n493 0.115789
R3312 VPWR.n491 VPWR.n490 0.115789
R3313 VPWR.n490 VPWR.n489 0.115789
R3314 VPWR.n487 VPWR.n486 0.115789
R3315 VPWR.n486 VPWR.n485 0.115789
R3316 VPWR.n483 VPWR.n482 0.115789
R3317 VPWR.n482 VPWR.n481 0.115789
R3318 VPWR.n479 VPWR.n478 0.115789
R3319 VPWR.n472 VPWR.n471 0.115789
R3320 VPWR.n471 VPWR.n470 0.115789
R3321 VPWR.n466 VPWR.n465 0.115789
R3322 VPWR.n462 VPWR.n172 0.204398
R3323 VPWR.n1575 VPWR.n1574 0.115789
R3324 VPWR.n1574 VPWR.n1573 0.115789
R3325 VPWR.n1571 VPWR.n1570 0.115789
R3326 VPWR.n1570 VPWR.n1569 0.115789
R3327 VPWR.n1586 VPWR.n1585 0.115789
R3328 VPWR.n1587 VPWR.n1586 0.115789
R3329 VPWR.n1628 VPWR.n1627 0.115789
R3330 VPWR.n1623 VPWR.n1622 0.115789
R3331 VPWR.n1617 VPWR.n1616 0.115789
R3332 VPWR.n1531 VPWR.n1529 0.115789
R3333 VPWR.n1531 VPWR.n1530 0.115789
R3334 VPWR.n1525 VPWR.n1524 0.115789
R3335 VPWR.n1532 VPWR.n1524 0.115789
R3336 VPWR.n1547 VPWR.n1546 0.115789
R3337 VPWR.n1645 VPWR.n1644 0.115789
R3338 VPWR.n1641 VPWR.n1640 0.115789
R3339 VPWR.n1639 VPWR.n1638 0.115789
R3340 VPWR.n568 VPWR.n567 0.115789
R3341 VPWR.n567 VPWR.n566 0.115789
R3342 VPWR.n561 VPWR.n560 0.115789
R3343 VPWR.n557 VPWR.n556 0.115789
R3344 VPWR.n556 VPWR.n555 0.115789
R3345 VPWR.n539 VPWR.n538 0.115789
R3346 VPWR.n538 VPWR.n537 0.115789
R3347 VPWR.n532 VPWR.n531 0.115789
R3348 VPWR.n530 VPWR.n529 0.115789
R3349 VPWR.n526 VPWR.n525 0.115789
R3350 VPWR.n521 VPWR.n520 0.115789
R3351 VPWR.n520 VPWR.n519 0.115789
R3352 VPWR.n577 VPWR.n576 0.115789
R3353 VPWR.n588 VPWR.n576 0.115789
R3354 VPWR.n592 VPWR.n590 0.115789
R3355 VPWR.n666 VPWR.n665 0.115789
R3356 VPWR.n657 VPWR.n656 0.115789
R3357 VPWR.n642 VPWR.n641 0.115789
R3358 VPWR.n641 VPWR.n640 0.115789
R3359 VPWR.n638 VPWR.n637 0.115789
R3360 VPWR.n625 VPWR.n624 0.115789
R3361 VPWR.n509 VPWR.n507 0.115789
R3362 VPWR.n505 VPWR.n504 0.115789
R3363 VPWR.n1393 VPWR.n1392 0.115789
R3364 VPWR.n1396 VPWR.n1395 0.115789
R3365 VPWR.n1379 VPWR.n1378 0.115789
R3366 VPWR.n1426 VPWR.n1425 0.115789
R3367 VPWR.n1429 VPWR.n1425 0.115789
R3368 VPWR.n1442 VPWR.n1440 0.115789
R3369 VPWR.n1442 VPWR.n1441 0.115789
R3370 VPWR.n1455 VPWR.n1453 0.115789
R3371 VPWR.n1455 VPWR.n1454 0.115789
R3372 VPWR.n1502 VPWR.n1501 0.115789
R3373 VPWR.n1501 VPWR.n1500 0.115789
R3374 VPWR.n1498 VPWR.n1497 0.115789
R3375 VPWR.n1497 VPWR.n1496 0.115789
R3376 VPWR.n1494 VPWR.n1493 0.115789
R3377 VPWR.n1493 VPWR.n1492 0.115789
R3378 VPWR.n1490 VPWR.n1489 0.115789
R3379 VPWR.n1489 VPWR.n1488 0.115789
R3380 VPWR.n1486 VPWR.n1485 0.115789
R3381 VPWR.n1485 VPWR.n1484 0.115789
R3382 VPWR.n1473 VPWR.n1472 0.115789
R3383 VPWR.n1472 VPWR.n1471 0.115789
R3384 VPWR.n1469 VPWR.n1468 0.115789
R3385 VPWR.n1462 VPWR.n1461 0.115789
R3386 VPWR.n1461 VPWR.n1460 0.115789
R3387 VPWR.n683 VPWR.n682 0.115789
R3388 VPWR.n1333 VPWR.n682 0.115789
R3389 VPWR.n1337 VPWR.n1335 0.115789
R3390 VPWR.n1337 VPWR.n1336 0.115789
R3391 VPWR.n1357 VPWR.n1356 0.115789
R3392 VPWR.n1346 VPWR.n1345 0.115789
R3393 VPWR.n1345 VPWR.n1344 0.115789
R3394 VPWR.n1266 VPWR.n1265 0.115789
R3395 VPWR.n1267 VPWR.n1266 0.115789
R3396 VPWR.n70 VPWR.n69 0.527255
R3397 VPWR.n1288 VPWR.n1287 0.115789
R3398 VPWR.n1304 VPWR.n1303 0.115789
R3399 VPWR.n1305 VPWR.n1304 0.115789
R3400 VPWR.n1314 VPWR.n1313 0.115789
R3401 VPWR.n1315 VPWR.n1314 0.115789
R3402 VPWR.n1318 VPWR.n1317 0.115789
R3403 VPWR.n700 VPWR.n130 0.168691
R3404 VPWR.n705 VPWR.n704 0.115789
R3405 VPWR.n706 VPWR.n705 0.115789
R3406 VPWR.n717 VPWR.n716 0.115789
R3407 VPWR.n718 VPWR.n717 0.115789
R3408 VPWR.n721 VPWR.n720 0.115789
R3409 VPWR.n1198 VPWR.n1197 0.115789
R3410 VPWR.n1217 VPWR.n1216 0.115789
R3411 VPWR.n1218 VPWR.n1217 0.115789
R3412 VPWR.n1221 VPWR.n1220 0.115789
R3413 VPWR.n1222 VPWR.n1221 0.115789
R3414 VPWR.n79 VPWR.n1225 0.115789
R3415 VPWR.n1239 VPWR.n1238 0.115789
R3416 VPWR.n1244 VPWR.n1238 0.115789
R3417 VPWR.n1247 VPWR.n1246 0.115789
R3418 VPWR.n1160 VPWR.n1159 0.115789
R3419 VPWR.n1051 VPWR.n1050 0.115789
R3420 VPWR.n1074 VPWR.n1073 0.115789
R3421 VPWR.n1082 VPWR.n1080 0.115789
R3422 VPWR.n1067 VPWR.n1066 0.115789
R3423 VPWR.n1065 VPWR.n1064 0.115789
R3424 VPWR.n1083 VPWR.n1064 0.115789
R3425 VPWR.n1087 VPWR.n1085 0.115789
R3426 VPWR.n1087 VPWR.n1086 0.115789
R3427 VPWR.n1095 VPWR.n1093 0.115789
R3428 VPWR.n1104 VPWR.n1102 0.115789
R3429 VPWR.n1116 VPWR.n1115 0.115789
R3430 VPWR.n1054 VPWR.n1053 0.115789
R3431 VPWR.n1118 VPWR.n1053 0.115789
R3432 VPWR.n88 VPWR.n86 0.178479
R3433 VPWR.n1153 VPWR.n1152 0.115789
R3434 VPWR.n1151 VPWR.n1150 0.115789
R3435 VPWR.n1150 VPWR.n1149 0.115789
R3436 VPWR.n1147 VPWR.n1146 0.115789
R3437 VPWR.n1146 VPWR.n1145 0.115789
R3438 VPWR.n1143 VPWR.n1142 0.115789
R3439 VPWR.n1142 VPWR.n1141 0.115789
R3440 VPWR.n1139 VPWR.n1138 0.115789
R3441 VPWR.n1138 VPWR.n1137 0.115789
R3442 VPWR.n1135 VPWR.n1134 0.115789
R3443 VPWR.n1134 VPWR.n1133 0.115789
R3444 VPWR.n1131 VPWR.n1130 0.115789
R3445 VPWR.n1130 VPWR.n1129 0.115789
R3446 VPWR.n1127 VPWR.n1126 0.115789
R3447 VPWR.n1126 VPWR.n1125 0.115789
R3448 VPWR.n1027 VPWR.n1026 0.115789
R3449 VPWR.n1026 VPWR.n1025 0.115789
R3450 VPWR.n1000 VPWR.n999 0.115789
R3451 VPWR.n998 VPWR.n997 0.115789
R3452 VPWR.n735 VPWR.n733 0.115789
R3453 VPWR.n744 VPWR.n743 0.115789
R3454 VPWR.n778 VPWR.n776 0.115789
R3455 VPWR.n774 VPWR.n773 0.115789
R3456 VPWR.n783 VPWR.n781 0.115789
R3457 VPWR.n783 VPWR.n782 0.115789
R3458 VPWR.n768 VPWR.n767 0.115789
R3459 VPWR.n790 VPWR.n767 0.115789
R3460 VPWR.n794 VPWR.n792 0.115789
R3461 VPWR.n794 VPWR.n793 0.115789
R3462 VPWR.n762 VPWR.n761 0.115789
R3463 VPWR.n761 VPWR.n760 0.115789
R3464 VPWR.n62 VPWR.n759 0.115789
R3465 VPWR.n812 VPWR.n811 0.115789
R3466 VPWR.n814 VPWR.n813 0.115789
R3467 VPWR.n815 VPWR.n754 0.115789
R3468 VPWR.n819 VPWR.n818 0.115789
R3469 VPWR.n747 VPWR.n746 0.115789
R3470 VPWR.n746 VPWR.n745 0.115789
R3471 VPWR.n920 VPWR.n918 0.115789
R3472 VPWR.n920 VPWR.n919 0.115789
R3473 VPWR.n925 VPWR.n923 0.115789
R3474 VPWR.n925 VPWR.n924 0.115789
R3475 VPWR.n855 VPWR.n854 0.115789
R3476 VPWR.n872 VPWR.n871 0.115789
R3477 VPWR.n847 VPWR.n846 0.115789
R3478 VPWR.n885 VPWR.n884 0.115789
R3479 VPWR.n886 VPWR.n842 0.115789
R3480 VPWR.n890 VPWR.n889 0.115789
R3481 VPWR.n133 VPWR.n132 0.173544
R3482 VPWR.n109 VPWR.n836 0.115789
R3483 VPWR.n835 VPWR.n834 0.115789
R3484 VPWR.n896 VPWR.n834 0.115789
R3485 VPWR.n832 VPWR.n831 0.115789
R3486 VPWR.n908 VPWR.n906 0.115789
R3487 VPWR.n908 VPWR.n907 0.115789
R3488 VPWR.n828 VPWR.n827 0.115789
R3489 VPWR.n909 VPWR.n827 0.115789
R3490 VPWR.n977 VPWR.n976 0.115789
R3491 VPWR.n969 VPWR.n968 0.115789
R3492 VPWR.n965 VPWR.n964 0.115789
R3493 VPWR.n961 VPWR.n960 0.115789
R3494 VPWR.n957 VPWR.n956 0.115789
R3495 VPWR.n953 VPWR.n952 0.115789
R3496 VPWR.n951 VPWR.n950 0.115789
R3497 VPWR.n950 VPWR.n949 0.115789
R3498 VPWR.n945 VPWR.n944 0.115789
R3499 VPWR.n944 VPWR.n943 0.115789
R3500 VPWR.n937 VPWR.n936 0.115789
R3501 VPWR.n933 VPWR.n932 0.115789
R3502 VPWR.n932 VPWR.n931 0.115789
R3503 VPWR.n929 VPWR.n221 0.163125
R3504 VPWR.n1762 VPWR.n1761 0.115708
R3505 VPWR.n731 VPWR.n730 0.115708
R3506 VPWR.n916 VPWR.n915 0.115708
R3507 VPWR.n288 VPWR.n287 0.11425
R3508 VPWR.n428 VPWR.n374 0.11425
R3509 VPWR.n1888 VPWR.n1874 0.11425
R3510 VPWR.n1868 VPWR.n1867 0.11425
R3511 VPWR.n1823 VPWR.n1822 0.11425
R3512 VPWR.n1730 VPWR.n442 0.11425
R3513 VPWR.n1724 VPWR.n1723 0.11425
R3514 VPWR.n1592 VPWR.n1591 0.11425
R3515 VPWR.n1595 VPWR.n1581 0.11425
R3516 VPWR.n1607 VPWR.n1606 0.11425
R3517 VPWR.n1601 VPWR.n1600 0.11425
R3518 VPWR.n1540 VPWR.n1522 0.11425
R3519 VPWR.n591 VPWR.n575 0.11425
R3520 VPWR.n598 VPWR.n597 0.11425
R3521 VPWR.n1510 VPWR.n1370 0.11425
R3522 VPWR.n1400 VPWR.n200 0.11425
R3523 VPWR.n1367 VPWR.n670 0.11425
R3524 VPWR.n723 VPWR.n722 0.11425
R3525 VPWR.n1184 VPWR.n1047 0.11425
R3526 VPWR.n1076 VPWR.n1075 0.11425
R3527 VPWR.n1041 VPWR.n727 0.11425
R3528 VPWR.n927 VPWR.n912 0.11425
R3529 VPWR.n895 VPWR.n894 0.11425
R3530 VPWR.n608 VPWR.n607 0.113289
R3531 VPWR.n1284 VPWR.n1283 0.112039
R3532 VPWR.n694 VPWR.n131 0.426905
R3533 VPWR.n157 VPWR.n1061 0.268309
R3534 VPWR.n1285 VPWR.n1284 0.108289
R3535 VPWR.n355 VPWR.n318 0.108
R3536 VPWR.n1707 VPWR.n1706 0.108
R3537 VPWR.n448 VPWR.n447 0.106914
R3538 VPWR.n1771 VPWR.n1754 0.105789
R3539 VPWR.n465 VPWR.n464 0.105789
R3540 VPWR.n1343 VPWR.n1342 0.105789
R3541 VPWR.n936 VPWR.n935 0.105789
R3542 VPWR.n1701 VPWR.n1654 0.103002
R3543 VPWR.n636 VPWR.n635 0.10175
R3544 VPWR.n1449 VPWR.n1418 0.10175
R3545 VPWR.n1278 VPWR.n1277 0.10175
R3546 VPWR.n1094 VPWR.n156 0.150862
R3547 VPWR.n897 VPWR.n833 0.10175
R3548 VPWR.n563 VPWR.n562 0.09925
R3549 VPWR.n691 VPWR.n690 0.09925
R3550 VPWR.n1331 VPWR.n684 0.09925
R3551 VPWR.n1260 VPWR.n43 0.572349
R3552 VPWR.n1177 VPWR.n1176 0.09925
R3553 VPWR.n1702 VPWR.n1701 0.098
R3554 VPWR.n368 VPWR.n367 0.09675
R3555 VPWR.n606 VPWR.n605 0.09675
R3556 VPWR.n1854 VPWR.n1853 0.0958247
R3557 VPWR.n1458 VPWR.n1457 0.0958247
R3558 VPWR.n322 VPWR.n321 0.094539
R3559 VPWR.n313 VPWR.n312 0.094539
R3560 VPWR.n41 VPWR.n1275 0.592001
R3561 VPWR.n1557 VPWR.n1556 0.093289
R3562 VPWR.n226 VPWR.n225 0.0317231
R3563 VPWR.n1271 VPWR.n1270 0.09175
R3564 VPWR.n780 VPWR.n779 0.09175
R3565 VPWR.n413 VPWR.n412 0.089539
R3566 VPWR.n1856 VPWR.n1855 0.089539
R3567 VPWR.n1169 VPWR.n1168 0.089539
R3568 VPWR.n779 VPWR.n773 0.089539
R3569 VPWR.n1556 VPWR.n1519 0.088
R3570 VPWR.n1207 VPWR.n1206 0.088
R3571 VPWR.n426 VPWR.n374 0.08675
R3572 VPWR.n314 VPWR.n313 0.08675
R3573 VPWR.n160 VPWR.n159 0.143935
R3574 VPWR.n1593 VPWR.n1592 0.08675
R3575 VPWR.n1633 VPWR.n1581 0.08675
R3576 VPWR.n1600 VPWR.n1599 0.08675
R3577 VPWR.n1649 VPWR.n166 0.143935
R3578 VPWR.n597 VPWR.n596 0.08675
R3579 VPWR.n1504 VPWR.n1456 0.08675
R3580 VPWR.n1428 VPWR.n150 0.163413
R3581 VPWR.n1465 VPWR.n1464 0.08675
R3582 VPWR.n1368 VPWR.n1367 0.08675
R3583 VPWR.n1272 VPWR.n1271 0.08675
R3584 VPWR.n1275 VPWR.n1274 0.08675
R3585 VPWR.n1300 VPWR.n218 0.0296542
R3586 VPWR.n207 VPWR.n1319 0.172055
R3587 VPWR.n163 VPWR.n162 0.143935
R3588 VPWR.n1242 VPWR.n153 0.143935
R3589 VPWR.n1155 VPWR.n1122 0.08675
R3590 VPWR.n1077 VPWR.n1076 0.08675
R3591 VPWR.n990 VPWR.n216 0.0296542
R3592 VPWR.n367 VPWR.n307 0.084539
R3593 VPWR.n626 VPWR.n625 0.084539
R3594 VPWR.n1703 VPWR.n1702 0.082039
R3595 VPWR.n1629 VPWR.n1628 0.082039
R3596 VPWR.n562 VPWR.n561 0.082039
R3597 VPWR.n1225 VPWR.n1224 0.082039
R3598 VPWR.n1511 VPWR.n219 0.0805
R3599 VPWR.n1189 VPWR.n1188 0.0805
R3600 VPWR.n1716 VPWR.n1715 0.079539
R3601 VPWR.n1729 VPWR.n1728 0.079539
R3602 VPWR.n637 VPWR.n636 0.079539
R3603 VPWR.n607 VPWR.n606 0.079539
R3604 VPWR.n1378 VPWR.n1377 0.079539
R3605 VPWR.n1450 VPWR.n1449 0.079539
R3606 VPWR.n696 VPWR.n695 0.079539
R3607 VPWR.n1248 VPWR.n1247 0.079539
R3608 VPWR.n1095 VPWR.n1094 0.079539
R3609 VPWR.n1282 VPWR.n1281 0.078289
R3610 VPWR.n611 VPWR.n610 0.078
R3611 VPWR.n1772 VPWR.n1771 0.0755
R3612 VPWR.n1339 VPWR.n1338 0.0755
R3613 VPWR.n935 VPWR.n934 0.0755
R3614 VPWR.n930 VPWR.n929 0.0755
R3615 VPWR.n356 VPWR.n355 0.073289
R3616 VPWR.n1861 VPWR.n1860 0.073289
R3617 VPWR.n687 VPWR.n686 0.073289
R3618 VPWR.n1329 VPWR.n1328 0.073289
R3619 VPWR.n778 VPWR.n777 0.073289
R3620 VPWR.n1722 VPWR.n1721 0.072039
R3621 VPWR.n600 VPWR.n599 0.072039
R3622 VPWR.n1509 VPWR.n1508 0.072039
R3623 VPWR.n1450 VPWR.n1448 0.072039
R3624 VPWR.n695 VPWR.n694 0.072039
R3625 VPWR.n1061 VPWR.n1060 0.072039
R3626 VPWR.n97 VPWR.n1109 0.430925
R3627 VPWR.n1116 VPWR.n1114 0.072039
R3628 VPWR.n205 VPWR.n204 0.0246817
R3629 VPWR.n981 VPWR.n980 0.072039
R3630 VPWR.n1279 VPWR.n1278 0.06925
R3631 VPWR.n612 VPWR.n611 0.068
R3632 VPWR.n609 VPWR.n608 0.068
R3633 VPWR.n260 VPWR.n259 0.067039
R3634 VPWR.n429 VPWR.n428 0.067039
R3635 VPWR.n1889 VPWR.n1888 0.067039
R3636 VPWR.n1867 VPWR.n1809 0.067039
R3637 VPWR.n461 VPWR.n442 0.067039
R3638 VPWR.n1661 VPWR.n1660 0.067039
R3639 VPWR.n1723 VPWR.n1722 0.067039
R3640 VPWR.n1608 VPWR.n1607 0.067039
R3641 VPWR.n1602 VPWR.n1601 0.067039
R3642 VPWR.n1541 VPWR.n1540 0.067039
R3643 VPWR.n592 VPWR.n591 0.067039
R3644 VPWR.n665 VPWR.n664 0.067039
R3645 VPWR.n599 VPWR.n598 0.067039
R3646 VPWR.n1508 VPWR.n1507 0.067039
R3647 VPWR.n1396 VPWR.n1370 0.067039
R3648 VPWR.n1401 VPWR.n1400 0.067039
R3649 VPWR.n1468 VPWR.n1467 0.067039
R3650 VPWR.n680 VPWR.n670 0.067039
R3651 VPWR.n1319 VPWR.n1318 0.067039
R3652 VPWR.n722 VPWR.n721 0.067039
R3653 VPWR.n1159 VPWR.n1158 0.067039
R3654 VPWR.n1051 VPWR.n1047 0.067039
R3655 VPWR.n1075 VPWR.n1074 0.067039
R3656 VPWR.n744 VPWR.n727 0.067039
R3657 VPWR.n854 VPWR.n853 0.067039
R3658 VPWR.n894 VPWR.n840 0.067039
R3659 VPWR.n616 VPWR.n615 0.06675
R3660 VPWR.n210 VPWR.n1418 0.06675
R3661 VPWR.n1718 VPWR.n1717 0.065789
R3662 VPWR.n605 VPWR.n604 0.065789
R3663 VPWR.n604 VPWR.n603 0.065789
R3664 VPWR.n1409 VPWR.n1375 0.065789
R3665 VPWR.n1446 VPWR.n1419 0.065789
R3666 VPWR.n1892 VPWR.n257 0.0655
R3667 VPWR.n1894 VPWR.n257 0.0655
R3668 VPWR.n1895 VPWR.n256 0.0655
R3669 VPWR.n256 VPWR.n255 0.0655
R3670 VPWR.n1899 VPWR.n1898 0.0655
R3671 VPWR.n1899 VPWR.n1897 0.0655
R3672 VPWR.n1901 VPWR.n1900 0.0655
R3673 VPWR.n1902 VPWR.n1901 0.0655
R3674 VPWR.n1903 VPWR.n250 0.0655
R3675 VPWR.n250 VPWR.n249 0.0655
R3676 VPWR.n1906 VPWR.n1905 0.0655
R3677 VPWR.n1907 VPWR.n1906 0.0655
R3678 VPWR.n1908 VPWR.n247 0.0655
R3679 VPWR.n247 VPWR.n246 0.0655
R3680 VPWR.n1911 VPWR.n244 0.0655
R3681 VPWR.n1913 VPWR.n244 0.0655
R3682 VPWR.n1917 VPWR.n1916 0.0655
R3683 VPWR.n1919 VPWR.n242 0.0655
R3684 VPWR.n1927 VPWR.n1926 0.0655
R3685 VPWR.n1932 VPWR.n1931 0.0655
R3686 VPWR.n1933 VPWR.n1932 0.0655
R3687 VPWR.n273 VPWR.n272 0.0655
R3688 VPWR.n60 VPWR.n266 0.0655
R3689 VPWR.n282 VPWR.n281 0.0655
R3690 VPWR.n288 VPWR.n286 0.0655
R3691 VPWR.n298 VPWR.n262 0.0655
R3692 VPWR.n262 VPWR.n261 0.0655
R3693 VPWR.n432 VPWR.n431 0.0655
R3694 VPWR.n431 VPWR.n430 0.0655
R3695 VPWR.n1877 VPWR.n1876 0.0655
R3696 VPWR.n1886 VPWR.n1885 0.0655
R3697 VPWR.n1887 VPWR.n1886 0.0655
R3698 VPWR.n333 VPWR.n332 0.0655
R3699 VPWR.n334 VPWR.n333 0.0655
R3700 VPWR.n345 VPWR.n344 0.0655
R3701 VPWR.n346 VPWR.n345 0.0655
R3702 VPWR.n350 VPWR.n349 0.0655
R3703 VPWR.n351 VPWR.n350 0.0655
R3704 VPWR.n358 VPWR.n317 0.0655
R3705 VPWR.n361 VPWR.n314 0.0655
R3706 VPWR.n394 VPWR.n393 0.0655
R3707 VPWR.n390 VPWR.n389 0.0655
R3708 VPWR.n379 VPWR.n378 0.0655
R3709 VPWR.n378 VPWR.n377 0.0655
R3710 VPWR.n1828 VPWR.n1819 0.0655
R3711 VPWR.n1818 VPWR.n1817 0.0655
R3712 VPWR.n1833 VPWR.n1832 0.0655
R3713 VPWR.n1836 VPWR.n1815 0.0655
R3714 VPWR.n1844 VPWR.n1811 0.0655
R3715 VPWR.n1811 VPWR.n1810 0.0655
R3716 VPWR.n1765 VPWR.n1764 0.0655
R3717 VPWR.n1765 VPWR.n1763 0.0655
R3718 VPWR.n1768 VPWR.n1767 0.0655
R3719 VPWR.n1756 VPWR.n1755 0.0655
R3720 VPWR.n1772 VPWR.n1733 0.0655
R3721 VPWR.n1749 VPWR.n1748 0.0655
R3722 VPWR.n1787 VPWR.n1786 0.0655
R3723 VPWR.n1788 VPWR.n1787 0.0655
R3724 VPWR.n1789 VPWR.n1746 0.0655
R3725 VPWR.n1746 VPWR.n1745 0.0655
R3726 VPWR.n1791 VPWR.n1741 0.0655
R3727 VPWR.n1798 VPWR.n1797 0.0655
R3728 VPWR.n1738 VPWR.n1737 0.0655
R3729 VPWR.n1803 VPWR.n1802 0.0655
R3730 VPWR.n1735 VPWR.n1734 0.0655
R3731 VPWR.n1826 VPWR.n1822 0.0655
R3732 VPWR.n450 VPWR.n449 0.0655
R3733 VPWR.n456 VPWR.n445 0.0655
R3734 VPWR.n445 VPWR.n444 0.0655
R3735 VPWR.n459 VPWR.n458 0.0655
R3736 VPWR.n460 VPWR.n459 0.0655
R3737 VPWR.n1658 VPWR.n1657 0.0655
R3738 VPWR.n1659 VPWR.n1658 0.0655
R3739 VPWR.n1668 VPWR.n1667 0.0655
R3740 VPWR.n1675 VPWR.n1674 0.0655
R3741 VPWR.n1676 VPWR.n1675 0.0655
R3742 VPWR.n1683 VPWR.n1682 0.0655
R3743 VPWR.n1690 VPWR.n1689 0.0655
R3744 VPWR.n1691 VPWR.n1690 0.0655
R3745 VPWR.n1694 VPWR.n1693 0.0655
R3746 VPWR.n1695 VPWR.n1694 0.0655
R3747 VPWR.n1708 VPWR.n1707 0.0655
R3748 VPWR.n1726 VPWR.n1725 0.0655
R3749 VPWR.n11 VPWR.n502 0.0655
R3750 VPWR.n502 VPWR.n501 0.0655
R3751 VPWR.n497 VPWR.n496 0.0655
R3752 VPWR.n496 VPWR.n495 0.0655
R3753 VPWR.n493 VPWR.n492 0.0655
R3754 VPWR.n492 VPWR.n491 0.0655
R3755 VPWR.n485 VPWR.n484 0.0655
R3756 VPWR.n484 VPWR.n483 0.0655
R3757 VPWR.n478 VPWR.n477 0.0655
R3758 VPWR.n474 VPWR.n473 0.0655
R3759 VPWR.n473 VPWR.n472 0.0655
R3760 VPWR.n1579 VPWR.n1578 0.0655
R3761 VPWR.n1578 VPWR.n1577 0.0655
R3762 VPWR.n1573 VPWR.n1572 0.0655
R3763 VPWR.n1572 VPWR.n1571 0.0655
R3764 VPWR.n1588 VPWR.n1587 0.0655
R3765 VPWR.n71 VPWR.n1588 0.0655
R3766 VPWR.n1620 VPWR.n1619 0.0655
R3767 VPWR.n1614 VPWR.n1613 0.0655
R3768 VPWR.n1611 VPWR.n1610 0.0655
R3769 VPWR.n1605 VPWR.n1604 0.0655
R3770 VPWR.n1528 VPWR.n1527 0.0655
R3771 VPWR.n1529 VPWR.n1528 0.0655
R3772 VPWR.n1530 VPWR.n1526 0.0655
R3773 VPWR.n1526 VPWR.n1525 0.0655
R3774 VPWR.n1538 VPWR.n1537 0.0655
R3775 VPWR.n1543 VPWR.n1542 0.0655
R3776 VPWR.n1559 VPWR.n1518 0.0655
R3777 VPWR.n1642 VPWR.n1641 0.0655
R3778 VPWR.n574 VPWR.n573 0.0655
R3779 VPWR.n574 VPWR.n572 0.0655
R3780 VPWR.n570 VPWR.n569 0.0655
R3781 VPWR.n569 VPWR.n568 0.0655
R3782 VPWR.n564 VPWR.n563 0.0655
R3783 VPWR.n541 VPWR.n540 0.0655
R3784 VPWR.n540 VPWR.n539 0.0655
R3785 VPWR.n535 VPWR.n534 0.0655
R3786 VPWR.n529 VPWR.n528 0.0655
R3787 VPWR.n523 VPWR.n522 0.0655
R3788 VPWR.n522 VPWR.n521 0.0655
R3789 VPWR.n519 VPWR.n518 0.0655
R3790 VPWR.n583 VPWR.n579 0.0655
R3791 VPWR.n585 VPWR.n579 0.0655
R3792 VPWR.n589 VPWR.n588 0.0655
R3793 VPWR.n590 VPWR.n589 0.0655
R3794 VPWR.n660 VPWR.n659 0.0655
R3795 VPWR.n640 VPWR.n639 0.0655
R3796 VPWR.n639 VPWR.n638 0.0655
R3797 VPWR.n635 VPWR.n634 0.0655
R3798 VPWR.n622 VPWR.n621 0.0655
R3799 VPWR.n506 VPWR.n505 0.0655
R3800 VPWR.n512 VPWR.n510 0.0655
R3801 VPWR.n514 VPWR.n513 0.0655
R3802 VPWR.n1388 VPWR.n1386 0.0655
R3803 VPWR.n1390 VPWR.n1389 0.0655
R3804 VPWR.n1398 VPWR.n1397 0.0655
R3805 VPWR.n1406 VPWR.n1380 0.0655
R3806 VPWR.n1380 VPWR.n1379 0.0655
R3807 VPWR.n1414 VPWR.n1412 0.0655
R3808 VPWR.n31 VPWR.n1426 0.69198
R3809 VPWR.n1441 VPWR.n1421 0.0655
R3810 VPWR.n1500 VPWR.n1499 0.0655
R3811 VPWR.n1499 VPWR.n1498 0.0655
R3812 VPWR.n1496 VPWR.n1495 0.0655
R3813 VPWR.n1495 VPWR.n1494 0.0655
R3814 VPWR.n1492 VPWR.n1491 0.0655
R3815 VPWR.n1491 VPWR.n1490 0.0655
R3816 VPWR.n1488 VPWR.n1487 0.0655
R3817 VPWR.n1487 VPWR.n1486 0.0655
R3818 VPWR.n1484 VPWR.n1483 0.0655
R3819 VPWR.n1483 VPWR.n1482 0.0655
R3820 VPWR.n1474 VPWR.n1473 0.0655
R3821 VPWR.n1471 VPWR.n1470 0.0655
R3822 VPWR.n1470 VPWR.n1469 0.0655
R3823 VPWR.n1466 VPWR.n1465 0.0655
R3824 VPWR.n1322 VPWR.n691 0.0655
R3825 VPWR.n684 VPWR.n683 0.0655
R3826 VPWR.n1334 VPWR.n1333 0.0655
R3827 VPWR.n1335 VPWR.n1334 0.0655
R3828 VPWR.n1360 VPWR.n1359 0.0655
R3829 VPWR.n1356 VPWR.n1355 0.0655
R3830 VPWR.n1351 VPWR.n1350 0.0655
R3831 VPWR.n675 VPWR.n671 0.0655
R3832 VPWR.n58 VPWR.n671 0.0655
R3833 VPWR.n678 VPWR.n677 0.0655
R3834 VPWR.n1291 VPWR.n1290 0.0655
R3835 VPWR.n1312 VPWR.n1311 0.0655
R3836 VPWR.n1313 VPWR.n1312 0.0655
R3837 VPWR.n1316 VPWR.n1315 0.0655
R3838 VPWR.n1317 VPWR.n1316 0.0655
R3839 VPWR.n19 VPWR.n701 0.0655
R3840 VPWR.n701 VPWR.n700 0.0655
R3841 VPWR.n707 VPWR.n706 0.0655
R3842 VPWR.n719 VPWR.n718 0.0655
R3843 VPWR.n720 VPWR.n719 0.0655
R3844 VPWR.n1197 VPWR.n1196 0.0655
R3845 VPWR.n1208 VPWR.n1207 0.0655
R3846 VPWR.n1212 VPWR.n1211 0.0655
R3847 VPWR.n1219 VPWR.n1218 0.0655
R3848 VPWR.n1220 VPWR.n1219 0.0655
R3849 VPWR.n1245 VPWR.n1244 0.0655
R3850 VPWR.n1246 VPWR.n1245 0.0655
R3851 VPWR.n1178 VPWR.n1177 0.0655
R3852 VPWR.n1161 VPWR.n1160 0.0655
R3853 VPWR.n1157 VPWR.n1122 0.0655
R3854 VPWR.n1072 VPWR.n1071 0.0655
R3855 VPWR.n1073 VPWR.n1072 0.0655
R3856 VPWR.n1080 VPWR.n1079 0.0655
R3857 VPWR.n1068 VPWR.n1067 0.0655
R3858 VPWR.n1084 VPWR.n1083 0.0655
R3859 VPWR.n1085 VPWR.n1084 0.0655
R3860 VPWR.n1086 VPWR.n1063 0.0655
R3861 VPWR.n1088 VPWR.n1063 0.0655
R3862 VPWR.n1102 VPWR.n1101 0.0655
R3863 VPWR.n1115 VPWR.n1055 0.0655
R3864 VPWR.n1055 VPWR.n1054 0.0655
R3865 VPWR.n1119 VPWR.n1118 0.0655
R3866 VPWR.n1119 VPWR.n1117 0.0655
R3867 VPWR.n86 VPWR.n1121 0.0655
R3868 VPWR.n1149 VPWR.n1148 0.0655
R3869 VPWR.n1148 VPWR.n1147 0.0655
R3870 VPWR.n1145 VPWR.n1144 0.0655
R3871 VPWR.n1144 VPWR.n1143 0.0655
R3872 VPWR.n1137 VPWR.n1136 0.0655
R3873 VPWR.n1136 VPWR.n1135 0.0655
R3874 VPWR.n1133 VPWR.n1132 0.0655
R3875 VPWR.n1132 VPWR.n1131 0.0655
R3876 VPWR.n1129 VPWR.n1128 0.0655
R3877 VPWR.n1128 VPWR.n1127 0.0655
R3878 VPWR.n1123 VPWR.n222 0.0958229
R3879 VPWR.n1029 VPWR.n1028 0.0655
R3880 VPWR.n1028 VPWR.n1027 0.0655
R3881 VPWR.n1003 VPWR.n1002 0.0655
R3882 VPWR.n736 VPWR.n729 0.0655
R3883 VPWR.n781 VPWR.n780 0.0655
R3884 VPWR.n791 VPWR.n790 0.0655
R3885 VPWR.n792 VPWR.n791 0.0655
R3886 VPWR.n793 VPWR.n766 0.0655
R3887 VPWR.n795 VPWR.n766 0.0655
R3888 VPWR.n809 VPWR.n808 0.0655
R3889 VPWR.n813 VPWR.n756 0.0655
R3890 VPWR.n816 VPWR.n815 0.0655
R3891 VPWR.n818 VPWR.n753 0.0655
R3892 VPWR.n822 VPWR.n820 0.0655
R3893 VPWR.n922 VPWR.n921 0.0655
R3894 VPWR.n923 VPWR.n922 0.0655
R3895 VPWR.n857 VPWR.n856 0.0655
R3896 VPWR.n856 VPWR.n855 0.0655
R3897 VPWR.n867 VPWR.n865 0.0655
R3898 VPWR.n869 VPWR.n868 0.0655
R3899 VPWR.n871 VPWR.n849 0.0655
R3900 VPWR.n877 VPWR.n876 0.0655
R3901 VPWR.n877 VPWR.n875 0.0655
R3902 VPWR.n880 VPWR.n878 0.0655
R3903 VPWR.n882 VPWR.n881 0.0655
R3904 VPWR.n884 VPWR.n844 0.0655
R3905 VPWR.n887 VPWR.n886 0.0655
R3906 VPWR.n893 VPWR.n839 0.0655
R3907 VPWR.n213 VPWR.n833 0.0655
R3908 VPWR.n901 VPWR.n899 0.0655
R3909 VPWR.n903 VPWR.n902 0.0655
R3910 VPWR.n907 VPWR.n829 0.0655
R3911 VPWR.n829 VPWR.n828 0.0655
R3912 VPWR.n988 VPWR.n987 0.0655
R3913 VPWR.n987 VPWR.n986 0.0655
R3914 VPWR.n978 VPWR.n977 0.0655
R3915 VPWR.n974 VPWR.n973 0.0655
R3916 VPWR.n966 VPWR.n965 0.0655
R3917 VPWR.n962 VPWR.n961 0.0655
R3918 VPWR.n958 VPWR.n957 0.0655
R3919 VPWR.n954 VPWR.n953 0.0655
R3920 VPWR.n949 VPWR.n948 0.0655
R3921 VPWR.n948 VPWR.n947 0.0655
R3922 VPWR.n943 VPWR.n942 0.0655
R3923 VPWR.n942 VPWR.n941 0.0655
R3924 VPWR.n938 VPWR.n937 0.0655
R3925 VPWR.n934 VPWR.n933 0.0655
R3926 VPWR.n931 VPWR.n930 0.0655
R3927 VPWR.n291 VPWR.n290 0.06425
R3928 VPWR.n402 VPWR.n400 0.06425
R3929 VPWR.n1774 VPWR.n1753 0.06425
R3930 VPWR.n1778 VPWR.n1777 0.06425
R3931 VPWR.n1664 VPWR.n1663 0.06425
R3932 VPWR.n662 VPWR.n661 0.06425
R3933 VPWR.n1384 VPWR.n1383 0.06425
R3934 VPWR.n1403 VPWR.n1381 0.06425
R3935 VPWR.n1434 VPWR.n1424 0.06425
R3936 VPWR.n1363 VPWR.n1361 0.06425
R3937 VPWR.n1191 VPWR.n1190 0.06425
R3938 VPWR.n864 VPWR.n863 0.06425
R3939 VPWR.n1290 VPWR.n1289 0.063
R3940 VPWR.n154 VPWR.n178 0.238766
R3941 VPWR.n1868 VPWR.n1866 0.0605
R3942 VPWR.n1507 VPWR.n1506 0.05925
R3943 VPWR.n1299 VPWR.n1298 0.05925
R3944 VPWR.n910 VPWR.n826 0.05925
R3945 VPWR.n673 VPWR.n672 0.0590543
R3946 VPWR.n290 VPWR.n264 0.05675
R3947 VPWR.n92 VPWR.n1774 0.444725
R3948 VPWR.n1777 VPWR.n1753 0.05675
R3949 VPWR.n1827 VPWR.n1825 0.05675
R3950 VPWR.n1727 VPWR.n1726 0.05675
R3951 VPWR.n1604 VPWR.n1603 0.05675
R3952 VPWR.n1545 VPWR.n1543 0.05675
R3953 VPWR.n1383 VPWR.n219 0.05675
R3954 VPWR.n201 VPWR.n1403 0.117039
R3955 VPWR.n1405 VPWR.n1381 0.05675
R3956 VPWR.n1190 VPWR.n1189 0.05675
R3957 VPWR.n1182 VPWR.n89 0.438148
R3958 VPWR.n1039 VPWR.n138 0.176736
R3959 VPWR.n839 VPWR.n838 0.05675
R3960 VPWR.n1914 VPWR.n243 0.0555
R3961 VPWR.n1916 VPWR.n243 0.0555
R3962 VPWR.n1918 VPWR.n1917 0.0555
R3963 VPWR.n1921 VPWR.n242 0.0555
R3964 VPWR.n1928 VPWR.n1927 0.0555
R3965 VPWR.n273 VPWR.t738 0.0555
R3966 VPWR.n272 VPWR.n269 0.0555
R3967 VPWR.n269 VPWR.n268 0.0555
R3968 VPWR.n275 VPWR.n274 0.0555
R3969 VPWR.n276 VPWR.n275 0.0555
R3970 VPWR.n279 VPWR.n266 0.0555
R3971 VPWR.n283 VPWR.n282 0.0555
R3972 VPWR.n286 VPWR.n264 0.0555
R3973 VPWR.n292 VPWR.n291 0.0555
R3974 VPWR.n1880 VPWR.n1878 0.0555
R3975 VPWR.n1882 VPWR.n1878 0.0555
R3976 VPWR.n1883 VPWR.n1877 0.0555
R3977 VPWR.n332 VPWR.n224 0.117443
R3978 VPWR.n340 VPWR.n339 0.0555
R3979 VPWR.n341 VPWR.n340 0.0555
R3980 VPWR.n357 VPWR.n318 0.0555
R3981 VPWR.n365 VPWR.n363 0.0555
R3982 VPWR.n368 VPWR.n366 0.0555
R3983 VPWR.n370 VPWR.n369 0.0555
R3984 VPWR.n371 VPWR.n370 0.0555
R3985 VPWR.n36 VPWR.n305 0.634018
R3986 VPWR.n400 VPWR.n399 0.0555
R3987 VPWR.n395 VPWR.n394 0.0555
R3988 VPWR.n391 VPWR.n390 0.0555
R3989 VPWR.n389 VPWR.n388 0.0555
R3990 VPWR.n388 VPWR.n387 0.0555
R3991 VPWR.n383 VPWR.n382 0.0555
R3992 VPWR.n382 VPWR.n381 0.0555
R3993 VPWR.n1820 VPWR.n1819 0.0555
R3994 VPWR.n1829 VPWR.n1818 0.0555
R3995 VPWR.n1832 VPWR.n1831 0.0555
R3996 VPWR.n1834 VPWR.n1815 0.0555
R3997 VPWR.n1767 VPWR.n1766 0.0555
R3998 VPWR.n1769 VPWR.n1756 0.0555
R3999 VPWR.n1778 VPWR.n1775 0.0555
R4000 VPWR.n1780 VPWR.n1779 0.0555
R4001 VPWR.n1793 VPWR.n1792 0.0555
R4002 VPWR.n1793 VPWR.n1791 0.0555
R4003 VPWR.n1794 VPWR.n1741 0.0555
R4004 VPWR.n1797 VPWR.n1796 0.0555
R4005 VPWR.n1799 VPWR.n1738 0.0555
R4006 VPWR.n1802 VPWR.n1801 0.0555
R4007 VPWR.n1806 VPWR.n1735 0.0555
R4008 VPWR.n1827 VPWR.n1826 0.0555
R4009 VPWR.n1855 VPWR.n7 0.144336
R4010 VPWR.n6 VPWR.t49 0.622939
R4011 VPWR.n56 VPWR.n1852 0.489683
R4012 VPWR.n447 VPWR.n446 0.0555
R4013 VPWR.n449 VPWR.n446 0.0555
R4014 VPWR.n451 VPWR.n450 0.0555
R4015 VPWR.n1657 VPWR.n226 0.117443
R4016 VPWR.n1665 VPWR.n1664 0.0555
R4017 VPWR.n1667 VPWR.n1666 0.0555
R4018 VPWR.n1681 VPWR.n1680 0.0555
R4019 VPWR.n1682 VPWR.n1681 0.0555
R4020 VPWR.n145 VPWR.n1683 0.0555
R4021 VPWR.n1711 VPWR.n1710 0.0555
R4022 VPWR.n1725 VPWR.n1724 0.0555
R4023 VPWR.n33 VPWR.n480 0.71388
R4024 VPWR.n477 VPWR.n476 0.0555
R4025 VPWR.n1594 VPWR.n228 0.117443
R4026 VPWR.n1615 VPWR.n1614 0.0555
R4027 VPWR.n1613 VPWR.n1612 0.0555
R4028 VPWR.n1612 VPWR.n1611 0.0555
R4029 VPWR.n1610 VPWR.n1609 0.0555
R4030 VPWR.n1606 VPWR.n1605 0.0555
R4031 VPWR.n1527 VPWR.n230 0.117443
R4032 VPWR.n1535 VPWR.n1523 0.0555
R4033 VPWR.n1537 VPWR.n1523 0.0555
R4034 VPWR.n1539 VPWR.n1538 0.0555
R4035 VPWR.n1542 VPWR.n1522 0.0555
R4036 VPWR.n1553 VPWR.n1520 0.0555
R4037 VPWR.n1558 VPWR.n1519 0.0555
R4038 VPWR.n1561 VPWR.n1518 0.0555
R4039 VPWR.n1643 VPWR.n1642 0.0555
R4040 VPWR.n1637 VPWR.n1636 0.0555
R4041 VPWR.n534 VPWR.n533 0.0555
R4042 VPWR.n528 VPWR.n527 0.0555
R4043 VPWR.n661 VPWR.n660 0.0555
R4044 VPWR.n659 VPWR.n658 0.0555
R4045 VPWR.n654 VPWR.n653 0.0555
R4046 VPWR.n653 VPWR.n652 0.0555
R4047 VPWR.n650 VPWR.n649 0.0555
R4048 VPWR.n649 VPWR.n648 0.0555
R4049 VPWR.n646 VPWR.n645 0.0555
R4050 VPWR.n645 VPWR.n644 0.0555
R4051 VPWR.n634 VPWR.n209 0.0555
R4052 VPWR.n615 VPWR.n614 0.0555
R4053 VPWR.n508 VPWR.n506 0.0555
R4054 VPWR.n512 VPWR.n511 0.0555
R4055 VPWR.n510 VPWR.n503 0.0555
R4056 VPWR.n513 VPWR.n503 0.0555
R4057 VPWR.n515 VPWR.n514 0.0555
R4058 VPWR.n1506 VPWR.n1456 0.0555
R4059 VPWR.n1388 VPWR.n1387 0.0555
R4060 VPWR.n1386 VPWR.n1385 0.0555
R4061 VPWR.n1389 VPWR.n1385 0.0555
R4062 VPWR.n1391 VPWR.n1390 0.0555
R4063 VPWR.n1397 VPWR.n1384 0.0555
R4064 VPWR.n1399 VPWR.n1398 0.0555
R4065 VPWR.n1414 VPWR.n1413 0.0555
R4066 VPWR.n1412 VPWR.n1373 0.0555
R4067 VPWR.n1373 VPWR.n1372 0.0555
R4068 VPWR.n1416 VPWR.n1415 0.0555
R4069 VPWR.n1417 VPWR.n1416 0.0555
R4070 VPWR.n1424 VPWR.n1423 0.0555
R4071 VPWR.n1437 VPWR.n1436 0.0555
R4072 VPWR.n1438 VPWR.n1437 0.0555
R4073 VPWR.n1443 VPWR.n1421 0.0555
R4074 VPWR.n1475 VPWR.n1474 0.0555
R4075 VPWR.n1361 VPWR.n1360 0.0555
R4076 VPWR.n1359 VPWR.n1358 0.0555
R4077 VPWR.n1355 VPWR.n1354 0.0555
R4078 VPWR.n1352 VPWR.n1351 0.0555
R4079 VPWR.n1350 VPWR.n1349 0.0555
R4080 VPWR.n1349 VPWR.n1348 0.0555
R4081 VPWR.n1340 VPWR.n1339 0.0555
R4082 VPWR.n1338 VPWR.n220 0.0869112
R4083 VPWR.n679 VPWR.n678 0.0555
R4084 VPWR.n1274 VPWR.n1273 0.0555
R4085 VPWR.n218 VPWR.n1299 0.113305
R4086 VPWR.n1308 VPWR.n1307 0.0555
R4087 VPWR.n1309 VPWR.n1308 0.0555
R4088 VPWR.n708 VPWR.n707 0.0555
R4089 VPWR.n713 VPWR.n712 0.0555
R4090 VPWR.n714 VPWR.n713 0.0555
R4091 VPWR.n116 VPWR.n1191 0.0555
R4092 VPWR.n1196 VPWR.n1195 0.0555
R4093 VPWR.n1211 VPWR.n1210 0.0555
R4094 VPWR.n1213 VPWR.n1212 0.0555
R4095 VPWR.n1214 VPWR.n1213 0.0555
R4096 VPWR.t26 VPWR.n2 0.824909
R4097 VPWR.n1071 VPWR.n237 0.117443
R4098 VPWR.n1079 VPWR.n1078 0.0555
R4099 VPWR.n1081 VPWR.n1068 0.0555
R4100 VPWR.n1097 VPWR.n1096 0.0555
R4101 VPWR.n1098 VPWR.n1097 0.0555
R4102 VPWR.n1101 VPWR.n1100 0.0555
R4103 VPWR.n1103 VPWR.n1058 0.0555
R4104 VPWR.n1058 VPWR.n1057 0.0555
R4105 VPWR.n1106 VPWR.n1105 0.0555
R4106 VPWR.n1107 VPWR.n1106 0.0555
R4107 VPWR.n1121 VPWR.n1120 0.0555
R4108 VPWR.n1005 VPWR.n1004 0.0555
R4109 VPWR.n1004 VPWR.n1003 0.0555
R4110 VPWR.n1002 VPWR.n1001 0.0555
R4111 VPWR.n734 VPWR.n729 0.0555
R4112 VPWR.n737 VPWR.n736 0.0555
R4113 VPWR.n738 VPWR.n737 0.0555
R4114 VPWR.n788 VPWR.n771 0.0555
R4115 VPWR.n771 VPWR.n770 0.0555
R4116 VPWR.n804 VPWR.n803 0.0555
R4117 VPWR.n805 VPWR.n804 0.0555
R4118 VPWR.n806 VPWR.n757 0.0555
R4119 VPWR.n808 VPWR.n757 0.0555
R4120 VPWR.n810 VPWR.n809 0.0555
R4121 VPWR.n756 VPWR.n755 0.0555
R4122 VPWR.n817 VPWR.n816 0.0555
R4123 VPWR.n753 VPWR.n752 0.0555
R4124 VPWR.n822 VPWR.n821 0.0555
R4125 VPWR.n820 VPWR.n750 0.0555
R4126 VPWR.n750 VPWR.n749 0.0555
R4127 VPWR.n238 VPWR.n857 0.117443
R4128 VPWR.n864 VPWR.n861 0.0555
R4129 VPWR.n867 VPWR.n866 0.0555
R4130 VPWR.n865 VPWR.n850 0.0555
R4131 VPWR.n868 VPWR.n850 0.0555
R4132 VPWR.n870 VPWR.n869 0.0555
R4133 VPWR.n873 VPWR.n849 0.0555
R4134 VPWR.n880 VPWR.n879 0.0555
R4135 VPWR.n878 VPWR.n845 0.0555
R4136 VPWR.n881 VPWR.n845 0.0555
R4137 VPWR.n883 VPWR.n882 0.0555
R4138 VPWR.n844 VPWR.n843 0.0555
R4139 VPWR.n888 VPWR.n887 0.0555
R4140 VPWR.n891 VPWR.n54 0.489683
R4141 VPWR.n134 VPWR.n841 0.342347
R4142 VPWR.n895 VPWR.n893 0.0555
R4143 VPWR.n215 VPWR.n213 0.0555
R4144 VPWR.n901 VPWR.n900 0.0555
R4145 VPWR.n899 VPWR.n830 0.0555
R4146 VPWR.n902 VPWR.n830 0.0555
R4147 VPWR.n904 VPWR.n903 0.0555
R4148 VPWR.n216 VPWR.n826 0.113305
R4149 VPWR.n979 VPWR.n978 0.0555
R4150 VPWR.n975 VPWR.n974 0.0555
R4151 VPWR.n973 VPWR.n972 0.0555
R4152 VPWR.n972 VPWR.n971 0.0555
R4153 VPWR.n967 VPWR.n966 0.0555
R4154 VPWR.n963 VPWR.n962 0.0555
R4155 VPWR.n959 VPWR.n958 0.0555
R4156 VPWR.n955 VPWR.n954 0.0555
R4157 VPWR.n939 VPWR.n938 0.0555
R4158 VPWR.n1872 VPWR.n171 0.120884
R4159 VPWR.n167 VPWR.n1890 0.120708
R4160 VPWR.n1687 VPWR.n1686 0.05425
R4161 VPWR.n1721 VPWR.n1720 0.05425
R4162 VPWR.n212 VPWR.n210 0.05425
R4163 VPWR.n558 VPWR.n557 0.053
R4164 VPWR.n1265 VPWR.n1264 0.053
R4165 VPWR.n405 VPWR.n404 0.04925
R4166 VPWR.n1432 VPWR.n1431 0.04925
R4167 VPWR.n1467 VPWR.n1466 0.04925
R4168 VPWR.n1365 VPWR.n1364 0.04925
R4169 VPWR.n1158 VPWR.n1157 0.04925
R4170 VPWR.n581 VPWR.n580 0.0478757
R4171 VPWR.n1873 VPWR.n438 0.04675
R4172 VPWR.n1731 VPWR.n225 0.04675
R4173 VPWR.n1515 VPWR.n1514 0.04675
R4174 VPWR.n697 VPWR.n696 0.04675
R4175 VPWR.n1185 VPWR.n1046 0.04675
R4176 VPWR.n1042 VPWR.n4 0.04675
R4177 VPWR.n860 VPWR.n724 0.04675
R4178 VPWR.n1781 VPWR.n1780 0.0455
R4179 VPWR.n1784 VPWR.n1749 0.0455
R4180 VPWR.n1636 VPWR.n1635 0.0455
R4181 VPWR.n518 VPWR.n517 0.0455
R4182 VPWR.n178 VPWR.n698 0.0448003
R4183 VPWR.n422 VPWR.n421 0.04425
R4184 VPWR.n1193 VPWR.n1192 0.04425
R4185 VPWR.n120 VPWR.n1099 0.04425
R4186 VPWR.n1109 VPWR.n1108 0.04425
R4187 VPWR.n1114 VPWR.n1113 0.04425
R4188 VPWR.n797 VPWR.n796 0.04425
R4189 VPWR.n1255 VPWR.n169 0.29335
R4190 VPWR.n417 VPWR.n416 0.043
R4191 VPWR.n1860 VPWR.n1859 0.043
R4192 VPWR.n610 VPWR.n609 0.043
R4193 VPWR.n801 VPWR.n800 0.043
R4194 VPWR.n168 VPWR.n1369 0.292596
R4195 VPWR.n84 VPWR.n82 0.159767
R4196 VPWR.n1719 VPWR.n1718 0.0423097
R4197 VPWR.n1685 VPWR.n1684 0.0423097
R4198 VPWR.n603 VPWR.n601 0.0423097
R4199 VPWR.n632 VPWR.n631 0.0423097
R4200 VPWR.n1447 VPWR.n1446 0.0423097
R4201 VPWR.n1411 VPWR.n1409 0.0423097
R4202 VPWR.n1112 VPWR.n1111 0.0423097
R4203 VPWR.n1874 VPWR.n1873 0.0405
R4204 VPWR.n1731 VPWR.n1730 0.0405
R4205 VPWR.n1514 VPWR.n575 0.0405
R4206 VPWR.n1511 VPWR.n1510 0.0405
R4207 VPWR.n1188 VPWR.n723 0.0405
R4208 VPWR.n1185 VPWR.n1184 0.0405
R4209 VPWR.n1042 VPWR.n1041 0.0405
R4210 VPWR.n912 VPWR.n724 0.0405
R4211 VPWR.n1294 VPWR.n1293 0.03925
R4212 VPWR.n1301 VPWR.n1300 0.038
R4213 VPWR.n17 VPWR.n1729 0.03675
R4214 VPWR.n1377 VPWR.n1376 0.03675
R4215 VPWR.n3 VPWR.n1234 0.03675
R4216 VPWR.n98 VPWR.n1248 0.03675
R4217 VPWR.n763 VPWR.n762 0.03675
R4218 VPWR.n336 VPWR.n335 0.03425
R4219 VPWR.n1630 VPWR.n1629 0.03425
R4220 VPWR.n1621 VPWR.n1620 0.03425
R4221 VPWR.n1162 VPWR.n1161 0.03425
R4222 VPWR.n1891 VPWR.n302 0.033
R4223 VPWR.n365 VPWR.n364 0.033
R4224 VPWR.n621 VPWR.n620 0.033
R4225 VPWR.n1320 VPWR.n1256 0.033
R4226 VPWR.n991 VPWR.n990 0.033
R4227 VPWR.n408 VPWR.n407 0.03175
R4228 VPWR.n548 VPWR.n547 0.03175
R4229 VPWR.n627 VPWR.n626 0.03175
R4230 VPWR.n1202 VPWR.n1201 0.03175
R4231 VPWR.n1232 VPWR.n1231 0.03175
R4232 VPWR.n785 VPWR.n784 0.03175
R4233 VPWR.n427 VPWR.n426 0.0317219
R4234 VPWR.n1865 VPWR.n1846 0.0317219
R4235 VPWR.n1156 VPWR.n1155 0.0317219
R4236 VPWR.n989 VPWR.n824 0.0317219
R4237 VPWR.n302 VPWR.n258 0.0296531
R4238 VPWR.n317 VPWR.n316 0.02925
R4239 VPWR.n1712 VPWR.n1711 0.02925
R4240 VPWR.n1325 VPWR.n1324 0.02925
R4241 VPWR.n1326 VPWR.n1325 0.02925
R4242 VPWR.n1866 VPWR.n1865 0.02675
R4243 VPWR.n1626 VPWR.n1625 0.02675
R4244 VPWR.n553 VPWR.n552 0.02675
R4245 VPWR.n1227 VPWR.n1226 0.02675
R4246 VPWR.n991 VPWR.n824 0.02675
R4247 VPWR.n1551 VPWR.n1520 0.02425
R4248 VPWR.n630 VPWR.n629 0.023
R4249 VPWR.n1270 VPWR.n1269 0.023
R4250 VPWR.n171 VPWR.n1938 0.55031
R4251 VPWR.t294 VPWR.n52 6.3101
R4252 VPWR.t26 VPWR.n20 1.47619
R4253 VPWR.t49 VPWR.n5 1.18395
R4254 VPWR.n27 VPWR.n8 1.10412
R4255 VPWR.n10 VPWR.n9 1.08412
R4256 VPWR.n21 VPWR.n20 0.257481
R4257 VPWR.n24 VPWR.n212 1.06229
R4258 VPWR.n67 VPWR.n21 1.03555
R4259 VPWR.n29 VPWR.n28 1.02102
R4260 VPWR.n26 VPWR.n25 1.01791
R4261 VPWR.n206 VPWR.n23 1.01448
R4262 VPWR.n1 VPWR.n0 1.00065
R4263 VGND.n1100 VGND.n1099 6438.42
R4264 VGND.t22 VGND.n321 6396.86
R4265 VGND.n1101 VGND.n1100 6300
R4266 VGND.n1101 VGND.t11 6300
R4267 VGND.n1013 VGND.t11 6300
R4268 VGND.n1014 VGND.n1013 6300
R4269 VGND.t4 VGND.n1014 6300
R4270 VGND.n1015 VGND.t4 6300
R4271 VGND.n1016 VGND.n1015 6300
R4272 VGND.n1017 VGND.n1016 6300
R4273 VGND.t93 VGND.n1017 6300
R4274 VGND.t22 VGND.t93 6300
R4275 VGND.n1088 VGND.n244 6191.72
R4276 VGND.t22 VGND.n271 6171.44
R4277 VGND.n1088 VGND.n1087 6031.92
R4278 VGND.n1087 VGND.t11 6031.92
R4279 VGND.n1023 VGND.t11 6031.92
R4280 VGND.n1023 VGND.t481 6031.92
R4281 VGND.t481 VGND.n1022 6031.92
R4282 VGND.n1022 VGND.n1021 6031.92
R4283 VGND.n1021 VGND.n1020 6031.92
R4284 VGND.n1020 VGND.n1019 6031.92
R4285 VGND.n1019 VGND.n1018 6031.92
R4286 VGND.n1018 VGND.t22 6031.92
R4287 VGND.n295 VGND.n294 0.00169213
R4288 VGND.n250 VGND.t502 23.2276
R4289 VGND.n257 VGND.t386 23.2276
R4290 VGND.n320 VGND.n294 0.00199054
R4291 VGND.t68 VGND.n268 718.582
R4292 VGND.n292 VGND.t319 718.574
R4293 VGND.t318 VGND.n248 718.574
R4294 VGND.n291 VGND.t1187 718.574
R4295 VGND.t660 VGND.n251 718.574
R4296 VGND.n289 VGND.t559 718.574
R4297 VGND.n252 VGND.t559 24.0019
R4298 VGND.n288 VGND.t562 718.574
R4299 VGND.t1453 VGND.n253 718.574
R4300 VGND.n287 VGND.t1452 718.574
R4301 VGND.t575 VGND.n254 718.574
R4302 VGND.t1390 VGND.n255 718.574
R4303 VGND.n283 VGND.t1389 718.574
R4304 VGND.t326 VGND.n256 718.574
R4305 VGND.t326 VGND.n282 24.0019
R4306 VGND.t574 VGND.n285 718.573
R4307 VGND.n259 VGND.t842 718.573
R4308 VGND.n278 VGND.t1368 718.573
R4309 VGND.n263 VGND.t577 718.573
R4310 VGND.t1195 VGND.n275 718.573
R4311 VGND.t1193 VGND.n265 718.573
R4312 VGND.n274 VGND.t1462 718.573
R4313 VGND.t1461 VGND.n266 718.573
R4314 VGND.t70 VGND.n272 718.573
R4315 VGND.t50 VGND.n247 718.193
R4316 VGND.t48 VGND.n247 718.193
R4317 VGND.n290 VGND.t813 718.193
R4318 VGND.n290 VGND.t661 718.193
R4319 VGND.t1364 VGND.n319 23.2171
R4320 VGND.t311 VGND.n284 718.193
R4321 VGND.n284 VGND.t309 718.193
R4322 VGND.n322 VGND.t1212 23.2181
R4323 VGND.t1330 VGND.n280 718.193
R4324 VGND.n280 VGND.t1329 718.193
R4325 VGND.n260 VGND.t841 718.193
R4326 VGND.t332 VGND.n260 718.193
R4327 VGND.t1367 VGND.n277 718.193
R4328 VGND.n277 VGND.t580 718.193
R4329 VGND.n264 VGND.t1219 718.193
R4330 VGND.t1218 VGND.n264 718.193
R4331 VGND.n267 VGND.t1327 718.193
R4332 VGND.t1326 VGND.n267 718.193
R4333 VGND.n269 VGND.t316 718.193
R4334 VGND.n1093 VGND.n1092 650.918
R4335 VGND.n611 VGND.n610 650.918
R4336 VGND.n245 VGND.n325 0.0121182
R4337 VGND.t418 VGND.n596 644.322
R4338 VGND.t1164 VGND.n245 22.3739
R4339 VGND.t274 VGND.n238 644.312
R4340 VGND.n236 VGND.t1271 644.312
R4341 VGND.n607 VGND.t1144 644.312
R4342 VGND.n606 VGND.t1356 644.312
R4343 VGND.n605 VGND.t1645 644.312
R4344 VGND.n604 VGND.t678 644.312
R4345 VGND.n603 VGND.t243 644.312
R4346 VGND.n602 VGND.t643 644.312
R4347 VGND.n601 VGND.t537 644.312
R4348 VGND.t658 VGND.n1095 644.312
R4349 VGND.t1143 VGND.n1096 644.312
R4350 VGND.t351 VGND.n1097 644.312
R4351 VGND.t597 VGND.n1098 644.312
R4352 VGND.t1636 VGND.n591 644.311
R4353 VGND.t775 VGND.n592 644.311
R4354 VGND.t532 VGND.n593 644.311
R4355 VGND.t1133 VGND.n597 644.311
R4356 VGND.t603 VGND.n598 644.311
R4357 VGND.t1289 VGND.n599 644.311
R4358 VGND.t531 VGND.n224 22.3735
R4359 VGND.t535 VGND.n609 644.311
R4360 VGND.n230 VGND.t656 644.311
R4361 VGND.t255 VGND.n239 644.311
R4362 VGND.n229 VGND.t681 644.311
R4363 VGND.n316 VGND.t1202 22.3735
R4364 VGND.n227 VGND.t491 644.311
R4365 VGND.t1643 VGND.n242 644.311
R4366 VGND.t1392 VGND.n226 644.311
R4367 VGND.t1478 VGND.n1094 643.889
R4368 VGND.n1094 VGND.t542 643.889
R4369 VGND.t1377 VGND.n327 643.889
R4370 VGND.n317 VGND.t834 22.357
R4371 VGND.t602 VGND.n317 644.308
R4372 VGND.n595 VGND.t245 643.889
R4373 VGND.t401 VGND.n595 643.889
R4374 VGND.n223 VGND.t629 22.357
R4375 VGND.t239 VGND.n223 644.308
R4376 VGND.n608 VGND.t585 643.889
R4377 VGND.t1276 VGND.n608 643.889
R4378 VGND.n235 VGND.t1464 643.889
R4379 VGND.t1269 VGND.n235 643.889
R4380 VGND.n233 VGND.t601 643.889
R4381 VGND.t1147 VGND.n233 643.889
R4382 VGND.n231 VGND.t384 643.889
R4383 VGND.t276 VGND.n231 643.889
R4384 VGND.t522 VGND.n241 643.889
R4385 VGND.n241 VGND.t1646 643.889
R4386 VGND.t1130 VGND.n228 644.308
R4387 VGND.t645 VGND.n243 643.889
R4388 VGND.n243 VGND.t1131 643.889
R4389 VGND.t806 VGND.n756 642.857
R4390 VGND.n759 VGND.t1334 642.857
R4391 VGND.n758 VGND.t1333 642.857
R4392 VGND.t843 VGND.n271 556.011
R4393 VGND.t797 VGND.n269 555.633
R4394 VGND.t1484 VGND.n321 539.409
R4395 VGND.t335 VGND.n1023 427.779
R4396 VGND.n1014 VGND.n6 427.755
R4397 VGND.n725 VGND.n724 427.755
R4398 VGND.n845 VGND.n844 427.755
R4399 VGND.n1018 VGND.n303 427.755
R4400 VGND.n1020 VGND.n418 427.755
R4401 VGND.n180 VGND.n1088 427.132
R4402 VGND.n334 VGND.n1101 427.132
R4403 VGND.n1015 VGND.n88 427.132
R4404 VGND.t1162 VGND.n119 20.6131
R4405 VGND.n1017 VGND.n442 427.132
R4406 VGND.n816 VGND.n502 427.132
R4407 VGND.n777 VGND.n776 427.132
R4408 VGND.t767 VGND.n221 20.6394
R4409 VGND.t620 VGND.n170 19.6785
R4410 VGND.n183 VGND.n181 16.1874
R4411 VGND.t995 VGND.n296 4.08161
R4412 VGND.t1657 VGND.n125 4.24425
R4413 VGND.n184 VGND.t1051 4.08161
R4414 VGND.n124 VGND.n122 0.00248513
R4415 VGND.t969 VGND.n298 4.08161
R4416 VGND.t931 VGND.n421 423.497
R4417 VGND.n314 VGND.n308 0.025141
R4418 VGND.n313 VGND.t89 19.6776
R4419 VGND.n182 VGND.n181 16.1874
R4420 VGND.t335 VGND.n125 15.4358
R4421 VGND.t383 VGND.n299 4.08161
R4422 VGND.n123 VGND.n122 16.1874
R4423 VGND.t1235 VGND.n421 423.495
R4424 VGND.t341 VGND.n998 423.478
R4425 VGND.t865 VGND.n898 423.478
R4426 VGND.t262 VGND.n823 423.478
R4427 VGND.t1653 VGND.n126 423.471
R4428 VGND.n162 VGND.t1469 423.471
R4429 VGND.t1149 VGND.n151 423.471
R4430 VGND.t55 VGND.n338 423.471
R4431 VGND.t654 VGND.n337 423.471
R4432 VGND.n23 VGND.t953 423.471
R4433 VGND.t335 VGND.n42 16.1874
R4434 VGND.n65 VGND.t883 18.8911
R4435 VGND.t335 VGND.t17 20.6368
R4436 VGND.n52 VGND.t335 15.4357
R4437 VGND.t686 VGND.t335 19.6548
R4438 VGND.t377 VGND.n56 4.24423
R4439 VGND.t108 VGND.n72 423.471
R4440 VGND.t340 VGND.n85 423.471
R4441 VGND.t1082 VGND.n108 423.471
R4442 VGND.n113 VGND.t180 423.471
R4443 VGND.n211 VGND.t1405 423.471
R4444 VGND.n458 VGND.t845 423.471
R4445 VGND.t1006 VGND.n434 423.471
R4446 VGND.t840 VGND.n436 423.471
R4447 VGND.n448 VGND.t986 423.471
R4448 VGND.t782 VGND.n439 423.471
R4449 VGND.n446 VGND.t783 423.471
R4450 VGND.t528 VGND.n440 423.471
R4451 VGND.n445 VGND.t530 423.471
R4452 VGND.n300 VGND.t36 423.471
R4453 VGND.t259 VGND.n154 423.469
R4454 VGND.n156 VGND.t609 423.469
R4455 VGND.t110 VGND.n140 423.469
R4456 VGND.n139 VGND.t424 423.469
R4457 VGND.t1343 VGND.n129 423.469
R4458 VGND.n127 VGND.t431 423.469
R4459 VGND.t1266 VGND.n356 423.469
R4460 VGND.n355 VGND.t402 423.469
R4461 VGND.t131 VGND.n350 423.469
R4462 VGND.n20 VGND.t357 423.469
R4463 VGND.n22 VGND.t851 423.469
R4464 VGND.n53 VGND.t1407 4.24424
R4465 VGND.n52 VGND.t397 4.2443
R4466 VGND.t335 VGND.n61 16.1874
R4467 VGND.n63 VGND.t425 4.0816
R4468 VGND.n6 VGND.t227 19.6765
R4469 VGND.t1064 VGND.n6 19.6558
R4470 VGND.n6 VGND.t1059 19.6558
R4471 VGND.n55 VGND.t459 4.0816
R4472 VGND.n92 VGND.t1047 423.469
R4473 VGND.n93 VGND.t853 423.469
R4474 VGND.n79 VGND.t882 423.469
R4475 VGND.n103 VGND.t1471 423.469
R4476 VGND.t1649 VGND.n74 423.469
R4477 VGND.t626 VGND.n107 423.469
R4478 VGND.n114 VGND.t790 423.469
R4479 VGND.n188 VGND.t1170 423.469
R4480 VGND.t933 VGND.n192 423.469
R4481 VGND.n213 VGND.t463 423.469
R4482 VGND.n713 VGND.t154 423.469
R4483 VGND.n423 VGND.t875 423.469
R4484 VGND.n464 VGND.t177 423.469
R4485 VGND.t378 VGND.n476 423.469
R4486 VGND.n788 VGND.t582 423.469
R4487 VGND.t802 VGND.n314 423.471
R4488 VGND.t1391 VGND.n155 423.464
R4489 VGND.t632 VGND.n153 422.846
R4490 VGND.t1296 VGND.n153 422.846
R4491 VGND.n157 VGND.t258 422.846
R4492 VGND.t630 VGND.n157 422.846
R4493 VGND.t1277 VGND.n150 422.846
R4494 VGND.n150 VGND.t727 422.846
R4495 VGND.n158 VGND.t305 422.846
R4496 VGND.n158 VGND.t1270 422.846
R4497 VGND.t1456 VGND.n148 422.846
R4498 VGND.n148 VGND.t51 422.846
R4499 VGND.t534 VGND.n146 422.846
R4500 VGND.n159 VGND.t398 422.846
R4501 VGND.n159 VGND.t623 422.846
R4502 VGND.n160 VGND.t1393 422.846
R4503 VGND.t1463 VGND.n160 422.846
R4504 VGND.t1264 VGND.n144 422.846
R4505 VGND.n143 VGND.t616 422.846
R4506 VGND.t786 VGND.n163 422.846
R4507 VGND.n164 VGND.t763 422.846
R4508 VGND.t891 VGND.n166 422.846
R4509 VGND.n141 VGND.t662 422.846
R4510 VGND.t293 VGND.n137 422.846
R4511 VGND.t349 VGND.n135 422.846
R4512 VGND.t676 VGND.n171 423.464
R4513 VGND.t844 VGND.n133 422.846
R4514 VGND.n133 VGND.t1322 422.846
R4515 VGND.n172 VGND.t1388 422.846
R4516 VGND.t1353 VGND.n172 422.846
R4517 VGND.t724 VGND.n132 422.846
R4518 VGND.n132 VGND.t725 422.846
R4519 VGND.t291 VGND.n130 422.846
R4520 VGND.t1132 VGND.n173 422.846
R4521 VGND.t546 VGND.n128 422.846
R4522 VGND.n128 VGND.t20 422.846
R4523 VGND.n175 VGND.t633 422.846
R4524 VGND.t576 VGND.n175 422.846
R4525 VGND.n178 VGND.t261 422.846
R4526 VGND.t407 VGND.n178 422.846
R4527 VGND.t247 VGND.n335 422.846
R4528 VGND.n378 VGND.t505 422.846
R4529 VGND.n376 VGND.t1396 422.846
R4530 VGND.t1284 VGND.n374 422.846
R4531 VGND.t241 VGND.n364 422.846
R4532 VGND.t409 VGND.n363 422.846
R4533 VGND.n363 VGND.t1151 422.846
R4534 VGND.t879 VGND.n362 422.846
R4535 VGND.n362 VGND.t1398 422.846
R4536 VGND.t395 VGND.n361 422.846
R4537 VGND.n361 VGND.t1400 422.846
R4538 VGND.t785 VGND.n359 422.846
R4539 VGND.t1641 VGND.n358 422.846
R4540 VGND.n358 VGND.t488 422.846
R4541 VGND.t1350 VGND.n357 422.846
R4542 VGND.n357 VGND.t1286 422.846
R4543 VGND.n344 VGND.t1293 422.846
R4544 VGND.n346 VGND.t370 422.846
R4545 VGND.n348 VGND.t830 422.846
R4546 VGND.n349 VGND.t1477 422.846
R4547 VGND.n18 VGND.t941 422.846
R4548 VGND.n18 VGND.t613 422.846
R4549 VGND.t1073 VGND.n41 19.6259
R4550 VGND.t541 VGND.n16 422.846
R4551 VGND.n15 VGND.t539 422.846
R4552 VGND.n19 VGND.t914 422.846
R4553 VGND.t448 VGND.n19 422.846
R4554 VGND.n21 VGND.t1055 422.846
R4555 VGND.t200 VGND.n21 422.846
R4556 VGND.n26 VGND.t1045 422.846
R4557 VGND.n26 VGND.t120 422.846
R4558 VGND.t1304 VGND.n13 422.846
R4559 VGND.t904 VGND.n29 422.846
R4560 VGND.t353 VGND.n31 422.846
R4561 VGND.t963 VGND.n32 422.846
R4562 VGND.t901 VGND.n33 422.846
R4563 VGND.n54 VGND.t1154 19.6268
R4564 VGND.t270 VGND.t335 19.6556
R4565 VGND.t335 VGND.t0 19.6555
R4566 VGND.t335 VGND.t189 19.6782
R4567 VGND.n1032 VGND.t215 422.846
R4568 VGND.n1030 VGND.t1303 422.846
R4569 VGND.t1076 VGND.n1028 422.846
R4570 VGND.n1028 VGND.t1345 422.846
R4571 VGND.t334 VGND.n1026 422.846
R4572 VGND.n1026 VGND.t1340 422.846
R4573 VGND.t964 VGND.n6 19.6259
R4574 VGND.t1403 VGND.n1007 422.846
R4575 VGND.n1005 VGND.t1075 422.846
R4576 VGND.t389 VGND.n1003 422.846
R4577 VGND.t468 VGND.n993 422.846
R4578 VGND.n991 VGND.t182 422.846
R4579 VGND.t216 VGND.n984 422.846
R4580 VGND.n9 VGND.n6 3.73737
R4581 VGND.t885 VGND.n2 422.846
R4582 VGND.t918 VGND.n3 422.846
R4583 VGND.n3 VGND.t337 422.846
R4584 VGND.n6 VGND.n10 16.1874
R4585 VGND.t1087 VGND.n4 422.846
R4586 VGND.n4 VGND.t158 422.846
R4587 VGND.n406 VGND.t371 422.846
R4588 VGND.t1245 VGND.n405 422.846
R4589 VGND.n404 VGND.t150 422.846
R4590 VGND.t1421 VGND.n404 422.846
R4591 VGND.n402 VGND.t152 422.846
R4592 VGND.t1057 VGND.n400 422.846
R4593 VGND.t423 VGND.n399 422.846
R4594 VGND.t472 VGND.n398 422.846
R4595 VGND.n87 VGND.t1096 422.846
R4596 VGND.n86 VGND.t962 422.846
R4597 VGND.n90 VGND.t1361 422.846
R4598 VGND.t231 VGND.n91 422.846
R4599 VGND.n83 VGND.t460 422.846
R4600 VGND.n97 VGND.t205 422.846
R4601 VGND.n99 VGND.t1153 422.846
R4602 VGND.t268 VGND.n100 422.846
R4603 VGND.t877 VGND.n297 19.6484
R4604 VGND.n297 VGND.t611 423.464
R4605 VGND.t151 VGND.n73 422.846
R4606 VGND.n73 VGND.t40 422.846
R4607 VGND.n106 VGND.t1031 422.846
R4608 VGND.t1049 VGND.n106 422.846
R4609 VGND.t346 VGND.n71 422.846
R4610 VGND.t1123 VGND.n71 422.846
R4611 VGND.n69 VGND.t1165 422.846
R4612 VGND.t38 VGND.n115 422.846
R4613 VGND.n117 VGND.t1109 422.846
R4614 VGND.t852 VGND.n117 422.846
R4615 VGND.n118 VGND.t1046 422.846
R4616 VGND.t1162 VGND.n118 422.846
R4617 VGND.t948 VGND.n187 422.846
R4618 VGND.n189 VGND.t475 422.846
R4619 VGND.t1120 VGND.n189 422.846
R4620 VGND.t455 VGND.n186 422.846
R4621 VGND.n186 VGND.t321 422.846
R4622 VGND.n190 VGND.t906 422.846
R4623 VGND.n190 VGND.t930 422.846
R4624 VGND.n194 VGND.t756 422.846
R4625 VGND.n197 VGND.t1115 422.846
R4626 VGND.t1034 VGND.n198 422.846
R4627 VGND.n209 VGND.t173 422.846
R4628 VGND.t1091 VGND.n209 422.846
R4629 VGND.n210 VGND.t1466 422.846
R4630 VGND.t473 VGND.n210 422.846
R4631 VGND.n212 VGND.t1155 422.846
R4632 VGND.n214 VGND.t494 422.846
R4633 VGND.t264 VGND.n214 422.846
R4634 VGND.t1112 VGND.n720 422.846
R4635 VGND.t625 VGND.n718 422.846
R4636 VGND.n710 VGND.t281 422.846
R4637 VGND.t25 VGND.n705 422.846
R4638 VGND.n443 VGND.t589 422.846
R4639 VGND.n444 VGND.t1114 422.846
R4640 VGND.n450 VGND.t438 422.846
R4641 VGND.t436 VGND.n438 422.846
R4642 VGND.n451 VGND.t765 422.846
R4643 VGND.t764 VGND.n437 422.846
R4644 VGND.n452 VGND.t328 422.846
R4645 VGND.t839 VGND.n452 422.846
R4646 VGND.t998 VGND.n435 422.846
R4647 VGND.n435 VGND.t722 422.846
R4648 VGND.t1062 VGND.n433 422.846
R4649 VGND.n453 VGND.t1371 422.846
R4650 VGND.t411 VGND.n453 422.846
R4651 VGND.t512 VGND.n431 422.846
R4652 VGND.n431 VGND.t925 422.846
R4653 VGND.n454 VGND.t510 422.846
R4654 VGND.t1413 VGND.n454 422.846
R4655 VGND.t484 VGND.n430 422.846
R4656 VGND.n430 VGND.t1078 422.846
R4657 VGND.n455 VGND.t483 422.846
R4658 VGND.t956 VGND.n455 422.846
R4659 VGND.t679 VGND.n429 422.846
R4660 VGND.n429 VGND.t426 422.846
R4661 VGND.n456 VGND.t394 422.846
R4662 VGND.t304 VGND.n456 422.846
R4663 VGND.t393 VGND.n428 422.846
R4664 VGND.n428 VGND.t249 422.846
R4665 VGND.n457 VGND.t1146 422.846
R4666 VGND.t1167 VGND.n457 422.846
R4667 VGND.t682 VGND.n427 422.846
R4668 VGND.n427 VGND.t1161 422.846
R4669 VGND.n461 VGND.t2 422.846
R4670 VGND.t520 VGND.n461 422.846
R4671 VGND.t936 VGND.n424 422.846
R4672 VGND.n424 VGND.t581 422.846
R4673 VGND.n463 VGND.t236 422.846
R4674 VGND.n468 VGND.t167 422.846
R4675 VGND.n470 VGND.t462 422.846
R4676 VGND.t421 VGND.n470 422.846
R4677 VGND.n471 VGND.t381 422.846
R4678 VGND.t179 VGND.n471 422.846
R4679 VGND.n472 VGND.t968 422.846
R4680 VGND.t624 VGND.n472 422.846
R4681 VGND.t1415 VGND.n475 422.846
R4682 VGND.t344 VGND.n480 422.846
R4683 VGND.t1448 VGND.n831 422.846
R4684 VGND.n839 VGND.t1188 422.846
R4685 VGND.t208 VGND.n839 422.846
R4686 VGND.n841 VGND.t743 422.846
R4687 VGND.t206 VGND.n841 422.846
R4688 VGND.t599 VGND.n801 422.846
R4689 VGND.t67 VGND.n807 422.846
R4690 VGND.n305 VGND.t65 422.846
R4691 VGND.t489 VGND.n304 422.846
R4692 VGND.n307 VGND.t58 422.846
R4693 VGND.t277 VGND.n311 19.6484
R4694 VGND.n311 VGND.t560 423.464
R4695 VGND.n301 VGND.t34 422.846
R4696 VGND.n302 VGND.t795 422.846
R4697 VGND.t731 VGND.n492 422.846
R4698 VGND.t135 VGND.n490 422.846
R4699 VGND.t97 VGND.n777 422.846
R4700 VGND.t95 VGND.n779 422.846
R4701 VGND.n784 VGND.t295 422.846
R4702 VGND.n790 VGND.t415 422.846
R4703 VGND.t590 VGND.n78 419.183
R4704 VGND.n77 VGND.t1004 418.56
R4705 VGND.n1100 VGND.n323 411.43
R4706 VGND.n1086 VGND.n558 411.43
R4707 VGND.n1087 VGND.n1086 411.43
R4708 VGND.n1013 VGND.n629 411.43
R4709 VGND.n1022 VGND.n395 427.132
R4710 VGND.n1021 VGND.n119 427.755
R4711 VGND.n1016 VGND.n324 411.43
R4712 VGND.n1019 VGND.n420 427.132
R4713 VGND.n819 VGND.n818 411.43
R4714 VGND.n782 VGND.n781 411.43
R4715 VGND.n6 VGND.t1042 410.637
R4716 VGND.t1252 VGND.n515 410.104
R4717 VGND.n524 VGND.t1258 410.104
R4718 VGND.n654 VGND.t190 410.104
R4719 VGND.t1435 VGND.n902 410.104
R4720 VGND.t1249 VGND.n896 410.104
R4721 VGND.n729 VGND.t712 410.104
R4722 VGND.t635 VGND.n884 410.104
R4723 VGND.n820 VGND.t804 410.104
R4724 VGND.n793 VGND.t707 410.104
R4725 VGND.n343 VGND.t1431 409.99
R4726 VGND.n1070 VGND.t498 407.144
R4727 VGND.t507 VGND.n1064 407.144
R4728 VGND.n1073 VGND.t1451 407.144
R4729 VGND.t781 VGND.n1062 407.144
R4730 VGND.t1299 VGND.n1061 407.144
R4731 VGND.n1074 VGND.t734 407.144
R4732 VGND.t1441 VGND.n1059 407.144
R4733 VGND.n1075 VGND.t372 407.144
R4734 VGND.n1075 VGND.t1197 407.144
R4735 VGND.n1058 VGND.t390 407.144
R4736 VGND.n1076 VGND.t538 407.144
R4737 VGND.t1137 VGND.n1057 407.144
R4738 VGND.t283 VGND.n1057 407.144
R4739 VGND.n1077 VGND.t1411 407.144
R4740 VGND.n1078 VGND.t1268 407.144
R4741 VGND.t595 VGND.n1055 407.144
R4742 VGND.n1082 VGND.t1295 407.144
R4743 VGND.n1082 VGND.t1430 407.144
R4744 VGND.t668 VGND.n1054 407.144
R4745 VGND.n1083 VGND.t1283 407.144
R4746 VGND.n1083 VGND.t1354 407.144
R4747 VGND.t1460 VGND.n1052 407.144
R4748 VGND.n1085 VGND.t586 407.144
R4749 VGND.n1085 VGND.t303 407.144
R4750 VGND.t253 VGND.n1051 407.144
R4751 VGND.n1102 VGND.t677 407.144
R4752 VGND.t618 VGND.n583 407.144
R4753 VGND.n1103 VGND.t1459 407.144
R4754 VGND.n576 VGND.t1136 407.144
R4755 VGND.t178 VGND.n575 407.144
R4756 VGND.t1352 VGND.n522 407.144
R4757 VGND.t1142 VGND.n566 407.144
R4758 VGND.t555 VGND.n563 407.144
R4759 VGND.n550 VGND.t1485 407.144
R4760 VGND.n551 VGND.t1273 407.144
R4761 VGND.n553 VGND.t237 407.144
R4762 VGND.t593 VGND.n553 407.144
R4763 VGND.n554 VGND.t1178 407.144
R4764 VGND.t1236 VGND.n627 407.144
R4765 VGND.n630 VGND.t1030 407.144
R4766 VGND.n630 VGND.t429 407.144
R4767 VGND.t541 VGND.n44 19.849
R4768 VGND.t949 VGND.n37 18.8704
R4769 VGND.t1342 VGND.n622 407.144
R4770 VGND.t361 VGND.n622 407.144
R4771 VGND.n67 VGND.t457 422.705
R4772 VGND.n67 VGND.t1426 18.8913
R4773 VGND.n68 VGND.t366 18.8913
R4774 VGND.t356 VGND.n621 407.144
R4775 VGND.t224 VGND.n621 407.144
R4776 VGND.t224 VGND.n48 19.849
R4777 VGND.t954 VGND.n619 407.144
R4778 VGND.n631 VGND.t1077 407.144
R4779 VGND.n631 VGND.t439 407.144
R4780 VGND.t142 VGND.n66 18.8913
R4781 VGND.t884 VGND.n636 407.144
R4782 VGND.t1482 VGND.n637 407.144
R4783 VGND.t1600 VGND.n58 242.707
R4784 VGND.t1594 VGND.n62 221.278
R4785 VGND.t1315 VGND.n1025 407.144
R4786 VGND.t1234 VGND.n1012 407.144
R4787 VGND.n1012 VGND.t983 407.144
R4788 VGND.n57 VGND.t14 18.8704
R4789 VGND.t1148 VGND.n1011 407.144
R4790 VGND.n1011 VGND.t966 407.144
R4791 VGND.t960 VGND.n1009 407.144
R4792 VGND.n1009 VGND.t358 407.144
R4793 VGND.t221 VGND.n986 407.144
R4794 VGND.t892 VGND.n975 407.144
R4795 VGND.n972 VGND.t810 407.144
R4796 VGND.n39 VGND.t965 18.8704
R4797 VGND.t129 VGND.n655 407.144
R4798 VGND.n960 VGND.t1013 407.144
R4799 VGND.n643 VGND.t1168 407.144
R4800 VGND.t698 VGND.n643 407.144
R4801 VGND.t870 VGND.n644 407.144
R4802 VGND.n645 VGND.t1093 407.144
R4803 VGND.n646 VGND.t1110 407.144
R4804 VGND.t973 VGND.n646 407.144
R4805 VGND.t943 VGND.n922 407.144
R4806 VGND.n923 VGND.t958 407.144
R4807 VGND.t1027 VGND.n920 407.144
R4808 VGND.t146 VGND.n920 407.144
R4809 VGND.n924 VGND.t556 407.144
R4810 VGND.n924 VGND.t898 407.144
R4811 VGND.t1175 VGND.n919 407.144
R4812 VGND.t445 VGND.n918 407.144
R4813 VGND.t1074 VGND.n918 407.144
R4814 VGND.n925 VGND.t1119 407.144
R4815 VGND.n925 VGND.t523 407.144
R4816 VGND.t198 VGND.n917 407.144
R4817 VGND.t706 VGND.n916 407.144
R4818 VGND.n926 VGND.t990 407.144
R4819 VGND.n934 VGND.t935 407.144
R4820 VGND.n937 VGND.t1098 407.144
R4821 VGND.t927 VGND.n937 407.144
R4822 VGND.n938 VGND.t1104 407.144
R4823 VGND.t382 VGND.n938 407.144
R4824 VGND.n939 VGND.t121 407.144
R4825 VGND.t691 VGND.n939 407.144
R4826 VGND.t388 VGND.n668 407.144
R4827 VGND.n684 VGND.t485 407.144
R4828 VGND.n315 VGND.t1034 19.8482
R4829 VGND.n692 VGND.t894 407.144
R4830 VGND.t469 VGND.n692 407.144
R4831 VGND.n696 VGND.t517 407.144
R4832 VGND.t1025 VGND.n721 407.144
R4833 VGND.t314 VGND.n719 407.144
R4834 VGND.n714 VGND.t518 407.144
R4835 VGND.n712 VGND.t1017 407.144
R4836 VGND.t1081 VGND.n708 407.144
R4837 VGND.t916 VGND.n748 407.144
R4838 VGND.n855 VGND.t1159 407.144
R4839 VGND.t1056 VGND.n747 407.144
R4840 VGND.n856 VGND.t1179 407.144
R4841 VGND.t942 VGND.n745 407.144
R4842 VGND.n858 VGND.t1005 407.144
R4843 VGND.t1647 VGND.n737 407.144
R4844 VGND.t821 VGND.n737 407.144
R4845 VGND.n864 VGND.t961 407.144
R4846 VGND.n864 VGND.t456 407.144
R4847 VGND.t192 VGND.n736 407.144
R4848 VGND.t87 VGND.n734 407.144
R4849 VGND.t1169 VGND.n734 407.144
R4850 VGND.t726 VGND.n874 407.144
R4851 VGND.n875 VGND.t1346 407.144
R4852 VGND.t228 VGND.n875 407.144
R4853 VGND.n876 VGND.t234 407.144
R4854 VGND.t385 VGND.n876 407.144
R4855 VGND.n877 VGND.t333 407.144
R4856 VGND.t1108 VGND.n877 407.144
R4857 VGND.t461 VGND.n878 407.144
R4858 VGND.n829 VGND.t416 407.144
R4859 VGND.n835 VGND.t568 407.144
R4860 VGND.t628 VGND.n835 407.144
R4861 VGND.n837 VGND.t1189 407.144
R4862 VGND.t627 VGND.n837 407.144
R4863 VGND.t1201 VGND.n799 407.144
R4864 VGND.t1332 VGND.n804 407.144
R4865 VGND.n809 VGND.t284 407.144
R4866 VGND.n310 VGND.t58 19.8481
R4867 VGND.n815 VGND.t819 407.144
R4868 VGND.n814 VGND.t818 407.144
R4869 VGND.n810 VGND.t794 407.144
R4870 VGND.t671 VGND.n772 407.144
R4871 VGND.n817 VGND.t669 407.144
R4872 VGND.t1339 VGND.n782 407.144
R4873 VGND.n785 VGND.t1184 407.144
R4874 VGND.n786 VGND.t294 407.144
R4875 VGND.t1338 VGND.n786 407.144
R4876 VGND.n789 VGND.t801 407.144
R4877 VGND.t1026 VGND.t859 405.647
R4878 VGND.t862 VGND.t959 405.647
R4879 VGND.t856 VGND.t339 405.647
R4880 VGND.t642 VGND.t1397 402.858
R4881 VGND.t739 VGND.t1088 402.858
R4882 VGND.t500 VGND.t1465 402.858
R4883 VGND.t1419 VGND.t238 402.858
R4884 VGND.t817 VGND.t1267 402.858
R4885 VGND.t1642 VGND.t432 402.858
R4886 VGND.t327 VGND.t1656 402.858
R4887 VGND.t1135 VGND.t122 402.858
R4888 VGND.t1412 VGND.t1141 402.858
R4889 VGND.t348 VGND.t1287 402.858
R4890 VGND.t649 VGND.n577 402.858
R4891 VGND.t18 VGND.t1423 402.858
R4892 VGND.t42 VGND.t1288 402.858
R4893 VGND.t1480 VGND.t406 402.858
R4894 VGND.t72 VGND.n571 402.858
R4895 VGND.n540 VGND.t774 402.858
R4896 VGND.n542 VGND.t772 402.858
R4897 VGND.t27 VGND.t257 402.858
R4898 VGND.t1422 VGND.t1410 402.858
R4899 VGND.n635 VGND.t653 402.858
R4900 VGND.t1111 VGND.t1177 402.858
R4901 VGND.t651 VGND.n989 402.858
R4902 VGND.t75 VGND.n973 402.858
R4903 VGND.t297 VGND.n43 18.6993
R4904 VGND.t266 VGND.t823 402.858
R4905 VGND.t674 VGND.n657 402.858
R4906 VGND.n641 VGND.t641 402.858
R4907 VGND.t994 VGND.t13 402.858
R4908 VGND.t1362 VGND.t1444 402.858
R4909 VGND.t144 VGND.t700 402.858
R4910 VGND.t872 VGND.t419 402.858
R4911 VGND.t903 VGND.t1181 402.858
R4912 VGND.t1433 VGND.n908 402.858
R4913 VGND.n683 VGND.t1106 402.858
R4914 VGND.t1121 VGND.t509 402.858
R4915 VGND.t937 VGND.t715 402.858
R4916 VGND.t1172 VGND.t1019 402.858
R4917 VGND.t1066 VGND.t1468 402.858
R4918 VGND.t1028 VGND.t701 402.858
R4919 VGND.t1429 VGND.t526 402.858
R4920 VGND.t1372 VGND.t1002 402.858
R4921 VGND.n871 VGND.t1473 402.858
R4922 VGND.t450 VGND.t728 402.858
R4923 VGND.t689 VGND.t1417 402.858
R4924 VGND.n833 VGND.t673 402.858
R4925 VGND.t286 VGND.t1341 402.858
R4926 VGND.n771 VGND.t639 402.858
R4927 VGND.t770 VGND.n962 398.572
R4928 VGND.t1331 VGND.t1640 398.572
R4929 VGND.t1215 VGND.n567 394.286
R4930 VGND.n971 VGND.t1039 394.286
R4931 VGND.t1475 VGND.n674 394.286
R4932 VGND.n954 VGND.t665 392.274
R4933 VGND.t779 VGND.n936 392.274
R4934 VGND.t760 VGND.t1171 390
R4935 VGND.n103 VGND.t413 384.899
R4936 VGND.t187 VGND.n77 384.274
R4937 VGND.n1068 VGND.t550 372.858
R4938 VGND.t1139 VGND.n1049 372.858
R4939 VGND.t169 VGND.n582 372.858
R4940 VGND.n581 VGND.t544 372.858
R4941 VGND.t647 VGND.n555 372.858
R4942 VGND.t427 VGND.n557 372.858
R4943 VGND.t921 VGND.n628 372.858
R4944 VGND.n1024 VGND.t1102 372.858
R4945 VGND.t272 VGND.n648 372.858
R4946 VGND.t148 VGND.n650 372.858
R4947 VGND.n929 VGND.t761 372.858
R4948 VGND.n707 VGND.t755 372.858
R4949 VGND.t551 VGND.n880 372.858
R4950 VGND.n812 VGND.t307 372.858
R4951 VGND.t1486 VGND.n249 371.293
R4952 VGND.n279 VGND.t1487 371.293
R4953 VGND.n250 VGND.t1486 371.293
R4954 VGND.t159 VGND.t515 368.572
R4955 VGND.t1292 VGND.n534 357.586
R4956 VGND.n928 VGND.t1070 355.714
R4957 VGND.t1024 VGND.n913 347.144
R4958 VGND.t1470 VGND.n203 345.704
R4959 VGND.t1150 VGND.n521 343.24
R4960 VGND.n559 VGND.t1355 343.24
R4961 VGND.n1033 VGND.t355 343.24
R4962 VGND.n997 VGND.t1404 343.24
R4963 VGND.n979 VGND.t453 343.24
R4964 VGND.t1021 VGND.n957 343.24
R4965 VGND.t680 VGND.n943 343.24
R4966 VGND.n897 VGND.t1048 343.24
R4967 VGND.t1374 VGND.n825 343.24
R4968 VGND.t226 VGND.n367 342.041
R4969 VGND.t952 VGND.n722 342.041
R4970 VGND.n469 VGND.t1125 342.041
R4971 VGND.n5 VGND.t1176 341.418
R4972 VGND.n405 VGND.t9 341.418
R4973 VGND.n196 VGND.t549 341.418
R4974 VGND.n807 VGND.t1383 341.418
R4975 VGND.t1450 VGND.t1424 338.783
R4976 VGND.t273 VGND.t1244 338.783
R4977 VGND.t1301 VGND.t820 338.783
R4978 VGND.t1243 VGND.t91 338.783
R4979 VGND.t598 VGND.t600 338.783
R4980 VGND.t738 VGND.t223 334.286
R4981 VGND.n246 VGND.n245 0.00139038
R4982 VGND.n318 VGND.t1633 158.489
R4983 VGND.n326 VGND.t1631 333.75
R4984 VGND.n237 VGND.t1634 333.75
R4985 VGND.n246 VGND.t1635 166.875
R4986 VGND.t166 VGND.n570 330
R4987 VGND.n544 VGND.t824 330
R4988 VGND.n9 VGND.t703 72.5306
R4989 VGND.n961 VGND.t104 330
R4990 VGND.t1040 VGND.n914 330
R4991 VGND.t826 VGND.n681 330
R4992 VGND.t1652 VGND.n351 329.185
R4993 VGND.t1080 VGND.n418 329.185
R4994 VGND.n179 VGND.t124 329.183
R4995 VGND.n332 VGND.t780 328.56
R4996 VGND.t1107 VGND.n379 328.56
R4997 VGND.n705 VGND.t516 328.56
R4998 VGND.n541 VGND.t721 325.714
R4999 VGND.n543 VGND.t434 325.714
R5000 VGND.t619 VGND.n988 325.714
R5001 VGND.t1360 VGND.n972 325.714
R5002 VGND.n933 VGND.t1408 325.714
R5003 VGND.n834 VGND.t1211 325.714
R5004 VGND.t287 VGND.n518 325.409
R5005 VGND.t1280 VGND.t1275 321.43
R5006 VGND.t1063 VGND.t1079 321.43
R5007 VGND.t1190 VGND.t137 321.43
R5008 VGND.n1092 VGND.t1631 317.182
R5009 VGND.n318 VGND.n327 658.571
R5010 VGND.t1634 VGND.n611 317.182
R5011 VGND.n578 VGND.t1285 317.144
R5012 VGND.n573 VGND.t1454 317.144
R5013 VGND.t594 VGND.t80 317.144
R5014 VGND.t1279 VGND.n537 317.144
R5015 VGND.t408 VGND.n539 317.144
R5016 VGND.t1442 VGND.t861 317.144
R5017 VGND.t271 VGND.n634 317.144
R5018 VGND.t864 VGND.t915 317.144
R5019 VGND.t858 VGND.t769 317.144
R5020 VGND.n974 VGND.t1023 317.144
R5021 VGND.n953 VGND.t553 317.144
R5022 VGND.t663 VGND.t1401 317.144
R5023 VGND.t1033 VGND.t86 317.144
R5024 VGND.t945 VGND.n640 317.144
R5025 VGND.t777 VGND.t490 317.144
R5026 VGND.t1241 VGND.t1437 317.144
R5027 VGND.t1118 VGND.n679 317.144
R5028 VGND.t511 VGND.t1251 317.144
R5029 VGND.t1067 VGND.n687 317.144
R5030 VGND.t978 VGND.t714 317.144
R5031 VGND.t422 VGND.t637 317.144
R5032 VGND.t1099 VGND.n870 317.144
R5033 VGND.t1449 VGND.t1257 317.144
R5034 VGND.t588 VGND.n830 317.144
R5035 VGND.t561 VGND.t709 317.144
R5036 VGND.t1384 VGND.n803 317.144
R5037 VGND.t744 VGND.t1262 317.144
R5038 VGND.t742 VGND.n770 317.144
R5039 VGND.t1366 VGND.n323 312.858
R5040 VGND.n1103 VGND.t988 312.858
R5041 VGND.t1126 VGND.n556 312.858
R5042 VGND.n629 VGND.t1263 312.858
R5043 VGND.n1025 VGND.t878 312.858
R5044 VGND.t161 VGND.t1010 312.858
R5045 VGND.t868 VGND.n647 312.858
R5046 VGND.t685 VGND.n649 312.858
R5047 VGND.t443 VGND.t1100 312.858
R5048 VGND.t1483 VGND.n324 312.858
R5049 VGND.n708 VGND.t835 312.858
R5050 VGND.t1000 VGND.n879 312.858
R5051 VGND.n813 VGND.t278 312.858
R5052 VGND.t652 VGND.n28 307.755
R5053 VGND.n379 VGND.t648 307.132
R5054 VGND.n993 VGND.t650 307.132
R5055 VGND.t1434 VGND.n69 307.132
R5056 VGND.t1637 VGND.n217 307.132
R5057 VGND.t1129 VGND.n366 302.846
R5058 VGND.t1101 VGND.n911 300
R5059 VGND.n75 VGND.t934 298.56
R5060 VGND.t605 VGND.n531 292.57
R5061 VGND.n533 VGND.t740 292.57
R5062 VGND.t773 VGND.n536 291.43
R5063 VGND.t771 VGND.n538 291.43
R5064 VGND.n975 VGND.t74 291.43
R5065 VGND.t675 VGND.n655 291.43
R5066 VGND.t672 VGND.n829 291.43
R5067 VGND.t1639 VGND.n802 291.43
R5068 VGND.t1290 VGND.t631 287.144
R5069 VGND.n545 VGND.t525 287.144
R5070 VGND.n962 VGND.t928 287.144
R5071 VGND.t640 VGND.t181 287.144
R5072 VGND.t1007 VGND.n680 287.144
R5073 VGND.t710 VGND.t375 287.144
R5074 VGND.t1472 VGND.t1237 287.144
R5075 VGND.t638 VGND.t62 287.144
R5076 VGND.n517 VGND.t683 280.832
R5077 VGND.n527 VGND.t1281 280.832
R5078 VGND.n528 VGND.t112 280.832
R5079 VGND.t138 VGND.n1034 280.832
R5080 VGND.t1036 VGND.n1033 280.832
R5081 VGND.t466 VGND.n1000 280.832
R5082 VGND.t1029 VGND.n997 280.832
R5083 VGND.t379 VGND.n981 280.832
R5084 VGND.t404 VGND.n979 280.832
R5085 VGND.n957 VGND.t1053 280.832
R5086 VGND.n956 VGND.t719 280.832
R5087 VGND.t441 VGND.n652 280.832
R5088 VGND.t993 VGND.n651 280.832
R5089 VGND.n943 VGND.t183 280.832
R5090 VGND.n942 VGND.t1086 280.832
R5091 VGND.t210 VGND.n900 280.832
R5092 VGND.t907 VGND.n897 280.832
R5093 VGND.t749 VGND.n894 280.832
R5094 VGND.t410 VGND.n893 280.832
R5095 VGND.t451 VGND.n727 280.832
R5096 VGND.t519 VGND.n726 280.832
R5097 VGND.t579 VGND.n881 280.832
R5098 VGND.n822 VGND.t1323 280.832
R5099 VGND.n825 VGND.t1185 280.832
R5100 VGND.n797 VGND.t800 280.832
R5101 VGND.t1083 VGND.t944 276.375
R5102 VGND.t496 VGND.t729 276.375
R5103 VGND.n568 VGND.t1214 274.286
R5104 VGND.t1432 VGND.n548 274.286
R5105 VGND.t1043 VGND.n965 274.286
R5106 VGND.n677 VGND.t1474 274.286
R5107 VGND.t132 VGND.t711 274.286
R5108 VGND.n569 VGND.t608 270
R5109 VGND.t1160 VGND.n547 270
R5110 VGND.t1038 VGND.t1174 270
R5111 VGND.t1018 VGND.n968 270
R5112 VGND.n678 VGND.t1124 270
R5113 VGND.t196 VGND.t757 257.144
R5114 VGND.t82 VGND.n531 255.418
R5115 VGND.n580 VGND.t684 254.087
R5116 VGND.n574 VGND.t1282 254.087
R5117 VGND.t139 VGND.n633 254.087
R5118 VGND.t718 VGND.n958 254.087
R5119 VGND.t442 VGND.n639 254.087
R5120 VGND.t211 VGND.n673 254.087
R5121 VGND.t750 VGND.n685 254.087
R5122 VGND.t452 VGND.n698 254.087
R5123 VGND.t1084 VGND.n867 254.087
R5124 VGND.t1324 VGND.n826 254.087
R5125 VGND.t730 VGND.n798 254.087
R5126 VGND.t1548 VGND.n80 252.041
R5127 VGND.n717 VGND.t1540 252.041
R5128 VGND.t1598 VGND.n34 251.417
R5129 VGND.t1555 VGND.n104 251.417
R5130 VGND.n194 VGND.t1527 251.417
R5131 VGND.t881 VGND.t467 249.63
R5132 VGND.t1085 VGND.t365 249.63
R5133 VGND.t53 VGND.n515 245.172
R5134 VGND.t1253 VGND.n517 245.172
R5135 VGND.t615 VGND.n524 245.172
R5136 VGND.t741 VGND.t83 245.172
R5137 VGND.n1036 VGND.t1305 245.172
R5138 VGND.n1034 VGND.t860 245.172
R5139 VGND.n1002 VGND.t1157 245.172
R5140 VGND.n1000 VGND.t863 245.172
R5141 VGND.n983 VGND.t222 245.172
R5142 VGND.n981 VGND.t857 245.172
R5143 VGND.t664 VGND.n956 245.172
R5144 VGND.t127 VGND.n954 245.172
R5145 VGND.n654 VGND.t296 245.172
R5146 VGND.t778 VGND.n942 245.172
R5147 VGND.t1247 VGND.n936 245.172
R5148 VGND.n902 VGND.t908 245.172
R5149 VGND.n900 VGND.t1436 245.172
R5150 VGND.n896 VGND.t103 245.172
R5151 VGND.n729 VGND.t495 245.172
R5152 VGND.n727 VGND.t713 245.172
R5153 VGND.n884 VGND.t803 245.172
R5154 VGND.n882 VGND.t636 245.172
R5155 VGND.t1348 VGND.n820 245.172
R5156 VGND.t1256 VGND.n822 245.172
R5157 VGND.t170 VGND.n793 245.172
R5158 VGND.t708 VGND.n795 245.172
R5159 VGND.t1593 VGND.n1030 242.846
R5160 VGND.t1576 VGND.n985 242.846
R5161 VGND.t1399 VGND.t1479 240.714
R5162 VGND.t1259 VGND.t570 240.714
R5163 VGND.t982 VGND.t85 240.714
R5164 VGND.t545 VGND.t1250 240.714
R5165 VGND.t1596 VGND.n49 243.578
R5166 VGND.n988 VGND.t1575 235.714
R5167 VGND.n46 VGND.t1577 101.781
R5168 VGND.t1537 VGND.n700 235.714
R5169 VGND.t1504 VGND.n842 235.714
R5170 VGND.n818 VGND.t1509 235.714
R5171 VGND.t1512 VGND.n502 235.714
R5172 VGND.t1515 VGND.n778 235.714
R5173 VGND.t17 VGND.t1592 231.429
R5174 VGND.t1260 VGND.t1617 227.143
R5175 VGND.t1597 VGND.n620 227.143
R5176 VGND.n930 VGND.t924 227.143
R5177 VGND.n903 VGND.t1530 227.143
R5178 VGND.t1541 VGND.n714 227.143
R5179 VGND.n817 VGND.t1511 227.143
R5180 VGND.n781 VGND.t1516 227.143
R5181 VGND.t1238 VGND.n202 225.703
R5182 VGND.n47 VGND.t1578 100.671
R5183 VGND.t1549 VGND.t867 222.857
R5184 VGND.t746 VGND.t1506 222.857
R5185 VGND.t1224 VGND.t1514 222.857
R5186 VGND.n170 VGND.t1627 222.069
R5187 VGND.n122 VGND.t1550 222.067
R5188 VGND.n215 VGND.t1534 111.022
R5189 VGND.n447 VGND.t1519 222.065
R5190 VGND.n6 VGND.n50 10.3196
R5191 VGND.n354 VGND.t1623 222.065
R5192 VGND.n156 VGND.t1625 222.042
R5193 VGND.n381 VGND.t1616 222.042
R5194 VGND.t1620 VGND.n355 222.042
R5195 VGND.n356 VGND.t1620 222.042
R5196 VGND.n38 VGND.t1589 110.939
R5197 VGND.t1574 VGND.n60 102.703
R5198 VGND.n93 VGND.t1545 222.042
R5199 VGND.n192 VGND.t1542 222.042
R5200 VGND.n205 VGND.t1533 222.042
R5201 VGND.n215 VGND.t125 423.483
R5202 VGND.n464 VGND.t1522 222.042
R5203 VGND.t1525 VGND.n425 222.042
R5204 VGND.t1524 VGND.n426 222.042
R5205 VGND.n449 VGND.t1520 222.042
R5206 VGND.t1629 VGND.n152 222.041
R5207 VGND.t1630 VGND.n134 222.041
R5208 VGND.t1621 VGND.n338 222.041
R5209 VGND.n368 VGND.t1619 222.041
R5210 VGND.t1623 VGND.n353 222.041
R5211 VGND.t1587 VGND.n45 102.703
R5212 VGND.n38 VGND.t335 0.166852
R5213 VGND.n49 VGND.t335 8.48812
R5214 VGND.t335 VGND.t1591 111.022
R5215 VGND.t1580 VGND.n40 106.784
R5216 VGND.t1545 VGND.n85 222.041
R5217 VGND.t1551 VGND.n72 222.041
R5218 VGND.t1542 VGND.n191 222.041
R5219 VGND.t1519 VGND.n439 222.041
R5220 VGND.t1520 VGND.n448 222.041
R5221 VGND.n460 VGND.t1525 222.041
R5222 VGND.n332 VGND.t1621 221.417
R5223 VGND.t1595 VGND.n15 221.417
R5224 VGND.n1029 VGND.t1594 221.417
R5225 VGND.n1007 VGND.t1581 221.417
R5226 VGND.t1573 VGND.n1005 221.417
R5227 VGND.n1003 VGND.t1582 221.417
R5228 VGND.n967 VGND.t1584 221.417
R5229 VGND.t1547 VGND.n83 221.417
R5230 VGND.n115 VGND.t1558 221.417
R5231 VGND.t1544 VGND.n715 221.417
R5232 VGND.t1526 VGND.n463 221.417
R5233 VGND.n305 VGND.t1518 221.417
R5234 VGND.t1517 VGND.n790 221.417
R5235 VGND.t77 VGND.t1265 218.75
R5236 VGND.t217 VGND.n569 218.571
R5237 VGND.n547 VGND.t499 218.571
R5238 VGND.n968 VGND.t1467 218.571
R5239 VGND.n964 VGND.t1306 218.571
R5240 VGND.t1020 VGND.t1553 218.571
R5241 VGND.t745 VGND.n678 218.571
R5242 VGND.t1068 VGND.t873 218.571
R5243 VGND.n978 VGND.t1583 213.968
R5244 VGND.n930 VGND.t447 210
R5245 VGND.t1467 VGND.n967 208.56
R5246 VGND.n1071 VGND.t1629 205.714
R5247 VGND.t1625 VGND.n1071 205.714
R5248 VGND.n1079 VGND.t1630 205.714
R5249 VGND.t1627 VGND.n1079 205.714
R5250 VGND.t1616 VGND.n383 222.065
R5251 VGND.t1619 VGND.n572 205.714
R5252 VGND.t1624 VGND.n545 205.714
R5253 VGND.n546 VGND.t1624 205.714
R5254 VGND.n45 VGND.t1595 213.578
R5255 VGND.n49 VGND.t1590 102.703
R5256 VGND.t1581 VGND.n1006 205.714
R5257 VGND.n1006 VGND.t1573 205.714
R5258 VGND.t1582 VGND.n60 213.578
R5259 VGND.n40 VGND.t1585 106.791
R5260 VGND.t1539 VGND.n723 205.714
R5261 VGND.n716 VGND.t1544 205.714
R5262 VGND.n866 VGND.t1526 205.714
R5263 VGND.t1522 VGND.n866 205.714
R5264 VGND.t1518 VGND.n808 205.714
R5265 VGND.n791 VGND.t1517 205.714
R5266 VGND.t1501 VGND.n791 205.714
R5267 VGND.t1579 VGND.n50 100.716
R5268 VGND.t836 VGND.t1547 201.429
R5269 VGND.t1558 VGND.t301 201.429
R5270 VGND.n689 VGND.t1238 201.429
R5271 VGND.t1533 VGND.t1439 201.429
R5272 VGND.t1406 VGND.t1524 201.429
R5273 VGND.n369 VGND.t1618 200.613
R5274 VGND.n25 VGND.t1597 200.613
R5275 VGND.n47 VGND.n6 9.32294
R5276 VGND.n101 VGND.t1549 200.613
R5277 VGND.t1556 VGND.n105 200.613
R5278 VGND.t1530 VGND.n185 200.613
R5279 VGND.t1506 VGND.n843 200.613
R5280 VGND.t1514 VGND.n775 200.613
R5281 VGND.t1600 VGND.n35 199.989
R5282 VGND.n715 VGND.t1541 199.989
R5283 VGND.t1511 VGND.n499 199.989
R5284 VGND.n340 VGND.t1259 198.513
R5285 VGND.n0 VGND.t664 198.513
R5286 VGND.t85 VGND.n396 198.513
R5287 VGND.t1250 VGND.n220 198.513
R5288 VGND.t713 VGND.n219 198.513
R5289 VGND.t636 VGND.n481 198.513
R5290 VGND.n796 VGND.t708 198.513
R5291 VGND.t1638 VGND.t1539 197.143
R5292 VGND.t499 VGND.n546 192.857
R5293 VGND.t1306 VGND.n963 192.857
R5294 VGND.n25 VGND.t1596 192.042
R5295 VGND.n6 VGND.n46 7.34144
R5296 VGND.n105 VGND.t1555 192.042
R5297 VGND.t1527 VGND.n185 192.042
R5298 VGND.n843 VGND.t1504 192.042
R5299 VGND.n726 VGND.t1536 191.679
R5300 VGND.t1592 VGND.n1032 191.417
R5301 VGND.t1575 VGND.n987 191.417
R5302 VGND.t1553 VGND.n75 191.417
R5303 VGND.n203 VGND.t1531 191.417
R5304 VGND.n217 VGND.t1537 191.417
R5305 VGND.n779 VGND.t1515 191.417
R5306 VGND.n532 VGND.t82 190.403
R5307 VGND.n534 VGND.t79 190.403
R5308 VGND.t684 VGND.n380 189.552
R5309 VGND.t1282 VGND.n370 189.552
R5310 VGND.n27 VGND.t139 189.552
R5311 VGND.t467 VGND.n995 189.552
R5312 VGND.t380 VGND.n977 189.552
R5313 VGND.n409 VGND.t442 189.552
R5314 VGND.n121 VGND.t1085 189.552
R5315 VGND.n199 VGND.t750 189.552
R5316 VGND.n216 VGND.t452 189.552
R5317 VGND.n465 VGND.t1084 189.552
R5318 VGND.t748 VGND.t217 188.571
R5319 VGND.n1031 VGND.t1593 184.286
R5320 VGND.n986 VGND.t1576 184.286
R5321 VGND.t1554 VGND.n912 184.286
R5322 VGND.t924 VGND.n911 184.286
R5323 VGND.t1532 VGND.n690 184.286
R5324 VGND.t1538 VGND.n701 184.286
R5325 VGND.t1516 VGND.n780 184.286
R5326 VGND.n516 VGND.t53 182.764
R5327 VGND.n518 VGND.t1253 182.764
R5328 VGND.n525 VGND.t615 182.764
R5329 VGND.t1305 VGND.n1035 182.764
R5330 VGND.t1157 VGND.n1001 182.764
R5331 VGND.t863 VGND.n999 182.764
R5332 VGND.t222 VGND.n982 182.764
R5333 VGND.n955 VGND.t127 182.764
R5334 VGND.t296 VGND.n653 182.764
R5335 VGND.n941 VGND.t1247 182.764
R5336 VGND.t908 VGND.n901 182.764
R5337 VGND.t1436 VGND.n899 182.764
R5338 VGND.t103 VGND.n895 182.764
R5339 VGND.t495 VGND.n728 182.764
R5340 VGND.t803 VGND.n883 182.764
R5341 VGND.n821 VGND.t1348 182.764
R5342 VGND.n823 VGND.t1256 182.764
R5343 VGND.n794 VGND.t170 182.764
R5344 VGND.t606 VGND.n559 181.115
R5345 VGND.t860 VGND.t369 178.306
R5346 VGND.t857 VGND.t524 178.306
R5347 VGND.t1376 VGND.t778 178.306
R5348 VGND.n637 VGND.t1598 175.714
R5349 VGND.t1540 VGND.n716 175.714
R5350 VGND.n772 VGND.t1509 175.714
R5351 VGND.n959 VGND.t718 173.849
R5352 VGND.n674 VGND.t211 173.849
R5353 VGND.t799 VGND.t1324 173.849
R5354 VGND.n799 VGND.t730 173.849
R5355 VGND.t967 VGND.t1548 171.429
R5356 VGND.t1071 VGND.t1532 171.429
R5357 VGND.t1226 VGND.t1512 171.429
R5358 VGND.n756 VGND.t1484 169.952
R5359 VGND.n759 VGND.t797 169.952
R5360 VGND.n758 VGND.t843 169.952
R5361 VGND.t112 VGND.n340 162.852
R5362 VGND.n36 VGND.t1036 162.852
R5363 VGND.n980 VGND.t404 162.852
R5364 VGND.n396 VGND.t993 162.852
R5365 VGND.t183 VGND.n120 162.852
R5366 VGND.n220 VGND.t410 162.852
R5367 VGND.n219 VGND.t519 162.852
R5368 VGND.n481 VGND.t579 162.852
R5369 VGND.t800 VGND.n796 162.852
R5370 VGND.t740 VGND.n532 153.251
R5371 VGND.t1395 VGND.n533 153.251
R5372 VGND.n560 VGND.t1117 153.251
R5373 VGND.t1214 VGND.n365 152.846
R5374 VGND.n970 VGND.t1038 152.846
R5375 VGND.n966 VGND.t1043 152.846
R5376 VGND.t1536 VGND.t477 151.56
R5377 VGND.t1479 VGND.n519 147.103
R5378 VGND.t1281 VGND.n525 147.103
R5379 VGND.n1035 VGND.t138 147.103
R5380 VGND.n1001 VGND.t466 147.103
R5381 VGND.n998 VGND.t1029 147.103
R5382 VGND.n982 VGND.t379 147.103
R5383 VGND.n653 VGND.t441 147.103
R5384 VGND.t1086 VGND.n941 147.103
R5385 VGND.n901 VGND.t210 147.103
R5386 VGND.n898 VGND.t907 147.103
R5387 VGND.n895 VGND.t749 147.103
R5388 VGND.n728 VGND.t451 147.103
R5389 VGND.n883 VGND.t1083 147.103
R5390 VGND.t1185 VGND.n824 147.103
R5391 VGND.t729 VGND.n794 147.103
R5392 VGND.t683 VGND.t1297 142.645
R5393 VGND.t1053 VGND.t1090 142.645
R5394 VGND.t719 VGND.t1009 142.645
R5395 VGND.t1323 VGND.t417 142.645
R5396 VGND.t608 VGND.n568 141.429
R5397 VGND.n548 VGND.t1160 141.429
R5398 VGND.n969 VGND.t1018 141.429
R5399 VGND.n965 VGND.t196 141.429
R5400 VGND.t1124 VGND.n677 141.429
R5401 VGND.n549 VGND.t1432 137.143
R5402 VGND.t1474 VGND.n676 137.143
R5403 VGND.t1265 VGND.t605 134.675
R5404 VGND.t1648 VGND.n689 132.857
R5405 VGND.t1012 VGND.t1538 132.857
R5406 VGND.t934 VGND.n912 128.571
R5407 VGND.n688 VGND.t132 128.571
R5408 VGND.n104 VGND.t1101 127.132
R5409 VGND.n570 VGND.t1129 124.287
R5410 VGND.t525 VGND.n544 124.287
R5411 VGND.t890 VGND.n9 136.9
R5412 VGND.t928 VGND.n961 124.287
R5413 VGND.n681 VGND.t1007 124.287
R5414 VGND.n202 VGND.t1068 122.847
R5415 VGND.t71 VGND.n573 120.001
R5416 VGND.n537 VGND.t773 120.001
R5417 VGND.n539 VGND.t771 120.001
R5418 VGND.t650 VGND.n992 120.001
R5419 VGND.t74 VGND.n974 120.001
R5420 VGND.n953 VGND.t675 120.001
R5421 VGND.n640 VGND.t640 120.001
R5422 VGND.n935 VGND.t1434 120.001
R5423 VGND.n679 VGND.t1105 120.001
R5424 VGND.n687 VGND.t710 120.001
R5425 VGND.n701 VGND.t1637 120.001
R5426 VGND.n870 VGND.t1472 120.001
R5427 VGND.n830 VGND.t672 120.001
R5428 VGND.n803 VGND.t1639 120.001
R5429 VGND.n770 VGND.t638 120.001
R5430 VGND.t648 VGND.t1418 115.715
R5431 VGND.t922 VGND.t652 115.715
R5432 VGND.t1117 VGND.t606 111.456
R5433 VGND.n201 VGND.t1067 110.638
R5434 VGND.t1454 VGND.n368 110.614
R5435 VGND.t1100 VGND.n70 110.612
R5436 VGND.t1285 VGND.n378 109.99
R5437 VGND.n342 VGND.t408 109.99
R5438 VGND.n29 VGND.t271 109.99
R5439 VGND.t1010 VGND.n991 109.99
R5440 VGND.n407 VGND.t945 109.99
R5441 VGND.n467 VGND.t1099 109.99
R5442 VGND.n831 VGND.t588 109.99
R5443 VGND.n492 VGND.t742 109.99
R5444 VGND.t1618 VGND.t71 107.144
R5445 VGND.n341 VGND.t784 104.856
R5446 VGND.t1531 VGND.t1648 102.858
R5447 VGND.n519 VGND.t287 102.526
R5448 VGND.t79 VGND.t1395 102.168
R5449 VGND.t1425 VGND.n369 102.041
R5450 VGND.n408 VGND.t1033 102.041
R5451 VGND.n200 VGND.t511 102.041
R5452 VGND.n466 VGND.t422 102.041
R5453 VGND.n493 VGND.t744 102.04
R5454 VGND.t769 VGND.n976 101.418
R5455 VGND.t1401 VGND.n1 101.418
R5456 VGND.n828 VGND.t1449 101.418
R5457 VGND.n801 VGND.t561 101.418
R5458 VGND.n1068 VGND.t1366 98.5719
R5459 VGND.t988 VGND.n582 98.5719
R5460 VGND.t780 VGND.n581 98.5719
R5461 VGND.n579 VGND.t1107 98.5719
R5462 VGND.n555 VGND.t1652 98.5719
R5463 VGND.n557 VGND.t1126 98.5719
R5464 VGND.t1263 VGND.n628 98.5719
R5465 VGND.t878 VGND.n1024 98.5719
R5466 VGND.n648 VGND.t868 98.5719
R5467 VGND.n650 VGND.t685 98.5719
R5468 VGND.n671 VGND.t1483 98.5719
R5469 VGND.t835 VGND.n707 98.5719
R5470 VGND.t516 VGND.n704 98.5719
R5471 VGND.n703 VGND.t1080 98.5719
R5472 VGND.n880 VGND.t1000 98.5719
R5473 VGND.t278 VGND.n812 98.5719
R5474 VGND.n195 VGND.t826 97.1319
R5475 VGND.t124 VGND.t63 94.2862
R5476 VGND.n538 VGND.t1279 94.2862
R5477 VGND.t553 VGND.n55 94.4505
R5478 VGND.n680 VGND.t1118 94.2862
R5479 VGND.n725 VGND.t1012 94.2862
R5480 VGND.n804 VGND.t1384 94.2862
R5481 VGND.t1617 VGND.t1425 90.0005
R5482 VGND.t1023 VGND.t1015 90.0005
R5483 VGND.n560 VGND.t1292 88.2358
R5484 VGND.t631 VGND.n579 85.7148
R5485 VGND.n577 VGND.t1280 85.7148
R5486 VGND.n571 VGND.t226 85.7148
R5487 VGND.n536 VGND.t594 85.7148
R5488 VGND.t721 VGND.n540 85.7148
R5489 VGND.t434 VGND.n542 85.7148
R5490 VGND.t1079 VGND.n635 85.7148
R5491 VGND.t915 VGND.n994 85.7148
R5492 VGND.n989 VGND.t619 85.7148
R5493 VGND.n973 VGND.t1360 85.7148
R5494 VGND.t1176 VGND.n657 85.7148
R5495 VGND.t1408 VGND.n908 85.7148
R5496 VGND.t490 VGND.n906 85.7148
R5497 VGND.n676 VGND.t1241 85.7148
R5498 VGND.t549 VGND.n683 85.7148
R5499 VGND.t873 VGND.n688 85.7148
R5500 VGND.n700 VGND.t978 85.7148
R5501 VGND.n723 VGND.t952 85.7148
R5502 VGND.t1211 VGND.n833 85.7148
R5503 VGND.t1383 VGND.n806 85.7148
R5504 VGND.t137 VGND.n771 85.7148
R5505 VGND.n580 VGND.t1150 84.6959
R5506 VGND.n574 VGND.t1450 84.6959
R5507 VGND.t1355 VGND.n535 84.6959
R5508 VGND.t784 VGND.t741 84.6959
R5509 VGND.t1404 VGND.n996 84.6959
R5510 VGND.t453 VGND.n978 84.6959
R5511 VGND.n958 VGND.t1021 84.6959
R5512 VGND.t1244 VGND.n639 84.6959
R5513 VGND.n944 VGND.t680 84.6959
R5514 VGND.t1048 VGND.n673 84.6959
R5515 VGND.t820 VGND.n685 84.6959
R5516 VGND.t477 VGND.n698 84.6959
R5517 VGND.t91 VGND.n867 84.6959
R5518 VGND.n826 VGND.t1374 84.6959
R5519 VGND.n798 VGND.t598 84.6959
R5520 VGND.t1333 VGND.n270 83.1163
R5521 VGND.n293 VGND.t806 83.1143
R5522 VGND.t1334 VGND.n270 83.1143
R5523 VGND.t824 VGND.n543 81.4291
R5524 VGND.t887 VGND.t1442 81.4291
R5525 VGND.t1584 VGND.t890 81.4291
R5526 VGND.t104 VGND.n46 90.4393
R5527 VGND.t9 VGND.t376 81.4291
R5528 VGND.n690 VGND.t1470 81.4291
R5529 VGND.t1125 VGND.t888 81.4291
R5530 VGND.t355 VGND.t1037 80.2382
R5531 VGND.t733 VGND.t166 77.1434
R5532 VGND.t1105 VGND.t745 72.8576
R5533 VGND.n204 VGND.t1071 72.0656
R5534 VGND.t895 VGND.t1040 64.2862
R5535 VGND.n929 VGND.t1024 64.2862
R5536 VGND.t1070 VGND.n915 55.7148
R5537 VGND.t45 VGND.t1210 54.9743
R5538 VGND.n180 VGND.t1139 54.2748
R5539 VGND.n17 VGND.t921 54.2748
R5540 VGND.t761 VGND.n76 54.2748
R5541 VGND.n187 VGND.t159 54.2748
R5542 VGND.n927 VGND.t187 42.8576
R5543 VGND.t413 VGND.n914 42.8576
R5544 VGND.n521 VGND.t1399 40.1194
R5545 VGND.t1583 VGND.t380 40.1194
R5546 VGND.t550 VGND.n1067 38.5719
R5547 VGND.n1104 VGND.t169 38.5719
R5548 VGND.n556 VGND.t647 38.5719
R5549 VGND.n558 VGND.t427 38.5719
R5550 VGND.n649 VGND.t272 38.5719
R5551 VGND.n395 VGND.t148 54.2748
R5552 VGND.t755 VGND.n706 38.5719
R5553 VGND.n704 VGND.t738 38.5719
R5554 VGND.t223 VGND.n703 38.5719
R5555 VGND.n420 VGND.t551 54.2748
R5556 VGND.t307 VGND.n810 38.5719
R5557 VGND.t544 VGND.t897 34.2862
R5558 VGND.t1102 VGND.t1233 34.2862
R5559 VGND.n353 VGND.t77 33.4703
R5560 VGND.n107 VGND.t1032 33.4703
R5561 VGND.n381 VGND.t1252 33.4693
R5562 VGND.n6 VGND.t862 33.4693
R5563 VGND.t1210 VGND.n845 33.4693
R5564 VGND.n365 VGND.t1215 32.8462
R5565 VGND.t859 VGND.n12 33.4649
R5566 VGND.n984 VGND.t856 32.8462
R5567 VGND.t1039 VGND.n970 32.8462
R5568 VGND.t1171 VGND.n102 32.8462
R5569 VGND.n76 VGND.t1020 32.8462
R5570 VGND.t1254 VGND.t1290 30.0005
R5571 VGND.t711 VGND.n201 24.9217
R5572 VGND.n724 VGND.t1638 24.8979
R5573 VGND.t1640 VGND.n805 24.8979
R5574 VGND.n380 VGND.t1254 24.2748
R5575 VGND.n377 VGND.t649 24.2748
R5576 VGND.n370 VGND.t1260 24.2748
R5577 VGND.t80 VGND.n341 24.2748
R5578 VGND.t774 VGND.n342 24.2748
R5579 VGND.t861 VGND.n27 24.2748
R5580 VGND.t653 VGND.n30 24.2748
R5581 VGND.n995 VGND.t864 24.2748
R5582 VGND.n990 VGND.t651 24.2748
R5583 VGND.n977 VGND.t858 24.2748
R5584 VGND.t641 VGND.n406 24.2748
R5585 VGND.n102 VGND.t590 24.2748
R5586 VGND.n121 VGND.t777 24.2748
R5587 VGND.t1106 VGND.n195 24.2748
R5588 VGND.t714 VGND.n216 24.2748
R5589 VGND.t1473 VGND.n468 24.2748
R5590 VGND.t1257 VGND.n827 24.2748
R5591 VGND.t673 VGND.n832 24.2748
R5592 VGND.t1262 VGND.n494 24.2748
R5593 VGND.t639 VGND.n491 24.2748
R5594 VGND.n322 VGND.n294 0.0135841
R5595 VGND.n294 VGND.n319 0.0135836
R5596 VGND.t193 VGND.n281 23.2294
R5597 VGND.n320 VGND.t362 23.2297
R5598 VGND.n261 VGND.t1409 23.2294
R5599 VGND.n293 VGND.t50 24.003
R5600 VGND.n286 VGND.t574 24.003
R5601 VGND.t842 VGND.n258 24.003
R5602 VGND.t577 VGND.n262 24.003
R5603 VGND.n276 VGND.t1195 24.003
R5604 VGND.n273 VGND.t70 24.003
R5605 VGND.t316 VGND.n268 24.003
R5606 VGND.n252 VGND.t557 23.2257
R5607 VGND.t324 VGND.n282 23.2257
R5608 VGND.t1187 VGND.n249 24.001
R5609 VGND.n295 VGND.t814 23.2257
R5610 VGND.n286 VGND.t575 24.001
R5611 VGND.t387 VGND.n257 24.0015
R5612 VGND.t1329 VGND.n258 24.001
R5613 VGND.n279 VGND.t332 24.001
R5614 VGND.t580 VGND.n262 24.001
R5615 VGND.n276 VGND.t1218 24.001
R5616 VGND.n273 VGND.t1326 24.001
R5617 VGND.n285 VGND.t311 23.9933
R5618 VGND.n281 VGND.t1330 24.0029
R5619 VGND.t841 VGND.n259 23.9933
R5620 VGND.t1368 VGND.n261 24.0029
R5621 VGND.n278 VGND.t1367 23.9933
R5622 VGND.t1219 VGND.n263 23.9933
R5623 VGND.n275 VGND.t1193 23.9933
R5624 VGND.t1462 VGND.n265 23.9933
R5625 VGND.n274 VGND.t1461 23.9933
R5626 VGND.t1327 VGND.n266 23.9933
R5627 VGND.n272 VGND.t68 23.9933
R5628 VGND.n292 VGND.t48 23.9923
R5629 VGND.t319 VGND.n248 23.9923
R5630 VGND.n291 VGND.t318 23.9923
R5631 VGND.t661 VGND.n251 23.9923
R5632 VGND.n289 VGND.t660 23.9923
R5633 VGND.n288 VGND.t563 23.9923
R5634 VGND.t562 VGND.n253 23.9923
R5635 VGND.n287 VGND.t1453 23.9923
R5636 VGND.t1452 VGND.n254 23.9923
R5637 VGND.t309 VGND.n255 23.9923
R5638 VGND.n283 VGND.t1390 23.9923
R5639 VGND.t1389 VGND.n256 23.9923
R5640 VGND.n225 VGND.t1392 23.1782
R5641 VGND.n316 VGND.n245 0.00139995
R5642 VGND.n222 VGND.n224 0.00139995
R5643 VGND.n594 VGND.t532 23.177
R5644 VGND.n596 VGND.t401 23.177
R5645 VGND.n600 VGND.t239 23.177
R5646 VGND.n234 VGND.t1128 23.177
R5647 VGND.n232 VGND.t1147 23.177
R5648 VGND.t681 VGND.n240 23.177
R5649 VGND.n326 VGND.t1377 23.177
R5650 VGND.t245 VGND.n594 23.177
R5651 VGND.t537 VGND.n600 23.177
R5652 VGND.t1271 VGND.n237 23.177
R5653 VGND.t601 VGND.n234 23.177
R5654 VGND.t384 VGND.n232 23.177
R5655 VGND.n240 VGND.t522 23.177
R5656 VGND.n317 VGND.n222 0.0160305
R5657 VGND.n223 VGND.n222 0.0160305
R5658 VGND.t1140 VGND.n228 22.357
R5659 VGND.n225 VGND.t645 23.1762
R5660 VGND.n226 VGND.t1643 23.1662
R5661 VGND.t491 VGND.n242 23.1662
R5662 VGND.n227 VGND.t1130 23.1662
R5663 VGND.t1646 VGND.n316 23.1778
R5664 VGND.n229 VGND.t255 23.1662
R5665 VGND.t656 VGND.n239 23.1662
R5666 VGND.n230 VGND.t276 23.1662
R5667 VGND.t32 VGND.n325 22.3624
R5668 VGND.n609 VGND.t1276 23.1662
R5669 VGND.n224 VGND.t1289 23.1778
R5670 VGND.n599 VGND.t603 23.1662
R5671 VGND.n598 VGND.t1133 23.1662
R5672 VGND.n597 VGND.t418 23.1662
R5673 VGND.n593 VGND.t775 23.1662
R5674 VGND.n592 VGND.t1636 23.1662
R5675 VGND.n591 VGND.t602 23.1662
R5676 VGND.t542 VGND.n1093 23.1662
R5677 VGND.n610 VGND.t535 23.1662
R5678 VGND.n1099 VGND.t597 23.1652
R5679 VGND.n1098 VGND.t351 23.1652
R5680 VGND.n1097 VGND.t1143 23.1652
R5681 VGND.n1096 VGND.t658 23.1652
R5682 VGND.n1095 VGND.t1478 23.1652
R5683 VGND.t643 VGND.n601 23.1652
R5684 VGND.t243 VGND.n602 23.1652
R5685 VGND.t678 VGND.n603 23.1652
R5686 VGND.t1645 VGND.n604 23.1652
R5687 VGND.t1356 VGND.n605 23.1652
R5688 VGND.t1144 VGND.n606 23.1652
R5689 VGND.t585 VGND.n607 23.1652
R5690 VGND.n236 VGND.t274 23.1652
R5691 VGND.t1464 VGND.n238 23.1652
R5692 VGND.t1131 VGND.n244 22.7441
R5693 VGND.t1550 VGND.t1556 21.4291
R5694 VGND.t479 VGND.n221 19.6804
R5695 VGND.t424 VGND.n138 20.6389
R5696 VGND.t118 VGND.n155 19.6502
R5697 VGND.n310 VGND.t279 18.8929
R5698 VGND.t1136 VGND.n375 20.638
R5699 VGND.t1400 VGND.n360 20.638
R5700 VGND.t1116 VGND.n171 19.6493
R5701 VGND.n124 VGND.t912 19.6794
R5702 VGND.n221 VGND.t101 20.6379
R5703 VGND.n315 VGND.t486 18.8921
R5704 VGND.n131 VGND.t291 20.637
R5705 VGND.n68 VGND.t335 0.789752
R5706 VGND.n12 VGND.t702 19.6485
R5707 VGND.t335 VGND.t31 19.6775
R5708 VGND.n95 VGND.t836 20.637
R5709 VGND.n709 VGND.t1081 20.637
R5710 VGND.t986 VGND.n447 20.637
R5711 VGND.t725 VGND.n131 20.637
R5712 VGND.n67 VGND.t335 0.789752
R5713 VGND.t335 VGND.n66 0.789752
R5714 VGND.t1233 VGND.t335 20.637
R5715 VGND.n47 VGND.t970 10.3566
R5716 VGND.n95 VGND.t1175 20.637
R5717 VGND.t1439 VGND.n204 20.637
R5718 VGND.t281 VGND.n709 20.637
R5719 VGND.t152 VGND.n403 20.637
R5720 VGND.n181 VGND.t642 20.6369
R5721 VGND.t538 VGND.n138 20.6369
R5722 VGND.t335 VGND.t464 19.6774
R5723 VGND.n6 VGND.t513 19.6785
R5724 VGND.n122 VGND.n297 0.0311701
R5725 VGND.n309 VGND.n311 0.0311701
R5726 VGND.t402 VGND.n354 20.636
R5727 VGND.n403 VGND.t1421 20.636
R5728 VGND.n375 VGND.t178 20.636
R5729 VGND.n360 VGND.t555 20.636
R5730 VGND.n313 VGND.t1501 222.067
R5731 VGND.n179 VGND.t407 20.6131
R5732 VGND.n177 VGND.t253 20.6131
R5733 VGND.t303 VGND.n127 20.6131
R5734 VGND.n176 VGND.t576 20.6131
R5735 VGND.t1354 VGND.n129 20.6131
R5736 VGND.t122 VGND.n134 20.6131
R5737 VGND.t1656 VGND.n136 20.6131
R5738 VGND.n169 VGND.t293 20.6131
R5739 VGND.t390 VGND.n139 20.6131
R5740 VGND.t432 VGND.n140 20.6131
R5741 VGND.n167 VGND.t1441 20.6131
R5742 VGND.t238 VGND.n142 20.6131
R5743 VGND.n165 VGND.t1299 20.6131
R5744 VGND.t1088 VGND.n145 20.6131
R5745 VGND.n161 VGND.t1463 20.6131
R5746 VGND.t498 VGND.n152 20.6131
R5747 VGND.t1397 VGND.n154 20.6131
R5748 VGND.n383 VGND.t897 20.638
R5749 VGND.n333 VGND.t348 20.6131
R5750 VGND.t1141 VGND.n336 20.6131
R5751 VGND.t406 VGND.n371 20.6131
R5752 VGND.t1423 VGND.n373 20.6131
R5753 VGND.n372 VGND.t1480 20.6131
R5754 VGND.n345 VGND.t27 20.6131
R5755 VGND.n350 VGND.t1422 20.6131
R5756 VGND.t106 VGND.n48 18.8704
R5757 VGND.n22 VGND.t200 20.6131
R5758 VGND.n20 VGND.t448 20.6131
R5759 VGND.t335 VGND.n37 0.788882
R5760 VGND.t1061 VGND.n44 18.8704
R5761 VGND.t1022 VGND.n62 18.8704
R5762 VGND.n54 VGND.t335 0.031137
R5763 VGND.t946 VGND.n58 18.8704
R5764 VGND.n28 VGND.t887 20.6131
R5765 VGND.n57 VGND.n6 0.788882
R5766 VGND.n6 VGND.t869 20.6131
R5767 VGND.n51 VGND.t209 4.0816
R5768 VGND.n6 VGND.t235 19.6268
R5769 VGND.n39 VGND.n6 0.788882
R5770 VGND.t825 VGND.n43 18.7002
R5771 VGND.t350 VGND.n50 9.36071
R5772 VGND.t1015 VGND.n6 20.6131
R5773 VGND.t768 VGND.n6 19.6492
R5774 VGND.n397 VGND.t472 20.6131
R5775 VGND.t1168 VGND.n401 20.6131
R5776 VGND.t935 VGND.n70 20.6131
R5777 VGND.t611 VGND.n74 20.6131
R5778 VGND.t882 VGND.n78 20.6131
R5779 VGND.t867 VGND.n79 20.6131
R5780 VGND.n101 VGND.t967 20.6131
R5781 VGND.t990 VGND.n80 20.6131
R5782 VGND.n98 VGND.t872 20.6131
R5783 VGND.t205 VGND.n81 20.6131
R5784 VGND.t853 VGND.n84 20.6131
R5785 VGND.n92 VGND.t231 20.6131
R5786 VGND.n89 VGND.t943 20.6131
R5787 VGND.t180 VGND.n112 20.6131
R5788 VGND.t301 VGND.n114 20.6131
R5789 VGND.n191 VGND.t388 20.6131
R5790 VGND.n188 VGND.t948 20.6131
R5791 VGND.n207 VGND.t1172 20.6131
R5792 VGND.t1019 VGND.n206 20.6131
R5793 VGND.t494 VGND.n213 20.6131
R5794 VGND.t1017 VGND.n711 20.6131
R5795 VGND.t518 VGND.n713 20.6131
R5796 VGND.t1468 VGND.n717 20.6131
R5797 VGND.t581 VGND.n423 20.6131
R5798 VGND.n460 VGND.t192 20.6131
R5799 VGND.t1002 VGND.n432 20.6131
R5800 VGND.t1114 VGND.n441 20.6131
R5801 VGND.t462 VGND.n469 20.6131
R5802 VGND.n473 VGND.t624 20.6131
R5803 VGND.t1417 VGND.n474 20.6131
R5804 VGND.n476 VGND.t726 20.6131
R5805 VGND.n775 VGND.t1226 20.6131
R5806 VGND.t801 VGND.n788 20.6131
R5807 VGND.t65 VGND.n306 20.6131
R5808 VGND.n805 VGND.t1332 20.6131
R5809 VGND.n314 VGND.t275 19.6558
R5810 VGND.t62 VGND.n493 20.6131
R5811 VGND.t258 VGND.n151 20.6121
R5812 VGND.n161 VGND.t739 20.6121
R5813 VGND.t1451 VGND.n145 20.6121
R5814 VGND.n162 VGND.t1264 20.6121
R5815 VGND.n165 VGND.t1419 20.6121
R5816 VGND.t1267 VGND.n142 20.6121
R5817 VGND.n167 VGND.t1642 20.6121
R5818 VGND.n169 VGND.t327 20.6121
R5819 VGND.t1268 VGND.n136 20.6121
R5820 VGND.n176 VGND.t1460 20.6121
R5821 VGND.n177 VGND.t1653 20.6121
R5822 VGND.t261 VGND.n126 20.6121
R5823 VGND.n336 VGND.t654 20.6121
R5824 VGND.t1287 VGND.n337 20.6121
R5825 VGND.n333 VGND.t618 20.6121
R5826 VGND.n373 VGND.t42 20.6121
R5827 VGND.t1288 VGND.n372 20.6121
R5828 VGND.n371 VGND.t1352 20.6121
R5829 VGND.n367 VGND.t733 20.6121
R5830 VGND.t370 VGND.n345 20.6121
R5831 VGND.n351 VGND.t131 20.6121
R5832 VGND.t335 VGND.n41 0.0311356
R5833 VGND.n23 VGND.t1342 20.6121
R5834 VGND.t335 VGND.t1111 20.6121
R5835 VGND.t335 VGND.t163 19.6546
R5836 VGND.n59 VGND.t1016 18.8696
R5837 VGND.n6 VGND.n43 0.957717
R5838 VGND.t823 VGND.n6 20.6121
R5839 VGND.t181 VGND.n408 20.6121
R5840 VGND.n401 VGND.t994 20.6121
R5841 VGND.t1093 VGND.n397 20.6121
R5842 VGND.t1361 VGND.n89 20.6121
R5843 VGND.t958 VGND.n84 20.6121
R5844 VGND.t419 VGND.n81 20.6121
R5845 VGND.n98 VGND.t706 20.6121
R5846 VGND.n108 VGND.t626 20.6121
R5847 VGND.n112 VGND.t691 20.6121
R5848 VGND.t790 VGND.n113 20.6121
R5849 VGND.t375 VGND.n200 20.6121
R5850 VGND.t715 VGND.n205 20.6121
R5851 VGND.n206 VGND.t937 20.6121
R5852 VGND.t894 VGND.n207 20.6121
R5853 VGND.t517 VGND.n211 20.6121
R5854 VGND.n722 VGND.t1025 20.6121
R5855 VGND.n711 VGND.t1028 20.6121
R5856 VGND.t530 VGND.n441 20.6121
R5857 VGND.n445 VGND.t528 20.6121
R5858 VGND.t783 VGND.n440 20.6121
R5859 VGND.n446 VGND.t782 20.6121
R5860 VGND.n449 VGND.t916 20.6121
R5861 VGND.t328 VGND.n436 20.6121
R5862 VGND.t1005 VGND.n434 20.6121
R5863 VGND.t1371 VGND.n432 20.6121
R5864 VGND.n458 VGND.t1406 20.6121
R5865 VGND.n426 VGND.t1647 20.6121
R5866 VGND.t2 VGND.n425 20.6121
R5867 VGND.t1237 VGND.n466 20.6121
R5868 VGND.t728 VGND.n473 20.6121
R5869 VGND.n474 VGND.t450 20.6121
R5870 VGND.t1341 VGND.n306 20.6121
R5871 VGND.t560 VGND.n300 20.6121
R5872 VGND.t794 VGND.n303 20.6121
R5873 VGND.t369 VGND.n36 20.2074
R5874 VGND.t524 VGND.n980 20.2074
R5875 VGND.t1090 VGND.n0 20.2074
R5876 VGND.n120 VGND.t1376 20.2074
R5877 VGND.t1270 VGND.n149 19.9891
R5878 VGND.n149 VGND.t1456 19.9891
R5879 VGND.t51 VGND.n147 19.9891
R5880 VGND.n147 VGND.t534 19.9891
R5881 VGND.n146 VGND.t507 19.9891
R5882 VGND.n144 VGND.t500 19.9891
R5883 VGND.t1465 VGND.n143 19.9891
R5884 VGND.n163 VGND.t781 19.9891
R5885 VGND.n164 VGND.t786 19.9891
R5886 VGND.n166 VGND.t817 19.9891
R5887 VGND.t734 VGND.n141 19.9891
R5888 VGND.n168 VGND.t110 19.9891
R5889 VGND.t372 VGND.n168 19.9891
R5890 VGND.t1411 VGND.n137 19.9891
R5891 VGND.n135 VGND.t1135 19.9891
R5892 VGND.n130 VGND.t595 19.9891
R5893 VGND.n173 VGND.t668 19.9891
R5894 VGND.n174 VGND.t1132 19.9891
R5895 VGND.t1283 VGND.n174 19.9891
R5896 VGND.t677 VGND.n334 19.9891
R5897 VGND.n335 VGND.t1412 19.9891
R5898 VGND.t505 VGND.n377 19.9891
R5899 VGND.t1275 VGND.n376 19.9891
R5900 VGND.n374 VGND.t18 19.9891
R5901 VGND.n366 VGND.t748 19.9891
R5902 VGND.n364 VGND.t1142 19.9891
R5903 VGND.n359 VGND.t1641 19.9891
R5904 VGND.t1273 VGND.n343 19.9891
R5905 VGND.t257 VGND.n344 19.9891
R5906 VGND.t237 VGND.n346 19.9891
R5907 VGND.n347 VGND.t593 19.9891
R5908 VGND.t830 VGND.n347 19.9891
R5909 VGND.t1178 VGND.n348 19.9891
R5910 VGND.t1410 VGND.n349 19.9891
R5911 VGND.t941 VGND.n17 19.9891
R5912 VGND.n41 VGND.t1236 20.6078
R5913 VGND.t429 VGND.n16 19.9891
R5914 VGND.n24 VGND.t361 19.9891
R5915 VGND.t457 VGND.n24 19.9891
R5916 VGND.t120 VGND.n14 19.9891
R5917 VGND.n14 VGND.t1304 19.9891
R5918 VGND.n13 VGND.t954 19.9891
R5919 VGND.n30 VGND.t904 19.9891
R5920 VGND.n31 VGND.t1063 19.9891
R5921 VGND.n32 VGND.t884 19.9891
R5922 VGND.n33 VGND.t963 19.9891
R5923 VGND.n34 VGND.t901 19.9891
R5924 VGND.n35 VGND.t1482 19.9891
R5925 VGND.t1303 VGND.n1029 19.9891
R5926 VGND.n11 VGND.t893 18.8658
R5927 VGND.t966 VGND.n1010 19.9891
R5928 VGND.n1010 VGND.t960 19.9891
R5929 VGND.t358 VGND.n1008 19.9891
R5930 VGND.n1008 VGND.t1403 19.9891
R5931 VGND.t1075 VGND.n1004 19.9891
R5932 VGND.n1004 VGND.t389 19.9891
R5933 VGND.t182 VGND.n990 19.9891
R5934 VGND.n987 VGND.t221 19.9891
R5935 VGND.n985 VGND.t216 19.9891
R5936 VGND.n976 VGND.t892 19.9891
R5937 VGND.t899 VGND.n966 19.9891
R5938 VGND.n2 VGND.t266 19.9891
R5939 VGND.t158 VGND.n5 19.9891
R5940 VGND.n1 VGND.t129 19.9891
R5941 VGND.t7 VGND.n409 19.9891
R5942 VGND.t371 VGND.n407 19.9891
R5943 VGND.t13 VGND.n402 19.9891
R5944 VGND.n400 VGND.t698 19.9891
R5945 VGND.n399 VGND.t1057 19.9891
R5946 VGND.n398 VGND.t870 19.9891
R5947 VGND.t1096 VGND.n88 19.9891
R5948 VGND.n87 VGND.t1362 19.9891
R5949 VGND.t1444 VGND.n86 19.9891
R5950 VGND.t700 VGND.n90 19.9891
R5951 VGND.n91 VGND.t144 19.9891
R5952 VGND.n94 VGND.t146 19.9891
R5953 VGND.t556 VGND.n94 19.9891
R5954 VGND.t460 VGND.n82 19.9891
R5955 VGND.n82 VGND.t445 19.9891
R5956 VGND.n96 VGND.t1074 19.9891
R5957 VGND.t1119 VGND.n96 19.9891
R5958 VGND.n97 VGND.t198 19.9891
R5959 VGND.t1181 VGND.n99 19.9891
R5960 VGND.n100 VGND.t903 19.9891
R5961 VGND.n109 VGND.t1082 19.9891
R5962 VGND.t1098 VGND.n109 19.9891
R5963 VGND.n110 VGND.t927 19.9891
R5964 VGND.t1104 VGND.n110 19.9891
R5965 VGND.n111 VGND.t382 19.9891
R5966 VGND.t121 VGND.n111 19.9891
R5967 VGND.n116 VGND.t38 19.9891
R5968 VGND.t1109 VGND.n116 19.9891
R5969 VGND.n193 VGND.t933 19.9891
R5970 VGND.t756 VGND.n193 19.9891
R5971 VGND.t485 VGND.n196 19.9891
R5972 VGND.t509 VGND.n197 19.9891
R5973 VGND.n198 VGND.t1121 19.9891
R5974 VGND.t282 VGND.n199 19.9891
R5975 VGND.n208 VGND.t469 19.9891
R5976 VGND.t173 VGND.n208 19.9891
R5977 VGND.t463 VGND.n212 19.9891
R5978 VGND.n720 VGND.t314 19.9891
R5979 VGND.n718 VGND.t1066 19.9891
R5980 VGND.t701 VGND.n710 19.9891
R5981 VGND.t589 VGND.n442 19.9891
R5982 VGND.t526 VGND.n443 19.9891
R5983 VGND.n444 VGND.t1429 19.9891
R5984 VGND.t1159 VGND.n450 19.9891
R5985 VGND.n438 VGND.t1056 19.9891
R5986 VGND.t1179 VGND.n451 19.9891
R5987 VGND.n437 VGND.t942 19.9891
R5988 VGND.n433 VGND.t1372 19.9891
R5989 VGND.n459 VGND.t821 19.9891
R5990 VGND.t961 VGND.n459 19.9891
R5991 VGND.t875 VGND.n422 19.9891
R5992 VGND.n422 VGND.t87 19.9891
R5993 VGND.n462 VGND.t1169 19.9891
R5994 VGND.t236 VGND.n462 19.9891
R5995 VGND.t793 VGND.n465 19.9891
R5996 VGND.t167 VGND.n467 19.9891
R5997 VGND.n475 VGND.t689 19.9891
R5998 VGND.n477 VGND.t378 19.9891
R5999 VGND.t1346 VGND.n477 19.9891
R6000 VGND.n478 VGND.t228 19.9891
R6001 VGND.t234 VGND.n478 19.9891
R6002 VGND.n479 VGND.t385 19.9891
R6003 VGND.t333 VGND.n479 19.9891
R6004 VGND.n480 VGND.t461 19.9891
R6005 VGND.t416 VGND.n828 19.9891
R6006 VGND.n832 VGND.t1448 19.9891
R6007 VGND.n836 VGND.t628 19.9891
R6008 VGND.t1189 VGND.n836 19.9891
R6009 VGND.n838 VGND.t627 19.9891
R6010 VGND.t1188 VGND.n838 19.9891
R6011 VGND.n304 VGND.t286 19.9891
R6012 VGND.t284 VGND.n307 19.9891
R6013 VGND.t819 VGND.n301 19.9891
R6014 VGND.t818 VGND.n302 19.9891
R6015 VGND.n491 VGND.t731 19.9891
R6016 VGND.n490 VGND.t1190 19.9891
R6017 VGND.n499 VGND.t671 19.9891
R6018 VGND.t669 VGND.n816 19.9891
R6019 VGND.n783 VGND.t1339 19.9891
R6020 VGND.t295 VGND.n783 19.9891
R6021 VGND.t1184 VGND.n784 19.9891
R6022 VGND.n787 VGND.t1338 19.9891
R6023 VGND.t582 VGND.n787 19.9891
R6024 VGND.t665 VGND.t359 17.8311
R6025 VGND.t1032 VGND.t779 17.8311
R6026 VGND.t481 VGND.t359 17.6316
R6027 VGND.t1258 VGND.n522 17.1434
R6028 VGND.t1431 VGND.n550 17.1434
R6029 VGND.n928 VGND.t895 17.1434
R6030 VGND.t447 VGND.t1554 17.1434
R6031 VGND.n903 VGND.t1435 17.1434
R6032 VGND.n675 VGND.t1475 17.1434
R6033 VGND.n885 VGND.t635 17.1434
R6034 VGND.t707 VGND.n792 17.1434
R6035 VGND.n1086 VGND.n352 17.001
R6036 VGND.n411 VGND.n395 0.649832
R6037 VGND.n482 VGND.n420 0.649832
R6038 VGND.n245 VGND.n611 17.0005
R6039 VGND.n318 VGND.n222 8.49553
R6040 VGND.n1092 VGND.n329 17.0005
R6041 VGND.n294 VGND.n321 17.0005
R6042 VGND.n294 VGND.n756 17.0005
R6043 VGND.n294 VGND.n759 17.0005
R6044 VGND.n294 VGND.n758 17.0005
R6045 VGND.n181 VGND.n1049 17.0005
R6046 VGND.n181 VGND.n1051 17.0005
R6047 VGND.n181 VGND.n1085 17.0005
R6048 VGND.n181 VGND.n1052 17.0005
R6049 VGND.n181 VGND.n1053 17.0005
R6050 VGND.n181 VGND.n1084 17.0005
R6051 VGND.n181 VGND.n1083 17.0005
R6052 VGND.n181 VGND.n1054 17.0005
R6053 VGND.n181 VGND.n1082 17.0005
R6054 VGND.n181 VGND.n1055 17.0005
R6055 VGND.n181 VGND.n1081 17.0005
R6056 VGND.n181 VGND.n1056 17.0005
R6057 VGND.n181 VGND.n1080 17.0005
R6058 VGND.n181 VGND.n1079 17.0005
R6059 VGND.n181 VGND.n1078 17.0005
R6060 VGND.n181 VGND.n1077 17.0005
R6061 VGND.n181 VGND.n1057 17.0005
R6062 VGND.n181 VGND.n1076 17.0005
R6063 VGND.n181 VGND.n1058 17.0005
R6064 VGND.n181 VGND.n1075 17.0005
R6065 VGND.n181 VGND.n1059 17.0005
R6066 VGND.n181 VGND.n1074 17.0005
R6067 VGND.n181 VGND.n1061 17.0005
R6068 VGND.n181 VGND.n1062 17.0005
R6069 VGND.n181 VGND.n1073 17.0005
R6070 VGND.n181 VGND.n1063 17.0005
R6071 VGND.n181 VGND.n1064 17.0005
R6072 VGND.n181 VGND.n1065 17.0005
R6073 VGND.n181 VGND.n1072 17.0005
R6074 VGND.n181 VGND.n1071 17.0005
R6075 VGND.n181 VGND.n1070 17.0005
R6076 VGND.n181 VGND.n1069 17.0005
R6077 VGND.n181 VGND.n1067 17.0005
R6078 VGND.n181 VGND.n1068 17.0005
R6079 VGND.n181 VGND.n323 17.0005
R6080 VGND.n382 VGND.n383 0.00196766
R6081 VGND.n382 VGND.n581 17.0005
R6082 VGND.n382 VGND.n1104 17.0005
R6083 VGND.n382 VGND.n582 17.0005
R6084 VGND.n382 VGND.n1103 17.0005
R6085 VGND.n382 VGND.n583 17.0005
R6086 VGND.n382 VGND.n1102 17.0005
R6087 VGND.n382 VGND.n580 17.0005
R6088 VGND.n382 VGND.n521 17.0005
R6089 VGND.n382 VGND.n519 17.0005
R6090 VGND.n382 VGND.n518 17.0005
R6091 VGND.n382 VGND.n517 17.0005
R6092 VGND.n382 VGND.n516 17.0005
R6093 VGND.n382 VGND.n515 17.0005
R6094 VGND.n382 VGND.n522 17.0005
R6095 VGND.n382 VGND.n575 17.0005
R6096 VGND.n382 VGND.n576 17.0005
R6097 VGND.n382 VGND.n577 17.0005
R6098 VGND.n382 VGND.n578 17.0005
R6099 VGND.n382 VGND.n579 17.0005
R6100 VGND.n382 VGND.n574 17.0005
R6101 VGND.n382 VGND.n528 17.0005
R6102 VGND.n382 VGND.n527 17.0005
R6103 VGND.n382 VGND.n525 17.0005
R6104 VGND.n382 VGND.n524 17.0005
R6105 VGND.n382 VGND.n561 17.0005
R6106 VGND.n382 VGND.n562 17.0005
R6107 VGND.n382 VGND.n563 17.0005
R6108 VGND.n382 VGND.n564 17.0005
R6109 VGND.n382 VGND.n565 17.0005
R6110 VGND.n382 VGND.n566 17.0005
R6111 VGND.n382 VGND.n567 17.0005
R6112 VGND.n382 VGND.n568 17.0005
R6113 VGND.n382 VGND.n569 17.0005
R6114 VGND.n382 VGND.n570 17.0005
R6115 VGND.n382 VGND.n571 17.0005
R6116 VGND.n382 VGND.n572 17.0005
R6117 VGND.n382 VGND.n573 17.0005
R6118 VGND.n382 VGND.n560 17.0005
R6119 VGND.n382 VGND.n534 17.0005
R6120 VGND.n382 VGND.n533 17.0005
R6121 VGND.n382 VGND.n532 17.0005
R6122 VGND.n382 VGND.n531 17.0005
R6123 VGND.n382 VGND.n535 17.0005
R6124 VGND.n382 VGND.n559 17.0005
R6125 VGND.n382 VGND.n558 17.0005
R6126 VGND.n382 VGND.n557 17.0005
R6127 VGND.n382 VGND.n556 17.0005
R6128 VGND.n382 VGND.n555 17.0005
R6129 VGND.n382 VGND.n554 17.0005
R6130 VGND.n382 VGND.n553 17.0005
R6131 VGND.n382 VGND.n551 17.0005
R6132 VGND.n382 VGND.n550 17.0005
R6133 VGND.n382 VGND.n549 17.0005
R6134 VGND.n382 VGND.n548 17.0005
R6135 VGND.n382 VGND.n547 17.0005
R6136 VGND.n382 VGND.n546 17.0005
R6137 VGND.n382 VGND.n545 17.0005
R6138 VGND.n382 VGND.n544 17.0005
R6139 VGND.n382 VGND.n543 17.0005
R6140 VGND.n382 VGND.n542 17.0005
R6141 VGND.n382 VGND.n541 17.0005
R6142 VGND.n382 VGND.n540 17.0005
R6143 VGND.n382 VGND.n539 17.0005
R6144 VGND.n382 VGND.n538 17.0005
R6145 VGND.n382 VGND.n537 17.0005
R6146 VGND.n382 VGND.n536 17.0005
R6147 VGND.t335 VGND.n631 17.0005
R6148 VGND.t335 VGND.n619 17.0005
R6149 VGND.t335 VGND.n620 17.0005
R6150 VGND.t335 VGND.n48 0.788882
R6151 VGND.t335 VGND.n621 17.0005
R6152 VGND.t335 VGND.n622 17.0005
R6153 VGND.t335 VGND.n623 17.0005
R6154 VGND.t335 VGND.n624 17.0005
R6155 VGND.t335 VGND.n625 17.0005
R6156 VGND.t335 VGND.n45 8.48812
R6157 VGND.t335 VGND.n44 0.788882
R6158 VGND.t335 VGND.n630 17.0005
R6159 VGND.t335 VGND.n627 17.0005
R6160 VGND.t335 VGND.n628 17.0005
R6161 VGND.t335 VGND.n629 17.0005
R6162 VGND.t335 VGND.n633 17.0005
R6163 VGND.t335 VGND.n1033 17.0005
R6164 VGND.t335 VGND.n1034 17.0005
R6165 VGND.t335 VGND.n1035 17.0005
R6166 VGND.t335 VGND.n1036 17.0005
R6167 VGND.n1024 VGND.t335 17.0005
R6168 VGND.n1025 VGND.t335 17.0005
R6169 VGND.n65 VGND.t335 0.789744
R6170 VGND.n296 VGND.t335 16.1874
R6171 VGND.n1027 VGND.t335 17.0005
R6172 VGND.n62 VGND.t335 0.788882
R6173 VGND.n1031 VGND.t335 17.0005
R6174 VGND.n56 VGND.t335 15.4358
R6175 VGND.n53 VGND.t335 15.4357
R6176 VGND.t335 VGND.n58 0.788882
R6177 VGND.t335 VGND.n637 17.0005
R6178 VGND.t335 VGND.n636 17.0005
R6179 VGND.t335 VGND.n635 17.0005
R6180 VGND.t335 VGND.n634 17.0005
R6181 VGND.n60 VGND.n6 8.48814
R6182 VGND.n1006 VGND.n6 17.0005
R6183 VGND.n1009 VGND.n6 17.0005
R6184 VGND.n1011 VGND.n6 17.0005
R6185 VGND.n11 VGND.n6 0.788688
R6186 VGND.n1012 VGND.n6 17.0005
R6187 VGND.n59 VGND.n6 0.788846
R6188 VGND.n996 VGND.n6 17.0005
R6189 VGND.n997 VGND.n6 17.0005
R6190 VGND.n998 VGND.n6 17.0005
R6191 VGND.n999 VGND.n6 17.0005
R6192 VGND.n1000 VGND.n6 17.0005
R6193 VGND.n1001 VGND.n6 17.0005
R6194 VGND.n1002 VGND.n6 17.0005
R6195 VGND.n986 VGND.n6 17.0005
R6196 VGND.n988 VGND.n6 17.0005
R6197 VGND.n989 VGND.n6 17.0005
R6198 VGND.n992 VGND.n6 17.0005
R6199 VGND.n994 VGND.n6 17.0005
R6200 VGND.n978 VGND.n6 17.0005
R6201 VGND.n979 VGND.n6 17.0005
R6202 VGND.n981 VGND.n6 17.0005
R6203 VGND.n982 VGND.n6 17.0005
R6204 VGND.n983 VGND.n6 17.0005
R6205 VGND.n6 VGND.n960 17.0005
R6206 VGND.n6 VGND.n655 17.0005
R6207 VGND.n6 VGND.n953 17.0005
R6208 VGND.n6 VGND.n55 16.1874
R6209 VGND.n6 VGND.n657 17.0005
R6210 VGND.n6 VGND.n51 16.1874
R6211 VGND.n6 VGND.n184 16.1874
R6212 VGND.n6 VGND.n40 4.24482
R6213 VGND.n961 VGND.n6 17.0005
R6214 VGND.n962 VGND.n6 17.0005
R6215 VGND.n963 VGND.n6 17.0005
R6216 VGND.n964 VGND.n6 17.0005
R6217 VGND.n965 VGND.n6 17.0005
R6218 VGND.n968 VGND.n6 17.0005
R6219 VGND.n969 VGND.n6 17.0005
R6220 VGND.n971 VGND.n6 17.0005
R6221 VGND.n972 VGND.n6 17.0005
R6222 VGND.n973 VGND.n6 17.0005
R6223 VGND.n63 VGND.n6 16.1874
R6224 VGND.n974 VGND.n6 17.0005
R6225 VGND.n975 VGND.n6 17.0005
R6226 VGND.n6 VGND.n954 17.0005
R6227 VGND.n6 VGND.n955 17.0005
R6228 VGND.n6 VGND.n956 17.0005
R6229 VGND.n6 VGND.n957 17.0005
R6230 VGND.n6 VGND.n958 17.0005
R6231 VGND.n6 VGND.n959 17.0005
R6232 VGND.n411 VGND.n639 17.0005
R6233 VGND.n411 VGND.n651 17.0005
R6234 VGND.n411 VGND.n652 17.0005
R6235 VGND.n411 VGND.n653 17.0005
R6236 VGND.n411 VGND.n654 17.0005
R6237 VGND.n411 VGND.n650 17.0005
R6238 VGND.n411 VGND.n649 17.0005
R6239 VGND.n411 VGND.n648 17.0005
R6240 VGND.n411 VGND.n647 17.0005
R6241 VGND.n411 VGND.n646 17.0005
R6242 VGND.n411 VGND.n645 17.0005
R6243 VGND.n411 VGND.n644 17.0005
R6244 VGND.n411 VGND.n643 17.0005
R6245 VGND.n411 VGND.n642 17.0005
R6246 VGND.n411 VGND.n641 17.0005
R6247 VGND.n411 VGND.n640 17.0005
R6248 VGND.n122 VGND.n906 17.0005
R6249 VGND.n122 VGND.n935 17.0005
R6250 VGND.n122 VGND.n934 17.0005
R6251 VGND.n122 VGND.n908 17.0005
R6252 VGND.n122 VGND.n933 17.0005
R6253 VGND.n122 VGND.n932 17.0005
R6254 VGND.n122 VGND.n910 17.0005
R6255 VGND.n122 VGND.n931 17.0005
R6256 VGND.n122 VGND.n911 17.0005
R6257 VGND.n122 VGND.n930 17.0005
R6258 VGND.n122 VGND.n912 17.0005
R6259 VGND.n122 VGND.n929 17.0005
R6260 VGND.n122 VGND.n913 17.0005
R6261 VGND.n122 VGND.n914 17.0005
R6262 VGND.n122 VGND.n928 17.0005
R6263 VGND.n122 VGND.n915 17.0005
R6264 VGND.n122 VGND.n927 17.0005
R6265 VGND.n122 VGND.n926 17.0005
R6266 VGND.n122 VGND.n916 17.0005
R6267 VGND.n122 VGND.n917 17.0005
R6268 VGND.n122 VGND.n925 17.0005
R6269 VGND.n122 VGND.n918 17.0005
R6270 VGND.n122 VGND.n919 17.0005
R6271 VGND.n122 VGND.n924 17.0005
R6272 VGND.n122 VGND.n920 17.0005
R6273 VGND.n122 VGND.n923 17.0005
R6274 VGND.n122 VGND.n299 16.1874
R6275 VGND.n122 VGND.n298 16.1874
R6276 VGND.n122 VGND.n922 17.0005
R6277 VGND.n122 VGND.n936 17.0005
R6278 VGND.n122 VGND.n941 17.0005
R6279 VGND.n122 VGND.n942 17.0005
R6280 VGND.n122 VGND.n943 17.0005
R6281 VGND.n122 VGND.n944 17.0005
R6282 VGND.n122 VGND.n940 17.0005
R6283 VGND.n122 VGND.n939 17.0005
R6284 VGND.n122 VGND.n938 17.0005
R6285 VGND.n122 VGND.n937 17.0005
R6286 VGND.n221 VGND.n903 17.0005
R6287 VGND.n221 VGND.n668 17.0005
R6288 VGND.n221 VGND.n669 17.0005
R6289 VGND.n221 VGND.n672 17.0005
R6290 VGND.n221 VGND.n670 17.0005
R6291 VGND.n221 VGND.n671 17.0005
R6292 VGND.n221 VGND.n324 17.0005
R6293 VGND.n221 VGND.n673 17.0005
R6294 VGND.n221 VGND.n897 17.0005
R6295 VGND.n221 VGND.n898 17.0005
R6296 VGND.n221 VGND.n899 17.0005
R6297 VGND.n221 VGND.n900 17.0005
R6298 VGND.n221 VGND.n901 17.0005
R6299 VGND.n221 VGND.n902 17.0005
R6300 VGND.n221 VGND.n315 0.789785
R6301 VGND.n221 VGND.n684 17.0005
R6302 VGND.n221 VGND.n683 17.0005
R6303 VGND.n221 VGND.n681 17.0005
R6304 VGND.n221 VGND.n680 17.0005
R6305 VGND.n221 VGND.n679 17.0005
R6306 VGND.n221 VGND.n678 17.0005
R6307 VGND.n221 VGND.n677 17.0005
R6308 VGND.n221 VGND.n676 17.0005
R6309 VGND.n221 VGND.n675 17.0005
R6310 VGND.n221 VGND.n674 17.0005
R6311 VGND.n221 VGND.n685 17.0005
R6312 VGND.n221 VGND.n893 17.0005
R6313 VGND.n221 VGND.n894 17.0005
R6314 VGND.n221 VGND.n895 17.0005
R6315 VGND.n221 VGND.n896 17.0005
R6316 VGND.n221 VGND.n697 17.0005
R6317 VGND.n221 VGND.n696 17.0005
R6318 VGND.n221 VGND.n694 17.0005
R6319 VGND.n221 VGND.n693 17.0005
R6320 VGND.n221 VGND.n692 17.0005
R6321 VGND.n221 VGND.n690 17.0005
R6322 VGND.n221 VGND.n689 17.0005
R6323 VGND.n221 VGND.n688 17.0005
R6324 VGND.n221 VGND.n687 17.0005
R6325 VGND.n221 VGND.n698 17.0005
R6326 VGND.n221 VGND.n726 17.0005
R6327 VGND.n221 VGND.n727 17.0005
R6328 VGND.n221 VGND.n728 17.0005
R6329 VGND.n221 VGND.n729 17.0005
R6330 VGND.n703 VGND.n218 17.0005
R6331 VGND.n704 VGND.n218 17.0005
R6332 VGND.n706 VGND.n218 17.0005
R6333 VGND.n707 VGND.n218 17.0005
R6334 VGND.n708 VGND.n218 17.0005
R6335 VGND.n712 VGND.n218 17.0005
R6336 VGND.n714 VGND.n218 17.0005
R6337 VGND.n716 VGND.n218 17.0005
R6338 VGND.n719 VGND.n218 17.0005
R6339 VGND.n721 VGND.n218 17.0005
R6340 VGND.n723 VGND.n218 17.0005
R6341 VGND.n221 VGND.n725 17.0005
R6342 VGND.n221 VGND.n701 17.0005
R6343 VGND.n221 VGND.n700 17.0005
R6344 VGND.n482 VGND.n885 17.0005
R6345 VGND.n482 VGND.n733 17.0005
R6346 VGND.n482 VGND.n866 17.0005
R6347 VGND.n482 VGND.n734 17.0005
R6348 VGND.n482 VGND.n865 17.0005
R6349 VGND.n482 VGND.n736 17.0005
R6350 VGND.n482 VGND.n864 17.0005
R6351 VGND.n482 VGND.n737 17.0005
R6352 VGND.n482 VGND.n738 17.0005
R6353 VGND.n482 VGND.n863 17.0005
R6354 VGND.n482 VGND.n739 17.0005
R6355 VGND.n482 VGND.n862 17.0005
R6356 VGND.n482 VGND.n741 17.0005
R6357 VGND.n482 VGND.n861 17.0005
R6358 VGND.n482 VGND.n742 17.0005
R6359 VGND.n482 VGND.n860 17.0005
R6360 VGND.n482 VGND.n743 17.0005
R6361 VGND.n482 VGND.n859 17.0005
R6362 VGND.n482 VGND.n858 17.0005
R6363 VGND.n482 VGND.n744 17.0005
R6364 VGND.n482 VGND.n857 17.0005
R6365 VGND.n482 VGND.n745 17.0005
R6366 VGND.n482 VGND.n856 17.0005
R6367 VGND.n482 VGND.n747 17.0005
R6368 VGND.n482 VGND.n855 17.0005
R6369 VGND.n482 VGND.n748 17.0005
R6370 VGND.n482 VGND.n867 17.0005
R6371 VGND.n482 VGND.n881 17.0005
R6372 VGND.n482 VGND.n882 17.0005
R6373 VGND.n482 VGND.n883 17.0005
R6374 VGND.n482 VGND.n884 17.0005
R6375 VGND.n482 VGND.n880 17.0005
R6376 VGND.n482 VGND.n879 17.0005
R6377 VGND.n482 VGND.n878 17.0005
R6378 VGND.n482 VGND.n877 17.0005
R6379 VGND.n482 VGND.n876 17.0005
R6380 VGND.n482 VGND.n875 17.0005
R6381 VGND.n482 VGND.n874 17.0005
R6382 VGND.n482 VGND.n873 17.0005
R6383 VGND.n482 VGND.n872 17.0005
R6384 VGND.n482 VGND.n871 17.0005
R6385 VGND.n482 VGND.n870 17.0005
R6386 VGND.n826 VGND.n484 17.0005
R6387 VGND.n825 VGND.n484 17.0005
R6388 VGND.n824 VGND.n484 17.0005
R6389 VGND.n823 VGND.n484 17.0005
R6390 VGND.n822 VGND.n484 17.0005
R6391 VGND.n821 VGND.n484 17.0005
R6392 VGND.n820 VGND.n484 17.0005
R6393 VGND.n844 VGND.n485 17.0005
R6394 VGND.n842 VGND.n485 17.0005
R6395 VGND.n840 VGND.n484 17.0005
R6396 VGND.n837 VGND.n484 17.0005
R6397 VGND.n835 VGND.n484 17.0005
R6398 VGND.n834 VGND.n484 17.0005
R6399 VGND.n833 VGND.n484 17.0005
R6400 VGND.n830 VGND.n484 17.0005
R6401 VGND.n829 VGND.n484 17.0005
R6402 VGND.n786 VGND.n308 17.0005
R6403 VGND.n785 VGND.n308 17.0005
R6404 VGND.n782 VGND.n308 17.0005
R6405 VGND.n781 VGND.n312 17.0005
R6406 VGND.n780 VGND.n312 17.0005
R6407 VGND.n778 VGND.n312 17.0005
R6408 VGND.n776 VGND.n501 17.0005
R6409 VGND.n501 VGND.n502 17.0005
R6410 VGND.n489 VGND.n817 17.0005
R6411 VGND.n489 VGND.n772 17.0005
R6412 VGND.n818 VGND.n489 17.0005
R6413 VGND.n496 VGND.n819 17.0005
R6414 VGND.n496 VGND.n771 17.0005
R6415 VGND.n496 VGND.n770 17.0005
R6416 VGND.n791 VGND.n308 17.0005
R6417 VGND.n789 VGND.n308 17.0005
R6418 VGND.n309 VGND.n310 0.789821
R6419 VGND.n309 VGND.n809 17.0005
R6420 VGND.n309 VGND.n808 17.0005
R6421 VGND.n806 VGND.n308 17.0005
R6422 VGND.n804 VGND.n308 17.0005
R6423 VGND.n803 VGND.n308 17.0005
R6424 VGND.n802 VGND.n308 17.0005
R6425 VGND.n800 VGND.n308 17.0005
R6426 VGND.n799 VGND.n308 17.0005
R6427 VGND.n798 VGND.n308 17.0005
R6428 VGND.n797 VGND.n308 17.0005
R6429 VGND.n795 VGND.n308 17.0005
R6430 VGND.n794 VGND.n308 17.0005
R6431 VGND.n793 VGND.n308 17.0005
R6432 VGND.n792 VGND.n308 17.0005
R6433 VGND.n309 VGND.n810 17.0005
R6434 VGND.n309 VGND.n812 17.0005
R6435 VGND.n309 VGND.n813 17.0005
R6436 VGND.n309 VGND.n814 17.0005
R6437 VGND.n309 VGND.n815 17.0005
R6438 VGND.n827 VGND.t799 15.7034
R6439 VGND.t1210 VGND.n494 15.7034
R6440 VGND.t93 VGND.t804 14.0945
R6441 VGND.t1042 VGND.t899 12.8576
R6442 VGND.t757 VGND.n964 12.8576
R6443 VGND.n963 VGND.t770 12.8576
R6444 VGND.t101 VGND.t1249 12.8576
R6445 VGND.t712 VGND.t767 12.8576
R6446 VGND.n1106 VGND.n512 9.0005
R6447 VGND.n1038 VGND.n512 9.0005
R6448 VGND.n851 VGND.n849 9.0005
R6449 VGND.n853 VGND.n847 9.0005
R6450 VGND.n891 VGND.n730 9.0005
R6451 VGND.n887 VGND.n730 9.0005
R6452 VGND.n613 VGND.n612 9.0005
R6453 VGND.n1045 VGND.n1044 9.0005
R6454 VGND.t83 VGND.n535 8.91581
R6455 VGND.n64 VGND.n6 0.431108
R6456 VGND.n352 VGND.t428 8.60839
R6457 VGND.t149 VGND.n412 0.694874
R6458 VGND.n483 VGND.t552 0.906252
R6459 VGND.n572 VGND.t72 8.57193
R6460 VGND.t772 VGND.n541 8.57193
R6461 VGND.n63 VGND.t75 8.73624
R6462 VGND.n960 VGND.t663 8.57193
R6463 VGND.t1004 VGND.n915 8.57193
R6464 VGND.n934 VGND.t1433 8.57193
R6465 VGND.t1437 VGND.n675 8.57193
R6466 VGND.t709 VGND.n800 8.57193
R6467 VGND.t536 VGND.n245 8.501
R6468 VGND.n331 VGND.t1378 0.911897
R6469 VGND.n330 VGND.t1632 0.228063
R6470 VGND.n384 VGND.n382 1.53233
R6471 VGND.n392 VGND.t470 0.942916
R6472 VGND.t225 VGND.n390 0.921868
R6473 VGND.t939 VGND.n388 0.718687
R6474 VGND.n393 VGND.t335 0.532544
R6475 VGND.t508 VGND.n416 0.490206
R6476 VGND.t1565 VGND.n415 0.123414
R6477 VGND.n419 VGND.n218 0.40968
R6478 VGND.t1503 VGND.n509 0.912564
R6479 VGND.t587 VGND.n510 0.22786
R6480 VGND.t747 VGND.n488 0.185108
R6481 VGND.t207 VGND.n486 0.130189
R6482 VGND.n497 VGND.n496 0.690157
R6483 VGND.n506 VGND.n308 0.428038
R6484 VGND.t98 VGND.n505 0.130189
R6485 VGND.t1225 VGND.n504 8.501
R6486 VGND.n503 VGND.t1227 0.130189
R6487 VGND.t670 VGND.n498 8.501
R6488 VGND.t136 VGND.n500 0.129991
R6489 VGND.n507 VGND.n309 1.21618
R6490 VGND.n382 VGND.t1265 8.5005
R6491 VGND.t1528 VGND.n221 8.5005
R6492 VGND.n482 VGND.n746 8.47794
R6493 VGND.n417 VGND.t1163 0.806227
R6494 VGND.n495 VGND.n487 0.00157137
R6495 VGND.t1546 VGND.n122 5.64719
R6496 VGND.n415 VGND.n414 3.33348
R6497 VGND.n486 VGND.n485 3.33079
R6498 VGND.n505 VGND.n312 3.33079
R6499 VGND.n503 VGND.n501 3.33079
R6500 VGND.n489 VGND.n500 3.33087
R6501 VGND.n767 VGND.t503 5.16578
R6502 VGND.t33 VGND.n1089 5.16578
R6503 VGND.n765 VGND.t363 5.16578
R6504 VGND.n767 VGND.t140 4.5005
R6505 VGND.n846 VGND.t1503 4.5005
R6506 VGND.t1521 VGND.n854 4.5005
R6507 VGND.n904 VGND.t1529 4.5005
R6508 VGND.n945 VGND.t854 4.5005
R6509 VGND.t153 VGND.n946 4.5005
R6510 VGND.t342 VGND.n617 4.5005
R6511 VGND.n1037 VGND.t540 4.5005
R6512 VGND.t420 VGND.n1039 4.5005
R6513 VGND.n1105 VGND.t54 4.5005
R6514 VGND.t610 VGND.n514 4.5005
R6515 VGND.t1378 VGND.n1091 4.5005
R6516 VGND.t567 VGND.n765 4.5005
R6517 VGND.t90 VGND.n732 4.5005
R6518 VGND.n886 VGND.t88 4.5005
R6519 VGND.t480 VGND.n892 4.5005
R6520 VGND.t347 VGND.n659 4.5005
R6521 VGND.n949 VGND.t902 4.5005
R6522 VGND.t514 VGND.n950 4.5005
R6523 VGND.t157 VGND.n615 4.5005
R6524 VGND.n1042 VGND.t233 4.5005
R6525 VGND.n1048 VGND.t78 4.5005
R6526 VGND.n1089 VGND.t621 4.5005
R6527 VGND.n850 VGND.n666 4.49573
R6528 VGND.n1047 VGND.n1046 4.49573
R6529 VGND.n1109 VGND.n1108 4.49046
R6530 VGND.n1107 VGND.n512 4.49046
R6531 VGND.n1109 VGND.n513 4.49046
R6532 VGND.n848 VGND.n847 4.49046
R6533 VGND.n852 VGND.n851 4.49046
R6534 VGND.n890 VGND.n731 4.49046
R6535 VGND.n889 VGND.n730 4.49046
R6536 VGND.n888 VGND.n731 4.49046
R6537 VGND.n1045 VGND.n614 4.49046
R6538 VGND.n1043 VGND.n613 4.49046
R6539 VGND.t1297 VGND.n516 4.45815
R6540 VGND.t570 VGND.n527 4.45815
R6541 VGND.t1424 VGND.n528 4.45815
R6542 VGND.n1036 VGND.t1026 4.45815
R6543 VGND.t1037 VGND.n633 4.45815
R6544 VGND.t959 VGND.n1002 4.45815
R6545 VGND.n999 VGND.t341 4.45815
R6546 VGND.n996 VGND.t881 4.45815
R6547 VGND.t339 VGND.n983 4.45815
R6548 VGND.t1009 VGND.n955 4.45815
R6549 VGND.n652 VGND.t982 4.45815
R6550 VGND.n651 VGND.t273 4.45815
R6551 VGND.t365 VGND.n944 4.45815
R6552 VGND.n899 VGND.t865 4.45815
R6553 VGND.n894 VGND.t545 4.45815
R6554 VGND.n893 VGND.t1301 4.45815
R6555 VGND.t944 VGND.n882 4.45815
R6556 VGND.n881 VGND.t1243 4.45815
R6557 VGND.t417 VGND.n821 4.45815
R6558 VGND.n824 VGND.t262 4.45815
R6559 VGND.n795 VGND.t496 4.45815
R6560 VGND.t600 VGND.n797 4.45815
R6561 VGND.t1391 VGND.n1067 4.28621
R6562 VGND.n1069 VGND.t259 4.28621
R6563 VGND.n1069 VGND.t632 4.28621
R6564 VGND.n1070 VGND.t1296 4.28621
R6565 VGND.t609 VGND.n183 4.45052
R6566 VGND.n183 VGND.t1180 4.08161
R6567 VGND.n182 VGND.t1145 4.08161
R6568 VGND.n182 VGND.t1149 4.45052
R6569 VGND.n1072 VGND.t630 4.28621
R6570 VGND.n1072 VGND.t1277 4.28621
R6571 VGND.t727 VGND.n1065 4.28621
R6572 VGND.t305 VGND.n1065 4.28621
R6573 VGND.t398 VGND.n1064 4.28621
R6574 VGND.t623 VGND.n1063 4.28621
R6575 VGND.t1393 VGND.n1063 4.28621
R6576 VGND.t1469 VGND.n1073 4.28621
R6577 VGND.t616 VGND.n1062 4.28621
R6578 VGND.t763 VGND.n1061 4.28621
R6579 VGND.n1074 VGND.t891 4.28621
R6580 VGND.t662 VGND.n1059 4.28621
R6581 VGND.t1197 VGND.n1058 4.28621
R6582 VGND.n1076 VGND.t1137 4.28621
R6583 VGND.n1077 VGND.t283 4.28621
R6584 VGND.n1078 VGND.t349 4.28621
R6585 VGND.n1080 VGND.t676 4.28621
R6586 VGND.n1080 VGND.t844 4.28621
R6587 VGND.t1322 VGND.n1056 4.28621
R6588 VGND.t1388 VGND.n1056 4.28621
R6589 VGND.n1081 VGND.t1353 4.28621
R6590 VGND.n1081 VGND.t724 4.28621
R6591 VGND.t1295 VGND.n1055 4.28621
R6592 VGND.t1430 VGND.n1054 4.28621
R6593 VGND.n1084 VGND.t1343 4.28621
R6594 VGND.n1084 VGND.t546 4.28621
R6595 VGND.t20 VGND.n1053 4.28621
R6596 VGND.t633 VGND.n1053 4.28621
R6597 VGND.t586 VGND.n1052 4.28621
R6598 VGND.t431 VGND.n1051 4.28621
R6599 VGND.t63 VGND.n1049 4.28621
R6600 VGND.n1102 VGND.t247 4.28621
R6601 VGND.t1459 VGND.n583 4.28621
R6602 VGND.n1104 VGND.t55 4.28621
R6603 VGND.t1418 VGND.n578 4.28621
R6604 VGND.t1396 VGND.n576 4.28621
R6605 VGND.n575 VGND.t1284 4.28621
R6606 VGND.n567 VGND.t241 4.28621
R6607 VGND.n566 VGND.t409 4.28621
R6608 VGND.t1151 VGND.n565 4.28621
R6609 VGND.n565 VGND.t879 4.28621
R6610 VGND.t1398 VGND.n564 4.28621
R6611 VGND.n564 VGND.t395 4.28621
R6612 VGND.n563 VGND.t785 4.28621
R6613 VGND.t488 VGND.n562 4.28621
R6614 VGND.n562 VGND.t1350 4.28621
R6615 VGND.t1286 VGND.n561 4.28621
R6616 VGND.n561 VGND.t1266 4.28621
R6617 VGND.t1485 VGND.n549 4.28621
R6618 VGND.t1293 VGND.n551 4.28621
R6619 VGND.t1477 VGND.n554 4.28621
R6620 VGND.t613 VGND.n42 4.45053
R6621 VGND.t929 VGND.n42 4.0816
R6622 VGND.t1030 VGND.n627 4.28621
R6623 VGND.t539 VGND.n37 19.849
R6624 VGND.t822 VGND.n625 4.28621
R6625 VGND.t914 VGND.n625 4.28621
R6626 VGND.t357 VGND.n624 4.28621
R6627 VGND.t1055 VGND.n624 4.28621
R6628 VGND.t851 VGND.n623 4.28621
R6629 VGND.t953 VGND.n623 4.28621
R6630 VGND.n68 VGND.t356 19.8482
R6631 VGND.t1045 VGND.n620 4.28621
R6632 VGND.t1077 VGND.n619 4.28621
R6633 VGND.t439 VGND.n66 19.8482
R6634 VGND.n634 VGND.t922 4.28621
R6635 VGND.n636 VGND.t353 4.28621
R6636 VGND.n53 VGND.t753 4.2443
R6637 VGND.t156 VGND.n125 4.2443
R6638 VGND.t400 VGND.n56 4.24431
R6639 VGND.n52 VGND.t1402 4.24424
R6640 VGND.t215 VGND.n1031 4.28621
R6641 VGND.t1420 VGND.n61 4.0816
R6642 VGND.n61 VGND.t1076 4.45053
R6643 VGND.t1345 VGND.n1027 4.28621
R6644 VGND.n1027 VGND.t334 4.28621
R6645 VGND.t1340 VGND.n296 4.45052
R6646 VGND.n65 VGND.t1315 19.8482
R6647 VGND.n59 VGND.t1234 19.8491
R6648 VGND.t983 VGND.n57 19.849
R6649 VGND.n11 VGND.t1148 19.8492
R6650 VGND.n994 VGND.t468 4.28621
R6651 VGND.n992 VGND.t161 4.28621
R6652 VGND.t810 VGND.n971 4.28621
R6653 VGND.t1174 VGND.n969 4.28621
R6654 VGND.n39 VGND.t885 19.849
R6655 VGND.n184 VGND.t918 4.45052
R6656 VGND.t337 VGND.n10 4.45053
R6657 VGND.t164 VGND.n10 4.0816
R6658 VGND.n51 VGND.t1087 4.45053
R6659 VGND.t869 VGND.t674 4.28621
R6660 VGND.t1013 VGND.n959 4.28621
R6661 VGND.t86 VGND.t7 4.28621
R6662 VGND.t376 VGND.n641 4.28621
R6663 VGND.n642 VGND.t1245 4.28621
R6664 VGND.t150 VGND.n642 4.28621
R6665 VGND.n644 VGND.t423 4.28621
R6666 VGND.t1110 VGND.n645 4.28621
R6667 VGND.n647 VGND.t973 4.28621
R6668 VGND.t962 VGND.n922 4.28621
R6669 VGND.t1047 VGND.n298 4.45052
R6670 VGND.n299 VGND.t340 4.45052
R6671 VGND.n923 VGND.t1027 4.28621
R6672 VGND.t898 VGND.n919 4.28621
R6673 VGND.t523 VGND.n917 4.28621
R6674 VGND.t1153 VGND.n916 4.28621
R6675 VGND.n926 VGND.t268 4.28621
R6676 VGND.n927 VGND.t760 4.28621
R6677 VGND.t1471 VGND.n913 4.28621
R6678 VGND.n931 VGND.t1649 4.28621
R6679 VGND.n931 VGND.t151 4.28621
R6680 VGND.t40 VGND.n910 4.28621
R6681 VGND.t1031 VGND.n910 4.28621
R6682 VGND.n932 VGND.t1049 4.28621
R6683 VGND.n932 VGND.t108 4.28621
R6684 VGND.n123 VGND.t458 4.08161
R6685 VGND.n123 VGND.t346 4.45052
R6686 VGND.n933 VGND.t1123 4.28621
R6687 VGND.n935 VGND.t443 4.28621
R6688 VGND.t1165 VGND.n906 4.28621
R6689 VGND.n940 VGND.t852 4.28621
R6690 VGND.t1046 VGND.n940 4.28621
R6691 VGND.t515 VGND.n671 4.28621
R6692 VGND.t1170 VGND.n670 4.28621
R6693 VGND.t475 VGND.n670 4.28621
R6694 VGND.n672 VGND.t1120 4.28621
R6695 VGND.n672 VGND.t455 4.28621
R6696 VGND.t321 VGND.n669 4.28621
R6697 VGND.t906 VGND.n669 4.28621
R6698 VGND.t930 VGND.n668 4.28621
R6699 VGND.t1115 VGND.n684 4.28621
R6700 VGND.t1251 VGND.t282 4.28621
R6701 VGND.n693 VGND.t1091 4.28621
R6702 VGND.t1466 VGND.n693 4.28621
R6703 VGND.n694 VGND.t473 4.28621
R6704 VGND.t1405 VGND.n694 4.28621
R6705 VGND.t1155 VGND.n696 4.28621
R6706 VGND.n697 VGND.t264 4.28621
R6707 VGND.t125 VGND.n697 4.28621
R6708 VGND.n721 VGND.t1112 4.28621
R6709 VGND.n719 VGND.t625 4.28621
R6710 VGND.t154 VGND.n712 4.28621
R6711 VGND.n706 VGND.t25 4.28621
R6712 VGND.t438 VGND.n748 4.28621
R6713 VGND.n855 VGND.t436 4.28621
R6714 VGND.t765 VGND.n747 4.28621
R6715 VGND.n856 VGND.t764 4.28621
R6716 VGND.n745 VGND.t840 4.28621
R6717 VGND.n857 VGND.t839 4.28621
R6718 VGND.n857 VGND.t998 4.28621
R6719 VGND.t722 VGND.n744 4.28621
R6720 VGND.n744 VGND.t1006 4.28621
R6721 VGND.n858 VGND.t1062 4.28621
R6722 VGND.n859 VGND.t411 4.28621
R6723 VGND.n859 VGND.t512 4.28621
R6724 VGND.t925 VGND.n743 4.28621
R6725 VGND.t510 VGND.n743 4.28621
R6726 VGND.n860 VGND.t1413 4.28621
R6727 VGND.n860 VGND.t484 4.28621
R6728 VGND.t1078 VGND.n742 4.28621
R6729 VGND.t483 VGND.n742 4.28621
R6730 VGND.n861 VGND.t956 4.28621
R6731 VGND.n861 VGND.t679 4.28621
R6732 VGND.t426 VGND.n741 4.28621
R6733 VGND.t394 VGND.n741 4.28621
R6734 VGND.n862 VGND.t304 4.28621
R6735 VGND.n862 VGND.t393 4.28621
R6736 VGND.t249 VGND.n739 4.28621
R6737 VGND.t1146 VGND.n739 4.28621
R6738 VGND.n863 VGND.t1167 4.28621
R6739 VGND.n863 VGND.t682 4.28621
R6740 VGND.t1161 VGND.n738 4.28621
R6741 VGND.t845 VGND.n738 4.28621
R6742 VGND.t456 VGND.n736 4.28621
R6743 VGND.n865 VGND.t520 4.28621
R6744 VGND.n865 VGND.t936 4.28621
R6745 VGND.t177 VGND.n733 4.28621
R6746 VGND.n733 VGND.t931 4.28621
R6747 VGND.n885 VGND.t1235 4.28621
R6748 VGND.t637 VGND.t793 4.28621
R6749 VGND.t888 VGND.n871 4.28621
R6750 VGND.n872 VGND.t421 4.28621
R6751 VGND.t381 VGND.n872 4.28621
R6752 VGND.n873 VGND.t179 4.28621
R6753 VGND.t968 VGND.n873 4.28621
R6754 VGND.n874 VGND.t1415 4.28621
R6755 VGND.n878 VGND.t1108 4.28621
R6756 VGND.n879 VGND.t344 4.28621
R6757 VGND.t568 VGND.n834 4.28621
R6758 VGND.n840 VGND.t208 4.28621
R6759 VGND.t743 VGND.n840 4.28621
R6760 VGND.n842 VGND.t206 4.28621
R6761 VGND.n844 VGND.t746 4.28621
R6762 VGND.n800 VGND.t1201 4.28621
R6763 VGND.n802 VGND.t599 4.28621
R6764 VGND.n806 VGND.t1331 4.28621
R6765 VGND.n808 VGND.t67 4.28621
R6766 VGND.n809 VGND.t489 4.28621
R6767 VGND.t36 VGND.n815 4.28621
R6768 VGND.t34 VGND.n814 4.28621
R6769 VGND.t795 VGND.n813 4.28621
R6770 VGND.n819 VGND.t135 4.28621
R6771 VGND.n776 VGND.t1224 4.28621
R6772 VGND.n778 VGND.t97 4.28621
R6773 VGND.n780 VGND.t95 4.28621
R6774 VGND.t294 VGND.n785 4.28621
R6775 VGND.t415 VGND.n789 4.28621
R6776 VGND.n792 VGND.t802 4.28621
R6777 VGND.t93 VGND.n484 4.2505
R6778 VGND.n495 VGND.t45 2.42933
R6779 VGND.n488 VGND.n487 2.74088
R6780 VGND.n410 VGND.n414 0.0019303
R6781 VGND.n664 VGND.n413 3.34691
R6782 VGND.n329 VGND.n330 2.318
R6783 VGND.n510 VGND.n508 2.31803
R6784 VGND.n1040 VGND.t1611 3.30696
R6785 VGND.n774 VGND.n308 3.30696
R6786 VGND.t4 VGND.t190 2.88085
R6787 VGND.n952 VGND.n6 2.81035
R6788 VGND.n6 VGND.n658 2.72109
R6789 VGND.n181 VGND.n1066 2.72095
R6790 VGND.n511 VGND.n508 0.00174051
R6791 VGND.n616 VGND.n386 2.3179
R6792 VGND.n851 VGND.n730 2.17938
R6793 VGND.n1045 VGND.n512 2.17938
R6794 VGND.t1588 VGND.t335 1.99303
R6795 VGND.n384 VGND.t288 0.539038
R6796 VGND.n1041 VGND.n391 1.77971
R6797 VGND.n769 VGND.n484 1.51839
R6798 VGND.n416 VGND.n411 1.21473
R6799 VGND.t285 VGND.n507 0.086361
R6800 VGND.t1194 VGND.t69 1.26098
R6801 VGND.t373 VGND.t123 1.25576
R6802 VGND.t117 VGND.t440 1.22182
R6803 VGND.n382 VGND.n523 1.20456
R6804 VGND.n294 VGND.t1369 1.20427
R6805 VGND.n589 VGND.t256 1.19806
R6806 VGND.t16 VGND.t470 1.17831
R6807 VGND.n1060 VGND.t111 1.16752
R6808 VGND.t107 VGND.n618 1.15679
R6809 VGND.t157 VGND.t1 1.15677
R6810 VGND.t76 VGND.n7 0.467766
R6811 VGND.t52 VGND.t399 1.13587
R6812 VGND.t578 VGND.n757 1.13166
R6813 VGND.t41 VGND.t612 1.11902
R6814 VGND.t188 VGND.t414 1.11508
R6815 VGND.t1565 VGND.n948 1.112
R6816 VGND.t6 VGND.n663 1.11022
R6817 VGND.t596 VGND.t547 1.10794
R6818 VGND.n1040 VGND.t134 1.10767
R6819 VGND.t449 VGND.t201 1.10742
R6820 VGND.t329 VGND.t437 1.10631
R6821 VGND.t49 VGND.t503 1.10616
R6822 VGND.t165 VGND.t130 1.09999
R6823 VGND.n921 VGND.t145 1.09984
R6824 VGND.n339 VGND.t54 1.09593
R6825 VGND.t140 VGND.n766 1.0938
R6826 VGND.n751 VGND.t44 1.0936
R6827 VGND.t420 VGND.t117 1.09117
R6828 VGND.n392 VGND.t113 1.13216
R6829 VGND.t849 VGND.n390 0.0510031
R6830 VGND.t3 VGND.n735 1.08889
R6831 VGND.n587 VGND.n222 1.08178
R6832 VGND.t849 VGND.t212 1.07999
R6833 VGND.n526 VGND.t73 1.07984
R6834 VGND.n763 VGND.t558 1.07898
R6835 VGND.n509 VGND.t263 1.10109
R6836 VGND.t88 VGND.t876 1.07695
R6837 VGND.t33 VGND.n590 1.07523
R6838 VGND.t260 VGND.t1626 1.07339
R6839 VGND.n763 VGND.t310 1.07225
R6840 VGND.t621 VGND.t292 1.07084
R6841 VGND.t345 VGND.t229 1.06821
R6842 VGND.n869 VGND.t92 1.06714
R6843 VGND.t52 VGND.t610 1.06566
R6844 VGND.t96 VGND.n506 0.898734
R6845 VGND.n663 VGND.t191 1.06311
R6846 VGND.t102 VGND.n682 1.06243
R6847 VGND.n483 VGND.t345 0.0455783
R6848 VGND.t229 VGND.n869 1.05625
R6849 VGND.t73 VGND.t242 1.05521
R6850 VGND.t1094 VGND.t128 1.05469
R6851 VGND.n761 VGND.t194 1.05431
R6852 VGND.t105 VGND.n394 0.899521
R6853 VGND.n695 VGND.t480 1.05218
R6854 VGND.n760 VGND.t363 1.05177
R6855 VGND.n761 VGND.t325 1.05161
R6856 VGND.n660 VGND.t8 1.05108
R6857 VGND.t105 VGND.n7 1.30346
R6858 VGND.t147 VGND.n905 1.04717
R6859 VGND.n755 VGND.t23 1.04717
R6860 VGND.n667 VGND.t322 1.04507
R6861 VGND.t39 VGND.t184 1.04288
R6862 VGND.t547 VGND.t21 1.0427
R6863 VGND.t292 VGND.t596 1.04216
R6864 VGND.n331 VGND.t246 1.0914
R6865 VGND.n552 VGND.t28 1.04102
R6866 VGND.t242 VGND.t396 1.04081
R6867 VGND.n755 VGND.t116 1.04038
R6868 VGND.n740 VGND.t250 1.04025
R6869 VGND.n520 VGND.t288 1.03917
R6870 VGND.t1274 VGND.t435 1.03865
R6871 VGND.n760 VGND.t194 1.03738
R6872 VGND.n695 VGND.t126 1.03693
R6873 VGND.n749 VGND.t100 1.03582
R6874 VGND.t529 VGND.t987 1.03456
R6875 VGND.t428 VGND.n552 1.0335
R6876 VGND.t342 VGND.n951 1.033
R6877 VGND.n948 VGND.t143 1.03238
R6878 VGND.t971 VGND.t267 1.02956
R6879 VGND.t199 VGND.t269 1.02795
R6880 VGND.t184 VGND.t444 1.02736
R6881 VGND.n750 VGND.t100 1.02708
R6882 VGND.n691 VGND.t174 1.0265
R6883 VGND.t28 VGND.t1274 1.02583
R6884 VGND.n585 VGND.t246 1.02529
R6885 VGND.t12 VGND.t1156 1.0245
R6886 VGND.t723 VGND.t412 1.02369
R6887 VGND.n585 VGND.t240 1.02241
R6888 VGND.n762 VGND.t310 1.02231
R6889 VGND.n586 VGND.t244 1.0223
R6890 VGND.n665 VGND.t5 1.02211
R6891 VGND.n417 VGND.t39 1.09229
R6892 VGND.n520 VGND.t19 1.02159
R6893 VGND.n752 VGND.t197 1.02153
R6894 VGND.n951 VGND.t15 1.02139
R6895 VGND.n686 VGND.t133 1.02092
R6896 VGND.n660 VGND.t902 1.02081
R6897 VGND.t360 VGND.n64 0.865382
R6898 VGND.n382 VGND.n529 1.01767
R6899 VGND.n662 VGND.t6 1.01758
R6900 VGND.n526 VGND.t43 1.01674
R6901 VGND.n661 VGND.t8 1.01642
R6902 VGND.n762 VGND.t325 1.0155
R6903 VGND.n586 VGND.t240 1.01543
R6904 VGND.t501 VGND.t617 1.01448
R6905 VGND.t102 VGND.t866 1.0142
R6906 VGND.n590 VGND.t1272 1.01308
R6907 VGND.n751 VGND.t56 1.01254
R6908 VGND.n8 VGND.t162 0.375866
R6909 VGND.n773 VGND.t171 1.01202
R6910 VGND.n661 VGND.t10 1.01192
R6911 VGND.n750 VGND.t44 1.01162
R6912 VGND.n618 VGND.t201 1.01134
R6913 VGND.n626 VGND.t430 1.00726
R6914 VGND.t1599 VGND.t354 1.00563
R6915 VGND.n811 VGND.t59 1.00432
R6916 VGND.t492 VGND.t1203 1.00384
R6917 VGND.t693 VGND.t343 1.00344
R6918 VGND.t315 VGND.t155 1.00205
R6919 VGND.n754 VGND.t23 1.0016
R6920 VGND.t126 VGND.n691 0.995897
R6921 VGND.n909 VGND.t347 0.993115
R6922 VGND.n1060 VGND.t617 0.993047
R6923 VGND.n773 VGND.t90 0.991209
R6924 VGND.n589 VGND.t33 0.990011
R6925 VGND.t199 VGND.t147 0.985069
R6926 VGND.t587 VGND.n768 0.981466
R6927 VGND.t854 VGND.n905 0.978174
R6928 VGND.t540 VGND.t449 0.978066
R6929 VGND.t947 VGND.t1599 0.975724
R6930 VGND.n482 VGND.n868 0.97568
R6931 VGND.n754 VGND.t567 0.972676
R6932 VGND.t1632 VGND.n584 0.967938
R6933 VGND.t233 VGND.t16 0.959006
R6934 VGND.t399 VGND.t501 0.958225
R6935 VGND.n752 VGND.t56 0.94987
R6936 VGND.n656 VGND.t128 0.949193
R6937 VGND.n393 VGND.t947 0.798911
R6938 VGND.n387 VGND.n385 0.00181929
R6939 VGND.n757 VGND.t1194 0.944383
R6940 VGND.n8 VGND.t342 1.16755
R6941 VGND.n735 VGND.t250 0.942263
R6942 VGND.t876 VGND.t3 0.928655
R6943 VGND.t157 VGND.t754 0.928484
R6944 VGND.t866 VGND.t1529 0.921499
R6945 VGND.t478 VGND.n419 0.791069
R6946 VGND.t412 VGND.n740 0.914939
R6947 VGND.n667 VGND.t160 0.913954
R6948 VGND.t621 VGND.t1628 0.912833
R6949 VGND.n339 VGND.t248 0.90172
R6950 VGND.t437 VGND.t1521 0.898944
R6951 VGND.t329 VGND.t723 0.898325
R6952 VGND.n702 VGND.t155 0.898109
R6953 VGND.n682 VGND.t133 0.897353
R6954 VGND.t153 VGND.n665 0.896623
R6955 VGND.n181 VGND.n1050 0.8965
R6956 VGND.t111 VGND.t373 0.89565
R6957 VGND.t514 VGND.t165 0.890257
R6958 VGND.n753 VGND.n638 0.883473
R6959 VGND.n764 VGND.n294 0.882386
R6960 VGND.n382 VGND.n530 0.882167
R6961 VGND.n122 VGND.n907 0.882096
R6962 VGND.t140 VGND.n749 0.861859
R6963 VGND.n588 VGND.t492 0.858579
R6964 VGND.t10 VGND.t1058 0.851759
R6965 VGND.t902 VGND.n662 0.851666
R6966 VGND.t93 VGND.n511 0.630438
R6967 VGND.t354 VGND.n632 0.839538
R6968 VGND.t116 VGND.t172 0.839491
R6969 VGND.t527 VGND.t529 0.839235
R6970 VGND.n753 VGND.t567 0.832028
R6971 VGND.t1097 VGND.n921 0.831076
R6972 VGND.t78 VGND.n530 0.830265
R6973 VGND.t1058 VGND.n412 0.0655476
R6974 VGND.t444 VGND.n907 0.825103
R6975 VGND.n699 VGND.t478 0.822933
R6976 VGND.n387 VGND.n388 0.686021
R6977 VGND.n497 VGND.t136 0.927729
R6978 VGND.t699 VGND.t12 0.816657
R6979 VGND.t172 VGND.n638 0.812753
R6980 VGND.n753 VGND.t197 0.811537
R6981 VGND.t188 VGND.t269 0.810981
R6982 VGND.t130 VGND.n656 0.807002
R6983 VGND.n1090 VGND.t256 0.806568
R6984 VGND.n412 VGND.n411 0.674545
R6985 VGND.t335 VGND.n632 0.800794
R6986 VGND.n764 VGND.t558 0.799896
R6987 VGND.t41 VGND.n909 0.79841
R6988 VGND.t225 VGND.n388 0.867021
R6989 VGND.t119 VGND.t260 0.795886
R6990 VGND.t21 VGND.n1050 0.794333
R6991 VGND.n764 VGND.t503 0.79308
R6992 VGND.n497 VGND.t46 0.666903
R6993 VGND.t807 VGND.t49 0.788621
R6994 VGND.n632 VGND.t107 0.784679
R6995 VGND.t435 VGND.n530 0.78247
R6996 VGND.n221 VGND.n699 0.774926
R6997 VGND.n947 VGND.n413 0.774469
R6998 VGND.t347 VGND.n907 0.773922
R6999 VGND.t440 VGND.t693 0.763092
R7000 VGND.t35 VGND.n811 0.762137
R7001 VGND.n221 VGND.n686 0.757611
R7002 VGND.t143 VGND.n947 0.749468
R7003 VGND.n587 VGND.t536 0.748454
R7004 VGND.n699 VGND.t480 0.74806
R7005 VGND.t29 VGND.n766 0.745927
R7006 VGND.t481 VGND.n6 0.741804
R7007 VGND.t92 VGND.n868 0.739164
R7008 VGND.n868 VGND.t88 0.732505
R7009 VGND.t1628 VGND.n181 0.727814
R7010 VGND.n1040 VGND.t693 0.727517
R7011 VGND.n588 VGND.t646 0.716797
R7012 VGND.n947 VGND.t153 0.713278
R7013 VGND.t244 VGND.n587 0.712819
R7014 VGND.n523 VGND.t43 0.708347
R7015 VGND.t612 VGND.t414 0.705596
R7016 VGND.t1628 VGND.t123 0.70323
R7017 VGND.t614 VGND.n626 0.688868
R7018 VGND.t94 VGND.n768 0.687508
R7019 VGND.t396 VGND.n529 0.678467
R7020 VGND.t939 VGND.t134 0.672081
R7021 VGND.n523 VGND.t19 0.666199
R7022 VGND.n1091 VGND.n514 0.66578
R7023 VGND.n1105 VGND.n514 0.66578
R7024 VGND.n1039 VGND.n1037 0.66578
R7025 VGND.n1037 VGND.n617 0.66578
R7026 VGND.n946 VGND.n617 0.66578
R7027 VGND.n946 VGND.n945 0.66578
R7028 VGND.n945 VGND.n904 0.66578
R7029 VGND.n854 VGND.n846 0.66578
R7030 VGND.n846 VGND.n767 0.66578
R7031 VGND.n1089 VGND.n1048 0.66578
R7032 VGND.n1042 VGND.n615 0.66578
R7033 VGND.n950 VGND.n615 0.66578
R7034 VGND.n950 VGND.n949 0.66578
R7035 VGND.n949 VGND.n659 0.66578
R7036 VGND.n892 VGND.n659 0.66578
R7037 VGND.n886 VGND.n732 0.66578
R7038 VGND.n765 VGND.n732 0.66578
R7039 VGND.t578 VGND.t1369 0.665263
R7040 VGND.n482 VGND.n740 0.662625
R7041 VGND.n6 VGND.t165 0.66262
R7042 VGND.n181 VGND.n180 0.649813
R7043 VGND.n181 VGND.n178 0.649813
R7044 VGND.n181 VGND.n175 0.649813
R7045 VGND.n181 VGND.n128 0.649813
R7046 VGND.n181 VGND.n174 0.649813
R7047 VGND.n181 VGND.n173 0.649813
R7048 VGND.n181 VGND.n130 0.649813
R7049 VGND.n181 VGND.n132 0.649813
R7050 VGND.n181 VGND.n172 0.649813
R7051 VGND.n181 VGND.n133 0.649813
R7052 VGND.n181 VGND.n171 0.0311716
R7053 VGND.n181 VGND.n135 0.649813
R7054 VGND.n181 VGND.n137 0.649813
R7055 VGND.n181 VGND.n168 0.649813
R7056 VGND.n181 VGND.n141 0.649813
R7057 VGND.n181 VGND.n166 0.649813
R7058 VGND.n181 VGND.n164 0.649813
R7059 VGND.n181 VGND.n163 0.649813
R7060 VGND.n181 VGND.n143 0.649813
R7061 VGND.n181 VGND.n144 0.649813
R7062 VGND.n181 VGND.n160 0.649813
R7063 VGND.n181 VGND.n159 0.649813
R7064 VGND.n181 VGND.n146 0.649813
R7065 VGND.n181 VGND.n147 0.649813
R7066 VGND.n181 VGND.n148 0.649813
R7067 VGND.n181 VGND.n149 0.649813
R7068 VGND.n181 VGND.n158 0.649813
R7069 VGND.n181 VGND.n150 0.649813
R7070 VGND.n181 VGND.n157 0.649813
R7071 VGND.n181 VGND.n153 0.649813
R7072 VGND.n181 VGND.n155 0.0311729
R7073 VGND.n382 VGND.n332 0.649813
R7074 VGND.n382 VGND.n335 0.649813
R7075 VGND.n382 VGND.n334 0.649813
R7076 VGND.n382 VGND.n374 0.649813
R7077 VGND.n382 VGND.n376 0.649813
R7078 VGND.n382 VGND.n377 0.649813
R7079 VGND.n382 VGND.n378 0.649813
R7080 VGND.n382 VGND.n379 0.649813
R7081 VGND.n382 VGND.n380 0.649813
R7082 VGND.n382 VGND.n357 0.649813
R7083 VGND.n382 VGND.n358 0.649813
R7084 VGND.n382 VGND.n359 0.649813
R7085 VGND.n382 VGND.n361 0.649813
R7086 VGND.n382 VGND.n362 0.649813
R7087 VGND.n382 VGND.n363 0.649813
R7088 VGND.n382 VGND.n364 0.649813
R7089 VGND.n382 VGND.n365 0.649813
R7090 VGND.n382 VGND.n366 0.649813
R7091 VGND.n382 VGND.n370 0.649813
R7092 VGND.n382 VGND.n349 0.649813
R7093 VGND.n382 VGND.n348 0.649813
R7094 VGND.n382 VGND.n347 0.649813
R7095 VGND.n382 VGND.n346 0.649813
R7096 VGND.n382 VGND.n344 0.649813
R7097 VGND.n382 VGND.n343 0.649813
R7098 VGND.n382 VGND.n342 0.649813
R7099 VGND.n382 VGND.n341 0.649813
R7100 VGND.t335 VGND.n12 0.0311702
R7101 VGND.t335 VGND.n13 0.649813
R7102 VGND.t335 VGND.n14 0.649813
R7103 VGND.t335 VGND.n26 0.649813
R7104 VGND.t335 VGND.n24 0.649813
R7105 VGND.t335 VGND.n21 0.649813
R7106 VGND.t335 VGND.n19 0.649813
R7107 VGND.t335 VGND.n15 0.649813
R7108 VGND.t335 VGND.n16 0.649813
R7109 VGND.t335 VGND.n18 0.649813
R7110 VGND.t335 VGND.n17 0.649813
R7111 VGND.n1026 VGND.t335 0.649813
R7112 VGND.n1028 VGND.t335 0.649813
R7113 VGND.n1029 VGND.t335 0.649813
R7114 VGND.n1030 VGND.t335 0.649813
R7115 VGND.n1032 VGND.t335 0.649813
R7116 VGND.t1177 VGND.n54 20.6078
R7117 VGND.t335 VGND.n35 0.649813
R7118 VGND.t335 VGND.n34 0.649813
R7119 VGND.t335 VGND.n33 0.649813
R7120 VGND.t335 VGND.n32 0.649813
R7121 VGND.t335 VGND.n31 0.649813
R7122 VGND.t335 VGND.n30 0.649813
R7123 VGND.t335 VGND.n29 0.649813
R7124 VGND.t335 VGND.n27 0.649813
R7125 VGND.n1003 VGND.n6 0.649813
R7126 VGND.n1004 VGND.n6 0.649813
R7127 VGND.n1005 VGND.n6 0.649813
R7128 VGND.n1007 VGND.n6 0.649813
R7129 VGND.n1008 VGND.n6 0.649813
R7130 VGND.n1010 VGND.n6 0.649813
R7131 VGND.n984 VGND.n6 0.649813
R7132 VGND.n985 VGND.n6 0.649813
R7133 VGND.n987 VGND.n6 0.649813
R7134 VGND.n990 VGND.n6 0.649813
R7135 VGND.n991 VGND.n6 0.649813
R7136 VGND.n993 VGND.n6 0.649813
R7137 VGND.n995 VGND.n6 0.649813
R7138 VGND.n6 VGND.n1 0.649813
R7139 VGND.n6 VGND.n5 0.649813
R7140 VGND.n6 VGND.n4 0.649813
R7141 VGND.n6 VGND.n3 0.649813
R7142 VGND.n6 VGND.n2 0.649813
R7143 VGND.n966 VGND.n6 0.649813
R7144 VGND.n967 VGND.n6 0.649813
R7145 VGND.n970 VGND.n6 0.649813
R7146 VGND.n976 VGND.n6 0.649813
R7147 VGND.n977 VGND.n6 0.649813
R7148 VGND.n411 VGND.n398 0.649813
R7149 VGND.n411 VGND.n399 0.649813
R7150 VGND.n411 VGND.n400 0.649813
R7151 VGND.n411 VGND.n402 0.649813
R7152 VGND.n411 VGND.n404 0.649813
R7153 VGND.n411 VGND.n405 0.649813
R7154 VGND.n411 VGND.n406 0.649813
R7155 VGND.n411 VGND.n407 0.649813
R7156 VGND.n411 VGND.n409 0.649813
R7157 VGND.n122 VGND.n121 0.649813
R7158 VGND.n122 VGND.n69 0.649813
R7159 VGND.n122 VGND.n71 0.649813
R7160 VGND.n122 VGND.n106 0.649813
R7161 VGND.n122 VGND.n73 0.649813
R7162 VGND.n122 VGND.n104 0.649813
R7163 VGND.n122 VGND.n75 0.649813
R7164 VGND.n122 VGND.n76 0.649813
R7165 VGND.n122 VGND.n77 0.649813
R7166 VGND.n122 VGND.n102 0.649813
R7167 VGND.n122 VGND.n100 0.649813
R7168 VGND.n122 VGND.n99 0.649813
R7169 VGND.n122 VGND.n97 0.649813
R7170 VGND.n122 VGND.n96 0.649813
R7171 VGND.n122 VGND.n82 0.649813
R7172 VGND.n122 VGND.n83 0.649813
R7173 VGND.n122 VGND.n94 0.649813
R7174 VGND.n122 VGND.n91 0.649813
R7175 VGND.n122 VGND.n90 0.649813
R7176 VGND.n122 VGND.n86 0.649813
R7177 VGND.n122 VGND.n87 0.649813
R7178 VGND.n122 VGND.n88 0.649813
R7179 VGND.n122 VGND.n119 0.0258182
R7180 VGND.n122 VGND.n118 0.649813
R7181 VGND.n122 VGND.n117 0.649813
R7182 VGND.n122 VGND.n116 0.649813
R7183 VGND.n122 VGND.n115 0.649813
R7184 VGND.n122 VGND.n111 0.649813
R7185 VGND.n122 VGND.n110 0.649813
R7186 VGND.n122 VGND.n109 0.649813
R7187 VGND.n221 VGND.n194 0.649813
R7188 VGND.n221 VGND.n193 0.649813
R7189 VGND.n221 VGND.n190 0.649813
R7190 VGND.n221 VGND.n186 0.649813
R7191 VGND.n221 VGND.n189 0.649813
R7192 VGND.n221 VGND.n187 0.649813
R7193 VGND.n221 VGND.n198 0.649813
R7194 VGND.n221 VGND.n197 0.649813
R7195 VGND.n221 VGND.n196 0.649813
R7196 VGND.n221 VGND.n195 0.649813
R7197 VGND.n221 VGND.n214 0.649813
R7198 VGND.n221 VGND.n212 0.649813
R7199 VGND.n221 VGND.n210 0.649813
R7200 VGND.n221 VGND.n209 0.649813
R7201 VGND.n221 VGND.n208 0.649813
R7202 VGND.n221 VGND.n203 0.649813
R7203 VGND.n221 VGND.n202 0.649813
R7204 VGND.n221 VGND.n199 0.649813
R7205 VGND.n705 VGND.n218 0.649813
R7206 VGND.n710 VGND.n218 0.649813
R7207 VGND.n715 VGND.n218 0.649813
R7208 VGND.n718 VGND.n218 0.649813
R7209 VGND.n720 VGND.n218 0.649813
R7210 VGND.n221 VGND.n217 0.649813
R7211 VGND.n221 VGND.n216 0.649813
R7212 VGND.n482 VGND.n463 0.649813
R7213 VGND.n482 VGND.n462 0.649813
R7214 VGND.n482 VGND.n422 0.649813
R7215 VGND.n482 VGND.n424 0.649813
R7216 VGND.n482 VGND.n461 0.649813
R7217 VGND.n482 VGND.n459 0.649813
R7218 VGND.n482 VGND.n427 0.649813
R7219 VGND.n482 VGND.n457 0.649813
R7220 VGND.n482 VGND.n428 0.649813
R7221 VGND.n482 VGND.n456 0.649813
R7222 VGND.n482 VGND.n429 0.649813
R7223 VGND.n482 VGND.n455 0.649813
R7224 VGND.n482 VGND.n430 0.649813
R7225 VGND.n482 VGND.n454 0.649813
R7226 VGND.n482 VGND.n431 0.649813
R7227 VGND.n482 VGND.n453 0.649813
R7228 VGND.n482 VGND.n433 0.649813
R7229 VGND.n482 VGND.n435 0.649813
R7230 VGND.n482 VGND.n452 0.649813
R7231 VGND.n482 VGND.n437 0.649813
R7232 VGND.n482 VGND.n451 0.649813
R7233 VGND.n482 VGND.n438 0.649813
R7234 VGND.n482 VGND.n450 0.649813
R7235 VGND.n482 VGND.n444 0.649813
R7236 VGND.n482 VGND.n443 0.649813
R7237 VGND.n482 VGND.n442 0.649813
R7238 VGND.n482 VGND.n480 0.649813
R7239 VGND.n482 VGND.n479 0.649813
R7240 VGND.n482 VGND.n478 0.649813
R7241 VGND.n482 VGND.n477 0.649813
R7242 VGND.n482 VGND.n475 0.649813
R7243 VGND.n482 VGND.n472 0.649813
R7244 VGND.n482 VGND.n471 0.649813
R7245 VGND.n482 VGND.n470 0.649813
R7246 VGND.n482 VGND.n468 0.649813
R7247 VGND.n482 VGND.n467 0.649813
R7248 VGND.n482 VGND.n465 0.649813
R7249 VGND.n841 VGND.n484 0.649813
R7250 VGND.n839 VGND.n484 0.649813
R7251 VGND.n838 VGND.n484 0.649813
R7252 VGND.n836 VGND.n484 0.649813
R7253 VGND.n832 VGND.n484 0.649813
R7254 VGND.n831 VGND.n484 0.649813
R7255 VGND.n828 VGND.n484 0.649813
R7256 VGND.n827 VGND.n484 0.649813
R7257 VGND.n496 VGND.n494 0.649813
R7258 VGND.n787 VGND.n308 0.649813
R7259 VGND.n784 VGND.n308 0.649813
R7260 VGND.n783 VGND.n308 0.649813
R7261 VGND.n779 VGND.n312 0.649813
R7262 VGND.n777 VGND.n504 0.649813
R7263 VGND.n816 VGND.n498 0.649813
R7264 VGND.n489 VGND.n499 0.649813
R7265 VGND.n496 VGND.n490 0.649813
R7266 VGND.n496 VGND.n491 0.649813
R7267 VGND.n496 VGND.n492 0.649813
R7268 VGND.n790 VGND.n308 0.649813
R7269 VGND.n309 VGND.n307 0.649813
R7270 VGND.n309 VGND.n304 0.649813
R7271 VGND.n309 VGND.n305 0.649813
R7272 VGND.n807 VGND.n308 0.649813
R7273 VGND.n801 VGND.n308 0.649813
R7274 VGND.n309 VGND.n302 0.649813
R7275 VGND.n309 VGND.n301 0.649813
R7276 VGND.t363 VGND.t1369 0.640441
R7277 VGND.t174 VGND.n686 0.635507
R7278 VGND.t285 VGND.t59 0.632665
R7279 VGND.n393 VGND.t754 0.060144
R7280 VGND.t172 VGND.t37 0.629306
R7281 VGND.t26 VGND.n702 0.626785
R7282 VGND.n382 VGND.n340 0.62663
R7283 VGND.t335 VGND.n36 0.62663
R7284 VGND.n980 VGND.n6 0.62663
R7285 VGND.n6 VGND.n0 0.62663
R7286 VGND.n411 VGND.n396 0.62663
R7287 VGND.n122 VGND.n120 0.62663
R7288 VGND.n221 VGND.n220 0.62663
R7289 VGND.n221 VGND.n219 0.62663
R7290 VGND.n482 VGND.n481 0.62663
R7291 VGND.n796 VGND.n308 0.62663
R7292 VGND.n584 VGND.n328 0.624584
R7293 VGND.n769 VGND.t207 0.614606
R7294 VGND.n768 VGND.n511 0.613132
R7295 VGND.t191 VGND.n416 0.697213
R7296 VGND.t335 VGND.n626 0.611904
R7297 VGND.n8 VGND.n6 0.23938
R7298 VGND.t66 VGND.n507 0.47917
R7299 VGND.n122 VGND.t612 0.58278
R7300 VGND.n218 VGND.n702 0.581415
R7301 VGND.n769 VGND.t263 0.568245
R7302 VGND.t352 VGND.n584 0.566668
R7303 VGND.t64 VGND.n1050 0.566084
R7304 VGND VGND.n1109 0.56194
R7305 VGND.n245 VGND.n588 0.560421
R7306 VGND.t343 VGND.t134 0.559738
R7307 VGND.n221 VGND.n691 0.55369
R7308 VGND.n482 VGND.t437 0.553257
R7309 VGND.n245 VGND.n1090 0.552431
R7310 VGND.n122 VGND.n905 0.552291
R7311 VGND.n181 VGND.n1060 0.552237
R7312 VGND.n6 VGND.n656 0.552223
R7313 VGND.t335 VGND.t449 0.552149
R7314 VGND.n122 VGND.n909 0.528193
R7315 VGND.n1039 VGND.n1038 0.52498
R7316 VGND.n1044 VGND.n1042 0.52498
R7317 VGND.t335 VGND.t1599 0.519652
R7318 VGND.n221 VGND.t866 0.518046
R7319 VGND.n122 VGND.t188 0.517988
R7320 VGND.t78 VGND.n529 0.516131
R7321 VGND.n181 VGND.t260 0.51105
R7322 VGND.n64 VGND.t1094 0.0518073
R7323 VGND.t90 VGND.n506 1.1002
R7324 VGND.n951 VGND.n6 0.506376
R7325 VGND.n122 VGND.n417 0.401472
R7326 VGND.n750 VGND.n638 0.506033
R7327 VGND.n382 VGND.n520 0.506009
R7328 VGND.n661 VGND.n411 0.505897
R7329 VGND.n773 VGND.n308 0.505788
R7330 VGND.n382 VGND.t1274 0.505434
R7331 VGND.n586 VGND.n222 0.505314
R7332 VGND.n762 VGND.n294 0.505257
R7333 VGND.n585 VGND.n222 0.505088
R7334 VGND.n245 VGND.n589 0.505057
R7335 VGND.n181 VGND.t501 0.504876
R7336 VGND.n482 VGND.t723 0.504812
R7337 VGND.t54 VGND.n384 0.382266
R7338 VGND.n391 VGND.n389 0.00161878
R7339 VGND.n665 VGND.n413 0.484322
R7340 VGND.n662 VGND.n411 0.484012
R7341 VGND.n419 VGND.t315 0.0452203
R7342 VGND.n1040 VGND.t12 0.475798
R7343 VGND.t113 VGND.n1041 0.46853
R7344 VGND.n749 VGND.n638 0.46803
R7345 VGND.n122 VGND.t199 0.466005
R7346 VGND.n755 VGND.n638 0.463644
R7347 VGND.n382 VGND.t242 0.463271
R7348 VGND.n382 VGND.n552 0.46315
R7349 VGND.n482 VGND.n869 0.463128
R7350 VGND.n660 VGND.n411 0.463064
R7351 VGND.n509 VGND.n484 0.39261
R7352 VGND.n331 VGND.n222 0.392306
R7353 VGND.t876 VGND.n482 0.462374
R7354 VGND.n761 VGND.n294 0.462141
R7355 VGND.n122 VGND.t184 0.462089
R7356 VGND.n386 VGND.n390 0.391377
R7357 VGND.n181 VGND.t547 0.461845
R7358 VGND.n754 VGND.n638 0.459998
R7359 VGND.n752 VGND.n638 0.455705
R7360 VGND.n221 VGND.n695 0.444409
R7361 VGND.n760 VGND.n294 0.443871
R7362 VGND.n309 VGND.n811 0.438021
R7363 VGND.n482 VGND.n735 0.436986
R7364 VGND.n245 VGND.n244 0.433401
R7365 VGND.n245 VGND.n243 0.433401
R7366 VGND.n245 VGND.n228 0.0160305
R7367 VGND.n245 VGND.n241 0.433401
R7368 VGND.n245 VGND.n231 0.433401
R7369 VGND.n245 VGND.n233 0.433401
R7370 VGND.n245 VGND.n235 0.433401
R7371 VGND.n608 VGND.n222 0.433401
R7372 VGND.n595 VGND.n222 0.433401
R7373 VGND.n329 VGND.n327 0.433401
R7374 VGND.n1094 VGND.n328 0.433401
R7375 VGND.n482 VGND.n483 0.362507
R7376 VGND.n221 VGND.n682 0.424144
R7377 VGND.n763 VGND.n294 0.423505
R7378 VGND.n181 VGND.t373 0.423234
R7379 VGND.n181 VGND.t52 0.423167
R7380 VGND.n904 VGND.n666 0.4229
R7381 VGND.n892 VGND.n891 0.4229
R7382 VGND.t233 VGND.n616 0.419149
R7383 VGND.t267 VGND.n658 0.416158
R7384 VGND.n294 VGND.t69 0.408385
R7385 VGND.n948 VGND.n413 0.406745
R7386 VGND.n245 VGND.n590 0.406449
R7387 VGND.n751 VGND.n638 0.402837
R7388 VGND.n394 VGND.t971 0.0430075
R7389 VGND.n122 VGND.n921 0.393523
R7390 VGND.n294 VGND.n247 0.389775
R7391 VGND.n294 VGND.n290 0.389775
R7392 VGND.n319 VGND.t563 718.571
R7393 VGND.n294 VGND.n284 0.389775
R7394 VGND.n322 VGND.t387 718.571
R7395 VGND.n294 VGND.n280 0.389775
R7396 VGND.n294 VGND.n260 0.389775
R7397 VGND.n294 VGND.n277 0.389775
R7398 VGND.n294 VGND.n264 0.389775
R7399 VGND.n294 VGND.n267 0.389775
R7400 VGND.n294 VGND.n269 0.389775
R7401 VGND.n663 VGND.n411 0.389015
R7402 VGND.n181 VGND.t292 0.387943
R7403 VGND.n1040 VGND.t117 0.38776
R7404 VGND.t1588 VGND.t430 0.386887
R7405 VGND.n658 VGND.t514 0.385285
R7406 VGND.n221 VGND.n667 0.374848
R7407 VGND.n392 VGND.n391 0.319287
R7408 VGND.n482 VGND.t529 0.373771
R7409 VGND.n7 VGND.n6 0.1668
R7410 VGND.n1066 VGND.t610 0.36561
R7411 VGND.n294 VGND.n757 0.355801
R7412 VGND.n766 VGND.n638 0.351447
R7413 VGND.n382 VGND.n339 0.344629
R7414 VGND.n382 VGND.n526 0.344541
R7415 VGND.t335 VGND.n618 0.338974
R7416 VGND.t1378 VGND.n330 0.419637
R7417 VGND.n774 VGND.t66 0.330603
R7418 VGND.n386 VGND.t16 0.329481
R7419 VGND.t1503 VGND.n510 0.419863
R7420 VGND.t540 VGND.t1588 0.321339
R7421 VGND.n294 VGND.t49 0.316253
R7422 VGND.t420 VGND.t1611 0.308518
R7423 VGND.t171 VGND.n774 0.303518
R7424 VGND.n389 VGND.t11 0.185547
R7425 VGND.n1066 VGND.t1626 0.295798
R7426 VGND.t1204 VGND.t46 0.283644
R7427 VGND.n488 VGND.t1204 0.0914569
R7428 VGND.t15 VGND.n952 0.260683
R7429 VGND.t4 VGND.n410 0.237046
R7430 VGND.t5 VGND.n664 0.252995
R7431 VGND.t1 VGND.t335 0.248929
R7432 VGND.t4 VGND.n413 0.246877
R7433 VGND.n616 VGND.t212 0.229511
R7434 VGND.t508 VGND.t1564 0.227075
R7435 VGND.t1510 VGND.t670 0.227075
R7436 VGND.t1505 VGND.t747 0.226736
R7437 VGND.t1513 VGND.t1225 0.226736
R7438 VGND.n505 VGND.t96 0.312561
R7439 VGND.n486 VGND.t1505 0.0863258
R7440 VGND.n503 VGND.t1513 0.0863258
R7441 VGND.n500 VGND.t1510 0.0861948
R7442 VGND.t214 VGND.n1041 0.215636
R7443 VGND.n385 VGND.t11 0.170853
R7444 VGND.t1564 VGND.n415 0.0818513
R7445 VGND.t1611 VGND.t1156 0.177814
R7446 VGND.t1546 VGND.t145 0.117444
R7447 VGND.n854 VGND.n853 0.11666
R7448 VGND.n887 VGND.n886 0.11666
R7449 VGND.t1203 VGND.n1090 0.105341
R7450 VGND.t987 VGND.n746 0.102125
R7451 VGND.t1072 VGND.n664 0.0927014
R7452 VGND.t22 VGND.n638 0.0890416
R7453 VGND.t536 VGND.t1272 0.08675
R7454 VGND.t1225 VGND.t98 0.0855
R7455 VGND.t1227 VGND.t670 0.0855
R7456 VGND.t984 VGND.n952 0.0745297
R7457 VGND.t854 VGND.t1546 0.0679719
R7458 VGND.t1529 VGND.t1528 0.048
R7459 VGND.t1521 VGND.n746 0.0471245
R7460 VGND.n1108 VGND.n1107 0.0436411
R7461 VGND.n852 VGND.n848 0.0436411
R7462 VGND.n1107 VGND.n513 0.0436411
R7463 VGND.n1043 VGND.n614 0.0436411
R7464 VGND.n890 VGND.n889 0.0436411
R7465 VGND.n889 VGND.n888 0.0436411
R7466 VGND.n849 VGND.n666 0.04274
R7467 VGND.n1047 VGND.n612 0.04274
R7468 VGND.t1528 VGND.t322 0.03925
R7469 VGND.n181 VGND.n179 0.0258175
R7470 VGND.n181 VGND.n126 0.0258175
R7471 VGND.n181 VGND.n177 0.0258175
R7472 VGND.n181 VGND.n127 0.0258175
R7473 VGND.n181 VGND.n176 0.0258175
R7474 VGND.n181 VGND.n129 0.0258175
R7475 VGND.n181 VGND.n134 0.0258175
R7476 VGND.n181 VGND.n136 0.0258175
R7477 VGND.n181 VGND.n169 0.0258175
R7478 VGND.n181 VGND.n139 0.0258175
R7479 VGND.n181 VGND.n140 0.0258175
R7480 VGND.n181 VGND.n167 0.0258175
R7481 VGND.n181 VGND.n142 0.0258175
R7482 VGND.n181 VGND.n165 0.0258175
R7483 VGND.n181 VGND.n162 0.0258175
R7484 VGND.n181 VGND.n145 0.0258175
R7485 VGND.n181 VGND.n161 0.0258175
R7486 VGND.n181 VGND.n151 0.0258175
R7487 VGND.n181 VGND.n156 0.0258175
R7488 VGND.n181 VGND.n152 0.0258175
R7489 VGND.n181 VGND.n154 0.0258175
R7490 VGND.n382 VGND.n381 0.0258175
R7491 VGND.n382 VGND.n338 0.0258175
R7492 VGND.n382 VGND.n333 0.0258175
R7493 VGND.n382 VGND.n337 0.0258175
R7494 VGND.n382 VGND.n336 0.0258175
R7495 VGND.n382 VGND.n371 0.0258175
R7496 VGND.n382 VGND.n372 0.0258175
R7497 VGND.n382 VGND.n373 0.0258175
R7498 VGND.n382 VGND.n353 0.0258175
R7499 VGND.n382 VGND.n355 0.0258175
R7500 VGND.n382 VGND.n356 0.0258175
R7501 VGND.n382 VGND.n367 0.0258175
R7502 VGND.n382 VGND.n368 0.0258175
R7503 VGND.n382 VGND.n369 0.0258175
R7504 VGND.n382 VGND.n351 0.0258175
R7505 VGND.n382 VGND.n350 0.0258175
R7506 VGND.n382 VGND.n345 0.0258175
R7507 VGND.t335 VGND.n25 0.0258175
R7508 VGND.t335 VGND.n23 0.0258175
R7509 VGND.t335 VGND.n22 0.0258175
R7510 VGND.t335 VGND.n20 0.0258175
R7511 VGND.t335 VGND.n28 0.0258175
R7512 VGND.n411 VGND.n397 0.0258175
R7513 VGND.n411 VGND.n401 0.0258175
R7514 VGND.n411 VGND.n408 0.0258175
R7515 VGND.n122 VGND.n70 0.0258175
R7516 VGND.n122 VGND.n72 0.0258175
R7517 VGND.n122 VGND.n74 0.0258175
R7518 VGND.n122 VGND.n105 0.0258175
R7519 VGND.n122 VGND.n103 0.0258175
R7520 VGND.n122 VGND.n78 0.0258175
R7521 VGND.n122 VGND.n79 0.0258175
R7522 VGND.n122 VGND.n101 0.0258175
R7523 VGND.n122 VGND.n80 0.0258175
R7524 VGND.n122 VGND.n98 0.0258175
R7525 VGND.n122 VGND.n81 0.0258175
R7526 VGND.n122 VGND.n84 0.0258175
R7527 VGND.n122 VGND.n93 0.0258175
R7528 VGND.n122 VGND.n85 0.0258175
R7529 VGND.n122 VGND.n92 0.0258175
R7530 VGND.n122 VGND.n89 0.0258175
R7531 VGND.n122 VGND.n114 0.0258175
R7532 VGND.n122 VGND.n113 0.0258175
R7533 VGND.n122 VGND.n112 0.0258175
R7534 VGND.n122 VGND.n108 0.0258175
R7535 VGND.n122 VGND.n107 0.0258175
R7536 VGND.n221 VGND.n185 0.0258175
R7537 VGND.n221 VGND.n192 0.0258175
R7538 VGND.n221 VGND.n191 0.0258175
R7539 VGND.n221 VGND.n188 0.0258175
R7540 VGND.n221 VGND.n215 0.0136587
R7541 VGND.n221 VGND.n213 0.0258175
R7542 VGND.n221 VGND.n211 0.0258175
R7543 VGND.n221 VGND.n207 0.0258175
R7544 VGND.n221 VGND.n206 0.0258175
R7545 VGND.n221 VGND.n205 0.0258175
R7546 VGND.n221 VGND.n200 0.0258175
R7547 VGND.n218 VGND.n418 0.0258175
R7548 VGND.n711 VGND.n218 0.0258175
R7549 VGND.n713 VGND.n218 0.0258175
R7550 VGND.n717 VGND.n218 0.0258175
R7551 VGND.n722 VGND.n218 0.0258175
R7552 VGND.n724 VGND.n218 0.0258175
R7553 VGND.n482 VGND.n464 0.0258175
R7554 VGND.n482 VGND.n423 0.0258175
R7555 VGND.n482 VGND.n425 0.0258175
R7556 VGND.n482 VGND.n460 0.0258175
R7557 VGND.n482 VGND.n426 0.0258175
R7558 VGND.n482 VGND.n458 0.0258175
R7559 VGND.n482 VGND.n432 0.0258175
R7560 VGND.n482 VGND.n434 0.0258175
R7561 VGND.n482 VGND.n436 0.0258175
R7562 VGND.n482 VGND.n449 0.0258175
R7563 VGND.n482 VGND.n448 0.0258175
R7564 VGND.n482 VGND.n439 0.0258175
R7565 VGND.n482 VGND.n446 0.0258175
R7566 VGND.n482 VGND.n440 0.0258175
R7567 VGND.n482 VGND.n445 0.0258175
R7568 VGND.n482 VGND.n441 0.0258175
R7569 VGND.n482 VGND.n476 0.0258175
R7570 VGND.n482 VGND.n474 0.0258175
R7571 VGND.n482 VGND.n473 0.0258175
R7572 VGND.n482 VGND.n469 0.0258175
R7573 VGND.n482 VGND.n466 0.0258175
R7574 VGND.n845 VGND.n487 0.0258175
R7575 VGND.n843 VGND.n485 0.0258175
R7576 VGND.n775 VGND.n501 0.0258175
R7577 VGND.n496 VGND.n493 0.0258175
R7578 VGND.n788 VGND.n308 0.0258175
R7579 VGND.n309 VGND.n306 0.0258175
R7580 VGND.n805 VGND.n308 0.0258175
R7581 VGND.n309 VGND.n303 0.0258175
R7582 VGND.n309 VGND.n300 0.0258175
R7583 VGND.n1038 VGND.n513 0.0220706
R7584 VGND.n1108 VGND.n1106 0.0220706
R7585 VGND.n849 VGND.n848 0.0220706
R7586 VGND.n853 VGND.n852 0.0220706
R7587 VGND.n891 VGND.n890 0.0220706
R7588 VGND.n888 VGND.n887 0.0220706
R7589 VGND.n614 VGND.n612 0.0220706
R7590 VGND.n1044 VGND.n1043 0.0220706
R7591 VGND.n731 VGND.n730 0.02162
R7592 VGND.n1109 VGND.n512 0.02162
R7593 VGND.n1091 VGND 0.01986
R7594 VGND.n1106 VGND.n1105 0.01458
R7595 VGND.n1048 VGND.n1047 0.01458
R7596 VGND.n245 VGND.n226 0.0120181
R7597 VGND.n245 VGND.n242 0.0120181
R7598 VGND.n245 VGND.n227 0.0120181
R7599 VGND.n245 VGND.n229 0.0120181
R7600 VGND.n245 VGND.n239 0.0120181
R7601 VGND.n245 VGND.n230 0.0120181
R7602 VGND.n325 VGND.t1128 644.312
R7603 VGND.n245 VGND.n238 0.0120181
R7604 VGND.n245 VGND.n236 0.0120181
R7605 VGND.n610 VGND.n222 0.0120181
R7606 VGND.n609 VGND.n222 0.0120181
R7607 VGND.n607 VGND.n222 0.0120181
R7608 VGND.n606 VGND.n222 0.0120181
R7609 VGND.n605 VGND.n222 0.0120181
R7610 VGND.n604 VGND.n222 0.0120181
R7611 VGND.n603 VGND.n222 0.0120181
R7612 VGND.n602 VGND.n222 0.0120181
R7613 VGND.n601 VGND.n222 0.0120181
R7614 VGND.n599 VGND.n222 0.0120181
R7615 VGND.n598 VGND.n222 0.0120181
R7616 VGND.n597 VGND.n222 0.0120181
R7617 VGND.n593 VGND.n222 0.0120181
R7618 VGND.n592 VGND.n222 0.0120181
R7619 VGND.n591 VGND.n222 0.0120181
R7620 VGND.n1093 VGND.n328 0.0120181
R7621 VGND.n1095 VGND.n328 0.0120181
R7622 VGND.n1096 VGND.n328 0.0120181
R7623 VGND.n1097 VGND.n328 0.0120181
R7624 VGND.n1098 VGND.n328 0.0120181
R7625 VGND.n1099 VGND.n328 0.0120181
R7626 VGND.n851 VGND.n850 0.0115476
R7627 VGND.n850 VGND.n847 0.0115476
R7628 VGND.n1046 VGND.n613 0.0115476
R7629 VGND.n1046 VGND.n1045 0.0115476
R7630 VGND.n294 VGND.n292 0.00990704
R7631 VGND.n294 VGND.n248 0.00990704
R7632 VGND.n294 VGND.n291 0.00990704
R7633 VGND.n294 VGND.n251 0.00990704
R7634 VGND.n294 VGND.n289 0.00990704
R7635 VGND.n294 VGND.n252 0.00130404
R7636 VGND.n294 VGND.n288 0.00990704
R7637 VGND.n294 VGND.n253 0.00990704
R7638 VGND.n294 VGND.n287 0.00990704
R7639 VGND.n294 VGND.n254 0.00990704
R7640 VGND.n294 VGND.n285 0.00990704
R7641 VGND.n294 VGND.n255 0.00990704
R7642 VGND.n294 VGND.n283 0.00990704
R7643 VGND.n294 VGND.n256 0.00990704
R7644 VGND.n294 VGND.n282 0.00130404
R7645 VGND.n294 VGND.n281 0.00130409
R7646 VGND.n294 VGND.n259 0.00990704
R7647 VGND.n294 VGND.n261 0.00130409
R7648 VGND.n294 VGND.n278 0.00990704
R7649 VGND.n294 VGND.n263 0.00990704
R7650 VGND.n294 VGND.n275 0.00990704
R7651 VGND.n294 VGND.n265 0.00990704
R7652 VGND.n294 VGND.n274 0.00990704
R7653 VGND.n294 VGND.n266 0.00990704
R7654 VGND.n294 VGND.n272 0.00990704
R7655 VGND.n294 VGND.n271 0.00990704
R7656 VGND.n382 VGND.n352 0.002
R7657 VGND.n382 VGND.n375 0.00196766
R7658 VGND.n382 VGND.n360 0.00196766
R7659 VGND.n221 VGND.n201 0.00196766
R7660 VGND.n313 VGND.n308 0.00239947
R7661 VGND.n382 VGND.n354 0.00196766
R7662 VGND.n411 VGND.n403 0.00196766
R7663 VGND.n181 VGND.n131 0.00194928
R7664 VGND.n221 VGND.n204 0.00194928
R7665 VGND.n709 VGND.n218 0.00194928
R7666 VGND.n482 VGND.n447 0.00194928
R7667 VGND.n411 VGND.n410 0.00156943
R7668 VGND.n181 VGND.n138 0.00155751
R7669 VGND.n482 VGND.n421 0.00155539
R7670 VGND.n245 VGND.n225 0.00152038
R7671 VGND.n484 VGND.n508 0.0015
R7672 VGND.n308 VGND.n312 0.0015
R7673 VGND.n504 VGND.n312 0.0015
R7674 VGND.n504 VGND.n501 0.0015
R7675 VGND.n498 VGND.n501 0.0015
R7676 VGND.n489 VGND.n498 0.0015
R7677 VGND.n496 VGND.n489 0.0015
R7678 VGND.n487 VGND.n485 0.0015
R7679 VGND.n485 VGND.n484 0.0015
R7680 VGND.n414 VGND.n413 0.0015
R7681 VGND.n387 VGND.n386 0.0015
R7682 VGND.n245 VGND.n222 0.0015
R7683 VGND.n329 VGND.n222 0.0015
R7684 VGND.n329 VGND.n328 0.0015
R7685 VGND.n1040 VGND.n385 0.00117984
R7686 VGND.n386 VGND.n389 0.00137995
R7687 VGND.n496 VGND.n495 0.00142853
R7688 VGND.n245 VGND.n240 0.00128076
R7689 VGND.n245 VGND.n234 0.00128076
R7690 VGND.n246 VGND.t1269 23.1779
R7691 VGND.n245 VGND.n237 0.00128076
R7692 VGND.n596 VGND.n222 0.00128076
R7693 VGND.n594 VGND.n222 0.00128076
R7694 VGND.n329 VGND.n326 0.00128076
R7695 VGND.n294 VGND.n293 0.00121524
R7696 VGND.n295 VGND.t813 24.0035
R7697 VGND.n294 VGND.n286 0.00121524
R7698 VGND.n294 VGND.n257 0.00169212
R7699 VGND.n294 VGND.n258 0.00121524
R7700 VGND.n294 VGND.n279 0.00121524
R7701 VGND.n294 VGND.n262 0.00121524
R7702 VGND.n294 VGND.n276 0.00121524
R7703 VGND.n294 VGND.n273 0.00121524
R7704 VGND.n294 VGND.n268 0.00121524
R7705 VGND.n294 VGND.n270 0.00121524
R7706 VGND.n320 VGND.t1487 371.293
R7707 VGND.n122 VGND.n95 0.00306007
R7708 VGND.n309 VGND.n308 0.00259241
R7709 VGND.n294 VGND.n250 0.00268707
R7710 VGND.n181 VGND.n170 0.00264037
R7711 VGND.n221 VGND.n218 0.00258368
R7712 VGND.n600 VGND.n222 0.0023205
R7713 VGND.n245 VGND.n232 0.00231868
R7714 VGND.n294 VGND.n249 0.00223877
R7715 VGND.n124 VGND.t1551 222.069
R7716 VGND.n38 VGND.t822 423.635
R7717 VGND.n6 VGND.n394 1.0325
R7718 sg13cmos5l_mux4_1_5.S1 sg13cmos5l_mux4_1_5.S1.n6 31.1545
R7719 sg13cmos5l_mux4_1_5.S1.n1 sg13cmos5l_mux4_1_5.S1 31.0834
R7720 sg13cmos5l_mux4_1_5.S1.n5 sg13cmos5l_mux4_1_5.S1.n4 26.9331
R7721 sg13cmos5l_mux4_1_5.S1.n6 sg13cmos5l_mux4_1_5.S1.n5 25.8149
R7722 sg13cmos5l_mux4_1_5.S1.n4 sg13cmos5l_mux4_1_5.S1.n3 25.8149
R7723 sg13cmos5l_mux4_1_5.S1.n0 sg13cmos5l_mux4_1_5.S1 24.4237
R7724 sg13cmos5l_mux4_1_5.S1.n1 sg13cmos5l_mux4_1_5.S1.n0 21.6725
R7725 sg13cmos5l_mux4_1_5.S1.n0 sg13cmos5l_mux4_1_5.S1 18.5629
R7726 sg13cmos5l_mux4_1_5.S1 sg13cmos5l_mux4_1_5.S1.t5 15.0498
R7727 sg13cmos5l_mux4_1_5.S1 sg13cmos5l_mux4_1_5.S1.t2 15.0498
R7728 sg13cmos5l_mux4_1_5.S1 sg13cmos5l_mux4_1_5.S1.t3 15.0498
R7729 sg13cmos5l_mux4_1_5.S1 sg13cmos5l_mux4_1_5.S1.t7 15.0498
R7730 sg13cmos5l_mux4_1_5.S1 sg13cmos5l_mux4_1_5.S1.t6 15.0498
R7731 sg13cmos5l_mux4_1_5.S1 sg13cmos5l_mux4_1_5.S1.t1 15.0249
R7732 sg13cmos5l_mux4_1_5.S1 sg13cmos5l_mux4_1_5.S1.t8 15.0249
R7733 sg13cmos5l_mux4_1_5.S1 sg13cmos5l_mux4_1_5.S1.t4 15.0005
R7734 sg13cmos5l_mux4_1_5.S1.n2 sg13cmos5l_mux4_1_5.S1 11.5085
R7735 sg13cmos5l_mux4_1_5.S1.n5 sg13cmos5l_mux4_1_5.S1 9.1655
R7736 sg13cmos5l_mux4_1_5.S1.n4 sg13cmos5l_mux4_1_5.S1 9.15146
R7737 sg13cmos5l_mux4_1_5.S1.n2 sg13cmos5l_mux4_1_5.S1 9.02494
R7738 sg13cmos5l_mux4_1_5.S1.n6 sg13cmos5l_mux4_1_5.S1 9.01098
R7739 sg13cmos5l_mux4_1_5.S1 sg13cmos5l_mux4_1_5.S1.t0 5.6237
R7740 sg13cmos5l_mux4_1_5.S1.n3 sg13cmos5l_mux4_1_5.S1.n2 5.36546
R7741 sg13cmos5l_mux4_1_5.S1.n3 sg13cmos5l_mux4_1_5.S1.n1 4.42962
R7742 sg13cmos5l_buf_1_8.A.n0 sg13cmos5l_buf_1_8.A 77.2316
R7743 sg13cmos5l_buf_1_8.A.n2 sg13cmos5l_buf_1_8.A 56.4074
R7744 sg13cmos5l_buf_1_8.A.n3 sg13cmos5l_buf_1_8.A.n1 29.1285
R7745 sg13cmos5l_buf_1_8.A.n2 sg13cmos5l_buf_1_8.A 19.0007
R7746 sg13cmos5l_buf_1_8.A.n1 sg13cmos5l_buf_1_8.A 18.9215
R7747 sg13cmos5l_buf_1_8.A sg13cmos5l_buf_1_8.A.n3 18.1038
R7748 sg13cmos5l_buf_1_8.A.n1 sg13cmos5l_buf_1_8.A.n0 18.0496
R7749 sg13cmos5l_buf_1_8.A sg13cmos5l_buf_1_8.A.t1 15.0525
R7750 sg13cmos5l_buf_1_8.A sg13cmos5l_buf_1_8.A.t2 15.0249
R7751 sg13cmos5l_buf_1_8.A sg13cmos5l_buf_1_8.A.t4 15.0249
R7752 sg13cmos5l_buf_1_8.A sg13cmos5l_buf_1_8.A.t3 15.0005
R7753 sg13cmos5l_buf_1_8.A.n0 sg13cmos5l_buf_1_8.A 9.0005
R7754 sg13cmos5l_buf_1_8.A sg13cmos5l_buf_1_8.A.t0 5.6237
R7755 sg13cmos5l_buf_1_8.A.n3 sg13cmos5l_buf_1_8.A.n2 1.2677
R7756 sg13cmos5l_nor3_1_2.B.n1 sg13cmos5l_nor3_1_2.B 41.5137
R7757 sg13cmos5l_nor3_1_2.B.n0 sg13cmos5l_nor3_1_2.B 31.5911
R7758 sg13cmos5l_nor3_1_2.B sg13cmos5l_nor3_1_2.B.n3 26.2397
R7759 sg13cmos5l_nor3_1_2.B.n2 sg13cmos5l_nor3_1_2.B 19.4759
R7760 sg13cmos5l_nor3_1_2.B.n3 sg13cmos5l_nor3_1_2.B 18.0525
R7761 sg13cmos5l_nor3_1_2.B sg13cmos5l_nor3_1_2.B.t1 15.0084
R7762 sg13cmos5l_nor3_1_2.B sg13cmos5l_nor3_1_2.B.t2 15.0005
R7763 sg13cmos5l_nor3_1_2.B.n2 sg13cmos5l_nor3_1_2.B.n1 12.7696
R7764 sg13cmos5l_nor3_1_2.B.n3 sg13cmos5l_nor3_1_2.B.n2 9.5045
R7765 sg13cmos5l_nor3_1_2.B.n0 sg13cmos5l_nor3_1_2.B 9.00217
R7766 sg13cmos5l_nor3_1_2.B sg13cmos5l_nor3_1_2.B.t0 6.3941
R7767 sg13cmos5l_nor3_1_2.B.n1 sg13cmos5l_nor3_1_2.B.n0 1.78082
R7768 sg13cmos5l_mux2_1_4.S.n3 sg13cmos5l_mux2_1_4.S.n2 43.4627
R7769 sg13cmos5l_mux2_1_4.S.n1 sg13cmos5l_mux2_1_4.S 39.7823
R7770 sg13cmos5l_mux2_1_4.S.n0 sg13cmos5l_mux2_1_4.S.n4 30.6062
R7771 sg13cmos5l_mux2_1_4.S.n5 sg13cmos5l_mux2_1_4.S.n0 29.1941
R7772 sg13cmos5l_mux2_1_4.S.n0 sg13cmos5l_mux2_1_4.S.n3 26.0479
R7773 sg13cmos5l_mux2_1_4.S.n5 sg13cmos5l_mux2_1_4.S.n1 20.3704
R7774 sg13cmos5l_mux2_1_4.S sg13cmos5l_mux2_1_4.S.t0 17.0317
R7775 sg13cmos5l_mux2_1_4.S sg13cmos5l_mux2_1_4.S.t1 15.0498
R7776 sg13cmos5l_mux2_1_4.S sg13cmos5l_mux2_1_4.S.t2 15.0498
R7777 sg13cmos5l_mux2_1_4.S sg13cmos5l_mux2_1_4.S.t4 15.0498
R7778 sg13cmos5l_mux2_1_4.S sg13cmos5l_mux2_1_4.S.t5 15.0498
R7779 sg13cmos5l_mux2_1_4.S sg13cmos5l_mux2_1_4.S.t3 15.0498
R7780 sg13cmos5l_mux2_1_4.S.n2 sg13cmos5l_mux2_1_4.S 11.2195
R7781 sg13cmos5l_mux2_1_4.S.n4 sg13cmos5l_mux2_1_4.S 10.8551
R7782 sg13cmos5l_mux2_1_4.S.n0 sg13cmos5l_mux2_1_4.S 9.72566
R7783 sg13cmos5l_mux2_1_4.S sg13cmos5l_mux2_1_4.S.n5 9.18226
R7784 sg13cmos5l_mux2_1_4.S.n2 sg13cmos5l_mux2_1_4.S 9.15146
R7785 sg13cmos5l_mux2_1_4.S.n1 sg13cmos5l_mux2_1_4.S 9.0255
R7786 sg13cmos5l_mux2_1_4.S.n3 sg13cmos5l_mux2_1_4.S 9.0005
R7787 sg13cmos5l_mux2_1_4.S.n4 sg13cmos5l_mux2_1_4.S 9.0005
R7788 sg13cmos5l_mux2_1_4.S.t0 sg13cmos5l_mux2_1_4.S 8.62605
R7789 sg13cmos5l_buf_1_9.A.n6 sg13cmos5l_buf_1_9.A.n5 71.9322
R7790 sg13cmos5l_buf_1_9.A.n0 sg13cmos5l_buf_1_9.A 41.2495
R7791 sg13cmos5l_buf_1_9.A.n3 sg13cmos5l_buf_1_9.A 26.1661
R7792 sg13cmos5l_buf_1_9.A.n6 sg13cmos5l_buf_1_9.A 19.7135
R7793 sg13cmos5l_buf_1_9.A.n4 sg13cmos5l_buf_1_9.A.n3 19.6576
R7794 sg13cmos5l_buf_1_9.A sg13cmos5l_buf_1_9.A.n6 19.4471
R7795 sg13cmos5l_buf_1_9.A.n2 sg13cmos5l_buf_1_9.A 19.3703
R7796 sg13cmos5l_buf_1_9.A.n3 sg13cmos5l_buf_1_9.A 18.9853
R7797 sg13cmos5l_buf_1_9.A sg13cmos5l_buf_1_9.A.t3 15.0498
R7798 sg13cmos5l_buf_1_9.A sg13cmos5l_buf_1_9.A.t7 15.0498
R7799 sg13cmos5l_buf_1_9.A sg13cmos5l_buf_1_9.A.t6 15.0498
R7800 sg13cmos5l_buf_1_9.A sg13cmos5l_buf_1_9.A.t1 15.0301
R7801 sg13cmos5l_buf_1_9.A sg13cmos5l_buf_1_9.A.t2 15.0249
R7802 sg13cmos5l_buf_1_9.A sg13cmos5l_buf_1_9.A.t5 15.0249
R7803 sg13cmos5l_buf_1_9.A sg13cmos5l_buf_1_9.A.t4 15.0005
R7804 sg13cmos5l_buf_1_9.A.n5 sg13cmos5l_buf_1_9.A.n4 14.4777
R7805 sg13cmos5l_buf_1_9.A.n4 sg13cmos5l_buf_1_9.A.n2 10.9829
R7806 sg13cmos5l_buf_1_9.A.n2 sg13cmos5l_buf_1_9.A.n1 10.1063
R7807 sg13cmos5l_buf_1_9.A.n0 sg13cmos5l_buf_1_9.A 10.0917
R7808 sg13cmos5l_buf_1_9.A.n1 sg13cmos5l_buf_1_9.A 9.02494
R7809 sg13cmos5l_buf_1_9.A.n5 sg13cmos5l_buf_1_9.A 9.0005
R7810 sg13cmos5l_buf_1_9.A sg13cmos5l_buf_1_9.A.t0 5.6237
R7811 sg13cmos5l_buf_1_9.A.n1 sg13cmos5l_buf_1_9.A.n0 3.9605
R7812 sg13cmos5l_mux4_1_5.S0.n0 sg13cmos5l_mux4_1_5.S0 55.3314
R7813 sg13cmos5l_mux4_1_5.S0.n4 sg13cmos5l_mux4_1_5.S0 35.7152
R7814 sg13cmos5l_mux4_1_5.S0 sg13cmos5l_mux4_1_5.S0.n5 29.3451
R7815 sg13cmos5l_mux4_1_5.S0.n0 sg13cmos5l_mux4_1_5.S0.n2 29.2445
R7816 sg13cmos5l_mux4_1_5.S0.n1 sg13cmos5l_mux4_1_5.S0 25.3347
R7817 sg13cmos5l_mux4_1_5.S0.n3 sg13cmos5l_mux4_1_5.S0.n0 24.92
R7818 sg13cmos5l_mux4_1_5.S0.n1 sg13cmos5l_mux4_1_5.S0 19.8435
R7819 sg13cmos5l_mux4_1_5.S0.n2 sg13cmos5l_mux4_1_5.S0.n1 16.2067
R7820 sg13cmos5l_mux4_1_5.S0 sg13cmos5l_mux4_1_5.S0.t2 15.0249
R7821 sg13cmos5l_mux4_1_5.S0 sg13cmos5l_mux4_1_5.S0.t4 15.0249
R7822 sg13cmos5l_mux4_1_5.S0 sg13cmos5l_mux4_1_5.S0.t3 15.0249
R7823 sg13cmos5l_mux4_1_5.S0 sg13cmos5l_mux4_1_5.S0.t1 15.0249
R7824 sg13cmos5l_mux4_1_5.S0 sg13cmos5l_mux4_1_5.S0.t6 15.0005
R7825 sg13cmos5l_mux4_1_5.S0 sg13cmos5l_mux4_1_5.S0.t5 15.0005
R7826 sg13cmos5l_mux4_1_5.S0 sg13cmos5l_mux4_1_5.S0.t8 15.0005
R7827 sg13cmos5l_mux4_1_5.S0 sg13cmos5l_mux4_1_5.S0.t7 15.0005
R7828 sg13cmos5l_mux4_1_5.S0.n0 sg13cmos5l_mux4_1_5.S0 9.73242
R7829 sg13cmos5l_mux4_1_5.S0.n2 sg13cmos5l_mux4_1_5.S0 9.02494
R7830 sg13cmos5l_mux4_1_5.S0.n3 sg13cmos5l_mux4_1_5.S0 9.0005
R7831 sg13cmos5l_mux4_1_5.S0.n4 sg13cmos5l_mux4_1_5.S0 9.0005
R7832 sg13cmos5l_mux4_1_5.S0.n5 sg13cmos5l_mux4_1_5.S0.n3 8.50706
R7833 sg13cmos5l_mux4_1_5.S0 sg13cmos5l_mux4_1_5.S0.t0 5.69515
R7834 sg13cmos5l_mux4_1_5.S0.n5 sg13cmos5l_mux4_1_5.S0.n4 2.22386
C0 sg13cmos5l_inv_1_961.Y VPWR 0.36361f
C1 sg13cmos5l_mux4_1_7.A3 a_6910_12970# 0.20126f
C2 a_19048_6254# a_19048_5538# 0.01275f
C3 sg13cmos5l_inv_1_890.A sg13cmos5l_inv_1_792.Y 0.10286f
C4 sg13cmos5l_inv_1_576.A VPWR 1.11598f
C5 sg13cmos5l_inv_1_147.Y sg13cmos5l_inv_1_217.A 0.01473f
C6 a_2240_13098# VPWR 0.08135f
C7 sg13cmos5l_inv_1_274.Y a_7582_3534# 0.19698f
C8 sg13cmos5l_inv_1_60.Y VPWR 0.42445f
C9 sg13cmos5l_inv_1_896.Y sg13cmos5l_inv_1_711.Y 0.07425f
C10 sg13cmos5l_inv_1_866.Y sg13cmos5l_inv_1_816.Y 0.01161f
C11 sg13cmos5l_mux4_1_5.S0 sg13cmos5l_inv_1_481.Y 0.01856f
C12 sg13cmos5l_inv_1_110.A sg13cmos5l_inv_1_217.A 0.02785f
C13 sg13cmos5l_inv_1_271.A sg13cmos5l_mux4_1_5.X 0.01002f
C14 sg13cmos5l_mux2_1_0.X sg13cmos5l_inv_1_959.Y 0.19893f
C15 sg13cmos5l_inv_1_305.Y sg13cmos5l_inv_1_306.A 0.03625f
C16 sg13cmos5l_inv_1_998.A VPWR 0.43395f
C17 a_13288_6254# a_13288_5538# 0.01275f
C18 a_10888_9278# VPWR 0.13747f
C19 sg13cmos5l_inv_1_216.Y sg13cmos5l_inv_1_16.A 0.06588f
C20 sg13cmos5l_inv_1_645.A VPWR 0.35052f
C21 sg13cmos5l_inv_1_882.A sg13cmos5l_inv_1_908.A 0.04175f
C22 sg13cmos5l_inv_1_910.A VPWR 0.42724f
C23 sg13cmos5l_inv_1_166.Y sg13cmos5l_inv_1_159.A 0.26531f
C24 sg13cmos5l_o21ai_1_0.B1 sg13cmos5l_nor3_1_1.Y 0.02376f
C25 sg13cmos5l_mux2_1_4.S sg13cmos5l_inv_1_1011.A 0.02115f
C26 sg13cmos5l_inv_1_913.A sg13cmos5l_inv_1_707.A 0.01075f
C27 sg13cmos5l_buf_1_0.A sg13cmos5l_inv_1_129.Y 0.14568f
C28 sg13cmos5l_inv_1_848.Y sg13cmos5l_inv_1_843.Y 0.06597f
C29 sg13cmos5l_inv_1_843.A sg13cmos5l_inv_1_871.Y 0.06253f
C30 sg13cmos5l_mux2_1_1.X sg13cmos5l_mux2_1_4.X 0.07189f
C31 sg13cmos5l_inv_1_130.Y sg13cmos5l_inv_1_105.A 0.79537f
C32 sg13cmos5l_inv_1_61.Y VPWR 0.46241f
C33 sg13cmos5l_inv_1_175.A sg13cmos5l_inv_1_141.Y 0.18584f
C34 sg13cmos5l_inv_1_553.Y sg13cmos5l_inv_1_562.A 0.05353f
C35 sg13cmos5l_mux4_1_9.A0 sg13cmos5l_inv_1_519.Y 0.04233f
C36 sg13cmos5l_inv_1_905.A a_11176_13814# 0.02316f
C37 sg13cmos5l_inv_1_905.Y sg13cmos5l_inv_1_904.A 0.20065f
C38 sg13cmos5l_mux4_1_16.A2 sg13cmos5l_inv_1_108.Y 0.2129f
C39 sg13cmos5l_inv_1_85.Y sg13cmos5l_inv_1_82.Y 0.0869f
C40 a_6430_8434# VPWR 0.88397f
C41 sg13cmos5l_inv_1_434.A sg13cmos5l_inv_1_421.Y 0.14874f
C42 sg13cmos5l_inv_1_266.Y VPWR 0.51931f
C43 sg13cmos5l_inv_1_857.Y VPWR 0.42489f
C44 a_808_16028# a_1192_16122# 0.03269f
C45 sg13cmos5l_inv_1_580.A a_7582_15994# 0.05409f
C46 sg13cmos5l_inv_1_683.A VPWR 0.44417f
C47 sg13cmos5l_buf_1_8.A sg13cmos5l_inv_1_370.Y 0.04842f
C48 sg13cmos5l_inv_1_305.A sg13cmos5l_inv_1_312.Y 0.49064f
C49 sg13cmos5l_inv_1_394.A a_7425_8476# 0.02371f
C50 sg13cmos5l_inv_1_787.Y sg13cmos5l_inv_1_768.A 0.31306f
C51 a_8383_12192# VPWR 0.375f
C52 sg13cmos5l_inv_1_99.Y a_11176_3230# 0.01986f
C53 sg13cmos5l_mux2_1_3.A0 sg13cmos5l_inv_1_122.Y 0.05913f
C54 sg13cmos5l_inv_1_605.Y VPWR 0.42488f
C55 sg13cmos5l_inv_1_758.A a_12808_13098# 0.02337f
C56 sg13cmos5l_inv_1_241.A sg13cmos5l_inv_1_245.A 0.04435f
C57 sg13cmos5l_inv_1_216.Y sg13cmos5l_inv_1_220.Y 0.01452f
C58 a_12896_16838# VPWR 0.12197f
C59 sg13cmos5l_mux4_1_12.A3 sg13cmos5l_inv_1_733.A 0.06263f
C60 a_6599_12970# VPWR 0.41014f
C61 sg13cmos5l_inv_1_475.Y sg13cmos5l_inv_1_925.A 0.12013f
C62 sg13cmos5l_inv_1_70.A VPWR 0.71931f
C63 sg13cmos5l_buf_1_9.A sg13cmos5l_inv_1_495.A 0.02572f
C64 sg13cmos5l_mux4_1_3.X a_9498_3514# 0.01953f
C65 sg13cmos5l_inv_1_418.Y a_5792_6254# 0.03646f
C66 sg13cmos5l_inv_1_612.Y VPWR 0.36074f
C67 sg13cmos5l_mux4_1_5.S0 sg13cmos5l_inv_1_387.Y 0.11027f
C68 a_14913_14524# sg13cmos5l_mux4_1_11.A1 0.20401f
C69 sg13cmos5l_inv_1_689.A sg13cmos5l_inv_1_689.Y 0.21825f
C70 sg13cmos5l_mux4_1_16.A1 a_9536_7766# 0.01054f
C71 sg13cmos5l_buf_1_9.A sg13cmos5l_inv_1_462.A 0.03411f
C72 sg13cmos5l_inv_1_740.A sg13cmos5l_inv_1_739.A 0.20065f
C73 sg13cmos5l_inv_1_668.Y sg13cmos5l_inv_1_531.A 0.01481f
C74 sg13cmos5l_inv_1_278.Y sg13cmos5l_inv_1_65.A 0.08445f
C75 sg13cmos5l_inv_1_576.A sg13cmos5l_inv_1_572.A 0.0128f
C76 sg13cmos5l_mux2_1_4.S sg13cmos5l_mux4_1_1.X 0.05286f
C77 a_13918_14482# a_14913_14524# 0.48298f
C78 sg13cmos5l_nor3_1_1.B sg13cmos5l_buf_1_12.X 0.01394f
C79 sg13cmos5l_inv_1_30.A sg13cmos5l_inv_1_29.A 0.18859f
C80 sg13cmos5l_inv_1_509.Y sg13cmos5l_inv_1_526.A 0.02142f
C81 sg13cmos5l_inv_1_520.A sg13cmos5l_inv_1_502.Y 0.0194f
C82 sg13cmos5l_inv_1_1010.Y sg13cmos5l_inv_1_72.Y 0.01857f
C83 sg13cmos5l_buf_1_9.A sg13cmos5l_nor3_1_2.B 4.28234f
C84 sg13cmos5l_inv_1_278.Y sg13cmos5l_inv_1_84.A 0.01155f
C85 sg13cmos5l_mux2_1_0.X sg13cmos5l_inv_1_187.A 0.01979f
C86 sg13cmos5l_inv_1_863.A sg13cmos5l_inv_1_844.Y 0.02913f
C87 sg13cmos5l_inv_1_879.A VPWR 0.41827f
C88 sg13cmos5l_inv_1_815.Y sg13cmos5l_inv_1_920.A 0.07293f
C89 sg13cmos5l_mux4_1_12.A1 a_17128_13098# 0.01085f
C90 a_3488_6254# VPWR 0.06885f
C91 sg13cmos5l_mux4_1_5.S1 sg13cmos5l_inv_1_138.Y 0.12197f
C92 sg13cmos5l_inv_1_748.A sg13cmos5l_inv_1_748.Y 0.2023f
C93 sg13cmos5l_inv_1_987.A sg13cmos5l_inv_1_759.A 0.20065f
C94 sg13cmos5l_nor4_1_0.Y sg13cmos5l_inv_1_120.A 0.13188f
C95 sg13cmos5l_inv_1_273.A VPWR 0.42694f
C96 sg13cmos5l_a21oi_1_0.B1 sg13cmos5l_inv_1_518.A 0.02746f
C97 sg13cmos5l_inv_1_66.Y a_13288_1002# 0.03352f
C98 sg13cmos5l_inv_1_393.Y sg13cmos5l_inv_1_392.A 0.03774f
C99 sg13cmos5l_inv_1_393.A sg13cmos5l_inv_1_389.Y 0.02308f
C100 sg13cmos5l_buf_1_6.A a_18176_5538# 0.05962f
C101 sg13cmos5l_inv_1_304.Y sg13cmos5l_inv_1_306.Y 0.0268f
C102 sg13cmos5l_nor3_1_2.B sg13cmos5l_mux4_1_15.X 0.36739f
C103 sg13cmos5l_inv_1_45.Y a_14110_3534# 0.14466f
C104 a_13799_3534# a_14228_3534# 0.0289f
C105 sg13cmos5l_inv_1_534.Y sg13cmos5l_inv_1_535.A 0.02441f
C106 sg13cmos5l_inv_1_610.Y sg13cmos5l_inv_1_562.A 0.01892f
C107 sg13cmos5l_inv_1_427.A VPWR 0.41717f
C108 sg13cmos5l_inv_1_314.Y invsel[1] 0.07099f
C109 sg13cmos5l_inv_1_986.Y sg13cmos5l_buf_1_27.X 0.06615f
C110 sg13cmos5l_inv_1_245.A sg13cmos5l_inv_1_237.A 0.01562f
C111 sg13cmos5l_a22oi_1_0.B1 sg13cmos5l_inv_1_491.A 0.7617f
C112 a_13288_12302# VPWR 0.12858f
C113 sg13cmos5l_inv_1_69.A sg13cmos5l_inv_1_945.A 0.07169f
C114 sg13cmos5l_inv_1_378.Y sg13cmos5l_inv_1_377.Y 0.16289f
C115 sg13cmos5l_inv_1_735.Y sg13cmos5l_inv_1_998.Y 0.22163f
C116 sg13cmos5l_inv_1_650.A VPWR 0.42124f
C117 sg13cmos5l_inv_1_22.A sg13cmos5l_inv_1_14.A 0.03145f
C118 sg13cmos5l_mux4_1_5.S1 sg13cmos5l_inv_1_284.A 0.11675f
C119 sg13cmos5l_inv_1_8.Y a_18088_1718# 0.02292f
C120 sg13cmos5l_inv_1_482.Y sg13cmos5l_inv_1_486.Y 0.02614f
C121 sg13cmos5l_inv_1_75.A VPWR 0.42994f
C122 a_13918_12606# a_14645_12221# 0.01228f
C123 sg13cmos5l_inv_1_362.A sg13cmos5l_inv_1_373.A 0.02846f
C124 sg13cmos5l_inv_1_305.Y a_808_6956# 0.0327f
C125 a_14494_9582# a_15221_9197# 0.01228f
C126 a_15565_9466# a_15489_9540# 0.2611f
C127 sg13cmos5l_buf_1_23.X a_19048_16122# 0.02116f
C128 sg13cmos5l_inv_1_137.A sg13cmos5l_inv_1_105.A 0.05808f
C129 sg13cmos5l_inv_1_462.A sg13cmos5l_inv_1_267.Y 0.01249f
C130 sg13cmos5l_inv_1_305.Y sg13cmos5l_inv_1_328.Y 0.08771f
C131 sg13cmos5l_inv_1_40.Y sg13cmos5l_inv_1_7.Y 0.0291f
C132 sg13cmos5l_inv_1_483.Y a_5984_11586# 0.01054f
C133 sg13cmos5l_inv_1_121.Y sg13cmos5l_inv_1_134.Y 0.01436f
C134 sg13cmos5l_inv_1_744.Y sg13cmos5l_inv_1_753.A 0.04052f
C135 sg13cmos5l_mux4_1_13.A0 a_17312_16122# 0.01193f
C136 sg13cmos5l_inv_1_375.Y VPWR 0.47677f
C137 sg13cmos5l_inv_1_819.A sg13cmos5l_inv_1_824.A 0.03497f
C138 sg13cmos5l_inv_1_994.A sg13cmos5l_inv_1_1000.Y 0.03166f
C139 sg13cmos5l_mux2_1_0.X sg13cmos5l_inv_1_228.Y 0.04128f
C140 sg13cmos5l_inv_1_521.Y sg13cmos5l_inv_1_507.A 0.18563f
C141 sg13cmos5l_mux4_1_5.S0 a_3934_3534# 0.08056f
C142 sg13cmos5l_inv_1_483.Y VPWR 0.52774f
C143 sg13cmos5l_inv_1_305.Y sg13cmos5l_inv_1_306.Y 0.04851f
C144 sg13cmos5l_nand2_1_1.B sg13cmos5l_mux2_1_3.X 0.04242f
C145 sg13cmos5l_inv_1_472.Y VPWR 0.43949f
C146 sg13cmos5l_inv_1_69.A a_7271_3534# 0.01516f
C147 sg13cmos5l_inv_1_305.Y sg13cmos5l_inv_1_439.A 0.03734f
C148 a_2912_1718# VPWR 0.1247f
C149 sg13cmos5l_inv_1_325.Y a_4736_2514# 0.01057f
C150 sg13cmos5l_mux2_1_3.S sg13cmos5l_mux4_1_4.X 0.08181f
C151 sg13cmos5l_inv_1_370.Y sg13cmos5l_inv_1_369.A 0.2427f
C152 sg13cmos5l_inv_1_283.A sg13cmos5l_inv_1_438.A 0.08945f
C153 sg13cmos5l_inv_1_265.A sg13cmos5l_inv_1_268.A 0.01463f
C154 sg13cmos5l_inv_1_731.Y a_12808_10790# 0.01986f
C155 sg13cmos5l_buf_1_9.A sg13cmos5l_inv_1_658.Y 0.0852f
C156 sg13cmos5l_mux4_1_1.X sg13cmos5l_inv_1_31.Y 0.03861f
C157 sg13cmos5l_inv_1_45.Y sg13cmos5l_inv_1_38.Y 0.05588f
C158 sg13cmos5l_inv_1_220.A VPWR 0.40083f
C159 sg13cmos5l_inv_1_118.Y VPWR 0.48564f
C160 sg13cmos5l_buf_1_8.A sg13cmos5l_inv_1_699.Y 0.02902f
C161 sg13cmos5l_inv_1_922.Y sg13cmos5l_inv_1_923.Y 0.19543f
C162 sg13cmos5l_inv_1_783.A sg13cmos5l_inv_1_779.Y 0.04193f
C163 sg13cmos5l_inv_1_780.Y sg13cmos5l_inv_1_780.A 0.2023f
C164 sg13cmos5l_inv_1_0.Y VPWR 0.36385f
C165 sg13cmos5l_buf_1_10.A sg13cmos5l_inv_1_334.A 0.03363f
C166 sg13cmos5l_inv_1_304.A sg13cmos5l_inv_1_304.Y 1.01971f
C167 sg13cmos5l_inv_1_584.A a_7271_15994# 0.04037f
C168 sg13cmos5l_buf_1_7.X a_2816_4026# 0.05855f
C169 sg13cmos5l_inv_1_236.Y a_11848_4026# 0.01138f
C170 sg13cmos5l_inv_1_828.Y VPWR 1.09024f
C171 sg13cmos5l_o21ai_1_0.B1 sg13cmos5l_nand2_1_1.Y 0.04186f
C172 sg13cmos5l_buf_1_10.A sg13cmos5l_inv_1_462.A 0.0667f
C173 a_1006_15296# a_808_15326# 0.01391f
C174 sg13cmos5l_inv_1_372.Y sg13cmos5l_inv_1_346.Y 0.02207f
C175 sg13cmos5l_inv_1_642.A sg13cmos5l_inv_1_690.A 0.20065f
C176 sg13cmos5l_inv_1_224.Y sg13cmos5l_inv_1_184.A 0.0127f
C177 sg13cmos5l_inv_1_78.A sg13cmos5l_inv_1_76.A 0.02696f
C178 sg13cmos5l_inv_1_190.A sg13cmos5l_inv_1_225.A 0.23283f
C179 sg13cmos5l_inv_1_337.Y sg13cmos5l_inv_1_322.A 0.24946f
C180 a_17216_10790# VPWR 0.08047f
C181 sg13cmos5l_inv_1_134.Y VPWR 0.43576f
C182 sg13cmos5l_inv_1_412.A VPWR 0.50729f
C183 sg13cmos5l_inv_1_674.A VPWR 0.42689f
C184 sg13cmos5l_inv_1_294.Y a_5032_1718# 0.0207f
C185 sg13cmos5l_nor4_1_0.Y sg13cmos5l_nor4_1_0.A 0.04031f
C186 a_3934_12606# a_4929_12564# 0.48298f
C187 a_8653_3418# a_8577_3492# 0.26108f
C188 sg13cmos5l_inv_1_389.A sg13cmos5l_inv_1_454.Y 0.02471f
C189 sg13cmos5l_mux4_1_5.S0 a_3488_3230# 0.03848f
C190 sg13cmos5l_nand2_1_1.B sg13cmos5l_nor4_1_0.A 1.02481f
C191 sg13cmos5l_o21ai_1_0.B1 sg13cmos5l_inv_1_522.A 0.22829f
C192 sg13cmos5l_inv_1_930.A VPWR 0.44684f
C193 sg13cmos5l_inv_1_890.A sg13cmos5l_inv_1_807.A 0.04526f
C194 sg13cmos5l_inv_1_445.A VPWR 0.71551f
C195 a_800_4026# VPWR 0.06781f
C196 sg13cmos5l_inv_1_753.A sg13cmos5l_inv_1_748.Y 0.01135f
C197 sg13cmos5l_inv_1_548.Y VPWR 0.53708f
C198 sg13cmos5l_inv_1_704.Y sg13cmos5l_inv_1_703.Y 0.1118f
C199 sg13cmos5l_mux4_1_5.S0 sg13cmos5l_inv_1_363.Y 0.01667f
C200 sg13cmos5l_buf_1_8.A sg13cmos5l_inv_1_202.Y 0.01956f
C201 sg13cmos5l_inv_1_959.Y a_13288_9278# 0.03352f
C202 sg13cmos5l_inv_1_598.A sg13cmos5l_inv_1_600.A 0.30689f
C203 sg13cmos5l_inv_1_57.Y VPWR 0.44081f
C204 sg13cmos5l_inv_1_37.A VPWR 1.09158f
C205 sg13cmos5l_mux2_1_4.S a_13918_3898# 0.03068f
C206 sg13cmos5l_inv_1_176.A a_18664_6956# 0.03452f
C207 a_3934_15994# sg13cmos5l_mux2_1_2.A0 0.01013f
C208 sg13cmos5l_buf_1_9.A a_13918_14482# 0.06782f
C209 sg13cmos5l_inv_1_241.Y sg13cmos5l_inv_1_287.A 0.09293f
C210 sg13cmos5l_inv_1_305.Y sg13cmos5l_inv_1_304.A 0.07543f
C211 sg13cmos5l_inv_1_940.A VPWR 0.39684f
C212 sg13cmos5l_inv_1_118.Y sg13cmos5l_inv_1_140.A 0.02551f
C213 sg13cmos5l_inv_1_889.Y VPWR 0.54849f
C214 sg13cmos5l_inv_1_909.A VPWR 0.42525f
C215 sg13cmos5l_inv_1_166.Y sg13cmos5l_inv_1_166.A 0.45968f
C216 sg13cmos5l_o21ai_1_0.B1 sg13cmos5l_nor3_1_0.Y 0.53085f
C217 sg13cmos5l_inv_1_217.A sg13cmos5l_inv_1_194.Y 0.01375f
C218 sg13cmos5l_inv_1_668.Y a_1576_13814# 0.03352f
C219 sg13cmos5l_inv_1_852.Y sg13cmos5l_inv_1_851.A 0.3875f
C220 sg13cmos5l_inv_1_103.A VPWR 1.34428f
C221 sg13cmos5l_inv_1_553.Y sg13cmos5l_inv_1_535.A 0.16906f
C222 sg13cmos5l_inv_1_787.Y a_14206_15630# 0.1646f
C223 sg13cmos5l_inv_1_975.A sg13cmos5l_inv_1_799.A 0.01528f
C224 a_5024_9278# VPWR 0.07777f
C225 sg13cmos5l_inv_1_439.Y a_800_5538# 0.01083f
C226 sg13cmos5l_inv_1_857.A VPWR 0.42688f
C227 sg13cmos5l_inv_1_787.Y sg13cmos5l_inv_1_767.A 0.03669f
C228 sg13cmos5l_inv_1_305.A sg13cmos5l_inv_1_328.A 0.01392f
C229 sg13cmos5l_inv_1_989.A sg13cmos5l_inv_1_75.Y 0.01353f
C230 sg13cmos5l_inv_1_99.Y sg13cmos5l_inv_1_89.Y 0.06038f
C231 sg13cmos5l_buf_1_9.A sg13cmos5l_inv_1_366.A 0.01696f
C232 sg13cmos5l_inv_1_588.Y VPWR 0.42363f
C233 sg13cmos5l_inv_1_905.Y sg13cmos5l_inv_1_740.A 0.01236f
C234 sg13cmos5l_mux2_1_3.A0 sg13cmos5l_inv_1_120.Y 0.31114f
C235 sg13cmos5l_buf_1_9.A sg13cmos5l_inv_1_422.A 0.02306f
C236 a_12808_6254# VPWR 0.20881f
C237 sg13cmos5l_mux4_1_5.S1 a_5005_3418# 0.36926f
C238 sg13cmos5l_inv_1_241.A sg13cmos5l_inv_1_247.A 0.01366f
C239 sg13cmos5l_inv_1_810.Y VPWR 0.53659f
C240 sg13cmos5l_inv_1_418.Y sg13cmos5l_inv_1_383.Y 0.21788f
C241 sg13cmos5l_inv_1_433.A a_5792_6254# 0.01054f
C242 sg13cmos5l_mux4_1_5.S0 sg13cmos5l_inv_1_404.Y 0.22199f
C243 sg13cmos5l_inv_1_593.Y VPWR 0.44572f
C244 sg13cmos5l_inv_1_120.A a_10976_7766# 0.04438f
C245 sg13cmos5l_inv_1_397.Y a_9536_7766# 0.03646f
C246 a_15584_5538# VPWR 0.07742f
C247 sg13cmos5l_inv_1_346.Y sg13cmos5l_inv_1_345.Y 0.15548f
C248 sg13cmos5l_inv_1_630.A sg13cmos5l_inv_1_622.Y 0.01942f
C249 sg13cmos5l_inv_1_747.Y sg13cmos5l_inv_1_762.Y 0.86298f
C250 a_15565_9466# VPWR 0.12185f
C251 sg13cmos5l_buf_1_12.X sg13cmos5l_inv_1_372.Y 0.1158f
C252 sg13cmos5l_inv_1_518.A sg13cmos5l_inv_1_502.Y 0.02014f
C253 sg13cmos5l_inv_1_576.A sg13cmos5l_mux4_1_5.S0 0.11243f
C254 sg13cmos5l_nor4_1_0.A a_10551_10240# 0.02677f
C255 sg13cmos5l_mux2_1_0.X sg13cmos5l_inv_1_25.Y 0.03151f
C256 sg13cmos5l_inv_1_878.A VPWR 0.35933f
C257 sg13cmos5l_buf_1_8.A sg13cmos5l_inv_1_184.Y 0.01333f
C258 sg13cmos5l_nand2_1_1.B sg13cmos5l_inv_1_1012.Y 0.2136f
C259 a_7333_13237# a_6910_12970# 0.01929f
C260 a_15104_4742# VPWR 0.07727f
C261 a_3623_15994# a_4052_15994# 0.0289f
C262 sg13cmos5l_inv_1_128.Y sg13cmos5l_inv_1_107.Y 0.15411f
C263 sg13cmos5l_mux4_1_5.S1 sg13cmos5l_inv_1_136.Y 0.01547f
C264 sg13cmos5l_buf_1_9.A sg13cmos5l_mux4_1_0.A0 0.02824f
C265 sg13cmos5l_or2_1_0.X sg13cmos5l_inv_1_120.A 0.02776f
C266 sg13cmos5l_inv_1_250.Y VPWR 0.41995f
C267 sg13cmos5l_mux4_1_13.A3 a_13895_15630# 0.08637f
C268 sg13cmos5l_inv_1_393.A sg13cmos5l_inv_1_392.A 0.17585f
C269 sg13cmos5l_inv_1_213.A a_18176_5538# 0.01295f
C270 sg13cmos5l_inv_1_304.Y sg13cmos5l_inv_1_307.A 0.03536f
C271 sg13cmos5l_inv_1_427.Y VPWR 0.42604f
C272 sg13cmos5l_or2_1_0.B sg13cmos5l_inv_1_120.A 0.02278f
C273 sg13cmos5l_inv_1_249.Y a_7808_1718# 0.04511f
C274 sg13cmos5l_inv_1_612.Y a_8192_16838# 0.01054f
C275 sg13cmos5l_a22oi_1_0.B1 sg13cmos5l_inv_1_485.A 0.02037f
C276 sg13cmos5l_inv_1_717.A sg13cmos5l_inv_1_696.A 0.13046f
C277 sg13cmos5l_inv_1_69.A sg13cmos5l_inv_1_945.Y 0.02619f
C278 sg13cmos5l_a21oi_1_1.A1 a_8897_11480# 0.01183f
C279 sg13cmos5l_inv_1_651.Y VPWR 0.41243f
C280 sg13cmos5l_inv_1_63.A a_13472_1718# 0.0351f
C281 sg13cmos5l_inv_1_149.A sg13cmos5l_inv_1_147.A 0.16553f
C282 a_8653_3418# VPWR 0.1234f
C283 sg13cmos5l_inv_1_414.A sg13cmos5l_inv_1_446.A 0.09137f
C284 a_13288_4026# a_13472_4026# 0.11523f
C285 a_13607_3898# sg13cmos5l_inv_1_85.A 0.23538f
C286 sg13cmos5l_inv_1_553.Y sg13cmos5l_inv_1_550.Y 0.0108f
C287 sg13cmos5l_inv_1_75.Y VPWR 0.43198f
C288 sg13cmos5l_mux4_1_5.S0 a_6430_8434# 0.10128f
C289 a_13288_17634# a_13472_17634# 0.11523f
C290 sg13cmos5l_mux2_1_2.A0 sg13cmos5l_a22oi_1_0.B1 0.03151f
C291 sg13cmos5l_inv_1_59.A a_12808_1718# 0.03356f
C292 sg13cmos5l_nand2_1_1.B sg13cmos5l_inv_1_663.Y 0.03225f
C293 sg13cmos5l_buf_1_8.A sg13cmos5l_inv_1_346.Y 0.04649f
C294 sg13cmos5l_inv_1_720.Y osc_tap[4] 0.05292f
C295 sg13cmos5l_buf_1_7.X sg13cmos5l_inv_1_304.Y 0.04792f
C296 sg13cmos5l_inv_1_113.A a_14407_9243# 0.01132f
C297 sg13cmos5l_inv_1_866.Y sg13cmos5l_inv_1_862.A 0.03938f
C298 sg13cmos5l_mux4_1_13.A0 sg13cmos5l_inv_1_818.A 0.1893f
C299 sg13cmos5l_buf_1_12.X sg13cmos5l_inv_1_381.Y 0.09395f
C300 sg13cmos5l_inv_1_111.A a_11944_7050# 0.02261f
C301 sg13cmos5l_inv_1_270.A a_9152_4026# 0.03508f
C302 sg13cmos5l_mux4_1_5.S0 a_6599_12970# 0.55174f
C303 a_13288_1718# a_13472_1718# 0.11523f
C304 a_14171_11488# a_14360_11776# 0.40359f
C305 a_16640_9278# VPWR 0.06652f
C306 sg13cmos5l_inv_1_431.A VPWR 1.52717f
C307 sg13cmos5l_inv_1_741.Y sg13cmos5l_inv_1_743.Y 0.19345f
C308 sg13cmos5l_inv_1_963.Y sg13cmos5l_inv_1_966.Y 0.20065f
C309 sg13cmos5l_mux2_1_3.S a_9260_9906# 0.04439f
C310 sg13cmos5l_mux2_1_0.X sg13cmos5l_inv_1_224.A 0.08779f
C311 sg13cmos5l_inv_1_471.Y VPWR 0.42129f
C312 sg13cmos5l_inv_1_202.Y sg13cmos5l_inv_1_158.Y 0.1716f
C313 sg13cmos5l_mux2_1_4.S sg13cmos5l_mux2_1_4.X 0.0376f
C314 sg13cmos5l_mux2_1_4.S sg13cmos5l_inv_1_699.A 0.58097f
C315 sg13cmos5l_inv_1_916.A sg13cmos5l_inv_1_882.Y 0.06447f
C316 sg13cmos5l_inv_1_310.Y VPWR 0.99077f
C317 sg13cmos5l_inv_1_325.A a_4736_2514# 0.03465f
C318 sg13cmos5l_inv_1_731.Y sg13cmos5l_inv_1_731.A 0.13683f
C319 sg13cmos5l_inv_1_100.A a_14913_3940# 0.04704f
C320 sg13cmos5l_inv_1_265.A sg13cmos5l_inv_1_264.A 0.16471f
C321 sg13cmos5l_inv_1_130.Y a_15016_7766# 0.0383f
C322 sg13cmos5l_buf_1_9.A a_4936_15326# 0.01623f
C323 sg13cmos5l_inv_1_63.A VPWR 0.48459f
C324 sg13cmos5l_inv_1_787.Y sg13cmos5l_inv_1_798.Y 0.08867f
C325 sg13cmos5l_buf_1_12.X sg13cmos5l_inv_1_345.Y 0.0228f
C326 sg13cmos5l_inv_1_811.Y sg13cmos5l_mux4_1_14.A0 0.05732f
C327 sg13cmos5l_inv_1_575.Y a_1952_16122# 0.01054f
C328 a_3623_15994# a_3488_16122# 0.01143f
C329 sg13cmos5l_inv_1_76.A a_17120_4026# 0.01325f
C330 sg13cmos5l_buf_1_8.A sg13cmos5l_inv_1_704.Y 0.52659f
C331 sg13cmos5l_inv_1_0.A VPWR 0.54602f
C332 sg13cmos5l_buf_1_8.A sg13cmos5l_inv_1_416.A 0.10489f
C333 sg13cmos5l_mux4_1_5.S1 a_7501_8440# 0.36152f
C334 sg13cmos5l_buf_1_10.A sg13cmos5l_inv_1_422.A 0.25462f
C335 a_13288_17634# VPWR 0.12206f
C336 a_10592_7766# VPWR 0.08426f
C337 sg13cmos5l_inv_1_584.A sg13cmos5l_inv_1_619.Y 0.04972f
C338 sg13cmos5l_mux2_1_3.A0 a_15275_7644# 0.20878f
C339 sg13cmos5l_inv_1_769.Y VPWR 0.41979f
C340 sg13cmos5l_o21ai_1_0.B1 sg13cmos5l_mux2_1_3.X 0.27427f
C341 a_9360_11832# sg13cmos5l_a21oi_1_0.Y 0.04704f
C342 sg13cmos5l_inv_1_305.Y sg13cmos5l_buf_1_7.X 0.08001f
C343 sg13cmos5l_inv_1_485.A sg13cmos5l_inv_1_491.A 0.18345f
C344 sg13cmos5l_inv_1_532.A a_3872_13098# 0.01056f
C345 sg13cmos5l_buf_1_10.A sg13cmos5l_inv_1_386.Y 0.13687f
C346 a_13288_1718# VPWR 0.12833f
C347 a_14171_11488# VPWR 0.119f
C348 sg13cmos5l_inv_1_362.A a_1568_7766# 0.01054f
C349 sg13cmos5l_mux4_1_16.A2 sg13cmos5l_inv_1_445.A 0.05236f
C350 sg13cmos5l_mux4_1_8.A1 a_9536_16838# 0.01142f
C351 sg13cmos5l_inv_1_78.A sg13cmos5l_inv_1_77.Y 0.33252f
C352 sg13cmos5l_inv_1_316.A sg13cmos5l_inv_1_322.A 0.11206f
C353 sg13cmos5l_inv_1_270.Y a_9152_4026# 0.01329f
C354 sg13cmos5l_inv_1_994.A VPWR 0.62121f
C355 sg13cmos5l_inv_1_133.Y VPWR 0.44277f
C356 sg13cmos5l_inv_1_584.A sg13cmos5l_inv_1_684.A 0.07007f
C357 sg13cmos5l_inv_1_394.A a_6119_8434# 0.08054f
C358 sg13cmos5l_inv_1_401.Y VPWR 0.66877f
C359 sg13cmos5l_inv_1_675.A VPWR 0.42723f
C360 sg13cmos5l_inv_1_294.Y sg13cmos5l_inv_1_453.Y 0.06964f
C361 sg13cmos5l_mux4_1_7.A1 a_6664_13814# 0.06357f
C362 a_14389_11500# sg13cmos5l_mux4_1_15.X 0.01509f
C363 sg13cmos5l_inv_1_171.Y sg13cmos5l_inv_1_165.Y 0.17949f
C364 sg13cmos5l_a21oi_1_0.B1 sg13cmos5l_inv_1_665.A 0.29507f
C365 sg13cmos5l_inv_1_931.A VPWR 0.42898f
C366 sg13cmos5l_inv_1_807.Y sg13cmos5l_inv_1_792.Y 0.06527f
C367 sg13cmos5l_inv_1_808.A sg13cmos5l_inv_1_807.A 0.18584f
C368 sg13cmos5l_inv_1_337.Y VPWR 0.44199f
C369 sg13cmos5l_inv_1_546.Y VPWR 0.43459f
C370 sg13cmos5l_mux4_1_5.S0 sg13cmos5l_inv_1_375.Y 0.17779f
C371 sg13cmos5l_inv_1_148.A sg13cmos5l_inv_1_217.A 0.03584f
C372 a_1192_13098# VPWR 0.14564f
C373 sg13cmos5l_inv_1_39.A VPWR 0.57661f
C374 sg13cmos5l_inv_1_73.A VPWR 0.48224f
C375 sg13cmos5l_buf_1_8.A sg13cmos5l_inv_1_237.Y 0.02655f
C376 sg13cmos5l_inv_1_59.Y sg13cmos5l_inv_1_67.A 0.01759f
C377 a_13607_14482# a_14422_14482# 0.49917f
C378 sg13cmos5l_inv_1_891.Y sg13cmos5l_inv_1_896.Y 0.20065f
C379 sg13cmos5l_mux4_1_5.S0 sg13cmos5l_inv_1_483.Y 0.04828f
C380 sg13cmos5l_inv_1_241.Y sg13cmos5l_inv_1_279.Y 0.01063f
C381 sg13cmos5l_buf_1_8.A sg13cmos5l_buf_1_12.X 0.01851f
C382 sg13cmos5l_mux2_1_4.S sg13cmos5l_inv_1_92.A 0.12634f
C383 sg13cmos5l_mux2_1_0.X VPWR 2.16868f
C384 sg13cmos5l_inv_1_369.A sg13cmos5l_inv_1_346.Y 0.01959f
C385 sg13cmos5l_inv_1_421.A sg13cmos5l_inv_1_422.A 1.01561f
C386 sg13cmos5l_inv_1_882.Y VPWR 0.37608f
C387 sg13cmos5l_inv_1_59.A a_12896_2514# 0.01054f
C388 sg13cmos5l_inv_1_898.Y sg13cmos5l_inv_1_908.A 0.01622f
C389 sg13cmos5l_inv_1_800.Y sg13cmos5l_inv_1_787.Y 0.15548f
C390 sg13cmos5l_inv_1_903.Y VPWR 0.41189f
C391 sg13cmos5l_mux4_1_5.S1 a_7425_8476# 0.20777f
C392 sg13cmos5l_inv_1_958.Y sg13cmos5l_inv_1_166.A 0.11152f
C393 sg13cmos5l_o21ai_1_0.B1 sg13cmos5l_nor4_1_0.A 0.0327f
C394 sg13cmos5l_inv_1_848.Y sg13cmos5l_inv_1_871.Y 0.06974f
C395 sg13cmos5l_inv_1_825.A sg13cmos5l_inv_1_851.A 0.02841f
C396 sg13cmos5l_inv_1_102.Y VPWR 1.527f
C397 sg13cmos5l_inv_1_174.A sg13cmos5l_inv_1_175.A 0.20065f
C398 sg13cmos5l_inv_1_975.A sg13cmos5l_inv_1_995.Y 0.01535f
C399 sg13cmos5l_inv_1_984.Y VPWR 0.48239f
C400 sg13cmos5l_inv_1_905.A sg13cmos5l_inv_1_905.Y 0.2026f
C401 sg13cmos5l_inv_1_459.Y sg13cmos5l_inv_1_416.A 0.03125f
C402 sg13cmos5l_inv_1_450.Y sg13cmos5l_inv_1_434.A 0.03688f
C403 sg13cmos5l_inv_1_439.A a_800_5538# 0.03589f
C404 sg13cmos5l_inv_1_744.Y a_18664_13004# 0.32132f
C405 sg13cmos5l_inv_1_847.Y VPWR 0.43017f
C406 sg13cmos5l_nor3_1_2.B a_4475_13008# 0.18398f
C407 sg13cmos5l_inv_1_964.A sg13cmos5l_mux4_1_4.X 0.02746f
C408 sg13cmos5l_inv_1_237.Y a_4556_3858# 0.02402f
C409 a_9982_8050# a_10592_7766# 0.0344f
C410 sg13cmos5l_mux2_1_3.A0 sg13cmos5l_inv_1_122.A 0.024f
C411 sg13cmos5l_inv_1_905.A sg13cmos5l_inv_1_740.A 0.01098f
C412 sg13cmos5l_inv_1_599.Y VPWR 0.52349f
C413 sg13cmos5l_inv_1_128.Y VPWR 0.58851f
C414 sg13cmos5l_inv_1_969.Y sg13cmos5l_inv_1_970.A 0.06737f
C415 a_808_13004# a_1192_13098# 0.03269f
C416 sg13cmos5l_inv_1_811.Y VPWR 0.69816f
C417 sg13cmos5l_buf_1_2.X a_19048_3230# 0.02116f
C418 sg13cmos5l_inv_1_311.A a_1480_1718# 0.03541f
C419 sg13cmos5l_inv_1_589.Y VPWR 0.36908f
C420 sg13cmos5l_inv_1_433.A sg13cmos5l_inv_1_383.Y 0.09475f
C421 sg13cmos5l_inv_1_120.A sg13cmos5l_inv_1_122.Y 0.01061f
C422 sg13cmos5l_inv_1_185.A VPWR 0.34769f
C423 sg13cmos5l_inv_1_113.A sg13cmos5l_inv_1_115.A 0.0392f
C424 sg13cmos5l_inv_1_739.A sg13cmos5l_inv_1_747.Y 0.01669f
C425 a_15277_15514# VPWR 0.12158f
C426 sg13cmos5l_inv_1_217.A osc_tap[1] 0.06271f
C427 sg13cmos5l_inv_1_747.Y sg13cmos5l_inv_1_761.A 0.10057f
C428 sg13cmos5l_inv_1_533.Y a_3623_15994# 0.03638f
C429 sg13cmos5l_inv_1_757.Y a_13856_11586# 0.03571f
C430 sg13cmos5l_mux4_1_15.A2 sg13cmos5l_inv_1_155.Y 0.01412f
C431 sg13cmos5l_inv_1_407.Y sg13cmos5l_inv_1_391.A 0.15745f
C432 sg13cmos5l_a21oi_1_0.B1 sg13cmos5l_inv_1_498.A 0.05086f
C433 sg13cmos5l_nor3_1_2.B sg13cmos5l_inv_1_531.A 0.01057f
C434 sg13cmos5l_inv_1_509.A sg13cmos5l_inv_1_526.Y 0.02716f
C435 sg13cmos5l_mux4_1_5.S0 sg13cmos5l_inv_1_445.A 0.06493f
C436 sg13cmos5l_inv_1_576.A sg13cmos5l_inv_1_537.Y 0.09839f
C437 a_19048_13814# VPWR 0.1263f
C438 sg13cmos5l_inv_1_278.Y sg13cmos5l_inv_1_1010.Y 0.1599f
C439 sg13cmos5l_inv_1_1011.A sg13cmos5l_inv_1_278.Y 0.39535f
C440 a_4438_12606# VPWR 0.0845f
C441 sg13cmos5l_buf_1_9.A a_3934_12606# 0.03058f
C442 sg13cmos5l_buf_1_8.A sg13cmos5l_inv_1_83.Y 0.02223f
C443 sg13cmos5l_inv_1_592.Y sg13cmos5l_inv_1_589.A 0.01936f
C444 sg13cmos5l_nand2_1_1.B sg13cmos5l_inv_1_947.Y 0.14117f
C445 sg13cmos5l_nor2b_1_0.B_N sg13cmos5l_o21ai_1_0.B1 0.02601f
C446 sg13cmos5l_inv_1_185.Y VPWR 0.43835f
C447 sg13cmos5l_mux4_1_5.S1 sg13cmos5l_inv_1_140.Y 0.60743f
C448 sg13cmos5l_inv_1_493.A sg13cmos5l_inv_1_987.A 0.20065f
C449 sg13cmos5l_buf_1_9.A sg13cmos5l_inv_1_159.Y 0.05456f
C450 sg13cmos5l_inv_1_736.Y sg13cmos5l_inv_1_748.A 0.34932f
C451 sg13cmos5l_inv_1_252.Y VPWR 0.42296f
C452 sg13cmos5l_inv_1_421.A a_3847_7731# 0.01129f
C453 sg13cmos5l_inv_1_280.Y sg13cmos5l_inv_1_237.A 0.01087f
C454 a_13472_7766# VPWR 0.0691f
C455 sg13cmos5l_inv_1_393.A sg13cmos5l_inv_1_393.Y 0.26964f
C456 sg13cmos5l_inv_1_304.Y sg13cmos5l_inv_1_308.A 0.02716f
C457 sg13cmos5l_inv_1_95.A a_14110_3534# 0.01726f
C458 sg13cmos5l_inv_1_689.Y sg13cmos5l_inv_1_668.Y 0.01163f
C459 a_13607_3898# a_14036_3898# 0.0289f
C460 sg13cmos5l_inv_1_553.A a_4928_17634# 0.04625f
C461 sg13cmos5l_inv_1_438.A VPWR 0.42013f
C462 sg13cmos5l_buf_1_8.A sg13cmos5l_inv_1_205.A 0.08662f
C463 sg13cmos5l_inv_1_247.A sg13cmos5l_inv_1_245.A 0.2026f
C464 sg13cmos5l_inv_1_249.Y sg13cmos5l_inv_1_237.A 0.0165f
C465 sg13cmos5l_inv_1_612.Y sg13cmos5l_inv_1_618.Y 0.09475f
C466 sg13cmos5l_a22oi_1_0.B1 sg13cmos5l_inv_1_485.Y 0.01781f
C467 sg13cmos5l_inv_1_69.A sg13cmos5l_inv_1_238.A 0.02619f
C468 a_9659_7736# VPWR 0.97128f
C469 sg13cmos5l_inv_1_652.Y VPWR 0.42651f
C470 sg13cmos5l_inv_1_212.Y sg13cmos5l_inv_1_209.Y 0.18584f
C471 sg13cmos5l_inv_1_305.A a_3934_3534# 0.16646f
C472 a_3623_3534# a_4052_3534# 0.0289f
C473 a_15277_15514# a_15201_15588# 0.26108f
C474 sg13cmos5l_inv_1_149.A sg13cmos5l_inv_1_147.Y 0.05259f
C475 sg13cmos5l_inv_1_85.Y sg13cmos5l_inv_1_85.A 0.88301f
C476 sg13cmos5l_o21ai_1_0.B1 sg13cmos5l_inv_1_1012.Y 0.08478f
C477 sg13cmos5l_inv_1_576.A sg13cmos5l_inv_1_542.A 0.78779f
C478 sg13cmos5l_inv_1_271.A VPWR 0.43497f
C479 sg13cmos5l_inv_1_890.A a_13472_17634# 0.01076f
C480 sg13cmos5l_buf_1_9.A sg13cmos5l_inv_1_757.Y 0.03806f
C481 a_7582_15994# a_7789_16261# 0.01967f
C482 a_8653_16000# a_8577_16036# 0.2611f
C483 sg13cmos5l_inv_1_490.A sg13cmos5l_inv_1_471.Y 0.03195f
C484 sg13cmos5l_inv_1_533.Y sg13cmos5l_mux4_1_10.A2 0.45139f
C485 sg13cmos5l_inv_1_699.A a_15584_10790# 0.04341f
C486 sg13cmos5l_inv_1_121.Y sg13cmos5l_inv_1_132.Y 0.01235f
C487 sg13cmos5l_inv_1_872.A sg13cmos5l_inv_1_862.A 0.34565f
C488 sg13cmos5l_buf_1_12.X sg13cmos5l_inv_1_411.A 0.01164f
C489 sg13cmos5l_inv_1_562.Y sg13cmos5l_inv_1_610.A 0.01014f
C490 sg13cmos5l_nand2_1_1.B sg13cmos5l_inv_1_505.Y 0.01025f
C491 sg13cmos5l_inv_1_593.Y sg13cmos5l_mux4_1_5.S0 0.04699f
C492 sg13cmos5l_inv_1_362.Y VPWR 0.64597f
C493 sg13cmos5l_inv_1_775.A sg13cmos5l_inv_1_800.A 0.01312f
C494 sg13cmos5l_inv_1_576.A sg13cmos5l_inv_1_682.A 0.03867f
C495 sg13cmos5l_mux2_1_3.S sg13cmos5l_mux2_1_1.X 0.02398f
C496 sg13cmos5l_inv_1_30.Y a_18664_4026# 0.03488f
C497 sg13cmos5l_inv_1_359.Y a_3304_9278# 0.04353f
C498 sg13cmos5l_inv_1_474.Y VPWR 0.35133f
C499 sg13cmos5l_mux4_1_0.A0 sg13cmos5l_inv_1_179.A 0.05636f
C500 sg13cmos5l_mux4_1_10.A3 a_3623_15994# 0.07982f
C501 sg13cmos5l_inv_1_916.A sg13cmos5l_inv_1_882.A 0.17399f
C502 sg13cmos5l_inv_1_335.Y a_4736_2514# 0.03508f
C503 sg13cmos5l_inv_1_378.Y sg13cmos5l_inv_1_369.A 0.38776f
C504 sg13cmos5l_buf_1_9.A sg13cmos5l_buf_1_8.A 0.22221f
C505 a_18280_12216# a_18088_12302# 0.01225f
C506 sg13cmos5l_inv_1_810.Y sg13cmos5l_inv_1_798.A 0.01367f
C507 sg13cmos5l_inv_1_575.Y sg13cmos5l_inv_1_563.Y 0.09847f
C508 a_8864_4742# VPWR 0.07946f
C509 sg13cmos5l_buf_1_8.A sg13cmos5l_mux4_1_15.X 1.4555f
C510 sg13cmos5l_inv_1_821.Y sg13cmos5l_inv_1_825.A 0.0123f
C511 a_4475_13008# a_4701_13264# 0.02749f
C512 sg13cmos5l_inv_1_783.A sg13cmos5l_inv_1_780.Y 0.20065f
C513 sg13cmos5l_buf_1_8.A sg13cmos5l_inv_1_426.A 0.13086f
C514 sg13cmos5l_inv_1_8.Y VPWR 0.51274f
C515 sg13cmos5l_inv_1_890.A VPWR 0.45728f
C516 sg13cmos5l_mux2_1_3.A0 sg13cmos5l_inv_1_130.A 0.0542f
C517 sg13cmos5l_inv_1_774.Y VPWR 0.54525f
C518 sg13cmos5l_inv_1_519.Y a_3872_13098# 0.03553f
C519 sg13cmos5l_inv_1_496.A sg13cmos5l_inv_1_498.A 0.01386f
C520 sg13cmos5l_mux4_1_15.A3 sg13cmos5l_mux4_1_5.S1 0.04672f
C521 sg13cmos5l_buf_1_10.A sg13cmos5l_inv_1_381.Y 0.1656f
C522 sg13cmos5l_inv_1_14.A VPWR 0.51229f
C523 sg13cmos5l_inv_1_376.A a_1568_7766# 0.03553f
C524 sg13cmos5l_inv_1_228.Y sg13cmos5l_inv_1_225.A 0.08135f
C525 sg13cmos5l_inv_1_78.A sg13cmos5l_inv_1_99.Y 0.06253f
C526 sg13cmos5l_inv_1_698.A VPWR 0.42366f
C527 sg13cmos5l_inv_1_132.Y VPWR 0.43973f
C528 sg13cmos5l_inv_1_241.A sg13cmos5l_inv_1_311.Y 0.56378f
C529 sg13cmos5l_mux2_1_4.S a_14494_9582# 0.05802f
C530 sg13cmos5l_inv_1_159.A sg13cmos5l_mux4_1_0.A0 0.2117f
C531 sg13cmos5l_inv_1_403.Y VPWR 0.49089f
C532 sg13cmos5l_inv_1_394.Y sg13cmos5l_mux4_1_16.A1 0.03543f
C533 sg13cmos5l_inv_1_669.A VPWR 0.42433f
C534 sg13cmos5l_inv_1_534.Y a_4929_16036# 0.01717f
C535 sg13cmos5l_inv_1_296.A sg13cmos5l_inv_1_453.Y 0.03542f
C536 a_9659_7736# a_9982_8050# 0.55132f
C537 sg13cmos5l_inv_1_416.A a_5408_4742# 0.04356f
C538 sg13cmos5l_mux2_1_4.X sg13cmos5l_inv_1_1011.A 0.06649f
C539 a_3680_4026# VPWR 0.11534f
C540 sg13cmos5l_buf_1_9.A a_4556_3858# 0.28883f
C541 a_3934_12606# sg13cmos5l_buf_1_10.A 0.03606f
C542 sg13cmos5l_a21oi_1_0.B1 sg13cmos5l_a22oi_1_0.B1 0.3074f
C543 sg13cmos5l_inv_1_931.Y VPWR 0.443f
C544 a_8327_6558# VPWR 0.39361f
C545 sg13cmos5l_buf_1_8.A sg13cmos5l_inv_1_507.A 0.21444f
C546 sg13cmos5l_inv_1_316.A VPWR 0.42705f
C547 sg13cmos5l_inv_1_807.Y sg13cmos5l_inv_1_807.A 0.10979f
C548 sg13cmos5l_inv_1_106.Y sg13cmos5l_inv_1_217.A 0.01472f
C549 sg13cmos5l_inv_1_545.Y VPWR 0.51255f
C550 sg13cmos5l_inv_1_68.A VPWR 0.42489f
C551 sg13cmos5l_buf_1_8.A sg13cmos5l_inv_1_267.Y 0.03865f
C552 a_13288_9278# VPWR 0.1339f
C553 sg13cmos5l_inv_1_59.Y sg13cmos5l_inv_1_66.A 0.28781f
C554 sg13cmos5l_mux4_1_14.A1 sg13cmos5l_inv_1_819.A 0.28126f
C555 sg13cmos5l_mux4_1_14.A3 VPWR 0.48385f
C556 sg13cmos5l_inv_1_268.A sg13cmos5l_inv_1_286.Y 0.01074f
C557 sg13cmos5l_inv_1_974.A sg13cmos5l_inv_1_350.A 0.01703f
C558 sg13cmos5l_o21ai_1_0.Y VPWR 0.43785f
C559 a_14614_3534# a_14110_3534# 0.97548f
C560 sg13cmos5l_inv_1_882.A VPWR 0.38735f
C561 sg13cmos5l_inv_1_731.A sg13cmos5l_inv_1_734.A 0.01904f
C562 sg13cmos5l_mux2_1_1.X sg13cmos5l_inv_1_964.Y 0.01923f
C563 sg13cmos5l_inv_1_980.A a_8000_9278# 0.03553f
C564 sg13cmos5l_inv_1_969.Y VPWR 0.36096f
C565 sg13cmos5l_inv_1_78.A sg13cmos5l_inv_1_142.A 0.02907f
C566 sg13cmos5l_inv_1_459.A sg13cmos5l_inv_1_416.A 0.02559f
C567 sg13cmos5l_inv_1_544.Y sg13cmos5l_inv_1_570.A 0.09589f
C568 sg13cmos5l_inv_1_846.Y VPWR 0.43404f
C569 sg13cmos5l_nor3_1_2.B sg13cmos5l_mux4_1_9.X 0.06427f
C570 sg13cmos5l_inv_1_828.Y sg13cmos5l_inv_1_771.Y 0.04314f
C571 a_6119_8434# a_6356_8434# 0.01012f
C572 sg13cmos5l_inv_1_880.A a_16456_14610# 0.03352f
C573 sg13cmos5l_mux2_1_3.A0 sg13cmos5l_inv_1_121.Y 0.74479f
C574 sg13cmos5l_inv_1_588.A VPWR 0.42482f
C575 sg13cmos5l_inv_1_141.A a_18368_6254# 0.05751f
C576 sg13cmos5l_inv_1_467.Y a_6430_8434# 0.14977f
C577 sg13cmos5l_inv_1_248.A sg13cmos5l_inv_1_382.A 0.30578f
C578 sg13cmos5l_inv_1_535.Y VPWR 0.6023f
C579 sg13cmos5l_mux4_1_5.S0 sg13cmos5l_inv_1_401.Y 0.04583f
C580 sg13cmos5l_inv_1_120.A sg13cmos5l_inv_1_120.Y 0.09097f
C581 sg13cmos5l_inv_1_184.A VPWR 0.41234f
C582 sg13cmos5l_inv_1_362.A sg13cmos5l_inv_1_348.Y 0.01012f
C583 sg13cmos5l_inv_1_92.A sg13cmos5l_inv_1_1011.A 0.09503f
C584 sg13cmos5l_buf_1_8.A sg13cmos5l_buf_1_10.A 0.61761f
C585 sg13cmos5l_inv_1_740.A sg13cmos5l_inv_1_747.Y 0.01374f
C586 sg13cmos5l_inv_1_973.Y sg13cmos5l_mux4_1_6.A2 0.16384f
C587 sg13cmos5l_inv_1_326.Y VPWR 2.01909f
C588 sg13cmos5l_inv_1_580.A sg13cmos5l_buf_1_9.A 0.26297f
C589 sg13cmos5l_inv_1_808.A sg13cmos5l_mux4_1_14.A0 0.02235f
C590 sg13cmos5l_inv_1_1011.A sg13cmos5l_inv_1_280.Y 0.05634f
C591 sg13cmos5l_inv_1_287.A sg13cmos5l_inv_1_1011.A 0.03294f
C592 a_6599_12970# a_7414_12970# 0.49917f
C593 sg13cmos5l_inv_1_495.A a_6910_12970# 0.01987f
C594 a_15662_4084# a_15834_4192# 0.01068f
C595 a_14110_3534# a_15105_3492# 0.48298f
C596 sg13cmos5l_mux2_1_4.S a_9432_3406# 0.16815f
C597 sg13cmos5l_buf_1_9.A sg13cmos5l_inv_1_158.Y 0.03543f
C598 sg13cmos5l_inv_1_828.Y a_19048_18350# 0.06329f
C599 sg13cmos5l_inv_1_810.Y sg13cmos5l_inv_1_798.Y 0.01683f
C600 sg13cmos5l_inv_1_252.A VPWR 0.41305f
C601 a_17896_17634# VPWR 0.13546f
C602 a_18664_6956# VPWR 0.31312f
C603 sg13cmos5l_inv_1_437.A VPWR 0.42673f
C604 sg13cmos5l_inv_1_553.A sg13cmos5l_inv_1_562.A 0.21661f
C605 a_13288_18350# a_13288_17634# 0.01275f
C606 sg13cmos5l_inv_1_100.A sg13cmos5l_inv_1_103.A 0.31026f
C607 sg13cmos5l_inv_1_828.Y sg13cmos5l_inv_1_837.Y 0.02529f
C608 sg13cmos5l_buf_1_8.A sg13cmos5l_inv_1_206.A 0.03776f
C609 sg13cmos5l_nor3_1_2.B a_6910_12970# 0.02156f
C610 sg13cmos5l_inv_1_249.Y sg13cmos5l_inv_1_245.A 0.01645f
C611 sg13cmos5l_a22oi_1_0.B1 sg13cmos5l_inv_1_496.A 0.01771f
C612 sg13cmos5l_inv_1_69.A sg13cmos5l_inv_1_244.A 0.02744f
C613 sg13cmos5l_mux2_1_3.A0 VPWR 0.44039f
C614 sg13cmos5l_mux2_1_4.X sg13cmos5l_inv_1_414.A 0.20662f
C615 sg13cmos5l_inv_1_656.Y VPWR 0.42247f
C616 sg13cmos5l_nor2b_1_0.A sg13cmos5l_o21ai_1_0.B1 0.18653f
C617 sg13cmos5l_buf_1_10.A a_4556_3858# 0.32681f
C618 sg13cmos5l_inv_1_149.A sg13cmos5l_inv_1_148.Y 0.60632f
C619 sg13cmos5l_inv_1_441.A sg13cmos5l_inv_1_446.A 0.16247f
C620 sg13cmos5l_inv_1_415.A sg13cmos5l_inv_1_414.A 0.18195f
C621 sg13cmos5l_inv_1_553.Y sg13cmos5l_inv_1_552.Y 0.03696f
C622 sg13cmos5l_inv_1_548.Y sg13cmos5l_inv_1_542.A 0.16201f
C623 sg13cmos5l_o21ai_1_0.B1 sg13cmos5l_inv_1_947.Y 0.24746f
C624 sg13cmos5l_inv_1_270.A VPWR 0.42526f
C625 sg13cmos5l_inv_1_983.Y sg13cmos5l_inv_1_984.Y 0.0688f
C626 sg13cmos5l_inv_1_481.Y sg13cmos5l_inv_1_487.A 0.01049f
C627 sg13cmos5l_inv_1_490.A sg13cmos5l_inv_1_474.Y 0.01721f
C628 sg13cmos5l_inv_1_533.Y sg13cmos5l_inv_1_533.A 0.65455f
C629 sg13cmos5l_inv_1_568.Y sg13cmos5l_mux4_1_10.A2 0.05933f
C630 sg13cmos5l_inv_1_809.Y a_12136_17634# 0.03528f
C631 sg13cmos5l_inv_1_699.A sg13cmos5l_inv_1_700.Y 0.0162f
C632 sg13cmos5l_mux4_1_8.A0 sg13cmos5l_inv_1_584.A 0.03428f
C633 sg13cmos5l_inv_1_606.Y sg13cmos5l_inv_1_772.A 0.0374f
C634 a_808_15326# invsel[5] 0.01199f
C635 sg13cmos5l_inv_1_560.A sg13cmos5l_inv_1_609.A 0.0121f
C636 sg13cmos5l_inv_1_144.Y sg13cmos5l_inv_1_145.Y 0.20065f
C637 sg13cmos5l_inv_1_1003.Y sg13cmos5l_inv_1_741.Y 0.16343f
C638 sg13cmos5l_inv_1_29.A a_18664_4026# 0.02031f
C639 sg13cmos5l_inv_1_962.Y sg13cmos5l_inv_1_963.Y 0.20065f
C640 sg13cmos5l_mux2_1_0.X sg13cmos5l_inv_1_218.A 0.01331f
C641 sg13cmos5l_inv_1_521.Y sg13cmos5l_inv_1_518.A 0.04881f
C642 sg13cmos5l_inv_1_854.Y sg13cmos5l_inv_1_853.Y 0.20065f
C643 sg13cmos5l_inv_1_100.A a_15104_4742# 0.01054f
C644 sg13cmos5l_inv_1_202.Y sg13cmos5l_inv_1_116.Y 0.11021f
C645 sg13cmos5l_inv_1_113.A sg13cmos5l_inv_1_158.Y 0.01626f
C646 sg13cmos5l_inv_1_1007.Y VPWR 0.75051f
C647 sg13cmos5l_mux4_1_14.A1 a_13895_15630# 0.048f
C648 a_15662_4084# a_16156_3898# 0.01637f
C649 sg13cmos5l_mux4_1_2.X a_15834_3898# 0.01954f
C650 sg13cmos5l_inv_1_348.A a_1576_6254# 0.02074f
C651 sg13cmos5l_inv_1_671.A sg13cmos5l_a22oi_1_0.B1 0.02404f
C652 sg13cmos5l_inv_1_738.A sg13cmos5l_inv_1_1002.A 0.04759f
C653 sg13cmos5l_inv_1_266.A sg13cmos5l_inv_1_265.A 0.1701f
C654 sg13cmos5l_mux2_1_4.S a_14827_11673# 0.04265f
C655 sg13cmos5l_inv_1_69.A sg13cmos5l_inv_1_259.Y 0.01256f
C656 a_18280_12216# sg13cmos5l_buf_1_18.A 0.3325f
C657 sg13cmos5l_inv_1_394.A sg13cmos5l_mux4_1_5.S1 0.61521f
C658 sg13cmos5l_inv_1_132.Y sg13cmos5l_mux4_1_16.A2 0.06496f
C659 sg13cmos5l_inv_1_811.Y sg13cmos5l_inv_1_798.A 0.01395f
C660 a_3304_3230# a_3488_3230# 0.11523f
C661 a_4929_3492# sg13cmos5l_mux4_1_5.X 0.20796f
C662 sg13cmos5l_inv_1_216.Y a_14110_3534# 0.07903f
C663 sg13cmos5l_mux2_1_1.X a_9064_8562# 0.02597f
C664 sg13cmos5l_o21ai_1_0.B1 sg13cmos5l_inv_1_505.Y 0.03983f
C665 sg13cmos5l_inv_1_270.Y VPWR 0.58703f
C666 sg13cmos5l_inv_1_7.A sg13cmos5l_inv_1_4.Y 0.0284f
C667 sg13cmos5l_inv_1_43.Y sg13cmos5l_inv_1_5.Y 0.18584f
C668 sg13cmos5l_a21oi_1_0.B1 sg13cmos5l_inv_1_537.A 0.04964f
C669 sg13cmos5l_buf_1_10.A sg13cmos5l_inv_1_420.A 0.01789f
C670 sg13cmos5l_mux4_1_5.S1 a_6119_8434# 0.02422f
C671 sg13cmos5l_inv_1_248.A sg13cmos5l_inv_1_274.Y 0.8897f
C672 sg13cmos5l_inv_1_808.A VPWR 0.42025f
C673 sg13cmos5l_inv_1_83.Y sg13cmos5l_inv_1_76.A 0.77267f
C674 sg13cmos5l_inv_1_770.A VPWR 0.41499f
C675 sg13cmos5l_inv_1_519.Y sg13cmos5l_inv_1_532.A 0.68304f
C676 sg13cmos5l_inv_1_485.Y sg13cmos5l_inv_1_485.A 0.20065f
C677 sg13cmos5l_inv_1_17.Y VPWR 0.42293f
C678 sg13cmos5l_inv_1_376.A sg13cmos5l_inv_1_362.A 0.18356f
C679 sg13cmos5l_inv_1_382.A a_8638_6558# 0.02074f
C680 a_8327_6558# sg13cmos5l_mux4_1_16.A2 0.222f
C681 sg13cmos5l_mux4_1_8.A1 sg13cmos5l_inv_1_627.A 0.11183f
C682 sg13cmos5l_inv_1_78.A sg13cmos5l_inv_1_75.A 0.22683f
C683 sg13cmos5l_inv_1_1004.Y VPWR 0.40764f
C684 sg13cmos5l_inv_1_340.Y sg13cmos5l_inv_1_283.A 0.16447f
C685 sg13cmos5l_inv_1_1002.A sg13cmos5l_inv_1_941.A 0.29479f
C686 sg13cmos5l_inv_1_159.A sg13cmos5l_inv_1_159.Y 0.1913f
C687 sg13cmos5l_inv_1_929.A sg13cmos5l_inv_1_202.Y 0.01248f
C688 sg13cmos5l_inv_1_394.Y sg13cmos5l_inv_1_397.Y 0.09557f
C689 sg13cmos5l_inv_1_403.A VPWR 0.48589f
C690 sg13cmos5l_inv_1_328.Y sg13cmos5l_inv_1_336.A 0.40751f
C691 sg13cmos5l_inv_1_320.A sg13cmos5l_inv_1_321.A 0.1968f
C692 sg13cmos5l_inv_1_186.A sg13cmos5l_inv_1_213.Y 0.23483f
C693 sg13cmos5l_inv_1_30.A a_18176_4742# 0.0147f
C694 sg13cmos5l_inv_1_99.Y sg13cmos5l_inv_1_98.Y 0.11738f
C695 sg13cmos5l_inv_1_664.A VPWR 0.47603f
C696 sg13cmos5l_inv_1_296.Y sg13cmos5l_inv_1_453.A 0.01481f
C697 sg13cmos5l_mux2_1_3.A0 a_9982_8050# 0.10047f
C698 sg13cmos5l_inv_1_416.A sg13cmos5l_inv_1_417.Y 0.01418f
C699 a_13288_9278# a_13472_9278# 0.11523f
C700 sg13cmos5l_inv_1_319.Y VPWR 0.47603f
C701 a_4798_12970# VPWR 0.11691f
C702 sg13cmos5l_inv_1_248.A sg13cmos5l_inv_1_447.A 0.02485f
C703 sg13cmos5l_inv_1_933.A VPWR 0.41671f
C704 sg13cmos5l_buf_1_8.A sg13cmos5l_inv_1_518.Y 0.02969f
C705 sg13cmos5l_inv_1_314.Y VPWR 0.42645f
C706 sg13cmos5l_mux2_1_3.S sg13cmos5l_inv_1_124.A 0.29609f
C707 sg13cmos5l_inv_1_543.Y VPWR 0.35771f
C708 sg13cmos5l_inv_1_532.Y a_4438_12606# 0.22149f
C709 sg13cmos5l_inv_1_107.Y sg13cmos5l_inv_1_217.A 0.13962f
C710 sg13cmos5l_buf_1_8.A sg13cmos5l_inv_1_179.A 1.1714f
C711 a_13472_8562# VPWR 0.06615f
C712 sg13cmos5l_inv_1_74.A VPWR 0.44951f
C713 sg13cmos5l_inv_1_895.Y sg13cmos5l_inv_1_891.Y 0.20065f
C714 sg13cmos5l_inv_1_86.Y sg13cmos5l_inv_1_66.A 0.0113f
C715 sg13cmos5l_inv_1_72.Y a_11456_1718# 0.01054f
C716 a_9948_10240# VPWR 0.01158f
C717 sg13cmos5l_inv_1_1011.A a_8086_3534# 0.01346f
C718 sg13cmos5l_inv_1_790.Y a_11464_16838# 0.01986f
C719 sg13cmos5l_mux4_1_5.S0 sg13cmos5l_inv_1_474.Y 0.15844f
C720 sg13cmos5l_inv_1_241.Y sg13cmos5l_inv_1_277.A 0.02841f
C721 sg13cmos5l_inv_1_100.A sg13cmos5l_inv_1_63.A 0.0328f
C722 sg13cmos5l_mux4_1_14.A1 sg13cmos5l_inv_1_779.A 0.31487f
C723 sg13cmos5l_inv_1_264.A sg13cmos5l_inv_1_286.Y 0.01506f
C724 sg13cmos5l_nor3_1_1.Y VPWR 0.37565f
C725 sg13cmos5l_inv_1_350.Y sg13cmos5l_inv_1_350.A 0.16776f
C726 sg13cmos5l_inv_1_236.Y a_11456_4742# 0.01162f
C727 sg13cmos5l_inv_1_731.A sg13cmos5l_inv_1_938.Y 0.24406f
C728 sg13cmos5l_inv_1_949.Y VPWR 0.4512f
C729 sg13cmos5l_mux4_1_13.A0 a_13895_15630# 0.24362f
C730 sg13cmos5l_inv_1_986.Y sg13cmos5l_inv_1_159.A 0.01563f
C731 sg13cmos5l_inv_1_308.Y a_800_1002# 0.01203f
C732 sg13cmos5l_inv_1_848.Y sg13cmos5l_inv_1_836.Y 0.3914f
C733 sg13cmos5l_mux2_1_1.X sg13cmos5l_inv_1_964.A 0.01904f
C734 sg13cmos5l_mux2_1_2.A0 sg13cmos5l_inv_1_645.Y 0.01905f
C735 sg13cmos5l_inv_1_627.A sg13cmos5l_inv_1_616.Y 0.01224f
C736 sg13cmos5l_inv_1_510.A sg13cmos5l_nor3_1_2.B 0.03454f
C737 sg13cmos5l_inv_1_433.Y sg13cmos5l_inv_1_416.A 0.01253f
C738 sg13cmos5l_inv_1_439.Y sg13cmos5l_inv_1_450.Y 0.10308f
C739 sg13cmos5l_inv_1_439.A sg13cmos5l_inv_1_434.A 0.02403f
C740 sg13cmos5l_inv_1_322.A a_3623_3534# 0.23032f
C741 sg13cmos5l_inv_1_845.Y VPWR 0.42588f
C742 sg13cmos5l_inv_1_775.A a_12136_17634# 0.01954f
C743 sg13cmos5l_mux2_1_4.S sg13cmos5l_inv_1_227.A 0.31745f
C744 sg13cmos5l_inv_1_241.A sg13cmos5l_inv_1_288.Y 0.01349f
C745 sg13cmos5l_inv_1_769.Y sg13cmos5l_inv_1_771.Y 0.01439f
C746 sg13cmos5l_inv_1_134.Y sg13cmos5l_inv_1_78.A 0.01203f
C747 sg13cmos5l_inv_1_828.Y sg13cmos5l_inv_1_771.A 1.37788f
C748 sg13cmos5l_buf_1_8.A sg13cmos5l_inv_1_159.A 0.03543f
C749 sg13cmos5l_inv_1_879.A a_16456_14610# 0.07657f
C750 sg13cmos5l_inv_1_594.Y VPWR 0.42419f
C751 a_19048_5538# VPWR 0.12296f
C752 sg13cmos5l_mux4_1_15.A2 a_15489_9540# 0.04623f
C753 sg13cmos5l_inv_1_467.Y a_5024_9278# 0.03803f
C754 sg13cmos5l_mux2_1_3.S a_9544_10074# 0.01055f
C755 sg13cmos5l_inv_1_753.A a_11656_12302# 0.0477f
C756 sg13cmos5l_inv_1_312.Y sg13cmos5l_inv_1_313.Y 0.11854f
C757 sg13cmos5l_inv_1_525.A a_3623_12606# 0.19723f
C758 sg13cmos5l_inv_1_534.Y VPWR 0.63917f
C759 sg13cmos5l_mux4_1_5.S0 sg13cmos5l_inv_1_403.Y 0.02989f
C760 sg13cmos5l_inv_1_702.Y sg13cmos5l_mux4_1_15.A3 0.10487f
C761 sg13cmos5l_inv_1_171.Y sg13cmos5l_inv_1_177.Y 0.01186f
C762 sg13cmos5l_buf_1_9.A sg13cmos5l_inv_1_364.A 0.01211f
C763 sg13cmos5l_inv_1_225.A VPWR 0.44925f
C764 sg13cmos5l_inv_1_305.Y a_808_6254# 0.01154f
C765 a_5032_1718# VPWR 0.13725f
C766 sg13cmos5l_mux2_1_4.S a_14614_3534# 0.07587f
C767 sg13cmos5l_inv_1_966.Y sg13cmos5l_inv_1_356.A 0.01224f
C768 sg13cmos5l_inv_1_553.Y sg13cmos5l_inv_1_573.A 0.03558f
C769 a_18856_16752# osc_tap[6] 0.28823f
C770 sg13cmos5l_inv_1_422.A sg13cmos5l_inv_1_423.A 0.16897f
C771 sg13cmos5l_inv_1_198.Y sg13cmos5l_inv_1_28.A 0.01236f
C772 a_7271_3534# a_7700_3534# 0.0289f
C773 sg13cmos5l_inv_1_1011.A a_7582_3534# 0.15609f
C774 sg13cmos5l_mux4_1_5.S0 a_8327_6558# 0.53387f
C775 sg13cmos5l_inv_1_889.Y sg13cmos5l_inv_1_745.A 0.16387f
C776 sg13cmos5l_inv_1_280.Y sg13cmos5l_inv_1_278.Y 0.11183f
C777 a_3623_12606# VPWR 0.48605f
C778 sg13cmos5l_inv_1_909.A sg13cmos5l_inv_1_745.A 0.11183f
C779 sg13cmos5l_nand2_1_1.B sg13cmos5l_inv_1_997.A 0.01571f
C780 sg13cmos5l_inv_1_875.A a_19136_15326# 0.01054f
C781 sg13cmos5l_a22oi_1_0.B1 sg13cmos5l_a22oi_1_0.A1 0.17739f
C782 sg13cmos5l_inv_1_492.A sg13cmos5l_inv_1_493.A 0.20065f
C783 sg13cmos5l_inv_1_688.A a_4928_17634# 0.03646f
C784 sg13cmos5l_inv_1_828.Y sg13cmos5l_buf_1_21.A 0.09639f
C785 sg13cmos5l_buf_1_9.A sg13cmos5l_inv_1_169.Y 0.07226f
C786 sg13cmos5l_or2_1_0.B a_14027_11654# 0.22317f
C787 sg13cmos5l_inv_1_582.A sg13cmos5l_inv_1_636.A 0.01415f
C788 sg13cmos5l_inv_1_254.Y VPWR 0.42515f
C789 sg13cmos5l_inv_1_811.Y sg13cmos5l_inv_1_798.Y 0.20552f
C790 sg13cmos5l_buf_1_19.A a_19048_12302# 0.05868f
C791 sg13cmos5l_inv_1_451.A VPWR 0.59003f
C792 sg13cmos5l_inv_1_100.A sg13cmos5l_inv_1_102.Y 0.29147f
C793 sg13cmos5l_inv_1_337.A sg13cmos5l_inv_1_323.A 0.09569f
C794 sg13cmos5l_inv_1_334.A a_1664_3230# 0.047f
C795 sg13cmos5l_inv_1_828.Y sg13cmos5l_inv_1_835.A 0.02738f
C796 a_1952_16122# VPWR 0.07767f
C797 sg13cmos5l_inv_1_301.A sg13cmos5l_inv_1_295.A 0.04887f
C798 sg13cmos5l_inv_1_788.Y sg13cmos5l_inv_1_789.Y 0.20065f
C799 sg13cmos5l_buf_1_12.X sg13cmos5l_inv_1_394.Y 0.52997f
C800 sg13cmos5l_inv_1_249.Y sg13cmos5l_inv_1_247.A 0.03913f
C801 sg13cmos5l_inv_1_270.Y sg13cmos5l_inv_1_448.A 0.03067f
C802 sg13cmos5l_inv_1_69.A sg13cmos5l_inv_1_239.A 0.03048f
C803 sg13cmos5l_mux4_1_16.X VPWR 0.40392f
C804 sg13cmos5l_inv_1_445.A a_9142_6558# 0.23471f
C805 sg13cmos5l_inv_1_207.A sg13cmos5l_inv_1_209.Y 0.19385f
C806 sg13cmos5l_inv_1_207.Y sg13cmos5l_inv_1_212.Y 0.10109f
C807 sg13cmos5l_inv_1_655.Y VPWR 0.4211f
C808 sg13cmos5l_inv_1_149.A sg13cmos5l_inv_1_148.A 0.19657f
C809 sg13cmos5l_inv_1_441.A sg13cmos5l_inv_1_414.A 0.33248f
C810 sg13cmos5l_inv_1_553.Y sg13cmos5l_inv_1_557.Y 0.05866f
C811 sg13cmos5l_o21ai_1_0.B1 sg13cmos5l_inv_1_990.A 0.46921f
C812 sg13cmos5l_inv_1_807.Y a_13472_17634# 0.03465f
C813 sg13cmos5l_inv_1_921.Y sg13cmos5l_inv_1_984.Y 0.01112f
C814 sg13cmos5l_inv_1_983.Y sg13cmos5l_inv_1_969.Y 0.21522f
C815 sg13cmos5l_mux4_1_15.A2 sg13cmos5l_inv_1_956.Y 0.01788f
C816 sg13cmos5l_inv_1_483.Y sg13cmos5l_inv_1_677.Y 0.14831f
C817 sg13cmos5l_nand2_1_1.B sg13cmos5l_inv_1_926.Y 0.03029f
C818 sg13cmos5l_inv_1_489.A sg13cmos5l_inv_1_474.Y 0.01347f
C819 VPWR enable 0.10557f
C820 sg13cmos5l_inv_1_809.Y sg13cmos5l_inv_1_806.Y 0.45506f
C821 sg13cmos5l_inv_1_775.Y a_12136_17634# 0.03533f
C822 sg13cmos5l_a21oi_1_1.A2 sg13cmos5l_inv_1_949.Y 0.16168f
C823 sg13cmos5l_inv_1_598.A a_9256_18350# 0.02292f
C824 sg13cmos5l_inv_1_606.A sg13cmos5l_inv_1_772.A 0.15638f
C825 sg13cmos5l_mux2_1_4.S a_15105_3492# 0.20983f
C826 a_12808_7050# a_12808_6254# 0.01095f
C827 sg13cmos5l_nand2_1_1.B sg13cmos5l_inv_1_503.Y 0.05131f
C828 sg13cmos5l_inv_1_560.A sg13cmos5l_inv_1_610.A 0.0122f
C829 sg13cmos5l_inv_1_562.Y a_4264_16838# 0.02014f
C830 sg13cmos5l_inv_1_535.Y sg13cmos5l_mux4_1_5.S0 0.11145f
C831 sg13cmos5l_inv_1_523.Y a_4438_12606# 0.02697f
C832 a_3623_12606# a_3860_12606# 0.01012f
C833 sg13cmos5l_inv_1_1011.A a_9432_3406# 0.1983f
C834 a_16075_7649# a_16828_8070# 0.01012f
C835 sg13cmos5l_mux4_1_5.S0 sg13cmos5l_inv_1_326.Y 0.08283f
C836 sg13cmos5l_buf_1_10.A sg13cmos5l_inv_1_459.A 0.06113f
C837 sg13cmos5l_inv_1_100.A sg13cmos5l_inv_1_185.Y 0.09475f
C838 sg13cmos5l_inv_1_231.Y a_15104_4742# 0.03508f
C839 sg13cmos5l_mux4_1_0.A0 a_16075_7649# 0.2592f
C840 sg13cmos5l_inv_1_113.A sg13cmos5l_inv_1_169.Y 0.01358f
C841 sg13cmos5l_inv_1_475.Y VPWR 0.42334f
C842 sg13cmos5l_mux4_1_5.S1 a_13664_3230# 0.04047f
C843 a_14023_3195# VPWR 0.02744f
C844 sg13cmos5l_inv_1_889.A a_13607_14482# 0.04706f
C845 sg13cmos5l_inv_1_787.Y sg13cmos5l_inv_1_874.Y 0.31799f
C846 sg13cmos5l_inv_1_348.A sg13cmos5l_inv_1_348.Y 0.2023f
C847 sg13cmos5l_inv_1_349.A a_1576_6254# 0.03921f
C848 sg13cmos5l_inv_1_69.A sg13cmos5l_inv_1_260.Y 0.20119f
C849 sg13cmos5l_a22oi_1_0.A1 sg13cmos5l_inv_1_491.A 0.0271f
C850 sg13cmos5l_inv_1_714.A a_18088_12302# 0.02316f
C851 a_18664_6956# a_19048_7050# 0.03269f
C852 sg13cmos5l_inv_1_1004.Y sg13cmos5l_mux4_1_16.A2 0.02964f
C853 sg13cmos5l_nand2_1_1.Y VPWR 0.73192f
C854 sg13cmos5l_inv_1_556.Y sg13cmos5l_inv_1_585.A 0.01496f
C855 sg13cmos5l_inv_1_319.Y a_4072_3932# 0.02112f
C856 sg13cmos5l_o21ai_1_0.B1 sg13cmos5l_inv_1_504.A 0.03569f
C857 a_19048_16122# VPWR 0.12794f
C858 sg13cmos5l_nor3_1_2.B sg13cmos5l_inv_1_756.Y 0.02562f
C859 sg13cmos5l_inv_1_550.Y sg13cmos5l_inv_1_553.A 0.01017f
C860 sg13cmos5l_inv_1_7.A sg13cmos5l_inv_1_5.Y 0.19251f
C861 sg13cmos5l_a21oi_1_0.B1 sg13cmos5l_inv_1_689.A 0.17389f
C862 sg13cmos5l_mux4_1_5.S1 sg13cmos5l_inv_1_411.Y 0.13531f
C863 sg13cmos5l_buf_1_10.A sg13cmos5l_inv_1_317.Y 0.0682f
C864 sg13cmos5l_inv_1_445.A a_9633_6516# 0.01269f
C865 sg13cmos5l_inv_1_807.Y VPWR 0.54553f
C866 sg13cmos5l_inv_1_608.A VPWR 0.58429f
C867 sg13cmos5l_inv_1_217.A VPWR 1.09686f
C868 a_3304_2514# VPWR 0.12923f
C869 sg13cmos5l_inv_1_82.A sg13cmos5l_inv_1_102.Y 0.03284f
C870 sg13cmos5l_inv_1_17.A VPWR 0.58473f
C871 sg13cmos5l_inv_1_640.A sg13cmos5l_inv_1_641.A 0.21202f
C872 sg13cmos5l_inv_1_372.Y sg13cmos5l_inv_1_305.Y 0.02935f
C873 a_8680_17634# VPWR 0.18289f
C874 sg13cmos5l_mux4_1_8.A1 sg13cmos5l_inv_1_580.A 0.05362f
C875 sg13cmos5l_inv_1_683.Y sg13cmos5l_inv_1_683.A 0.15651f
C876 sg13cmos5l_inv_1_400.Y VPWR 0.41964f
C877 sg13cmos5l_inv_1_241.A sg13cmos5l_inv_1_318.Y 0.02292f
C878 sg13cmos5l_inv_1_159.A sg13cmos5l_inv_1_158.Y 0.27585f
C879 a_13607_12606# a_13918_12606# 0.49675f
C880 sg13cmos5l_inv_1_522.A VPWR 0.7278f
C881 sg13cmos5l_inv_1_30.A sg13cmos5l_inv_1_213.Y 0.02031f
C882 sg13cmos5l_inv_1_199.Y a_18176_4742# 0.03508f
C883 sg13cmos5l_inv_1_328.Y sg13cmos5l_inv_1_321.A 0.07674f
C884 sg13cmos5l_inv_1_296.Y sg13cmos5l_inv_1_295.Y 0.09917f
C885 a_6343_8701# a_6430_8434# 0.02548f
C886 sg13cmos5l_mux4_1_16.X a_9982_8050# 0.5666f
C887 a_7501_8440# a_6934_8434# 0.40359f
C888 sg13cmos5l_inv_1_305.A sg13cmos5l_inv_1_310.Y 0.06817f
C889 sg13cmos5l_buf_1_9.A sg13cmos5l_inv_1_734.A 0.01661f
C890 sg13cmos5l_inv_1_114.A a_13288_8562# 0.04353f
C891 sg13cmos5l_inv_1_426.A sg13cmos5l_inv_1_417.Y 0.02915f
C892 sg13cmos5l_inv_1_416.A sg13cmos5l_inv_1_452.Y 0.02213f
C893 sg13cmos5l_inv_1_357.A sg13cmos5l_inv_1_411.Y 0.18584f
C894 sg13cmos5l_nand2_1_1.B sg13cmos5l_inv_1_980.A 0.03255f
C895 sg13cmos5l_o21ai_1_0.B1 sg13cmos5l_mux4_1_9.A0 0.20924f
C896 sg13cmos5l_inv_1_933.Y VPWR 0.41658f
C897 sg13cmos5l_buf_1_8.A sg13cmos5l_inv_1_520.A 0.0158f
C898 sg13cmos5l_inv_1_320.Y VPWR 0.40388f
C899 sg13cmos5l_inv_1_553.Y VPWR 0.95351f
C900 sg13cmos5l_o21ai_1_0.Y a_10050_10240# 0.02122f
C901 sg13cmos5l_inv_1_72.Y sg13cmos5l_inv_1_66.Y 0.09797f
C902 sg13cmos5l_mux4_1_15.A2 VPWR 0.47737f
C903 sg13cmos5l_inv_1_790.Y sg13cmos5l_inv_1_800.A 0.06849f
C904 sg13cmos5l_inv_1_775.Y sg13cmos5l_inv_1_794.A 0.01314f
C905 sg13cmos5l_mux4_1_5.S0 sg13cmos5l_inv_1_1007.Y 0.06776f
C906 sg13cmos5l_inv_1_274.Y sg13cmos5l_inv_1_287.Y 0.01835f
C907 sg13cmos5l_inv_1_779.Y sg13cmos5l_inv_1_779.A 1.04085f
C908 sg13cmos5l_inv_1_274.Y sg13cmos5l_mux4_1_5.X 0.02186f
C909 sg13cmos5l_inv_1_264.A sg13cmos5l_inv_1_288.Y 0.01199f
C910 a_3934_3534# a_4357_3195# 0.01929f
C911 sg13cmos5l_inv_1_350.Y sg13cmos5l_inv_1_378.Y 0.07074f
C912 sg13cmos5l_nor3_1_0.Y VPWR 0.28245f
C913 sg13cmos5l_inv_1_65.Y a_10696_1718# 0.03352f
C914 sg13cmos5l_inv_1_235.A a_12136_4742# 0.02464f
C915 sg13cmos5l_inv_1_211.Y sg13cmos5l_inv_1_209.Y 0.05311f
C916 sg13cmos5l_inv_1_898.Y VPWR 0.45342f
C917 sg13cmos5l_inv_1_988.A a_16744_10074# 0.02261f
C918 sg13cmos5l_inv_1_986.Y sg13cmos5l_inv_1_166.A 0.1911f
C919 sg13cmos5l_inv_1_643.A sg13cmos5l_inv_1_651.Y 0.04444f
C920 sg13cmos5l_o21ai_1_0.B1 sg13cmos5l_mux2_1_1.X 0.02892f
C921 a_13607_3898# VPWR 0.3925f
C922 a_8123_8472# VPWR 0.9735f
C923 sg13cmos5l_inv_1_836.A sg13cmos5l_inv_1_836.Y 0.19525f
C924 sg13cmos5l_inv_1_980.A sg13cmos5l_inv_1_964.A 0.24462f
C925 sg13cmos5l_inv_1_324.Y a_3934_3534# 0.19664f
C926 sg13cmos5l_mux2_1_2.A0 sg13cmos5l_inv_1_671.A 0.01875f
C927 sg13cmos5l_inv_1_57.Y a_13472_1002# 0.04754f
C928 sg13cmos5l_inv_1_510.A sg13cmos5l_inv_1_509.Y 0.10746f
C929 sg13cmos5l_inv_1_416.Y sg13cmos5l_inv_1_416.A 0.09102f
C930 sg13cmos5l_inv_1_124.Y a_10976_7766# 0.03539f
C931 sg13cmos5l_inv_1_439.A sg13cmos5l_inv_1_450.Y 0.24701f
C932 sg13cmos5l_inv_1_322.A sg13cmos5l_inv_1_327.A 0.11402f
C933 sg13cmos5l_inv_1_775.A sg13cmos5l_inv_1_806.Y 0.05827f
C934 sg13cmos5l_inv_1_129.A a_11944_7050# 0.0383f
C935 sg13cmos5l_inv_1_844.Y VPWR 0.42427f
C936 sg13cmos5l_mux2_1_4.S sg13cmos5l_inv_1_206.Y 0.0648f
C937 sg13cmos5l_inv_1_241.A sg13cmos5l_inv_1_282.Y 0.17136f
C938 sg13cmos5l_inv_1_88.Y sg13cmos5l_inv_1_85.Y 0.01049f
C939 sg13cmos5l_inv_1_88.A a_13607_3898# 0.04877f
C940 a_9326_3410# a_9758_3168# 0.02925f
C941 a_9432_3406# a_9498_3168# 0.03336f
C942 sg13cmos5l_inv_1_260.A a_7328_1002# 0.01054f
C943 sg13cmos5l_mux4_1_9.X a_3934_12606# 0.02141f
C944 a_13607_12606# a_13472_12302# 0.01143f
C945 a_6934_8434# a_7425_8476# 0.3824f
C946 sg13cmos5l_inv_1_205.A sg13cmos5l_inv_1_186.Y 0.02096f
C947 sg13cmos5l_inv_1_141.A sg13cmos5l_inv_1_142.A 0.17209f
C948 sg13cmos5l_inv_1_595.Y VPWR 0.42281f
C949 sg13cmos5l_mux4_1_14.A1 sg13cmos5l_inv_1_865.Y 0.01175f
C950 sg13cmos5l_inv_1_237.Y a_3934_3534# 0.05523f
C951 sg13cmos5l_inv_1_467.A a_5024_9278# 0.01153f
C952 sg13cmos5l_inv_1_467.Y sg13cmos5l_inv_1_984.Y 0.31675f
C953 sg13cmos5l_inv_1_753.A sg13cmos5l_inv_1_750.Y 0.01438f
C954 sg13cmos5l_inv_1_959.A a_11656_10074# 0.01986f
C955 sg13cmos5l_inv_1_311.A sg13cmos5l_inv_1_304.Y 0.02436f
C956 sg13cmos5l_inv_1_610.Y VPWR 0.35274f
C957 sg13cmos5l_mux4_1_5.S0 sg13cmos5l_inv_1_403.A 0.02666f
C958 sg13cmos5l_inv_1_722.Y sg13cmos5l_mux4_1_15.A3 0.01135f
C959 sg13cmos5l_inv_1_120.A sg13cmos5l_inv_1_121.Y 0.11992f
C960 sg13cmos5l_inv_1_171.Y sg13cmos5l_inv_1_182.A 0.1126f
C961 sg13cmos5l_buf_1_9.A sg13cmos5l_inv_1_368.Y 0.31606f
C962 sg13cmos5l_inv_1_305.Y sg13cmos5l_inv_1_345.Y 0.03586f
C963 sg13cmos5l_inv_1_834.Y a_18280_18264# 0.0344f
C964 sg13cmos5l_mux4_1_5.S0 sg13cmos5l_inv_1_319.Y 0.05071f
C965 a_7144_16838# VPWR 0.14851f
C966 sg13cmos5l_inv_1_610.A sg13cmos5l_inv_1_624.Y 0.01213f
C967 a_3623_3534# VPWR 0.39541f
C968 sg13cmos5l_inv_1_453.Y VPWR 0.56897f
C969 sg13cmos5l_nand2_1_1.B sg13cmos5l_inv_1_124.A 0.08595f
C970 a_3304_6254# a_3488_6254# 0.11523f
C971 sg13cmos5l_inv_1_671.A a_5024_13814# 0.03508f
C972 sg13cmos5l_mux4_1_1.A3 a_17312_3230# 0.0469f
C973 a_14110_3534# a_14837_3149# 0.01228f
C974 sg13cmos5l_buf_1_9.A sg13cmos5l_inv_1_883.A 0.01625f
C975 a_13472_13814# VPWR 0.0685f
C976 sg13cmos5l_inv_1_152.Y VPWR 0.69719f
C977 sg13cmos5l_inv_1_267.Y sg13cmos5l_inv_1_433.Y 0.16131f
C978 sg13cmos5l_inv_1_237.Y sg13cmos5l_inv_1_416.Y 0.17124f
C979 sg13cmos5l_nand2_1_1.B sg13cmos5l_inv_1_944.Y 0.03455f
C980 sg13cmos5l_mux4_1_16.X sg13cmos5l_mux4_1_16.A2 0.06069f
C981 a_19048_12302# VPWR 0.13014f
C982 sg13cmos5l_mux2_1_0.X sg13cmos5l_inv_1_78.A 0.0291f
C983 sg13cmos5l_inv_1_688.A sg13cmos5l_inv_1_562.A 0.09841f
C984 sg13cmos5l_inv_1_442.Y VPWR 0.40255f
C985 sg13cmos5l_inv_1_277.Y sg13cmos5l_inv_1_245.A 0.01149f
C986 a_17896_7050# VPWR 0.14116f
C987 sg13cmos5l_inv_1_533.Y sg13cmos5l_inv_1_535.A 1.28374f
C988 sg13cmos5l_a22oi_1_0.B1 sg13cmos5l_nor3_1_1.A 0.17981f
C989 sg13cmos5l_inv_1_436.A VPWR 0.51939f
C990 sg13cmos5l_inv_1_495.A sg13cmos5l_inv_1_498.A 0.14652f
C991 sg13cmos5l_inv_1_334.A sg13cmos5l_inv_1_323.A 0.05511f
C992 sg13cmos5l_inv_1_828.Y sg13cmos5l_inv_1_823.Y 0.05657f
C993 sg13cmos5l_inv_1_563.Y VPWR 0.39205f
C994 a_3680_10074# VPWR 0.11864f
C995 sg13cmos5l_inv_1_715.Y sg13cmos5l_inv_1_730.A 0.03551f
C996 sg13cmos5l_mux2_1_3.X sg13cmos5l_inv_1_121.Y 0.02197f
C997 sg13cmos5l_inv_1_69.A sg13cmos5l_inv_1_240.A 0.03057f
C998 sg13cmos5l_inv_1_654.Y VPWR 0.41629f
C999 sg13cmos5l_inv_1_207.A sg13cmos5l_inv_1_212.Y 0.1111f
C1000 sg13cmos5l_inv_1_305.Y sg13cmos5l_inv_1_311.A 0.08859f
C1001 sg13cmos5l_inv_1_306.A sg13cmos5l_inv_1_308.Y 0.3874f
C1002 sg13cmos5l_inv_1_645.A sg13cmos5l_mux4_1_7.A1 0.01198f
C1003 sg13cmos5l_mux2_1_4.S sg13cmos5l_nand2_1_1.B 0.11584f
C1004 sg13cmos5l_inv_1_149.A sg13cmos5l_inv_1_106.Y 0.03917f
C1005 sg13cmos5l_inv_1_429.A a_6368_4742# 0.03465f
C1006 sg13cmos5l_inv_1_441.A sg13cmos5l_inv_1_415.A 0.0962f
C1007 sg13cmos5l_inv_1_553.Y sg13cmos5l_inv_1_564.Y 0.01674f
C1008 sg13cmos5l_o21ai_1_0.B1 sg13cmos5l_inv_1_997.A 0.02962f
C1009 sg13cmos5l_inv_1_818.A a_17312_16122# 0.01054f
C1010 sg13cmos5l_inv_1_120.A VPWR 1.01597f
C1011 sg13cmos5l_nand2_1_1.B a_9544_10074# 0.03031f
C1012 sg13cmos5l_inv_1_78.A sg13cmos5l_inv_1_128.Y 0.23521f
C1013 sg13cmos5l_inv_1_483.Y sg13cmos5l_inv_1_487.A 0.13479f
C1014 sg13cmos5l_buf_1_8.A sg13cmos5l_inv_1_305.Y 0.02289f
C1015 sg13cmos5l_inv_1_570.A sg13cmos5l_mux4_1_10.A2 0.16769f
C1016 sg13cmos5l_inv_1_340.Y VPWR 0.64622f
C1017 sg13cmos5l_a21oi_1_1.A2 sg13cmos5l_inv_1_898.Y 0.05639f
C1018 sg13cmos5l_inv_1_606.A sg13cmos5l_inv_1_606.Y 0.25139f
C1019 sg13cmos5l_inv_1_257.A sg13cmos5l_inv_1_252.A 0.01015f
C1020 sg13cmos5l_nand2_1_1.B sg13cmos5l_inv_1_950.Y 0.24978f
C1021 sg13cmos5l_inv_1_534.Y sg13cmos5l_mux4_1_5.S0 1.86808f
C1022 a_9432_3406# sg13cmos5l_inv_1_278.Y 0.01135f
C1023 sg13cmos5l_inv_1_181.Y sg13cmos5l_inv_1_144.Y 0.21232f
C1024 sg13cmos5l_inv_1_480.Y sg13cmos5l_inv_1_1003.Y 0.17062f
C1025 sg13cmos5l_inv_1_922.A sg13cmos5l_inv_1_923.Y 0.11403f
C1026 a_7495_16261# VPWR 0.02431f
C1027 sg13cmos5l_inv_1_985.Y sg13cmos5l_inv_1_962.Y 0.19675f
C1028 sg13cmos5l_inv_1_391.Y a_8000_7050# 0.01054f
C1029 sg13cmos5l_inv_1_502.Y a_3592_10790# 0.02024f
C1030 sg13cmos5l_inv_1_855.Y sg13cmos5l_inv_1_854.Y 0.20065f
C1031 sg13cmos5l_buf_1_10.A sg13cmos5l_inv_1_433.Y 0.22806f
C1032 a_17888_18350# VPWR 0.07995f
C1033 sg13cmos5l_inv_1_113.A sg13cmos5l_inv_1_116.Y 0.09322f
C1034 sg13cmos5l_inv_1_473.Y VPWR 0.41398f
C1035 sg13cmos5l_mux4_1_7.A1 a_6599_12970# 0.19714f
C1036 sg13cmos5l_inv_1_16.A VPWR 0.97535f
C1037 sg13cmos5l_inv_1_902.Y a_13607_14482# 0.05715f
C1038 a_8672_15326# VPWR 0.08245f
C1039 sg13cmos5l_inv_1_349.A sg13cmos5l_inv_1_348.Y 0.03398f
C1040 a_4357_16261# a_3934_15994# 0.01929f
C1041 sg13cmos5l_inv_1_169.Y sg13cmos5l_inv_1_130.Y 0.09823f
C1042 sg13cmos5l_inv_1_762.Y sg13cmos5l_or2_1_0.B 1.1917f
C1043 sg13cmos5l_inv_1_311.Y sg13cmos5l_inv_1_266.A 0.03618f
C1044 sg13cmos5l_inv_1_69.A sg13cmos5l_inv_1_260.A 0.56987f
C1045 sg13cmos5l_a22oi_1_0.A1 sg13cmos5l_inv_1_485.A 0.01014f
C1046 sg13cmos5l_inv_1_714.A sg13cmos5l_buf_1_18.A 0.02313f
C1047 sg13cmos5l_mux2_1_4.S sg13cmos5l_inv_1_147.Y 0.0138f
C1048 sg13cmos5l_mux2_1_3.X VPWR 0.57884f
C1049 sg13cmos5l_inv_1_556.Y sg13cmos5l_inv_1_688.A 0.11745f
C1050 a_8638_6558# a_9061_6219# 0.01929f
C1051 sg13cmos5l_inv_1_575.Y sg13cmos5l_inv_1_575.A 0.13791f
C1052 sg13cmos5l_inv_1_584.A a_8086_15994# 0.06111f
C1053 a_10496_3230# VPWR 0.08408f
C1054 a_13288_7766# a_13288_7050# 0.01275f
C1055 sg13cmos5l_inv_1_819.Y sg13cmos5l_inv_1_827.Y 0.02541f
C1056 sg13cmos5l_mux4_1_5.S0 sg13cmos5l_inv_1_451.A 0.53958f
C1057 sg13cmos5l_nor3_1_2.B sg13cmos5l_inv_1_748.Y 0.02599f
C1058 sg13cmos5l_inv_1_491.A sg13cmos5l_nor3_1_1.A 0.67201f
C1059 sg13cmos5l_inv_1_7.A sg13cmos5l_inv_1_43.Y 0.18495f
C1060 a_808_1632# invsel[0] 0.33057f
C1061 sg13cmos5l_inv_1_248.A sg13cmos5l_inv_1_241.Y 0.02994f
C1062 sg13cmos5l_inv_1_707.Y sg13cmos5l_inv_1_744.Y 0.29066f
C1063 sg13cmos5l_inv_1_301.A VPWR 0.86572f
C1064 sg13cmos5l_inv_1_90.Y sg13cmos5l_inv_1_102.Y 0.22343f
C1065 sg13cmos5l_inv_1_496.A sg13cmos5l_inv_1_485.Y 0.20065f
C1066 sg13cmos5l_inv_1_220.Y VPWR 0.4951f
C1067 sg13cmos5l_inv_1_617.A VPWR 0.42417f
C1068 sg13cmos5l_inv_1_399.Y VPWR 0.4272f
C1069 sg13cmos5l_buf_1_12.X sg13cmos5l_inv_1_404.Y 0.02388f
C1070 a_4929_12564# sg13cmos5l_inv_1_483.Y 0.03603f
C1071 sg13cmos5l_inv_1_328.Y sg13cmos5l_inv_1_320.A 0.18683f
C1072 sg13cmos5l_buf_1_9.A sg13cmos5l_inv_1_938.Y 0.36568f
C1073 sg13cmos5l_mux2_1_4.X sg13cmos5l_inv_1_279.Y 0.02488f
C1074 sg13cmos5l_inv_1_416.A sg13cmos5l_inv_1_266.Y 0.01512f
C1075 sg13cmos5l_inv_1_426.A sg13cmos5l_inv_1_452.Y 0.41474f
C1076 a_9709_6442# VPWR 0.12253f
C1077 a_4438_3534# VPWR 0.03477f
C1078 sg13cmos5l_inv_1_163.Y sg13cmos5l_inv_1_161.Y 0.20065f
C1079 sg13cmos5l_nand2_1_1.B sg13cmos5l_inv_1_923.Y 0.18784f
C1080 sg13cmos5l_o21ai_1_0.B1 sg13cmos5l_inv_1_666.Y 0.01463f
C1081 sg13cmos5l_inv_1_935.A VPWR 0.42599f
C1082 sg13cmos5l_inv_1_507.A a_2632_10790# 0.04417f
C1083 sg13cmos5l_buf_1_8.A sg13cmos5l_inv_1_518.A 0.01673f
C1084 sg13cmos5l_inv_1_622.Y sg13cmos5l_inv_1_619.A 0.13361f
C1085 sg13cmos5l_inv_1_532.Y a_3623_12606# 0.1008f
C1086 sg13cmos5l_buf_1_8.A a_16075_7649# 0.5622f
C1087 sg13cmos5l_buf_1_8.A sg13cmos5l_inv_1_347.Y 0.18244f
C1088 sg13cmos5l_inv_1_16.Y sg13cmos5l_inv_1_3.Y 0.21017f
C1089 sg13cmos5l_inv_1_894.Y sg13cmos5l_inv_1_895.Y 0.20065f
C1090 a_7271_3534# sg13cmos5l_inv_1_258.A 0.20572f
C1091 sg13cmos5l_inv_1_295.A sg13cmos5l_inv_1_300.Y 0.17068f
C1092 sg13cmos5l_mux4_1_5.S0 sg13cmos5l_inv_1_475.Y 0.08966f
C1093 sg13cmos5l_inv_1_837.Y a_17896_17634# 0.01986f
C1094 sg13cmos5l_mux4_1_1.X a_15105_3492# 0.20262f
C1095 sg13cmos5l_inv_1_274.Y sg13cmos5l_inv_1_292.Y 0.12563f
C1096 sg13cmos5l_inv_1_780.A sg13cmos5l_inv_1_779.A 0.1983f
C1097 sg13cmos5l_inv_1_265.A sg13cmos5l_inv_1_288.Y 0.01353f
C1098 sg13cmos5l_inv_1_326.Y a_3488_2514# 0.0365f
C1099 sg13cmos5l_inv_1_1.Y a_19136_2514# 0.03553f
C1100 sg13cmos5l_nor4_1_0.A VPWR 0.33298f
C1101 sg13cmos5l_inv_1_981.Y sg13cmos5l_inv_1_70.A 0.01972f
C1102 sg13cmos5l_inv_1_981.A a_10696_1718# 0.02464f
C1103 sg13cmos5l_a22oi_1_0.B1 sg13cmos5l_inv_1_495.A 0.01522f
C1104 sg13cmos5l_inv_1_211.Y sg13cmos5l_inv_1_212.Y 0.03647f
C1105 sg13cmos5l_inv_1_235.A sg13cmos5l_inv_1_228.A 0.01725f
C1106 sg13cmos5l_mux4_1_11.A1 sg13cmos5l_inv_1_744.Y 0.02313f
C1107 sg13cmos5l_nor3_1_2.B sg13cmos5l_inv_1_733.A 0.06413f
C1108 a_14422_3898# VPWR 0.02985f
C1109 sg13cmos5l_inv_1_369.A sg13cmos5l_inv_1_305.Y 0.04666f
C1110 sg13cmos5l_inv_1_886.Y VPWR 0.42841f
C1111 sg13cmos5l_inv_1_36.A sg13cmos5l_inv_1_1.Y 0.11571f
C1112 sg13cmos5l_inv_1_928.A sg13cmos5l_inv_1_159.A 0.03544f
C1113 sg13cmos5l_inv_1_267.Y sg13cmos5l_inv_1_452.Y 0.16938f
C1114 a_13472_13098# VPWR 0.06706f
C1115 sg13cmos5l_buf_1_0.A sg13cmos5l_inv_1_1.Y 0.06491f
C1116 sg13cmos5l_inv_1_112.A sg13cmos5l_inv_1_122.Y 0.06592f
C1117 sg13cmos5l_o21ai_1_0.B1 sg13cmos5l_inv_1_980.A 0.03973f
C1118 sg13cmos5l_inv_1_306.Y sg13cmos5l_inv_1_308.Y 0.01629f
C1119 sg13cmos5l_nor3_1_2.B sg13cmos5l_mux4_1_15.A3 0.01454f
C1120 sg13cmos5l_inv_1_85.Y VPWR 0.63515f
C1121 sg13cmos5l_mux4_1_6.X VPWR 0.30246f
C1122 sg13cmos5l_inv_1_836.A sg13cmos5l_inv_1_848.Y 0.18321f
C1123 sg13cmos5l_inv_1_337.Y a_3304_3230# 0.01986f
C1124 sg13cmos5l_inv_1_961.Y a_16456_9278# 0.03064f
C1125 sg13cmos5l_nor3_1_2.B sg13cmos5l_a22oi_1_0.B1 0.03732f
C1126 a_3488_9278# VPWR 0.07304f
C1127 sg13cmos5l_inv_1_416.Y sg13cmos5l_inv_1_426.A 0.03365f
C1128 sg13cmos5l_mux2_1_3.X a_9982_8050# 0.24505f
C1129 sg13cmos5l_inv_1_439.A sg13cmos5l_inv_1_439.Y 0.23337f
C1130 sg13cmos5l_mux2_1_4.X a_9432_3406# 0.01517f
C1131 sg13cmos5l_inv_1_775.A sg13cmos5l_inv_1_804.A 0.04082f
C1132 sg13cmos5l_mux2_1_4.S sg13cmos5l_inv_1_225.Y 0.03331f
C1133 sg13cmos5l_inv_1_241.A sg13cmos5l_inv_1_293.Y 0.08201f
C1134 sg13cmos5l_inv_1_88.A sg13cmos5l_inv_1_85.Y 0.09642f
C1135 sg13cmos5l_inv_1_637.A sg13cmos5l_mux4_1_7.A3 0.38621f
C1136 sg13cmos5l_inv_1_596.Y VPWR 0.42357f
C1137 sg13cmos5l_mux4_1_14.A1 sg13cmos5l_inv_1_792.Y 0.34475f
C1138 sg13cmos5l_buf_1_9.A sg13cmos5l_inv_1_787.Y 0.53623f
C1139 a_13288_1002# VPWR 0.12492f
C1140 sg13cmos5l_inv_1_467.Y sg13cmos5l_inv_1_969.Y 0.05858f
C1141 sg13cmos5l_inv_1_467.A sg13cmos5l_inv_1_984.Y 0.09642f
C1142 a_4929_3492# VPWR 0.7084f
C1143 sg13cmos5l_inv_1_51.A a_18272_3230# 0.04587f
C1144 sg13cmos5l_inv_1_328.A sg13cmos5l_inv_1_309.Y 0.02398f
C1145 sg13cmos5l_inv_1_592.A VPWR 0.49017f
C1146 sg13cmos5l_inv_1_161.Y sg13cmos5l_inv_1_182.A 0.01842f
C1147 a_12808_12302# a_12808_11586# 0.01275f
C1148 sg13cmos5l_buf_1_9.A sg13cmos5l_inv_1_363.Y 0.03526f
C1149 sg13cmos5l_inv_1_305.Y sg13cmos5l_inv_1_345.A 0.11033f
C1150 sg13cmos5l_inv_1_612.A VPWR 0.41255f
C1151 sg13cmos5l_inv_1_327.A VPWR 1.00641f
C1152 sg13cmos5l_inv_1_256.A VPWR 0.43136f
C1153 sg13cmos5l_inv_1_963.Y sg13cmos5l_inv_1_356.Y 0.01224f
C1154 sg13cmos5l_inv_1_49.A a_17512_2514# 0.05578f
C1155 sg13cmos5l_nor2b_1_0.B_N VPWR 0.60897f
C1156 sg13cmos5l_inv_1_404.Y sg13cmos5l_inv_1_391.A 0.01075f
C1157 sg13cmos5l_inv_1_287.A a_7582_3534# 0.02704f
C1158 a_15275_7644# a_15637_8028# 0.48298f
C1159 sg13cmos5l_inv_1_671.A sg13cmos5l_inv_1_645.Y 0.2026f
C1160 sg13cmos5l_inv_1_553.Y sg13cmos5l_mux4_1_5.S0 0.01313f
C1161 sg13cmos5l_inv_1_36.Y sg13cmos5l_inv_1_36.A 0.10977f
C1162 sg13cmos5l_inv_1_279.Y sg13cmos5l_inv_1_280.Y 0.20065f
C1163 sg13cmos5l_mux4_1_5.S1 sg13cmos5l_mux4_1_1.A3 0.0473f
C1164 sg13cmos5l_inv_1_267.Y sg13cmos5l_inv_1_416.Y 0.02618f
C1165 sg13cmos5l_inv_1_237.Y sg13cmos5l_inv_1_427.A 0.32576f
C1166 sg13cmos5l_inv_1_286.Y sg13cmos5l_inv_1_287.A 0.11317f
C1167 sg13cmos5l_nor3_1_2.B sg13cmos5l_mux4_1_12.A3 0.03659f
C1168 sg13cmos5l_mux4_1_5.S1 sg13cmos5l_buf_1_0.A 0.01859f
C1169 sg13cmos5l_inv_1_442.A VPWR 0.39943f
C1170 sg13cmos5l_buf_1_10.A sg13cmos5l_inv_1_452.Y 0.01198f
C1171 sg13cmos5l_inv_1_277.A sg13cmos5l_inv_1_245.A 0.01738f
C1172 sg13cmos5l_inv_1_217.A sg13cmos5l_inv_1_218.A 0.15065f
C1173 sg13cmos5l_inv_1_419.A VPWR 0.35042f
C1174 sg13cmos5l_inv_1_828.Y sg13cmos5l_inv_1_838.Y 0.02353f
C1175 sg13cmos5l_inv_1_1012.Y VPWR 0.5143f
C1176 sg13cmos5l_inv_1_702.Y sg13cmos5l_inv_1_730.A 0.09993f
C1177 sg13cmos5l_inv_1_964.Y a_8968_9278# 0.034f
C1178 sg13cmos5l_inv_1_69.A sg13cmos5l_inv_1_240.Y 0.03071f
C1179 sg13cmos5l_inv_1_207.A sg13cmos5l_inv_1_207.Y 0.23351f
C1180 a_8327_6558# a_9142_6558# 0.49917f
C1181 sg13cmos5l_inv_1_680.Y sg13cmos5l_o21ai_1_0.B1 0.40027f
C1182 sg13cmos5l_inv_1_305.A sg13cmos5l_inv_1_326.Y 1.99309f
C1183 sg13cmos5l_inv_1_304.A sg13cmos5l_inv_1_308.Y 0.10017f
C1184 sg13cmos5l_inv_1_306.A sg13cmos5l_inv_1_306.Y 0.23014f
C1185 sg13cmos5l_mux4_1_12.A3 sg13cmos5l_mux4_1_11.A2 0.01759f
C1186 sg13cmos5l_inv_1_553.Y sg13cmos5l_inv_1_564.A 0.13564f
C1187 sg13cmos5l_nor3_1_2.B sg13cmos5l_inv_1_491.A 0.20222f
C1188 sg13cmos5l_o21ai_1_0.B1 sg13cmos5l_inv_1_944.Y 0.02342f
C1189 a_14827_11673# sg13cmos5l_inv_1_699.A 0.08502f
C1190 a_3934_12606# a_3847_12267# 0.02548f
C1191 sg13cmos5l_inv_1_875.Y sg13cmos5l_mux4_1_13.A3 0.28114f
C1192 a_18176_10074# VPWR 0.07795f
C1193 sg13cmos5l_inv_1_682.A sg13cmos5l_inv_1_664.A 0.06901f
C1194 sg13cmos5l_inv_1_483.Y sg13cmos5l_inv_1_677.A 0.01942f
C1195 sg13cmos5l_inv_1_520.A a_4640_10790# 0.01054f
C1196 sg13cmos5l_inv_1_421.Y sg13cmos5l_inv_1_422.A 0.64537f
C1197 sg13cmos5l_inv_1_544.Y sg13cmos5l_mux4_1_10.A2 0.01493f
C1198 sg13cmos5l_inv_1_775.Y sg13cmos5l_inv_1_804.A 0.1124f
C1199 sg13cmos5l_inv_1_182.A sg13cmos5l_inv_1_177.Y 0.19459f
C1200 sg13cmos5l_inv_1_44.A sg13cmos5l_inv_1_36.Y 0.16708f
C1201 sg13cmos5l_buf_1_12.X sg13cmos5l_inv_1_375.Y 0.07819f
C1202 a_13607_14482# a_13844_14482# 0.01012f
C1203 sg13cmos5l_inv_1_598.A sg13cmos5l_inv_1_606.Y 0.0542f
C1204 sg13cmos5l_inv_1_560.Y sg13cmos5l_inv_1_562.Y 0.13271f
C1205 sg13cmos5l_inv_1_429.A sg13cmos5l_inv_1_264.A 0.0123f
C1206 a_3623_12606# sg13cmos5l_inv_1_523.Y 0.2057f
C1207 sg13cmos5l_mux4_1_8.A0 a_10496_16838# 0.04614f
C1208 sg13cmos5l_inv_1_922.A sg13cmos5l_inv_1_922.Y 0.19743f
C1209 sg13cmos5l_inv_1_389.Y a_8000_7050# 0.03553f
C1210 sg13cmos5l_mux4_1_5.S0 a_3623_3534# 0.58038f
C1211 sg13cmos5l_inv_1_1009.Y a_3592_10790# 0.03921f
C1212 sg13cmos5l_inv_1_792.Y sg13cmos5l_mux4_1_13.A0 0.04224f
C1213 sg13cmos5l_inv_1_502.Y sg13cmos5l_inv_1_500.Y 0.20209f
C1214 sg13cmos5l_buf_1_10.A sg13cmos5l_inv_1_416.Y 0.02498f
C1215 sg13cmos5l_inv_1_114.Y sg13cmos5l_mux4_1_5.S1 1.03592f
C1216 sg13cmos5l_inv_1_824.A VPWR 0.72475f
C1217 sg13cmos5l_inv_1_111.A sg13cmos5l_inv_1_111.Y 0.16831f
C1218 sg13cmos5l_inv_1_113.A sg13cmos5l_inv_1_115.Y 0.37553f
C1219 sg13cmos5l_inv_1_663.Y VPWR 0.44664f
C1220 sg13cmos5l_inv_1_676.Y a_6376_13098# 0.01059f
C1221 sg13cmos5l_mux4_1_0.A0 a_15608_7680# 0.01105f
C1222 a_8776_5538# VPWR 0.1496f
C1223 sg13cmos5l_mux4_1_15.X sg13cmos5l_inv_1_961.Y 0.04072f
C1224 sg13cmos5l_inv_1_55.Y VPWR 0.61813f
C1225 sg13cmos5l_inv_1_902.Y sg13cmos5l_inv_1_889.A 0.43703f
C1226 sg13cmos5l_inv_1_642.Y VPWR 0.55619f
C1227 sg13cmos5l_inv_1_349.A sg13cmos5l_inv_1_348.A 0.23205f
C1228 a_808_10790# VPWR 0.12719f
C1229 sg13cmos5l_inv_1_761.A sg13cmos5l_or2_1_0.B 0.02257f
C1230 sg13cmos5l_nor3_1_0.Y a_9443_9192# 0.02535f
C1231 sg13cmos5l_inv_1_908.A a_11176_13814# 0.03631f
C1232 sg13cmos5l_inv_1_78.A a_18664_6956# 0.33473f
C1233 sg13cmos5l_mux2_1_4.S sg13cmos5l_inv_1_148.Y 0.19185f
C1234 sg13cmos5l_inv_1_566.A sg13cmos5l_inv_1_575.A 0.01329f
C1235 sg13cmos5l_inv_1_118.A a_12896_7766# 0.03589f
C1236 sg13cmos5l_mux4_1_13.A3 VPWR 0.59273f
C1237 sg13cmos5l_mux4_1_5.S0 sg13cmos5l_inv_1_436.A 0.02309f
C1238 sg13cmos5l_inv_1_826.Y sg13cmos5l_inv_1_827.Y 0.014f
C1239 sg13cmos5l_nor3_1_2.B sg13cmos5l_inv_1_748.A 0.02141f
C1240 sg13cmos5l_inv_1_551.Y sg13cmos5l_inv_1_533.Y 0.01177f
C1241 sg13cmos5l_inv_1_802.A sg13cmos5l_inv_1_883.A 0.01367f
C1242 sg13cmos5l_inv_1_248.A sg13cmos5l_inv_1_268.A 0.01779f
C1243 sg13cmos5l_inv_1_382.Y a_8104_6254# 0.0363f
C1244 sg13cmos5l_mux4_1_16.A2 a_9709_6442# 0.01059f
C1245 a_13607_12606# VPWR 0.4976f
C1246 sg13cmos5l_inv_1_914.A sg13cmos5l_inv_1_744.Y 0.01989f
C1247 sg13cmos5l_mux2_1_3.A0 sg13cmos5l_inv_1_78.A 0.02237f
C1248 sg13cmos5l_mux4_1_5.S1 a_7271_3534# 0.01344f
C1249 sg13cmos5l_inv_1_59.Y VPWR 1.10113f
C1250 sg13cmos5l_inv_1_58.Y VPWR 0.53926f
C1251 sg13cmos5l_inv_1_394.A a_6934_8434# 0.23246f
C1252 sg13cmos5l_inv_1_639.A sg13cmos5l_inv_1_640.A 0.20065f
C1253 sg13cmos5l_inv_1_608.Y VPWR 0.3749f
C1254 a_8008_12302# VPWR 0.13744f
C1255 sg13cmos5l_mux4_1_5.S0 sg13cmos5l_inv_1_654.Y 0.01658f
C1256 sg13cmos5l_inv_1_398.Y VPWR 0.40809f
C1257 sg13cmos5l_buf_1_12.X sg13cmos5l_inv_1_412.A 0.03843f
C1258 sg13cmos5l_buf_1_9.A a_6599_12970# 0.03058f
C1259 a_9326_3410# a_9498_3514# 0.03097f
C1260 sg13cmos5l_inv_1_304.A sg13cmos5l_inv_1_306.A 0.40893f
C1261 a_6119_8434# a_6934_8434# 0.49917f
C1262 sg13cmos5l_mux4_1_16.A1 a_9659_7736# 0.0808f
C1263 sg13cmos5l_inv_1_296.A sg13cmos5l_inv_1_295.Y 0.24331f
C1264 sg13cmos5l_inv_1_426.A sg13cmos5l_inv_1_266.Y 0.0237f
C1265 sg13cmos5l_inv_1_535.Y sg13cmos5l_inv_1_534.A 0.05668f
C1266 sg13cmos5l_mux4_1_7.A1 sg13cmos5l_inv_1_651.Y 0.01345f
C1267 sg13cmos5l_mux4_1_5.S0 sg13cmos5l_inv_1_340.Y 0.13589f
C1268 sg13cmos5l_inv_1_750.Y a_11656_12302# 0.0199f
C1269 sg13cmos5l_inv_1_356.A sg13cmos5l_inv_1_357.A 0.20065f
C1270 a_13918_14482# a_14422_14482# 0.97548f
C1271 sg13cmos5l_inv_1_248.A sg13cmos5l_inv_1_241.A 0.13833f
C1272 sg13cmos5l_inv_1_228.Y a_12136_4742# 0.02375f
C1273 sg13cmos5l_inv_1_936.A VPWR 0.42423f
C1274 sg13cmos5l_o21ai_1_0.B1 sg13cmos5l_inv_1_511.A 0.49338f
C1275 a_8086_3534# a_7582_3534# 0.97548f
C1276 a_6599_12970# a_7028_12970# 0.0289f
C1277 sg13cmos5l_inv_1_382.A VPWR 0.79161f
C1278 sg13cmos5l_inv_1_624.Y sg13cmos5l_mux2_1_2.A0 0.03008f
C1279 sg13cmos5l_mux2_1_3.S sg13cmos5l_mux2_1_4.X 0.89466f
C1280 sg13cmos5l_mux4_1_13.A3 a_15201_15588# 0.01695f
C1281 a_14183_9582# VPWR 0.38747f
C1282 sg13cmos5l_inv_1_296.A sg13cmos5l_inv_1_298.A 0.04144f
C1283 sg13cmos5l_inv_1_295.A sg13cmos5l_inv_1_298.Y 0.02764f
C1284 sg13cmos5l_mux4_1_8.A0 a_8653_16000# 0.01079f
C1285 sg13cmos5l_inv_1_950.A sg13cmos5l_inv_1_505.Y 0.03478f
C1286 sg13cmos5l_mux4_1_5.S0 sg13cmos5l_inv_1_473.Y 0.01767f
C1287 sg13cmos5l_inv_1_30.Y VPWR 0.42459f
C1288 sg13cmos5l_inv_1_780.Y sg13cmos5l_inv_1_779.A 0.02415f
C1289 sg13cmos5l_inv_1_265.A sg13cmos5l_inv_1_282.Y 0.01052f
C1290 sg13cmos5l_inv_1_1.Y sg13cmos5l_inv_1_8.A 0.0165f
C1291 sg13cmos5l_buf_1_6.A a_18280_5444# 0.33254f
C1292 sg13cmos5l_inv_1_981.A sg13cmos5l_inv_1_70.Y 0.07036f
C1293 sg13cmos5l_inv_1_211.Y sg13cmos5l_inv_1_207.Y 0.11348f
C1294 a_3623_15994# a_3847_16261# 0.01074f
C1295 a_13799_3534# a_14036_3534# 0.01012f
C1296 sg13cmos5l_inv_1_45.Y a_14614_3534# 0.07225f
C1297 sg13cmos5l_a22oi_1_0.B1 sg13cmos5l_a21oi_1_0.A2 0.17224f
C1298 sg13cmos5l_buf_1_9.A sg13cmos5l_inv_1_427.A 0.01289f
C1299 sg13cmos5l_inv_1_948.A VPWR 0.38758f
C1300 sg13cmos5l_inv_1_340.Y a_3934_8070# 0.18256f
C1301 sg13cmos5l_inv_1_267.Y sg13cmos5l_inv_1_266.Y 0.25294f
C1302 sg13cmos5l_inv_1_216.Y a_13918_3898# 0.13618f
C1303 sg13cmos5l_o21ai_1_0.B1 sg13cmos5l_inv_1_923.Y 0.07387f
C1304 sg13cmos5l_inv_1_307.A sg13cmos5l_inv_1_308.Y 0.82044f
C1305 sg13cmos5l_inv_1_308.A a_800_1002# 0.03465f
C1306 a_14989_12490# VPWR 0.13452f
C1307 sg13cmos5l_inv_1_668.Y a_808_13814# 0.02316f
C1308 sg13cmos5l_inv_1_344.A sg13cmos5l_inv_1_368.Y 0.04701f
C1309 sg13cmos5l_mux4_1_4.X VPWR 0.22481f
C1310 sg13cmos5l_inv_1_421.A sg13cmos5l_inv_1_363.Y 0.03453f
C1311 sg13cmos5l_inv_1_386.Y sg13cmos5l_inv_1_383.Y 0.04774f
C1312 a_13918_12606# a_14125_12267# 0.01967f
C1313 sg13cmos5l_inv_1_416.Y sg13cmos5l_inv_1_425.A 0.02531f
C1314 sg13cmos5l_inv_1_124.Y sg13cmos5l_inv_1_120.Y 0.01269f
C1315 a_14494_9582# a_14701_9243# 0.01967f
C1316 sg13cmos5l_inv_1_898.A sg13cmos5l_inv_1_741.Y 0.01215f
C1317 sg13cmos5l_inv_1_585.Y VPWR 0.36388f
C1318 sg13cmos5l_inv_1_619.Y a_7271_15994# 0.18667f
C1319 sg13cmos5l_inv_1_753.A a_11264_12302# 0.03501f
C1320 sg13cmos5l_inv_1_328.A sg13cmos5l_inv_1_304.Y 0.01077f
C1321 sg13cmos5l_inv_1_888.Y sg13cmos5l_inv_1_887.Y 0.18805f
C1322 sg13cmos5l_inv_1_679.A VPWR 0.46928f
C1323 a_14913_14524# sg13cmos5l_inv_1_878.A 0.03472f
C1324 sg13cmos5l_inv_1_480.A sg13cmos5l_inv_1_493.A 0.01199f
C1325 sg13cmos5l_inv_1_619.Y a_7232_15326# 0.04504f
C1326 sg13cmos5l_mux4_1_5.S0 a_4438_3534# 0.0473f
C1327 sg13cmos5l_inv_1_251.A VPWR 0.43072f
C1328 a_5005_12490# VPWR 0.14088f
C1329 sg13cmos5l_mux4_1_8.A0 a_8577_16036# 0.01345f
C1330 sg13cmos5l_mux4_1_1.A3 sg13cmos5l_inv_1_44.A 0.16807f
C1331 sg13cmos5l_inv_1_38.Y sg13cmos5l_inv_1_22.A 0.20619f
C1332 sg13cmos5l_inv_1_149.A VPWR 0.6657f
C1333 sg13cmos5l_inv_1_237.Y sg13cmos5l_inv_1_427.Y 0.01265f
C1334 sg13cmos5l_mux4_1_11.A3 sg13cmos5l_inv_1_744.Y 0.05335f
C1335 sg13cmos5l_inv_1_45.Y a_15105_3492# 0.0116f
C1336 a_13799_3534# a_13664_3230# 0.01143f
C1337 sg13cmos5l_mux4_1_16.A1 a_8327_6558# 0.21632f
C1338 sg13cmos5l_inv_1_300.Y VPWR 0.41551f
C1339 sg13cmos5l_mux4_1_5.S1 sg13cmos5l_inv_1_105.A 0.05944f
C1340 sg13cmos5l_buf_1_10.A sg13cmos5l_inv_1_266.Y 0.02345f
C1341 sg13cmos5l_inv_1_277.A sg13cmos5l_inv_1_247.A 0.03162f
C1342 sg13cmos5l_inv_1_557.A sg13cmos5l_inv_1_535.A 0.02697f
C1343 sg13cmos5l_inv_1_334.A sg13cmos5l_inv_1_321.A 0.27204f
C1344 sg13cmos5l_inv_1_491.A sg13cmos5l_a21oi_1_0.A2 0.01283f
C1345 sg13cmos5l_inv_1_828.Y sg13cmos5l_inv_1_830.A 0.02692f
C1346 sg13cmos5l_nor2b_1_0.A VPWR 0.40468f
C1347 sg13cmos5l_inv_1_103.A a_13472_2514# 0.01094f
C1348 a_2248_3932# a_2632_4026# 0.03269f
C1349 sg13cmos5l_inv_1_947.Y VPWR 0.62932f
C1350 sg13cmos5l_inv_1_593.Y sg13cmos5l_mux4_1_8.A2 0.01094f
C1351 sg13cmos5l_inv_1_626.Y sg13cmos5l_mux4_1_8.A1 0.02801f
C1352 sg13cmos5l_inv_1_722.Y sg13cmos5l_inv_1_730.A 0.51117f
C1353 sg13cmos5l_inv_1_702.Y sg13cmos5l_inv_1_715.Y 0.30653f
C1354 sg13cmos5l_inv_1_69.A sg13cmos5l_inv_1_243.A 0.03105f
C1355 sg13cmos5l_mux4_1_5.S0 sg13cmos5l_mux4_1_6.X 1.1016f
C1356 a_13472_16838# VPWR 0.0691f
C1357 sg13cmos5l_mux2_1_4.S a_8638_6558# 0.0104f
C1358 sg13cmos5l_inv_1_612.A a_8192_16838# 0.03465f
C1359 a_5984_13814# VPWR 0.07785f
C1360 sg13cmos5l_inv_1_306.A sg13cmos5l_inv_1_307.A 1.43998f
C1361 sg13cmos5l_inv_1_304.A sg13cmos5l_inv_1_306.Y 0.03438f
C1362 sg13cmos5l_inv_1_256.A a_6088_1718# 0.07385f
C1363 sg13cmos5l_inv_1_440.A sg13cmos5l_inv_1_441.A 0.18711f
C1364 sg13cmos5l_o21ai_1_0.B1 sg13cmos5l_inv_1_973.Y 0.01054f
C1365 sg13cmos5l_inv_1_553.Y sg13cmos5l_inv_1_542.A 0.0491f
C1366 sg13cmos5l_inv_1_274.Y VPWR 0.9092f
C1367 sg13cmos5l_inv_1_815.Y sg13cmos5l_mux4_1_13.A3 0.93628f
C1368 sg13cmos5l_inv_1_862.A a_18664_16028# 0.32083f
C1369 sg13cmos5l_inv_1_184.A sg13cmos5l_inv_1_222.Y 0.01313f
C1370 sg13cmos5l_inv_1_488.A sg13cmos5l_inv_1_475.Y 0.01288f
C1371 sg13cmos5l_inv_1_421.Y sg13cmos5l_inv_1_449.A 0.07341f
C1372 sg13cmos5l_inv_1_450.Y sg13cmos5l_inv_1_334.A 0.0539f
C1373 a_4438_12606# a_4929_12564# 0.3824f
C1374 sg13cmos5l_inv_1_544.Y sg13cmos5l_inv_1_533.A 0.04086f
C1375 sg13cmos5l_mux2_1_2.A0 sg13cmos5l_nor3_1_2.B 0.07026f
C1376 a_3304_2514# a_3488_2514# 0.11523f
C1377 a_3623_8070# VPWR 0.50104f
C1378 sg13cmos5l_inv_1_608.A a_9440_17634# 0.03646f
C1379 sg13cmos5l_a21oi_1_1.A2 sg13cmos5l_inv_1_948.A 0.16162f
C1380 sg13cmos5l_buf_1_12.X sg13cmos5l_inv_1_431.A 0.01966f
C1381 sg13cmos5l_inv_1_560.A sg13cmos5l_inv_1_562.Y 0.78511f
C1382 sg13cmos5l_inv_1_211.Y sg13cmos5l_inv_1_181.Y 0.01716f
C1383 sg13cmos5l_mux4_1_8.A0 sg13cmos5l_inv_1_789.Y 0.05205f
C1384 sg13cmos5l_nor2b_1_0.B_N sg13cmos5l_inv_1_571.A 0.02361f
C1385 sg13cmos5l_inv_1_359.Y sg13cmos5l_inv_1_985.Y 0.31081f
C1386 sg13cmos5l_inv_1_392.A a_8000_7050# 0.01162f
C1387 sg13cmos5l_inv_1_612.A sg13cmos5l_mux4_1_5.S0 0.01502f
C1388 sg13cmos5l_inv_1_855.A sg13cmos5l_inv_1_855.Y 0.20065f
C1389 sg13cmos5l_buf_1_10.A sg13cmos5l_inv_1_427.A 0.03613f
C1390 sg13cmos5l_inv_1_111.A sg13cmos5l_inv_1_110.A 0.13894f
C1391 sg13cmos5l_inv_1_662.Y VPWR 0.4267f
C1392 sg13cmos5l_inv_1_113.A sg13cmos5l_inv_1_118.Y 0.32481f
C1393 sg13cmos5l_inv_1_479.Y a_6376_13098# 0.01986f
C1394 sg13cmos5l_inv_1_447.A VPWR 0.40898f
C1395 sg13cmos5l_mux4_1_14.A1 sg13cmos5l_inv_1_884.Y 0.51063f
C1396 sg13cmos5l_inv_1_42.A VPWR 0.43528f
C1397 sg13cmos5l_mux2_1_0.X sg13cmos5l_inv_1_112.Y 0.07617f
C1398 sg13cmos5l_o21ai_1_0.Y a_10268_9172# 0.01087f
C1399 sg13cmos5l_inv_1_976.Y sg13cmos5l_inv_1_976.A 0.23289f
C1400 sg13cmos5l_inv_1_787.Y sg13cmos5l_inv_1_802.A 0.18868f
C1401 sg13cmos5l_mux4_1_5.S1 a_13831_4165# 0.01519f
C1402 sg13cmos5l_inv_1_116.Y sg13cmos5l_inv_1_129.Y 0.01159f
C1403 sg13cmos5l_inv_1_505.Y VPWR 0.45261f
C1404 sg13cmos5l_inv_1_987.A sg13cmos5l_or2_1_0.X 0.01103f
C1405 sg13cmos5l_inv_1_410.Y sg13cmos5l_inv_1_311.Y 0.05491f
C1406 sg13cmos5l_buf_1_9.A sg13cmos5l_inv_1_889.Y 0.03334f
C1407 a_2152_15326# VPWR 0.13783f
C1408 sg13cmos5l_mux2_1_4.S sg13cmos5l_inv_1_148.A 0.1516f
C1409 sg13cmos5l_inv_1_166.Y a_18664_9192# 0.02151f
C1410 sg13cmos5l_inv_1_216.Y sg13cmos5l_inv_1_45.Y 0.23059f
C1411 sg13cmos5l_nor3_1_2.B sg13cmos5l_inv_1_736.Y 0.0251f
C1412 sg13cmos5l_inv_1_19.A sg13cmos5l_inv_1_43.Y 0.04119f
C1413 sg13cmos5l_a22oi_1_0.B1 sg13cmos5l_a21oi_1_0.A1 0.01986f
C1414 sg13cmos5l_inv_1_563.Y sg13cmos5l_inv_1_537.Y 0.02024f
C1415 a_16456_9278# a_16640_9278# 0.11523f
C1416 sg13cmos5l_inv_1_389.A a_8104_6254# 0.02028f
C1417 sg13cmos5l_inv_1_843.Y a_18856_16752# 0.01139f
C1418 sg13cmos5l_inv_1_85.Y sg13cmos5l_inv_1_89.Y 0.03704f
C1419 a_14206_15630# a_14933_15245# 0.01228f
C1420 sg13cmos5l_mux4_1_16.X sg13cmos5l_inv_1_78.A 0.01182f
C1421 sg13cmos5l_inv_1_86.Y VPWR 0.5148f
C1422 sg13cmos5l_inv_1_61.A VPWR 0.42606f
C1423 sg13cmos5l_inv_1_600.A VPWR 0.3737f
C1424 sg13cmos5l_inv_1_752.A VPWR 0.49889f
C1425 sg13cmos5l_inv_1_396.Y VPWR 0.42557f
C1426 sg13cmos5l_buf_1_12.X sg13cmos5l_inv_1_401.Y 0.04954f
C1427 sg13cmos5l_inv_1_1002.A sg13cmos5l_mux2_1_0.X 0.01124f
C1428 sg13cmos5l_buf_1_10.A sg13cmos5l_inv_1_483.Y 0.04038f
C1429 a_9326_3410# sg13cmos5l_mux4_1_3.X 0.58536f
C1430 sg13cmos5l_inv_1_762.Y a_13918_12606# 0.1287f
C1431 sg13cmos5l_inv_1_199.Y sg13cmos5l_inv_1_30.A 0.11183f
C1432 sg13cmos5l_inv_1_580.A a_8288_15326# 0.03527f
C1433 sg13cmos5l_inv_1_295.A sg13cmos5l_inv_1_295.Y 0.50688f
C1434 a_10880_10790# VPWR 0.08727f
C1435 sg13cmos5l_inv_1_534.Y sg13cmos5l_inv_1_534.A 0.09153f
C1436 sg13cmos5l_inv_1_535.Y sg13cmos5l_inv_1_683.Y 0.01915f
C1437 sg13cmos5l_buf_1_17.X a_19048_13098# 0.02116f
C1438 sg13cmos5l_inv_1_162.Y sg13cmos5l_inv_1_163.Y 0.20065f
C1439 sg13cmos5l_inv_1_6.Y sg13cmos5l_inv_1_4.Y 0.13273f
C1440 sg13cmos5l_inv_1_273.Y a_7328_1002# 0.01082f
C1441 sg13cmos5l_inv_1_344.Y sg13cmos5l_inv_1_241.A 0.09825f
C1442 sg13cmos5l_inv_1_228.Y sg13cmos5l_inv_1_228.A 0.99664f
C1443 sg13cmos5l_inv_1_937.A VPWR 0.42659f
C1444 sg13cmos5l_inv_1_521.Y a_3592_10790# 0.01029f
C1445 sg13cmos5l_inv_1_623.Y sg13cmos5l_inv_1_622.Y 0.19345f
C1446 sg13cmos5l_inv_1_658.Y sg13cmos5l_mux2_1_2.A0 0.11777f
C1447 sg13cmos5l_mux4_1_10.A3 a_5005_16000# 0.05942f
C1448 sg13cmos5l_buf_1_8.A a_15608_7680# 0.07004f
C1449 sg13cmos5l_inv_1_893.Y sg13cmos5l_inv_1_894.Y 0.20065f
C1450 sg13cmos5l_inv_1_411.Y sg13cmos5l_inv_1_462.A 0.20568f
C1451 a_15637_8028# VPWR 0.88391f
C1452 sg13cmos5l_inv_1_295.A sg13cmos5l_inv_1_298.A 0.01695f
C1453 sg13cmos5l_inv_1_950.A sg13cmos5l_inv_1_504.A 0.01592f
C1454 sg13cmos5l_mux4_1_5.S0 a_8776_5538# 0.01766f
C1455 sg13cmos5l_inv_1_29.A VPWR 0.36418f
C1456 sg13cmos5l_inv_1_241.Y sg13cmos5l_inv_1_292.Y 0.0873f
C1457 sg13cmos5l_a21oi_1_0.B1 sg13cmos5l_inv_1_947.A 0.01256f
C1458 sg13cmos5l_inv_1_213.A a_18280_5444# 0.07999f
C1459 sg13cmos5l_buf_1_8.A sg13cmos5l_inv_1_421.Y 0.09375f
C1460 sg13cmos5l_inv_1_258.A a_6848_1718# 0.04624f
C1461 sg13cmos5l_inv_1_981.A sg13cmos5l_inv_1_70.A 0.01937f
C1462 a_9260_9906# VPWR 0.28158f
C1463 sg13cmos5l_inv_1_211.Y sg13cmos5l_inv_1_207.A 0.13973f
C1464 sg13cmos5l_inv_1_617.A sg13cmos5l_inv_1_618.Y 0.06537f
C1465 sg13cmos5l_buf_1_0.A sg13cmos5l_inv_1_8.A 0.01181f
C1466 sg13cmos5l_inv_1_693.A VPWR 0.4304f
C1467 sg13cmos5l_buf_1_0.A sg13cmos5l_inv_1_2.Y 0.01416f
C1468 sg13cmos5l_inv_1_308.A sg13cmos5l_inv_1_308.Y 0.19025f
C1469 sg13cmos5l_inv_1_307.A sg13cmos5l_inv_1_306.Y 0.03825f
C1470 sg13cmos5l_buf_1_10.A sg13cmos5l_inv_1_412.A 0.13361f
C1471 sg13cmos5l_mux2_1_4.S sg13cmos5l_mux4_1_5.X 0.06209f
C1472 sg13cmos5l_inv_1_421.A sg13cmos5l_inv_1_375.Y 0.19467f
C1473 sg13cmos5l_inv_1_346.Y sg13cmos5l_inv_1_362.Y 0.01942f
C1474 sg13cmos5l_inv_1_248.A sg13cmos5l_inv_1_1011.A 0.08797f
C1475 sg13cmos5l_a21oi_1_1.A1 a_8795_11752# 0.04065f
C1476 sg13cmos5l_buf_1_9.A sg13cmos5l_inv_1_651.Y 0.623f
C1477 sg13cmos5l_inv_1_381.Y sg13cmos5l_inv_1_383.Y 0.16289f
C1478 sg13cmos5l_inv_1_105.A sg13cmos5l_inv_1_106.A 0.35274f
C1479 sg13cmos5l_inv_1_851.A sg13cmos5l_inv_1_858.Y 0.02133f
C1480 sg13cmos5l_inv_1_843.Y sg13cmos5l_inv_1_862.A 0.02877f
C1481 sg13cmos5l_inv_1_491.A sg13cmos5l_a21oi_1_0.A1 0.01496f
C1482 sg13cmos5l_inv_1_78.A sg13cmos5l_inv_1_217.A 0.33066f
C1483 a_8123_8472# a_8446_8434# 0.55132f
C1484 sg13cmos5l_inv_1_248.A sg13cmos5l_inv_1_245.A 0.20952f
C1485 sg13cmos5l_inv_1_241.A sg13cmos5l_mux4_1_5.X 0.01551f
C1486 sg13cmos5l_inv_1_636.A sg13cmos5l_inv_1_637.A 0.17007f
C1487 sg13cmos5l_inv_1_76.A a_11848_4026# 0.05352f
C1488 sg13cmos5l_inv_1_890.A sg13cmos5l_inv_1_861.A 0.0846f
C1489 a_19048_9278# VPWR 0.12791f
C1490 sg13cmos5l_inv_1_592.Y VPWR 0.62985f
C1491 sg13cmos5l_inv_1_876.A sg13cmos5l_inv_1_887.Y 0.18545f
C1492 sg13cmos5l_inv_1_553.A VPWR 0.45918f
C1493 a_14027_11654# a_14360_11776# 0.3824f
C1494 sg13cmos5l_inv_1_733.A sg13cmos5l_inv_1_757.Y 0.25435f
C1495 sg13cmos5l_inv_1_837.Y a_17888_18350# 0.04511f
C1496 sg13cmos5l_inv_1_828.Y osc_tap[7] 0.13401f
C1497 a_5600_16838# VPWR 0.07777f
C1498 sg13cmos5l_mux4_1_10.A3 a_4929_16036# 0.0488f
C1499 sg13cmos5l_inv_1_582.A sg13cmos5l_inv_1_581.A 0.18555f
C1500 sg13cmos5l_inv_1_453.A VPWR 0.41698f
C1501 a_6910_12970# a_7637_13283# 0.01228f
C1502 sg13cmos5l_mux4_1_11.A3 sg13cmos5l_mux4_1_12.A3 0.04525f
C1503 sg13cmos5l_mux4_1_5.S0 sg13cmos5l_inv_1_382.A 0.33237f
C1504 a_18764_5370# osc_tap[1] 0.01412f
C1505 sg13cmos5l_mux4_1_16.X a_9633_6516# 0.20353f
C1506 sg13cmos5l_nor3_1_2.B sg13cmos5l_inv_1_730.A 0.01205f
C1507 sg13cmos5l_inv_1_533.A a_3847_16261# 0.0127f
C1508 sg13cmos5l_inv_1_277.Y sg13cmos5l_inv_1_279.Y 0.21076f
C1509 sg13cmos5l_mux4_1_13.A3 a_14206_15630# 0.16649f
C1510 sg13cmos5l_mux4_1_5.S1 a_13799_3534# 0.51773f
C1511 sg13cmos5l_inv_1_237.Y sg13cmos5l_inv_1_438.A 0.01297f
C1512 sg13cmos5l_inv_1_100.A a_14422_3898# 0.04368f
C1513 sg13cmos5l_inv_1_288.Y sg13cmos5l_inv_1_286.Y 0.20065f
C1514 a_12136_4742# VPWR 0.13594f
C1515 a_13288_2514# VPWR 0.12966f
C1516 sg13cmos5l_inv_1_113.Y VPWR 0.46923f
C1517 sg13cmos5l_inv_1_793.A sg13cmos5l_inv_1_787.Y 0.0153f
C1518 sg13cmos5l_inv_1_298.Y VPWR 0.432f
C1519 sg13cmos5l_inv_1_281.Y sg13cmos5l_inv_1_247.A 0.01288f
C1520 sg13cmos5l_inv_1_292.Y a_7808_1718# 0.01054f
C1521 sg13cmos5l_inv_1_730.A sg13cmos5l_inv_1_712.A 0.0377f
C1522 sg13cmos5l_inv_1_828.Y sg13cmos5l_inv_1_820.A 0.02751f
C1523 sg13cmos5l_inv_1_575.A VPWR 0.43993f
C1524 a_12136_4742# sg13cmos5l_inv_1_88.A 0.0104f
C1525 sg13cmos5l_buf_1_7.X a_2920_3932# 0.33094f
C1526 sg13cmos5l_inv_1_990.A VPWR 0.34378f
C1527 sg13cmos5l_inv_1_722.Y sg13cmos5l_inv_1_715.Y 0.03489f
C1528 sg13cmos5l_mux4_1_11.A2 sg13cmos5l_inv_1_730.A 0.1076f
C1529 sg13cmos5l_inv_1_337.Y sg13cmos5l_inv_1_331.A 0.01044f
C1530 sg13cmos5l_inv_1_69.A sg13cmos5l_inv_1_273.Y 0.05171f
C1531 sg13cmos5l_buf_1_8.A sg13cmos5l_mux4_1_15.A3 0.7646f
C1532 a_14027_11654# VPWR 0.70322f
C1533 sg13cmos5l_buf_1_9.A a_14171_11488# 0.02317f
C1534 sg13cmos5l_inv_1_305.Y sg13cmos5l_inv_1_329.A 0.11396f
C1535 sg13cmos5l_inv_1_676.Y VPWR 0.36996f
C1536 a_3623_3534# sg13cmos5l_inv_1_305.A 0.20711f
C1537 sg13cmos5l_inv_1_304.A sg13cmos5l_inv_1_307.A 0.06226f
C1538 sg13cmos5l_inv_1_256.A sg13cmos5l_inv_1_257.A 0.24658f
C1539 sg13cmos5l_inv_1_988.A sg13cmos5l_inv_1_162.A 0.01122f
C1540 sg13cmos5l_inv_1_276.A VPWR 0.43672f
C1541 sg13cmos5l_inv_1_535.Y a_4438_15994# 0.06118f
C1542 sg13cmos5l_inv_1_375.Y sg13cmos5l_inv_1_341.Y 0.01705f
C1543 sg13cmos5l_mux4_1_16.A2 sg13cmos5l_inv_1_447.A 0.01064f
C1544 sg13cmos5l_inv_1_184.A sg13cmos5l_inv_1_184.Y 0.18634f
C1545 sg13cmos5l_mux4_1_14.A1 sg13cmos5l_mux4_1_14.A0 0.08601f
C1546 a_14389_11500# a_14773_11771# 0.01228f
C1547 sg13cmos5l_mux2_1_4.S sg13cmos5l_inv_1_959.Y 0.21244f
C1548 a_2240_2514# VPWR 0.0892f
C1549 sg13cmos5l_buf_1_12.X sg13cmos5l_inv_1_362.Y 0.76908f
C1550 sg13cmos5l_a21oi_1_1.A2 sg13cmos5l_inv_1_693.A 0.01291f
C1551 sg13cmos5l_inv_1_945.Y sg13cmos5l_inv_1_945.A 0.2023f
C1552 sg13cmos5l_inv_1_560.A sg13cmos5l_inv_1_560.Y 0.22626f
C1553 sg13cmos5l_inv_1_568.A sg13cmos5l_inv_1_562.Y 0.01441f
C1554 sg13cmos5l_mux4_1_8.A0 sg13cmos5l_inv_1_788.Y 0.22215f
C1555 a_18664_3144# VPWR 0.25617f
C1556 a_13607_14482# a_13918_14482# 0.49675f
C1557 sg13cmos5l_mux4_1_14.A3 a_14989_14488# 0.01704f
C1558 sg13cmos5l_inv_1_1009.Y sg13cmos5l_inv_1_502.Y 0.21399f
C1559 sg13cmos5l_inv_1_953.Y sg13cmos5l_inv_1_114.Y 0.06748f
C1560 sg13cmos5l_inv_1_464.Y sg13cmos5l_inv_1_454.Y 0.20065f
C1561 sg13cmos5l_inv_1_499.Y VPWR 0.38042f
C1562 sg13cmos5l_inv_1_448.Y VPWR 0.48536f
C1563 sg13cmos5l_buf_1_7.X sg13cmos5l_inv_1_304.A 1.2195f
C1564 sg13cmos5l_inv_1_31.A VPWR 0.43239f
C1565 sg13cmos5l_mux4_1_15.X sg13cmos5l_inv_1_931.A 0.02145f
C1566 sg13cmos5l_mux2_1_4.S a_13918_12606# 0.0336f
C1567 sg13cmos5l_inv_1_152.Y sg13cmos5l_inv_1_78.A 0.03307f
C1568 sg13cmos5l_mux4_1_10.A2 a_3623_15994# 0.21675f
C1569 sg13cmos5l_inv_1_976.A a_10888_9278# 0.03352f
C1570 sg13cmos5l_mux4_1_7.A3 sg13cmos5l_nor3_1_2.B 0.25212f
C1571 sg13cmos5l_inv_1_248.A sg13cmos5l_inv_1_414.A 0.17104f
C1572 sg13cmos5l_inv_1_504.A VPWR 0.36033f
C1573 sg13cmos5l_inv_1_493.A sg13cmos5l_or2_1_0.X 0.02442f
C1574 a_3488_16122# VPWR 0.07144f
C1575 sg13cmos5l_a21oi_1_0.Y a_9825_11776# 0.01589f
C1576 sg13cmos5l_buf_1_9.A sg13cmos5l_inv_1_903.Y 0.07096f
C1577 sg13cmos5l_inv_1_889.Y sg13cmos5l_inv_1_904.Y 0.31117f
C1578 a_4798_12970# a_5408_13098# 0.0344f
C1579 sg13cmos5l_mux4_1_5.S1 a_6934_8434# 0.05898f
C1580 sg13cmos5l_inv_1_144.Y sg13cmos5l_inv_1_189.Y 0.01053f
C1581 sg13cmos5l_inv_1_571.A sg13cmos5l_nor2b_1_0.A 0.01627f
C1582 a_10304_2514# VPWR 0.08484f
C1583 sg13cmos5l_inv_1_326.Y sg13cmos5l_inv_1_297.Y 0.05628f
C1584 sg13cmos5l_inv_1_85.Y sg13cmos5l_inv_1_82.A 0.16581f
C1585 sg13cmos5l_inv_1_402.A VPWR 0.51495f
C1586 sg13cmos5l_inv_1_84.Y VPWR 0.5238f
C1587 sg13cmos5l_inv_1_580.A sg13cmos5l_inv_1_582.A 0.68537f
C1588 sg13cmos5l_inv_1_336.A sg13cmos5l_inv_1_311.A 0.08916f
C1589 sg13cmos5l_inv_1_584.A VPWR 0.8526f
C1590 sg13cmos5l_inv_1_751.A VPWR 0.49027f
C1591 a_9982_8050# a_9885_7704# 0.02925f
C1592 a_9659_7736# a_10159_7704# 0.03336f
C1593 sg13cmos5l_inv_1_391.Y VPWR 0.36452f
C1594 a_14998_9582# a_15565_9466# 0.40359f
C1595 sg13cmos5l_mux4_1_5.S0 sg13cmos5l_inv_1_274.Y 0.10117f
C1596 sg13cmos5l_mux4_1_9.A0 VPWR 1.01007f
C1597 sg13cmos5l_inv_1_580.A sg13cmos5l_inv_1_625.Y 0.02447f
C1598 sg13cmos5l_inv_1_738.Y VPWR 0.45246f
C1599 sg13cmos5l_inv_1_884.Y a_13288_15326# 0.04353f
C1600 sg13cmos5l_inv_1_295.A sg13cmos5l_inv_1_332.A 0.01156f
C1601 sg13cmos5l_mux2_1_4.S a_15275_7644# 0.01719f
C1602 sg13cmos5l_inv_1_6.Y sg13cmos5l_inv_1_5.Y 0.01171f
C1603 sg13cmos5l_inv_1_757.Y a_13472_11586# 0.04557f
C1604 sg13cmos5l_mux4_1_5.S0 a_3623_8070# 0.58822f
C1605 sg13cmos5l_inv_1_356.Y sg13cmos5l_inv_1_356.A 0.20065f
C1606 sg13cmos5l_mux4_1_14.A3 a_14913_14524# 0.02221f
C1607 sg13cmos5l_inv_1_273.A a_7328_1002# 0.0359f
C1608 sg13cmos5l_inv_1_283.A sg13cmos5l_inv_1_241.A 0.80226f
C1609 sg13cmos5l_inv_1_937.Y VPWR 0.42631f
C1610 sg13cmos5l_mux2_1_0.X sg13cmos5l_inv_1_113.A 0.02091f
C1611 sg13cmos5l_mux2_1_2.A0 a_4936_15326# 0.01162f
C1612 sg13cmos5l_inv_1_756.Y sg13cmos5l_inv_1_738.A 0.05551f
C1613 sg13cmos5l_mux4_1_13.A0 sg13cmos5l_mux4_1_14.A0 0.14188f
C1614 a_3304_3230# a_3304_2514# 0.01275f
C1615 sg13cmos5l_a21oi_1_0.B1 sg13cmos5l_nor3_1_2.B 0.01931f
C1616 sg13cmos5l_buf_1_9.A a_4438_12606# 0.06626f
C1617 sg13cmos5l_inv_1_950.A sg13cmos5l_inv_1_503.Y 0.19272f
C1618 sg13cmos5l_nor2b_1_0.B_N a_1006_15296# 0.34213f
C1619 sg13cmos5l_mux4_1_8.A0 a_7271_15994# 0.24941f
C1620 sg13cmos5l_inv_1_37.Y VPWR 0.54365f
C1621 sg13cmos5l_buf_1_12.X sg13cmos5l_o21ai_1_0.Y 0.01727f
C1622 sg13cmos5l_inv_1_241.Y sg13cmos5l_inv_1_247.Y 0.05971f
C1623 a_13288_16122# a_13288_15326# 0.01095f
C1624 sg13cmos5l_a21oi_1_0.B1 sg13cmos5l_inv_1_521.Y 1.30632f
C1625 sg13cmos5l_inv_1_2.Y sg13cmos5l_inv_1_8.A 0.04374f
C1626 sg13cmos5l_inv_1_213.A sg13cmos5l_buf_1_6.A 0.03653f
C1627 sg13cmos5l_buf_1_8.A sg13cmos5l_inv_1_434.A 0.01133f
C1628 sg13cmos5l_inv_1_258.A sg13cmos5l_inv_1_259.Y 0.03408f
C1629 sg13cmos5l_mux2_1_1.X VPWR 0.41973f
C1630 sg13cmos5l_mux4_1_14.A1 VPWR 0.99792f
C1631 sg13cmos5l_inv_1_147.Y sg13cmos5l_inv_1_207.Y 0.01388f
C1632 sg13cmos5l_inv_1_617.A sg13cmos5l_inv_1_618.A 0.16023f
C1633 a_13799_3534# sg13cmos5l_mux4_1_1.A3 0.08487f
C1634 sg13cmos5l_mux4_1_12.A1 a_13607_12606# 0.19977f
C1635 sg13cmos5l_buf_1_9.A sg13cmos5l_inv_1_438.A 0.37131f
C1636 sg13cmos5l_inv_1_644.A VPWR 0.42405f
C1637 sg13cmos5l_mux2_1_2.A0 sg13cmos5l_inv_1_684.Y 0.10254f
C1638 sg13cmos5l_inv_1_928.A a_17504_10074# 0.04616f
C1639 a_3623_8070# a_3934_8070# 0.49675f
C1640 sg13cmos5l_inv_1_85.A a_13918_3898# 0.01301f
C1641 sg13cmos5l_inv_1_248.A sg13cmos5l_inv_1_278.Y 0.02218f
C1642 sg13cmos5l_buf_1_10.A sg13cmos5l_inv_1_401.Y 0.04433f
C1643 sg13cmos5l_inv_1_344.A sg13cmos5l_inv_1_375.Y 0.04172f
C1644 sg13cmos5l_buf_1_9.A sg13cmos5l_inv_1_652.Y 0.0312f
C1645 a_3623_3534# a_3860_3534# 0.01012f
C1646 sg13cmos5l_inv_1_326.Y sg13cmos5l_inv_1_324.Y 0.40523f
C1647 sg13cmos5l_inv_1_393.A sg13cmos5l_inv_1_248.A 0.01621f
C1648 sg13cmos5l_inv_1_85.Y a_13288_4026# 0.03352f
C1649 sg13cmos5l_mux4_1_9.X sg13cmos5l_inv_1_486.Y 0.20257f
C1650 sg13cmos5l_inv_1_451.A a_3872_4742# 0.03465f
C1651 sg13cmos5l_buf_1_0.A sg13cmos5l_inv_1_22.Y 0.03962f
C1652 sg13cmos5l_mux4_1_6.X a_8446_8434# 0.57107f
C1653 sg13cmos5l_inv_1_124.Y sg13cmos5l_inv_1_121.Y 0.22735f
C1654 sg13cmos5l_inv_1_241.A sg13cmos5l_inv_1_292.Y 0.02558f
C1655 sg13cmos5l_inv_1_696.A sg13cmos5l_inv_1_694.A 0.01491f
C1656 sg13cmos5l_inv_1_120.Y a_11944_7050# 0.01215f
C1657 a_7495_16261# a_7582_15994# 0.02548f
C1658 a_8653_16000# a_8086_15994# 0.40359f
C1659 sg13cmos5l_inv_1_149.Y sg13cmos5l_inv_1_217.A 0.87413f
C1660 sg13cmos5l_inv_1_394.A sg13cmos5l_inv_1_407.Y 0.01075f
C1661 sg13cmos5l_inv_1_884.Y sg13cmos5l_mux2_1_4.S 0.01525f
C1662 sg13cmos5l_inv_1_585.A VPWR 0.4195f
C1663 sg13cmos5l_inv_1_186.A a_18664_4026# 0.01138f
C1664 sg13cmos5l_mux4_1_13.A0 sg13cmos5l_inv_1_875.Y 0.28827f
C1665 sg13cmos5l_inv_1_533.Y VPWR 0.46537f
C1666 a_1184_7050# VPWR 0.07846f
C1667 sg13cmos5l_inv_1_733.A sg13cmos5l_inv_1_731.Y 0.22169f
C1668 sg13cmos5l_mux4_1_16.A1 sg13cmos5l_inv_1_400.Y 0.0113f
C1669 sg13cmos5l_inv_1_837.Y sg13cmos5l_inv_1_824.A 0.07834f
C1670 sg13cmos5l_inv_1_295.Y VPWR 0.51959f
C1671 sg13cmos5l_inv_1_985.Y sg13cmos5l_inv_1_366.Y 0.01675f
C1672 sg13cmos5l_inv_1_367.Y a_3488_6254# 0.04643f
C1673 sg13cmos5l_inv_1_811.Y sg13cmos5l_inv_1_796.Y 0.02861f
C1674 sg13cmos5l_inv_1_676.Y sg13cmos5l_inv_1_482.Y 0.01292f
C1675 a_4929_8028# sg13cmos5l_inv_1_412.A 0.01324f
C1676 sg13cmos5l_inv_1_479.Y sg13cmos5l_inv_1_478.Y 0.0909f
C1677 sg13cmos5l_inv_1_448.Y sg13cmos5l_inv_1_448.A 0.12327f
C1678 sg13cmos5l_mux4_1_5.X sg13cmos5l_inv_1_1011.A 0.40114f
C1679 sg13cmos5l_inv_1_745.A a_13472_13098# 0.03571f
C1680 a_13288_7766# a_13472_7766# 0.11523f
C1681 sg13cmos5l_inv_1_228.A VPWR 0.57854f
C1682 a_14110_3534# VPWR 0.89017f
C1683 a_15662_4084# sg13cmos5l_mux4_1_1.X 0.11315f
C1684 sg13cmos5l_mux4_1_2.X a_15768_4088# 0.16688f
C1685 sg13cmos5l_buf_1_10.A sg13cmos5l_inv_1_984.Y 0.0854f
C1686 sg13cmos5l_inv_1_112.A VPWR 0.4532f
C1687 sg13cmos5l_inv_1_298.A VPWR 0.45618f
C1688 sg13cmos5l_inv_1_82.Y sg13cmos5l_inv_1_95.A 0.2102f
C1689 sg13cmos5l_inv_1_495.A sg13cmos5l_inv_1_496.A 0.17382f
C1690 sg13cmos5l_inv_1_982.A a_6656_10074# 0.01054f
C1691 sg13cmos5l_inv_1_563.A VPWR 0.42708f
C1692 sg13cmos5l_inv_1_828.Y sg13cmos5l_inv_1_821.A 0.02804f
C1693 a_16936_1718# VPWR 0.13706f
C1694 sg13cmos5l_inv_1_124.Y VPWR 0.58247f
C1695 sg13cmos5l_mux2_1_0.X sg13cmos5l_inv_1_206.A 0.27896f
C1696 a_9142_6558# a_9709_6442# 0.40359f
C1697 sg13cmos5l_inv_1_997.A VPWR 0.42759f
C1698 sg13cmos5l_o21ai_1_0.B1 sg13cmos5l_mux2_1_4.X 0.01229f
C1699 sg13cmos5l_inv_1_722.Y sg13cmos5l_inv_1_702.Y 0.22578f
C1700 sg13cmos5l_inv_1_69.A sg13cmos5l_inv_1_273.A 0.68884f
C1701 sg13cmos5l_mux4_1_13.A0 VPWR 0.77231f
C1702 sg13cmos5l_inv_1_612.A sg13cmos5l_inv_1_618.A 0.01007f
C1703 a_8086_15994# a_8577_16036# 0.3824f
C1704 sg13cmos5l_inv_1_479.Y VPWR 0.51103f
C1705 sg13cmos5l_inv_1_327.A sg13cmos5l_inv_1_305.A 0.11555f
C1706 sg13cmos5l_inv_1_430.A sg13cmos5l_inv_1_440.A 0.20065f
C1707 sg13cmos5l_inv_1_241.Y VPWR 0.57541f
C1708 sg13cmos5l_inv_1_862.A a_17984_16122# 0.01228f
C1709 sg13cmos5l_inv_1_534.Y a_4438_15994# 0.05016f
C1710 sg13cmos5l_inv_1_225.A sg13cmos5l_inv_1_184.Y 0.07892f
C1711 sg13cmos5l_inv_1_487.A sg13cmos5l_inv_1_475.Y 0.01985f
C1712 a_4438_12606# sg13cmos5l_buf_1_10.A 0.05552f
C1713 sg13cmos5l_inv_1_608.Y a_9440_17634# 0.01101f
C1714 sg13cmos5l_inv_1_147.A sg13cmos5l_inv_1_211.Y 0.08547f
C1715 sg13cmos5l_inv_1_49.A VPWR 0.69881f
C1716 sg13cmos5l_mux4_1_10.A3 VPWR 0.63734f
C1717 sg13cmos5l_inv_1_863.Y sg13cmos5l_inv_1_855.A 0.20065f
C1718 sg13cmos5l_inv_1_66.Y a_11456_1718# 0.01054f
C1719 sg13cmos5l_inv_1_206.A sg13cmos5l_inv_1_185.A 0.06999f
C1720 sg13cmos5l_inv_1_926.Y VPWR 0.53542f
C1721 sg13cmos5l_inv_1_443.Y VPWR 0.44585f
C1722 sg13cmos5l_buf_1_9.A sg13cmos5l_mux4_1_14.A3 0.07187f
C1723 sg13cmos5l_inv_1_38.Y VPWR 0.64218f
C1724 a_13288_14610# VPWR 0.12833f
C1725 sg13cmos5l_mux4_1_15.X sg13cmos5l_inv_1_931.Y 0.14064f
C1726 sg13cmos5l_a22oi_1_0.A1 sg13cmos5l_nor3_1_1.A 0.15394f
C1727 sg13cmos5l_mux2_1_4.X sg13cmos5l_inv_1_248.A 0.06227f
C1728 sg13cmos5l_inv_1_533.A a_3623_15994# 0.05149f
C1729 sg13cmos5l_mux4_1_5.S1 sg13cmos5l_mux4_1_2.A2 0.0651f
C1730 sg13cmos5l_inv_1_248.A sg13cmos5l_inv_1_415.A 0.0139f
C1731 sg13cmos5l_inv_1_337.A sg13cmos5l_buf_1_7.X 0.17077f
C1732 sg13cmos5l_inv_1_503.Y VPWR 0.38894f
C1733 sg13cmos5l_inv_1_115.Y sg13cmos5l_inv_1_138.Y 0.01175f
C1734 sg13cmos5l_inv_1_747.Y sg13cmos5l_or2_1_0.B 0.53919f
C1735 sg13cmos5l_inv_1_318.Y sg13cmos5l_inv_1_410.Y 0.21456f
C1736 sg13cmos5l_buf_1_9.A sg13cmos5l_inv_1_882.A 0.08815f
C1737 a_11176_13814# VPWR 0.18218f
C1738 sg13cmos5l_inv_1_908.A sg13cmos5l_inv_1_905.A 0.20994f
C1739 a_14341_4165# a_13918_3898# 0.01929f
C1740 a_4929_3492# sg13cmos5l_inv_1_325.A 0.02012f
C1741 sg13cmos5l_inv_1_958.Y sg13cmos5l_inv_1_166.Y 0.04871f
C1742 sg13cmos5l_inv_1_557.Y sg13cmos5l_inv_1_688.A 0.01348f
C1743 sg13cmos5l_inv_1_904.Y sg13cmos5l_inv_1_903.Y 0.22983f
C1744 sg13cmos5l_inv_1_950.A sg13cmos5l_inv_1_944.Y 0.06758f
C1745 a_9709_6442# a_9633_6516# 0.2611f
C1746 sg13cmos5l_inv_1_572.A sg13cmos5l_inv_1_563.A 0.01528f
C1747 sg13cmos5l_inv_1_216.Y sg13cmos5l_inv_1_95.A 0.11612f
C1748 sg13cmos5l_inv_1_65.A VPWR 0.4873f
C1749 sg13cmos5l_inv_1_241.A a_5896_3230# 0.01891f
C1750 sg13cmos5l_inv_1_19.A sg13cmos5l_inv_1_18.Y 0.26971f
C1751 sg13cmos5l_inv_1_557.Y sg13cmos5l_inv_1_568.Y 0.0156f
C1752 sg13cmos5l_inv_1_758.A VPWR 0.82809f
C1753 sg13cmos5l_inv_1_326.Y sg13cmos5l_inv_1_331.A 1.12082f
C1754 a_17896_7050# a_17896_6254# 0.01095f
C1755 sg13cmos5l_inv_1_871.Y a_18856_16752# 0.04854f
C1756 sg13cmos5l_inv_1_762.Y VPWR 0.7143f
C1757 sg13cmos5l_mux2_1_4.S a_15489_9540# 0.25301f
C1758 sg13cmos5l_inv_1_84.A VPWR 0.6533f
C1759 sg13cmos5l_inv_1_237.Y sg13cmos5l_inv_1_319.Y 0.24071f
C1760 sg13cmos5l_inv_1_614.A VPWR 0.41642f
C1761 sg13cmos5l_inv_1_749.A VPWR 0.49f
C1762 sg13cmos5l_inv_1_389.Y VPWR 0.41171f
C1763 sg13cmos5l_buf_1_12.X sg13cmos5l_inv_1_403.A 0.08754f
C1764 a_7808_1718# VPWR 0.07958f
C1765 sg13cmos5l_inv_1_198.Y sg13cmos5l_inv_1_199.Y 0.20065f
C1766 sg13cmos5l_inv_1_666.Y VPWR 0.41039f
C1767 sg13cmos5l_inv_1_737.A VPWR 0.47674f
C1768 sg13cmos5l_inv_1_202.Y sg13cmos5l_mux4_1_15.A2 2.69771f
C1769 sg13cmos5l_inv_1_619.A a_6848_16122# 0.05858f
C1770 sg13cmos5l_inv_1_162.A sg13cmos5l_inv_1_162.Y 0.20065f
C1771 sg13cmos5l_inv_1_6.Y sg13cmos5l_inv_1_43.Y 0.04705f
C1772 sg13cmos5l_inv_1_250.Y a_7328_1002# 0.03465f
C1773 sg13cmos5l_inv_1_218.A a_12136_4742# 0.01121f
C1774 sg13cmos5l_inv_1_418.Y sg13cmos5l_inv_1_459.Y 0.0535f
C1775 sg13cmos5l_inv_1_938.A VPWR 0.42452f
C1776 sg13cmos5l_inv_1_533.A sg13cmos5l_mux4_1_10.A2 0.58745f
C1777 sg13cmos5l_inv_1_624.Y sg13cmos5l_inv_1_623.Y 0.17062f
C1778 a_3934_8070# a_4661_7685# 0.01228f
C1779 sg13cmos5l_inv_1_892.Y sg13cmos5l_inv_1_893.Y 0.20065f
C1780 sg13cmos5l_inv_1_887.Y sg13cmos5l_inv_1_720.Y 0.01279f
C1781 a_6599_12970# a_6910_12970# 0.49675f
C1782 sg13cmos5l_inv_1_515.Y sg13cmos5l_inv_1_504.A 0.04669f
C1783 sg13cmos5l_inv_1_950.A sg13cmos5l_inv_1_950.Y 0.54191f
C1784 a_14614_3534# a_15105_3492# 0.3824f
C1785 sg13cmos5l_inv_1_28.A VPWR 0.42857f
C1786 sg13cmos5l_buf_1_12.X sg13cmos5l_nor3_1_1.Y 0.02284f
C1787 sg13cmos5l_inv_1_662.Y sg13cmos5l_inv_1_921.Y 0.01224f
C1788 sg13cmos5l_inv_1_311.Y sg13cmos5l_inv_1_293.Y 0.03727f
C1789 sg13cmos5l_inv_1_926.Y a_4736_10074# 0.01054f
C1790 sg13cmos5l_buf_1_8.A sg13cmos5l_inv_1_174.A 0.02962f
C1791 sg13cmos5l_inv_1_980.A VPWR 0.40362f
C1792 sg13cmos5l_inv_1_258.A sg13cmos5l_inv_1_260.Y 0.46351f
C1793 sg13cmos5l_inv_1_720.Y sg13cmos5l_buf_1_18.A 0.02049f
C1794 sg13cmos5l_inv_1_779.Y VPWR 0.56745f
C1795 sg13cmos5l_buf_1_9.A sg13cmos5l_inv_1_437.A 0.01319f
C1796 sg13cmos5l_inv_1_213.Y osc_tap[1] 0.04589f
C1797 sg13cmos5l_inv_1_692.A VPWR 0.42834f
C1798 sg13cmos5l_mux2_1_2.A0 sg13cmos5l_inv_1_633.A 0.18403f
C1799 sg13cmos5l_mux4_1_5.S0 a_3488_16122# 0.0385f
C1800 sg13cmos5l_inv_1_46.Y sg13cmos5l_inv_1_2.Y 0.04813f
C1801 sg13cmos5l_inv_1_537.Y a_2152_15326# 0.02089f
C1802 sg13cmos5l_inv_1_308.A sg13cmos5l_inv_1_307.A 0.18209f
C1803 sg13cmos5l_buf_1_10.A sg13cmos5l_inv_1_403.Y 0.1064f
C1804 sg13cmos5l_inv_1_344.A sg13cmos5l_inv_1_431.A 0.42261f
C1805 sg13cmos5l_buf_1_9.A sg13cmos5l_mux2_1_3.A0 0.14902f
C1806 sg13cmos5l_nor2b_1_0.A a_1006_15296# 0.10916f
C1807 sg13cmos5l_inv_1_480.A sg13cmos5l_mux4_1_7.A2 0.02657f
C1808 sg13cmos5l_nor3_1_2.B a_9064_10790# 0.05023f
C1809 sg13cmos5l_inv_1_427.Y sg13cmos5l_inv_1_424.A 0.01522f
C1810 sg13cmos5l_buf_1_0.A sg13cmos5l_inv_1_16.Y 1.77241f
C1811 sg13cmos5l_mux4_1_4.X a_8446_8434# 0.11932f
C1812 sg13cmos5l_mux4_1_5.S0 sg13cmos5l_inv_1_402.A 0.72056f
C1813 sg13cmos5l_inv_1_241.A sg13cmos5l_inv_1_247.Y 1.74131f
C1814 a_12136_16122# VPWR 0.13979f
C1815 sg13cmos5l_inv_1_866.Y sg13cmos5l_mux4_1_13.A3 0.03171f
C1816 sg13cmos5l_inv_1_209.Y sg13cmos5l_inv_1_187.A 0.01297f
C1817 sg13cmos5l_inv_1_635.A sg13cmos5l_inv_1_636.A 0.20753f
C1818 sg13cmos5l_inv_1_807.Y sg13cmos5l_inv_1_861.A 0.02521f
C1819 sg13cmos5l_inv_1_584.A sg13cmos5l_mux4_1_5.S0 0.04586f
C1820 sg13cmos5l_o21ai_1_0.B1 sg13cmos5l_mux4_1_6.A2 0.0199f
C1821 sg13cmos5l_inv_1_688.A VPWR 0.50528f
C1822 sg13cmos5l_inv_1_171.Y sg13cmos5l_inv_1_176.A 0.0338f
C1823 sg13cmos5l_inv_1_217.A sg13cmos5l_inv_1_141.A 0.01819f
C1824 sg13cmos5l_mux4_1_5.S0 sg13cmos5l_inv_1_391.Y 0.16021f
C1825 sg13cmos5l_inv_1_1003.Y a_10208_13098# 0.05751f
C1826 sg13cmos5l_inv_1_824.A sg13cmos5l_buf_1_21.A 0.01226f
C1827 sg13cmos5l_mux4_1_13.A0 sg13cmos5l_inv_1_815.Y 0.21119f
C1828 sg13cmos5l_inv_1_876.A sg13cmos5l_inv_1_896.Y 0.03062f
C1829 sg13cmos5l_inv_1_568.Y VPWR 0.48118f
C1830 sg13cmos5l_inv_1_373.A VPWR 0.42369f
C1831 sg13cmos5l_inv_1_835.A sg13cmos5l_inv_1_824.A 0.02618f
C1832 sg13cmos5l_mux4_1_16.A1 sg13cmos5l_inv_1_399.Y 0.04494f
C1833 sg13cmos5l_inv_1_716.A sg13cmos5l_inv_1_994.A 0.01922f
C1834 sg13cmos5l_mux2_1_4.X a_8638_6558# 0.05678f
C1835 sg13cmos5l_mux4_1_11.A3 sg13cmos5l_inv_1_730.A 0.16356f
C1836 sg13cmos5l_inv_1_521.Y a_2632_11586# 0.02235f
C1837 sg13cmos5l_buf_1_8.A a_3592_10790# 0.01134f
C1838 a_13288_15326# VPWR 0.1312f
C1839 sg13cmos5l_mux2_1_4.S sg13cmos5l_inv_1_989.A 0.02291f
C1840 sg13cmos5l_inv_1_874.Y sg13cmos5l_inv_1_844.Y 0.18166f
C1841 sg13cmos5l_inv_1_332.A VPWR 0.52149f
C1842 sg13cmos5l_inv_1_359.Y sg13cmos5l_inv_1_366.Y 0.38777f
C1843 sg13cmos5l_inv_1_642.Y sg13cmos5l_inv_1_643.A 1.13091f
C1844 sg13cmos5l_inv_1_25.Y sg13cmos5l_inv_1_31.Y 0.01063f
C1845 sg13cmos5l_inv_1_495.A sg13cmos5l_a22oi_1_0.A1 0.01976f
C1846 sg13cmos5l_inv_1_277.A sg13cmos5l_inv_1_277.Y 0.28877f
C1847 sg13cmos5l_inv_1_811.Y sg13cmos5l_inv_1_802.A 0.03253f
C1848 sg13cmos5l_inv_1_287.A sg13cmos5l_inv_1_285.Y 0.02342f
C1849 sg13cmos5l_inv_1_479.Y sg13cmos5l_inv_1_482.Y 0.06072f
C1850 sg13cmos5l_inv_1_282.Y sg13cmos5l_inv_1_288.Y 0.20044f
C1851 sg13cmos5l_buf_1_10.A sg13cmos5l_inv_1_969.Y 0.12509f
C1852 sg13cmos5l_inv_1_701.A sg13cmos5l_inv_1_930.A 0.01495f
C1853 a_13288_1002# a_13472_1002# 0.11523f
C1854 sg13cmos5l_inv_1_124.A VPWR 0.6191f
C1855 sg13cmos5l_a21oi_1_0.A2 a_8315_11752# 0.11019f
C1856 sg13cmos5l_inv_1_113.A sg13cmos5l_mux2_1_3.A0 0.07688f
C1857 sg13cmos5l_nor3_1_2.B sg13cmos5l_a22oi_1_0.A1 0.07754f
C1858 a_6368_4742# VPWR 0.07706f
C1859 sg13cmos5l_inv_1_924.Y a_6656_10074# 0.01162f
C1860 sg13cmos5l_inv_1_828.Y sg13cmos5l_inv_1_821.Y 0.02923f
C1861 sg13cmos5l_inv_1_680.Y VPWR 0.47871f
C1862 sg13cmos5l_inv_1_7.Y VPWR 0.59152f
C1863 sg13cmos5l_inv_1_510.A a_2240_13098# 0.04886f
C1864 sg13cmos5l_inv_1_944.Y VPWR 0.49401f
C1865 sg13cmos5l_inv_1_964.A a_8000_9278# 0.01162f
C1866 sg13cmos5l_inv_1_69.A sg13cmos5l_inv_1_250.Y 0.02952f
C1867 sg13cmos5l_inv_1_850.Y VPWR 0.42563f
C1868 sg13cmos5l_inv_1_224.A a_13288_5538# 0.04567f
C1869 sg13cmos5l_inv_1_206.Y sg13cmos5l_inv_1_227.A 0.20349f
C1870 sg13cmos5l_inv_1_268.A VPWR 0.48105f
C1871 sg13cmos5l_inv_1_95.A sg13cmos5l_inv_1_67.A 0.18154f
C1872 a_5005_7954# VPWR 0.12166f
C1873 sg13cmos5l_inv_1_177.Y a_18464_7766# 0.04511f
C1874 sg13cmos5l_inv_1_431.A sg13cmos5l_inv_1_367.Y 0.03721f
C1875 a_2632_4026# VPWR 0.15492f
C1876 sg13cmos5l_inv_1_487.A sg13cmos5l_inv_1_473.Y 0.0389f
C1877 sg13cmos5l_buf_1_9.A sg13cmos5l_inv_1_319.Y 0.0708f
C1878 sg13cmos5l_mux4_1_5.S1 sg13cmos5l_inv_1_115.A 0.10215f
C1879 sg13cmos5l_buf_1_9.A a_4798_12970# 0.04017f
C1880 sg13cmos5l_inv_1_990.A sg13cmos5l_inv_1_351.A 0.01055f
C1881 sg13cmos5l_inv_1_238.A sg13cmos5l_inv_1_945.Y 0.20065f
C1882 sg13cmos5l_mux2_1_4.S VPWR 3.96128f
C1883 sg13cmos5l_inv_1_533.Y sg13cmos5l_mux4_1_5.S0 0.03945f
C1884 sg13cmos5l_inv_1_600.A a_9440_17634# 0.01098f
C1885 sg13cmos5l_inv_1_107.Y a_13288_6254# 0.02188f
C1886 sg13cmos5l_mux4_1_14.A1 a_14206_15630# 0.03865f
C1887 a_12808_8562# VPWR 0.20995f
C1888 sg13cmos5l_inv_1_733.A sg13cmos5l_inv_1_734.A 0.18555f
C1889 a_5792_1002# VPWR 0.08036f
C1890 sg13cmos5l_a21oi_1_0.B1 sg13cmos5l_a21oi_1_0.A1 0.12961f
C1891 a_9544_10074# VPWR 0.13947f
C1892 sg13cmos5l_inv_1_463.Y sg13cmos5l_inv_1_464.Y 0.20065f
C1893 sg13cmos5l_inv_1_206.A sg13cmos5l_inv_1_184.A 0.01517f
C1894 sg13cmos5l_inv_1_241.A VPWR 1.21862f
C1895 sg13cmos5l_mux4_1_15.X sg13cmos5l_inv_1_933.A 0.07504f
C1896 sg13cmos5l_inv_1_149.A sg13cmos5l_inv_1_78.A 0.7366f
C1897 sg13cmos5l_inv_1_248.A sg13cmos5l_inv_1_441.A 0.20452f
C1898 a_19048_13098# VPWR 0.13045f
C1899 a_10504_9192# VPWR 0.33884f
C1900 sg13cmos5l_inv_1_950.Y VPWR 0.44739f
C1901 sg13cmos5l_buf_1_9.A sg13cmos5l_inv_1_949.Y 0.08777f
C1902 sg13cmos5l_buf_1_12.X sg13cmos5l_nand2_1_1.Y 0.07814f
C1903 sg13cmos5l_inv_1_904.A VPWR 0.45199f
C1904 sg13cmos5l_inv_1_956.Y a_17696_9278# 0.03465f
C1905 sg13cmos5l_inv_1_345.A sg13cmos5l_inv_1_450.Y 0.04201f
C1906 sg13cmos5l_inv_1_950.A sg13cmos5l_inv_1_973.Y 0.05626f
C1907 sg13cmos5l_inv_1_248.A a_8086_3534# 0.06922f
C1908 sg13cmos5l_inv_1_828.Y sg13cmos5l_inv_1_843.Y 0.07322f
C1909 sg13cmos5l_buf_1_8.A sg13cmos5l_inv_1_962.Y 0.0128f
C1910 sg13cmos5l_inv_1_18.A sg13cmos5l_inv_1_18.Y 0.16988f
C1911 sg13cmos5l_inv_1_557.Y sg13cmos5l_inv_1_557.A 0.27011f
C1912 sg13cmos5l_inv_1_739.A VPWR 0.45754f
C1913 sg13cmos5l_inv_1_124.A a_9982_8050# 0.04252f
C1914 sg13cmos5l_inv_1_283.A sg13cmos5l_inv_1_265.A 0.02343f
C1915 sg13cmos5l_nand2_1_1.B sg13cmos5l_mux2_1_3.S 0.87747f
C1916 sg13cmos5l_inv_1_761.A VPWR 0.72182f
C1917 sg13cmos5l_mux2_1_4.S a_15201_15588# 0.25757f
C1918 sg13cmos5l_inv_1_744.Y sg13cmos5l_inv_1_720.Y 0.07755f
C1919 sg13cmos5l_inv_1_72.Y VPWR 0.42207f
C1920 sg13cmos5l_inv_1_336.A sg13cmos5l_inv_1_328.A 0.01853f
C1921 sg13cmos5l_mux4_1_5.S0 sg13cmos5l_inv_1_479.Y 0.01287f
C1922 sg13cmos5l_inv_1_759.A VPWR 0.48803f
C1923 sg13cmos5l_mux4_1_16.X a_10159_7704# 0.01329f
C1924 sg13cmos5l_inv_1_392.A VPWR 0.43839f
C1925 a_18764_5370# VPWR 0.25723f
C1926 sg13cmos5l_mux4_1_5.S0 sg13cmos5l_inv_1_241.Y 0.22718f
C1927 sg13cmos5l_inv_1_237.A VPWR 0.74532f
C1928 sg13cmos5l_inv_1_511.A VPWR 0.46307f
C1929 sg13cmos5l_inv_1_534.Y sg13cmos5l_buf_1_9.A 0.13232f
C1930 sg13cmos5l_inv_1_998.Y VPWR 0.58686f
C1931 a_13288_5538# VPWR 0.14013f
C1932 sg13cmos5l_mux4_1_7.A1 sg13cmos5l_inv_1_654.Y 0.2817f
C1933 sg13cmos5l_mux2_1_4.X sg13cmos5l_mux4_1_5.X 0.03186f
C1934 sg13cmos5l_inv_1_622.Y a_6848_16122# 0.03508f
C1935 sg13cmos5l_inv_1_6.Y sg13cmos5l_inv_1_7.A 0.29661f
C1936 sg13cmos5l_inv_1_366.Y sg13cmos5l_inv_1_356.Y 0.04824f
C1937 sg13cmos5l_inv_1_418.Y sg13cmos5l_inv_1_459.A 0.38471f
C1938 sg13cmos5l_inv_1_422.A a_2632_4742# 0.04543f
C1939 sg13cmos5l_inv_1_334.A sg13cmos5l_inv_1_337.A 0.03427f
C1940 a_7271_3534# a_7508_3534# 0.01012f
C1941 sg13cmos5l_mux2_1_3.S sg13cmos5l_inv_1_964.A 0.01037f
C1942 sg13cmos5l_buf_1_9.A a_3623_12606# 0.01603f
C1943 sg13cmos5l_buf_1_8.A sg13cmos5l_inv_1_236.Y 0.01282f
C1944 sg13cmos5l_inv_1_411.Y sg13cmos5l_inv_1_411.A 0.11167f
C1945 sg13cmos5l_inv_1_16.Y sg13cmos5l_inv_1_18.Y 0.06388f
C1946 sg13cmos5l_mux4_1_10.A3 sg13cmos5l_mux4_1_5.S0 0.07661f
C1947 sg13cmos5l_inv_1_711.Y sg13cmos5l_inv_1_720.Y 0.02106f
C1948 sg13cmos5l_mux2_1_4.S a_9982_8050# 0.076f
C1949 sg13cmos5l_mux2_1_0.X sg13cmos5l_inv_1_129.Y 0.02698f
C1950 sg13cmos5l_inv_1_31.Y VPWR 0.42954f
C1951 sg13cmos5l_buf_1_12.X sg13cmos5l_nor3_1_0.Y 0.02976f
C1952 sg13cmos5l_inv_1_45.Y sg13cmos5l_inv_1_22.A 0.12398f
C1953 sg13cmos5l_nor4_1_0.Y a_9996_11500# 0.28131f
C1954 sg13cmos5l_inv_1_311.Y sg13cmos5l_inv_1_272.A 0.3391f
C1955 sg13cmos5l_inv_1_46.A sg13cmos5l_inv_1_8.A 0.0114f
C1956 sg13cmos5l_mux4_1_13.A0 a_14206_15630# 0.01891f
C1957 sg13cmos5l_inv_1_923.Y VPWR 0.49833f
C1958 sg13cmos5l_inv_1_258.A sg13cmos5l_inv_1_260.A 0.04503f
C1959 sg13cmos5l_inv_1_780.A VPWR 0.34232f
C1960 sg13cmos5l_inv_1_584.A sg13cmos5l_inv_1_618.Y 0.05363f
C1961 sg13cmos5l_mux4_1_2.A2 a_15768_4088# 0.01766f
C1962 sg13cmos5l_a22oi_1_0.B1 sg13cmos5l_a21oi_1_0.Y 0.01034f
C1963 sg13cmos5l_inv_1_690.A VPWR 0.41878f
C1964 sg13cmos5l_inv_1_248.A a_7582_3534# 0.02365f
C1965 sg13cmos5l_mux2_1_2.A0 sg13cmos5l_inv_1_632.A 0.0133f
C1966 sg13cmos5l_inv_1_46.A sg13cmos5l_inv_1_2.Y 0.19424f
C1967 sg13cmos5l_buf_1_0.A sg13cmos5l_inv_1_6.Y 0.03027f
C1968 sg13cmos5l_a22oi_1_0.B1 sg13cmos5l_inv_1_481.Y 0.01778f
C1969 sg13cmos5l_buf_1_10.A sg13cmos5l_inv_1_403.A 0.05827f
C1970 sg13cmos5l_inv_1_248.A sg13cmos5l_inv_1_279.Y 0.01032f
C1971 sg13cmos5l_inv_1_723.A sg13cmos5l_inv_1_696.A 0.01686f
C1972 sg13cmos5l_inv_1_344.A sg13cmos5l_inv_1_362.Y 0.05786f
C1973 sg13cmos5l_a21oi_1_0.A1 a_8315_11752# 0.1352f
C1974 sg13cmos5l_inv_1_311.Y sg13cmos5l_inv_1_294.Y 0.01046f
C1975 a_3623_3534# sg13cmos5l_inv_1_324.Y 0.09748f
C1976 sg13cmos5l_inv_1_328.A a_1856_2514# 0.05751f
C1977 sg13cmos5l_buf_1_10.A sg13cmos5l_inv_1_319.Y 0.05571f
C1978 a_13288_13098# a_13288_12302# 0.01095f
C1979 sg13cmos5l_inv_1_101.Y a_10496_3230# 0.04511f
C1980 a_4798_12970# sg13cmos5l_buf_1_10.A 0.01363f
C1981 sg13cmos5l_buf_1_0.A sg13cmos5l_inv_1_15.Y 0.0154f
C1982 sg13cmos5l_inv_1_120.A sg13cmos5l_inv_1_112.Y 0.03537f
C1983 sg13cmos5l_mux4_1_15.A2 a_16456_9278# 0.05229f
C1984 sg13cmos5l_inv_1_828.Y sg13cmos5l_inv_1_806.Y 0.01195f
C1985 sg13cmos5l_inv_1_872.A sg13cmos5l_mux4_1_13.A3 0.01603f
C1986 a_7271_15994# a_8086_15994# 0.49917f
C1987 sg13cmos5l_buf_1_10.A sg13cmos5l_inv_1_314.Y 0.01283f
C1988 sg13cmos5l_inv_1_305.Y sg13cmos5l_inv_1_310.Y 0.01872f
C1989 sg13cmos5l_inv_1_212.Y sg13cmos5l_inv_1_187.A 0.01075f
C1990 sg13cmos5l_inv_1_614.A sg13cmos5l_mux4_1_5.S0 0.0202f
C1991 a_17696_9278# VPWR 0.07957f
C1992 sg13cmos5l_inv_1_217.A sg13cmos5l_inv_1_205.A 0.05205f
C1993 sg13cmos5l_mux4_1_5.S0 sg13cmos5l_inv_1_389.Y 0.13123f
C1994 a_8795_11752# VPWR 0.28414f
C1995 sg13cmos5l_inv_1_480.Y a_10208_13098# 0.03465f
C1996 sg13cmos5l_inv_1_892.A sg13cmos5l_inv_1_892.Y 0.18584f
C1997 sg13cmos5l_inv_1_557.A VPWR 0.49492f
C1998 sg13cmos5l_inv_1_684.Y sg13cmos5l_inv_1_671.A 0.03297f
C1999 sg13cmos5l_inv_1_372.A VPWR 0.42359f
C2000 sg13cmos5l_inv_1_1011.A a_8577_3492# 0.01784f
C2001 sg13cmos5l_mux4_1_16.A1 sg13cmos5l_inv_1_398.Y 0.32246f
C2002 sg13cmos5l_inv_1_124.A sg13cmos5l_mux4_1_16.A2 0.01099f
C2003 sg13cmos5l_inv_1_823.Y sg13cmos5l_inv_1_824.A 0.09635f
C2004 sg13cmos5l_mux4_1_11.A3 sg13cmos5l_inv_1_715.Y 0.02542f
C2005 sg13cmos5l_inv_1_521.Y sg13cmos5l_inv_1_947.A 0.11958f
C2006 sg13cmos5l_buf_1_8.A sg13cmos5l_mux4_1_5.S1 1.21587f
C2007 sg13cmos5l_mux2_1_4.S sg13cmos5l_inv_1_448.A 0.71159f
C2008 sg13cmos5l_inv_1_359.Y sg13cmos5l_inv_1_366.A 0.23664f
C2009 sg13cmos5l_inv_1_874.A sg13cmos5l_inv_1_844.Y 0.02521f
C2010 sg13cmos5l_a22oi_1_0.A1 sg13cmos5l_a21oi_1_0.A2 0.35694f
C2011 sg13cmos5l_inv_1_505.Y a_2152_10790# 0.03867f
C2012 a_808_1632# VPWR 0.25232f
C2013 sg13cmos5l_inv_1_297.Y sg13cmos5l_inv_1_301.A 0.06627f
C2014 sg13cmos5l_inv_1_331.A a_3304_2514# 0.05172f
C2015 sg13cmos5l_inv_1_287.A sg13cmos5l_inv_1_287.Y 0.20927f
C2016 sg13cmos5l_inv_1_479.Y sg13cmos5l_inv_1_478.A 0.01928f
C2017 sg13cmos5l_inv_1_341.Y sg13cmos5l_inv_1_437.A 0.01051f
C2018 sg13cmos5l_a21oi_1_0.B1 sg13cmos5l_buf_1_8.A 0.02137f
C2019 sg13cmos5l_inv_1_696.A VPWR 0.37128f
C2020 sg13cmos5l_inv_1_446.A VPWR 0.43513f
C2021 sg13cmos5l_inv_1_924.Y sg13cmos5l_inv_1_982.A 0.09812f
C2022 sg13cmos5l_inv_1_972.Y a_6656_10074# 0.03553f
C2023 sg13cmos5l_inv_1_782.A a_12808_18350# 0.03479f
C2024 sg13cmos5l_inv_1_828.Y sg13cmos5l_inv_1_819.Y 0.26721f
C2025 sg13cmos5l_inv_1_2.A VPWR 0.4142f
C2026 sg13cmos5l_inv_1_973.Y VPWR 0.34176f
C2027 sg13cmos5l_mux2_1_3.A0 sg13cmos5l_inv_1_130.Y 0.03513f
C2028 a_11944_7050# VPWR 0.1371f
C2029 a_9256_18350# VPWR 0.12739f
C2030 a_13288_6254# VPWR 0.12492f
C2031 sg13cmos5l_nor3_1_2.B sg13cmos5l_nor3_1_1.A 0.32574f
C2032 sg13cmos5l_inv_1_964.A sg13cmos5l_inv_1_964.Y 0.2026f
C2033 sg13cmos5l_inv_1_851.Y VPWR 0.42555f
C2034 sg13cmos5l_mux2_1_4.S sg13cmos5l_mux4_1_16.A2 0.03028f
C2035 a_15584_10790# VPWR 0.08348f
C2036 sg13cmos5l_mux4_1_7.A3 a_6664_13814# 0.01591f
C2037 sg13cmos5l_inv_1_120.A sg13cmos5l_buf_1_12.X 0.02006f
C2038 sg13cmos5l_inv_1_429.A sg13cmos5l_inv_1_430.A 0.20065f
C2039 sg13cmos5l_inv_1_264.A VPWR 0.42555f
C2040 sg13cmos5l_inv_1_90.Y sg13cmos5l_inv_1_86.Y 0.15745f
C2041 a_7582_3534# a_8005_3195# 0.01929f
C2042 sg13cmos5l_inv_1_95.A sg13cmos5l_inv_1_66.A 0.0235f
C2043 sg13cmos5l_inv_1_177.Y sg13cmos5l_inv_1_176.A 0.10867f
C2044 a_13607_12606# a_14422_12606# 0.49917f
C2045 sg13cmos5l_inv_1_535.A a_3623_15994# 0.03881f
C2046 a_13288_9278# a_13288_8562# 0.01275f
C2047 sg13cmos5l_inv_1_431.A sg13cmos5l_inv_1_347.Y 0.23369f
C2048 sg13cmos5l_buf_1_12.X sg13cmos5l_inv_1_340.Y 0.58075f
C2049 sg13cmos5l_inv_1_338.Y VPWR 0.56537f
C2050 sg13cmos5l_inv_1_450.Y sg13cmos5l_inv_1_317.Y 0.12251f
C2051 a_3872_13098# VPWR 0.0889f
C2052 sg13cmos5l_inv_1_114.Y sg13cmos5l_inv_1_115.A 0.60673f
C2053 a_1568_7766# VPWR 0.07736f
C2054 sg13cmos5l_buf_1_9.A sg13cmos5l_inv_1_933.Y 0.02943f
C2055 a_18176_4742# VPWR 0.07952f
C2056 sg13cmos5l_inv_1_806.Y sg13cmos5l_inv_1_810.Y 0.01469f
C2057 sg13cmos5l_inv_1_147.Y sg13cmos5l_inv_1_147.A 0.20499f
C2058 sg13cmos5l_inv_1_165.Y VPWR 0.42137f
C2059 sg13cmos5l_inv_1_159.A sg13cmos5l_mux2_1_3.A0 0.01632f
C2060 a_8008_12302# a_8192_12302# 0.11523f
C2061 sg13cmos5l_inv_1_733.A sg13cmos5l_inv_1_938.Y 0.07558f
C2062 sg13cmos5l_buf_1_9.A sg13cmos5l_mux4_1_15.A2 0.09835f
C2063 sg13cmos5l_inv_1_863.A sg13cmos5l_inv_1_863.Y 0.20065f
C2064 sg13cmos5l_inv_1_66.A a_11456_1718# 0.03589f
C2065 sg13cmos5l_inv_1_145.Y sg13cmos5l_inv_1_205.Y 0.01087f
C2066 sg13cmos5l_inv_1_100.A a_14110_3534# 0.14704f
C2067 sg13cmos5l_inv_1_562.A a_4928_17634# 0.01092f
C2068 sg13cmos5l_inv_1_565.Y a_3623_15994# 0.26748f
C2069 sg13cmos5l_inv_1_798.A a_12136_16122# 0.03609f
C2070 a_3934_3534# a_3847_3195# 0.02548f
C2071 sg13cmos5l_inv_1_418.Y sg13cmos5l_inv_1_417.Y 0.17994f
C2072 sg13cmos5l_inv_1_118.Y sg13cmos5l_inv_1_136.Y 0.05978f
C2073 sg13cmos5l_inv_1_110.A sg13cmos5l_inv_1_111.Y 0.02204f
C2074 sg13cmos5l_mux4_1_15.X sg13cmos5l_mux4_1_15.A2 0.05804f
C2075 sg13cmos5l_buf_1_12.X sg13cmos5l_mux2_1_3.X 0.17186f
C2076 sg13cmos5l_inv_1_149.A sg13cmos5l_inv_1_149.Y 0.18502f
C2077 sg13cmos5l_a21oi_1_1.A2 a_8795_11752# 0.10988f
C2078 sg13cmos5l_inv_1_905.Y VPWR 0.43428f
C2079 sg13cmos5l_inv_1_986.Y a_18664_9192# 0.01487f
C2080 sg13cmos5l_inv_1_957.Y sg13cmos5l_inv_1_958.Y 0.19345f
C2081 sg13cmos5l_inv_1_345.A sg13cmos5l_inv_1_439.Y 0.14361f
C2082 sg13cmos5l_inv_1_85.A sg13cmos5l_inv_1_95.A 0.16671f
C2083 sg13cmos5l_nor2b_1_0.B_N invsel[5] 0.52202f
C2084 sg13cmos5l_buf_1_8.A sg13cmos5l_inv_1_985.Y 0.15457f
C2085 sg13cmos5l_inv_1_324.Y a_4438_3534# 0.24643f
C2086 sg13cmos5l_inv_1_18.A sg13cmos5l_inv_1_19.A 0.03699f
C2087 sg13cmos5l_inv_1_740.A VPWR 0.44698f
C2088 sg13cmos5l_inv_1_394.A sg13cmos5l_inv_1_394.Y 0.09204f
C2089 sg13cmos5l_inv_1_283.A sg13cmos5l_inv_1_266.A 0.35143f
C2090 sg13cmos5l_nand2_1_1.B sg13cmos5l_inv_1_922.A 0.13666f
C2091 sg13cmos5l_inv_1_535.A sg13cmos5l_mux4_1_10.A2 0.15952f
C2092 a_2816_4742# VPWR 0.08039f
C2093 sg13cmos5l_inv_1_1010.Y VPWR 0.53659f
C2094 sg13cmos5l_inv_1_1011.A VPWR 0.92531f
C2095 a_6823_13237# VPWR 0.02431f
C2096 sg13cmos5l_inv_1_336.A sg13cmos5l_inv_1_329.A 0.71644f
C2097 sg13cmos5l_inv_1_321.A sg13cmos5l_inv_1_328.A 0.0237f
C2098 sg13cmos5l_mux4_1_9.X a_4438_12606# 0.0421f
C2099 a_14422_12606# a_14989_12490# 0.40359f
C2100 a_6430_8434# a_7425_8476# 0.48298f
C2101 sg13cmos5l_inv_1_987.A VPWR 0.48684f
C2102 sg13cmos5l_inv_1_393.Y VPWR 0.44939f
C2103 sg13cmos5l_inv_1_237.Y a_4438_3534# 0.05366f
C2104 sg13cmos5l_inv_1_936.A sg13cmos5l_inv_1_202.Y 0.02234f
C2105 a_10496_16838# VPWR 0.08398f
C2106 sg13cmos5l_mux4_1_13.A0 a_18184_16838# 0.03921f
C2107 sg13cmos5l_inv_1_245.A VPWR 0.5044f
C2108 sg13cmos5l_inv_1_874.Y sg13cmos5l_mux4_1_13.A3 0.03562f
C2109 sg13cmos5l_inv_1_467.Y sg13cmos5l_inv_1_402.A 0.02012f
C2110 sg13cmos5l_inv_1_747.Y a_13918_12606# 0.01539f
C2111 sg13cmos5l_inv_1_189.Y sg13cmos5l_inv_1_198.Y 0.20065f
C2112 sg13cmos5l_inv_1_735.Y VPWR 0.36342f
C2113 sg13cmos5l_inv_1_209.Y VPWR 0.43589f
C2114 sg13cmos5l_inv_1_576.A a_3934_15994# 0.13914f
C2115 sg13cmos5l_inv_1_533.Y sg13cmos5l_inv_1_682.A 0.01788f
C2116 sg13cmos5l_inv_1_113.A sg13cmos5l_mux4_1_15.A2 0.01136f
C2117 a_14183_9582# sg13cmos5l_inv_1_202.Y 0.21171f
C2118 sg13cmos5l_mux4_1_5.S0 a_2632_4026# 0.024f
C2119 sg13cmos5l_inv_1_421.A sg13cmos5l_inv_1_451.A 0.61465f
C2120 sg13cmos5l_inv_1_157.Y sg13cmos5l_inv_1_162.A 0.20065f
C2121 sg13cmos5l_inv_1_366.A sg13cmos5l_inv_1_356.Y 0.11319f
C2122 sg13cmos5l_inv_1_418.Y sg13cmos5l_inv_1_433.Y 0.05766f
C2123 sg13cmos5l_o21ai_1_0.B1 sg13cmos5l_mux2_1_3.S 0.0982f
C2124 sg13cmos5l_inv_1_565.Y sg13cmos5l_mux4_1_10.A2 0.01891f
C2125 sg13cmos5l_inv_1_658.Y sg13cmos5l_inv_1_624.Y 0.18584f
C2126 sg13cmos5l_mux4_1_5.S1 sg13cmos5l_inv_1_158.Y 0.01135f
C2127 a_14110_3534# a_14317_3195# 0.01967f
C2128 a_2816_11586# VPWR 0.07663f
C2129 sg13cmos5l_inv_1_736.Y sg13cmos5l_inv_1_738.A 0.0186f
C2130 sg13cmos5l_inv_1_306.A sg13cmos5l_inv_1_260.A 0.0407f
C2131 sg13cmos5l_inv_1_903.Y a_13288_13814# 0.02174f
C2132 sg13cmos5l_mux4_1_5.X a_8086_3534# 0.01884f
C2133 a_1576_6254# VPWR 0.13634f
C2134 sg13cmos5l_mux4_1_1.A3 a_15181_3418# 0.01232f
C2135 sg13cmos5l_mux4_1_1.X VPWR 0.35933f
C2136 sg13cmos5l_mux4_1_5.S0 sg13cmos5l_inv_1_241.A 0.01517f
C2137 sg13cmos5l_buf_1_12.X sg13cmos5l_nor4_1_0.A 0.03161f
C2138 sg13cmos5l_buf_1_8.A sg13cmos5l_buf_1_0.A 0.02086f
C2139 sg13cmos5l_inv_1_828.Y a_18764_18228# 0.32828f
C2140 sg13cmos5l_or2_1_0.X a_9996_11500# 0.01784f
C2141 sg13cmos5l_inv_1_499.Y sg13cmos5l_inv_1_926.A 0.01072f
C2142 sg13cmos5l_inv_1_311.Y sg13cmos5l_mux4_1_5.X 0.01832f
C2143 sg13cmos5l_inv_1_386.Y a_5608_7050# 0.01986f
C2144 sg13cmos5l_inv_1_868.A a_17224_15326# 0.03488f
C2145 sg13cmos5l_inv_1_922.Y VPWR 0.46399f
C2146 sg13cmos5l_inv_1_584.A sg13cmos5l_inv_1_618.A 0.03728f
C2147 sg13cmos5l_inv_1_148.Y sg13cmos5l_inv_1_227.A 0.0141f
C2148 sg13cmos5l_buf_1_19.A a_18764_12180# 0.33391f
C2149 sg13cmos5l_inv_1_780.Y VPWR 0.40662f
C2150 sg13cmos5l_mux4_1_12.A1 sg13cmos5l_inv_1_762.Y 0.42482f
C2151 sg13cmos5l_nand2_1_1.B sg13cmos5l_nor4_1_0.Y 0.18251f
C2152 sg13cmos5l_inv_1_642.A VPWR 0.42472f
C2153 sg13cmos5l_inv_1_46.A sg13cmos5l_inv_1_46.Y 0.26834f
C2154 sg13cmos5l_inv_1_6.Y sg13cmos5l_inv_1_2.Y 0.05189f
C2155 sg13cmos5l_buf_1_12.X sg13cmos5l_mux4_1_6.X 0.12803f
C2156 sg13cmos5l_mux2_1_1.X a_8446_8434# 0.22607f
C2157 sg13cmos5l_nor3_1_2.B sg13cmos5l_inv_1_495.A 0.01557f
C2158 sg13cmos5l_a22oi_1_0.B1 sg13cmos5l_inv_1_486.Y 0.1642f
C2159 sg13cmos5l_nor3_1_1.A sg13cmos5l_nor3_1_1.B 0.90575f
C2160 sg13cmos5l_inv_1_248.A sg13cmos5l_inv_1_277.Y 0.38624f
C2161 sg13cmos5l_inv_1_721.A sg13cmos5l_inv_1_696.A 0.01076f
C2162 sg13cmos5l_inv_1_305.Y sg13cmos5l_inv_1_362.Y 0.32632f
C2163 sg13cmos5l_inv_1_827.A sg13cmos5l_inv_1_825.A 0.20065f
C2164 a_14989_12490# a_14913_12564# 0.26108f
C2165 a_14206_15630# sg13cmos5l_mux2_1_4.S 0.05055f
C2166 sg13cmos5l_inv_1_806.Y a_13288_17634# 0.03352f
C2167 sg13cmos5l_inv_1_237.Y a_4929_3492# 0.03245f
C2168 a_18664_3144# a_19048_3230# 0.03269f
C2169 sg13cmos5l_buf_1_8.A a_2920_3932# 0.30037f
C2170 sg13cmos5l_inv_1_212.Y sg13cmos5l_inv_1_25.Y 0.06015f
C2171 sg13cmos5l_inv_1_634.A sg13cmos5l_inv_1_635.A 0.20065f
C2172 sg13cmos5l_inv_1_105.Y sg13cmos5l_inv_1_217.A 0.21166f
C2173 sg13cmos5l_inv_1_394.A sg13cmos5l_inv_1_387.Y 0.01368f
C2174 sg13cmos5l_mux4_1_7.A2 a_7905_13012# 0.01095f
C2175 sg13cmos5l_mux4_1_5.S0 sg13cmos5l_inv_1_392.A 0.05658f
C2176 sg13cmos5l_inv_1_217.A sg13cmos5l_inv_1_206.A 0.0176f
C2177 a_15637_8028# a_16723_7731# 0.02548f
C2178 sg13cmos5l_buf_1_9.A sg13cmos5l_inv_1_340.Y 0.21655f
C2179 sg13cmos5l_inv_1_892.A sg13cmos5l_inv_1_707.Y 0.05361f
C2180 sg13cmos5l_inv_1_570.A VPWR 0.60166f
C2181 sg13cmos5l_inv_1_397.Y sg13cmos5l_inv_1_398.Y 0.03719f
C2182 sg13cmos5l_mux4_1_16.A1 sg13cmos5l_inv_1_396.Y 0.03938f
C2183 a_8653_16000# VPWR 0.12086f
C2184 sg13cmos5l_buf_1_8.A sg13cmos5l_inv_1_502.Y 0.01612f
C2185 sg13cmos5l_inv_1_517.A a_2816_11586# 0.03465f
C2186 sg13cmos5l_mux4_1_5.X a_7582_3534# 0.01093f
C2187 a_15275_7644# a_15419_8040# 0.26108f
C2188 sg13cmos5l_nor3_1_2.B sg13cmos5l_mux4_1_11.A2 0.05849f
C2189 sg13cmos5l_inv_1_504.Y sg13cmos5l_inv_1_505.Y 0.19537f
C2190 sg13cmos5l_inv_1_504.A a_2152_10790# 0.02074f
C2191 sg13cmos5l_inv_1_798.Y a_12136_16122# 0.0213f
C2192 sg13cmos5l_inv_1_331.A sg13cmos5l_inv_1_301.A 0.13831f
C2193 sg13cmos5l_inv_1_311.A sg13cmos5l_inv_1_304.A 0.01493f
C2194 sg13cmos5l_inv_1_281.Y sg13cmos5l_inv_1_277.A 0.17584f
C2195 sg13cmos5l_inv_1_287.A sg13cmos5l_inv_1_292.Y 0.1004f
C2196 sg13cmos5l_inv_1_916.A sg13cmos5l_inv_1_905.A 0.0242f
C2197 sg13cmos5l_mux4_1_5.X sg13cmos5l_inv_1_286.Y 0.01262f
C2198 sg13cmos5l_inv_1_293.Y sg13cmos5l_inv_1_282.Y 0.30702f
C2199 sg13cmos5l_inv_1_714.A a_18280_12216# 0.04948f
C2200 sg13cmos5l_mux4_1_13.A3 a_14989_14488# 0.01051f
C2201 sg13cmos5l_nor3_1_1.A sg13cmos5l_a21oi_1_0.A2 0.53553f
C2202 sg13cmos5l_inv_1_717.A VPWR 0.36632f
C2203 sg13cmos5l_inv_1_292.Y sg13cmos5l_inv_1_249.Y 0.01882f
C2204 sg13cmos5l_inv_1_247.Y sg13cmos5l_inv_1_247.A 0.11315f
C2205 a_8968_9278# VPWR 0.12409f
C2206 a_8638_6558# a_8551_6219# 0.02548f
C2207 sg13cmos5l_inv_1_338.Y a_4072_3932# 0.03661f
C2208 sg13cmos5l_inv_1_83.Y sg13cmos5l_inv_1_85.Y 0.02366f
C2209 sg13cmos5l_inv_1_584.A a_7582_15994# 0.02506f
C2210 sg13cmos5l_inv_1_414.A VPWR 0.45202f
C2211 sg13cmos5l_inv_1_738.A a_11656_10074# 0.01023f
C2212 sg13cmos5l_inv_1_972.Y sg13cmos5l_inv_1_982.A 0.06203f
C2213 sg13cmos5l_inv_1_925.Y a_6656_10074# 0.03571f
C2214 sg13cmos5l_inv_1_384.Y a_9536_8562# 0.05795f
C2215 sg13cmos5l_inv_1_519.Y a_4264_13098# 0.04744f
C2216 a_4475_13008# a_4798_12970# 0.55132f
C2217 sg13cmos5l_inv_1_828.Y sg13cmos5l_inv_1_826.Y 0.04815f
C2218 sg13cmos5l_inv_1_40.Y VPWR 0.45935f
C2219 sg13cmos5l_inv_1_233.A sg13cmos5l_inv_1_92.A 0.01381f
C2220 sg13cmos5l_inv_1_236.Y sg13cmos5l_inv_1_76.A 0.01119f
C2221 sg13cmos5l_inv_1_111.A VPWR 0.36497f
C2222 sg13cmos5l_mux2_1_3.A0 sg13cmos5l_inv_1_129.Y 0.10108f
C2223 sg13cmos5l_inv_1_772.A VPWR 0.41436f
C2224 sg13cmos5l_o21ai_1_0.B1 sg13cmos5l_inv_1_964.Y 0.02824f
C2225 sg13cmos5l_inv_1_534.Y sg13cmos5l_mux4_1_8.A1 0.04724f
C2226 sg13cmos5l_inv_1_584.A sg13cmos5l_inv_1_643.A 0.01255f
C2227 sg13cmos5l_inv_1_145.Y VPWR 0.41024f
C2228 sg13cmos5l_inv_1_853.Y VPWR 0.42463f
C2229 sg13cmos5l_inv_1_377.Y a_808_7766# 0.02074f
C2230 sg13cmos5l_mux4_1_8.A2 sg13cmos5l_inv_1_612.A 0.27088f
C2231 sg13cmos5l_inv_1_389.A a_8327_6558# 0.06312f
C2232 sg13cmos5l_inv_1_225.Y sg13cmos5l_inv_1_206.Y 0.02955f
C2233 sg13cmos5l_inv_1_700.Y VPWR 0.42572f
C2234 sg13cmos5l_inv_1_584.A sg13cmos5l_inv_1_534.A 0.22161f
C2235 sg13cmos5l_inv_1_340.Y sg13cmos5l_inv_1_267.Y 0.02402f
C2236 sg13cmos5l_inv_1_265.A VPWR 0.44414f
C2237 a_5005_12490# a_4929_12564# 0.26108f
C2238 a_13288_8562# a_13472_8562# 0.11523f
C2239 sg13cmos5l_mux4_1_6.X sg13cmos5l_inv_1_391.A 0.01256f
C2240 sg13cmos5l_inv_1_182.A sg13cmos5l_inv_1_176.A 0.01801f
C2241 sg13cmos5l_mux4_1_15.A2 a_14998_9582# 0.02989f
C2242 sg13cmos5l_inv_1_941.A a_11656_10074# 0.03631f
C2243 sg13cmos5l_inv_1_532.A VPWR 1.0805f
C2244 sg13cmos5l_inv_1_114.Y sg13cmos5l_inv_1_114.A 0.27431f
C2245 sg13cmos5l_inv_1_362.A VPWR 0.59989f
C2246 a_8577_16036# VPWR 0.70708f
C2247 sg13cmos5l_inv_1_244.A sg13cmos5l_inv_1_238.A 0.20065f
C2248 sg13cmos5l_buf_1_9.A sg13cmos5l_inv_1_935.A 0.03138f
C2249 sg13cmos5l_inv_1_213.Y VPWR 0.39562f
C2250 sg13cmos5l_mux4_1_5.X a_9432_3406# 0.02944f
C2251 sg13cmos5l_inv_1_171.Y VPWR 0.45973f
C2252 sg13cmos5l_buf_1_8.A a_15768_4088# 0.19696f
C2253 sg13cmos5l_inv_1_66.A sg13cmos5l_inv_1_66.Y 0.1667f
C2254 sg13cmos5l_inv_1_461.Y sg13cmos5l_inv_1_463.Y 0.20065f
C2255 a_3934_15994# a_4661_16307# 0.01228f
C2256 sg13cmos5l_inv_1_510.Y sg13cmos5l_inv_1_522.A 0.44066f
C2257 sg13cmos5l_a22oi_1_0.B1 a_8383_12192# 0.06511f
C2258 sg13cmos5l_inv_1_800.Y a_12136_16122# 0.03631f
C2259 sg13cmos5l_buf_1_27.X a_19048_9278# 0.02116f
C2260 sg13cmos5l_inv_1_235.Y a_10784_4742# 0.01101f
C2261 sg13cmos5l_mux4_1_5.S1 sg13cmos5l_inv_1_384.Y 0.01771f
C2262 a_13918_3898# VPWR 0.88382f
C2263 sg13cmos5l_inv_1_905.A VPWR 0.51437f
C2264 sg13cmos5l_inv_1_986.Y sg13cmos5l_inv_1_166.Y 0.09559f
C2265 sg13cmos5l_mux4_1_5.S1 sg13cmos5l_inv_1_76.A 0.12041f
C2266 a_12808_13098# VPWR 0.20783f
C2267 a_11456_4026# VPWR 0.07734f
C2268 sg13cmos5l_inv_1_345.A sg13cmos5l_inv_1_439.A 0.04613f
C2269 sg13cmos5l_inv_1_85.A sg13cmos5l_inv_1_82.Y 0.89639f
C2270 sg13cmos5l_inv_1_122.Y sg13cmos5l_inv_1_129.A 0.10243f
C2271 sg13cmos5l_buf_1_8.A sg13cmos5l_inv_1_359.Y 0.06001f
C2272 sg13cmos5l_mux2_1_2.A0 sg13cmos5l_inv_1_672.A 0.51823f
C2273 sg13cmos5l_a21oi_1_1.A1 sg13cmos5l_mux2_1_3.S 0.2186f
C2274 sg13cmos5l_inv_1_283.A sg13cmos5l_inv_1_311.Y 0.02093f
C2275 sg13cmos5l_nand2_1_1.B sg13cmos5l_inv_1_925.A 0.03074f
C2276 sg13cmos5l_inv_1_535.A sg13cmos5l_inv_1_533.A 0.06906f
C2277 a_1480_4026# sg13cmos5l_inv_1_321.A 0.01054f
C2278 sg13cmos5l_mux2_1_4.X a_8577_3492# 0.04163f
C2279 sg13cmos5l_inv_1_278.Y VPWR 1.38376f
C2280 sg13cmos5l_buf_1_23.X a_18664_16838# 0.06311f
C2281 a_19136_15326# VPWR 0.06747f
C2282 sg13cmos5l_mux4_1_11.A1 sg13cmos5l_nor3_1_2.B 0.04793f
C2283 sg13cmos5l_inv_1_493.A VPWR 0.48589f
C2284 sg13cmos5l_mux2_1_4.S sg13cmos5l_mux4_1_12.A1 0.02313f
C2285 sg13cmos5l_inv_1_393.A VPWR 0.40738f
C2286 sg13cmos5l_inv_1_967.Y a_5024_9278# 0.03589f
C2287 sg13cmos5l_inv_1_241.A sg13cmos5l_inv_1_257.A 0.02496f
C2288 sg13cmos5l_buf_1_10.A sg13cmos5l_inv_1_473.Y 0.08495f
C2289 sg13cmos5l_inv_1_789.Y VPWR 0.42464f
C2290 sg13cmos5l_inv_1_500.Y a_4640_10790# 0.03508f
C2291 sg13cmos5l_inv_1_247.A VPWR 0.42731f
C2292 sg13cmos5l_mux2_1_4.S sg13cmos5l_inv_1_100.A 0.379f
C2293 sg13cmos5l_mux4_1_13.A0 sg13cmos5l_inv_1_866.Y 0.10385f
C2294 sg13cmos5l_inv_1_212.Y VPWR 0.48316f
C2295 sg13cmos5l_inv_1_973.Y invsel[3] 0.01406f
C2296 sg13cmos5l_mux4_1_5.S0 sg13cmos5l_inv_1_338.Y 0.15985f
C2297 sg13cmos5l_a21oi_1_0.B1 a_7912_11586# 0.01277f
C2298 sg13cmos5l_inv_1_421.A sg13cmos5l_inv_1_436.A 0.21946f
C2299 sg13cmos5l_buf_1_12.X sg13cmos5l_inv_1_382.A 0.04014f
C2300 sg13cmos5l_inv_1_366.A sg13cmos5l_inv_1_366.Y 0.99509f
C2301 sg13cmos5l_inv_1_449.A sg13cmos5l_inv_1_337.A 0.19478f
C2302 sg13cmos5l_inv_1_433.A sg13cmos5l_inv_1_433.Y 0.23416f
C2303 sg13cmos5l_inv_1_672.A a_5024_13814# 0.05343f
C2304 sg13cmos5l_inv_1_565.Y sg13cmos5l_inv_1_533.A 0.43638f
C2305 sg13cmos5l_mux4_1_5.S1 sg13cmos5l_inv_1_169.Y 0.0136f
C2306 sg13cmos5l_inv_1_994.A a_17504_10074# 0.04632f
C2307 sg13cmos5l_inv_1_623.Y sg13cmos5l_inv_1_581.A 0.02413f
C2308 sg13cmos5l_mux4_1_11.A1 sg13cmos5l_mux4_1_11.A2 1.03576f
C2309 sg13cmos5l_inv_1_914.A sg13cmos5l_inv_1_892.Y 0.02716f
C2310 sg13cmos5l_inv_1_348.Y VPWR 0.43435f
C2311 sg13cmos5l_inv_1_514.A sg13cmos5l_inv_1_503.Y 0.03613f
C2312 sg13cmos5l_inv_1_514.Y sg13cmos5l_inv_1_950.Y 0.01312f
C2313 a_18764_12180# VPWR 0.27705f
C2314 sg13cmos5l_or2_1_0.X sg13cmos5l_nor4_1_0.Y 0.25317f
C2315 sg13cmos5l_inv_1_926.Y sg13cmos5l_inv_1_926.A 0.11183f
C2316 sg13cmos5l_inv_1_381.Y a_5608_7050# 0.03412f
C2317 sg13cmos5l_inv_1_783.A VPWR 0.4208f
C2318 sg13cmos5l_nand2_1_1.B sg13cmos5l_or2_1_0.X 0.041f
C2319 sg13cmos5l_inv_1_641.A VPWR 0.43466f
C2320 sg13cmos5l_inv_1_6.Y sg13cmos5l_inv_1_46.Y 0.06934f
C2321 sg13cmos5l_inv_1_421.A sg13cmos5l_inv_1_340.Y 0.39235f
C2322 a_3623_8070# sg13cmos5l_inv_1_346.Y 0.20049f
C2323 a_8577_16036# sg13cmos5l_a21oi_1_1.A2 0.20379f
C2324 sg13cmos5l_inv_1_818.Y sg13cmos5l_inv_1_868.A 0.2026f
C2325 sg13cmos5l_buf_1_9.A sg13cmos5l_inv_1_1012.Y 0.01089f
C2326 sg13cmos5l_a22oi_1_0.B1 sg13cmos5l_inv_1_483.Y 0.11659f
C2327 sg13cmos5l_nor3_1_1.A sg13cmos5l_a21oi_1_0.A1 0.2182f
C2328 sg13cmos5l_inv_1_713.A sg13cmos5l_inv_1_696.A 0.13434f
C2329 sg13cmos5l_buf_1_7.X sg13cmos5l_inv_1_311.A 0.11795f
C2330 sg13cmos5l_inv_1_248.A sg13cmos5l_inv_1_277.A 0.09336f
C2331 sg13cmos5l_mux4_1_5.S1 sg13cmos5l_inv_1_409.Y 0.02548f
C2332 sg13cmos5l_or2_1_0.B sg13cmos5l_nand2_1_1.B 0.23535f
C2333 sg13cmos5l_inv_1_6.Y sg13cmos5l_inv_1_22.Y 0.10099f
C2334 sg13cmos5l_inv_1_848.Y sg13cmos5l_inv_1_862.A 0.02879f
C2335 a_14389_11500# a_15475_11725# 0.02548f
C2336 sg13cmos5l_inv_1_168.A sg13cmos5l_buf_1_4.X 0.04724f
C2337 sg13cmos5l_buf_1_8.A sg13cmos5l_buf_1_7.X 0.0126f
C2338 sg13cmos5l_inv_1_509.Y sg13cmos5l_nor3_1_2.B 0.03902f
C2339 sg13cmos5l_mux4_1_5.S0 sg13cmos5l_inv_1_1011.A 0.03009f
C2340 a_16744_10074# VPWR 0.13722f
C2341 sg13cmos5l_inv_1_532.A a_2912_12302# 0.0359f
C2342 sg13cmos5l_inv_1_887.Y a_19048_13814# 0.03352f
C2343 sg13cmos5l_inv_1_892.A sg13cmos5l_inv_1_914.A 0.03954f
C2344 sg13cmos5l_mux4_1_11.A1 sg13cmos5l_inv_1_707.Y 0.15159f
C2345 sg13cmos5l_inv_1_544.Y VPWR 0.74197f
C2346 sg13cmos5l_inv_1_152.Y sg13cmos5l_inv_1_179.A 0.43291f
C2347 sg13cmos5l_inv_1_397.Y sg13cmos5l_inv_1_396.Y 0.10967f
C2348 sg13cmos5l_inv_1_576.A sg13cmos5l_inv_1_537.A 0.02572f
C2349 sg13cmos5l_o21ai_1_0.B1 sg13cmos5l_nand2_1_1.B 0.37005f
C2350 sg13cmos5l_mux4_1_11.A3 sg13cmos5l_inv_1_722.Y 0.17548f
C2351 sg13cmos5l_buf_1_8.A sg13cmos5l_inv_1_1009.Y 0.11755f
C2352 a_18280_18264# VPWR 0.31338f
C2353 sg13cmos5l_mux4_1_10.A3 sg13cmos5l_inv_1_534.A 0.09746f
C2354 sg13cmos5l_inv_1_504.A sg13cmos5l_inv_1_507.Y 0.06886f
C2355 sg13cmos5l_inv_1_504.Y sg13cmos5l_inv_1_504.A 0.1561f
C2356 sg13cmos5l_buf_1_9.A sg13cmos5l_inv_1_642.Y 0.73269f
C2357 sg13cmos5l_inv_1_312.Y sg13cmos5l_inv_1_304.A 0.01067f
C2358 sg13cmos5l_buf_1_10.A sg13cmos5l_mux4_1_6.X 0.03495f
C2359 sg13cmos5l_inv_1_341.Y sg13cmos5l_inv_1_436.A 0.01412f
C2360 sg13cmos5l_mux4_1_5.X sg13cmos5l_inv_1_288.Y 0.01277f
C2361 sg13cmos5l_inv_1_272.A sg13cmos5l_inv_1_282.Y 0.06743f
C2362 sg13cmos5l_inv_1_843.Y a_17896_17634# 0.02295f
C2363 sg13cmos5l_inv_1_45.Y VPWR 2.38919f
C2364 sg13cmos5l_inv_1_726.A a_17896_13098# 0.02261f
C2365 sg13cmos5l_inv_1_714.A sg13cmos5l_inv_1_712.A 0.11592f
C2366 sg13cmos5l_mux4_1_15.A3 sg13cmos5l_inv_1_930.A 0.03029f
C2367 sg13cmos5l_inv_1_699.A VPWR 0.51897f
C2368 sg13cmos5l_mux2_1_4.X VPWR 0.97528f
C2369 sg13cmos5l_o21ai_1_0.B1 a_9920_9278# 0.04047f
C2370 sg13cmos5l_inv_1_415.A VPWR 0.42576f
C2371 a_17312_16122# VPWR 0.07746f
C2372 sg13cmos5l_inv_1_925.Y sg13cmos5l_inv_1_982.A 0.12212f
C2373 sg13cmos5l_buf_1_9.A sg13cmos5l_mux4_1_13.A3 0.04813f
C2374 sg13cmos5l_inv_1_972.Y sg13cmos5l_inv_1_924.Y 0.23015f
C2375 sg13cmos5l_inv_1_394.Y a_9536_8562# 0.03527f
C2376 sg13cmos5l_mux4_1_9.X a_4798_12970# 0.57981f
C2377 sg13cmos5l_buf_1_8.A sg13cmos5l_inv_1_337.A 0.38962f
C2378 a_11456_17634# VPWR 0.07741f
C2379 sg13cmos5l_buf_1_9.A a_13607_12606# 0.5678f
C2380 sg13cmos5l_mux2_1_3.A0 sg13cmos5l_inv_1_138.Y 0.07375f
C2381 sg13cmos5l_inv_1_606.Y VPWR 0.36786f
C2382 sg13cmos5l_o21ai_1_0.B1 sg13cmos5l_inv_1_964.A 0.02482f
C2383 sg13cmos5l_inv_1_535.Y sg13cmos5l_inv_1_630.A 0.03562f
C2384 sg13cmos5l_inv_1_144.Y VPWR 0.42373f
C2385 sg13cmos5l_inv_1_305.Y sg13cmos5l_inv_1_314.Y 0.02896f
C2386 sg13cmos5l_inv_1_525.A sg13cmos5l_inv_1_519.Y 0.24285f
C2387 sg13cmos5l_inv_1_854.Y VPWR 0.42579f
C2388 sg13cmos5l_buf_1_0.A sg13cmos5l_inv_1_76.A 0.02112f
C2389 sg13cmos5l_buf_1_8.A sg13cmos5l_inv_1_213.A 0.01996f
C2390 sg13cmos5l_inv_1_372.Y a_808_7766# 0.03921f
C2391 sg13cmos5l_inv_1_394.A a_6430_8434# 0.16331f
C2392 sg13cmos5l_mux4_1_8.A1 a_7144_16838# 0.05062f
C2393 sg13cmos5l_buf_1_9.A a_8008_12302# 0.01623f
C2394 sg13cmos5l_inv_1_340.Y sg13cmos5l_inv_1_341.Y 0.1212f
C2395 sg13cmos5l_inv_1_266.A VPWR 0.40595f
C2396 sg13cmos5l_mux4_1_4.X sg13cmos5l_inv_1_391.A 0.01085f
C2397 a_6119_8434# a_6430_8434# 0.49675f
C2398 sg13cmos5l_inv_1_677.A sg13cmos5l_inv_1_662.Y 0.01513f
C2399 sg13cmos5l_inv_1_519.Y VPWR 0.74801f
C2400 sg13cmos5l_inv_1_976.Y a_11656_10074# 0.03352f
C2401 sg13cmos5l_inv_1_953.Y sg13cmos5l_inv_1_114.A 0.29854f
C2402 sg13cmos5l_inv_1_941.A sg13cmos5l_inv_1_959.A 0.49295f
C2403 sg13cmos5l_inv_1_376.A VPWR 0.41109f
C2404 sg13cmos5l_inv_1_875.Y sg13cmos5l_inv_1_875.A 0.27252f
C2405 sg13cmos5l_inv_1_0.A sg13cmos5l_inv_1_3.Y 0.11089f
C2406 sg13cmos5l_a21oi_1_0.B1 a_8200_10790# 0.01159f
C2407 sg13cmos5l_buf_1_9.A sg13cmos5l_inv_1_936.A 0.0318f
C2408 sg13cmos5l_inv_1_431.A sg13cmos5l_inv_1_421.Y 0.14313f
C2409 sg13cmos5l_inv_1_186.A VPWR 0.43788f
C2410 sg13cmos5l_inv_1_148.A sg13cmos5l_inv_1_147.A 0.02218f
C2411 sg13cmos5l_inv_1_148.Y sg13cmos5l_inv_1_147.Y 0.03658f
C2412 sg13cmos5l_inv_1_161.Y VPWR 0.42474f
C2413 sg13cmos5l_buf_1_9.A a_14183_9582# 0.02943f
C2414 sg13cmos5l_inv_1_865.Y sg13cmos5l_inv_1_863.A 0.20065f
C2415 sg13cmos5l_buf_1_8.A sg13cmos5l_mux4_1_2.X 0.05797f
C2416 sg13cmos5l_inv_1_66.A sg13cmos5l_inv_1_67.A 0.08754f
C2417 sg13cmos5l_inv_1_535.A sg13cmos5l_inv_1_562.A 0.19706f
C2418 sg13cmos5l_inv_1_113.Y a_11368_8562# 0.02458f
C2419 sg13cmos5l_nor3_1_2.B a_14389_11500# 0.08463f
C2420 sg13cmos5l_mux4_1_5.S1 a_13472_4026# 0.04012f
C2421 sg13cmos5l_inv_1_235.A a_10784_4742# 0.03589f
C2422 sg13cmos5l_mux4_1_5.S1 sg13cmos5l_inv_1_394.Y 0.09775f
C2423 a_8795_11752# a_9160_11586# 0.01003f
C2424 sg13cmos5l_buf_1_9.A sg13cmos5l_inv_1_948.A 0.03816f
C2425 sg13cmos5l_inv_1_340.Y a_4438_8070# 0.22339f
C2426 sg13cmos5l_a21oi_1_0.A2 sg13cmos5l_nor3_1_1.B 0.107f
C2427 sg13cmos5l_inv_1_92.A VPWR 0.43617f
C2428 sg13cmos5l_mux2_1_2.A0 sg13cmos5l_inv_1_672.Y 0.01253f
C2429 sg13cmos5l_inv_1_24.Y sg13cmos5l_inv_1_18.A 0.20065f
C2430 sg13cmos5l_inv_1_195.Y sg13cmos5l_inv_1_199.Y 0.03462f
C2431 sg13cmos5l_mux4_1_11.A3 sg13cmos5l_inv_1_892.A 0.25668f
C2432 sg13cmos5l_inv_1_747.Y VPWR 1.09852f
C2433 sg13cmos5l_inv_1_337.Y sg13cmos5l_inv_1_323.A 0.02346f
C2434 a_14494_9582# a_15489_9540# 0.48298f
C2435 sg13cmos5l_inv_1_775.A sg13cmos5l_inv_1_809.Y 0.04084f
C2436 sg13cmos5l_inv_1_541.A sg13cmos5l_inv_1_541.Y 0.19855f
C2437 sg13cmos5l_inv_1_280.Y VPWR 0.52521f
C2438 sg13cmos5l_buf_1_12.X sg13cmos5l_inv_1_396.Y 0.0116f
C2439 sg13cmos5l_inv_1_772.A a_10408_18350# 0.06445f
C2440 sg13cmos5l_inv_1_875.A VPWR 0.62765f
C2441 sg13cmos5l_inv_1_287.A VPWR 0.75293f
C2442 sg13cmos5l_mux4_1_11.A2 a_14389_11500# 0.12573f
C2443 sg13cmos5l_inv_1_328.Y sg13cmos5l_inv_1_328.A 0.1039f
C2444 a_808_18264# sg13cmos5l_inv_1_545.Y 0.03717f
C2445 a_13288_17634# a_13288_16838# 0.01095f
C2446 sg13cmos5l_inv_1_492.A VPWR 0.50504f
C2447 sg13cmos5l_mux2_1_4.S sg13cmos5l_inv_1_745.A 0.02257f
C2448 sg13cmos5l_inv_1_788.Y VPWR 0.43428f
C2449 sg13cmos5l_mux4_1_13.A0 sg13cmos5l_inv_1_872.A 0.22502f
C2450 sg13cmos5l_buf_1_10.A sg13cmos5l_inv_1_663.Y 0.36847f
C2451 sg13cmos5l_inv_1_249.Y VPWR 0.52398f
C2452 sg13cmos5l_mux2_1_4.S sg13cmos5l_inv_1_231.Y 0.02444f
C2453 sg13cmos5l_inv_1_248.A sg13cmos5l_inv_1_462.Y 0.01567f
C2454 sg13cmos5l_inv_1_194.Y sg13cmos5l_inv_1_189.Y 0.21232f
C2455 sg13cmos5l_inv_1_207.Y VPWR 0.38444f
C2456 a_8086_3534# a_8577_3492# 0.3824f
C2457 sg13cmos5l_inv_1_113.A a_14183_9582# 0.2156f
C2458 sg13cmos5l_inv_1_676.Y sg13cmos5l_mux4_1_7.A1 0.13361f
C2459 sg13cmos5l_a21oi_1_0.B1 sg13cmos5l_a21oi_1_0.Y 0.2155f
C2460 sg13cmos5l_mux2_1_4.S sg13cmos5l_inv_1_78.A 0.77321f
C2461 sg13cmos5l_inv_1_883.Y a_11936_14610# 0.01054f
C2462 sg13cmos5l_inv_1_883.A sg13cmos5l_inv_1_889.A 0.07143f
C2463 sg13cmos5l_inv_1_156.Y sg13cmos5l_inv_1_157.Y 0.20065f
C2464 sg13cmos5l_inv_1_311.A sg13cmos5l_inv_1_308.A 0.01127f
C2465 sg13cmos5l_inv_1_177.Y VPWR 0.56019f
C2466 sg13cmos5l_inv_1_420.A sg13cmos5l_inv_1_337.A 0.0278f
C2467 sg13cmos5l_buf_1_0.A sg13cmos5l_inv_1_56.Y 0.04933f
C2468 sg13cmos5l_mux4_1_8.A0 a_8086_15994# 0.0199f
C2469 sg13cmos5l_inv_1_575.Y sg13cmos5l_inv_1_533.A 0.05858f
C2470 sg13cmos5l_mux2_1_2.A0 sg13cmos5l_inv_1_645.A 0.0225f
C2471 sg13cmos5l_mux4_1_5.S1 sg13cmos5l_inv_1_116.Y 0.04968f
C2472 sg13cmos5l_inv_1_914.A sg13cmos5l_inv_1_707.Y 0.49825f
C2473 sg13cmos5l_buf_1_9.A sg13cmos5l_inv_1_149.A 0.05292f
C2474 a_15419_8040# VPWR 0.12095f
C2475 sg13cmos5l_inv_1_348.A VPWR 0.36753f
C2476 a_3847_16261# VPWR 0.02431f
C2477 sg13cmos5l_inv_1_112.Y sg13cmos5l_inv_1_113.Y 0.04319f
C2478 a_9260_9906# sg13cmos5l_buf_1_12.X 0.33703f
C2479 a_12896_7766# VPWR 0.12068f
C2480 sg13cmos5l_inv_1_338.Y sg13cmos5l_inv_1_325.Y 0.09501f
C2481 sg13cmos5l_or2_1_0.B sg13cmos5l_or2_1_0.X 0.07486f
C2482 sg13cmos5l_inv_1_640.A VPWR 0.42423f
C2483 sg13cmos5l_inv_1_103.A a_12896_2514# 0.03646f
C2484 sg13cmos5l_inv_1_344.A sg13cmos5l_inv_1_340.Y 0.04929f
C2485 sg13cmos5l_inv_1_6.Y sg13cmos5l_inv_1_46.A 0.15467f
C2486 sg13cmos5l_inv_1_627.A a_9536_16838# 0.03508f
C2487 sg13cmos5l_inv_1_581.A sg13cmos5l_inv_1_635.A 0.02913f
C2488 sg13cmos5l_inv_1_260.Y a_6848_1718# 0.01175f
C2489 sg13cmos5l_buf_1_0.A sg13cmos5l_inv_1_12.Y 0.01446f
C2490 sg13cmos5l_inv_1_76.A a_15768_4088# 0.01382f
C2491 sg13cmos5l_buf_1_7.X sg13cmos5l_inv_1_312.Y 0.08029f
C2492 sg13cmos5l_mux4_1_5.S1 sg13cmos5l_inv_1_387.Y 0.02126f
C2493 sg13cmos5l_a21oi_1_1.A1 sg13cmos5l_nand2_1_1.B 0.02228f
C2494 sg13cmos5l_inv_1_827.Y sg13cmos5l_inv_1_827.A 0.20065f
C2495 sg13cmos5l_mux2_1_4.S a_9142_6558# 0.03608f
C2496 sg13cmos5l_inv_1_283.A sg13cmos5l_inv_1_288.Y 0.01201f
C2497 a_18664_16028# a_19048_16122# 0.03269f
C2498 sg13cmos5l_inv_1_6.Y sg13cmos5l_inv_1_16.Y 0.29446f
C2499 sg13cmos5l_mux4_1_11.A3 sg13cmos5l_nor3_1_2.B 0.37281f
C2500 sg13cmos5l_inv_1_736.Y sg13cmos5l_inv_1_998.A 0.0123f
C2501 sg13cmos5l_mux4_1_6.A2 VPWR 0.96879f
C2502 sg13cmos5l_inv_1_120.A sg13cmos5l_inv_1_976.A 0.03007f
C2503 sg13cmos5l_mux4_1_14.A1 sg13cmos5l_inv_1_874.Y 0.22569f
C2504 sg13cmos5l_inv_1_806.Y sg13cmos5l_inv_1_808.A 0.14468f
C2505 sg13cmos5l_inv_1_875.Y sg13cmos5l_inv_1_818.A 0.01233f
C2506 sg13cmos5l_inv_1_509.A sg13cmos5l_nor3_1_2.B 0.04821f
C2507 sg13cmos5l_inv_1_207.A sg13cmos5l_inv_1_25.Y 0.02236f
C2508 sg13cmos5l_inv_1_684.Y sg13cmos5l_inv_1_634.A 0.03644f
C2509 sg13cmos5l_inv_1_988.A VPWR 0.36429f
C2510 sg13cmos5l_inv_1_15.Y sg13cmos5l_inv_1_16.Y 0.213f
C2511 sg13cmos5l_inv_1_532.A sg13cmos5l_inv_1_532.Y 1.15776f
C2512 sg13cmos5l_inv_1_98.Y sg13cmos5l_inv_1_84.A 0.01495f
C2513 sg13cmos5l_inv_1_773.Y a_10784_17634# 0.01162f
C2514 a_7582_3534# a_8577_3492# 0.48298f
C2515 sg13cmos5l_buf_1_9.A a_3623_8070# 0.0438f
C2516 sg13cmos5l_inv_1_881.A sg13cmos5l_inv_1_894.Y 0.03195f
C2517 sg13cmos5l_inv_1_750.Y sg13cmos5l_inv_1_738.A 0.01422f
C2518 sg13cmos5l_inv_1_584.A sg13cmos5l_mux4_1_7.A1 0.01127f
C2519 a_7271_15994# VPWR 0.4064f
C2520 sg13cmos5l_mux4_1_15.A3 sg13cmos5l_inv_1_994.A 0.01599f
C2521 sg13cmos5l_inv_1_28.A a_17120_4026# 0.03508f
C2522 sg13cmos5l_mux4_1_11.A3 sg13cmos5l_mux4_1_11.A2 0.0943f
C2523 sg13cmos5l_mux2_1_4.X sg13cmos5l_mux4_1_16.A2 0.03297f
C2524 sg13cmos5l_inv_1_811.Y a_13288_16838# 0.04353f
C2525 sg13cmos5l_inv_1_834.Y VPWR 0.63292f
C2526 a_7232_15326# VPWR 0.09068f
C2527 sg13cmos5l_inv_1_285.Y sg13cmos5l_inv_1_281.Y 0.17698f
C2528 sg13cmos5l_mux4_1_11.A1 a_14389_11500# 0.14354f
C2529 sg13cmos5l_inv_1_367.Y sg13cmos5l_inv_1_436.A 0.05373f
C2530 sg13cmos5l_inv_1_347.Y sg13cmos5l_inv_1_451.A 0.01179f
C2531 sg13cmos5l_inv_1_140.Y a_13472_7766# 0.04298f
C2532 sg13cmos5l_mux4_1_5.S1 sg13cmos5l_inv_1_97.Y 0.01502f
C2533 sg13cmos5l_inv_1_720.Y a_19136_11586# 0.01054f
C2534 sg13cmos5l_inv_1_720.Y a_18664_13004# 0.05437f
C2535 sg13cmos5l_inv_1_43.Y a_17024_1002# 0.01257f
C2536 sg13cmos5l_inv_1_177.A a_18664_6956# 0.01378f
C2537 sg13cmos5l_nor3_1_2.B sg13cmos5l_inv_1_757.Y 0.7402f
C2538 sg13cmos5l_inv_1_550.Y sg13cmos5l_inv_1_556.Y 0.20065f
C2539 sg13cmos5l_inv_1_441.A VPWR 0.48923f
C2540 sg13cmos5l_a21oi_1_0.Y a_8315_11752# 0.18937f
C2541 a_9360_11832# a_8795_11752# 0.03145f
C2542 sg13cmos5l_inv_1_818.A VPWR 0.36354f
C2543 sg13cmos5l_mux2_1_4.S a_9633_6516# 0.0298f
C2544 sg13cmos5l_buf_1_8.A sg13cmos5l_inv_1_366.Y 0.08562f
C2545 sg13cmos5l_buf_1_8.A sg13cmos5l_inv_1_334.A 0.02117f
C2546 a_14206_15630# a_14413_15291# 0.01967f
C2547 sg13cmos5l_mux2_1_3.A0 sg13cmos5l_inv_1_136.Y 0.05116f
C2548 sg13cmos5l_inv_1_606.A VPWR 0.42145f
C2549 sg13cmos5l_inv_1_535.Y sg13cmos5l_inv_1_609.A 0.12363f
C2550 sg13cmos5l_mux4_1_14.A1 sg13cmos5l_inv_1_861.A 0.21165f
C2551 sg13cmos5l_inv_1_181.Y VPWR 0.43833f
C2552 sg13cmos5l_inv_1_305.Y sg13cmos5l_inv_1_320.Y 0.13192f
C2553 sg13cmos5l_inv_1_855.Y VPWR 0.42879f
C2554 sg13cmos5l_a21oi_1_0.A1 sg13cmos5l_nor3_1_1.B 0.23058f
C2555 a_8086_3534# VPWR 0.03218f
C2556 sg13cmos5l_inv_1_372.Y sg13cmos5l_inv_1_377.Y 0.23068f
C2557 sg13cmos5l_inv_1_382.A a_7136_6254# 0.03491f
C2558 sg13cmos5l_inv_1_190.A sg13cmos5l_inv_1_225.Y 0.04264f
C2559 a_13472_10790# VPWR 0.06615f
C2560 sg13cmos5l_mux4_1_5.S1 sg13cmos5l_inv_1_108.Y 0.01763f
C2561 sg13cmos5l_mux4_1_5.S1 a_3934_3534# 0.03236f
C2562 sg13cmos5l_inv_1_311.Y VPWR 1.23078f
C2563 sg13cmos5l_buf_1_10.A a_5005_12490# 0.36625f
C2564 sg13cmos5l_inv_1_161.Y a_18184_8562# 0.03488f
C2565 sg13cmos5l_inv_1_171.Y sg13cmos5l_inv_1_171.A 0.29062f
C2566 sg13cmos5l_inv_1_762.Y a_14422_12606# 0.02782f
C2567 sg13cmos5l_mux4_1_11.A3 sg13cmos5l_inv_1_707.Y 0.69163f
C2568 sg13cmos5l_inv_1_294.Y sg13cmos5l_inv_1_296.Y 0.29447f
C2569 a_14183_9582# a_14998_9582# 0.49917f
C2570 sg13cmos5l_nor3_1_2.B sg13cmos5l_buf_1_8.A 0.41321f
C2571 sg13cmos5l_inv_1_976.Y sg13cmos5l_inv_1_959.A 0.03186f
C2572 sg13cmos5l_mux4_1_6.X a_4929_8028# 0.20431f
C2573 sg13cmos5l_mux4_1_13.A0 sg13cmos5l_inv_1_874.Y 0.05372f
C2574 a_14494_9582# VPWR 0.88382f
C2575 sg13cmos5l_inv_1_239.A sg13cmos5l_inv_1_244.A 0.20065f
C2576 sg13cmos5l_buf_1_9.A sg13cmos5l_inv_1_937.A 0.0338f
C2577 sg13cmos5l_buf_1_8.A sg13cmos5l_inv_1_521.Y 0.16024f
C2578 sg13cmos5l_inv_1_30.A VPWR 0.58921f
C2579 sg13cmos5l_inv_1_148.A sg13cmos5l_inv_1_147.Y 0.16941f
C2580 sg13cmos5l_inv_1_163.Y VPWR 0.43054f
C2581 sg13cmos5l_buf_1_9.A a_15637_8028# 0.03042f
C2582 sg13cmos5l_inv_1_460.Y sg13cmos5l_inv_1_461.Y 0.20065f
C2583 a_13288_2514# a_13472_2514# 0.11523f
C2584 sg13cmos5l_inv_1_643.A sg13cmos5l_inv_1_690.A 0.06041f
C2585 sg13cmos5l_inv_1_433.A sg13cmos5l_inv_1_266.Y 0.01545f
C2586 sg13cmos5l_inv_1_234.A a_10784_4742# 0.04601f
C2587 sg13cmos5l_inv_1_235.A sg13cmos5l_inv_1_235.Y 0.25752f
C2588 sg13cmos5l_inv_1_738.Y sg13cmos5l_inv_1_1002.A 0.07789f
C2589 sg13cmos5l_inv_1_1.Y a_18856_1632# 0.12785f
C2590 sg13cmos5l_inv_1_149.A sg13cmos5l_inv_1_206.A 0.01592f
C2591 sg13cmos5l_mux4_1_5.S0 sg13cmos5l_mux2_1_4.X 0.05376f
C2592 sg13cmos5l_a21oi_1_0.A2 sg13cmos5l_a21oi_1_0.A1 0.46244f
C2593 sg13cmos5l_inv_1_982.A a_5992_9278# 0.0345f
C2594 sg13cmos5l_inv_1_338.Y sg13cmos5l_inv_1_305.A 0.02104f
C2595 sg13cmos5l_buf_1_12.X sg13cmos5l_inv_1_402.A 0.03736f
C2596 a_7582_3534# VPWR 0.88591f
C2597 sg13cmos5l_mux4_1_11.A3 sg13cmos5l_mux4_1_11.A1 1.55838f
C2598 sg13cmos5l_inv_1_258.A sg13cmos5l_inv_1_273.A 0.05584f
C2599 sg13cmos5l_inv_1_124.A sg13cmos5l_mux4_1_16.A1 0.06423f
C2600 sg13cmos5l_inv_1_775.A sg13cmos5l_inv_1_775.Y 0.28725f
C2601 sg13cmos5l_nor3_1_1.A a_8576_10074# 0.04132f
C2602 sg13cmos5l_inv_1_279.Y VPWR 0.52076f
C2603 sg13cmos5l_buf_1_12.X sg13cmos5l_inv_1_391.Y 0.01163f
C2604 sg13cmos5l_inv_1_286.Y VPWR 0.43146f
C2605 sg13cmos5l_inv_1_328.Y sg13cmos5l_inv_1_329.A 0.31946f
C2606 sg13cmos5l_inv_1_694.Y a_19136_10790# 0.03508f
C2607 sg13cmos5l_buf_1_10.A sg13cmos5l_inv_1_662.Y 0.01807f
C2608 sg13cmos5l_inv_1_850.Y sg13cmos5l_inv_1_872.A 0.11183f
C2609 sg13cmos5l_mux4_1_13.A0 sg13cmos5l_inv_1_861.A 0.01f
C2610 sg13cmos5l_inv_1_51.A sg13cmos5l_inv_1_36.Y 0.06527f
C2611 a_14027_11654# a_13856_11586# 0.03515f
C2612 sg13cmos5l_inv_1_207.A VPWR 0.51469f
C2613 sg13cmos5l_mux4_1_10.A3 a_4438_15994# 0.25387f
C2614 sg13cmos5l_inv_1_272.A a_5696_2514# 0.04627f
C2615 sg13cmos5l_inv_1_182.A VPWR 0.52672f
C2616 sg13cmos5l_inv_1_449.A sg13cmos5l_inv_1_422.A 0.18711f
C2617 sg13cmos5l_inv_1_420.A sg13cmos5l_inv_1_334.A 0.14501f
C2618 a_6910_12970# a_7117_13237# 0.01967f
C2619 sg13cmos5l_inv_1_672.A sg13cmos5l_inv_1_671.A 0.12103f
C2620 a_7981_12976# a_7905_13012# 0.2611f
C2621 sg13cmos5l_inv_1_566.A sg13cmos5l_inv_1_533.A 0.10598f
C2622 sg13cmos5l_mux4_1_5.S1 sg13cmos5l_inv_1_115.Y 0.19605f
C2623 sg13cmos5l_mux2_1_4.S sg13cmos5l_inv_1_149.Y 0.19687f
C2624 sg13cmos5l_inv_1_624.Y sg13cmos5l_inv_1_583.A 0.01538f
C2625 sg13cmos5l_inv_1_100.A a_13918_3898# 0.03366f
C2626 sg13cmos5l_inv_1_876.Y sg13cmos5l_inv_1_813.Y 0.19028f
C2627 sg13cmos5l_inv_1_349.A VPWR 0.66986f
C2628 sg13cmos5l_mux2_1_4.S sg13cmos5l_mux4_1_16.A1 0.03466f
C2629 sg13cmos5l_inv_1_112.Y sg13cmos5l_inv_1_112.A 0.14295f
C2630 sg13cmos5l_mux2_1_1.X sg13cmos5l_buf_1_12.X 0.93241f
C2631 sg13cmos5l_inv_1_311.Y sg13cmos5l_inv_1_290.Y 0.01032f
C2632 sg13cmos5l_inv_1_118.A VPWR 0.42153f
C2633 sg13cmos5l_inv_1_411.A sg13cmos5l_inv_1_462.A 0.07341f
C2634 sg13cmos5l_inv_1_381.Y sg13cmos5l_inv_1_386.Y 0.31021f
C2635 sg13cmos5l_inv_1_584.A sg13cmos5l_mux4_1_8.A2 0.21848f
C2636 sg13cmos5l_inv_1_639.A VPWR 0.42428f
C2637 sg13cmos5l_inv_1_421.A a_3623_8070# 0.22542f
C2638 sg13cmos5l_inv_1_103.A sg13cmos5l_inv_1_59.A 0.1264f
C2639 sg13cmos5l_inv_1_627.A sg13cmos5l_inv_1_975.A 0.2026f
C2640 sg13cmos5l_mux4_1_11.A3 sg13cmos5l_inv_1_818.Y 0.03198f
C2641 sg13cmos5l_inv_1_260.Y sg13cmos5l_inv_1_259.Y 0.2001f
C2642 sg13cmos5l_inv_1_260.A a_6848_1718# 0.03602f
C2643 sg13cmos5l_inv_1_76.A sg13cmos5l_mux4_1_2.X 0.01152f
C2644 a_9432_3406# VPWR 0.96982f
C2645 sg13cmos5l_inv_1_729.Y sg13cmos5l_inv_1_717.A 0.14255f
C2646 sg13cmos5l_inv_1_283.A sg13cmos5l_inv_1_282.Y 0.20211f
C2647 a_13288_11586# VPWR 0.1312f
C2648 sg13cmos5l_buf_1_9.A a_14027_11654# 0.01944f
C2649 sg13cmos5l_inv_1_645.A sg13cmos5l_inv_1_645.Y 0.24462f
C2650 sg13cmos5l_mux4_1_14.A1 sg13cmos5l_inv_1_874.A 0.09527f
C2651 sg13cmos5l_inv_1_956.Y sg13cmos5l_inv_1_162.Y 0.01969f
C2652 a_3623_12606# a_3847_12267# 0.01074f
C2653 sg13cmos5l_inv_1_535.Y a_3934_15994# 0.02708f
C2654 sg13cmos5l_inv_1_509.A sg13cmos5l_inv_1_509.Y 0.16471f
C2655 sg13cmos5l_mux4_1_5.S0 sg13cmos5l_inv_1_287.A 0.30923f
C2656 sg13cmos5l_inv_1_680.Y a_1376_14610# 0.01054f
C2657 sg13cmos5l_inv_1_633.A sg13cmos5l_inv_1_634.A 0.16939f
C2658 sg13cmos5l_inv_1_519.Y sg13cmos5l_inv_1_532.Y 0.02299f
C2659 a_14360_11776# a_14827_11673# 0.49917f
C2660 sg13cmos5l_inv_1_101.Y sg13cmos5l_inv_1_84.A 0.10006f
C2661 sg13cmos5l_inv_1_790.Y a_10784_17634# 0.03553f
C2662 a_1472_2514# VPWR 0.08215f
C2663 sg13cmos5l_buf_1_12.X a_1184_7050# 0.01288f
C2664 a_13288_13814# a_13472_13814# 0.11523f
C2665 sg13cmos5l_mux4_1_11.A1 sg13cmos5l_inv_1_913.A 0.06716f
C2666 sg13cmos5l_inv_1_881.A sg13cmos5l_inv_1_893.Y 0.01402f
C2667 sg13cmos5l_mux4_1_7.A3 a_6599_12970# 0.08887f
C2668 sg13cmos5l_inv_1_186.Y sg13cmos5l_buf_1_6.A 0.11462f
C2669 sg13cmos5l_inv_1_411.Y sg13cmos5l_inv_1_412.A 0.05652f
C2670 sg13cmos5l_inv_1_149.A sg13cmos5l_inv_1_179.A 0.02919f
C2671 a_16075_7649# sg13cmos5l_inv_1_152.Y 0.20676f
C2672 sg13cmos5l_inv_1_391.A sg13cmos5l_inv_1_391.Y 0.2307f
C2673 sg13cmos5l_inv_1_821.A sg13cmos5l_inv_1_824.A 0.02445f
C2674 sg13cmos5l_inv_1_619.Y VPWR 0.40379f
C2675 sg13cmos5l_inv_1_576.A sg13cmos5l_a21oi_1_0.B1 0.04027f
C2676 sg13cmos5l_inv_1_31.Y a_17120_4026# 0.03553f
C2677 sg13cmos5l_inv_1_159.Y sg13cmos5l_mux4_1_0.A0 0.1572f
C2678 sg13cmos5l_inv_1_823.A VPWR 0.59037f
C2679 sg13cmos5l_inv_1_113.A sg13cmos5l_inv_1_113.Y 0.48405f
C2680 sg13cmos5l_buf_1_9.A sg13cmos5l_inv_1_499.Y 0.10244f
C2681 sg13cmos5l_inv_1_158.Y a_15016_7766# 0.01054f
C2682 sg13cmos5l_mux2_1_4.S sg13cmos5l_inv_1_699.Y 0.18868f
C2683 sg13cmos5l_mux2_1_4.S a_14422_12606# 0.04108f
C2684 sg13cmos5l_inv_1_684.A VPWR 0.64874f
C2685 sg13cmos5l_buf_1_8.A sg13cmos5l_mux4_1_2.A2 1.35794f
C2686 sg13cmos5l_inv_1_345.Y a_808_6254# 0.02074f
C2687 sg13cmos5l_inv_1_510.A sg13cmos5l_inv_1_522.A 0.0493f
C2688 sg13cmos5l_inv_1_665.A sg13cmos5l_inv_1_664.A 0.23788f
C2689 sg13cmos5l_inv_1_118.A sg13cmos5l_inv_1_140.A 0.17967f
C2690 sg13cmos5l_mux4_1_5.S1 sg13cmos5l_inv_1_61.Y 0.0137f
C2691 a_3623_15994# VPWR 0.39443f
C2692 sg13cmos5l_inv_1_95.A VPWR 0.88666f
C2693 sg13cmos5l_inv_1_724.Y sg13cmos5l_inv_1_714.A 0.0484f
C2694 sg13cmos5l_mux4_1_15.A3 sg13cmos5l_inv_1_931.Y 0.02219f
C2695 sg13cmos5l_inv_1_7.A a_17024_1002# 0.03528f
C2696 a_4798_12970# a_4701_12970# 0.01637f
C2697 sg13cmos5l_mux4_1_5.S1 a_6430_8434# 0.04186f
C2698 sg13cmos5l_inv_1_67.Y sg13cmos5l_inv_1_73.A 0.23204f
C2699 a_8000_9278# VPWR 0.08848f
C2700 sg13cmos5l_inv_1_440.A VPWR 0.42608f
C2701 a_7271_15994# a_7508_15994# 0.01012f
C2702 sg13cmos5l_inv_1_925.Y sg13cmos5l_inv_1_972.Y 0.02979f
C2703 a_808_18264# enable 0.32031f
C2704 sg13cmos5l_buf_1_8.A sg13cmos5l_inv_1_366.A 0.10133f
C2705 sg13cmos5l_buf_1_8.A sg13cmos5l_inv_1_422.A 0.15251f
C2706 a_14827_11673# VPWR 0.44109f
C2707 sg13cmos5l_inv_1_237.Y sg13cmos5l_inv_1_241.Y 2.75538f
C2708 sg13cmos5l_a21oi_1_1.A1 a_8810_10704# 0.01407f
C2709 sg13cmos5l_inv_1_598.A VPWR 0.55781f
C2710 sg13cmos5l_inv_1_779.A sg13cmos5l_inv_1_807.A 0.01462f
C2711 sg13cmos5l_inv_1_535.Y sg13cmos5l_inv_1_610.A 0.01678f
C2712 sg13cmos5l_inv_1_534.Y sg13cmos5l_inv_1_609.A 0.31607f
C2713 sg13cmos5l_inv_1_211.Y VPWR 0.6293f
C2714 sg13cmos5l_inv_1_855.A VPWR 0.4258f
C2715 sg13cmos5l_buf_1_0.A sg13cmos5l_inv_1_99.Y 0.0108f
C2716 a_11456_1718# VPWR 0.07821f
C2717 sg13cmos5l_inv_1_224.Y sg13cmos5l_inv_1_225.Y 0.0309f
C2718 sg13cmos5l_inv_1_584.A sg13cmos5l_buf_1_9.A 0.15175f
C2719 a_18764_12180# osc_tap[4] 0.01077f
C2720 sg13cmos5l_inv_1_382.A sg13cmos5l_inv_1_382.Y 0.86628f
C2721 a_2152_15326# sg13cmos5l_inv_1_510.Y 0.01059f
C2722 sg13cmos5l_mux4_1_5.S0 sg13cmos5l_mux4_1_6.A2 0.24692f
C2723 a_8551_6219# VPWR 0.02431f
C2724 sg13cmos5l_mux2_1_4.S sg13cmos5l_inv_1_202.Y 0.37176f
C2725 sg13cmos5l_inv_1_410.Y VPWR 0.42432f
C2726 sg13cmos5l_inv_1_161.Y sg13cmos5l_inv_1_171.A 0.11738f
C2727 sg13cmos5l_mux4_1_11.A3 sg13cmos5l_inv_1_914.A 0.47719f
C2728 sg13cmos5l_inv_1_296.A sg13cmos5l_inv_1_296.Y 0.31432f
C2729 sg13cmos5l_inv_1_940.A a_11656_10074# 0.02395f
C2730 sg13cmos5l_inv_1_757.Y a_12808_11586# 0.02019f
C2731 sg13cmos5l_mux4_1_13.A0 sg13cmos5l_inv_1_874.A 0.03821f
C2732 sg13cmos5l_mux4_1_14.A3 a_14422_14482# 0.23512f
C2733 sg13cmos5l_inv_1_65.A sg13cmos5l_inv_1_981.Y 0.01219f
C2734 sg13cmos5l_inv_1_8.Y sg13cmos5l_inv_1_4.Y 0.18432f
C2735 sg13cmos5l_buf_1_9.A sg13cmos5l_inv_1_937.Y 0.04146f
C2736 sg13cmos5l_inv_1_199.Y VPWR 0.42322f
C2737 a_2632_11586# a_2632_10790# 0.01095f
C2738 sg13cmos5l_buf_1_8.A sg13cmos5l_mux4_1_0.A0 0.51908f
C2739 sg13cmos5l_inv_1_824.A sg13cmos5l_inv_1_851.A 0.10762f
C2740 sg13cmos5l_inv_1_148.A sg13cmos5l_inv_1_148.Y 0.51873f
C2741 sg13cmos5l_inv_1_162.Y VPWR 0.44376f
C2742 sg13cmos5l_mux4_1_5.S0 a_7271_15994# 0.52158f
C2743 sg13cmos5l_inv_1_991.A sg13cmos5l_inv_1_990.Y 0.33252f
C2744 sg13cmos5l_mux2_1_4.S a_14913_12564# 0.24287f
C2745 sg13cmos5l_mux4_1_10.A2 VPWR 0.77735f
C2746 sg13cmos5l_inv_1_792.Y sg13cmos5l_inv_1_865.Y 0.18711f
C2747 sg13cmos5l_mux4_1_11.A3 a_14389_11500# 0.19823f
C2748 sg13cmos5l_inv_1_100.A sg13cmos5l_inv_1_45.Y 0.32751f
C2749 sg13cmos5l_inv_1_228.A sg13cmos5l_inv_1_83.Y 0.25184f
C2750 sg13cmos5l_mux4_1_6.A2 a_3934_8070# 0.11423f
C2751 sg13cmos5l_inv_1_593.Y a_6752_17634# 0.01365f
C2752 sg13cmos5l_inv_1_782.A a_13472_18350# 0.0138f
C2753 sg13cmos5l_inv_1_643.A sg13cmos5l_inv_1_642.A 0.05963f
C2754 sg13cmos5l_inv_1_237.A a_9640_1718# 0.05325f
C2755 sg13cmos5l_mux4_1_14.A1 sg13cmos5l_buf_1_9.A 0.17456f
C2756 sg13cmos5l_inv_1_234.A sg13cmos5l_inv_1_235.Y 0.19903f
C2757 sg13cmos5l_inv_1_237.Y sg13cmos5l_inv_1_65.A 0.02507f
C2758 sg13cmos5l_inv_1_369.A sg13cmos5l_inv_1_377.Y 0.06525f
C2759 sg13cmos5l_inv_1_737.A sg13cmos5l_inv_1_1002.A 0.15278f
C2760 sg13cmos5l_inv_1_986.Y sg13cmos5l_inv_1_942.Y 0.20991f
C2761 a_3623_8070# a_4438_8070# 0.49917f
C2762 sg13cmos5l_mux4_1_7.A2 VPWR 1.11045f
C2763 sg13cmos5l_inv_1_994.Y sg13cmos5l_inv_1_957.Y 0.01522f
C2764 sg13cmos5l_inv_1_1.Y sg13cmos5l_inv_1_0.Y 0.15524f
C2765 a_10592_13098# VPWR 0.08122f
C2766 sg13cmos5l_inv_1_876.Y sg13cmos5l_inv_1_873.A 0.10539f
C2767 sg13cmos5l_buf_1_0.A a_18856_1632# 0.32175f
C2768 sg13cmos5l_buf_1_17.X a_18856_14516# 0.34041f
C2769 sg13cmos5l_inv_1_346.Y sg13cmos5l_inv_1_373.A 0.32003f
C2770 VPWR osc 0.1766f
C2771 sg13cmos5l_inv_1_311.A a_800_2514# 0.01054f
C2772 sg13cmos5l_inv_1_59.A a_13288_1718# 0.04329f
C2773 sg13cmos5l_inv_1_13.Y sg13cmos5l_inv_1_24.Y 0.20065f
C2774 sg13cmos5l_inv_1_111.A sg13cmos5l_inv_1_78.A 0.08974f
C2775 sg13cmos5l_inv_1_205.Y sg13cmos5l_inv_1_198.Y 0.04279f
C2776 sg13cmos5l_inv_1_124.A sg13cmos5l_inv_1_397.Y 0.02167f
C2777 sg13cmos5l_inv_1_545.A a_800_17634# 0.03465f
C2778 sg13cmos5l_inv_1_277.Y VPWR 0.60796f
C2779 sg13cmos5l_inv_1_288.Y VPWR 0.4279f
C2780 sg13cmos5l_mux4_1_5.S0 a_8086_3534# 0.02695f
C2781 a_808_18264# sg13cmos5l_inv_1_553.Y 0.03582f
C2782 sg13cmos5l_inv_1_519.Y sg13cmos5l_inv_1_523.Y 0.11516f
C2783 sg13cmos5l_inv_1_171.A sg13cmos5l_inv_1_177.Y 0.05347f
C2784 sg13cmos5l_mux4_1_5.S0 sg13cmos5l_inv_1_311.Y 0.01756f
C2785 sg13cmos5l_buf_1_10.A sg13cmos5l_inv_1_499.Y 0.04949f
C2786 sg13cmos5l_mux2_1_4.S sg13cmos5l_inv_1_184.Y 0.01214f
C2787 sg13cmos5l_inv_1_51.A sg13cmos5l_inv_1_44.A 0.0961f
C2788 sg13cmos5l_inv_1_344.Y sg13cmos5l_inv_1_248.A 0.39976f
C2789 sg13cmos5l_inv_1_187.Y sg13cmos5l_inv_1_194.Y 0.20866f
C2790 sg13cmos5l_mux2_1_3.S VPWR 1.1538f
C2791 sg13cmos5l_inv_1_227.A VPWR 0.44368f
C2792 sg13cmos5l_inv_1_179.A a_15637_8028# 0.17098f
C2793 sg13cmos5l_inv_1_372.Y sg13cmos5l_inv_1_345.Y 0.02207f
C2794 sg13cmos5l_inv_1_155.Y sg13cmos5l_inv_1_156.Y 0.21202f
C2795 sg13cmos5l_inv_1_37.A sg13cmos5l_inv_1_1.Y 0.12217f
C2796 sg13cmos5l_inv_1_317.Y sg13cmos5l_inv_1_334.A 0.13932f
C2797 sg13cmos5l_inv_1_282.Y a_5896_3230# 0.02171f
C2798 sg13cmos5l_a21oi_1_0.B1 sg13cmos5l_inv_1_483.Y 0.0172f
C2799 sg13cmos5l_inv_1_171.Y sg13cmos5l_inv_1_78.A 0.03577f
C2800 sg13cmos5l_inv_1_573.A sg13cmos5l_inv_1_533.A 0.165f
C2801 sg13cmos5l_inv_1_575.Y sg13cmos5l_inv_1_565.Y 0.19027f
C2802 sg13cmos5l_mux4_1_5.S1 sg13cmos5l_inv_1_118.Y 0.24053f
C2803 sg13cmos5l_inv_1_114.Y sg13cmos5l_inv_1_115.Y 0.26252f
C2804 sg13cmos5l_inv_1_913.A sg13cmos5l_inv_1_914.A 0.15547f
C2805 sg13cmos5l_inv_1_447.A a_8480_4742# 0.03502f
C2806 a_14614_3534# VPWR 0.03076f
C2807 sg13cmos5l_inv_1_311.Y sg13cmos5l_inv_1_466.Y 0.25853f
C2808 sg13cmos5l_buf_1_10.A sg13cmos5l_inv_1_402.A 0.17547f
C2809 sg13cmos5l_inv_1_129.A VPWR 0.58416f
C2810 sg13cmos5l_inv_1_364.A sg13cmos5l_inv_1_462.A 0.11121f
C2811 sg13cmos5l_inv_1_411.A sg13cmos5l_inv_1_386.Y 0.014f
C2812 sg13cmos5l_inv_1_106.Y sg13cmos5l_inv_1_225.Y 0.01055f
C2813 sg13cmos5l_inv_1_614.A sg13cmos5l_mux4_1_8.A2 0.18793f
C2814 sg13cmos5l_buf_1_8.A a_14389_11500# 0.04606f
C2815 sg13cmos5l_inv_1_723.Y a_18464_11586# 0.01162f
C2816 sg13cmos5l_inv_1_338.Y sg13cmos5l_inv_1_335.Y 0.12896f
C2817 sg13cmos5l_inv_1_78.A a_11456_4026# 0.01058f
C2818 a_4936_15326# sg13cmos5l_inv_1_633.A 0.01112f
C2819 sg13cmos5l_inv_1_583.A sg13cmos5l_inv_1_634.A 0.02913f
C2820 sg13cmos5l_buf_1_0.A sg13cmos5l_inv_1_61.Y 0.01715f
C2821 sg13cmos5l_inv_1_248.A sg13cmos5l_mux4_1_5.X 0.01849f
C2822 sg13cmos5l_inv_1_283.A sg13cmos5l_inv_1_293.Y 0.66056f
C2823 sg13cmos5l_mux4_1_13.A3 a_18664_16028# 0.11641f
C2824 sg13cmos5l_mux4_1_13.A0 sg13cmos5l_buf_1_9.A 0.28418f
C2825 a_7582_15994# a_8577_16036# 0.48298f
C2826 sg13cmos5l_mux4_1_5.S0 a_7582_3534# 0.06421f
C2827 sg13cmos5l_mux4_1_14.A1 sg13cmos5l_inv_1_796.Y 0.04943f
C2828 a_9996_11500# VPWR 0.39208f
C2829 sg13cmos5l_inv_1_534.Y a_3934_15994# 0.02366f
C2830 sg13cmos5l_inv_1_36.Y sg13cmos5l_inv_1_37.A 0.33574f
C2831 sg13cmos5l_mux4_1_5.S1 sg13cmos5l_inv_1_445.A 0.06112f
C2832 sg13cmos5l_mux4_1_5.S0 sg13cmos5l_inv_1_286.Y 0.04236f
C2833 sg13cmos5l_inv_1_680.Y sg13cmos5l_inv_1_668.A 0.09599f
C2834 sg13cmos5l_mux2_1_4.S a_14989_14488# 0.35907f
C2835 sg13cmos5l_inv_1_633.A sg13cmos5l_inv_1_684.Y 0.09561f
C2836 sg13cmos5l_inv_1_762.Y a_13856_11586# 0.01139f
C2837 sg13cmos5l_inv_1_1011.A sg13cmos5l_inv_1_98.Y 0.01432f
C2838 sg13cmos5l_mux2_1_4.S sg13cmos5l_inv_1_112.Y 0.03817f
C2839 sg13cmos5l_buf_1_12.X sg13cmos5l_inv_1_373.A 0.02537f
C2840 sg13cmos5l_a21oi_1_1.A2 sg13cmos5l_mux4_1_7.A2 0.42764f
C2841 sg13cmos5l_inv_1_880.A sg13cmos5l_inv_1_893.Y 0.01506f
C2842 sg13cmos5l_mux4_1_11.A1 sg13cmos5l_inv_1_915.A 0.58171f
C2843 sg13cmos5l_inv_1_186.Y sg13cmos5l_inv_1_213.A 0.11895f
C2844 sg13cmos5l_inv_1_142.A sg13cmos5l_buf_1_6.A 0.01306f
C2845 sg13cmos5l_mux4_1_10.A3 sg13cmos5l_buf_1_9.A 0.36911f
C2846 sg13cmos5l_mux4_1_6.A2 sg13cmos5l_inv_1_351.A 0.21934f
C2847 sg13cmos5l_inv_1_819.A VPWR 0.53113f
C2848 sg13cmos5l_buf_1_9.A sg13cmos5l_inv_1_926.Y 0.25792f
C2849 sg13cmos5l_inv_1_169.Y a_15016_7766# 0.01986f
C2850 sg13cmos5l_inv_1_113.A sg13cmos5l_inv_1_112.A 0.13506f
C2851 sg13cmos5l_mux2_1_3.S a_9982_8050# 0.11803f
C2852 sg13cmos5l_mux2_1_4.S sg13cmos5l_inv_1_704.Y 0.28762f
C2853 a_15105_3492# VPWR 0.71654f
C2854 sg13cmos5l_inv_1_901.Y sg13cmos5l_inv_1_703.Y 0.20065f
C2855 sg13cmos5l_inv_1_284.A a_4929_3492# 0.03902f
C2856 sg13cmos5l_inv_1_889.Y sg13cmos5l_inv_1_889.A 1.45407f
C2857 sg13cmos5l_inv_1_889.A sg13cmos5l_inv_1_909.A 0.04784f
C2858 sg13cmos5l_inv_1_287.Y sg13cmos5l_inv_1_285.Y 0.18895f
C2859 sg13cmos5l_inv_1_345.A a_808_6254# 0.03921f
C2860 sg13cmos5l_mux4_1_5.X sg13cmos5l_inv_1_272.A 0.03845f
C2861 sg13cmos5l_inv_1_665.A sg13cmos5l_inv_1_522.A 0.09394f
C2862 sg13cmos5l_inv_1_843.A a_17896_17634# 0.03785f
C2863 sg13cmos5l_inv_1_82.Y VPWR 0.65334f
C2864 sg13cmos5l_buf_1_19.A a_17896_13098# 0.03631f
C2865 a_4798_12970# sg13cmos5l_a22oi_1_0.B1 0.23215f
C2866 sg13cmos5l_mux4_1_9.X a_4912_12970# 0.0209f
C2867 sg13cmos5l_inv_1_177.A a_17896_7050# 0.03488f
C2868 sg13cmos5l_nor3_1_2.B sg13cmos5l_inv_1_738.A 0.01405f
C2869 sg13cmos5l_inv_1_789.Y sg13cmos5l_inv_1_786.Y 0.01219f
C2870 sg13cmos5l_inv_1_964.Y VPWR 0.42906f
C2871 sg13cmos5l_inv_1_551.Y sg13cmos5l_inv_1_550.Y 0.20065f
C2872 sg13cmos5l_inv_1_67.Y sg13cmos5l_inv_1_68.A 0.01318f
C2873 sg13cmos5l_inv_1_241.A sg13cmos5l_inv_1_416.A 0.14833f
C2874 sg13cmos5l_nor3_1_1.A sg13cmos5l_a21oi_1_0.Y 0.05567f
C2875 sg13cmos5l_inv_1_430.A VPWR 0.42548f
C2876 sg13cmos5l_mux4_1_14.A0 a_13895_15630# 0.04281f
C2877 sg13cmos5l_mux2_1_4.X a_8446_8434# 0.01495f
C2878 sg13cmos5l_buf_1_8.A sg13cmos5l_inv_1_449.A 0.01064f
C2879 sg13cmos5l_buf_1_9.A sg13cmos5l_inv_1_762.Y 0.21192f
C2880 sg13cmos5l_o21ai_1_0.B1 sg13cmos5l_mux4_1_4.A2 0.03281f
C2881 sg13cmos5l_inv_1_589.A VPWR 0.5366f
C2882 sg13cmos5l_inv_1_534.Y sg13cmos5l_inv_1_610.A 0.01284f
C2883 sg13cmos5l_inv_1_147.A VPWR 0.46001f
C2884 sg13cmos5l_inv_1_863.Y VPWR 0.42577f
C2885 sg13cmos5l_inv_1_66.Y VPWR 0.82774f
C2886 a_18856_7680# sg13cmos5l_buf_1_4.X 0.32674f
C2887 a_4928_17634# VPWR 0.08066f
C2888 sg13cmos5l_inv_1_176.A a_18464_7766# 0.0147f
C2889 sg13cmos5l_inv_1_382.A sg13cmos5l_inv_1_389.A 0.21415f
C2890 sg13cmos5l_inv_1_224.Y sg13cmos5l_inv_1_190.A 0.18209f
C2891 sg13cmos5l_inv_1_228.Y sg13cmos5l_inv_1_225.Y 0.01181f
C2892 a_9982_8050# a_9885_8050# 0.01637f
C2893 sg13cmos5l_inv_1_888.Y sg13cmos5l_inv_1_873.A 0.29537f
C2894 sg13cmos5l_mux2_1_4.S a_14913_14524# 0.25059f
C2895 sg13cmos5l_inv_1_114.A sg13cmos5l_inv_1_115.A 0.07449f
C2896 sg13cmos5l_mux4_1_11.A3 sg13cmos5l_buf_1_8.A 0.07057f
C2897 sg13cmos5l_inv_1_111.Y VPWR 0.43493f
C2898 sg13cmos5l_inv_1_318.Y VPWR 0.52776f
C2899 sg13cmos5l_inv_1_950.A sg13cmos5l_nand2_1_1.B 0.05316f
C2900 sg13cmos5l_inv_1_84.A a_10688_2514# 0.01162f
C2901 sg13cmos5l_inv_1_884.Y sg13cmos5l_inv_1_883.Y 0.65869f
C2902 sg13cmos5l_inv_1_270.A sg13cmos5l_mux4_1_3.X 0.02795f
C2903 sg13cmos5l_inv_1_296.A sg13cmos5l_inv_1_294.Y 0.09873f
C2904 sg13cmos5l_mux4_1_11.A3 sg13cmos5l_inv_1_913.A 0.09558f
C2905 sg13cmos5l_inv_1_295.A sg13cmos5l_inv_1_296.Y 0.09421f
C2906 sg13cmos5l_inv_1_712.A sg13cmos5l_inv_1_928.A 0.02309f
C2907 sg13cmos5l_mux4_1_8.A0 sg13cmos5l_mux4_1_14.A0 0.013f
C2908 sg13cmos5l_mux2_1_4.S sg13cmos5l_buf_1_12.X 0.04706f
C2909 sg13cmos5l_buf_1_8.A a_3934_12606# 0.06168f
C2910 sg13cmos5l_inv_1_940.A sg13cmos5l_inv_1_959.A 0.06982f
C2911 sg13cmos5l_inv_1_731.Y a_12808_11586# 0.03352f
C2912 sg13cmos5l_mux4_1_13.A0 sg13cmos5l_inv_1_796.Y 0.03249f
C2913 sg13cmos5l_inv_1_65.A sg13cmos5l_inv_1_65.Y 0.18584f
C2914 sg13cmos5l_inv_1_240.A sg13cmos5l_inv_1_239.A 0.20065f
C2915 sg13cmos5l_inv_1_8.Y sg13cmos5l_inv_1_5.Y 0.04479f
C2916 sg13cmos5l_inv_1_237.Y sg13cmos5l_inv_1_241.A 0.31811f
C2917 sg13cmos5l_inv_1_274.Y sg13cmos5l_inv_1_69.A 0.035f
C2918 sg13cmos5l_inv_1_276.A a_7424_4026# 0.03508f
C2919 a_5032_6254# VPWR 0.1496f
C2920 sg13cmos5l_buf_1_9.A sg13cmos5l_inv_1_938.A 0.07737f
C2921 sg13cmos5l_inv_1_198.Y VPWR 0.42386f
C2922 sg13cmos5l_buf_1_12.X a_9544_10074# 0.05846f
C2923 sg13cmos5l_inv_1_162.A VPWR 0.42823f
C2924 sg13cmos5l_mux4_1_5.S0 sg13cmos5l_inv_1_619.Y 0.11543f
C2925 sg13cmos5l_inv_1_974.A a_800_9278# 0.01083f
C2926 a_3934_8070# a_4141_7731# 0.01967f
C2927 sg13cmos5l_inv_1_533.A VPWR 0.8217f
C2928 sg13cmos5l_inv_1_310.Y sg13cmos5l_inv_1_308.Y 0.75049f
C2929 sg13cmos5l_inv_1_459.Y sg13cmos5l_inv_1_460.Y 0.21202f
C2930 sg13cmos5l_inv_1_510.Y sg13cmos5l_mux4_1_9.A0 0.19617f
C2931 sg13cmos5l_inv_1_589.Y a_6752_17634# 0.01098f
C2932 sg13cmos5l_buf_1_12.X a_10504_9192# 0.32342f
C2933 sg13cmos5l_inv_1_643.A sg13cmos5l_inv_1_641.A 0.18933f
C2934 sg13cmos5l_mux4_1_5.S0 sg13cmos5l_inv_1_684.A 0.02228f
C2935 sg13cmos5l_inv_1_237.A sg13cmos5l_inv_1_981.Y 0.75649f
C2936 sg13cmos5l_buf_1_0.A sg13cmos5l_inv_1_220.A 0.01573f
C2937 sg13cmos5l_inv_1_233.A sg13cmos5l_inv_1_235.Y 0.01965f
C2938 sg13cmos5l_inv_1_234.A sg13cmos5l_inv_1_235.A 0.43929f
C2939 a_13918_3898# a_14645_4211# 0.01228f
C2940 sg13cmos5l_mux4_1_11.A3 sg13cmos5l_inv_1_901.Y 0.01448f
C2941 sg13cmos5l_inv_1_216.Y VPWR 0.96807f
C2942 sg13cmos5l_inv_1_370.Y sg13cmos5l_inv_1_362.A 0.17982f
C2943 sg13cmos5l_inv_1_998.Y sg13cmos5l_inv_1_1002.A 0.03117f
C2944 sg13cmos5l_mux4_1_5.S0 a_3623_15994# 0.51839f
C2945 sg13cmos5l_buf_1_9.A sg13cmos5l_inv_1_692.A 0.04732f
C2946 sg13cmos5l_mux4_1_5.S1 a_8653_3418# 0.38392f
C2947 a_4438_3534# a_5005_3418# 0.40359f
C2948 sg13cmos5l_inv_1_480.A VPWR 0.72248f
C2949 sg13cmos5l_inv_1_36.A sg13cmos5l_inv_1_0.Y 0.04397f
C2950 sg13cmos5l_inv_1_1.Y sg13cmos5l_inv_1_0.A 0.01487f
C2951 sg13cmos5l_inv_1_876.Y sg13cmos5l_inv_1_888.Y 0.03114f
C2952 sg13cmos5l_buf_1_0.A sg13cmos5l_inv_1_0.Y 0.05823f
C2953 sg13cmos5l_inv_1_346.Y sg13cmos5l_inv_1_372.A 0.12478f
C2954 sg13cmos5l_inv_1_120.Y sg13cmos5l_inv_1_122.Y 0.12034f
C2955 sg13cmos5l_inv_1_924.Y sg13cmos5l_inv_1_971.Y 0.01193f
C2956 a_13288_13098# a_13472_13098# 0.11523f
C2957 VPWR invsel[0] 0.19268f
C2958 sg13cmos5l_inv_1_76.A sg13cmos5l_mux4_1_2.A2 3.36662f
C2959 sg13cmos5l_inv_1_270.Y sg13cmos5l_mux4_1_3.X 0.01954f
C2960 sg13cmos5l_mux4_1_9.X a_5005_12490# 0.03928f
C2961 sg13cmos5l_inv_1_141.Y sg13cmos5l_inv_1_217.A 0.01264f
C2962 sg13cmos5l_inv_1_237.Y sg13cmos5l_inv_1_237.A 0.09825f
C2963 sg13cmos5l_inv_1_549.A sg13cmos5l_inv_1_541.A 0.1589f
C2964 sg13cmos5l_inv_1_277.A VPWR 0.47848f
C2965 sg13cmos5l_buf_1_12.X sg13cmos5l_inv_1_392.A 0.02269f
C2966 sg13cmos5l_inv_1_282.Y VPWR 0.38998f
C2967 sg13cmos5l_inv_1_171.A sg13cmos5l_inv_1_182.A 0.13491f
C2968 a_3304_18350# VPWR 0.13177f
C2969 sg13cmos5l_inv_1_145.Y a_17896_6254# 0.03488f
C2970 a_18280_18264# sg13cmos5l_buf_1_21.A 0.3325f
C2971 sg13cmos5l_inv_1_694.A sg13cmos5l_inv_1_694.Y 0.20046f
C2972 a_3304_9278# a_3488_9278# 0.11523f
C2973 sg13cmos5l_buf_1_10.A sg13cmos5l_inv_1_926.Y 0.03745f
C2974 sg13cmos5l_inv_1_37.A a_19136_2514# 0.01054f
C2975 sg13cmos5l_inv_1_283.A sg13cmos5l_inv_1_248.A 1.83863f
C2976 sg13cmos5l_inv_1_187.A sg13cmos5l_inv_1_194.Y 0.01544f
C2977 sg13cmos5l_inv_1_922.A VPWR 0.54281f
C2978 sg13cmos5l_inv_1_206.Y VPWR 0.36283f
C2979 sg13cmos5l_inv_1_837.Y sg13cmos5l_inv_1_834.Y 0.06693f
C2980 a_13895_15630# VPWR 0.38517f
C2981 a_3304_1718# VPWR 0.12535f
C2982 sg13cmos5l_inv_1_39.A sg13cmos5l_inv_1_1.Y 0.04048f
C2983 sg13cmos5l_inv_1_37.A sg13cmos5l_inv_1_36.A 0.16884f
C2984 sg13cmos5l_inv_1_369.A sg13cmos5l_inv_1_370.A 0.06731f
C2985 sg13cmos5l_buf_1_0.A sg13cmos5l_inv_1_57.Y 0.04923f
C2986 sg13cmos5l_inv_1_293.Y a_5896_3230# 0.03434f
C2987 sg13cmos5l_inv_1_566.A sg13cmos5l_inv_1_565.Y 0.09802f
C2988 sg13cmos5l_inv_1_572.A sg13cmos5l_inv_1_533.A 0.0258f
C2989 sg13cmos5l_inv_1_114.Y sg13cmos5l_inv_1_118.Y 0.01844f
C2990 sg13cmos5l_inv_1_15.Y sg13cmos5l_inv_1_20.Y 0.21399f
C2991 sg13cmos5l_mux4_1_10.A2 sg13cmos5l_mux4_1_5.S0 0.48623f
C2992 sg13cmos5l_inv_1_815.A a_17224_15326# 0.03747f
C2993 sg13cmos5l_inv_1_816.Y sg13cmos5l_inv_1_876.Y 0.07122f
C2994 a_10784_4742# VPWR 0.08093f
C2995 a_14913_3940# sg13cmos5l_mux4_1_2.X 0.2029f
C2996 a_9064_8562# VPWR 0.14379f
C2997 a_5005_3418# a_4929_3492# 0.26108f
C2998 sg13cmos5l_inv_1_868.A sg13cmos5l_inv_1_815.A 0.01546f
C2999 sg13cmos5l_mux4_1_8.A0 VPWR 1.00553f
C3000 sg13cmos5l_inv_1_584.A sg13cmos5l_mux4_1_8.A1 0.02673f
C3001 sg13cmos5l_inv_1_723.A a_18464_11586# 0.03553f
C3002 a_18664_16838# VPWR 0.1318f
C3003 sg13cmos5l_inv_1_78.A sg13cmos5l_inv_1_92.A 0.09795f
C3004 sg13cmos5l_mux4_1_5.S0 sg13cmos5l_mux4_1_7.A2 0.03352f
C3005 sg13cmos5l_inv_1_260.A sg13cmos5l_inv_1_260.Y 0.22087f
C3006 sg13cmos5l_inv_1_699.Y sg13cmos5l_inv_1_717.A 0.02914f
C3007 a_14827_11673# a_15580_11458# 0.01012f
C3008 sg13cmos5l_nor3_1_2.B sg13cmos5l_a21oi_1_0.Y 0.28871f
C3009 sg13cmos5l_inv_1_535.Y sg13cmos5l_mux2_1_2.A0 0.0255f
C3010 a_14710_15630# a_15277_15514# 0.40359f
C3011 sg13cmos5l_inv_1_426.A a_6368_4742# 0.01368f
C3012 sg13cmos5l_nor4_1_0.Y VPWR 0.42514f
C3013 a_808_18264# sg13cmos5l_nor2b_1_0.B_N 0.32989f
C3014 sg13cmos5l_inv_1_632.A sg13cmos5l_inv_1_684.Y 0.02521f
C3015 sg13cmos5l_inv_1_101.Y sg13cmos5l_inv_1_1010.Y 0.10403f
C3016 sg13cmos5l_inv_1_571.Y a_800_16838# 0.01054f
C3017 sg13cmos5l_inv_1_699.Y sg13cmos5l_inv_1_700.Y 0.03365f
C3018 sg13cmos5l_inv_1_1011.A sg13cmos5l_inv_1_101.Y 0.03998f
C3019 sg13cmos5l_inv_1_287.A a_7495_3195# 0.0124f
C3020 sg13cmos5l_nand2_1_1.B VPWR 2.1919f
C3021 sg13cmos5l_mux2_1_4.S sg13cmos5l_inv_1_978.A 0.01166f
C3022 sg13cmos5l_buf_1_12.X sg13cmos5l_inv_1_372.A 0.02645f
C3023 sg13cmos5l_buf_1_9.A sg13cmos5l_mux2_1_4.S 0.29805f
C3024 sg13cmos5l_a21oi_1_1.A2 sg13cmos5l_inv_1_480.A 0.14843f
C3025 sg13cmos5l_inv_1_880.A sg13cmos5l_inv_1_892.Y 0.01199f
C3026 sg13cmos5l_mux4_1_11.A1 sg13cmos5l_inv_1_912.A 0.21784f
C3027 sg13cmos5l_inv_1_402.A a_4929_8028# 0.03578f
C3028 sg13cmos5l_inv_1_149.A a_16075_7649# 0.0833f
C3029 a_15608_7680# sg13cmos5l_inv_1_152.Y 0.02744f
C3030 sg13cmos5l_inv_1_819.Y sg13cmos5l_inv_1_824.A 0.02029f
C3031 sg13cmos5l_mux2_1_0.X sg13cmos5l_mux4_1_5.S1 0.09345f
C3032 a_13607_14482# sg13cmos5l_mux4_1_14.A3 0.08569f
C3033 a_13288_14610# a_13472_14610# 0.11523f
C3034 sg13cmos5l_mux4_1_6.A2 sg13cmos5l_inv_1_351.Y 0.09289f
C3035 sg13cmos5l_inv_1_959.Y a_12896_9278# 0.04618f
C3036 a_8805_10240# VPWR 0.01364f
C3037 sg13cmos5l_inv_1_779.A VPWR 0.58506f
C3038 sg13cmos5l_mux2_1_4.S sg13cmos5l_mux4_1_15.X 0.57465f
C3039 sg13cmos5l_inv_1_889.Y sg13cmos5l_inv_1_902.Y 0.04862f
C3040 sg13cmos5l_inv_1_149.A a_16928_7050# 0.01057f
C3041 sg13cmos5l_inv_1_889.A sg13cmos5l_inv_1_903.Y 0.04041f
C3042 sg13cmos5l_inv_1_247.Y sg13cmos5l_inv_1_281.Y 0.01009f
C3043 sg13cmos5l_inv_1_345.A sg13cmos5l_inv_1_345.Y 0.2307f
C3044 sg13cmos5l_inv_1_334.A a_1480_4026# 0.01461f
C3045 a_18464_11586# VPWR 0.07788f
C3046 a_17896_13098# VPWR 0.14007f
C3047 a_9920_9278# VPWR 0.06841f
C3048 sg13cmos5l_mux4_1_5.S1 sg13cmos5l_inv_1_102.Y 0.02751f
C3049 sg13cmos5l_inv_1_836.Y a_17896_17634# 0.03691f
C3050 sg13cmos5l_inv_1_708.A a_17896_13098# 0.03488f
C3051 sg13cmos5l_buf_1_19.A sg13cmos5l_inv_1_726.A 0.03592f
C3052 sg13cmos5l_mux4_1_15.A3 sg13cmos5l_inv_1_933.Y 0.06767f
C3053 sg13cmos5l_inv_1_141.Y a_17896_7050# 0.05073f
C3054 sg13cmos5l_inv_1_964.A VPWR 0.49695f
C3055 sg13cmos5l_mux4_1_16.A2 sg13cmos5l_inv_1_111.Y 0.01851f
C3056 sg13cmos5l_inv_1_241.A sg13cmos5l_inv_1_426.A 0.06138f
C3057 sg13cmos5l_inv_1_429.A VPWR 0.42432f
C3058 sg13cmos5l_inv_1_338.Y sg13cmos5l_inv_1_324.Y 0.60669f
C3059 sg13cmos5l_mux4_1_15.A3 sg13cmos5l_mux4_1_15.A2 0.05076f
C3060 sg13cmos5l_nor2b_1_0.A a_1192_16122# 0.03265f
C3061 sg13cmos5l_mux4_1_14.A0 sg13cmos5l_inv_1_883.Y 0.12793f
C3062 sg13cmos5l_mux4_1_5.S1 sg13cmos5l_inv_1_128.Y 0.39102f
C3063 sg13cmos5l_inv_1_610.Y sg13cmos5l_inv_1_610.A 0.1808f
C3064 sg13cmos5l_o21ai_1_0.B1 sg13cmos5l_inv_1_970.A 0.0247f
C3065 sg13cmos5l_inv_1_147.Y VPWR 0.42798f
C3066 sg13cmos5l_inv_1_863.A VPWR 0.42587f
C3067 sg13cmos5l_inv_1_67.A VPWR 0.4287f
C3068 sg13cmos5l_inv_1_562.A VPWR 0.39573f
C3069 sg13cmos5l_inv_1_237.Y sg13cmos5l_inv_1_338.Y 0.18161f
C3070 sg13cmos5l_inv_1_876.A sg13cmos5l_inv_1_873.A 0.36694f
C3071 sg13cmos5l_inv_1_346.Y a_1576_6254# 0.02358f
C3072 sg13cmos5l_mux2_1_4.S sg13cmos5l_inv_1_113.A 0.11946f
C3073 sg13cmos5l_inv_1_110.A VPWR 0.5638f
C3074 sg13cmos5l_inv_1_72.Y a_10688_2514# 0.03553f
C3075 sg13cmos5l_inv_1_916.A sg13cmos5l_inv_1_883.Y 0.04046f
C3076 sg13cmos5l_mux4_1_8.A0 sg13cmos5l_a21oi_1_1.A2 0.2658f
C3077 sg13cmos5l_inv_1_520.A sg13cmos5l_inv_1_499.Y 0.09475f
C3078 sg13cmos5l_mux2_1_0.X sg13cmos5l_inv_1_959.A 0.241f
C3079 sg13cmos5l_inv_1_731.Y sg13cmos5l_inv_1_757.Y 0.26162f
C3080 sg13cmos5l_inv_1_407.A sg13cmos5l_inv_1_407.Y 0.20065f
C3081 sg13cmos5l_inv_1_65.A sg13cmos5l_inv_1_981.A 0.12365f
C3082 sg13cmos5l_inv_1_267.Y sg13cmos5l_inv_1_241.A 1.13376f
C3083 sg13cmos5l_inv_1_228.Y sg13cmos5l_inv_1_235.A 0.07947f
C3084 sg13cmos5l_inv_1_241.Y a_7424_4026# 0.04394f
C3085 sg13cmos5l_inv_1_189.Y VPWR 0.4306f
C3086 sg13cmos5l_inv_1_462.Y VPWR 0.42339f
C3087 sg13cmos5l_inv_1_157.Y VPWR 0.42676f
C3088 sg13cmos5l_inv_1_350.Y a_800_9278# 0.03646f
C3089 sg13cmos5l_inv_1_974.Y sg13cmos5l_inv_1_991.A 0.04871f
C3090 sg13cmos5l_inv_1_807.A sg13cmos5l_inv_1_792.Y 0.06737f
C3091 sg13cmos5l_inv_1_310.Y sg13cmos5l_inv_1_306.Y 0.09474f
C3092 sg13cmos5l_inv_1_791.A sg13cmos5l_inv_1_975.A 0.24595f
C3093 sg13cmos5l_inv_1_100.A sg13cmos5l_inv_1_95.A 0.1151f
C3094 sg13cmos5l_inv_1_535.Y a_6752_17634# 0.03465f
C3095 sg13cmos5l_o21ai_1_0.B1 sg13cmos5l_inv_1_950.A 0.02785f
C3096 a_3623_3534# a_3847_3195# 0.01074f
C3097 sg13cmos5l_inv_1_8.A sg13cmos5l_inv_1_0.Y 0.01802f
C3098 sg13cmos5l_inv_1_720.Y sg13cmos5l_inv_1_712.A 0.01084f
C3099 sg13cmos5l_buf_1_0.A sg13cmos5l_inv_1_63.A 0.01338f
C3100 sg13cmos5l_inv_1_370.Y sg13cmos5l_inv_1_376.A 0.26769f
C3101 sg13cmos5l_inv_1_378.Y a_1568_7766# 0.01054f
C3102 sg13cmos5l_inv_1_928.A sg13cmos5l_inv_1_942.Y 0.09909f
C3103 sg13cmos5l_buf_1_9.A sg13cmos5l_inv_1_690.A 0.01287f
C3104 sg13cmos5l_inv_1_311.Y sg13cmos5l_inv_1_305.A 0.01618f
C3105 sg13cmos5l_inv_1_994.Y sg13cmos5l_inv_1_986.Y 0.01015f
C3106 sg13cmos5l_inv_1_36.A sg13cmos5l_inv_1_0.A 0.01476f
C3107 sg13cmos5l_inv_1_876.Y sg13cmos5l_inv_1_876.A 0.12895f
C3108 sg13cmos5l_buf_1_0.A sg13cmos5l_inv_1_0.A 0.05724f
C3109 sg13cmos5l_inv_1_121.Y a_10976_7766# 0.01372f
C3110 sg13cmos5l_inv_1_122.A sg13cmos5l_inv_1_122.Y 0.11155f
C3111 sg13cmos5l_nor3_1_1.B sg13cmos5l_a21oi_1_0.Y 0.07316f
C3112 sg13cmos5l_inv_1_972.Y sg13cmos5l_inv_1_971.Y 0.23289f
C3113 VPWR osc_tap[0] 0.14359f
C3114 sg13cmos5l_inv_1_312.Y sg13cmos5l_inv_1_311.A 0.01317f
C3115 sg13cmos5l_inv_1_20.Y sg13cmos5l_inv_1_13.Y 0.2023f
C3116 sg13cmos5l_inv_1_868.A sg13cmos5l_inv_1_880.A 0.01942f
C3117 sg13cmos5l_inv_1_7.Y a_17696_1718# 0.03646f
C3118 sg13cmos5l_mux2_1_4.X sg13cmos5l_mux4_1_16.A1 0.61326f
C3119 sg13cmos5l_inv_1_723.A a_19136_10790# 0.01054f
C3120 sg13cmos5l_inv_1_320.Y sg13cmos5l_inv_1_336.A 0.04034f
C3121 sg13cmos5l_inv_1_723.Y sg13cmos5l_inv_1_694.Y 0.01193f
C3122 sg13cmos5l_mux2_1_2.A0 a_4798_12970# 0.10857f
C3123 sg13cmos5l_inv_1_549.A sg13cmos5l_inv_1_571.Y 0.23152f
C3124 sg13cmos5l_inv_1_281.Y VPWR 0.50878f
C3125 a_7271_15994# a_7582_15994# 0.49675f
C3126 sg13cmos5l_inv_1_293.Y VPWR 0.5499f
C3127 sg13cmos5l_inv_1_556.Y VPWR 0.42274f
C3128 sg13cmos5l_inv_1_145.Y sg13cmos5l_inv_1_141.A 0.01431f
C3129 a_8096_11586# VPWR 0.06569f
C3130 sg13cmos5l_inv_1_834.Y sg13cmos5l_buf_1_21.A 0.17256f
C3131 sg13cmos5l_inv_1_1000.Y sg13cmos5l_inv_1_694.Y 0.01318f
C3132 sg13cmos5l_buf_1_10.A sg13cmos5l_inv_1_241.A 0.02096f
C3133 sg13cmos5l_inv_1_283.A sg13cmos5l_inv_1_344.Y 0.08196f
C3134 sg13cmos5l_inv_1_187.A sg13cmos5l_inv_1_187.Y 0.20032f
C3135 sg13cmos5l_inv_1_925.A VPWR 0.51538f
C3136 a_3488_12302# VPWR 0.07363f
C3137 sg13cmos5l_inv_1_225.Y VPWR 0.5136f
C3138 a_16075_7649# a_15637_8028# 0.49675f
C3139 sg13cmos5l_inv_1_837.Y sg13cmos5l_inv_1_823.A 0.03173f
C3140 sg13cmos5l_inv_1_883.Y VPWR 0.61987f
C3141 sg13cmos5l_inv_1_296.Y VPWR 0.43855f
C3142 a_18664_4026# VPWR 0.13338f
C3143 sg13cmos5l_inv_1_39.A sg13cmos5l_inv_1_36.A 0.34611f
C3144 sg13cmos5l_inv_1_916.A a_11936_14610# 0.03603f
C3145 sg13cmos5l_inv_1_272.A a_5896_3230# 0.01986f
C3146 sg13cmos5l_inv_1_566.A sg13cmos5l_inv_1_575.Y 0.10235f
C3147 sg13cmos5l_nor3_1_1.A a_8383_12192# 0.09705f
C3148 sg13cmos5l_mux2_1_4.S sg13cmos5l_inv_1_206.A 0.21242f
C3149 sg13cmos5l_inv_1_583.A sg13cmos5l_inv_1_581.A 0.20065f
C3150 sg13cmos5l_inv_1_915.A sg13cmos5l_inv_1_913.A 0.35687f
C3151 sg13cmos5l_inv_1_15.Y sg13cmos5l_inv_1_56.Y 0.06335f
C3152 sg13cmos5l_inv_1_533.A sg13cmos5l_mux4_1_5.S0 0.11543f
C3153 sg13cmos5l_inv_1_920.A a_17224_15326# 0.03544f
C3154 sg13cmos5l_inv_1_815.A sg13cmos5l_inv_1_813.Y 0.02696f
C3155 sg13cmos5l_inv_1_235.Y VPWR 0.4827f
C3156 sg13cmos5l_mux2_1_0.X sg13cmos5l_buf_1_0.A 0.98571f
C3157 sg13cmos5l_inv_1_938.Y a_13472_10074# 0.01054f
C3158 a_10976_7766# VPWR 0.08239f
C3159 sg13cmos5l_inv_1_304.A sg13cmos5l_inv_1_310.Y 0.05861f
C3160 sg13cmos5l_a21oi_1_0.A2 sg13cmos5l_a21oi_1_0.Y 0.01234f
C3161 sg13cmos5l_inv_1_868.A sg13cmos5l_inv_1_920.A 0.11152f
C3162 sg13cmos5l_inv_1_614.A sg13cmos5l_mux4_1_8.A1 0.03024f
C3163 sg13cmos5l_inv_1_350.Y sg13cmos5l_inv_1_377.Y 0.01158f
C3164 sg13cmos5l_inv_1_89.Y sg13cmos5l_inv_1_82.Y 0.09544f
C3165 a_19048_6254# VPWR 0.12473f
C3166 sg13cmos5l_inv_1_721.A a_18464_11586# 0.01083f
C3167 sg13cmos5l_buf_1_23.X VPWR 0.30318f
C3168 sg13cmos5l_inv_1_48.Y sg13cmos5l_inv_1_53.Y 0.2026f
C3169 sg13cmos5l_inv_1_362.A sg13cmos5l_inv_1_346.Y 0.20252f
C3170 a_19136_10790# VPWR 0.06734f
C3171 sg13cmos5l_inv_1_110.A sg13cmos5l_inv_1_236.A 0.20038f
C3172 sg13cmos5l_buf_1_0.A sg13cmos5l_inv_1_102.Y 0.01819f
C3173 sg13cmos5l_inv_1_699.Y sg13cmos5l_inv_1_699.A 0.26936f
C3174 sg13cmos5l_inv_1_248.A sg13cmos5l_inv_1_247.Y 0.016f
C3175 sg13cmos5l_buf_1_8.A sg13cmos5l_inv_1_734.Y 0.02433f
C3176 sg13cmos5l_inv_1_283.A sg13cmos5l_mux4_1_5.X 0.02601f
C3177 a_3488_13814# VPWR 0.07406f
C3178 sg13cmos5l_inv_1_534.Y sg13cmos5l_mux2_1_2.A0 0.13732f
C3179 sg13cmos5l_inv_1_323.A sg13cmos5l_inv_1_327.A 0.22805f
C3180 sg13cmos5l_inv_1_416.A sg13cmos5l_inv_1_414.A 0.02234f
C3181 sg13cmos5l_mux2_1_4.S a_14998_9582# 0.05736f
C3182 a_7582_3534# a_7495_3195# 0.02548f
C3183 sg13cmos5l_or2_1_0.X VPWR 0.41639f
C3184 sg13cmos5l_inv_1_44.A sg13cmos5l_inv_1_39.A 0.01392f
C3185 sg13cmos5l_buf_1_0.A sg13cmos5l_inv_1_128.Y 0.01958f
C3186 sg13cmos5l_inv_1_632.A sg13cmos5l_inv_1_633.A 0.18681f
C3187 sg13cmos5l_buf_1_9.A sg13cmos5l_inv_1_338.Y 0.0555f
C3188 sg13cmos5l_inv_1_101.Y sg13cmos5l_inv_1_278.Y 0.02772f
C3189 sg13cmos5l_inv_1_790.Y sg13cmos5l_inv_1_773.Y 0.23018f
C3190 sg13cmos5l_inv_1_704.Y sg13cmos5l_inv_1_700.Y 0.01931f
C3191 sg13cmos5l_or2_1_0.B VPWR 0.87984f
C3192 sg13cmos5l_mux2_1_4.S sg13cmos5l_inv_1_977.A 0.01166f
C3193 sg13cmos5l_inv_1_598.A a_9440_17634# 0.03618f
C3194 sg13cmos5l_inv_1_66.A a_13472_1718# 0.013f
C3195 sg13cmos5l_o21ai_1_0.B1 sg13cmos5l_inv_1_525.A 0.25824f
C3196 sg13cmos5l_mux4_1_6.A2 sg13cmos5l_inv_1_370.Y 0.08882f
C3197 sg13cmos5l_inv_1_100.A a_14614_3534# 0.04709f
C3198 sg13cmos5l_inv_1_412.A a_5608_7050# 0.05409f
C3199 a_11936_14610# VPWR 0.07774f
C3200 sg13cmos5l_o21ai_1_0.Y a_10162_9570# 0.12103f
C3201 sg13cmos5l_inv_1_734.Y sg13cmos5l_inv_1_901.Y 0.20065f
C3202 sg13cmos5l_inv_1_902.Y sg13cmos5l_inv_1_903.Y 0.34527f
C3203 sg13cmos5l_inv_1_292.Y sg13cmos5l_inv_1_287.Y 0.02425f
C3204 sg13cmos5l_inv_1_726.A VPWR 0.53815f
C3205 sg13cmos5l_inv_1_293.Y sg13cmos5l_inv_1_290.Y 0.11745f
C3206 sg13cmos5l_nor3_1_0.Y sg13cmos5l_inv_1_394.A 0.04387f
C3207 sg13cmos5l_inv_1_708.A sg13cmos5l_inv_1_726.A 0.1118f
C3208 sg13cmos5l_o21ai_1_0.B1 VPWR 1.62177f
C3209 sg13cmos5l_buf_1_8.A sg13cmos5l_inv_1_76.A 2.18045f
C3210 sg13cmos5l_inv_1_389.Y sg13cmos5l_inv_1_382.Y 0.04735f
C3211 sg13cmos5l_inv_1_788.Y sg13cmos5l_inv_1_797.Y 0.0123f
C3212 sg13cmos5l_inv_1_552.Y sg13cmos5l_inv_1_551.Y 0.18235f
C3213 sg13cmos5l_inv_1_904.A sg13cmos5l_inv_1_904.Y 0.11308f
C3214 sg13cmos5l_inv_1_564.A a_3304_18350# 0.04368f
C3215 sg13cmos5l_inv_1_672.Y sg13cmos5l_nor3_1_2.B 0.01323f
C3216 sg13cmos5l_mux4_1_16.A2 sg13cmos5l_inv_1_110.A 0.22714f
C3217 sg13cmos5l_mux4_1_8.A0 sg13cmos5l_mux4_1_5.S0 0.31379f
C3218 sg13cmos5l_inv_1_421.Y sg13cmos5l_inv_1_419.A 0.07004f
C3219 a_5696_2514# VPWR 0.08807f
C3220 sg13cmos5l_inv_1_394.A a_8123_8472# 0.03681f
C3221 sg13cmos5l_inv_1_851.A sg13cmos5l_mux4_1_13.A0 0.03105f
C3222 sg13cmos5l_inv_1_535.Y sg13cmos5l_inv_1_562.Y 0.8734f
C3223 sg13cmos5l_inv_1_148.Y VPWR 0.40927f
C3224 sg13cmos5l_inv_1_865.Y VPWR 0.42715f
C3225 sg13cmos5l_inv_1_66.A VPWR 0.63558f
C3226 a_7981_12976# VPWR 0.12579f
C3227 sg13cmos5l_mux4_1_5.S1 sg13cmos5l_inv_1_184.A 0.02604f
C3228 sg13cmos5l_inv_1_535.A VPWR 0.41595f
C3229 sg13cmos5l_inv_1_228.Y sg13cmos5l_inv_1_224.Y 0.14183f
C3230 sg13cmos5l_inv_1_224.A sg13cmos5l_inv_1_190.A 0.02698f
C3231 sg13cmos5l_inv_1_879.A sg13cmos5l_inv_1_892.A 0.12697f
C3232 a_13288_15326# a_13472_15326# 0.11523f
C3233 sg13cmos5l_mux4_1_7.A3 sg13cmos5l_inv_1_656.Y 0.01126f
C3234 a_13895_15630# a_14206_15630# 0.49675f
C3235 a_6430_8434# a_6934_8434# 0.97548f
C3236 sg13cmos5l_inv_1_876.A sg13cmos5l_inv_1_888.Y 0.28331f
C3237 sg13cmos5l_mux4_1_16.X a_10096_8050# 0.0168f
C3238 sg13cmos5l_mux2_1_4.S sg13cmos5l_inv_1_179.A 0.77149f
C3239 sg13cmos5l_inv_1_109.Y VPWR 0.69791f
C3240 sg13cmos5l_inv_1_1010.Y a_10688_2514# 0.03508f
C3241 a_18856_14516# VPWR 0.24864f
C3242 sg13cmos5l_inv_1_295.A sg13cmos5l_inv_1_296.A 0.15283f
C3243 sg13cmos5l_buf_1_17.X sg13cmos5l_buf_1_19.A 0.01429f
C3244 sg13cmos5l_mux4_1_5.S0 sg13cmos5l_nand2_1_1.B 0.09672f
C3245 sg13cmos5l_inv_1_818.A a_16256_15326# 0.03553f
C3246 sg13cmos5l_inv_1_8.Y sg13cmos5l_inv_1_7.A 0.09751f
C3247 sg13cmos5l_inv_1_240.Y sg13cmos5l_inv_1_240.A 0.20065f
C3248 sg13cmos5l_inv_1_702.Y sg13cmos5l_inv_1_931.A 0.01019f
C3249 sg13cmos5l_inv_1_241.Y sg13cmos5l_inv_1_69.A 1.88607f
C3250 sg13cmos5l_inv_1_268.A a_7424_4026# 0.01402f
C3251 sg13cmos5l_inv_1_248.A VPWR 2.19867f
C3252 sg13cmos5l_inv_1_194.Y VPWR 0.46157f
C3253 sg13cmos5l_inv_1_156.Y VPWR 0.42541f
C3254 sg13cmos5l_mux2_1_0.X a_15768_4088# 0.01917f
C3255 sg13cmos5l_inv_1_1010.Y sg13cmos5l_inv_1_65.Y 0.0342f
C3256 sg13cmos5l_inv_1_565.Y VPWR 1.05493f
C3257 sg13cmos5l_inv_1_310.Y sg13cmos5l_inv_1_307.A 0.04388f
C3258 a_6599_12970# sg13cmos5l_inv_1_495.A 0.25432f
C3259 sg13cmos5l_inv_1_459.A sg13cmos5l_inv_1_459.Y 0.20237f
C3260 sg13cmos5l_inv_1_437.A a_3680_5538# 0.03465f
C3261 sg13cmos5l_inv_1_791.A sg13cmos5l_inv_1_627.A 0.01114f
C3262 sg13cmos5l_inv_1_685.Y sg13cmos5l_inv_1_666.Y 0.03462f
C3263 a_4438_8070# a_5005_7954# 0.40359f
C3264 sg13cmos5l_nand2_1_1.B invsel[3] 0.01109f
C3265 sg13cmos5l_inv_1_205.Y a_17216_5538# 0.01083f
C3266 sg13cmos5l_inv_1_8.A sg13cmos5l_inv_1_0.A 0.01529f
C3267 sg13cmos5l_inv_1_237.A sg13cmos5l_inv_1_981.A 0.04636f
C3268 sg13cmos5l_inv_1_233.A sg13cmos5l_inv_1_234.A 0.18234f
C3269 sg13cmos5l_mux4_1_2.A2 a_14913_3940# 0.01074f
C3270 sg13cmos5l_inv_1_85.A VPWR 0.63146f
C3271 sg13cmos5l_mux4_1_5.S1 sg13cmos5l_mux2_1_3.A0 0.62092f
C3272 sg13cmos5l_inv_1_378.Y sg13cmos5l_inv_1_362.A 0.0961f
C3273 sg13cmos5l_inv_1_928.A sg13cmos5l_inv_1_986.Y 0.02656f
C3274 sg13cmos5l_buf_1_9.A sg13cmos5l_inv_1_642.A 0.03057f
C3275 sg13cmos5l_mux2_1_4.S sg13cmos5l_inv_1_159.A 0.20186f
C3276 sg13cmos5l_inv_1_563.Y sg13cmos5l_inv_1_537.A 0.01516f
C3277 sg13cmos5l_nor3_1_2.B a_6599_12970# 0.02113f
C3278 sg13cmos5l_inv_1_306.A sg13cmos5l_inv_1_252.A 0.07357f
C3279 sg13cmos5l_buf_1_0.A sg13cmos5l_inv_1_8.Y 0.01072f
C3280 sg13cmos5l_inv_1_122.A sg13cmos5l_inv_1_120.Y 0.10957f
C3281 sg13cmos5l_a21oi_1_0.A1 sg13cmos5l_a21oi_1_0.Y 0.20755f
C3282 sg13cmos5l_mux4_1_12.A3 a_13472_13098# 0.01094f
C3283 VPWR invsel[1] 0.1811f
C3284 sg13cmos5l_inv_1_329.A a_800_2514# 0.03646f
C3285 a_7905_13012# VPWR 0.71647f
C3286 sg13cmos5l_inv_1_2.A a_17696_1718# 0.01083f
C3287 sg13cmos5l_inv_1_16.Y a_18856_1632# 0.02599f
C3288 sg13cmos5l_buf_1_0.A sg13cmos5l_inv_1_14.A 0.02601f
C3289 sg13cmos5l_mux2_1_4.X sg13cmos5l_inv_1_397.Y 0.28978f
C3290 a_7425_8476# sg13cmos5l_mux4_1_4.X 0.20279f
C3291 sg13cmos5l_inv_1_723.A sg13cmos5l_inv_1_694.Y 0.23289f
C3292 sg13cmos5l_inv_1_314.Y sg13cmos5l_inv_1_320.A 0.0114f
C3293 sg13cmos5l_inv_1_545.A sg13cmos5l_inv_1_571.Y 0.06111f
C3294 sg13cmos5l_inv_1_285.Y VPWR 0.6851f
C3295 sg13cmos5l_buf_1_12.X sg13cmos5l_inv_1_393.A 0.11767f
C3296 sg13cmos5l_inv_1_272.A VPWR 0.61861f
C3297 sg13cmos5l_mux4_1_7.A2 a_7414_12970# 0.03038f
C3298 sg13cmos5l_inv_1_550.Y VPWR 0.42362f
C3299 sg13cmos5l_inv_1_145.Y sg13cmos5l_inv_1_205.A 0.19503f
C3300 a_15637_8028# a_16021_7685# 0.01228f
C3301 sg13cmos5l_inv_1_1000.Y sg13cmos5l_inv_1_694.A 0.23204f
C3302 sg13cmos5l_inv_1_25.Y sg13cmos5l_inv_1_187.Y 0.0576f
C3303 sg13cmos5l_inv_1_684.Y sg13cmos5l_inv_1_672.A 0.02619f
C3304 a_18464_7766# VPWR 0.07957f
C3305 sg13cmos5l_inv_1_190.A VPWR 0.42305f
C3306 sg13cmos5l_inv_1_835.A sg13cmos5l_inv_1_823.A 0.11107f
C3307 sg13cmos5l_buf_1_9.A a_8653_16000# 0.36352f
C3308 sg13cmos5l_inv_1_294.Y VPWR 0.36263f
C3309 sg13cmos5l_inv_1_916.A sg13cmos5l_inv_1_908.A 0.04054f
C3310 sg13cmos5l_mux2_1_3.S a_8446_8434# 0.14192f
C3311 sg13cmos5l_inv_1_625.Y sg13cmos5l_inv_1_642.Y 0.0951f
C3312 sg13cmos5l_inv_1_317.Y sg13cmos5l_inv_1_420.A 0.07418f
C3313 sg13cmos5l_inv_1_439.Y sg13cmos5l_inv_1_314.Y 0.0154f
C3314 sg13cmos5l_inv_1_573.A sg13cmos5l_inv_1_575.Y 0.23445f
C3315 a_17512_2514# VPWR 0.16302f
C3316 sg13cmos5l_inv_1_534.A sg13cmos5l_inv_1_684.A 0.06768f
C3317 a_5005_7954# a_4929_8028# 0.2611f
C3318 sg13cmos5l_mux4_1_5.S1 sg13cmos5l_inv_1_270.Y 0.02877f
C3319 sg13cmos5l_inv_1_100.A sg13cmos5l_inv_1_216.Y 0.16348f
C3320 sg13cmos5l_inv_1_815.A sg13cmos5l_inv_1_876.Y 0.09225f
C3321 sg13cmos5l_inv_1_816.A sg13cmos5l_inv_1_816.Y 0.20065f
C3322 sg13cmos5l_inv_1_235.A VPWR 0.4269f
C3323 sg13cmos5l_inv_1_364.A sg13cmos5l_inv_1_411.A 0.04677f
C3324 sg13cmos5l_inv_1_122.Y VPWR 0.44631f
C3325 a_2632_4026# a_2816_4026# 0.11523f
C3326 a_13472_7050# VPWR 0.06615f
C3327 sg13cmos5l_inv_1_82.A sg13cmos5l_inv_1_82.Y 0.27429f
C3328 sg13cmos5l_inv_1_12.Y sg13cmos5l_inv_1_53.Y 0.03099f
C3329 sg13cmos5l_inv_1_337.Y sg13cmos5l_buf_1_7.X 0.07593f
C3330 sg13cmos5l_inv_1_694.Y VPWR 0.42262f
C3331 a_8000_7050# VPWR 0.07787f
C3332 sg13cmos5l_inv_1_110.A sg13cmos5l_inv_1_218.A 0.11665f
C3333 sg13cmos5l_inv_1_704.Y sg13cmos5l_inv_1_699.A 0.13626f
C3334 sg13cmos5l_inv_1_988.A sg13cmos5l_inv_1_202.Y 0.14581f
C3335 sg13cmos5l_buf_1_8.A sg13cmos5l_inv_1_734.A 0.02415f
C3336 sg13cmos5l_inv_1_489.A sg13cmos5l_nand2_1_1.B 0.01347f
C3337 sg13cmos5l_inv_1_92.A sg13cmos5l_inv_1_101.Y 0.05033f
C3338 sg13cmos5l_inv_1_336.A sg13cmos5l_inv_1_327.A 0.01277f
C3339 sg13cmos5l_mux4_1_5.S1 sg13cmos5l_inv_1_319.Y 0.84872f
C3340 sg13cmos5l_inv_1_416.A sg13cmos5l_inv_1_415.A 0.16371f
C3341 sg13cmos5l_inv_1_733.A a_13607_12606# 0.01153f
C3342 a_8638_6558# VPWR 0.88385f
C3343 a_2248_3932# VPWR 0.3166f
C3344 sg13cmos5l_a21oi_1_1.A1 VPWR 0.28266f
C3345 sg13cmos5l_mux2_1_4.S sg13cmos5l_inv_1_976.A 0.01139f
C3346 a_8086_15994# VPWR 0.03022f
C3347 sg13cmos5l_buf_1_9.A a_8577_16036# 0.20781f
C3348 sg13cmos5l_inv_1_59.Y a_12808_1718# 0.02608f
C3349 sg13cmos5l_inv_1_106.A sg13cmos5l_inv_1_184.A 0.03305f
C3350 sg13cmos5l_mux4_1_5.S0 sg13cmos5l_inv_1_925.A 0.18566f
C3351 sg13cmos5l_nor3_1_1.Y a_8919_10240# 0.02785f
C3352 a_15608_7680# sg13cmos5l_inv_1_149.A 0.22338f
C3353 sg13cmos5l_inv_1_169.Y sg13cmos5l_inv_1_158.Y 0.20994f
C3354 a_5005_16000# a_4929_16036# 0.2611f
C3355 a_3934_15994# a_4141_16261# 0.01967f
C3356 a_2816_10790# VPWR 0.07864f
C3357 a_12896_9278# VPWR 0.12777f
C3358 sg13cmos5l_inv_1_421.A a_2816_4742# 0.03465f
C3359 sg13cmos5l_inv_1_731.A a_13472_10790# 0.01411f
C3360 sg13cmos5l_inv_1_908.A VPWR 0.42248f
C3361 sg13cmos5l_inv_1_149.A sg13cmos5l_inv_1_141.Y 0.03704f
C3362 sg13cmos5l_inv_1_337.A sg13cmos5l_inv_1_337.Y 0.49998f
C3363 sg13cmos5l_mux4_1_9.A0 sg13cmos5l_inv_1_510.A 0.38193f
C3364 sg13cmos5l_inv_1_666.Y a_1576_13814# 0.03488f
C3365 sg13cmos5l_buf_1_12.X sg13cmos5l_mux2_1_4.X 1.1469f
C3366 sg13cmos5l_inv_1_725.Y sg13cmos5l_inv_1_726.A 0.06829f
C3367 sg13cmos5l_inv_1_392.A sg13cmos5l_inv_1_382.Y 0.011f
C3368 sg13cmos5l_inv_1_389.Y sg13cmos5l_inv_1_389.A 0.15563f
C3369 a_19048_7050# a_19048_6254# 0.01095f
C3370 sg13cmos5l_inv_1_434.A sg13cmos5l_inv_1_419.A 0.13494f
C3371 sg13cmos5l_mux4_1_15.A3 a_14183_9582# 0.07873f
C3372 sg13cmos5l_inv_1_828.Y sg13cmos5l_inv_1_782.A 0.25887f
C3373 sg13cmos5l_inv_1_771.Y sg13cmos5l_mux4_1_8.A0 0.02852f
C3374 sg13cmos5l_inv_1_563.A a_1192_16122# 0.02316f
C3375 sg13cmos5l_inv_1_327.A a_1856_2514# 0.03603f
C3376 sg13cmos5l_inv_1_394.A sg13cmos5l_mux4_1_6.X 0.19534f
C3377 sg13cmos5l_mux2_1_3.A0 sg13cmos5l_buf_1_0.A 0.11796f
C3378 sg13cmos5l_inv_1_535.Y sg13cmos5l_inv_1_560.Y 0.13768f
C3379 sg13cmos5l_inv_1_148.A VPWR 0.36491f
C3380 sg13cmos5l_inv_1_970.A sg13cmos5l_mux4_1_4.A2 0.24159f
C3381 sg13cmos5l_inv_1_509.Y a_2240_13098# 0.03534f
C3382 sg13cmos5l_mux4_1_12.A3 a_13607_12606# 0.14092f
C3383 sg13cmos5l_inv_1_792.Y VPWR 0.52989f
C3384 sg13cmos5l_mux4_1_5.S1 sg13cmos5l_inv_1_225.A 0.03453f
C3385 sg13cmos5l_inv_1_224.A sg13cmos5l_inv_1_224.Y 0.98764f
C3386 sg13cmos5l_inv_1_878.A sg13cmos5l_inv_1_892.A 0.4846f
C3387 a_17216_5538# VPWR 0.1165f
C3388 a_14183_9582# a_14612_9582# 0.0289f
C3389 sg13cmos5l_inv_1_202.Y a_14494_9582# 0.2115f
C3390 sg13cmos5l_inv_1_346.Y sg13cmos5l_inv_1_348.A 0.1244f
C3391 a_13288_16838# a_13472_16838# 0.11523f
C3392 sg13cmos5l_inv_1_874.Y sg13cmos5l_inv_1_818.A 0.01609f
C3393 sg13cmos5l_buf_1_17.X VPWR 0.35287f
C3394 sg13cmos5l_nor3_1_2.B sg13cmos5l_inv_1_940.A 0.02591f
C3395 sg13cmos5l_inv_1_744.Y sg13cmos5l_inv_1_752.A 0.01207f
C3396 a_13288_14610# a_13288_13814# 0.01095f
C3397 sg13cmos5l_inv_1_409.Y sg13cmos5l_inv_1_407.A 0.20065f
C3398 sg13cmos5l_inv_1_236.A sg13cmos5l_inv_1_235.A 0.03111f
C3399 sg13cmos5l_nand2_1_1.B sg13cmos5l_inv_1_921.Y 0.01571f
C3400 sg13cmos5l_inv_1_268.A sg13cmos5l_inv_1_69.A 0.05642f
C3401 sg13cmos5l_inv_1_344.Y VPWR 0.52267f
C3402 sg13cmos5l_inv_1_187.Y VPWR 0.42855f
C3403 sg13cmos5l_inv_1_155.Y VPWR 0.41219f
C3404 sg13cmos5l_a21oi_1_0.A2 a_8383_12192# 0.19485f
C3405 sg13cmos5l_inv_1_736.Y sg13cmos5l_inv_1_120.A 0.12332f
C3406 sg13cmos5l_inv_1_350.Y sg13cmos5l_inv_1_991.A 0.01392f
C3407 sg13cmos5l_inv_1_974.A sg13cmos5l_inv_1_974.Y 0.2023f
C3408 sg13cmos5l_inv_1_326.Y sg13cmos5l_inv_1_304.A 0.03034f
C3409 sg13cmos5l_inv_1_575.Y VPWR 0.47606f
C3410 sg13cmos5l_inv_1_14.A sg13cmos5l_inv_1_18.Y 0.20954f
C3411 sg13cmos5l_mux2_1_0.X sg13cmos5l_mux4_1_2.X 0.33263f
C3412 sg13cmos5l_mux4_1_6.A2 sg13cmos5l_inv_1_346.Y 0.73634f
C3413 a_15662_4084# VPWR 0.11012f
C3414 sg13cmos5l_mux4_1_14.A1 sg13cmos5l_inv_1_819.Y 0.08684f
C3415 sg13cmos5l_inv_1_491.A a_8008_12302# 0.05213f
C3416 sg13cmos5l_o21ai_1_0.B1 sg13cmos5l_inv_1_515.Y 0.08502f
C3417 sg13cmos5l_inv_1_205.Y sg13cmos5l_inv_1_195.Y 0.2023f
C3418 sg13cmos5l_inv_1_789.Y a_11464_16838# 0.03398f
C3419 sg13cmos5l_inv_1_8.A sg13cmos5l_inv_1_8.Y 0.09426f
C3420 sg13cmos5l_mux4_1_5.S1 sg13cmos5l_mux4_1_16.X 0.0228f
C3421 sg13cmos5l_buf_1_9.A sg13cmos5l_inv_1_641.A 0.04112f
C3422 sg13cmos5l_inv_1_928.A sg13cmos5l_inv_1_994.Y 0.1958f
C3423 sg13cmos5l_a21oi_1_1.A2 sg13cmos5l_a21oi_1_1.A1 0.22895f
C3424 a_13288_5538# a_13472_5538# 0.11523f
C3425 sg13cmos5l_mux4_1_5.S0 sg13cmos5l_o21ai_1_0.B1 0.16316f
C3426 sg13cmos5l_inv_1_563.Y sg13cmos5l_inv_1_689.A 0.09463f
C3427 sg13cmos5l_inv_1_306.A sg13cmos5l_inv_1_254.Y 0.0423f
C3428 sg13cmos5l_inv_1_446.A a_8480_4742# 0.05751f
C3429 sg13cmos5l_inv_1_241.A sg13cmos5l_inv_1_69.A 0.15163f
C3430 sg13cmos5l_o21ai_1_0.B1 sg13cmos5l_inv_1_983.Y 0.02057f
C3431 sg13cmos5l_inv_1_237.Y sg13cmos5l_inv_1_280.Y 0.01655f
C3432 sg13cmos5l_inv_1_305.Y sg13cmos5l_inv_1_373.A 0.01842f
C3433 sg13cmos5l_inv_1_362.A a_2144_7050# 0.04632f
C3434 a_8446_8434# a_8623_8728# 0.01068f
C3435 sg13cmos5l_inv_1_121.Y sg13cmos5l_inv_1_120.Y 0.40265f
C3436 VPWR osc_tap[1] 0.15843f
C3437 sg13cmos5l_inv_1_329.A sg13cmos5l_inv_1_311.A 0.14259f
C3438 sg13cmos5l_inv_1_548.Y sg13cmos5l_inv_1_541.Y 0.01066f
C3439 sg13cmos5l_inv_1_576.A sg13cmos5l_inv_1_541.A 0.18099f
C3440 sg13cmos5l_buf_1_0.A sg13cmos5l_inv_1_17.Y 0.02402f
C3441 sg13cmos5l_mux2_1_4.X sg13cmos5l_inv_1_391.A 0.03821f
C3442 sg13cmos5l_inv_1_723.A sg13cmos5l_inv_1_694.A 0.04734f
C3443 sg13cmos5l_inv_1_202.Y a_14701_9243# 0.01047f
C3444 sg13cmos5l_inv_1_314.Y sg13cmos5l_inv_1_328.Y 0.01147f
C3445 sg13cmos5l_inv_1_320.Y sg13cmos5l_inv_1_320.A 0.11165f
C3446 sg13cmos5l_inv_1_545.A sg13cmos5l_inv_1_549.A 0.2026f
C3447 sg13cmos5l_inv_1_828.Y sg13cmos5l_inv_1_809.Y 0.14737f
C3448 sg13cmos5l_inv_1_287.Y VPWR 0.56926f
C3449 a_18560_1002# VPWR 0.0774f
C3450 sg13cmos5l_mux4_1_5.X VPWR 0.274f
C3451 sg13cmos5l_inv_1_75.Y a_9832_4026# 0.03352f
C3452 sg13cmos5l_inv_1_78.A sg13cmos5l_inv_1_111.Y 0.0101f
C3453 sg13cmos5l_inv_1_14.A a_16168_1718# 0.05409f
C3454 sg13cmos5l_inv_1_535.A sg13cmos5l_mux4_1_5.S0 0.04107f
C3455 a_6464_12302# VPWR 0.07876f
C3456 sg13cmos5l_inv_1_551.Y VPWR 0.42476f
C3457 sg13cmos5l_inv_1_132.Y a_10688_7050# 0.04597f
C3458 sg13cmos5l_inv_1_25.Y sg13cmos5l_inv_1_187.A 0.29651f
C3459 sg13cmos5l_inv_1_115.A sg13cmos5l_inv_1_115.Y 0.16749f
C3460 sg13cmos5l_inv_1_633.A sg13cmos5l_inv_1_672.A 0.05394f
C3461 sg13cmos5l_inv_1_224.Y VPWR 0.55625f
C3462 sg13cmos5l_inv_1_176.A VPWR 0.51787f
C3463 a_15608_7680# a_15637_8028# 0.97548f
C3464 sg13cmos5l_inv_1_823.Y sg13cmos5l_inv_1_823.A 0.93333f
C3465 sg13cmos5l_inv_1_700.Y a_16256_10790# 0.03508f
C3466 sg13cmos5l_inv_1_296.A VPWR 0.63255f
C3467 sg13cmos5l_inv_1_466.Y a_5696_2514# 0.04341f
C3468 sg13cmos5l_inv_1_185.Y sg13cmos5l_mux4_1_2.X 0.01413f
C3469 sg13cmos5l_inv_1_411.Y sg13cmos5l_inv_1_340.Y 0.23875f
C3470 sg13cmos5l_mux4_1_5.S0 sg13cmos5l_inv_1_248.A 0.01127f
C3471 sg13cmos5l_inv_1_573.A sg13cmos5l_inv_1_566.A 0.17724f
C3472 sg13cmos5l_inv_1_69.A sg13cmos5l_inv_1_237.A 1.53768f
C3473 sg13cmos5l_inv_1_22.A VPWR 0.40998f
C3474 sg13cmos5l_inv_1_912.A sg13cmos5l_inv_1_915.A 0.20116f
C3475 sg13cmos5l_inv_1_565.Y sg13cmos5l_mux4_1_5.S0 0.62577f
C3476 sg13cmos5l_inv_1_815.A sg13cmos5l_inv_1_816.Y 0.19009f
C3477 sg13cmos5l_inv_1_234.A VPWR 0.41018f
C3478 sg13cmos5l_nand2_1_1.Y a_10162_9570# 0.09931f
C3479 sg13cmos5l_inv_1_311.Y sg13cmos5l_inv_1_297.Y 0.03875f
C3480 a_18088_1718# VPWR 0.13679f
C3481 sg13cmos5l_inv_1_120.Y VPWR 0.52912f
C3482 sg13cmos5l_mux4_1_11.A3 sg13cmos5l_inv_1_920.A 0.03143f
C3483 sg13cmos5l_mux4_1_5.S1 sg13cmos5l_inv_1_217.A 0.57869f
C3484 sg13cmos5l_inv_1_107.Y sg13cmos5l_inv_1_228.Y 0.01402f
C3485 sg13cmos5l_inv_1_90.Y sg13cmos5l_inv_1_82.Y 0.09144f
C3486 sg13cmos5l_buf_1_19.A sg13cmos5l_inv_1_723.Y 0.018f
C3487 a_8446_8434# a_9064_8562# 0.03326f
C3488 sg13cmos5l_inv_1_684.Y sg13cmos5l_inv_1_645.A 0.15548f
C3489 sg13cmos5l_inv_1_798.Y sg13cmos5l_inv_1_883.Y 0.01613f
C3490 sg13cmos5l_mux4_1_5.S1 sg13cmos5l_inv_1_400.Y 0.01935f
C3491 sg13cmos5l_inv_1_12.Y sg13cmos5l_inv_1_48.Y 0.24901f
C3492 sg13cmos5l_mux4_1_16.A2 a_8638_6558# 0.11736f
C3493 a_8327_6558# a_8756_6558# 0.0289f
C3494 sg13cmos5l_inv_1_694.A VPWR 0.49631f
C3495 sg13cmos5l_inv_1_110.A sg13cmos5l_inv_1_192.Y 0.04954f
C3496 sg13cmos5l_inv_1_283.A sg13cmos5l_inv_1_247.Y 0.03618f
C3497 sg13cmos5l_mux4_1_15.X sg13cmos5l_inv_1_699.A 0.08716f
C3498 a_3934_12606# a_4661_12221# 0.01228f
C3499 sg13cmos5l_buf_1_12.X sg13cmos5l_mux4_1_6.A2 0.01452f
C3500 sg13cmos5l_inv_1_321.A sg13cmos5l_inv_1_327.A 0.18242f
C3501 sg13cmos5l_inv_1_416.A sg13cmos5l_inv_1_441.A 0.35735f
C3502 sg13cmos5l_mux4_1_5.S0 sg13cmos5l_inv_1_285.Y 0.01451f
C3503 sg13cmos5l_inv_1_206.Y sg13cmos5l_inv_1_231.Y 0.01959f
C3504 sg13cmos5l_a21oi_1_0.B1 sg13cmos5l_inv_1_522.A 0.04812f
C3505 sg13cmos5l_inv_1_680.Y sg13cmos5l_inv_1_680.A 0.11944f
C3506 sg13cmos5l_inv_1_631.A sg13cmos5l_inv_1_632.A 0.20065f
C3507 sg13cmos5l_inv_1_791.A sg13cmos5l_inv_1_790.Y 0.03275f
C3508 a_2632_13098# VPWR 0.16383f
C3509 sg13cmos5l_buf_1_9.A sg13cmos5l_inv_1_519.Y 0.16177f
C3510 sg13cmos5l_inv_1_953.Y a_13288_9278# 0.02188f
C3511 sg13cmos5l_mux4_1_5.S1 sg13cmos5l_mux4_1_15.A2 0.03221f
C3512 a_14341_14749# a_13918_14482# 0.01929f
C3513 sg13cmos5l_buf_1_4.X a_18664_6956# 0.2906f
C3514 sg13cmos5l_inv_1_601.Y sg13cmos5l_inv_1_602.Y 0.20065f
C3515 sg13cmos5l_inv_1_809.Y sg13cmos5l_inv_1_810.Y 0.13493f
C3516 sg13cmos5l_inv_1_471.Y sg13cmos5l_inv_1_924.Y 0.01061f
C3517 sg13cmos5l_mux4_1_6.A2 sg13cmos5l_inv_1_378.Y 0.01419f
C3518 sg13cmos5l_inv_1_350.Y sg13cmos5l_inv_1_369.A 0.16187f
C3519 sg13cmos5l_inv_1_959.Y VPWR 0.67098f
C3520 sg13cmos5l_inv_1_734.A sg13cmos5l_inv_1_734.Y 0.20065f
C3521 sg13cmos5l_inv_1_152.Y sg13cmos5l_inv_1_150.A 0.1571f
C3522 sg13cmos5l_inv_1_478.Y a_6376_13098# 0.03352f
C3523 sg13cmos5l_inv_1_247.Y sg13cmos5l_inv_1_292.Y 0.04525f
C3524 sg13cmos5l_nor3_1_2.B a_14171_11488# 0.01227f
C3525 sg13cmos5l_mux4_1_5.S1 a_13607_3898# 0.60387f
C3526 sg13cmos5l_inv_1_334.A sg13cmos5l_inv_1_337.Y 0.0169f
C3527 sg13cmos5l_inv_1_272.A sg13cmos5l_inv_1_466.Y 0.03085f
C3528 sg13cmos5l_inv_1_308.Y sg13cmos5l_inv_1_442.Y 0.04671f
C3529 sg13cmos5l_inv_1_511.A a_1576_13814# 0.01986f
C3530 sg13cmos5l_inv_1_666.Y sg13cmos5l_inv_1_510.A 0.19511f
C3531 sg13cmos5l_mux4_1_9.A0 sg13cmos5l_inv_1_665.A 0.0464f
C3532 sg13cmos5l_inv_1_956.Y a_17312_9278# 0.05751f
C3533 sg13cmos5l_mux4_1_4.A2 VPWR 0.65241f
C3534 sg13cmos5l_inv_1_557.Y sg13cmos5l_inv_1_552.Y 0.12203f
C3535 sg13cmos5l_inv_1_459.A sg13cmos5l_inv_1_417.Y 0.01755f
C3536 a_9152_4026# VPWR 0.11658f
C3537 sg13cmos5l_inv_1_85.A sg13cmos5l_inv_1_89.Y 0.05172f
C3538 a_13918_12606# VPWR 0.91291f
C3539 sg13cmos5l_inv_1_450.Y sg13cmos5l_inv_1_419.A 0.10037f
C3540 sg13cmos5l_nand2_1_1.B a_9360_11832# 0.2633f
C3541 sg13cmos5l_buf_1_7.X sg13cmos5l_inv_1_326.Y 0.02124f
C3542 sg13cmos5l_inv_1_129.Y a_11944_7050# 0.01986f
C3543 sg13cmos5l_inv_1_828.Y sg13cmos5l_inv_1_775.A 0.08187f
C3544 sg13cmos5l_inv_1_680.Y a_1192_16122# 0.03694f
C3545 sg13cmos5l_inv_1_394.A sg13cmos5l_mux4_1_4.X 0.07239f
C3546 sg13cmos5l_mux4_1_14.A0 sg13cmos5l_inv_1_884.Y 0.02506f
C3547 a_13607_12606# a_13831_12267# 0.01074f
C3548 sg13cmos5l_inv_1_237.Y sg13cmos5l_inv_1_311.Y 0.49361f
C3549 sg13cmos5l_inv_1_851.A sg13cmos5l_inv_1_851.Y 0.18166f
C3550 sg13cmos5l_buf_1_9.A sg13cmos5l_inv_1_747.Y 0.83035f
C3551 sg13cmos5l_inv_1_535.Y sg13cmos5l_inv_1_560.A 0.10771f
C3552 sg13cmos5l_mux2_1_3.A0 sg13cmos5l_inv_1_105.A 0.01861f
C3553 sg13cmos5l_inv_1_106.Y VPWR 0.40903f
C3554 sg13cmos5l_nor3_1_2.B a_1192_13098# 0.03109f
C3555 sg13cmos5l_inv_1_807.A VPWR 0.43765f
C3556 sg13cmos5l_mux4_1_8.A2 a_7271_15994# 0.20775f
C3557 sg13cmos5l_inv_1_866.Y a_18664_16838# 0.03921f
C3558 a_6376_13098# VPWR 0.13973f
C3559 sg13cmos5l_inv_1_224.A sg13cmos5l_inv_1_228.Y 0.24661f
C3560 sg13cmos5l_inv_1_610.A a_5600_16838# 0.03508f
C3561 sg13cmos5l_inv_1_881.A sg13cmos5l_inv_1_876.A 0.01158f
C3562 sg13cmos5l_mux4_1_7.A3 sg13cmos5l_inv_1_654.Y 0.02358f
C3563 sg13cmos5l_inv_1_195.Y VPWR 0.42336f
C3564 sg13cmos5l_inv_1_514.A sg13cmos5l_nand2_1_1.B 0.01026f
C3565 sg13cmos5l_inv_1_171.Y sg13cmos5l_inv_1_179.A 0.02943f
C3566 sg13cmos5l_nor3_1_2.B sg13cmos5l_mux2_1_0.X 0.22824f
C3567 sg13cmos5l_mux4_1_5.S0 a_2248_3932# 0.28972f
C3568 sg13cmos5l_mux4_1_5.S0 a_8638_6558# 0.06199f
C3569 sg13cmos5l_mux4_1_5.S0 a_8086_15994# 0.0274f
C3570 sg13cmos5l_inv_1_243.A sg13cmos5l_inv_1_240.Y 0.20065f
C3571 sg13cmos5l_nand2_1_1.B sg13cmos5l_inv_1_926.A 0.01571f
C3572 sg13cmos5l_inv_1_264.A sg13cmos5l_inv_1_69.A 0.02714f
C3573 sg13cmos5l_mux4_1_12.A1 sg13cmos5l_inv_1_726.A 0.01263f
C3574 sg13cmos5l_inv_1_283.A VPWR 1.10237f
C3575 sg13cmos5l_inv_1_187.A VPWR 0.56471f
C3576 sg13cmos5l_mux4_1_8.A0 a_7582_15994# 0.0315f
C3577 sg13cmos5l_nor2b_1_0.B_N sg13cmos5l_inv_1_689.A 0.06491f
C3578 sg13cmos5l_inv_1_824.A sg13cmos5l_inv_1_836.Y 0.07466f
C3579 a_1664_11586# VPWR 0.07753f
C3580 sg13cmos5l_a22oi_1_0.A2 a_9004_12216# 0.01294f
C3581 sg13cmos5l_inv_1_350.Y sg13cmos5l_inv_1_974.Y 0.01221f
C3582 sg13cmos5l_inv_1_994.A sg13cmos5l_inv_1_957.Y 0.01007f
C3583 a_15275_7644# VPWR 0.70569f
C3584 sg13cmos5l_inv_1_14.A sg13cmos5l_inv_1_19.A 0.11191f
C3585 sg13cmos5l_inv_1_306.A sg13cmos5l_inv_1_453.Y 0.04154f
C3586 sg13cmos5l_buf_1_9.A a_15419_8040# 0.34239f
C3587 sg13cmos5l_inv_1_566.A VPWR 0.4689f
C3588 sg13cmos5l_o21ai_1_0.B1 sg13cmos5l_inv_1_523.Y 0.50865f
C3589 sg13cmos5l_inv_1_436.A a_3680_5538# 0.01252f
C3590 sg13cmos5l_inv_1_433.Y sg13cmos5l_inv_1_459.A 0.14888f
C3591 a_5005_16000# VPWR 0.12194f
C3592 a_3623_15994# a_4438_15994# 0.49917f
C3593 sg13cmos5l_mux4_1_14.A1 sg13cmos5l_inv_1_826.Y 0.16587f
C3594 sg13cmos5l_inv_1_301.A a_3488_1718# 0.04398f
C3595 sg13cmos5l_inv_1_989.A sg13cmos5l_inv_1_233.A 0.16468f
C3596 a_14989_3904# a_14913_3940# 0.26108f
C3597 sg13cmos5l_inv_1_482.Y a_6464_12302# 0.01086f
C3598 a_13472_12302# VPWR 0.07005f
C3599 sg13cmos5l_or2_1_0.B a_9160_11586# 0.06019f
C3600 sg13cmos5l_inv_1_929.A sg13cmos5l_inv_1_994.Y 0.01392f
C3601 sg13cmos5l_nor2b_1_0.A sg13cmos5l_inv_1_537.A 0.01047f
C3602 sg13cmos5l_inv_1_563.Y sg13cmos5l_a21oi_1_0.B1 0.01396f
C3603 sg13cmos5l_inv_1_306.A sg13cmos5l_inv_1_442.Y 0.35465f
C3604 sg13cmos5l_inv_1_220.A sg13cmos5l_inv_1_15.Y 0.01999f
C3605 sg13cmos5l_inv_1_120.A sg13cmos5l_mux4_1_5.S1 0.03225f
C3606 sg13cmos5l_inv_1_723.A sg13cmos5l_inv_1_723.Y 0.23035f
C3607 a_18280_18264# osc_tap[7] 0.2937f
C3608 sg13cmos5l_inv_1_159.A sg13cmos5l_inv_1_171.Y 0.10824f
C3609 sg13cmos5l_inv_1_394.Y sg13cmos5l_inv_1_384.Y 0.17306f
C3610 sg13cmos5l_inv_1_305.Y sg13cmos5l_inv_1_372.A 0.01883f
C3611 sg13cmos5l_inv_1_121.Y sg13cmos5l_inv_1_122.A 0.18711f
C3612 sg13cmos5l_inv_1_311.Y a_1480_1718# 0.02f
C3613 sg13cmos5l_inv_1_59.Y sg13cmos5l_inv_1_59.A 0.41053f
C3614 sg13cmos5l_inv_1_828.Y sg13cmos5l_inv_1_827.Y 0.11052f
C3615 VPWR invsel[2] 0.10716f
C3616 sg13cmos5l_mux4_1_14.A0 a_13831_14749# 0.01193f
C3617 sg13cmos5l_inv_1_58.A sg13cmos5l_inv_1_20.Y 0.19079f
C3618 sg13cmos5l_inv_1_545.Y a_800_17634# 0.01054f
C3619 sg13cmos5l_inv_1_576.A sg13cmos5l_inv_1_571.Y 0.08947f
C3620 sg13cmos5l_buf_1_0.A sg13cmos5l_inv_1_217.A 0.60772f
C3621 sg13cmos5l_mux4_1_8.A1 a_8577_16036# 0.01623f
C3622 sg13cmos5l_mux4_1_11.A3 sg13cmos5l_inv_1_879.A 0.03752f
C3623 sg13cmos5l_inv_1_16.Y sg13cmos5l_inv_1_0.A 0.09584f
C3624 sg13cmos5l_buf_1_9.A sg13cmos5l_mux4_1_6.A2 0.14458f
C3625 sg13cmos5l_inv_1_649.Y sg13cmos5l_inv_1_648.Y 0.22856f
C3626 sg13cmos5l_inv_1_106.A sg13cmos5l_inv_1_217.A 0.03817f
C3627 sg13cmos5l_buf_1_0.A sg13cmos5l_inv_1_17.A 0.03847f
C3628 sg13cmos5l_mux4_1_5.S1 sg13cmos5l_inv_1_340.Y 0.05622f
C3629 sg13cmos5l_inv_1_168.A a_18856_7680# 0.0301f
C3630 sg13cmos5l_inv_1_320.Y sg13cmos5l_inv_1_328.Y 0.07734f
C3631 sg13cmos5l_inv_1_717.A sg13cmos5l_inv_1_716.A 0.18584f
C3632 sg13cmos5l_inv_1_292.Y VPWR 0.45564f
C3633 sg13cmos5l_buf_1_8.A sg13cmos5l_inv_1_961.Y 0.11288f
C3634 a_9256_18350# a_9440_18350# 0.11523f
C3635 sg13cmos5l_inv_1_305.Y a_808_1632# 0.02711f
C3636 sg13cmos5l_inv_1_77.Y sg13cmos5l_inv_1_76.A 0.02112f
C3637 sg13cmos5l_inv_1_271.A a_9832_4026# 0.07409f
C3638 sg13cmos5l_inv_1_14.A sg13cmos5l_inv_1_22.Y 0.01244f
C3639 sg13cmos5l_inv_1_260.A sg13cmos5l_inv_1_273.Y 0.09654f
C3640 sg13cmos5l_inv_1_78.A sg13cmos5l_inv_1_110.A 0.1198f
C3641 a_17312_9278# VPWR 0.08176f
C3642 a_13288_6254# a_13472_6254# 0.11523f
C3643 sg13cmos5l_inv_1_552.Y VPWR 0.36598f
C3644 sg13cmos5l_inv_1_55.Y a_17312_3230# 0.04511f
C3645 sg13cmos5l_inv_1_115.A sg13cmos5l_inv_1_118.Y 0.11813f
C3646 sg13cmos5l_inv_1_632.A sg13cmos5l_inv_1_672.A 0.02072f
C3647 sg13cmos5l_inv_1_228.Y VPWR 0.47442f
C3648 sg13cmos5l_inv_1_838.Y sg13cmos5l_inv_1_823.A 0.19855f
C3649 sg13cmos5l_buf_1_9.A a_7271_15994# 0.02453f
C3650 a_808_4656# invsel[1] 0.32955f
C3651 sg13cmos5l_inv_1_295.A VPWR 0.64106f
C3652 sg13cmos5l_mux4_1_10.A2 a_4438_15994# 0.01807f
C3653 sg13cmos5l_inv_1_884.Y VPWR 0.8546f
C3654 sg13cmos5l_inv_1_752.A sg13cmos5l_inv_1_748.A 0.01322f
C3655 sg13cmos5l_inv_1_357.A sg13cmos5l_inv_1_340.Y 0.01442f
C3656 a_4929_16036# VPWR 0.70701f
C3657 sg13cmos5l_mux2_1_3.X sg13cmos5l_mux4_1_5.S1 0.02796f
C3658 sg13cmos5l_inv_1_431.A sg13cmos5l_inv_1_422.A 0.01618f
C3659 sg13cmos5l_inv_1_100.A sg13cmos5l_inv_1_85.A 0.3392f
C3660 sg13cmos5l_inv_1_565.Y sg13cmos5l_inv_1_537.Y 0.09626f
C3661 sg13cmos5l_inv_1_815.A sg13cmos5l_inv_1_816.A 0.0282f
C3662 sg13cmos5l_o21ai_1_0.B1 sg13cmos5l_inv_1_515.A 0.21179f
C3663 sg13cmos5l_inv_1_233.A VPWR 0.44074f
C3664 sg13cmos5l_mux2_1_3.X a_10162_9570# 0.12457f
C3665 sg13cmos5l_inv_1_537.A a_2152_15326# 0.03747f
C3666 sg13cmos5l_buf_1_8.A sg13cmos5l_inv_1_266.Y 0.02465f
C3667 sg13cmos5l_inv_1_723.Y VPWR 0.43759f
C3668 sg13cmos5l_inv_1_122.A VPWR 0.42807f
C3669 sg13cmos5l_inv_1_368.Y sg13cmos5l_inv_1_364.A 0.21202f
C3670 sg13cmos5l_inv_1_584.A sg13cmos5l_inv_1_582.A 0.48665f
C3671 a_13288_16122# VPWR 0.1312f
C3672 sg13cmos5l_inv_1_532.A a_4475_13008# 0.01436f
C3673 a_1006_15296# sg13cmos5l_o21ai_1_0.B1 0.28333f
C3674 sg13cmos5l_inv_1_633.A sg13cmos5l_inv_1_645.A 0.18922f
C3675 sg13cmos5l_mux4_1_5.S1 sg13cmos5l_inv_1_399.Y 0.01191f
C3676 a_7912_11586# sg13cmos5l_inv_1_494.Y 0.01078f
C3677 sg13cmos5l_inv_1_1000.Y VPWR 0.59923f
C3678 sg13cmos5l_inv_1_584.A sg13cmos5l_inv_1_625.Y 0.8994f
C3679 sg13cmos5l_inv_1_283.A sg13cmos5l_inv_1_290.Y 0.0703f
C3680 sg13cmos5l_inv_1_534.Y sg13cmos5l_inv_1_623.Y 0.04312f
C3681 sg13cmos5l_mux4_1_5.S1 a_9709_6442# 0.35031f
C3682 sg13cmos5l_inv_1_452.Y a_5408_4742# 0.01076f
C3683 sg13cmos5l_inv_1_416.A sg13cmos5l_inv_1_440.A 0.05443f
C3684 sg13cmos5l_mux4_1_7.A1 sg13cmos5l_mux4_1_7.A2 0.63729f
C3685 a_14827_11673# sg13cmos5l_inv_1_704.Y 0.0453f
C3686 sg13cmos5l_mux4_1_5.S1 a_4438_3534# 0.0411f
C3687 a_4264_13098# VPWR 0.14368f
C3688 sg13cmos5l_inv_1_533.Y a_3934_15994# 0.05243f
C3689 sg13cmos5l_inv_1_762.Y a_12808_12302# 0.0347f
C3690 sg13cmos5l_buf_1_2.X a_18856_3932# 0.33093f
C3691 sg13cmos5l_mux4_1_5.S0 sg13cmos5l_inv_1_287.Y 0.0167f
C3692 sg13cmos5l_inv_1_883.A a_12896_15326# 0.01057f
C3693 sg13cmos5l_mux4_1_14.A3 sg13cmos5l_inv_1_892.A 0.10878f
C3694 sg13cmos5l_mux4_1_5.S0 sg13cmos5l_mux4_1_5.X 2.30059f
C3695 sg13cmos5l_inv_1_322.A VPWR 0.68873f
C3696 sg13cmos5l_buf_1_9.A a_14494_9582# 0.03727f
C3697 sg13cmos5l_inv_1_809.Y sg13cmos5l_inv_1_811.Y 0.01189f
C3698 a_13831_14749# VPWR 0.02431f
C3699 sg13cmos5l_inv_1_149.Y sg13cmos5l_inv_1_206.Y 0.01021f
C3700 sg13cmos5l_inv_1_116.Y sg13cmos5l_inv_1_169.Y 0.04884f
C3701 sg13cmos5l_mux4_1_5.S1 a_14422_3898# 0.02671f
C3702 sg13cmos5l_inv_1_533.A sg13cmos5l_inv_1_683.Y 0.12613f
C3703 sg13cmos5l_nor2b_1_0.B_N a_808_16028# 0.06187f
C3704 sg13cmos5l_mux2_1_3.S sg13cmos5l_inv_1_397.Y 0.01625f
C3705 sg13cmos5l_inv_1_401.Y sg13cmos5l_inv_1_386.Y 0.11092f
C3706 sg13cmos5l_inv_1_149.A sg13cmos5l_inv_1_174.A 0.1118f
C3707 sg13cmos5l_mux2_1_0.X sg13cmos5l_mux4_1_2.A2 0.02938f
C3708 a_19048_3230# osc_tap[0] 0.01476f
C3709 sg13cmos5l_inv_1_78.A sg13cmos5l_inv_1_235.Y 0.18554f
C3710 sg13cmos5l_inv_1_317.Y a_1480_4026# 0.01986f
C3711 sg13cmos5l_buf_1_19.A VPWR 0.74902f
C3712 sg13cmos5l_inv_1_334.A sg13cmos5l_inv_1_316.A 0.04136f
C3713 sg13cmos5l_mux4_1_5.S1 sg13cmos5l_mux4_1_6.X 0.76873f
C3714 sg13cmos5l_inv_1_272.A sg13cmos5l_inv_1_325.Y 0.04686f
C3715 sg13cmos5l_inv_1_308.Y sg13cmos5l_inv_1_442.A 0.03735f
C3716 sg13cmos5l_inv_1_511.A sg13cmos5l_inv_1_510.A 0.0698f
C3717 a_9360_11832# sg13cmos5l_or2_1_0.X 0.16641f
C3718 sg13cmos5l_inv_1_708.A sg13cmos5l_buf_1_19.A 0.01496f
C3719 sg13cmos5l_buf_1_8.A sg13cmos5l_inv_1_75.A 0.5502f
C3720 sg13cmos5l_inv_1_393.A sg13cmos5l_inv_1_382.Y 0.02699f
C3721 sg13cmos5l_inv_1_970.A VPWR 0.42917f
C3722 sg13cmos5l_inv_1_564.Y sg13cmos5l_inv_1_552.Y 0.15541f
C3723 sg13cmos5l_inv_1_564.A sg13cmos5l_inv_1_551.Y 0.01836f
C3724 sg13cmos5l_inv_1_88.Y VPWR 0.40845f
C3725 sg13cmos5l_or2_1_0.B a_9360_11832# 0.14381f
C3726 sg13cmos5l_inv_1_129.Y sg13cmos5l_inv_1_111.A 0.06963f
C3727 sg13cmos5l_mux4_1_14.A0 sg13cmos5l_inv_1_916.A 0.01256f
C3728 a_5896_3230# VPWR 0.13772f
C3729 sg13cmos5l_inv_1_267.Y sg13cmos5l_inv_1_311.Y 0.1261f
C3730 sg13cmos5l_inv_1_851.A sg13cmos5l_inv_1_853.Y 0.06749f
C3731 sg13cmos5l_o21ai_1_0.B1 sg13cmos5l_inv_1_467.Y 0.09124f
C3732 sg13cmos5l_inv_1_107.Y VPWR 0.4351f
C3733 sg13cmos5l_mux4_1_5.S1 a_4929_3492# 0.21908f
C3734 sg13cmos5l_inv_1_519.Y sg13cmos5l_inv_1_518.Y 0.57532f
C3735 sg13cmos5l_inv_1_866.Y sg13cmos5l_buf_1_23.X 0.07838f
C3736 sg13cmos5l_inv_1_88.A sg13cmos5l_inv_1_88.Y 0.21211f
C3737 sg13cmos5l_inv_1_205.Y VPWR 0.43433f
C3738 sg13cmos5l_inv_1_113.A a_14494_9582# 0.01797f
C3739 sg13cmos5l_inv_1_744.Y sg13cmos5l_inv_1_758.A 0.96496f
C3740 sg13cmos5l_inv_1_753.A sg13cmos5l_inv_1_752.A 0.15144f
C3741 sg13cmos5l_inv_1_202.Y sg13cmos5l_inv_1_162.A 0.01517f
C3742 a_15489_9540# VPWR 0.70602f
C3743 sg13cmos5l_nor3_1_2.B sg13cmos5l_o21ai_1_0.Y 0.01317f
C3744 sg13cmos5l_mux4_1_8.A0 sg13cmos5l_inv_1_797.Y 0.01107f
C3745 sg13cmos5l_inv_1_743.Y sg13cmos5l_inv_1_751.A 0.02413f
C3746 sg13cmos5l_mux4_1_10.A3 a_3934_15994# 0.1681f
C3747 sg13cmos5l_inv_1_862.A sg13cmos5l_inv_1_815.A 0.01554f
C3748 sg13cmos5l_inv_1_387.Y sg13cmos5l_inv_1_409.Y 0.2023f
C3749 a_7981_12976# a_7414_12970# 0.40359f
C3750 a_6823_13237# a_6910_12970# 0.02548f
C3751 sg13cmos5l_nor2b_1_0.B_N sg13cmos5l_a21oi_1_0.B1 0.1173f
C3752 sg13cmos5l_inv_1_25.Y VPWR 0.53018f
C3753 sg13cmos5l_mux4_1_1.A3 sg13cmos5l_inv_1_16.A 0.03168f
C3754 sg13cmos5l_inv_1_824.A sg13cmos5l_inv_1_848.Y 0.04354f
C3755 sg13cmos5l_inv_1_994.A sg13cmos5l_inv_1_942.Y 0.01341f
C3756 sg13cmos5l_inv_1_716.A a_16744_10074# 0.01059f
C3757 sg13cmos5l_inv_1_950.A VPWR 0.57921f
C3758 sg13cmos5l_inv_1_350.Y sg13cmos5l_inv_1_974.A 0.23063f
C3759 sg13cmos5l_mux4_1_13.A3 a_14710_15630# 0.2285f
C3760 sg13cmos5l_inv_1_304.A sg13cmos5l_inv_1_453.Y 0.01226f
C3761 sg13cmos5l_inv_1_306.A sg13cmos5l_inv_1_256.A 0.30872f
C3762 sg13cmos5l_inv_1_130.A VPWR 0.58237f
C3763 sg13cmos5l_buf_1_0.A sg13cmos5l_inv_1_16.A 0.01143f
C3764 sg13cmos5l_inv_1_573.A VPWR 0.45884f
C3765 sg13cmos5l_mux4_1_6.A2 sg13cmos5l_inv_1_421.A 0.03079f
C3766 sg13cmos5l_inv_1_48.Y a_15016_2514# 0.0199f
C3767 sg13cmos5l_inv_1_929.A sg13cmos5l_inv_1_928.A 0.18681f
C3768 sg13cmos5l_nor2b_1_0.A sg13cmos5l_inv_1_689.A 0.01129f
C3769 sg13cmos5l_inv_1_304.A sg13cmos5l_inv_1_442.Y 0.04385f
C3770 sg13cmos5l_inv_1_6.Y sg13cmos5l_inv_1_0.A 0.109f
C3771 sg13cmos5l_inv_1_306.A sg13cmos5l_inv_1_442.A 0.04777f
C3772 a_8577_3492# VPWR 0.71104f
C3773 sg13cmos5l_inv_1_76.A a_14913_3940# 0.01122f
C3774 sg13cmos5l_mux4_1_5.S0 sg13cmos5l_mux4_1_4.A2 0.19176f
C3775 sg13cmos5l_inv_1_721.A sg13cmos5l_inv_1_723.Y 0.09848f
C3776 sg13cmos5l_inv_1_834.Y osc_tap[7] 0.01182f
C3777 sg13cmos5l_inv_1_237.Y sg13cmos5l_inv_1_277.Y 0.29942f
C3778 sg13cmos5l_inv_1_159.A sg13cmos5l_inv_1_161.Y 0.02026f
C3779 sg13cmos5l_inv_1_166.A sg13cmos5l_inv_1_171.Y 0.06496f
C3780 sg13cmos5l_inv_1_494.Y a_8200_10790# 0.03488f
C3781 VPWR osc_tap[2] 0.14206f
C3782 sg13cmos5l_inv_1_576.A sg13cmos5l_inv_1_549.A 0.10318f
C3783 sg13cmos5l_inv_1_58.A sg13cmos5l_inv_1_56.Y 0.25251f
C3784 sg13cmos5l_inv_1_546.Y sg13cmos5l_inv_1_541.A 0.01055f
C3785 sg13cmos5l_mux4_1_11.A3 sg13cmos5l_inv_1_878.A 0.18289f
C3786 sg13cmos5l_buf_1_17.X sg13cmos5l_mux4_1_12.A1 0.05305f
C3787 sg13cmos5l_inv_1_16.Y sg13cmos5l_inv_1_8.Y 0.0305f
C3788 sg13cmos5l_buf_1_0.A sg13cmos5l_inv_1_220.Y 0.05274f
C3789 sg13cmos5l_inv_1_809.Y sg13cmos5l_inv_1_890.A 0.16406f
C3790 sg13cmos5l_buf_1_8.A sg13cmos5l_inv_1_930.A 0.0148f
C3791 sg13cmos5l_nor3_1_1.A sg13cmos5l_nor3_1_1.Y 0.3697f
C3792 sg13cmos5l_mux4_1_14.A0 VPWR 0.67598f
C3793 sg13cmos5l_inv_1_247.Y VPWR 0.41763f
C3794 sg13cmos5l_mux4_1_5.S0 a_6376_13098# 0.04424f
C3795 sg13cmos5l_inv_1_78.A sg13cmos5l_inv_1_109.Y 0.07963f
C3796 sg13cmos5l_inv_1_14.A sg13cmos5l_inv_1_16.Y 0.02845f
C3797 sg13cmos5l_nand2_1_1.B sg13cmos5l_inv_1_507.Y 0.07563f
C3798 sg13cmos5l_inv_1_956.Y VPWR 0.41766f
C3799 sg13cmos5l_inv_1_557.Y VPWR 0.61548f
C3800 sg13cmos5l_inv_1_274.Y a_6952_2514# 0.01986f
C3801 sg13cmos5l_mux2_1_3.S sg13cmos5l_buf_1_12.X 0.61821f
C3802 sg13cmos5l_inv_1_985.Y a_3488_9278# 0.04512f
C3803 sg13cmos5l_inv_1_632.A sg13cmos5l_inv_1_672.Y 0.01522f
C3804 sg13cmos5l_inv_1_224.A VPWR 0.48184f
C3805 sg13cmos5l_inv_1_761.A sg13cmos5l_inv_1_756.Y 0.04869f
C3806 a_15419_8040# sg13cmos5l_inv_1_179.A 0.01481f
C3807 sg13cmos5l_inv_1_830.A sg13cmos5l_inv_1_823.A 0.01314f
C3808 a_7414_12970# a_7905_13012# 0.3824f
C3809 a_6176_16122# VPWR 0.08077f
C3810 sg13cmos5l_inv_1_700.Y sg13cmos5l_inv_1_701.A 0.01747f
C3811 sg13cmos5l_buf_1_9.A sg13cmos5l_inv_1_619.Y 0.04745f
C3812 sg13cmos5l_inv_1_274.Y sg13cmos5l_inv_1_258.A 0.41194f
C3813 sg13cmos5l_inv_1_515.Y a_1664_11586# 0.01083f
C3814 sg13cmos5l_inv_1_916.A VPWR 0.67206f
C3815 sg13cmos5l_inv_1_752.A sg13cmos5l_inv_1_736.Y 0.01463f
C3816 sg13cmos5l_inv_1_140.A sg13cmos5l_inv_1_130.A 0.21854f
C3817 sg13cmos5l_inv_1_572.A sg13cmos5l_inv_1_573.A 0.18711f
C3818 sg13cmos5l_mux4_1_5.S0 sg13cmos5l_inv_1_283.A 0.03658f
C3819 sg13cmos5l_inv_1_911.A sg13cmos5l_inv_1_912.A 0.20737f
C3820 sg13cmos5l_inv_1_736.Y a_10880_10790# 0.01054f
C3821 sg13cmos5l_o21ai_1_0.B1 a_2152_10790# 0.01107f
C3822 sg13cmos5l_inv_1_118.A a_13288_7766# 0.04573f
C3823 sg13cmos5l_inv_1_989.A VPWR 0.46246f
C3824 a_3304_16122# a_3488_16122# 0.11523f
C3825 sg13cmos5l_inv_1_874.Y a_13895_15630# 0.2837f
C3826 sg13cmos5l_inv_1_689.A a_2152_15326# 0.01986f
C3827 sg13cmos5l_inv_1_723.A VPWR 0.35165f
C3828 sg13cmos5l_inv_1_121.Y VPWR 0.4444f
C3829 a_13472_17634# VPWR 0.06555f
C3830 sg13cmos5l_mux2_1_3.A0 a_15016_7766# 0.03605f
C3831 sg13cmos5l_inv_1_875.Y VPWR 0.50616f
C3832 sg13cmos5l_inv_1_519.Y a_4475_13008# 0.01203f
C3833 sg13cmos5l_buf_1_0.A sg13cmos5l_inv_1_85.Y 0.05367f
C3834 a_13472_1718# VPWR 0.06635f
C3835 a_14360_11776# VPWR 0.02988f
C3836 sg13cmos5l_inv_1_362.A sg13cmos5l_inv_1_305.Y 0.03236f
C3837 sg13cmos5l_inv_1_534.Y sg13cmos5l_inv_1_624.Y 0.02123f
C3838 sg13cmos5l_inv_1_328.Y sg13cmos5l_inv_1_327.A 0.03901f
C3839 sg13cmos5l_inv_1_213.Y a_19136_4742# 0.03571f
C3840 sg13cmos5l_inv_1_452.Y sg13cmos5l_inv_1_417.Y 0.20059f
C3841 sg13cmos5l_inv_1_416.A sg13cmos5l_inv_1_430.A 0.02831f
C3842 sg13cmos5l_inv_1_535.A sg13cmos5l_inv_1_534.A 0.0404f
C3843 sg13cmos5l_inv_1_266.Y a_5408_4742# 0.03465f
C3844 a_14998_9582# a_14494_9582# 0.97548f
C3845 a_14827_11673# sg13cmos5l_mux4_1_15.X 0.23745f
C3846 sg13cmos5l_inv_1_858.Y sg13cmos5l_inv_1_862.A 0.01844f
C3847 sg13cmos5l_inv_1_478.Y VPWR 0.44266f
C3848 sg13cmos5l_inv_1_301.A sg13cmos5l_inv_1_304.A 0.02228f
C3849 sg13cmos5l_inv_1_762.Y sg13cmos5l_inv_1_733.A 0.26947f
C3850 sg13cmos5l_mux4_1_14.A3 sg13cmos5l_mux4_1_11.A1 0.22562f
C3851 a_6119_8434# sg13cmos5l_inv_1_402.A 0.24346f
C3852 sg13cmos5l_inv_1_225.Y sg13cmos5l_inv_1_222.Y 0.08501f
C3853 sg13cmos5l_inv_1_631.Y sg13cmos5l_inv_1_631.A 0.20065f
C3854 sg13cmos5l_inv_1_525.A VPWR 1.1106f
C3855 sg13cmos5l_mux4_1_5.S1 a_14183_9582# 0.51234f
C3856 a_5984_11586# VPWR 0.07666f
C3857 sg13cmos5l_mux4_1_14.A3 a_13918_14482# 0.16389f
C3858 sg13cmos5l_inv_1_604.Y sg13cmos5l_inv_1_601.Y 0.20065f
C3859 sg13cmos5l_inv_1_878.A sg13cmos5l_inv_1_913.A 0.0913f
C3860 sg13cmos5l_inv_1_1007.Y sg13cmos5l_inv_1_924.Y 0.265f
C3861 sg13cmos5l_inv_1_70.Y a_10696_1718# 0.02074f
C3862 sg13cmos5l_mux4_1_6.A2 a_4438_8070# 0.01449f
C3863 sg13cmos5l_mux2_1_4.S sg13cmos5l_inv_1_744.Y 0.13501f
C3864 sg13cmos5l_inv_1_403.Y sg13cmos5l_inv_1_386.Y 0.01668f
C3865 sg13cmos5l_inv_1_401.Y sg13cmos5l_inv_1_381.Y 0.04103f
C3866 sg13cmos5l_inv_1_412.A sg13cmos5l_inv_1_411.A 0.19028f
C3867 sg13cmos5l_mux4_1_5.S0 a_4929_16036# 0.01307f
C3868 sg13cmos5l_inv_1_149.A sg13cmos5l_inv_1_150.A 0.13566f
C3869 sg13cmos5l_inv_1_78.A sg13cmos5l_inv_1_235.A 0.02828f
C3870 sg13cmos5l_inv_1_334.A sg13cmos5l_inv_1_314.Y 0.03957f
C3871 sg13cmos5l_inv_1_708.A VPWR 0.45385f
C3872 sg13cmos5l_mux4_1_5.S1 sg13cmos5l_mux4_1_4.X 0.08527f
C3873 sg13cmos5l_inv_1_272.A sg13cmos5l_inv_1_325.A 0.32528f
C3874 sg13cmos5l_inv_1_308.Y sg13cmos5l_inv_1_300.Y 0.0261f
C3875 sg13cmos5l_mux2_1_1.X sg13cmos5l_inv_1_394.A 0.21418f
C3876 sg13cmos5l_buf_1_9.A sg13cmos5l_mux4_1_7.A2 0.03742f
C3877 a_13607_3898# a_13831_4165# 0.01074f
C3878 sg13cmos5l_inv_1_564.Y sg13cmos5l_inv_1_557.Y 0.04183f
C3879 sg13cmos5l_inv_1_564.A sg13cmos5l_inv_1_552.Y 0.29952f
C3880 sg13cmos5l_inv_1_433.Y sg13cmos5l_inv_1_452.Y 0.0219f
C3881 sg13cmos5l_inv_1_88.A VPWR 0.53338f
C3882 sg13cmos5l_inv_1_439.A sg13cmos5l_inv_1_419.A 0.16529f
C3883 sg13cmos5l_nor3_1_2.B a_4798_12970# 0.13123f
C3884 a_808_16028# sg13cmos5l_nor2b_1_0.A 0.28803f
C3885 sg13cmos5l_inv_1_237.Y sg13cmos5l_inv_1_318.Y 0.24024f
C3886 sg13cmos5l_inv_1_267.Y sg13cmos5l_inv_1_410.Y 0.03027f
C3887 sg13cmos5l_inv_1_851.A sg13cmos5l_inv_1_854.Y 0.01447f
C3888 sg13cmos5l_inv_1_881.A a_17512_14610# 0.02074f
C3889 sg13cmos5l_o21ai_1_0.B1 sg13cmos5l_inv_1_467.A 0.01399f
C3890 sg13cmos5l_inv_1_610.Y sg13cmos5l_inv_1_560.A 0.09846f
C3891 sg13cmos5l_inv_1_142.A a_18368_6254# 0.0351f
C3892 sg13cmos5l_inv_1_758.A sg13cmos5l_mux4_1_12.A3 0.26143f
C3893 sg13cmos5l_mux4_1_12.A3 sg13cmos5l_inv_1_762.Y 0.29929f
C3894 sg13cmos5l_mux4_1_8.A1 a_7271_15994# 0.20787f
C3895 sg13cmos5l_buf_1_8.A sg13cmos5l_inv_1_431.A 0.16076f
C3896 sg13cmos5l_inv_1_218.A sg13cmos5l_inv_1_228.Y 0.01122f
C3897 sg13cmos5l_a22oi_1_0.A2 VPWR 0.50137f
C3898 sg13cmos5l_inv_1_880.A sg13cmos5l_inv_1_881.A 0.2023f
C3899 sg13cmos5l_inv_1_744.Y sg13cmos5l_inv_1_739.A 0.02954f
C3900 sg13cmos5l_mux2_1_4.S a_15608_7680# 0.02977f
C3901 a_15201_15588# VPWR 0.71578f
C3902 sg13cmos5l_inv_1_237.Y a_5032_6254# 0.05082f
C3903 sg13cmos5l_nor3_1_2.B sg13cmos5l_nor3_1_1.Y 0.07255f
C3904 sg13cmos5l_inv_1_645.Y a_5984_13814# 0.01162f
C3905 sg13cmos5l_mux4_1_8.A0 sg13cmos5l_inv_1_797.A 0.05529f
C3906 sg13cmos5l_mux4_1_5.S0 sg13cmos5l_inv_1_322.A 0.36894f
C3907 a_808_13004# VPWR 0.25853f
C3908 sg13cmos5l_inv_1_273.Y sg13cmos5l_inv_1_243.A 0.03779f
C3909 sg13cmos5l_inv_1_191.A sg13cmos5l_inv_1_235.Y 0.02564f
C3910 sg13cmos5l_inv_1_191.Y sg13cmos5l_inv_1_235.A 0.02027f
C3911 a_15768_4088# a_15834_4192# 0.03336f
C3912 sg13cmos5l_mux4_1_1.A3 sg13cmos5l_inv_1_55.Y 0.08868f
C3913 a_13799_3534# a_14023_3195# 0.01074f
C3914 sg13cmos5l_inv_1_517.A VPWR 0.52241f
C3915 sg13cmos5l_inv_1_847.Y sg13cmos5l_mux4_1_11.A3 0.01601f
C3916 sg13cmos5l_inv_1_304.A sg13cmos5l_inv_1_256.A 0.20695f
C3917 sg13cmos5l_inv_1_572.A VPWR 0.42382f
C3918 sg13cmos5l_inv_1_140.A VPWR 0.49674f
C3919 sg13cmos5l_mux4_1_6.A2 sg13cmos5l_inv_1_344.A 0.01081f
C3920 sg13cmos5l_mux4_1_12.A1 a_13918_12606# 0.15668f
C3921 a_15584_12302# VPWR 0.07614f
C3922 sg13cmos5l_inv_1_780.A sg13cmos5l_inv_1_826.Y 0.01454f
C3923 sg13cmos5l_inv_1_48.Y sg13cmos5l_inv_1_220.A 0.06737f
C3924 sg13cmos5l_inv_1_12.Y a_15016_2514# 0.03352f
C3925 a_4736_10074# VPWR 0.08856f
C3926 sg13cmos5l_inv_1_448.A sg13cmos5l_inv_1_989.A 0.1526f
C3927 sg13cmos5l_inv_1_815.A a_17512_14610# 0.01193f
C3928 sg13cmos5l_buf_1_8.A a_14171_11488# 0.3622f
C3929 a_8968_9278# a_9152_9278# 0.11523f
C3930 a_9982_8050# VPWR 0.11743f
C3931 a_9142_6558# a_8638_6558# 0.97548f
C3932 a_15277_15514# sg13cmos5l_mux4_1_11.A3 0.0139f
C3933 sg13cmos5l_nor2b_1_0.A sg13cmos5l_a21oi_1_0.B1 0.26873f
C3934 sg13cmos5l_inv_1_306.A sg13cmos5l_inv_1_300.Y 0.01627f
C3935 sg13cmos5l_inv_1_6.Y sg13cmos5l_inv_1_8.Y 0.05526f
C3936 sg13cmos5l_mux4_1_5.S1 sg13cmos5l_inv_1_274.Y 0.248f
C3937 sg13cmos5l_inv_1_920.A sg13cmos5l_inv_1_881.A 0.23068f
C3938 sg13cmos5l_mux4_1_5.S0 sg13cmos5l_inv_1_970.A 0.08618f
C3939 sg13cmos5l_inv_1_237.Y sg13cmos5l_inv_1_277.A 0.03645f
C3940 sg13cmos5l_inv_1_721.A sg13cmos5l_inv_1_723.A 0.02206f
C3941 sg13cmos5l_inv_1_166.A sg13cmos5l_inv_1_161.Y 0.01792f
C3942 sg13cmos5l_inv_1_159.A sg13cmos5l_inv_1_163.Y 0.02026f
C3943 sg13cmos5l_inv_1_311.Y sg13cmos5l_inv_1_309.Y 0.01869f
C3944 a_7582_15994# a_8086_15994# 0.97548f
C3945 VPWR osc_tap[3] 0.12787f
C3946 sg13cmos5l_mux2_1_2.A0 sg13cmos5l_mux4_1_9.A0 0.0147f
C3947 sg13cmos5l_inv_1_60.Y sg13cmos5l_inv_1_56.Y 0.16939f
C3948 sg13cmos5l_buf_1_0.A sg13cmos5l_inv_1_59.Y 0.16197f
C3949 sg13cmos5l_inv_1_650.Y sg13cmos5l_inv_1_649.Y 0.20535f
C3950 sg13cmos5l_buf_1_0.A sg13cmos5l_inv_1_58.Y 0.03154f
C3951 sg13cmos5l_inv_1_809.Y sg13cmos5l_inv_1_808.A 0.28211f
C3952 sg13cmos5l_inv_1_283.A sg13cmos5l_inv_1_257.A 0.01176f
C3953 sg13cmos5l_inv_1_815.Y sg13cmos5l_inv_1_875.Y 0.24769f
C3954 sg13cmos5l_inv_1_774.Y sg13cmos5l_inv_1_775.Y 0.09475f
C3955 sg13cmos5l_inv_1_290.Y VPWR 0.52632f
C3956 sg13cmos5l_buf_1_8.A sg13cmos5l_inv_1_931.A 0.06145f
C3957 sg13cmos5l_a21oi_1_1.A2 VPWR 1.22629f
C3958 sg13cmos5l_buf_1_8.A sg13cmos5l_inv_1_337.Y 0.0468f
C3959 sg13cmos5l_inv_1_606.Y a_9440_18350# 0.01083f
C3960 sg13cmos5l_inv_1_99.Y sg13cmos5l_inv_1_77.Y 0.20978f
C3961 sg13cmos5l_inv_1_75.A sg13cmos5l_inv_1_76.A 0.22588f
C3962 sg13cmos5l_inv_1_260.A sg13cmos5l_inv_1_250.Y 0.1329f
C3963 sg13cmos5l_inv_1_17.A sg13cmos5l_inv_1_22.Y 0.0114f
C3964 sg13cmos5l_inv_1_17.Y sg13cmos5l_inv_1_16.Y 0.0338f
C3965 sg13cmos5l_inv_1_149.Y sg13cmos5l_inv_1_148.Y 0.1403f
C3966 sg13cmos5l_inv_1_564.Y VPWR 0.55365f
C3967 a_4438_12606# a_3934_12606# 0.97548f
C3968 sg13cmos5l_inv_1_274.Y sg13cmos5l_inv_1_306.A 0.014f
C3969 sg13cmos5l_inv_1_179.A sg13cmos5l_inv_1_182.A 0.1563f
C3970 sg13cmos5l_mux4_1_5.S1 sg13cmos5l_inv_1_447.A 0.026f
C3971 sg13cmos5l_inv_1_236.A VPWR 0.34136f
C3972 sg13cmos5l_buf_1_8.A sg13cmos5l_mux2_1_0.X 0.09161f
C3973 sg13cmos5l_inv_1_69.A sg13cmos5l_inv_1_287.A 0.20194f
C3974 sg13cmos5l_inv_1_121.Y sg13cmos5l_mux4_1_16.A2 0.0137f
C3975 sg13cmos5l_inv_1_768.A VPWR 0.43688f
C3976 sg13cmos5l_inv_1_348.Y sg13cmos5l_inv_1_347.Y 0.17047f
C3977 a_2912_12302# VPWR 0.12335f
C3978 sg13cmos5l_inv_1_751.A sg13cmos5l_inv_1_736.Y 0.01109f
C3979 sg13cmos5l_inv_1_69.A sg13cmos5l_inv_1_249.Y 0.05756f
C3980 sg13cmos5l_buf_1_12.X a_9064_8562# 0.01909f
C3981 sg13cmos5l_o21ai_1_0.B1 sg13cmos5l_inv_1_504.Y 0.07701f
C3982 a_18856_14516# osc_tap[5] 0.28827f
C3983 sg13cmos5l_o21ai_1_0.B1 sg13cmos5l_inv_1_507.Y 0.16454f
C3984 sg13cmos5l_a21oi_1_1.A2 sg13cmos5l_a22oi_1_0.A2 0.12709f
C3985 sg13cmos5l_inv_1_448.A VPWR 0.5156f
C3986 a_11176_3230# VPWR 0.12744f
C3987 sg13cmos5l_mux2_1_4.S sg13cmos5l_mux4_1_15.A3 0.56688f
C3988 a_4798_12970# a_4701_13264# 0.02925f
C3989 a_4475_13008# a_4975_13264# 0.03336f
C3990 sg13cmos5l_inv_1_482.Y sg13cmos5l_inv_1_478.Y 0.43134f
C3991 sg13cmos5l_inv_1_721.A VPWR 0.39835f
C3992 sg13cmos5l_inv_1_522.A a_2816_13098# 0.04305f
C3993 a_8638_6558# a_9633_6516# 0.48298f
C3994 sg13cmos5l_inv_1_363.Y sg13cmos5l_inv_1_368.Y 0.2117f
C3995 sg13cmos5l_inv_1_815.Y VPWR 0.35594f
C3996 sg13cmos5l_inv_1_787.Y sg13cmos5l_inv_1_883.A 0.01161f
C3997 sg13cmos5l_inv_1_950.A invsel[3] 0.0204f
C3998 a_8577_16036# sg13cmos5l_inv_1_579.Y 0.03999f
C3999 sg13cmos5l_inv_1_88.Y sg13cmos5l_inv_1_89.Y 0.01082f
C4000 sg13cmos5l_inv_1_109.Y sg13cmos5l_inv_1_191.A 0.19028f
C4001 sg13cmos5l_inv_1_486.Y sg13cmos5l_inv_1_481.Y 0.1984f
C4002 sg13cmos5l_inv_1_484.Y sg13cmos5l_inv_1_494.Y 0.20065f
C4003 sg13cmos5l_inv_1_610.Y sg13cmos5l_inv_1_624.Y 0.01153f
C4004 sg13cmos5l_inv_1_534.Y sg13cmos5l_inv_1_658.Y 0.01891f
C4005 sg13cmos5l_inv_1_186.A a_19136_4742# 0.01162f
C4006 a_9659_7736# a_9536_7766# 0.01107f
C4007 sg13cmos5l_inv_1_416.A sg13cmos5l_inv_1_429.A 0.02804f
C4008 sg13cmos5l_inv_1_266.Y sg13cmos5l_inv_1_417.Y 0.06133f
C4009 sg13cmos5l_mux2_1_4.S a_14422_14482# 0.03567f
C4010 a_4072_3932# VPWR 0.31456f
C4011 sg13cmos5l_inv_1_482.Y VPWR 0.6055f
C4012 sg13cmos5l_inv_1_542.A sg13cmos5l_inv_1_566.A 0.01632f
C4013 sg13cmos5l_inv_1_51.A sg13cmos5l_buf_1_2.X 0.0305f
C4014 sg13cmos5l_inv_1_937.A sg13cmos5l_mux4_1_5.S1 0.01406f
C4015 sg13cmos5l_inv_1_382.A sg13cmos5l_inv_1_454.Y 0.11171f
C4016 sg13cmos5l_nor3_1_1.B sg13cmos5l_nor3_1_1.Y 0.34158f
C4017 sg13cmos5l_inv_1_225.Y sg13cmos5l_inv_1_184.Y 0.16262f
C4018 sg13cmos5l_nand2_1_1.B sg13cmos5l_buf_1_12.X 0.03629f
C4019 sg13cmos5l_mux4_1_16.A2 VPWR 0.63636f
C4020 sg13cmos5l_buf_1_8.A a_4438_12606# 0.0264f
C4021 sg13cmos5l_inv_1_114.Y a_14183_9582# 0.02341f
C4022 sg13cmos5l_inv_1_490.A VPWR 0.44853f
C4023 a_18184_8562# VPWR 0.14281f
C4024 sg13cmos5l_buf_1_8.A sg13cmos5l_inv_1_185.Y 0.0139f
C4025 a_13472_9278# VPWR 0.0685f
C4026 sg13cmos5l_inv_1_176.A sg13cmos5l_inv_1_78.A 0.17683f
C4027 sg13cmos5l_inv_1_515.A a_1664_11586# 0.03646f
C4028 sg13cmos5l_mux4_1_8.A0 sg13cmos5l_mux4_1_8.A2 0.02266f
C4029 sg13cmos5l_inv_1_823.A a_16840_17634# 0.05461f
C4030 sg13cmos5l_mux4_1_2.X sg13cmos5l_inv_1_16.A 0.01169f
C4031 sg13cmos5l_mux2_1_4.S sg13cmos5l_mux4_1_12.A3 0.078f
C4032 sg13cmos5l_inv_1_1007.Y sg13cmos5l_inv_1_972.Y 0.01642f
C4033 sg13cmos5l_inv_1_70.A a_10696_1718# 0.0383f
C4034 sg13cmos5l_inv_1_118.Y sg13cmos5l_inv_1_169.Y 0.0139f
C4035 sg13cmos5l_inv_1_115.Y sg13cmos5l_inv_1_116.Y 0.1846f
C4036 sg13cmos5l_inv_1_206.A sg13cmos5l_inv_1_227.A 0.47001f
C4037 sg13cmos5l_inv_1_236.Y a_12136_4742# 0.03536f
C4038 sg13cmos5l_mux4_1_14.A1 a_13607_14482# 0.19458f
C4039 sg13cmos5l_inv_1_149.A sg13cmos5l_inv_1_106.A 0.20051f
C4040 sg13cmos5l_inv_1_78.A sg13cmos5l_inv_1_234.A 0.17404f
C4041 sg13cmos5l_inv_1_334.A sg13cmos5l_inv_1_320.Y 0.0565f
C4042 a_13918_3898# a_14125_4165# 0.01967f
C4043 sg13cmos5l_inv_1_725.Y VPWR 0.47605f
C4044 sg13cmos5l_mux4_1_5.X sg13cmos5l_inv_1_325.A 0.0105f
C4045 sg13cmos5l_inv_1_308.Y sg13cmos5l_inv_1_298.Y 0.02646f
C4046 sg13cmos5l_inv_1_120.Y sg13cmos5l_inv_1_78.A 0.03764f
C4047 sg13cmos5l_inv_1_725.Y sg13cmos5l_inv_1_708.A 0.18584f
C4048 sg13cmos5l_buf_1_9.A sg13cmos5l_inv_1_480.A 0.02329f
C4049 sg13cmos5l_mux2_1_2.A0 sg13cmos5l_inv_1_479.Y 0.01885f
C4050 sg13cmos5l_buf_1_8.A sg13cmos5l_inv_1_271.A 0.20379f
C4051 sg13cmos5l_inv_1_898.Y sg13cmos5l_inv_1_898.A 0.18105f
C4052 sg13cmos5l_inv_1_522.A sg13cmos5l_nor3_1_2.B 0.23553f
C4053 sg13cmos5l_inv_1_564.A sg13cmos5l_inv_1_557.Y 0.2347f
C4054 sg13cmos5l_inv_1_416.Y sg13cmos5l_inv_1_452.Y 0.01839f
C4055 sg13cmos5l_buf_1_7.X sg13cmos5l_inv_1_327.A 0.04598f
C4056 sg13cmos5l_inv_1_297.Y sg13cmos5l_inv_1_296.Y 0.07348f
C4057 sg13cmos5l_inv_1_267.Y sg13cmos5l_inv_1_318.Y 0.06543f
C4058 a_6119_8434# a_6548_8434# 0.0289f
C4059 a_800_8562# VPWR 0.06706f
C4060 sg13cmos5l_inv_1_533.Y a_4264_16838# 0.01833f
C4061 sg13cmos5l_inv_1_142.A sg13cmos5l_inv_1_186.Y 0.21287f
C4062 sg13cmos5l_inv_1_467.Y sg13cmos5l_mux4_1_4.A2 0.34115f
C4063 sg13cmos5l_inv_1_519.Y sg13cmos5l_inv_1_518.A 0.03183f
C4064 sg13cmos5l_mux4_1_8.A1 sg13cmos5l_inv_1_619.Y 0.01907f
C4065 sg13cmos5l_buf_1_8.A sg13cmos5l_inv_1_362.Y 0.07925f
C4066 sg13cmos5l_mux4_1_11.A3 sg13cmos5l_mux4_1_14.A3 0.06363f
C4067 sg13cmos5l_inv_1_888.Y a_19048_13814# 0.01986f
C4068 sg13cmos5l_inv_1_562.Y a_5600_16838# 0.03522f
C4069 sg13cmos5l_inv_1_879.A sg13cmos5l_inv_1_881.A 0.01621f
C4070 sg13cmos5l_mux4_1_7.A3 sg13cmos5l_inv_1_676.Y 0.0349f
C4071 sg13cmos5l_inv_1_723.Y osc_tap[4] 0.01115f
C4072 sg13cmos5l_inv_1_744.Y sg13cmos5l_inv_1_740.A 0.08319f
C4073 a_8192_16838# VPWR 0.07768f
C4074 sg13cmos5l_inv_1_525.A sg13cmos5l_inv_1_515.Y 0.02036f
C4075 sg13cmos5l_mux4_1_10.A3 sg13cmos5l_mux2_1_2.A0 0.61293f
C4076 a_6088_1718# VPWR 0.14217f
C4077 sg13cmos5l_inv_1_645.Y sg13cmos5l_inv_1_676.Y 0.0985f
C4078 sg13cmos5l_mux4_1_8.A0 sg13cmos5l_inv_1_799.A 0.03303f
C4079 sg13cmos5l_inv_1_741.Y sg13cmos5l_inv_1_749.A 0.02413f
C4080 sg13cmos5l_buf_1_9.A a_13895_15630# 0.51803f
C4081 sg13cmos5l_inv_1_865.Y sg13cmos5l_inv_1_874.Y 0.02288f
C4082 sg13cmos5l_inv_1_273.A sg13cmos5l_inv_1_243.A 0.1638f
C4083 sg13cmos5l_inv_1_404.Y sg13cmos5l_inv_1_387.Y 0.21399f
C4084 sg13cmos5l_inv_1_298.Y a_3680_1002# 0.01083f
C4085 sg13cmos5l_inv_1_191.Y sg13cmos5l_inv_1_234.A 0.01682f
C4086 sg13cmos5l_inv_1_672.Y sg13cmos5l_inv_1_672.A 0.20385f
C4087 a_15662_4084# a_16094_4192# 0.02925f
C4088 sg13cmos5l_mux4_1_5.S1 sg13cmos5l_inv_1_113.Y 0.03237f
C4089 sg13cmos5l_mux4_1_1.A3 sg13cmos5l_inv_1_42.A 0.03154f
C4090 sg13cmos5l_mux4_1_16.A1 a_8638_6558# 0.13195f
C4091 sg13cmos5l_inv_1_824.A sg13cmos5l_inv_1_852.Y 0.0578f
C4092 sg13cmos5l_inv_1_994.A sg13cmos5l_inv_1_994.Y 0.19028f
C4093 sg13cmos5l_mux2_1_4.S sg13cmos5l_mux4_1_3.X 0.05918f
C4094 sg13cmos5l_inv_1_515.Y VPWR 0.36951f
C4095 sg13cmos5l_inv_1_846.Y sg13cmos5l_mux4_1_11.A3 0.0281f
C4096 sg13cmos5l_inv_1_17.Y sg13cmos5l_inv_1_24.Y 0.01085f
C4097 sg13cmos5l_inv_1_17.A sg13cmos5l_inv_1_18.A 0.04145f
C4098 sg13cmos5l_inv_1_304.A sg13cmos5l_inv_1_251.A 0.01954f
C4099 sg13cmos5l_inv_1_571.A VPWR 0.42116f
C4100 a_19048_7050# VPWR 0.12656f
C4101 sg13cmos5l_mux4_1_6.A2 sg13cmos5l_inv_1_305.Y 0.02141f
C4102 sg13cmos5l_mux4_1_5.S0 VPWR 7.90786f
C4103 sg13cmos5l_inv_1_1009.Y sg13cmos5l_inv_1_1012.Y 0.09594f
C4104 sg13cmos5l_inv_1_983.Y VPWR 0.42383f
C4105 sg13cmos5l_mux4_1_8.A0 sg13cmos5l_buf_1_9.A 0.36387f
C4106 a_10408_18350# VPWR 0.13315f
C4107 sg13cmos5l_inv_1_920.A a_17512_14610# 0.03921f
C4108 sg13cmos5l_mux2_1_4.X a_9152_9278# 0.04533f
C4109 sg13cmos5l_inv_1_961.Y sg13cmos5l_inv_1_929.A 0.01483f
C4110 sg13cmos5l_buf_1_10.A sg13cmos5l_inv_1_318.Y 0.01199f
C4111 sg13cmos5l_inv_1_306.A sg13cmos5l_inv_1_298.Y 0.04673f
C4112 sg13cmos5l_inv_1_159.A sg13cmos5l_inv_1_162.Y 0.02026f
C4113 sg13cmos5l_inv_1_311.Y sg13cmos5l_inv_1_304.Y 0.02454f
C4114 sg13cmos5l_inv_1_535.A a_4438_15994# 0.03154f
C4115 sg13cmos5l_inv_1_645.A sg13cmos5l_inv_1_672.A 0.03301f
C4116 VPWR invsel[3] 0.11454f
C4117 sg13cmos5l_inv_1_545.Y sg13cmos5l_inv_1_571.Y 0.06242f
C4118 sg13cmos5l_inv_1_57.Y sg13cmos5l_inv_1_56.Y 0.0222f
C4119 sg13cmos5l_inv_1_60.Y sg13cmos5l_inv_1_58.A 0.03699f
C4120 sg13cmos5l_inv_1_421.Y a_2816_4742# 0.01062f
C4121 sg13cmos5l_inv_1_419.A sg13cmos5l_inv_1_337.A 0.02847f
C4122 sg13cmos5l_inv_1_78.A sg13cmos5l_inv_1_106.Y 0.02027f
C4123 sg13cmos5l_inv_1_451.A sg13cmos5l_inv_1_422.A 0.10151f
C4124 sg13cmos5l_buf_1_0.A sg13cmos5l_inv_1_61.A 0.02764f
C4125 sg13cmos5l_buf_1_19.A osc_tap[4] 0.01022f
C4126 sg13cmos5l_inv_1_809.Y sg13cmos5l_inv_1_807.Y 0.08998f
C4127 a_3934_8070# VPWR 0.88382f
C4128 sg13cmos5l_inv_1_798.A VPWR 0.7193f
C4129 sg13cmos5l_inv_1_774.Y sg13cmos5l_inv_1_773.Y 0.2715f
C4130 sg13cmos5l_buf_1_8.A sg13cmos5l_inv_1_931.Y 0.025f
C4131 sg13cmos5l_inv_1_466.Y VPWR 0.77396f
C4132 sg13cmos5l_buf_1_8.A sg13cmos5l_inv_1_316.A 0.01681f
C4133 sg13cmos5l_inv_1_606.A a_9440_18350# 0.03589f
C4134 sg13cmos5l_inv_1_75.A sg13cmos5l_inv_1_77.Y 0.06593f
C4135 sg13cmos5l_inv_1_17.A sg13cmos5l_inv_1_16.Y 0.08707f
C4136 sg13cmos5l_inv_1_525.A sg13cmos5l_inv_1_532.Y 1.42228f
C4137 sg13cmos5l_inv_1_149.Y sg13cmos5l_inv_1_148.A 0.37679f
C4138 sg13cmos5l_inv_1_584.A sg13cmos5l_mux4_1_7.A3 0.02259f
C4139 sg13cmos5l_inv_1_564.A VPWR 0.43614f
C4140 sg13cmos5l_mux4_1_8.A0 a_11464_16838# 0.01517f
C4141 sg13cmos5l_buf_1_9.A sg13cmos5l_nand2_1_1.B 0.03071f
C4142 sg13cmos5l_inv_1_865.Y sg13cmos5l_inv_1_861.A 0.05336f
C4143 a_14206_15630# VPWR 0.88382f
C4144 sg13cmos5l_mux4_1_5.S1 sg13cmos5l_inv_1_448.Y 0.01984f
C4145 sg13cmos5l_inv_1_631.A sg13cmos5l_inv_1_674.A 0.01522f
C4146 sg13cmos5l_inv_1_218.A VPWR 0.43585f
C4147 sg13cmos5l_inv_1_940.A sg13cmos5l_inv_1_941.A 0.01866f
C4148 sg13cmos5l_inv_1_998.A sg13cmos5l_inv_1_976.Y 0.06436f
C4149 sg13cmos5l_mux4_1_15.A3 a_15584_10790# 0.04405f
C4150 sg13cmos5l_inv_1_274.Y a_7271_3534# 0.12935f
C4151 sg13cmos5l_inv_1_69.A sg13cmos5l_inv_1_286.Y 0.04084f
C4152 sg13cmos5l_inv_1_241.Y sg13cmos5l_inv_1_258.A 0.01841f
C4153 sg13cmos5l_inv_1_976.Y a_10888_9278# 0.01986f
C4154 sg13cmos5l_inv_1_514.Y sg13cmos5l_inv_1_950.A 0.15548f
C4155 sg13cmos5l_inv_1_514.A a_1664_11586# 0.01076f
C4156 sg13cmos5l_inv_1_767.A VPWR 0.42672f
C4157 sg13cmos5l_inv_1_507.Y a_2816_10790# 0.04351f
C4158 sg13cmos5l_mux4_1_14.A3 sg13cmos5l_inv_1_913.A 0.01318f
C4159 a_13288_18350# VPWR 0.12833f
C4160 sg13cmos5l_inv_1_418.Y a_6368_4742# 0.01054f
C4161 sg13cmos5l_inv_1_532.Y VPWR 0.82352f
C4162 sg13cmos5l_inv_1_571.A sg13cmos5l_inv_1_572.A 0.20065f
C4163 a_18764_12180# sg13cmos5l_buf_1_18.A 0.29455f
C4164 a_3680_15326# VPWR 0.11607f
C4165 sg13cmos5l_mux4_1_14.A0 sg13cmos5l_inv_1_798.Y 1.59844f
C4166 a_18664_9192# a_19048_9278# 0.03269f
C4167 a_9443_9192# VPWR 0.01364f
C4168 sg13cmos5l_inv_1_910.A sg13cmos5l_inv_1_911.A 0.20065f
C4169 sg13cmos5l_inv_1_748.A sg13cmos5l_inv_1_998.Y 0.01164f
C4170 sg13cmos5l_buf_1_17.X osc_tap[5] 0.22229f
C4171 sg13cmos5l_inv_1_118.A sg13cmos5l_inv_1_129.Y 0.07795f
C4172 sg13cmos5l_inv_1_89.Y VPWR 0.39449f
C4173 sg13cmos5l_inv_1_478.A sg13cmos5l_inv_1_478.Y 0.2349f
C4174 sg13cmos5l_nor3_1_2.B sg13cmos5l_inv_1_120.A 0.36067f
C4175 sg13cmos5l_mux4_1_5.S1 sg13cmos5l_inv_1_402.A 0.0387f
C4176 sg13cmos5l_inv_1_713.A VPWR 0.43055f
C4177 sg13cmos5l_inv_1_290.Y a_6088_1718# 0.01078f
C4178 sg13cmos5l_inv_1_375.Y sg13cmos5l_inv_1_368.Y 0.01464f
C4179 sg13cmos5l_inv_1_61.Y sg13cmos5l_inv_1_97.Y 0.18584f
C4180 a_14206_15630# a_15201_15588# 0.48298f
C4181 sg13cmos5l_inv_1_88.Y sg13cmos5l_inv_1_82.A 0.01164f
C4182 sg13cmos5l_inv_1_984.Y a_5992_9278# 0.03352f
C4183 a_12808_13098# a_12808_12302# 0.01095f
C4184 sg13cmos5l_inv_1_507.A sg13cmos5l_nand2_1_1.B 0.07572f
C4185 sg13cmos5l_o21ai_1_0.B1 sg13cmos5l_inv_1_668.A 0.40916f
C4186 sg13cmos5l_inv_1_115.A a_13472_8562# 0.03465f
C4187 sg13cmos5l_inv_1_426.A sg13cmos5l_inv_1_429.A 0.1694f
C4188 sg13cmos5l_inv_1_266.Y sg13cmos5l_inv_1_452.Y 0.38644f
C4189 sg13cmos5l_inv_1_857.Y sg13cmos5l_inv_1_858.Y 0.20065f
C4190 sg13cmos5l_inv_1_478.A VPWR 0.42651f
C4191 sg13cmos5l_a21oi_1_0.B1 sg13cmos5l_mux4_1_9.A0 0.01536f
C4192 sg13cmos5l_inv_1_683.A sg13cmos5l_inv_1_631.Y 0.20065f
C4193 sg13cmos5l_inv_1_37.Y sg13cmos5l_inv_1_36.Y 0.54303f
C4194 sg13cmos5l_inv_1_489.A VPWR 0.41369f
C4195 sg13cmos5l_inv_1_171.A VPWR 0.37357f
C4196 sg13cmos5l_inv_1_752.A sg13cmos5l_inv_1_750.Y 0.014f
C4197 sg13cmos5l_inv_1_7.Y sg13cmos5l_inv_1_5.Y 0.02386f
C4198 sg13cmos5l_inv_1_605.Y sg13cmos5l_inv_1_604.Y 0.20065f
C4199 sg13cmos5l_inv_1_295.Y sg13cmos5l_inv_1_308.Y 0.07879f
C4200 sg13cmos5l_inv_1_513.A a_1664_11586# 0.03465f
C4201 sg13cmos5l_inv_1_834.Y sg13cmos5l_inv_1_843.Y 0.11772f
C4202 sg13cmos5l_inv_1_823.A sg13cmos5l_inv_1_851.A 0.02157f
C4203 sg13cmos5l_inv_1_70.A sg13cmos5l_inv_1_70.Y 0.28896f
C4204 sg13cmos5l_inv_1_206.A sg13cmos5l_inv_1_206.Y 0.23031f
C4205 sg13cmos5l_inv_1_612.Y sg13cmos5l_inv_1_626.Y 0.19622f
C4206 sg13cmos5l_inv_1_800.Y sg13cmos5l_mux4_1_14.A0 0.22504f
C4207 sg13cmos5l_mux4_1_13.A0 a_14710_15630# 0.01168f
C4208 sg13cmos5l_inv_1_466.Y sg13cmos5l_inv_1_290.Y 0.18555f
C4209 sg13cmos5l_inv_1_248.A sg13cmos5l_inv_1_416.A 0.08997f
C4210 sg13cmos5l_inv_1_728.Y VPWR 0.64918f
C4211 sg13cmos5l_inv_1_308.Y sg13cmos5l_inv_1_298.A 1.39842f
C4212 sg13cmos5l_o21ai_1_0.B1 sg13cmos5l_buf_1_12.X 0.58775f
C4213 sg13cmos5l_mux2_1_0.X sg13cmos5l_inv_1_76.A 0.01056f
C4214 a_13607_3898# sg13cmos5l_mux4_1_2.A2 0.20874f
C4215 sg13cmos5l_inv_1_564.A sg13cmos5l_inv_1_564.Y 0.89833f
C4216 sg13cmos5l_inv_1_322.A sg13cmos5l_inv_1_305.A 0.46907f
C4217 sg13cmos5l_inv_1_297.Y sg13cmos5l_inv_1_294.Y 0.15491f
C4218 sg13cmos5l_inv_1_836.Y sg13cmos5l_inv_1_850.Y 0.01879f
C4219 sg13cmos5l_inv_1_848.Y sg13cmos5l_mux4_1_13.A0 0.10114f
C4220 sg13cmos5l_buf_1_10.A sg13cmos5l_nand2_1_1.B 0.063f
C4221 sg13cmos5l_inv_1_351.A VPWR 0.43599f
C4222 a_808_4656# VPWR 0.24834f
C4223 sg13cmos5l_inv_1_798.Y VPWR 0.44298f
C4224 sg13cmos5l_buf_1_2.X sg13cmos5l_inv_1_37.A 0.01691f
C4225 sg13cmos5l_inv_1_525.A sg13cmos5l_inv_1_523.Y 1.41444f
C4226 sg13cmos5l_inv_1_879.A sg13cmos5l_inv_1_880.A 0.17688f
C4227 sg13cmos5l_mux4_1_7.A3 sg13cmos5l_inv_1_479.Y 0.0659f
C4228 a_18280_18264# a_18764_18228# 0.03472f
C4229 sg13cmos5l_inv_1_618.Y VPWR 0.37389f
C4230 sg13cmos5l_inv_1_257.A VPWR 0.44036f
C4231 sg13cmos5l_mux4_1_5.S0 sg13cmos5l_inv_1_482.Y 0.19985f
C4232 sg13cmos5l_inv_1_237.Y sg13cmos5l_inv_1_248.A 0.42012f
C4233 sg13cmos5l_inv_1_267.Y sg13cmos5l_inv_1_462.Y 0.04446f
C4234 sg13cmos5l_inv_1_766.A sg13cmos5l_inv_1_916.A 0.19503f
C4235 sg13cmos5l_inv_1_767.A sg13cmos5l_inv_1_768.A 0.20065f
C4236 sg13cmos5l_buf_1_23.X osc_tap[6] 0.12241f
C4237 sg13cmos5l_nor3_1_2.B sg13cmos5l_nor4_1_0.A 0.27898f
C4238 sg13cmos5l_inv_1_645.Y sg13cmos5l_inv_1_479.Y 0.02309f
C4239 sg13cmos5l_mux4_1_8.A0 sg13cmos5l_inv_1_995.Y 0.0299f
C4240 sg13cmos5l_mux4_1_5.S0 sg13cmos5l_mux4_1_16.A2 0.03324f
C4241 sg13cmos5l_inv_1_532.Y a_2912_12302# 0.01143f
C4242 sg13cmos5l_inv_1_1000.Y a_18856_9980# 0.11794f
C4243 sg13cmos5l_buf_1_9.A sg13cmos5l_inv_1_883.Y 2.02371f
C4244 sg13cmos5l_mux4_1_12.A1 VPWR 2.73125f
C4245 sg13cmos5l_mux4_1_5.S0 sg13cmos5l_inv_1_490.A 0.03223f
C4246 sg13cmos5l_inv_1_883.A sg13cmos5l_inv_1_889.Y 0.1826f
C4247 sg13cmos5l_buf_1_12.X sg13cmos5l_inv_1_248.A 0.04355f
C4248 sg13cmos5l_inv_1_792.Y sg13cmos5l_inv_1_874.Y 0.16093f
C4249 sg13cmos5l_inv_1_523.Y VPWR 0.83564f
C4250 sg13cmos5l_inv_1_273.A sg13cmos5l_inv_1_273.Y 0.23031f
C4251 sg13cmos5l_inv_1_298.A a_3680_1002# 0.03483f
C4252 sg13cmos5l_mux4_1_5.S1 a_14110_3534# 0.06281f
C4253 sg13cmos5l_inv_1_311.Y sg13cmos5l_inv_1_284.A 0.27125f
C4254 sg13cmos5l_inv_1_100.A VPWR 0.81809f
C4255 sg13cmos5l_mux4_1_5.S1 sg13cmos5l_inv_1_112.A 0.01052f
C4256 sg13cmos5l_mux4_1_1.A3 sg13cmos5l_inv_1_31.A 0.03339f
C4257 sg13cmos5l_inv_1_824.A sg13cmos5l_inv_1_825.A 0.19028f
C4258 sg13cmos5l_inv_1_994.A sg13cmos5l_inv_1_928.A 0.07337f
C4259 sg13cmos5l_inv_1_514.Y VPWR 0.36555f
C4260 sg13cmos5l_inv_1_55.Y sg13cmos5l_inv_1_46.Y 0.11231f
C4261 sg13cmos5l_or2_1_0.B a_13856_11586# 0.01583f
C4262 sg13cmos5l_buf_1_8.A sg13cmos5l_inv_1_270.Y 0.03823f
C4263 sg13cmos5l_inv_1_304.A sg13cmos5l_inv_1_453.A 0.01896f
C4264 sg13cmos5l_inv_1_17.A sg13cmos5l_inv_1_24.Y 0.04313f
C4265 sg13cmos5l_inv_1_427.A sg13cmos5l_inv_1_416.Y 0.21554f
C4266 sg13cmos5l_inv_1_589.A sg13cmos5l_mux4_1_8.A1 0.01156f
C4267 sg13cmos5l_inv_1_112.Y sg13cmos5l_inv_1_122.Y 0.01085f
C4268 sg13cmos5l_inv_1_537.Y VPWR 0.70734f
C4269 sg13cmos5l_inv_1_16.A sg13cmos5l_inv_1_16.Y 0.09593f
C4270 sg13cmos5l_inv_1_921.Y VPWR 0.43453f
C4271 sg13cmos5l_inv_1_771.Y VPWR 0.46128f
C4272 a_18184_16838# VPWR 0.14168f
C4273 sg13cmos5l_inv_1_680.Y sg13cmos5l_inv_1_689.A 0.05199f
C4274 sg13cmos5l_inv_1_306.A sg13cmos5l_inv_1_298.A 0.03258f
C4275 sg13cmos5l_inv_1_713.A sg13cmos5l_inv_1_721.A 0.2023f
C4276 sg13cmos5l_inv_1_159.A sg13cmos5l_inv_1_162.A 0.01948f
C4277 sg13cmos5l_inv_1_237.Y sg13cmos5l_inv_1_272.A 0.01688f
C4278 a_17416_11586# sg13cmos5l_inv_1_698.A 0.01078f
C4279 a_10880_11586# VPWR 0.11617f
C4280 VPWR osc_tap[4] 0.37666f
C4281 sg13cmos5l_buf_1_8.A sg13cmos5l_inv_1_319.Y 0.52676f
C4282 sg13cmos5l_inv_1_553.Y sg13cmos5l_inv_1_541.A 0.01014f
C4283 sg13cmos5l_inv_1_543.Y sg13cmos5l_inv_1_571.Y 0.01208f
C4284 sg13cmos5l_inv_1_650.A sg13cmos5l_inv_1_650.Y 0.21002f
C4285 sg13cmos5l_inv_1_78.A sg13cmos5l_inv_1_107.Y 0.11411f
C4286 sg13cmos5l_inv_1_436.A sg13cmos5l_inv_1_422.A 0.02031f
C4287 a_16456_9278# sg13cmos5l_inv_1_156.Y 0.01059f
C4288 a_9160_11586# VPWR 0.13415f
C4289 sg13cmos5l_buf_1_8.A sg13cmos5l_inv_1_933.A 0.01543f
C4290 sg13cmos5l_inv_1_800.Y VPWR 0.36376f
C4291 sg13cmos5l_inv_1_774.Y sg13cmos5l_inv_1_790.Y 0.01526f
C4292 sg13cmos5l_inv_1_325.Y VPWR 0.47631f
C4293 sg13cmos5l_buf_1_10.A sg13cmos5l_inv_1_462.Y 0.02877f
C4294 sg13cmos5l_inv_1_525.A sg13cmos5l_inv_1_515.A 0.58859f
C4295 sg13cmos5l_inv_1_173.Y sg13cmos5l_inv_1_148.A 0.01555f
C4296 sg13cmos5l_inv_1_562.Y sg13cmos5l_mux4_1_10.A3 0.0335f
C4297 sg13cmos5l_inv_1_584.A sg13cmos5l_inv_1_637.A 0.0246f
C4298 sg13cmos5l_inv_1_542.A VPWR 0.74602f
C4299 a_3623_12606# a_3934_12606# 0.49675f
C4300 sg13cmos5l_mux4_1_8.A0 sg13cmos5l_inv_1_800.A 0.03836f
C4301 sg13cmos5l_inv_1_237.Y sg13cmos5l_inv_1_294.Y 0.01927f
C4302 sg13cmos5l_inv_1_1011.A sg13cmos5l_mux4_1_3.X 0.03187f
C4303 sg13cmos5l_buf_1_9.A sg13cmos5l_or2_1_0.B 0.33633f
C4304 sg13cmos5l_inv_1_792.Y sg13cmos5l_inv_1_861.A 0.06996f
C4305 a_19048_18350# VPWR 0.12259f
C4306 a_17896_6254# sg13cmos5l_inv_1_195.Y 0.01059f
C4307 sg13cmos5l_inv_1_192.Y VPWR 0.41682f
C4308 sg13cmos5l_inv_1_747.Y sg13cmos5l_inv_1_756.Y 0.14787f
C4309 sg13cmos5l_mux2_1_0.X sg13cmos5l_inv_1_941.A 0.06752f
C4310 sg13cmos5l_inv_1_940.A sg13cmos5l_inv_1_976.Y 0.24801f
C4311 sg13cmos5l_inv_1_411.Y a_5005_7954# 0.01814f
C4312 sg13cmos5l_mux4_1_15.A3 sg13cmos5l_inv_1_700.Y 0.19884f
C4313 sg13cmos5l_inv_1_177.Y sg13cmos5l_inv_1_177.A 0.15651f
C4314 sg13cmos5l_inv_1_514.A sg13cmos5l_inv_1_950.A 0.04286f
C4315 sg13cmos5l_inv_1_766.A VPWR 0.42525f
C4316 sg13cmos5l_mux4_1_14.A3 sg13cmos5l_inv_1_915.A 0.06957f
C4317 sg13cmos5l_inv_1_837.Y VPWR 0.49177f
C4318 sg13cmos5l_inv_1_349.A sg13cmos5l_inv_1_347.Y 0.01057f
C4319 sg13cmos5l_inv_1_515.A VPWR 0.64644f
C4320 sg13cmos5l_inv_1_37.Y sg13cmos5l_mux4_1_1.A3 0.25703f
C4321 sg13cmos5l_inv_1_682.A VPWR 0.67905f
C4322 sg13cmos5l_inv_1_748.A sg13cmos5l_inv_1_735.Y 0.04851f
C4323 sg13cmos5l_inv_1_947.A sg13cmos5l_inv_1_947.Y 0.11146f
C4324 sg13cmos5l_inv_1_319.Y a_4556_3858# 0.02321f
C4325 sg13cmos5l_inv_1_129.A sg13cmos5l_inv_1_129.Y 0.16909f
C4326 sg13cmos5l_inv_1_118.A sg13cmos5l_inv_1_138.Y 0.03925f
C4327 sg13cmos5l_inv_1_82.A VPWR 0.43851f
C4328 a_1006_15296# VPWR 0.21817f
C4329 sg13cmos5l_buf_1_9.A sg13cmos5l_o21ai_1_0.B1 0.03775f
C4330 sg13cmos5l_inv_1_478.A sg13cmos5l_inv_1_482.Y 0.18186f
C4331 sg13cmos5l_inv_1_802.A a_13895_15630# 0.15264f
C4332 sg13cmos5l_inv_1_729.Y VPWR 0.42645f
C4333 sg13cmos5l_inv_1_375.Y sg13cmos5l_inv_1_363.Y 0.16148f
C4334 sg13cmos5l_inv_1_241.A sg13cmos5l_inv_1_258.A 0.07847f
C4335 a_3488_2514# VPWR 0.0708f
C4336 a_808_6956# a_1184_7050# 0.03376f
C4337 a_9440_17634# VPWR 0.07753f
C4338 sg13cmos5l_inv_1_969.Y a_5992_9278# 0.01986f
C4339 sg13cmos5l_inv_1_483.Y sg13cmos5l_inv_1_486.Y 0.25214f
C4340 sg13cmos5l_inv_1_489.A sg13cmos5l_inv_1_490.A 0.27936f
C4341 sg13cmos5l_inv_1_488.A a_5984_11586# 0.03553f
C4342 sg13cmos5l_inv_1_472.Y sg13cmos5l_inv_1_484.Y 0.20693f
C4343 sg13cmos5l_inv_1_171.A a_18184_8562# 0.01986f
C4344 sg13cmos5l_buf_1_9.A a_7981_12976# 0.37283f
C4345 a_13607_12606# a_14036_12606# 0.0289f
C4346 a_14422_12606# a_13918_12606# 0.97548f
C4347 sg13cmos5l_mux4_1_5.S0 a_3934_8070# 0.07565f
C4348 sg13cmos5l_inv_1_937.Y sg13cmos5l_inv_1_114.Y 0.01944f
C4349 sg13cmos5l_buf_1_8.A a_3623_12606# 0.53879f
C4350 sg13cmos5l_inv_1_488.A VPWR 0.42465f
C4351 sg13cmos5l_inv_1_37.Y sg13cmos5l_inv_1_44.A 0.13005f
C4352 sg13cmos5l_mux4_1_13.A3 sg13cmos5l_inv_1_868.A 0.02793f
C4353 sg13cmos5l_inv_1_7.Y sg13cmos5l_inv_1_43.Y 0.171f
C4354 sg13cmos5l_inv_1_513.A sg13cmos5l_inv_1_950.A 0.05432f
C4355 sg13cmos5l_inv_1_332.A sg13cmos5l_inv_1_308.Y 0.75978f
C4356 sg13cmos5l_buf_1_9.A sg13cmos5l_inv_1_248.A 0.03096f
C4357 sg13cmos5l_mux4_1_8.A0 sg13cmos5l_mux4_1_8.A1 2.65845f
C4358 sg13cmos5l_inv_1_588.Y sg13cmos5l_inv_1_626.Y 0.02694f
C4359 sg13cmos5l_o21ai_1_0.B1 sg13cmos5l_inv_1_507.A 0.0934f
C4360 sg13cmos5l_inv_1_220.A a_15016_2514# 0.01986f
C4361 a_3934_3534# a_4661_3149# 0.01228f
C4362 sg13cmos5l_inv_1_118.Y sg13cmos5l_inv_1_115.Y 0.11575f
C4363 sg13cmos5l_inv_1_206.A sg13cmos5l_inv_1_225.Y 0.04862f
C4364 sg13cmos5l_mux4_1_1.A3 a_14110_3534# 0.1642f
C4365 sg13cmos5l_inv_1_593.Y sg13cmos5l_inv_1_626.Y 0.14499f
C4366 sg13cmos5l_a21oi_1_1.A2 a_9160_11586# 0.04234f
C4367 sg13cmos5l_buf_1_0.A sg13cmos5l_inv_1_228.A 0.15351f
C4368 sg13cmos5l_inv_1_786.Y sg13cmos5l_mux4_1_14.A0 0.11209f
C4369 sg13cmos5l_inv_1_344.Y sg13cmos5l_inv_1_416.A 0.0101f
C4370 sg13cmos5l_inv_1_706.A VPWR 0.43887f
C4371 sg13cmos5l_mux4_1_2.A2 a_14422_3898# 0.03612f
C4372 a_13288_4026# VPWR 0.13142f
C4373 a_8446_8434# VPWR 0.10962f
C4374 sg13cmos5l_inv_1_571.Y enable 0.0104f
C4375 sg13cmos5l_inv_1_179.A sg13cmos5l_inv_1_147.Y 0.01546f
C4376 sg13cmos5l_inv_1_467.Y VPWR 0.77954f
C4377 sg13cmos5l_mux4_1_12.A3 a_12808_13098# 0.03352f
C4378 sg13cmos5l_inv_1_770.A a_10592_18350# 0.03528f
C4379 sg13cmos5l_mux4_1_8.A2 a_8086_15994# 0.01811f
C4380 sg13cmos5l_inv_1_88.A a_13288_4026# 0.01988f
C4381 a_9432_3406# a_9758_3168# 0.02749f
C4382 a_7414_12970# VPWR 0.04711f
C4383 sg13cmos5l_buf_1_9.A a_7905_13012# 0.24548f
C4384 sg13cmos5l_inv_1_297.Y sg13cmos5l_inv_1_296.A 0.11396f
C4385 sg13cmos5l_inv_1_175.A sg13cmos5l_inv_1_145.Y 0.02413f
C4386 a_13918_12606# a_14913_12564# 0.48298f
C4387 sg13cmos5l_inv_1_848.Y sg13cmos5l_inv_1_850.Y 0.0194f
C4388 a_14710_15630# sg13cmos5l_mux2_1_4.S 0.06566f
C4389 sg13cmos5l_inv_1_351.Y VPWR 0.42145f
C4390 sg13cmos5l_inv_1_740.A sg13cmos5l_inv_1_753.A 0.1118f
C4391 sg13cmos5l_inv_1_866.Y sg13cmos5l_inv_1_875.Y 0.05822f
C4392 sg13cmos5l_inv_1_51.A sg13cmos5l_inv_1_37.A 0.09176f
C4393 sg13cmos5l_inv_1_560.A a_5600_16838# 0.01203f
C4394 sg13cmos5l_inv_1_192.Y sg13cmos5l_inv_1_236.A 0.18042f
C4395 sg13cmos5l_mux4_1_7.A2 a_6910_12970# 0.12897f
C4396 sg13cmos5l_inv_1_636.A sg13cmos5l_inv_1_676.Y 0.01176f
C4397 a_9360_11832# VPWR 0.23444f
C4398 sg13cmos5l_inv_1_834.Y a_18764_18228# 0.01084f
C4399 sg13cmos5l_inv_1_391.A a_8000_7050# 0.03465f
C4400 sg13cmos5l_inv_1_134.Y sg13cmos5l_inv_1_135.Y 0.20065f
C4401 sg13cmos5l_inv_1_618.A VPWR 0.4512f
C4402 sg13cmos5l_inv_1_305.A VPWR 1.4134f
C4403 sg13cmos5l_inv_1_237.Y sg13cmos5l_inv_1_344.Y 0.12077f
C4404 sg13cmos5l_inv_1_267.Y sg13cmos5l_inv_1_248.A 0.06682f
C4405 sg13cmos5l_mux4_1_8.A0 sg13cmos5l_inv_1_616.Y 0.02587f
C4406 sg13cmos5l_mux4_1_1.A3 sg13cmos5l_inv_1_49.A 0.27675f
C4407 sg13cmos5l_inv_1_1003.Y sg13cmos5l_inv_1_759.A 0.01533f
C4408 sg13cmos5l_mux2_1_4.S sg13cmos5l_inv_1_150.A 0.07928f
C4409 sg13cmos5l_inv_1_745.A VPWR 0.72181f
C4410 sg13cmos5l_inv_1_1000.Y sg13cmos5l_buf_1_27.X 0.03713f
C4411 sg13cmos5l_mux4_1_5.S0 sg13cmos5l_inv_1_489.A 0.34527f
C4412 sg13cmos5l_inv_1_410.Y sg13cmos5l_inv_1_284.A 0.11059f
C4413 sg13cmos5l_inv_1_674.A sg13cmos5l_inv_1_672.Y 0.20065f
C4414 sg13cmos5l_o21ai_1_0.B1 sg13cmos5l_buf_1_10.A 0.02756f
C4415 sg13cmos5l_mux4_1_12.A1 sg13cmos5l_inv_1_725.Y 0.09902f
C4416 sg13cmos5l_inv_1_231.Y VPWR 0.42362f
C4417 sg13cmos5l_mux4_1_1.A3 sg13cmos5l_inv_1_38.Y 0.03095f
C4418 sg13cmos5l_mux4_1_5.S1 sg13cmos5l_inv_1_124.A 0.04649f
C4419 sg13cmos5l_nor3_1_2.B a_14989_12490# 0.02155f
C4420 sg13cmos5l_inv_1_514.A VPWR 0.46978f
C4421 sg13cmos5l_inv_1_55.Y sg13cmos5l_inv_1_46.A 0.21974f
C4422 sg13cmos5l_inv_1_42.A sg13cmos5l_inv_1_46.Y 0.01509f
C4423 sg13cmos5l_inv_1_306.A sg13cmos5l_inv_1_332.A 0.29256f
C4424 sg13cmos5l_inv_1_304.A sg13cmos5l_inv_1_295.Y 0.03703f
C4425 sg13cmos5l_inv_1_78.A VPWR 1.31752f
C4426 sg13cmos5l_inv_1_97.Y sg13cmos5l_inv_1_63.A 0.02521f
C4427 sg13cmos5l_inv_1_61.Y sg13cmos5l_inv_1_220.A 0.04691f
C4428 sg13cmos5l_buf_1_8.A sg13cmos5l_inv_1_217.A 0.02953f
C4429 sg13cmos5l_inv_1_926.A VPWR 0.43082f
C4430 sg13cmos5l_inv_1_771.A VPWR 0.60653f
C4431 a_12808_7050# VPWR 0.20401f
C4432 a_7495_3195# VPWR 0.02541f
C4433 sg13cmos5l_inv_1_394.A a_8968_9278# 0.02298f
C4434 sg13cmos5l_inv_1_866.Y VPWR 0.57554f
C4435 sg13cmos5l_inv_1_930.A sg13cmos5l_inv_1_961.Y 0.28644f
C4436 sg13cmos5l_inv_1_618.Y a_8192_16838# 0.01083f
C4437 sg13cmos5l_inv_1_680.Y sg13cmos5l_a21oi_1_0.B1 0.06289f
C4438 sg13cmos5l_inv_1_257.A a_6088_1718# 0.03352f
C4439 sg13cmos5l_inv_1_304.A sg13cmos5l_inv_1_298.A 0.03052f
C4440 sg13cmos5l_inv_1_548.Y sg13cmos5l_inv_1_576.A 0.15518f
C4441 a_14989_12490# sg13cmos5l_mux4_1_11.A2 0.02992f
C4442 sg13cmos5l_inv_1_159.A sg13cmos5l_inv_1_157.Y 0.0192f
C4443 sg13cmos5l_mux4_1_5.S1 a_5005_7954# 0.35547f
C4444 sg13cmos5l_inv_1_202.Y a_17312_9278# 0.03565f
C4445 VPWR invsel[4] 0.1728f
C4446 sg13cmos5l_inv_1_543.Y sg13cmos5l_inv_1_549.A 0.01704f
C4447 sg13cmos5l_inv_1_57.Y sg13cmos5l_inv_1_60.Y 0.19826f
C4448 sg13cmos5l_inv_1_553.Y sg13cmos5l_inv_1_571.Y 0.05421f
C4449 sg13cmos5l_inv_1_545.Y sg13cmos5l_inv_1_545.A 0.1143f
C4450 sg13cmos5l_inv_1_651.Y sg13cmos5l_inv_1_650.Y 0.04133f
C4451 a_18856_9980# VPWR 0.24869f
C4452 sg13cmos5l_inv_1_699.A sg13cmos5l_mux4_1_15.A3 0.02567f
C4453 sg13cmos5l_mux2_1_4.S sg13cmos5l_mux4_1_5.S1 2.10212f
C4454 sg13cmos5l_inv_1_325.A VPWR 1.24652f
C4455 sg13cmos5l_inv_1_786.Y VPWR 0.43276f
C4456 sg13cmos5l_nor3_1_1.A a_9260_9906# 0.29235f
C4457 sg13cmos5l_buf_1_10.A sg13cmos5l_inv_1_248.A 0.02035f
C4458 sg13cmos5l_inv_1_220.Y sg13cmos5l_inv_1_15.Y 0.11805f
C4459 a_9142_6558# VPWR 0.02988f
C4460 sg13cmos5l_inv_1_560.Y sg13cmos5l_mux4_1_10.A3 0.11619f
C4461 sg13cmos5l_inv_1_148.Y sg13cmos5l_inv_1_206.A 0.10903f
C4462 sg13cmos5l_buf_1_8.A sg13cmos5l_mux4_1_15.A2 0.17478f
C4463 sg13cmos5l_buf_1_9.A a_8086_15994# 0.05967f
C4464 a_7582_15994# VPWR 0.88431f
C4465 a_19048_3230# VPWR 0.13181f
C4466 sg13cmos5l_mux4_1_5.S1 sg13cmos5l_inv_1_241.A 0.0983f
C4467 sg13cmos5l_inv_1_523.Y sg13cmos5l_inv_1_515.Y 0.1514f
C4468 sg13cmos5l_buf_1_21.A VPWR 0.2367f
C4469 sg13cmos5l_inv_1_205.A a_17216_5538# 0.03646f
C4470 sg13cmos5l_inv_1_631.Y sg13cmos5l_inv_1_675.A 0.01522f
C4471 sg13cmos5l_inv_1_191.Y VPWR 0.43361f
C4472 sg13cmos5l_mux2_1_0.X sg13cmos5l_inv_1_976.Y 0.0281f
C4473 sg13cmos5l_inv_1_940.A sg13cmos5l_inv_1_998.A 0.23433f
C4474 a_15419_8040# a_15608_7680# 0.40359f
C4475 sg13cmos5l_inv_1_821.Y sg13cmos5l_inv_1_819.A 0.11212f
C4476 sg13cmos5l_inv_1_241.Y a_7271_3534# 0.0552f
C4477 sg13cmos5l_inv_1_37.Y sg13cmos5l_inv_1_8.A 0.16385f
C4478 sg13cmos5l_inv_1_902.Y a_13288_14610# 0.04359f
C4479 sg13cmos5l_inv_1_177.Y sg13cmos5l_inv_1_141.Y 0.01819f
C4480 sg13cmos5l_inv_1_643.A VPWR 0.58429f
C4481 sg13cmos5l_inv_1_112.Y sg13cmos5l_inv_1_959.Y 0.03673f
C4482 sg13cmos5l_inv_1_835.A VPWR 0.4255f
C4483 a_3847_16261# a_3934_15994# 0.02548f
C4484 a_5005_16000# a_4438_15994# 0.40359f
C4485 a_2152_10790# VPWR 0.13645f
C4486 sg13cmos5l_inv_1_513.A VPWR 0.51808f
C4487 sg13cmos5l_inv_1_882.Y a_10888_14610# 0.01986f
C4488 sg13cmos5l_inv_1_140.A sg13cmos5l_inv_1_78.A 0.10998f
C4489 a_18664_13004# a_19048_13098# 0.03269f
C4490 sg13cmos5l_inv_1_534.A VPWR 0.41234f
C4491 a_10162_9570# a_10504_9192# 0.03354f
C4492 sg13cmos5l_inv_1_798.A sg13cmos5l_inv_1_798.Y 0.8999f
C4493 sg13cmos5l_inv_1_909.A sg13cmos5l_inv_1_910.A 0.20065f
C4494 a_8638_6558# a_9365_6173# 0.01228f
C4495 sg13cmos5l_inv_1_736.Y sg13cmos5l_inv_1_735.Y 0.167f
C4496 sg13cmos5l_inv_1_118.A sg13cmos5l_inv_1_136.Y 0.01811f
C4497 sg13cmos5l_buf_1_10.A invsel[1] 0.06148f
C4498 sg13cmos5l_inv_1_90.Y VPWR 0.66351f
C4499 sg13cmos5l_inv_1_241.A sg13cmos5l_inv_1_306.A 0.17459f
C4500 sg13cmos5l_a21oi_1_1.A2 a_9360_11832# 0.01167f
C4501 sg13cmos5l_inv_1_140.A a_12808_7050# 0.03548f
C4502 sg13cmos5l_inv_1_703.Y sg13cmos5l_inv_1_935.A 0.01942f
C4503 sg13cmos5l_inv_1_730.Y VPWR 0.43457f
C4504 sg13cmos5l_inv_1_802.A sg13cmos5l_inv_1_883.Y 0.10281f
C4505 sg13cmos5l_inv_1_169.Y sg13cmos5l_mux2_1_3.A0 0.09313f
C4506 sg13cmos5l_inv_1_304.Y invsel[0] 0.04425f
C4507 a_808_13004# invsel[4] 0.32113f
C4508 a_8327_6558# a_8104_6254# 0.02107f
C4509 sg13cmos5l_inv_1_926.A a_4736_10074# 0.03508f
C4510 sg13cmos5l_inv_1_921.Y sg13cmos5l_inv_1_983.Y 0.19499f
C4511 sg13cmos5l_inv_1_677.Y a_5984_11586# 0.03627f
C4512 a_12808_10790# VPWR 0.19997f
C4513 sg13cmos5l_o21ai_1_0.B1 sg13cmos5l_inv_1_510.Y 0.08631f
C4514 sg13cmos5l_inv_1_883.Y a_13472_15326# 0.04511f
C4515 a_14183_9582# a_14420_9582# 0.01012f
C4516 a_9633_6516# VPWR 0.7138f
C4517 sg13cmos5l_inv_1_857.A sg13cmos5l_inv_1_857.Y 0.20065f
C4518 sg13cmos5l_inv_1_747.Y sg13cmos5l_inv_1_733.A 0.02283f
C4519 a_16456_14610# VPWR 0.14228f
C4520 sg13cmos5l_inv_1_532.Y sg13cmos5l_inv_1_523.Y 0.05025f
C4521 sg13cmos5l_buf_1_8.A sg13cmos5l_inv_1_152.Y 0.23466f
C4522 sg13cmos5l_inv_1_677.Y VPWR 0.60854f
C4523 sg13cmos5l_inv_1_752.A a_11264_12302# 0.05751f
C4524 sg13cmos5l_mux4_1_13.A3 sg13cmos5l_inv_1_818.Y 0.02483f
C4525 sg13cmos5l_inv_1_78.A sg13cmos5l_inv_1_236.A 0.1326f
C4526 sg13cmos5l_inv_1_588.Y sg13cmos5l_inv_1_605.Y 0.18711f
C4527 sg13cmos5l_inv_1_7.Y sg13cmos5l_inv_1_7.A 0.16465f
C4528 sg13cmos5l_inv_1_1011.A sg13cmos5l_inv_1_258.A 0.45001f
C4529 sg13cmos5l_inv_1_504.Y sg13cmos5l_inv_1_950.A 0.06868f
C4530 sg13cmos5l_inv_1_515.A sg13cmos5l_inv_1_515.Y 0.21402f
C4531 sg13cmos5l_buf_1_9.A sg13cmos5l_inv_1_344.Y 0.06248f
C4532 a_4438_15994# a_4929_16036# 0.3824f
C4533 sg13cmos5l_inv_1_535.Y sg13cmos5l_inv_1_631.A 0.02367f
C4534 a_18856_9980# osc_tap[3] 0.28868f
C4535 sg13cmos5l_inv_1_599.Y sg13cmos5l_inv_1_626.Y 0.1825f
C4536 a_9996_11500# a_9825_11776# 0.16591f
C4537 sg13cmos5l_inv_1_105.Y sg13cmos5l_inv_1_190.A 0.01446f
C4538 sg13cmos5l_inv_1_810.Y a_12896_16838# 0.01203f
C4539 sg13cmos5l_inv_1_305.Y invsel[0] 0.64393f
C4540 a_18280_5444# a_18764_5370# 0.03472f
C4541 sg13cmos5l_inv_1_593.Y sg13cmos5l_inv_1_612.Y 0.05217f
C4542 sg13cmos5l_inv_1_942.Y a_18176_10074# 0.01162f
C4543 sg13cmos5l_inv_1_800.Y sg13cmos5l_inv_1_798.A 0.01769f
C4544 sg13cmos5l_inv_1_325.A sg13cmos5l_inv_1_290.Y 0.01392f
C4545 sg13cmos5l_inv_1_325.Y sg13cmos5l_inv_1_466.Y 0.18238f
C4546 sg13cmos5l_inv_1_283.A sg13cmos5l_inv_1_416.A 0.03636f
C4547 sg13cmos5l_inv_1_317.Y sg13cmos5l_inv_1_314.Y 0.11805f
C4548 sg13cmos5l_inv_1_707.A VPWR 0.45809f
C4549 sg13cmos5l_inv_1_2.Y a_16936_1718# 0.01986f
C4550 sg13cmos5l_inv_1_467.A VPWR 0.51612f
C4551 sg13cmos5l_buf_1_0.A sg13cmos5l_inv_1_7.Y 0.02699f
C4552 a_8123_8472# a_8349_8728# 0.02749f
C4553 sg13cmos5l_mux2_1_4.X sg13cmos5l_mux4_1_3.X 0.45539f
C4554 sg13cmos5l_inv_1_800.Y sg13cmos5l_inv_1_767.A 0.02048f
C4555 sg13cmos5l_a21oi_1_1.A2 sg13cmos5l_inv_1_643.A 0.0277f
C4556 sg13cmos5l_inv_1_297.Y sg13cmos5l_inv_1_295.A 0.05288f
C4557 sg13cmos5l_inv_1_370.Y VPWR 0.50948f
C4558 a_14183_9582# a_14407_9243# 0.01074f
C4559 sg13cmos5l_inv_1_202.Y a_15489_9540# 0.016f
C4560 sg13cmos5l_inv_1_124.Y a_10688_7050# 0.01329f
C4561 sg13cmos5l_inv_1_872.A sg13cmos5l_inv_1_875.Y 0.069f
C4562 sg13cmos5l_inv_1_866.Y sg13cmos5l_inv_1_815.Y 0.09403f
C4563 a_7271_15994# sg13cmos5l_inv_1_582.A 0.08146f
C4564 a_13472_1002# VPWR 0.0685f
C4565 sg13cmos5l_mux4_1_12.A3 sg13cmos5l_inv_1_747.Y 0.25094f
C4566 a_3304_3230# VPWR 0.13092f
C4567 a_16256_15326# VPWR 0.11526f
C4568 sg13cmos5l_inv_1_51.A sg13cmos5l_inv_1_39.A 0.09385f
C4569 sg13cmos5l_inv_1_192.Y sg13cmos5l_inv_1_218.A 0.04579f
C4570 sg13cmos5l_inv_1_878.A sg13cmos5l_inv_1_879.A 0.15902f
C4571 sg13cmos5l_inv_1_635.A sg13cmos5l_inv_1_676.Y 0.03174f
C4572 sg13cmos5l_mux4_1_14.A1 a_14119_15291# 0.01166f
C4573 sg13cmos5l_mux2_1_4.S sg13cmos5l_mux4_1_1.A3 0.12729f
C4574 sg13cmos5l_inv_1_63.A sg13cmos5l_inv_1_60.Y 0.01088f
C4575 sg13cmos5l_inv_1_49.A sg13cmos5l_inv_1_8.A 0.09265f
C4576 sg13cmos5l_inv_1_237.Y sg13cmos5l_inv_1_283.A 0.02365f
C4577 sg13cmos5l_inv_1_78.A sg13cmos5l_mux4_1_16.A2 0.14519f
C4578 sg13cmos5l_inv_1_267.Y sg13cmos5l_inv_1_344.Y 1.09375f
C4579 sg13cmos5l_inv_1_766.A sg13cmos5l_inv_1_767.A 0.20065f
C4580 a_16723_7731# VPWR 0.02431f
C4581 sg13cmos5l_inv_1_156.Y sg13cmos5l_inv_1_179.A 0.01048f
C4582 sg13cmos5l_mux4_1_8.A0 sg13cmos5l_inv_1_616.A 0.02443f
C4583 a_15181_3418# sg13cmos5l_inv_1_16.A 0.02069f
C4584 sg13cmos5l_inv_1_1003.Y sg13cmos5l_inv_1_987.A 0.01506f
C4585 a_17120_4026# VPWR 0.07665f
C4586 sg13cmos5l_mux2_1_4.S sg13cmos5l_inv_1_106.A 0.03074f
C4587 sg13cmos5l_inv_1_883.A sg13cmos5l_inv_1_882.A 0.0126f
C4588 sg13cmos5l_inv_1_49.A sg13cmos5l_inv_1_2.Y 0.03267f
C4589 sg13cmos5l_mux4_1_5.S0 sg13cmos5l_inv_1_488.A 0.03302f
C4590 sg13cmos5l_inv_1_792.Y sg13cmos5l_inv_1_796.Y 0.11183f
C4591 sg13cmos5l_inv_1_37.A sg13cmos5l_inv_1_0.Y 0.01055f
C4592 sg13cmos5l_inv_1_401.Y sg13cmos5l_inv_1_404.Y 0.01429f
C4593 sg13cmos5l_inv_1_664.A a_3304_13814# 0.05166f
C4594 sg13cmos5l_mux4_1_12.A1 sg13cmos5l_inv_1_728.Y 0.07117f
C4595 sg13cmos5l_inv_1_222.Y VPWR 0.42254f
C4596 sg13cmos5l_inv_1_31.A sg13cmos5l_inv_1_46.Y 0.01515f
C4597 sg13cmos5l_inv_1_16.A sg13cmos5l_inv_1_53.Y 0.03023f
C4598 sg13cmos5l_inv_1_682.A a_3680_15326# 0.01173f
C4599 sg13cmos5l_inv_1_427.Y sg13cmos5l_inv_1_427.A 0.21202f
C4600 sg13cmos5l_inv_1_491.A sg13cmos5l_inv_1_492.A 0.11317f
C4601 sg13cmos5l_inv_1_61.Y sg13cmos5l_inv_1_63.A 0.16538f
C4602 sg13cmos5l_inv_1_149.Y VPWR 0.453f
C4603 sg13cmos5l_inv_1_98.Y VPWR 0.43864f
C4604 sg13cmos5l_inv_1_82.A sg13cmos5l_inv_1_89.Y 0.26038f
C4605 a_17896_6254# VPWR 0.13566f
C4606 a_8446_8434# a_8349_8434# 0.01637f
C4607 sg13cmos5l_inv_1_394.A sg13cmos5l_mux2_1_4.X 0.91583f
C4608 sg13cmos5l_inv_1_872.A VPWR 0.53441f
C4609 sg13cmos5l_mux4_1_16.A1 VPWR 0.58254f
C4610 sg13cmos5l_mux4_1_16.A2 a_9142_6558# 0.04599f
C4611 a_8327_6558# a_8564_6558# 0.01012f
C4612 sg13cmos5l_inv_1_618.A a_8192_16838# 0.03589f
C4613 sg13cmos5l_inv_1_316.A a_1480_4026# 0.03352f
C4614 sg13cmos5l_mux4_1_5.S0 sg13cmos5l_inv_1_467.Y 0.38897f
C4615 sg13cmos5l_inv_1_546.Y sg13cmos5l_inv_1_576.A 0.10836f
C4616 sg13cmos5l_inv_1_237.Y sg13cmos5l_inv_1_292.Y 0.02762f
C4617 sg13cmos5l_inv_1_159.A sg13cmos5l_inv_1_156.Y 0.0192f
C4618 a_3934_12606# a_4141_12267# 0.01967f
C4619 sg13cmos5l_inv_1_983.Y sg13cmos5l_inv_1_467.Y 0.02979f
C4620 sg13cmos5l_inv_1_202.Y sg13cmos5l_inv_1_956.Y 0.16035f
C4621 VPWR osc_tap[5] 0.12158f
C4622 sg13cmos5l_inv_1_12.Y sg13cmos5l_inv_1_17.Y 0.43523f
C4623 sg13cmos5l_inv_1_553.Y sg13cmos5l_inv_1_549.A 0.04919f
C4624 sg13cmos5l_mux4_1_5.S1 sg13cmos5l_inv_1_338.Y 0.01114f
C4625 sg13cmos5l_mux4_1_5.S0 a_7414_12970# 0.02642f
C4626 sg13cmos5l_buf_1_27.X VPWR 0.21874f
C4627 sg13cmos5l_inv_1_651.Y sg13cmos5l_inv_1_650.A 0.22992f
C4628 sg13cmos5l_inv_1_419.A sg13cmos5l_inv_1_449.A 0.05504f
C4629 sg13cmos5l_mux4_1_6.X sg13cmos5l_inv_1_407.Y 0.02406f
C4630 sg13cmos5l_mux2_1_4.S sg13cmos5l_inv_1_114.Y 0.12578f
C4631 sg13cmos5l_inv_1_797.Y VPWR 0.44651f
C4632 sg13cmos5l_nor3_1_1.A sg13cmos5l_mux2_1_1.X 0.1515f
C4633 sg13cmos5l_inv_1_335.Y VPWR 0.50632f
C4634 a_13607_14482# a_14036_14482# 0.0289f
C4635 sg13cmos5l_inv_1_75.Y sg13cmos5l_inv_1_75.A 0.18585f
C4636 sg13cmos5l_inv_1_525.A sg13cmos5l_inv_1_504.Y 0.24646f
C4637 sg13cmos5l_inv_1_58.Y sg13cmos5l_inv_1_15.Y 0.05312f
C4638 sg13cmos5l_inv_1_560.A sg13cmos5l_mux4_1_10.A3 0.03919f
C4639 sg13cmos5l_inv_1_215.Y sg13cmos5l_inv_1_106.Y 0.15537f
C4640 sg13cmos5l_mux4_1_3.X sg13cmos5l_inv_1_280.Y 0.01374f
C4641 sg13cmos5l_inv_1_114.Y a_12808_8562# 0.02221f
C4642 sg13cmos5l_mux4_1_8.A0 sg13cmos5l_inv_1_794.A 0.01892f
C4643 sg13cmos5l_inv_1_148.A sg13cmos5l_inv_1_206.A 0.16832f
C4644 sg13cmos5l_mux4_1_5.S0 sg13cmos5l_inv_1_305.A 0.10021f
C4645 sg13cmos5l_inv_1_205.A sg13cmos5l_inv_1_195.Y 0.01316f
C4646 sg13cmos5l_mux4_1_0.A0 sg13cmos5l_inv_1_149.A 0.01555f
C4647 sg13cmos5l_inv_1_191.A VPWR 0.44195f
C4648 sg13cmos5l_mux2_1_0.X sg13cmos5l_inv_1_998.A 0.04076f
C4649 sg13cmos5l_inv_1_819.Y sg13cmos5l_inv_1_819.A 0.40033f
C4650 sg13cmos5l_inv_1_177.Y sg13cmos5l_inv_1_175.A 0.01495f
C4651 sg13cmos5l_inv_1_182.A sg13cmos5l_inv_1_141.Y 0.03062f
C4652 sg13cmos5l_inv_1_514.A sg13cmos5l_inv_1_515.Y 0.09547f
C4653 sg13cmos5l_inv_1_978.A sg13cmos5l_inv_1_959.Y 0.01836f
C4654 sg13cmos5l_inv_1_823.Y VPWR 0.56617f
C4655 a_2632_4742# a_2632_4026# 0.01275f
C4656 sg13cmos5l_inv_1_504.Y VPWR 0.93913f
C4657 sg13cmos5l_inv_1_507.Y VPWR 0.59096f
C4658 a_10268_9172# VPWR 0.01784f
C4659 sg13cmos5l_inv_1_31.Y sg13cmos5l_mux4_1_1.A3 0.02177f
C4660 sg13cmos5l_inv_1_882.A a_10888_14610# 0.03691f
C4661 sg13cmos5l_inv_1_683.Y VPWR 0.65418f
C4662 sg13cmos5l_inv_1_800.Y sg13cmos5l_inv_1_798.Y 0.01227f
C4663 sg13cmos5l_inv_1_908.A sg13cmos5l_inv_1_904.Y 0.01029f
C4664 sg13cmos5l_inv_1_478.Y a_5408_13098# 0.01054f
C4665 sg13cmos5l_nor3_1_2.B a_14027_11654# 0.01784f
C4666 sg13cmos5l_inv_1_349.A sg13cmos5l_inv_1_421.Y 0.05048f
C4667 sg13cmos5l_inv_1_947.A sg13cmos5l_inv_1_997.A 0.03618f
C4668 sg13cmos5l_inv_1_118.A sg13cmos5l_inv_1_140.Y 0.25623f
C4669 sg13cmos5l_mux4_1_15.A3 a_14494_9582# 0.1581f
C4670 sg13cmos5l_inv_1_241.A sg13cmos5l_inv_1_304.A 0.31568f
C4671 sg13cmos5l_inv_1_699.Y VPWR 0.39274f
C4672 sg13cmos5l_mux4_1_16.A2 a_9633_6516# 0.05503f
C4673 a_14422_12606# VPWR 0.08943f
C4674 sg13cmos5l_buf_1_9.A a_13918_12606# 0.09423f
C4675 a_6343_8701# VPWR 0.02431f
C4676 a_3872_4742# VPWR 0.07664f
C4677 sg13cmos5l_mux4_1_5.S1 sg13cmos5l_inv_1_1011.A 1.19062f
C4678 a_1376_14610# VPWR 0.07742f
C4679 sg13cmos5l_inv_1_102.Y sg13cmos5l_inv_1_61.Y 0.05705f
C4680 sg13cmos5l_inv_1_237.A sg13cmos5l_inv_1_945.A 0.04045f
C4681 a_8192_12302# VPWR 0.06714f
C4682 sg13cmos5l_inv_1_487.A a_5984_11586# 0.01324f
C4683 sg13cmos5l_nor2b_1_0.B_N sg13cmos5l_inv_1_571.Y 0.54504f
C4684 sg13cmos5l_inv_1_488.A sg13cmos5l_inv_1_489.A 0.22603f
C4685 a_5408_13098# VPWR 0.07855f
C4686 sg13cmos5l_inv_1_471.Y sg13cmos5l_inv_1_472.Y 0.16468f
C4687 a_9640_1718# VPWR 0.1467f
C4688 a_9326_3410# a_9820_3514# 0.01637f
C4689 sg13cmos5l_inv_1_248.A sg13cmos5l_inv_1_382.Y 0.01633f
C4690 sg13cmos5l_inv_1_580.A a_8672_15326# 0.04419f
C4691 sg13cmos5l_inv_1_731.A VPWR 0.45831f
C4692 a_14183_9582# sg13cmos5l_inv_1_115.A 0.1517f
C4693 sg13cmos5l_inv_1_740.A a_11656_12302# 0.01078f
C4694 sg13cmos5l_inv_1_739.A sg13cmos5l_inv_1_750.Y 0.01609f
C4695 sg13cmos5l_inv_1_750.Y sg13cmos5l_inv_1_761.A 0.11805f
C4696 sg13cmos5l_mux4_1_5.S0 sg13cmos5l_inv_1_325.A 0.03222f
C4697 a_13918_14482# a_14645_14795# 0.01228f
C4698 sg13cmos5l_inv_1_310.Y a_2912_1718# 0.04596f
C4699 sg13cmos5l_mux4_1_5.S0 a_9142_6558# 0.0264f
C4700 sg13cmos5l_inv_1_515.A sg13cmos5l_inv_1_523.Y 0.03785f
C4701 sg13cmos5l_inv_1_487.A VPWR 0.37311f
C4702 sg13cmos5l_mux4_1_5.S0 a_7582_15994# 0.06752f
C4703 sg13cmos5l_mux4_1_13.A3 sg13cmos5l_mux4_1_11.A3 0.0588f
C4704 sg13cmos5l_inv_1_202.Y VPWR 0.63962f
C4705 sg13cmos5l_inv_1_2.A sg13cmos5l_inv_1_7.A 0.01058f
C4706 sg13cmos5l_inv_1_40.Y sg13cmos5l_inv_1_43.Y 0.09242f
C4707 sg13cmos5l_inv_1_332.A sg13cmos5l_inv_1_307.A 0.14456f
C4708 a_3304_6254# VPWR 0.1429f
C4709 sg13cmos5l_buf_1_9.A sg13cmos5l_inv_1_283.A 0.21438f
C4710 sg13cmos5l_inv_1_517.A sg13cmos5l_inv_1_507.Y 0.10619f
C4711 sg13cmos5l_buf_1_27.X osc_tap[3] 0.06198f
C4712 sg13cmos5l_inv_1_834.Y sg13cmos5l_inv_1_843.A 0.75166f
C4713 sg13cmos5l_nor4_1_0.Y a_9825_11776# 0.05354f
C4714 sg13cmos5l_inv_1_599.Y sg13cmos5l_inv_1_612.Y 0.09421f
C4715 sg13cmos5l_inv_1_588.Y sg13cmos5l_inv_1_593.Y 0.02177f
C4716 sg13cmos5l_inv_1_66.Y a_12808_1002# 0.04967f
C4717 a_3623_8070# a_3847_7731# 0.01074f
C4718 sg13cmos5l_buf_1_9.A a_15275_7644# 0.22451f
C4719 sg13cmos5l_buf_1_6.A a_18764_5370# 0.28809f
C4720 sg13cmos5l_inv_1_811.Y a_12896_16838# 0.03539f
C4721 sg13cmos5l_inv_1_258.A sg13cmos5l_inv_1_247.A 0.01806f
C4722 sg13cmos5l_inv_1_608.Y sg13cmos5l_inv_1_627.A 0.01748f
C4723 a_3623_15994# a_3934_15994# 0.49675f
C4724 sg13cmos5l_buf_1_9.A a_5005_16000# 0.3488f
C4725 a_13799_3534# a_14110_3534# 0.49675f
C4726 sg13cmos5l_buf_1_8.A sg13cmos5l_inv_1_1012.Y 0.05919f
C4727 sg13cmos5l_inv_1_986.Y a_18176_10074# 0.03553f
C4728 sg13cmos5l_inv_1_325.A sg13cmos5l_inv_1_466.Y 0.17711f
C4729 sg13cmos5l_inv_1_8.A sg13cmos5l_inv_1_7.Y 0.02163f
C4730 sg13cmos5l_inv_1_283.A sg13cmos5l_inv_1_426.A 0.08853f
C4731 a_14989_3904# a_14422_3898# 0.40359f
C4732 a_11368_8562# sg13cmos5l_inv_1_121.Y 0.01002f
C4733 a_14913_12564# VPWR 0.72501f
C4734 sg13cmos5l_inv_1_668.Y sg13cmos5l_inv_1_511.A 0.11242f
C4735 sg13cmos5l_buf_1_9.A a_13472_12302# 0.03668f
C4736 sg13cmos5l_inv_1_706.A sg13cmos5l_inv_1_728.Y 0.18584f
C4737 sg13cmos5l_inv_1_326.Y a_3934_3534# 0.1219f
C4738 sg13cmos5l_inv_1_2.Y sg13cmos5l_inv_1_7.Y 0.01581f
C4739 sg13cmos5l_inv_1_98.Y a_11176_3230# 0.03488f
C4740 sg13cmos5l_mux4_1_9.A0 sg13cmos5l_nor3_1_2.B 0.27761f
C4741 sg13cmos5l_inv_1_0.A sg13cmos5l_inv_1_0.Y 0.289f
C4742 a_13918_12606# a_14341_12267# 0.01929f
C4743 sg13cmos5l_nor3_1_2.B sg13cmos5l_inv_1_738.Y 0.05894f
C4744 sg13cmos5l_buf_1_0.A sg13cmos5l_inv_1_2.A 0.02434f
C4745 sg13cmos5l_inv_1_124.A a_10688_7050# 0.03651f
C4746 a_14494_9582# a_14917_9243# 0.01929f
C4747 sg13cmos5l_inv_1_874.Y VPWR 0.44596f
C4748 sg13cmos5l_buf_1_23.X a_18664_16028# 0.2906f
C4749 sg13cmos5l_inv_1_769.Y sg13cmos5l_inv_1_828.Y 0.03776f
C4750 sg13cmos5l_inv_1_76.A a_13607_3898# 0.09544f
C4751 sg13cmos5l_inv_1_800.Y sg13cmos5l_inv_1_766.A 0.01975f
C4752 sg13cmos5l_mux4_1_8.A1 a_8086_15994# 0.01598f
C4753 sg13cmos5l_inv_1_22.Y a_16936_1718# 0.03352f
C4754 sg13cmos5l_inv_1_836.A sg13cmos5l_inv_1_851.Y 0.02413f
C4755 sg13cmos5l_inv_1_174.A sg13cmos5l_inv_1_144.Y 0.02413f
C4756 sg13cmos5l_mux4_1_7.A2 sg13cmos5l_inv_1_744.Y 0.32065f
C4757 sg13cmos5l_inv_1_350.A VPWR 0.3561f
C4758 sg13cmos5l_inv_1_619.Y sg13cmos5l_inv_1_582.A 0.0311f
C4759 sg13cmos5l_inv_1_753.A sg13cmos5l_inv_1_747.Y 0.02928f
C4760 sg13cmos5l_inv_1_994.A a_17216_10790# 0.01054f
C4761 sg13cmos5l_inv_1_133.Y sg13cmos5l_inv_1_134.Y 0.20065f
C4762 sg13cmos5l_inv_1_619.Y sg13cmos5l_inv_1_625.Y 0.14907f
C4763 sg13cmos5l_inv_1_267.Y sg13cmos5l_inv_1_283.A 0.16974f
C4764 a_4929_12564# VPWR 0.7251f
C4765 sg13cmos5l_mux4_1_0.A0 a_15637_8028# 0.0222f
C4766 sg13cmos5l_inv_1_480.Y sg13cmos5l_inv_1_987.A 0.01199f
C4767 sg13cmos5l_mux4_1_10.A2 a_3934_15994# 0.13962f
C4768 sg13cmos5l_buf_1_9.A sg13cmos5l_inv_1_884.Y 0.18848f
C4769 sg13cmos5l_mux4_1_5.S0 sg13cmos5l_inv_1_677.Y 0.01215f
C4770 sg13cmos5l_inv_1_49.A sg13cmos5l_inv_1_46.Y 0.0156f
C4771 sg13cmos5l_inv_1_3.Y osc 0.04222f
C4772 sg13cmos5l_mux2_1_3.S a_7425_8476# 0.03517f
C4773 sg13cmos5l_inv_1_807.A sg13cmos5l_inv_1_796.Y 0.02913f
C4774 sg13cmos5l_inv_1_351.Y sg13cmos5l_inv_1_351.A 0.20065f
C4775 sg13cmos5l_inv_1_39.A sg13cmos5l_inv_1_0.Y 0.01164f
C4776 sg13cmos5l_inv_1_664.A sg13cmos5l_inv_1_672.A 0.01319f
C4777 sg13cmos5l_inv_1_675.A sg13cmos5l_inv_1_674.A 0.20065f
C4778 a_4438_15994# VPWR 0.02985f
C4779 sg13cmos5l_inv_1_184.Y VPWR 0.49628f
C4780 sg13cmos5l_buf_1_9.A a_4929_16036# 0.20274f
C4781 sg13cmos5l_mux4_1_16.A1 sg13cmos5l_mux4_1_16.A2 0.3649f
C4782 sg13cmos5l_inv_1_16.A sg13cmos5l_inv_1_48.Y 0.15597f
C4783 sg13cmos5l_inv_1_38.Y sg13cmos5l_inv_1_46.Y 0.02873f
C4784 a_11368_8562# VPWR 0.18108f
C4785 sg13cmos5l_mux4_1_5.S1 sg13cmos5l_inv_1_414.A 0.12445f
C4786 sg13cmos5l_inv_1_103.A sg13cmos5l_inv_1_63.A 0.02094f
C4787 sg13cmos5l_mux4_1_5.S1 sg13cmos5l_inv_1_111.A 0.0169f
C4788 sg13cmos5l_inv_1_83.Y sg13cmos5l_inv_1_88.Y 0.11256f
C4789 sg13cmos5l_inv_1_173.Y VPWR 0.4309f
C4790 sg13cmos5l_inv_1_101.Y VPWR 0.63926f
C4791 sg13cmos5l_inv_1_90.Y sg13cmos5l_inv_1_89.Y 0.13404f
C4792 a_14913_12564# a_15584_12302# 0.03515f
C4793 sg13cmos5l_inv_1_141.A VPWR 0.41078f
C4794 sg13cmos5l_mux4_1_6.X a_8560_8434# 0.02009f
C4795 sg13cmos5l_inv_1_861.A VPWR 0.62271f
C4796 sg13cmos5l_inv_1_931.A sg13cmos5l_inv_1_930.A 0.2026f
C4797 sg13cmos5l_inv_1_397.Y VPWR 0.57466f
C4798 sg13cmos5l_inv_1_584.A sg13cmos5l_inv_1_658.Y 0.0303f
C4799 sg13cmos5l_inv_1_618.A sg13cmos5l_inv_1_618.Y 0.25125f
C4800 sg13cmos5l_inv_1_314.Y a_1480_4026# 0.03871f
C4801 sg13cmos5l_mux4_1_7.A1 VPWR 0.62854f
C4802 sg13cmos5l_inv_1_545.Y sg13cmos5l_inv_1_576.A 0.01746f
C4803 sg13cmos5l_inv_1_546.Y sg13cmos5l_inv_1_548.Y 0.21537f
C4804 sg13cmos5l_inv_1_237.Y sg13cmos5l_inv_1_247.Y 0.02636f
C4805 sg13cmos5l_inv_1_159.A sg13cmos5l_inv_1_155.Y 0.1229f
C4806 sg13cmos5l_inv_1_921.Y sg13cmos5l_inv_1_467.Y 0.01669f
C4807 VPWR invsel[5] 0.10622f
C4808 sg13cmos5l_inv_1_39.A sg13cmos5l_inv_1_37.A 0.74322f
C4809 sg13cmos5l_inv_1_12.Y sg13cmos5l_inv_1_17.A 0.18639f
C4810 sg13cmos5l_inv_1_419.A sg13cmos5l_inv_1_420.A 0.21084f
C4811 sg13cmos5l_mux4_1_6.X sg13cmos5l_inv_1_407.A 0.02024f
C4812 sg13cmos5l_mux4_1_4.X sg13cmos5l_inv_1_407.Y 0.03299f
C4813 sg13cmos5l_inv_1_346.Y VPWR 0.82927f
C4814 sg13cmos5l_nor3_1_1.A sg13cmos5l_inv_1_980.A 0.01982f
C4815 sg13cmos5l_inv_1_608.A sg13cmos5l_inv_1_791.A 0.02956f
C4816 sg13cmos5l_inv_1_797.A VPWR 0.43716f
C4817 sg13cmos5l_buf_1_10.A sg13cmos5l_inv_1_283.A 0.07416f
C4818 sg13cmos5l_inv_1_297.Y VPWR 0.46782f
C4819 sg13cmos5l_inv_1_271.A sg13cmos5l_inv_1_75.A 0.0326f
C4820 sg13cmos5l_o21ai_1_0.B1 a_1576_13814# 0.01117f
C4821 sg13cmos5l_inv_1_525.A sg13cmos5l_inv_1_526.A 0.18916f
C4822 sg13cmos5l_inv_1_105.Y sg13cmos5l_inv_1_106.Y 0.13808f
C4823 sg13cmos5l_inv_1_601.Y a_8680_17634# 0.01059f
C4824 sg13cmos5l_inv_1_205.A sg13cmos5l_inv_1_205.Y 0.23204f
C4825 sg13cmos5l_inv_1_231.Y sg13cmos5l_inv_1_100.A 0.1119f
C4826 sg13cmos5l_inv_1_683.A sg13cmos5l_inv_1_669.A 0.0151f
C4827 sg13cmos5l_mux2_1_0.X sg13cmos5l_inv_1_940.A 0.81504f
C4828 sg13cmos5l_inv_1_826.Y sg13cmos5l_inv_1_819.A 0.1712f
C4829 a_14989_14488# VPWR 0.12226f
C4830 sg13cmos5l_inv_1_514.A sg13cmos5l_inv_1_514.Y 0.24721f
C4831 sg13cmos5l_mux4_1_14.A3 sg13cmos5l_inv_1_910.A 0.01057f
C4832 sg13cmos5l_mux4_1_5.S1 a_13918_3898# 0.09168f
C4833 sg13cmos5l_inv_1_838.Y VPWR 0.3437f
C4834 sg13cmos5l_inv_1_526.A VPWR 0.48783f
C4835 sg13cmos5l_inv_1_112.Y VPWR 0.60853f
C4836 sg13cmos5l_mux4_1_1.X sg13cmos5l_mux4_1_1.A3 0.02665f
C4837 sg13cmos5l_inv_1_113.A sg13cmos5l_inv_1_122.A 0.01229f
C4838 sg13cmos5l_inv_1_949.Y a_10888_14610# 0.03609f
C4839 sg13cmos5l_inv_1_681.Y VPWR 0.93037f
C4840 sg13cmos5l_inv_1_510.Y a_2632_13098# 0.01986f
C4841 sg13cmos5l_inv_1_889.Y sg13cmos5l_inv_1_903.Y 0.62344f
C4842 sg13cmos5l_inv_1_349.A sg13cmos5l_inv_1_434.A 0.15542f
C4843 sg13cmos5l_inv_1_340.Y sg13cmos5l_inv_1_364.A 0.0523f
C4844 a_9360_11832# a_9160_11586# 0.02227f
C4845 sg13cmos5l_inv_1_901.Y sg13cmos5l_inv_1_936.A 0.01942f
C4846 sg13cmos5l_inv_1_730.A sg13cmos5l_inv_1_699.A 0.01108f
C4847 sg13cmos5l_inv_1_704.Y VPWR 0.35796f
C4848 sg13cmos5l_inv_1_841.Y a_18664_16838# 0.01054f
C4849 sg13cmos5l_inv_1_416.A VPWR 0.46688f
C4850 sg13cmos5l_inv_1_926.A sg13cmos5l_inv_1_921.Y 0.20065f
C4851 sg13cmos5l_inv_1_771.A sg13cmos5l_inv_1_771.Y 0.22009f
C4852 sg13cmos5l_inv_1_668.A VPWR 0.35164f
C4853 sg13cmos5l_inv_1_327.A sg13cmos5l_inv_1_312.Y 0.03892f
C4854 sg13cmos5l_inv_1_336.A a_1472_2514# 0.03618f
C4855 sg13cmos5l_inv_1_102.Y sg13cmos5l_inv_1_103.A 0.6242f
C4856 sg13cmos5l_mux4_1_5.S0 sg13cmos5l_mux4_1_16.A1 0.0305f
C4857 sg13cmos5l_inv_1_237.A sg13cmos5l_inv_1_945.Y 0.0156f
C4858 sg13cmos5l_inv_1_421.A sg13cmos5l_inv_1_283.A 0.06798f
C4859 sg13cmos5l_inv_1_344.A sg13cmos5l_inv_1_344.Y 0.09131f
C4860 sg13cmos5l_inv_1_984.Y a_5024_9278# 0.01059f
C4861 sg13cmos5l_nor2b_1_0.B_N sg13cmos5l_inv_1_549.A 0.01836f
C4862 sg13cmos5l_inv_1_866.Y a_18184_16838# 0.05409f
C4863 sg13cmos5l_inv_1_474.Y sg13cmos5l_inv_1_472.Y 0.01408f
C4864 sg13cmos5l_inv_1_981.Y VPWR 0.62227f
C4865 a_9432_3406# sg13cmos5l_mux4_1_3.X 0.16688f
C4866 sg13cmos5l_o21ai_1_0.B1 sg13cmos5l_inv_1_680.A 0.0533f
C4867 sg13cmos5l_inv_1_580.A sg13cmos5l_inv_1_642.Y 0.02242f
C4868 sg13cmos5l_inv_1_1002.A VPWR 0.71228f
C4869 sg13cmos5l_inv_1_324.Y VPWR 1.06167f
C4870 sg13cmos5l_inv_1_847.Y sg13cmos5l_inv_1_857.A 0.20065f
C4871 sg13cmos5l_inv_1_990.A sg13cmos5l_inv_1_990.Y 0.20857f
C4872 a_13288_11586# a_13472_11586# 0.11523f
C4873 sg13cmos5l_mux4_1_13.A3 sg13cmos5l_inv_1_816.Y 0.01651f
C4874 sg13cmos5l_mux2_1_4.S sg13cmos5l_mux4_1_2.X 0.04327f
C4875 sg13cmos5l_mux4_1_14.A3 sg13cmos5l_inv_1_879.A 0.0439f
C4876 a_2632_4742# a_2816_4742# 0.11523f
C4877 sg13cmos5l_nor3_1_1.B sg13cmos5l_mux2_1_1.X 0.22538f
C4878 sg13cmos5l_nor4_1_0.A a_10437_10240# 0.02822f
C4879 sg13cmos5l_inv_1_677.A VPWR 0.43463f
C4880 sg13cmos5l_buf_1_8.A sg13cmos5l_inv_1_149.A 0.48499f
C4881 a_14913_14524# VPWR 0.70588f
C4882 sg13cmos5l_inv_1_588.A sg13cmos5l_inv_1_605.Y 0.01788f
C4883 sg13cmos5l_inv_1_585.Y a_5320_18350# 0.01986f
C4884 sg13cmos5l_inv_1_599.Y sg13cmos5l_inv_1_588.Y 0.16182f
C4885 sg13cmos5l_inv_1_78.A sg13cmos5l_inv_1_192.Y 0.01199f
C4886 sg13cmos5l_inv_1_287.A sg13cmos5l_inv_1_258.A 0.02967f
C4887 a_7271_3534# sg13cmos5l_inv_1_1011.A 0.1971f
C4888 sg13cmos5l_inv_1_504.Y sg13cmos5l_inv_1_515.Y 0.05602f
C4889 sg13cmos5l_inv_1_237.Y VPWR 1.75198f
C4890 sg13cmos5l_inv_1_513.A sg13cmos5l_inv_1_514.Y 0.06481f
C4891 a_3623_15994# a_3860_15994# 0.01012f
C4892 sg13cmos5l_mux4_1_14.A1 a_13918_14482# 0.16005f
C4893 sg13cmos5l_inv_1_128.Y a_12808_6254# 0.04682f
C4894 sg13cmos5l_mux4_1_15.X a_15489_9540# 0.20906f
C4895 sg13cmos5l_or2_1_0.X a_9825_11776# 0.20654f
C4896 sg13cmos5l_inv_1_811.Y sg13cmos5l_inv_1_810.Y 0.32017f
C4897 sg13cmos5l_inv_1_305.Y invsel[1] 0.62266f
C4898 sg13cmos5l_buf_1_12.X VPWR 1.24537f
C4899 sg13cmos5l_inv_1_258.A sg13cmos5l_inv_1_249.Y 0.17616f
C4900 sg13cmos5l_inv_1_726.A a_18088_12302# 0.03601f
C4901 sg13cmos5l_nor3_1_2.B sg13cmos5l_inv_1_762.Y 0.14093f
C4902 sg13cmos5l_inv_1_589.Y sg13cmos5l_inv_1_593.Y 0.2268f
C4903 sg13cmos5l_or2_1_0.B a_9825_11776# 0.01052f
C4904 sg13cmos5l_inv_1_994.Y a_18176_10074# 0.03465f
C4905 sg13cmos5l_inv_1_185.A a_15584_5538# 0.01054f
C4906 sg13cmos5l_inv_1_8.A sg13cmos5l_inv_1_2.A 0.04137f
C4907 sg13cmos5l_inv_1_325.A sg13cmos5l_inv_1_325.Y 0.22553f
C4908 sg13cmos5l_inv_1_707.A sg13cmos5l_inv_1_728.Y 0.01451f
C4909 sg13cmos5l_inv_1_2.Y sg13cmos5l_inv_1_2.A 0.31228f
C4910 a_13607_3898# a_13472_4026# 0.01143f
C4911 sg13cmos5l_inv_1_76.A a_14422_3898# 0.23529f
C4912 sg13cmos5l_inv_1_8.Y sg13cmos5l_inv_1_0.Y 0.06978f
C4913 sg13cmos5l_inv_1_166.Y sg13cmos5l_inv_1_165.Y 0.02521f
C4914 sg13cmos5l_mux4_1_5.S0 a_6343_8701# 0.01113f
C4915 sg13cmos5l_mux4_1_8.A0 sg13cmos5l_inv_1_804.A 0.05669f
C4916 sg13cmos5l_inv_1_828.Y sg13cmos5l_inv_1_890.A 0.03045f
C4917 sg13cmos5l_inv_1_874.A VPWR 0.41901f
C4918 sg13cmos5l_inv_1_138.A a_13472_7050# 0.03481f
C4919 sg13cmos5l_inv_1_185.A a_15104_4742# 0.03465f
C4920 sg13cmos5l_inv_1_762.Y sg13cmos5l_mux4_1_11.A2 0.01967f
C4921 sg13cmos5l_inv_1_852.Y sg13cmos5l_inv_1_851.Y 0.02521f
C4922 sg13cmos5l_inv_1_378.Y VPWR 0.41879f
C4923 sg13cmos5l_mux4_1_7.A2 sg13cmos5l_inv_1_743.Y 0.01149f
C4924 sg13cmos5l_inv_1_217.A sg13cmos5l_inv_1_186.Y 0.54843f
C4925 sg13cmos5l_inv_1_568.Y sg13cmos5l_inv_1_568.A 0.23332f
C4926 sg13cmos5l_buf_1_7.X a_808_1632# 0.29366f
C4927 sg13cmos5l_buf_1_9.A sg13cmos5l_mux4_1_14.A0 1.02549f
C4928 a_14027_11654# a_14389_11500# 0.48298f
C4929 sg13cmos5l_inv_1_191.Y sg13cmos5l_inv_1_192.Y 0.21202f
C4930 a_16456_9278# VPWR 0.12397f
C4931 sg13cmos5l_inv_1_698.A a_17216_10790# 0.03508f
C4932 sg13cmos5l_mux4_1_8.A2 VPWR 0.70232f
C4933 a_2632_11586# a_2816_11586# 0.11523f
C4934 sg13cmos5l_mux4_1_10.A3 sg13cmos5l_inv_1_658.Y 0.17102f
C4935 sg13cmos5l_inv_1_115.Y a_13472_8562# 0.01076f
C4936 sg13cmos5l_inv_1_185.Y a_15104_4742# 0.01059f
C4937 sg13cmos5l_inv_1_835.A sg13cmos5l_inv_1_837.Y 0.19028f
C4938 a_6910_12970# a_7905_13012# 0.48298f
C4939 a_15275_7644# sg13cmos5l_inv_1_179.A 0.05072f
C4940 sg13cmos5l_inv_1_513.A sg13cmos5l_inv_1_515.A 0.0102f
C4941 sg13cmos5l_inv_1_480.Y sg13cmos5l_inv_1_493.A 0.01506f
C4942 sg13cmos5l_mux4_1_16.X sg13cmos5l_inv_1_108.Y 0.03143f
C4943 sg13cmos5l_inv_1_533.A a_3934_15994# 0.04149f
C4944 sg13cmos5l_buf_1_9.A sg13cmos5l_inv_1_916.A 0.05235f
C4945 a_1480_1718# VPWR 0.14312f
C4946 sg13cmos5l_mux4_1_5.S0 sg13cmos5l_inv_1_487.A 0.01329f
C4947 sg13cmos5l_inv_1_370.Y sg13cmos5l_inv_1_351.A 0.01088f
C4948 sg13cmos5l_inv_1_403.Y sg13cmos5l_inv_1_412.A 0.02521f
C4949 sg13cmos5l_inv_1_350.A a_800_8562# 0.01083f
C4950 sg13cmos5l_mux4_1_5.S1 sg13cmos5l_inv_1_45.Y 0.0434f
C4951 sg13cmos5l_inv_1_252.Y sg13cmos5l_inv_1_250.Y 0.20065f
C4952 sg13cmos5l_inv_1_83.Y VPWR 0.89634f
C4953 a_15768_4088# sg13cmos5l_mux4_1_1.X 0.02914f
C4954 sg13cmos5l_mux2_1_4.X sg13cmos5l_mux4_1_5.S1 0.72466f
C4955 a_13472_2514# VPWR 0.07032f
C4956 sg13cmos5l_inv_1_16.A sg13cmos5l_inv_1_12.Y 0.13829f
C4957 sg13cmos5l_inv_1_683.Y a_3680_15326# 0.03646f
C4958 sg13cmos5l_inv_1_438.A sg13cmos5l_inv_1_427.Y 0.20864f
C4959 sg13cmos5l_inv_1_102.Y sg13cmos5l_inv_1_63.A 0.12174f
C4960 sg13cmos5l_inv_1_83.Y sg13cmos5l_inv_1_88.A 0.76675f
C4961 sg13cmos5l_inv_1_215.Y VPWR 0.35502f
C4962 sg13cmos5l_inv_1_90.Y sg13cmos5l_inv_1_82.A 0.05909f
C4963 sg13cmos5l_inv_1_205.A VPWR 0.57303f
C4964 sg13cmos5l_inv_1_938.A a_13472_10074# 0.03508f
C4965 sg13cmos5l_inv_1_931.Y sg13cmos5l_inv_1_930.A 0.01407f
C4966 a_13856_11586# VPWR 0.07458f
C4967 sg13cmos5l_inv_1_391.A VPWR 0.62061f
C4968 a_8327_6558# sg13cmos5l_inv_1_445.A 0.08795f
C4969 sg13cmos5l_mux2_1_4.S sg13cmos5l_inv_1_892.A 0.05957f
C4970 sg13cmos5l_inv_1_545.Y sg13cmos5l_inv_1_548.Y 0.10734f
C4971 sg13cmos5l_inv_1_730.Y sg13cmos5l_inv_1_729.Y 0.20065f
C4972 sg13cmos5l_inv_1_926.A sg13cmos5l_inv_1_467.Y 0.01374f
C4973 VPWR osc_tap[6] 0.18718f
C4974 sg13cmos5l_inv_1_652.Y sg13cmos5l_inv_1_651.Y 0.15106f
C4975 a_14389_11500# a_15056_11771# 0.01929f
C4976 sg13cmos5l_buf_1_9.A sg13cmos5l_inv_1_478.Y 0.05814f
C4977 sg13cmos5l_mux4_1_6.X sg13cmos5l_inv_1_409.Y 0.01996f
C4978 sg13cmos5l_mux4_1_4.X sg13cmos5l_inv_1_407.A 0.01939f
C4979 sg13cmos5l_inv_1_799.A VPWR 0.44833f
C4980 sg13cmos5l_inv_1_331.A VPWR 1.23137f
C4981 sg13cmos5l_nor3_1_1.A sg13cmos5l_inv_1_923.Y 0.0397f
C4982 sg13cmos5l_inv_1_271.A sg13cmos5l_inv_1_75.Y 0.12066f
C4983 sg13cmos5l_o21ai_1_0.B1 sg13cmos5l_inv_1_510.A 0.21517f
C4984 sg13cmos5l_inv_1_137.A sg13cmos5l_inv_1_106.Y 0.04782f
C4985 sg13cmos5l_inv_1_105.Y sg13cmos5l_inv_1_107.Y 0.01481f
C4986 sg13cmos5l_inv_1_525.A sg13cmos5l_inv_1_526.Y 0.01598f
C4987 sg13cmos5l_inv_1_617.A sg13cmos5l_inv_1_791.A 0.02419f
C4988 sg13cmos5l_buf_1_8.A a_15637_8028# 0.07394f
C4989 a_18272_3230# VPWR 0.08506f
C4990 sg13cmos5l_a21oi_1_0.B1 sg13cmos5l_inv_1_519.Y 0.02415f
C4991 sg13cmos5l_inv_1_258.A a_8086_3534# 0.01934f
C4992 sg13cmos5l_inv_1_284.A sg13cmos5l_inv_1_272.A 0.12523f
C4993 sg13cmos5l_inv_1_69.A sg13cmos5l_mux4_1_5.X 0.01496f
C4994 sg13cmos5l_mux2_1_4.S a_9832_4026# 0.01982f
C4995 sg13cmos5l_mux4_1_14.A0 sg13cmos5l_inv_1_796.Y 0.17613f
C4996 sg13cmos5l_mux4_1_11.A3 a_14027_11654# 0.01422f
C4997 sg13cmos5l_inv_1_830.A VPWR 0.4077f
C4998 sg13cmos5l_inv_1_526.Y VPWR 0.50804f
C4999 sg13cmos5l_inv_1_978.A VPWR 0.42792f
C5000 sg13cmos5l_mux4_1_5.S0 a_4438_15994# 0.03937f
C5001 sg13cmos5l_buf_1_9.A VPWR 7.62773f
C5002 a_12896_13814# VPWR 0.12411f
C5003 sg13cmos5l_inv_1_478.A a_5408_13098# 0.03465f
C5004 sg13cmos5l_inv_1_874.Y a_14206_15630# 0.11429f
C5005 sg13cmos5l_nor3_1_1.A a_8795_11752# 0.02531f
C5006 sg13cmos5l_inv_1_340.Y sg13cmos5l_inv_1_368.Y 0.14062f
C5007 sg13cmos5l_inv_1_138.Y a_13472_7050# 0.01059f
C5008 sg13cmos5l_inv_1_130.A sg13cmos5l_inv_1_105.Y 0.57952f
C5009 a_10688_2514# VPWR 0.08214f
C5010 sg13cmos5l_inv_1_213.A a_18176_4742# 0.04504f
C5011 sg13cmos5l_mux4_1_15.X VPWR 0.37928f
C5012 sg13cmos5l_inv_1_802.A sg13cmos5l_inv_1_884.Y 0.03641f
C5013 sg13cmos5l_inv_1_70.A sg13cmos5l_inv_1_74.A 0.11022f
C5014 sg13cmos5l_inv_1_118.Y sg13cmos5l_mux2_1_3.A0 1.08368f
C5015 sg13cmos5l_inv_1_362.Y sg13cmos5l_inv_1_431.A 0.09933f
C5016 sg13cmos5l_inv_1_871.Y a_18664_16838# 0.01986f
C5017 sg13cmos5l_inv_1_426.A VPWR 0.42467f
C5018 sg13cmos5l_mux4_1_5.S1 sg13cmos5l_inv_1_287.A 0.52799f
C5019 sg13cmos5l_inv_1_681.A VPWR 0.64972f
C5020 sg13cmos5l_inv_1_327.A sg13cmos5l_inv_1_328.A 0.1599f
C5021 sg13cmos5l_inv_1_237.A sg13cmos5l_inv_1_238.A 0.02168f
C5022 sg13cmos5l_mux2_1_0.X sg13cmos5l_inv_1_128.Y 0.17932f
C5023 sg13cmos5l_mux4_1_5.S0 sg13cmos5l_mux4_1_7.A1 0.80661f
C5024 sg13cmos5l_mux2_1_4.S sg13cmos5l_nor3_1_2.B 0.04654f
C5025 a_9982_8050# a_10159_7704# 0.01068f
C5026 a_14998_9582# a_15489_9540# 0.3824f
C5027 sg13cmos5l_inv_1_344.A sg13cmos5l_inv_1_283.A 0.02127f
C5028 sg13cmos5l_mux2_1_0.X sg13cmos5l_inv_1_185.A 0.09362f
C5029 sg13cmos5l_inv_1_677.Y sg13cmos5l_inv_1_488.A 0.01901f
C5030 a_11464_16838# VPWR 0.13693f
C5031 sg13cmos5l_inv_1_474.Y sg13cmos5l_inv_1_471.Y 0.2023f
C5032 sg13cmos5l_inv_1_1007.Y sg13cmos5l_inv_1_472.Y 0.01052f
C5033 sg13cmos5l_inv_1_65.Y VPWR 0.42571f
C5034 sg13cmos5l_inv_1_462.Y a_5792_6254# 0.03465f
C5035 sg13cmos5l_inv_1_702.Y sg13cmos5l_inv_1_700.Y 0.11165f
C5036 sg13cmos5l_o21ai_1_0.B1 sg13cmos5l_inv_1_689.Y 0.06678f
C5037 sg13cmos5l_inv_1_990.A sg13cmos5l_inv_1_991.A 0.06004f
C5038 sg13cmos5l_inv_1_802.A a_13288_16122# 0.04348f
C5039 sg13cmos5l_buf_1_12.X sg13cmos5l_mux4_1_16.A2 0.01627f
C5040 sg13cmos5l_mux4_1_5.S0 sg13cmos5l_inv_1_346.Y 0.06478f
C5041 sg13cmos5l_inv_1_747.Y a_11656_12302# 0.04247f
C5042 sg13cmos5l_mux4_1_13.A3 sg13cmos5l_inv_1_816.A 0.19409f
C5043 sg13cmos5l_mux4_1_5.S0 sg13cmos5l_inv_1_297.Y 0.01357f
C5044 sg13cmos5l_mux4_1_14.A3 sg13cmos5l_inv_1_878.A 0.59127f
C5045 sg13cmos5l_inv_1_258.A a_7582_3534# 0.14496f
C5046 sg13cmos5l_mux2_1_3.S sg13cmos5l_inv_1_394.A 0.35975f
C5047 sg13cmos5l_mux2_1_2.A0 sg13cmos5l_inv_1_684.A 0.15973f
C5048 sg13cmos5l_inv_1_507.A VPWR 0.44153f
C5049 sg13cmos5l_mux2_1_0.X sg13cmos5l_inv_1_185.Y 0.08703f
C5050 sg13cmos5l_inv_1_113.A VPWR 0.70837f
C5051 sg13cmos5l_mux2_1_4.S sg13cmos5l_mux4_1_11.A2 0.31992f
C5052 sg13cmos5l_inv_1_588.A sg13cmos5l_inv_1_588.Y 0.1954f
C5053 sg13cmos5l_inv_1_78.A sg13cmos5l_inv_1_191.Y 0.32061f
C5054 sg13cmos5l_inv_1_40.Y sg13cmos5l_inv_1_18.Y 0.07593f
C5055 sg13cmos5l_inv_1_711.Y a_17896_13098# 0.01986f
C5056 sg13cmos5l_inv_1_513.A sg13cmos5l_inv_1_514.A 0.18911f
C5057 sg13cmos5l_inv_1_526.A sg13cmos5l_inv_1_515.Y 0.01438f
C5058 sg13cmos5l_inv_1_267.Y VPWR 0.69983f
C5059 sg13cmos5l_nor2b_1_0.B_N a_808_15326# 0.05192f
C5060 sg13cmos5l_mux4_1_8.A0 sg13cmos5l_inv_1_582.A 0.01022f
C5061 sg13cmos5l_inv_1_823.A sg13cmos5l_inv_1_836.Y 0.03069f
C5062 a_13288_7766# VPWR 0.1312f
C5063 sg13cmos5l_inv_1_195.Y a_18176_5538# 0.03508f
C5064 sg13cmos5l_inv_1_720.Y a_19048_12302# 0.01107f
C5065 sg13cmos5l_inv_1_45.Y sg13cmos5l_mux4_1_1.A3 0.17985f
C5066 a_13607_3898# a_13844_3898# 0.01012f
C5067 sg13cmos5l_inv_1_535.Y sg13cmos5l_inv_1_593.Y 0.22305f
C5068 sg13cmos5l_nor3_1_2.B sg13cmos5l_inv_1_761.A 0.02305f
C5069 sg13cmos5l_mux4_1_12.A1 a_14422_12606# 0.0153f
C5070 sg13cmos5l_mux4_1_8.A0 sg13cmos5l_inv_1_625.Y 0.01834f
C5071 sg13cmos5l_inv_1_928.A a_18176_10074# 0.01182f
C5072 sg13cmos5l_inv_1_346.Y a_3934_8070# 0.16953f
C5073 a_3623_8070# a_4052_8070# 0.0289f
C5074 sg13cmos5l_inv_1_259.Y a_7808_1718# 0.03508f
C5075 sg13cmos5l_buf_1_8.A a_14027_11654# 0.20766f
C5076 sg13cmos5l_inv_1_707.A sg13cmos5l_inv_1_706.A 0.1623f
C5077 a_3623_3534# a_3934_3534# 0.49675f
C5078 sg13cmos5l_inv_1_6.Y a_16936_1718# 0.01115f
C5079 sg13cmos5l_inv_1_2.Y sg13cmos5l_inv_1_40.Y 0.06768f
C5080 sg13cmos5l_inv_1_120.A sg13cmos5l_inv_1_976.Y 0.13547f
C5081 sg13cmos5l_inv_1_511.A sg13cmos5l_nor3_1_2.B 0.04671f
C5082 sg13cmos5l_inv_1_8.Y sg13cmos5l_inv_1_0.A 0.04441f
C5083 sg13cmos5l_inv_1_166.Y sg13cmos5l_inv_1_171.Y 0.04282f
C5084 sg13cmos5l_mux4_1_9.A0 a_3934_12606# 0.01673f
C5085 sg13cmos5l_inv_1_372.Y a_1184_7050# 0.01329f
C5086 sg13cmos5l_mux4_1_7.A2 sg13cmos5l_inv_1_753.A 0.02842f
C5087 sg13cmos5l_inv_1_796.Y VPWR 0.4264f
C5088 sg13cmos5l_inv_1_770.A sg13cmos5l_inv_1_828.Y 0.0377f
C5089 sg13cmos5l_inv_1_774.Y sg13cmos5l_inv_1_769.Y 0.2307f
C5090 sg13cmos5l_inv_1_185.A sg13cmos5l_inv_1_185.Y 0.20949f
C5091 sg13cmos5l_inv_1_16.Y sg13cmos5l_inv_1_7.Y 0.03228f
C5092 sg13cmos5l_inv_1_852.Y sg13cmos5l_inv_1_853.Y 0.23278f
C5093 sg13cmos5l_mux4_1_7.A2 sg13cmos5l_inv_1_741.Y 0.01043f
C5094 sg13cmos5l_inv_1_217.A sg13cmos5l_inv_1_142.A 0.03872f
C5095 sg13cmos5l_inv_1_741.Y a_10592_13098# 0.05751f
C5096 sg13cmos5l_buf_1_9.A sg13cmos5l_a21oi_1_1.A2 0.1822f
C5097 sg13cmos5l_inv_1_467.A sg13cmos5l_inv_1_467.Y 0.5172f
C5098 sg13cmos5l_mux2_1_4.S sg13cmos5l_inv_1_707.Y 0.25131f
C5099 a_2144_7050# VPWR 0.08324f
C5100 sg13cmos5l_inv_1_698.A sg13cmos5l_inv_1_994.A 0.19503f
C5101 sg13cmos5l_inv_1_132.Y sg13cmos5l_inv_1_133.Y 0.18681f
C5102 sg13cmos5l_inv_1_947.A a_2816_11586# 0.01054f
C5103 sg13cmos5l_inv_1_517.A sg13cmos5l_inv_1_507.A 0.01743f
C5104 sg13cmos5l_mux4_1_5.S0 sg13cmos5l_inv_1_324.Y 0.17614f
C5105 sg13cmos5l_inv_1_445.A sg13cmos5l_inv_1_270.Y 0.02341f
C5106 sg13cmos5l_mux4_1_10.A3 a_4936_15326# 0.04415f
C5107 sg13cmos5l_buf_1_10.A VPWR 1.84664f
C5108 sg13cmos5l_inv_1_823.Y sg13cmos5l_inv_1_837.Y 0.01734f
C5109 sg13cmos5l_inv_1_504.Y sg13cmos5l_inv_1_515.A 0.79207f
C5110 sg13cmos5l_buf_1_9.A sg13cmos5l_inv_1_768.A 0.01124f
C5111 sg13cmos5l_inv_1_313.Y VPWR 0.4551f
C5112 sg13cmos5l_inv_1_378.Y a_800_8562# 0.03589f
C5113 sg13cmos5l_inv_1_370.Y sg13cmos5l_inv_1_351.Y 0.04371f
C5114 sg13cmos5l_inv_1_403.Y sg13cmos5l_inv_1_401.Y 0.10138f
C5115 sg13cmos5l_inv_1_669.A sg13cmos5l_inv_1_675.A 0.20065f
C5116 sg13cmos5l_inv_1_130.Y sg13cmos5l_inv_1_130.A 0.16873f
C5117 sg13cmos5l_mux4_1_5.S0 sg13cmos5l_inv_1_237.Y 0.03572f
C5118 sg13cmos5l_mux4_1_2.X sg13cmos5l_mux4_1_1.X 0.53179f
C5119 sg13cmos5l_mux4_1_12.A1 a_14913_12564# 0.01456f
C5120 sg13cmos5l_inv_1_38.Y sg13cmos5l_inv_1_6.Y 0.09158f
C5121 sg13cmos5l_inv_1_800.A sg13cmos5l_mux4_1_14.A0 0.01443f
C5122 sg13cmos5l_inv_1_683.Y sg13cmos5l_inv_1_682.A 0.33385f
C5123 sg13cmos5l_inv_1_58.Y sg13cmos5l_inv_1_56.Y 0.23524f
C5124 sg13cmos5l_inv_1_454.Y sg13cmos5l_inv_1_415.A 0.01538f
C5125 sg13cmos5l_mux4_1_5.S0 sg13cmos5l_buf_1_12.X 1.34589f
C5126 sg13cmos5l_inv_1_972.Y sg13cmos5l_inv_1_980.A 0.01722f
C5127 a_4475_13008# a_4264_13098# 0.0213f
C5128 a_17696_1718# VPWR 0.08129f
C5129 a_9142_6558# a_9633_6516# 0.3824f
C5130 sg13cmos5l_inv_1_283.A sg13cmos5l_inv_1_69.A 0.03392f
C5131 a_3623_3534# a_3488_3230# 0.01143f
C5132 sg13cmos5l_inv_1_105.Y VPWR 0.47116f
C5133 sg13cmos5l_inv_1_206.A VPWR 0.4802f
C5134 sg13cmos5l_mux4_1_5.S1 a_8086_3534# 0.05535f
C5135 sg13cmos5l_inv_1_964.Y sg13cmos5l_inv_1_394.A 0.11203f
C5136 sg13cmos5l_inv_1_931.Y sg13cmos5l_inv_1_931.A 0.16471f
C5137 sg13cmos5l_inv_1_228.Y a_13472_5538# 0.04288f
C5138 sg13cmos5l_inv_1_316.A sg13cmos5l_inv_1_337.Y 0.18584f
C5139 sg13cmos5l_inv_1_314.Y a_800_4026# 0.0111f
C5140 a_16256_10790# VPWR 0.07707f
C5141 sg13cmos5l_mux4_1_5.S1 sg13cmos5l_inv_1_311.Y 0.04588f
C5142 sg13cmos5l_inv_1_584.A sg13cmos5l_inv_1_581.A 0.0297f
C5143 sg13cmos5l_mux2_1_4.S sg13cmos5l_mux4_1_11.A1 0.92768f
C5144 sg13cmos5l_inv_1_545.Y sg13cmos5l_inv_1_546.Y 0.12201f
C5145 sg13cmos5l_inv_1_553.Y sg13cmos5l_inv_1_576.A 0.08748f
C5146 sg13cmos5l_inv_1_237.Y sg13cmos5l_inv_1_466.Y 0.7469f
C5147 sg13cmos5l_inv_1_961.Y sg13cmos5l_mux4_1_15.A2 0.16025f
C5148 sg13cmos5l_mux4_1_9.A0 sg13cmos5l_buf_1_8.A 0.28089f
C5149 sg13cmos5l_inv_1_862.A sg13cmos5l_mux4_1_13.A3 0.05245f
C5150 sg13cmos5l_inv_1_326.Y sg13cmos5l_inv_1_310.Y 0.12175f
C5151 VPWR osc_tap[7] 0.12603f
C5152 sg13cmos5l_inv_1_68.A sg13cmos5l_inv_1_73.A 0.2023f
C5153 sg13cmos5l_mux2_1_4.S a_13918_14482# 0.03316f
C5154 sg13cmos5l_buf_1_12.X a_3934_8070# 0.01038f
C5155 sg13cmos5l_inv_1_676.Y a_6664_13814# 0.03439f
C5156 sg13cmos5l_buf_1_9.A a_4072_3932# 0.32811f
C5157 sg13cmos5l_mux4_1_5.S1 a_14494_9582# 0.06057f
C5158 sg13cmos5l_buf_1_9.A sg13cmos5l_inv_1_482.Y 0.02272f
C5159 sg13cmos5l_mux4_1_6.X sg13cmos5l_inv_1_387.Y 0.04866f
C5160 sg13cmos5l_inv_1_421.A VPWR 0.83642f
C5161 sg13cmos5l_inv_1_995.Y VPWR 0.44267f
C5162 sg13cmos5l_mux4_1_10.A2 a_4264_16838# 0.04637f
C5163 a_7136_6254# VPWR 0.08848f
C5164 sg13cmos5l_inv_1_808.A sg13cmos5l_inv_1_810.Y 0.11788f
C5165 sg13cmos5l_inv_1_584.A sg13cmos5l_inv_1_633.A 0.02419f
C5166 sg13cmos5l_inv_1_608.Y sg13cmos5l_inv_1_791.A 0.14534f
C5167 sg13cmos5l_inv_1_311.Y sg13cmos5l_inv_1_306.A 0.02723f
C5168 sg13cmos5l_mux2_1_4.S sg13cmos5l_mux4_1_2.A2 0.02168f
C5169 a_14998_9582# VPWR 0.02985f
C5170 sg13cmos5l_mux4_1_8.A2 sg13cmos5l_mux4_1_5.S0 0.06491f
C5171 sg13cmos5l_inv_1_66.Y sg13cmos5l_inv_1_67.Y 0.12098f
C5172 sg13cmos5l_inv_1_222.Y sg13cmos5l_inv_1_231.Y 0.20065f
C5173 sg13cmos5l_inv_1_69.A sg13cmos5l_inv_1_292.Y 0.14667f
C5174 a_13472_14610# VPWR 0.0681f
C5175 sg13cmos5l_inv_1_284.A sg13cmos5l_mux4_1_5.X 0.19433f
C5176 sg13cmos5l_mux4_1_14.A0 sg13cmos5l_inv_1_802.A 0.31022f
C5177 sg13cmos5l_inv_1_820.A VPWR 0.42353f
C5178 sg13cmos5l_inv_1_527.A VPWR 0.46934f
C5179 sg13cmos5l_inv_1_977.A VPWR 0.4284f
C5180 sg13cmos5l_inv_1_882.A sg13cmos5l_inv_1_882.Y 0.2781f
C5181 sg13cmos5l_inv_1_904.Y VPWR 0.68041f
C5182 sg13cmos5l_inv_1_510.Y sg13cmos5l_inv_1_525.A 0.01823f
C5183 sg13cmos5l_inv_1_712.A sg13cmos5l_inv_1_696.A 0.03659f
C5184 a_13831_4165# a_13918_3898# 0.02548f
C5185 sg13cmos5l_inv_1_957.Y a_17696_9278# 0.05751f
C5186 sg13cmos5l_inv_1_340.Y sg13cmos5l_inv_1_363.Y 0.07868f
C5187 sg13cmos5l_inv_1_130.A sg13cmos5l_inv_1_137.A 0.04742f
C5188 sg13cmos5l_mux4_1_5.S1 a_7582_3534# 0.04426f
C5189 sg13cmos5l_inv_1_734.Y sg13cmos5l_inv_1_937.A 0.01942f
C5190 a_4438_3534# a_3934_3534# 0.9733f
C5191 sg13cmos5l_inv_1_149.Y sg13cmos5l_inv_1_78.A 0.04176f
C5192 sg13cmos5l_inv_1_702.Y sg13cmos5l_inv_1_699.A 0.10542f
C5193 sg13cmos5l_inv_1_78.A sg13cmos5l_inv_1_98.Y 0.01419f
C5194 sg13cmos5l_inv_1_213.A sg13cmos5l_inv_1_213.Y 0.149f
C5195 sg13cmos5l_inv_1_382.A a_8104_6254# 0.0145f
C5196 sg13cmos5l_inv_1_871.Y sg13cmos5l_buf_1_23.X 0.01288f
C5197 sg13cmos5l_inv_1_425.A VPWR 0.42958f
C5198 sg13cmos5l_inv_1_744.Y sg13cmos5l_inv_1_726.A 0.01166f
C5199 sg13cmos5l_mux4_1_5.S1 sg13cmos5l_inv_1_286.Y 0.02965f
C5200 sg13cmos5l_inv_1_510.Y VPWR 0.48569f
C5201 sg13cmos5l_mux4_1_7.A3 sg13cmos5l_inv_1_639.A 0.16694f
C5202 sg13cmos5l_inv_1_237.A sg13cmos5l_inv_1_244.A 0.05204f
C5203 sg13cmos5l_mux4_1_5.S0 sg13cmos5l_inv_1_391.A 0.18092f
C5204 sg13cmos5l_o21ai_1_0.B1 sg13cmos5l_inv_1_967.Y 0.29935f
C5205 sg13cmos5l_inv_1_969.Y sg13cmos5l_inv_1_984.Y 0.26156f
C5206 sg13cmos5l_inv_1_800.A VPWR 0.56045f
C5207 sg13cmos5l_inv_1_487.A sg13cmos5l_inv_1_488.A 0.12456f
C5208 sg13cmos5l_inv_1_981.A VPWR 0.49678f
C5209 sg13cmos5l_inv_1_1007.Y sg13cmos5l_inv_1_471.Y 0.04466f
C5210 sg13cmos5l_mux2_1_4.S sg13cmos5l_mux4_1_0.A0 0.39745f
C5211 sg13cmos5l_inv_1_619.A sg13cmos5l_inv_1_619.Y 0.10626f
C5212 sg13cmos5l_inv_1_846.Y sg13cmos5l_inv_1_847.Y 0.20065f
C5213 sg13cmos5l_inv_1_997.A sg13cmos5l_inv_1_991.A 0.01419f
C5214 sg13cmos5l_inv_1_747.Y sg13cmos5l_inv_1_750.Y 0.37988f
C5215 sg13cmos5l_mux4_1_13.A3 sg13cmos5l_inv_1_815.A 1.16247f
C5216 sg13cmos5l_inv_1_576.A sg13cmos5l_inv_1_563.Y 0.07269f
C5217 sg13cmos5l_inv_1_16.A a_15016_2514# 0.01382f
C5218 sg13cmos5l_inv_1_518.Y VPWR 0.44422f
C5219 sg13cmos5l_buf_1_8.A sg13cmos5l_inv_1_228.A 0.12241f
C5220 sg13cmos5l_inv_1_258.A sg13cmos5l_inv_1_277.Y 0.02568f
C5221 sg13cmos5l_inv_1_588.A sg13cmos5l_inv_1_599.Y 0.19028f
C5222 sg13cmos5l_inv_1_585.A a_5320_18350# 0.03631f
C5223 sg13cmos5l_inv_1_40.Y sg13cmos5l_inv_1_19.A 0.03429f
C5224 sg13cmos5l_inv_1_594.Y sg13cmos5l_inv_1_588.Y 0.01789f
C5225 sg13cmos5l_inv_1_179.A VPWR 0.82196f
C5226 sg13cmos5l_inv_1_287.A a_7271_3534# 0.37423f
C5227 sg13cmos5l_inv_1_711.Y sg13cmos5l_inv_1_726.A 0.06946f
C5228 sg13cmos5l_inv_1_341.Y VPWR 0.44463f
C5229 sg13cmos5l_inv_1_504.Y sg13cmos5l_inv_1_514.A 0.16107f
C5230 sg13cmos5l_mux4_1_11.A3 sg13cmos5l_inv_1_762.Y 0.02431f
C5231 sg13cmos5l_mux2_1_4.S a_9326_3410# 0.13192f
C5232 sg13cmos5l_mux4_1_5.S1 sg13cmos5l_inv_1_118.A 0.02263f
C5233 sg13cmos5l_buf_1_27.X a_18856_9980# 0.33093f
C5234 sg13cmos5l_inv_1_130.Y VPWR 0.60153f
C5235 sg13cmos5l_inv_1_381.Y sg13cmos5l_inv_1_389.Y 0.0144f
C5236 a_16840_17634# VPWR 0.14337f
C5237 sg13cmos5l_inv_1_305.Y invsel[2] 0.27742f
C5238 sg13cmos5l_inv_1_584.A sg13cmos5l_inv_1_580.A 0.11264f
C5239 a_14422_3898# a_14913_3940# 0.3824f
C5240 sg13cmos5l_mux4_1_2.A2 sg13cmos5l_inv_1_31.Y 0.1963f
C5241 sg13cmos5l_inv_1_535.Y sg13cmos5l_inv_1_589.Y 0.01322f
C5242 sg13cmos5l_mux4_1_5.S0 sg13cmos5l_buf_1_9.A 0.40468f
C5243 sg13cmos5l_inv_1_797.Y sg13cmos5l_inv_1_786.Y 0.20065f
C5244 sg13cmos5l_inv_1_537.Y sg13cmos5l_inv_1_681.Y 0.03973f
C5245 sg13cmos5l_inv_1_995.Y sg13cmos5l_a21oi_1_1.A2 0.0395f
C5246 a_3934_3534# a_4929_3492# 0.48298f
C5247 sg13cmos5l_buf_1_9.A sg13cmos5l_inv_1_983.Y 0.03761f
C5248 sg13cmos5l_mux2_1_0.X sg13cmos5l_mux2_1_3.A0 0.02432f
C5249 sg13cmos5l_inv_1_312.Y a_2240_2514# 0.04394f
C5250 sg13cmos5l_inv_1_6.Y sg13cmos5l_inv_1_7.Y 0.13934f
C5251 sg13cmos5l_inv_1_120.A sg13cmos5l_inv_1_998.A 0.14251f
C5252 sg13cmos5l_inv_1_98.Y sg13cmos5l_inv_1_90.Y 0.01353f
C5253 sg13cmos5l_inv_1_511.A sg13cmos5l_inv_1_509.Y 0.01339f
C5254 a_7424_4026# VPWR 0.07985f
C5255 sg13cmos5l_inv_1_120.A a_10888_9278# 0.01565f
C5256 sg13cmos5l_inv_1_808.A a_13288_17634# 0.01995f
C5257 sg13cmos5l_inv_1_828.Y sg13cmos5l_inv_1_807.Y 0.0844f
C5258 sg13cmos5l_inv_1_535.A a_3934_15994# 0.02815f
C5259 sg13cmos5l_inv_1_802.A VPWR 0.46826f
C5260 sg13cmos5l_inv_1_770.A sg13cmos5l_inv_1_769.Y 0.22878f
C5261 sg13cmos5l_buf_1_17.X sg13cmos5l_inv_1_887.Y 0.06599f
C5262 sg13cmos5l_inv_1_22.Y sg13cmos5l_inv_1_40.Y 0.11824f
C5263 sg13cmos5l_inv_1_150.A sg13cmos5l_inv_1_211.Y 0.04169f
C5264 sg13cmos5l_inv_1_852.Y sg13cmos5l_inv_1_854.Y 0.07174f
C5265 sg13cmos5l_inv_1_159.A VPWR 0.98222f
C5266 sg13cmos5l_mux4_1_7.A2 sg13cmos5l_inv_1_1003.Y 0.01757f
C5267 a_4438_8070# VPWR 0.02985f
C5268 sg13cmos5l_inv_1_1003.Y a_10592_13098# 0.03465f
C5269 sg13cmos5l_buf_1_9.A a_3934_8070# 0.03267f
C5270 sg13cmos5l_inv_1_191.A sg13cmos5l_inv_1_191.Y 0.20857f
C5271 sg13cmos5l_mux2_1_4.S sg13cmos5l_inv_1_914.A 0.18071f
C5272 sg13cmos5l_inv_1_762.Y sg13cmos5l_inv_1_757.Y 0.10536f
C5273 sg13cmos5l_inv_1_29.A a_18856_3932# 0.048f
C5274 sg13cmos5l_inv_1_30.Y sg13cmos5l_buf_1_2.X 0.01361f
C5275 a_13472_15326# VPWR 0.0691f
C5276 sg13cmos5l_mux4_1_8.A1 VPWR 0.98974f
C5277 sg13cmos5l_buf_1_9.A a_14206_15630# 0.06074f
C5278 sg13cmos5l_buf_1_8.A sg13cmos5l_inv_1_38.Y 0.01265f
C5279 sg13cmos5l_inv_1_823.Y sg13cmos5l_inv_1_835.A 0.04847f
C5280 a_15662_4084# a_15834_3898# 0.03097f
C5281 sg13cmos5l_inv_1_504.Y sg13cmos5l_inv_1_513.A 0.13974f
C5282 sg13cmos5l_inv_1_526.A sg13cmos5l_inv_1_515.A 0.04467f
C5283 sg13cmos5l_inv_1_565.Y a_3934_15994# 0.01499f
C5284 sg13cmos5l_inv_1_507.Y a_2152_10790# 0.02189f
C5285 sg13cmos5l_buf_1_9.A sg13cmos5l_inv_1_767.A 0.01123f
C5286 sg13cmos5l_inv_1_309.Y VPWR 0.42567f
C5287 sg13cmos5l_buf_1_9.A sg13cmos5l_inv_1_532.Y 0.23867f
C5288 sg13cmos5l_inv_1_403.A sg13cmos5l_inv_1_401.Y 0.24729f
C5289 sg13cmos5l_inv_1_252.A sg13cmos5l_inv_1_252.Y 0.21105f
C5290 sg13cmos5l_inv_1_733.A sg13cmos5l_or2_1_0.B 0.0173f
C5291 sg13cmos5l_mux4_1_5.S1 sg13cmos5l_inv_1_95.A 0.29704f
C5292 sg13cmos5l_inv_1_130.Y sg13cmos5l_inv_1_140.A 0.05619f
C5293 sg13cmos5l_inv_1_129.Y sg13cmos5l_inv_1_130.A 0.6896f
C5294 sg13cmos5l_mux2_1_4.S a_14389_11500# 0.03147f
C5295 a_18280_12216# a_18764_12180# 0.03472f
C5296 sg13cmos5l_inv_1_681.Y sg13cmos5l_inv_1_682.A 0.21793f
C5297 sg13cmos5l_inv_1_58.Y sg13cmos5l_inv_1_58.A 0.19274f
C5298 a_5005_3418# sg13cmos5l_mux4_1_5.X 0.01029f
C5299 a_8480_4742# VPWR 0.0837f
C5300 sg13cmos5l_inv_1_437.A sg13cmos5l_inv_1_438.A 0.22603f
C5301 sg13cmos5l_mux2_1_4.S sg13cmos5l_inv_1_703.Y 0.02992f
C5302 sg13cmos5l_o21ai_1_0.B1 a_1228_15240# 0.01382f
C5303 sg13cmos5l_inv_1_510.A a_2632_13098# 0.03352f
C5304 sg13cmos5l_inv_1_137.A VPWR 0.40718f
C5305 sg13cmos5l_inv_1_377.Y a_1568_7766# 0.03465f
C5306 sg13cmos5l_inv_1_320.Y a_800_4026# 0.03553f
C5307 sg13cmos5l_inv_1_716.A VPWR 0.42625f
C5308 sg13cmos5l_mux4_1_7.A3 sg13cmos5l_mux4_1_7.A2 0.68393f
C5309 sg13cmos5l_mux4_1_5.S1 sg13cmos5l_inv_1_410.Y 0.04191f
C5310 sg13cmos5l_inv_1_584.A sg13cmos5l_inv_1_583.A 0.08326f
C5311 sg13cmos5l_inv_1_553.Y sg13cmos5l_inv_1_548.Y 0.01886f
C5312 sg13cmos5l_inv_1_543.Y sg13cmos5l_inv_1_546.Y 0.16682f
C5313 sg13cmos5l_mux2_1_4.S sg13cmos5l_inv_1_115.A 0.02502f
C5314 sg13cmos5l_inv_1_930.A sg13cmos5l_mux4_1_15.A2 0.01019f
C5315 sg13cmos5l_inv_1_237.Y sg13cmos5l_inv_1_325.Y 0.16164f
C5316 a_4929_8028# VPWR 0.70714f
C5317 sg13cmos5l_inv_1_177.Y sg13cmos5l_buf_1_4.X 0.0182f
C5318 sg13cmos5l_mux2_1_3.A0 a_9659_7736# 0.0324f
C5319 sg13cmos5l_inv_1_656.Y sg13cmos5l_inv_1_652.Y 0.20065f
C5320 a_2816_4026# VPWR 0.07642f
C5321 a_4475_13008# VPWR 0.99191f
C5322 sg13cmos5l_buf_1_9.A sg13cmos5l_inv_1_478.A 0.01337f
C5323 sg13cmos5l_inv_1_344.A VPWR 0.62659f
C5324 sg13cmos5l_inv_1_616.Y VPWR 0.43558f
C5325 sg13cmos5l_inv_1_270.A sg13cmos5l_inv_1_271.A 0.19985f
C5326 sg13cmos5l_inv_1_382.Y VPWR 0.42284f
C5327 sg13cmos5l_inv_1_431.A sg13cmos5l_inv_1_451.A 0.02248f
C5328 sg13cmos5l_inv_1_808.A sg13cmos5l_inv_1_811.Y 0.01138f
C5329 sg13cmos5l_inv_1_107.Y a_13472_6254# 0.04577f
C5330 sg13cmos5l_inv_1_311.Y sg13cmos5l_inv_1_304.A 3.62208f
C5331 sg13cmos5l_inv_1_589.A a_6752_17634# 0.03618f
C5332 a_13288_8562# VPWR 0.12833f
C5333 a_7328_1002# VPWR 0.07658f
C5334 sg13cmos5l_inv_1_176.A sg13cmos5l_inv_1_177.A 0.18391f
C5335 a_7271_3534# a_8086_3534# 0.49917f
C5336 a_9846_10240# VPWR 0.01715f
C5337 sg13cmos5l_inv_1_67.A sg13cmos5l_inv_1_67.Y 0.19503f
C5338 sg13cmos5l_mux4_1_5.S0 sg13cmos5l_buf_1_10.A 1.86012f
C5339 sg13cmos5l_nor4_1_0.A sg13cmos5l_inv_1_998.A 0.14572f
C5340 sg13cmos5l_inv_1_100.A a_13472_2514# 0.03646f
C5341 sg13cmos5l_inv_1_69.A sg13cmos5l_inv_1_247.Y 0.15492f
C5342 sg13cmos5l_buf_1_10.A sg13cmos5l_inv_1_983.Y 0.09038f
C5343 sg13cmos5l_inv_1_821.A VPWR 0.42103f
C5344 sg13cmos5l_inv_1_531.A VPWR 0.57094f
C5345 sg13cmos5l_inv_1_976.A VPWR 0.42364f
C5346 sg13cmos5l_inv_1_731.A a_12808_10790# 0.03547f
C5347 sg13cmos5l_inv_1_948.A a_10888_14610# 0.0213f
C5348 sg13cmos5l_inv_1_340.Y sg13cmos5l_inv_1_375.Y 0.40119f
C5349 sg13cmos5l_inv_1_130.A sg13cmos5l_inv_1_138.A 0.1218f
C5350 sg13cmos5l_inv_1_722.Y sg13cmos5l_inv_1_699.A 0.06373f
C5351 sg13cmos5l_inv_1_213.A sg13cmos5l_inv_1_186.A 0.03656f
C5352 sg13cmos5l_inv_1_78.A sg13cmos5l_inv_1_141.A 0.01059f
C5353 sg13cmos5l_buf_1_18.A sg13cmos5l_inv_1_694.A 0.01008f
C5354 sg13cmos5l_mux2_1_4.S sg13cmos5l_mux4_1_11.A3 0.23314f
C5355 sg13cmos5l_inv_1_424.A VPWR 0.42327f
C5356 sg13cmos5l_mux4_1_5.S1 sg13cmos5l_inv_1_277.Y 0.01132f
C5357 sg13cmos5l_mux4_1_5.S1 sg13cmos5l_inv_1_288.Y 0.02752f
C5358 sg13cmos5l_nor3_1_2.B sg13cmos5l_inv_1_532.A 0.01083f
C5359 sg13cmos5l_inv_1_685.Y VPWR 0.4221f
C5360 sg13cmos5l_inv_1_328.Y a_1472_2514# 0.01312f
C5361 sg13cmos5l_nor2b_1_0.B_N sg13cmos5l_inv_1_576.A 0.04283f
C5362 sg13cmos5l_o21ai_1_0.B1 sg13cmos5l_inv_1_966.Y 0.02779f
C5363 a_18176_5538# VPWR 0.0732f
C5364 sg13cmos5l_inv_1_793.A VPWR 0.57018f
C5365 sg13cmos5l_inv_1_487.A sg13cmos5l_inv_1_677.Y 0.17169f
C5366 sg13cmos5l_inv_1_1007.Y sg13cmos5l_inv_1_474.Y 0.29082f
C5367 sg13cmos5l_inv_1_499.Y a_4640_10790# 0.01054f
C5368 sg13cmos5l_mux2_1_3.S sg13cmos5l_mux4_1_5.S1 0.18452f
C5369 sg13cmos5l_mux2_1_4.S sg13cmos5l_inv_1_159.Y 0.06161f
C5370 a_13472_5538# VPWR 0.07338f
C5371 sg13cmos5l_mux2_1_3.A0 sg13cmos5l_inv_1_132.Y 0.02334f
C5372 sg13cmos5l_inv_1_532.Y sg13cmos5l_buf_1_10.A 0.10415f
C5373 sg13cmos5l_mux4_1_5.S0 sg13cmos5l_inv_1_421.A 0.84735f
C5374 sg13cmos5l_mux4_1_13.A3 sg13cmos5l_inv_1_920.A 0.01531f
C5375 a_7271_3534# a_7582_3534# 0.49675f
C5376 sg13cmos5l_buf_1_9.A sg13cmos5l_mux4_1_12.A1 0.06641f
C5377 sg13cmos5l_inv_1_520.A VPWR 0.3506f
C5378 sg13cmos5l_inv_1_16.A sg13cmos5l_inv_1_220.A 0.10115f
C5379 sg13cmos5l_buf_1_9.A sg13cmos5l_inv_1_523.Y 0.06848f
C5380 sg13cmos5l_inv_1_258.A sg13cmos5l_inv_1_277.A 0.35758f
C5381 sg13cmos5l_inv_1_688.A a_5320_18350# 0.01986f
C5382 sg13cmos5l_mux4_1_5.S1 a_14614_3534# 0.0264f
C5383 sg13cmos5l_inv_1_891.Y a_17896_13098# 0.01059f
C5384 sg13cmos5l_inv_1_367.Y VPWR 0.4485f
C5385 sg13cmos5l_inv_1_823.A sg13cmos5l_inv_1_836.A 0.03852f
C5386 sg13cmos5l_inv_1_851.A VPWR 0.48358f
C5387 sg13cmos5l_inv_1_129.Y VPWR 0.72379f
C5388 a_13799_3534# sg13cmos5l_inv_1_45.Y 0.22269f
C5389 sg13cmos5l_inv_1_45.Y sg13cmos5l_inv_1_46.Y 0.01503f
C5390 sg13cmos5l_inv_1_421.A a_3934_8070# 0.02556f
C5391 sg13cmos5l_inv_1_975.A a_10496_16838# 0.01162f
C5392 sg13cmos5l_buf_1_0.A sg13cmos5l_inv_1_95.A 0.83797f
C5393 sg13cmos5l_mux2_1_1.X sg13cmos5l_inv_1_384.Y 0.01496f
C5394 sg13cmos5l_inv_1_616.Y sg13cmos5l_a21oi_1_1.A2 0.01856f
C5395 sg13cmos5l_inv_1_270.Y a_8864_4742# 0.03465f
C5396 sg13cmos5l_inv_1_612.Y sg13cmos5l_inv_1_612.A 0.18105f
C5397 a_15475_11725# sg13cmos5l_inv_1_699.A 0.01452f
C5398 sg13cmos5l_a21oi_1_0.A1 a_8795_11752# 0.18637f
C5399 sg13cmos5l_inv_1_305.A sg13cmos5l_inv_1_324.Y 0.01225f
C5400 sg13cmos5l_inv_1_220.A sg13cmos5l_inv_1_220.Y 0.24769f
C5401 sg13cmos5l_inv_1_644.A sg13cmos5l_inv_1_648.Y 0.0273f
C5402 sg13cmos5l_buf_1_8.A sg13cmos5l_inv_1_268.A 0.29118f
C5403 sg13cmos5l_inv_1_6.Y sg13cmos5l_inv_1_2.A 0.03106f
C5404 sg13cmos5l_inv_1_120.A sg13cmos5l_inv_1_940.A 0.08208f
C5405 sg13cmos5l_inv_1_101.Y sg13cmos5l_inv_1_90.Y 0.03767f
C5406 sg13cmos5l_inv_1_511.A sg13cmos5l_inv_1_509.A 0.18297f
C5407 sg13cmos5l_inv_1_684.A sg13cmos5l_inv_1_671.A 0.01173f
C5408 sg13cmos5l_inv_1_69.A VPWR 1.12352f
C5409 sg13cmos5l_inv_1_372.Y sg13cmos5l_inv_1_372.A 0.11152f
C5410 sg13cmos5l_inv_1_808.A sg13cmos5l_inv_1_890.A 0.39691f
C5411 sg13cmos5l_mux4_1_15.A2 a_16640_9278# 0.01376f
C5412 sg13cmos5l_inv_1_582.A a_8086_15994# 0.23154f
C5413 sg13cmos5l_inv_1_770.A sg13cmos5l_inv_1_774.Y 0.12521f
C5414 sg13cmos5l_buf_1_17.X sg13cmos5l_inv_1_711.Y 0.03838f
C5415 sg13cmos5l_inv_1_150.A sg13cmos5l_inv_1_147.A 0.25517f
C5416 sg13cmos5l_inv_1_16.Y sg13cmos5l_inv_1_40.Y 0.02525f
C5417 sg13cmos5l_inv_1_166.A VPWR 0.50251f
C5418 sg13cmos5l_mux2_1_4.S sg13cmos5l_buf_1_8.A 0.70661f
C5419 sg13cmos5l_mux2_1_4.S a_15181_3418# 0.37226f
C5420 sg13cmos5l_inv_1_17.Y sg13cmos5l_inv_1_14.A 0.04832f
C5421 sg13cmos5l_inv_1_523.Y sg13cmos5l_inv_1_507.A 0.02424f
C5422 sg13cmos5l_mux2_1_4.S sg13cmos5l_inv_1_913.A 0.55185f
C5423 a_3623_12606# a_4438_12606# 0.49917f
C5424 sg13cmos5l_inv_1_762.Y sg13cmos5l_inv_1_731.Y 0.02426f
C5425 sg13cmos5l_inv_1_1011.A a_9326_3410# 0.04577f
C5426 a_16075_7649# a_16540_8070# 0.0289f
C5427 sg13cmos5l_inv_1_284.A a_5896_3230# 0.03352f
C5428 sg13cmos5l_inv_1_30.Y sg13cmos5l_inv_1_51.A 0.03063f
C5429 sg13cmos5l_inv_1_29.A sg13cmos5l_buf_1_2.X 0.02963f
C5430 sg13cmos5l_inv_1_628.Y VPWR 0.43318f
C5431 sg13cmos5l_inv_1_1004.Y sg13cmos5l_inv_1_132.Y 0.24656f
C5432 sg13cmos5l_buf_1_8.A sg13cmos5l_inv_1_241.A 0.75043f
C5433 sg13cmos5l_inv_1_304.Y VPWR 0.52931f
C5434 sg13cmos5l_inv_1_331.A a_3488_2514# 0.01094f
C5435 sg13cmos5l_inv_1_350.A sg13cmos5l_inv_1_370.Y 0.03618f
C5436 sg13cmos5l_inv_1_403.A sg13cmos5l_inv_1_403.Y 0.2329f
C5437 sg13cmos5l_inv_1_738.A sg13cmos5l_inv_1_738.Y 0.17716f
C5438 sg13cmos5l_inv_1_664.A sg13cmos5l_inv_1_669.A 0.11819f
C5439 sg13cmos5l_inv_1_129.Y sg13cmos5l_inv_1_140.A 0.1021f
C5440 sg13cmos5l_inv_1_138.Y sg13cmos5l_inv_1_130.A 0.20452f
C5441 sg13cmos5l_mux4_1_5.S0 sg13cmos5l_inv_1_341.Y 0.01225f
C5442 sg13cmos5l_nor3_1_1.A sg13cmos5l_inv_1_492.A 0.03739f
C5443 sg13cmos5l_inv_1_3.Y a_18560_1002# 0.03553f
C5444 a_3304_18350# a_3488_18350# 0.11523f
C5445 sg13cmos5l_buf_1_7.X sg13cmos5l_inv_1_311.Y 1.56581f
C5446 sg13cmos5l_inv_1_319.Y a_3680_4026# 0.01203f
C5447 a_18664_16028# VPWR 0.25011f
C5448 sg13cmos5l_inv_1_498.A a_6464_12302# 0.01054f
C5449 sg13cmos5l_inv_1_782.A sg13cmos5l_inv_1_783.A 0.17578f
C5450 sg13cmos5l_buf_1_10.A a_808_4656# 0.28869f
C5451 sg13cmos5l_mux2_1_0.X sg13cmos5l_inv_1_217.A 3.8727f
C5452 a_12136_17634# VPWR 0.1373f
C5453 a_9440_18350# VPWR 0.06555f
C5454 sg13cmos5l_inv_1_138.A VPWR 0.42267f
C5455 sg13cmos5l_o21ai_1_0.B1 sg13cmos5l_inv_1_394.A 0.07928f
C5456 sg13cmos5l_inv_1_562.A a_4264_16838# 0.03352f
C5457 a_13472_6254# VPWR 0.0685f
C5458 sg13cmos5l_inv_1_933.A sg13cmos5l_inv_1_931.Y 0.16827f
C5459 sg13cmos5l_inv_1_682.A sg13cmos5l_inv_1_681.A 0.15096f
C5460 sg13cmos5l_mux4_1_5.S1 sg13cmos5l_inv_1_111.Y 0.02571f
C5461 sg13cmos5l_inv_1_701.A VPWR 0.42794f
C5462 sg13cmos5l_mux4_1_5.S1 sg13cmos5l_inv_1_318.Y 0.45353f
C5463 sg13cmos5l_inv_1_543.Y sg13cmos5l_inv_1_545.Y 0.09934f
C5464 sg13cmos5l_inv_1_553.Y sg13cmos5l_inv_1_546.Y 0.01145f
C5465 sg13cmos5l_mux2_1_4.S sg13cmos5l_inv_1_114.A 0.76467f
C5466 sg13cmos5l_inv_1_237.Y sg13cmos5l_inv_1_325.A 0.42949f
C5467 sg13cmos5l_inv_1_931.A sg13cmos5l_mux4_1_15.A2 0.01053f
C5468 a_7582_3534# a_8309_3149# 0.01228f
C5469 a_13607_12606# a_13844_12606# 0.01012f
C5470 a_1576_13814# VPWR 0.13623f
C5471 a_13895_15630# a_14710_15630# 0.49917f
C5472 a_3304_1718# a_3488_1718# 0.11523f
C5473 a_6853_8701# a_6430_8434# 0.01929f
C5474 sg13cmos5l_mux4_1_16.X a_9659_7736# 0.18751f
C5475 sg13cmos5l_inv_1_114.A a_12808_8562# 0.03468f
C5476 sg13cmos5l_inv_1_74.A sg13cmos5l_inv_1_68.A 0.20065f
C5477 sg13cmos5l_mux4_1_9.X VPWR 0.46998f
C5478 sg13cmos5l_inv_1_305.Y VPWR 1.70979f
C5479 sg13cmos5l_mux4_1_6.X sg13cmos5l_inv_1_412.A 0.24548f
C5480 sg13cmos5l_mux4_1_5.S0 a_4438_8070# 0.05333f
C5481 sg13cmos5l_inv_1_616.A VPWR 0.44279f
C5482 sg13cmos5l_inv_1_389.A VPWR 0.44255f
C5483 sg13cmos5l_inv_1_431.A sg13cmos5l_inv_1_436.A 0.04392f
C5484 a_19136_4742# VPWR 0.06747f
C5485 sg13cmos5l_mux2_1_4.S a_14989_3904# 0.4004f
C5486 sg13cmos5l_mux4_1_8.A1 sg13cmos5l_mux4_1_5.S0 0.66136f
C5487 sg13cmos5l_inv_1_66.A sg13cmos5l_inv_1_67.Y 0.04398f
C5488 sg13cmos5l_nor3_1_2.B sg13cmos5l_inv_1_699.A 0.08032f
C5489 sg13cmos5l_inv_1_184.Y sg13cmos5l_inv_1_222.Y 0.2026f
C5490 sg13cmos5l_inv_1_626.Y sg13cmos5l_inv_1_600.A 0.01124f
C5491 sg13cmos5l_nor3_1_1.Y sg13cmos5l_o21ai_1_0.Y 0.38954f
C5492 sg13cmos5l_inv_1_980.A a_8576_10074# 0.01054f
C5493 sg13cmos5l_inv_1_565.Y a_3304_16122# 0.02f
C5494 sg13cmos5l_mux4_1_13.A3 sg13cmos5l_inv_1_879.A 0.033f
C5495 a_3934_3534# a_4141_3195# 0.01967f
C5496 sg13cmos5l_inv_1_798.A sg13cmos5l_inv_1_802.A 0.2242f
C5497 sg13cmos5l_inv_1_821.Y VPWR 0.424f
C5498 sg13cmos5l_mux4_1_5.S1 sg13cmos5l_inv_1_216.Y 0.21826f
C5499 sg13cmos5l_inv_1_235.Y a_11456_4742# 0.03465f
C5500 sg13cmos5l_mux4_1_1.A3 a_14614_3534# 0.22049f
C5501 sg13cmos5l_inv_1_370.Y sg13cmos5l_inv_1_346.Y 0.01564f
C5502 sg13cmos5l_inv_1_949.Y sg13cmos5l_inv_1_882.A 0.02219f
C5503 a_4438_8070# a_3934_8070# 0.97548f
C5504 sg13cmos5l_buf_1_18.A sg13cmos5l_inv_1_723.Y 0.01972f
C5505 sg13cmos5l_mux4_1_2.A2 a_13918_3898# 0.14204f
C5506 sg13cmos5l_buf_1_0.A sg13cmos5l_inv_1_129.A 0.07921f
C5507 sg13cmos5l_inv_1_140.A sg13cmos5l_inv_1_138.A 0.19597f
C5508 sg13cmos5l_inv_1_734.A sg13cmos5l_inv_1_937.Y 0.01942f
C5509 sg13cmos5l_inv_1_57.Y a_13288_1002# 0.02188f
C5510 sg13cmos5l_inv_1_215.Y sg13cmos5l_inv_1_78.A 0.03127f
C5511 sg13cmos5l_inv_1_213.A sg13cmos5l_inv_1_30.A 0.02821f
C5512 sg13cmos5l_buf_1_9.A sg13cmos5l_inv_1_467.Y 0.02518f
C5513 sg13cmos5l_inv_1_423.A VPWR 0.41965f
C5514 sg13cmos5l_inv_1_337.Y a_3623_3534# 0.04914f
C5515 sg13cmos5l_mux4_1_5.S1 sg13cmos5l_inv_1_282.Y 0.41539f
C5516 sg13cmos5l_inv_1_541.Y sg13cmos5l_inv_1_544.Y 0.17046f
C5517 sg13cmos5l_nor3_1_2.B sg13cmos5l_inv_1_519.Y 0.05146f
C5518 sg13cmos5l_inv_1_173.Y sg13cmos5l_inv_1_149.Y 0.27099f
C5519 sg13cmos5l_inv_1_680.A VPWR 0.42087f
C5520 sg13cmos5l_mux4_1_8.A2 a_7582_15994# 0.12934f
C5521 sg13cmos5l_inv_1_88.Y a_11848_4026# 0.02074f
C5522 a_9326_3410# a_9498_3168# 0.01068f
C5523 sg13cmos5l_buf_1_9.A a_7414_12970# 0.05451f
C5524 a_6910_12970# VPWR 0.88846f
C5525 sg13cmos5l_inv_1_101.Y sg13cmos5l_inv_1_98.Y 0.19028f
C5526 a_14422_12606# a_14913_12564# 0.3824f
C5527 sg13cmos5l_inv_1_270.Y sg13cmos5l_inv_1_270.A 0.11152f
C5528 sg13cmos5l_o21ai_1_0.B1 sg13cmos5l_inv_1_963.Y 0.0278f
C5529 sg13cmos5l_inv_1_141.A a_17896_6254# 0.03488f
C5530 sg13cmos5l_inv_1_677.A sg13cmos5l_inv_1_677.Y 0.24092f
C5531 sg13cmos5l_inv_1_794.A VPWR 0.42807f
C5532 sg13cmos5l_inv_1_926.Y a_4640_10790# 0.03465f
C5533 sg13cmos5l_buf_1_2.X a_18664_3144# 0.28895f
C5534 sg13cmos5l_inv_1_311.A a_808_1632# 0.0423f
C5535 sg13cmos5l_inv_1_462.Y sg13cmos5l_inv_1_433.A 0.11584f
C5536 sg13cmos5l_inv_1_248.A sg13cmos5l_inv_1_418.Y 0.02635f
C5537 sg13cmos5l_inv_1_397.Y sg13cmos5l_mux4_1_16.A1 0.34732f
C5538 sg13cmos5l_mux2_1_4.S sg13cmos5l_inv_1_158.Y 0.01114f
C5539 sg13cmos5l_mux4_1_16.X sg13cmos5l_inv_1_132.Y 0.23896f
C5540 sg13cmos5l_inv_1_845.Y sg13cmos5l_inv_1_846.Y 0.20065f
C5541 sg13cmos5l_mux4_1_5.S0 sg13cmos5l_inv_1_344.A 0.022f
C5542 sg13cmos5l_inv_1_120.A sg13cmos5l_inv_1_133.Y 0.02047f
C5543 sg13cmos5l_mux4_1_5.S0 sg13cmos5l_inv_1_382.Y 0.0381f
C5544 a_14110_3534# a_14533_3195# 0.01929f
C5545 a_13288_13814# VPWR 0.12492f
C5546 sg13cmos5l_buf_1_9.A sg13cmos5l_inv_1_745.A 0.29692f
C5547 sg13cmos5l_inv_1_518.A VPWR 0.40789f
C5548 sg13cmos5l_inv_1_258.A sg13cmos5l_inv_1_281.Y 0.14414f
C5549 sg13cmos5l_inv_1_903.Y a_13472_13814# 0.04567f
C5550 a_16075_7649# VPWR 0.46981f
C5551 sg13cmos5l_inv_1_594.Y sg13cmos5l_inv_1_588.A 0.03618f
C5552 sg13cmos5l_inv_1_813.Y a_19136_15326# 0.03508f
C5553 sg13cmos5l_inv_1_527.A sg13cmos5l_inv_1_514.Y 0.03447f
C5554 sg13cmos5l_inv_1_347.Y VPWR 0.65369f
C5555 sg13cmos5l_mux4_1_1.A3 a_15105_3492# 0.02203f
C5556 sg13cmos5l_inv_1_823.A sg13cmos5l_inv_1_852.Y 0.07393f
C5557 a_18088_12302# VPWR 0.14433f
C5558 sg13cmos5l_inv_1_828.Y sg13cmos5l_inv_1_824.A 0.90384f
C5559 sg13cmos5l_inv_1_138.Y VPWR 0.557f
C5560 a_3934_8070# a_4929_8028# 0.48298f
C5561 sg13cmos5l_inv_1_381.Y sg13cmos5l_inv_1_393.Y 0.01524f
C5562 sg13cmos5l_inv_1_843.Y VPWR 0.43109f
C5563 a_16928_7050# VPWR 0.11546f
C5564 sg13cmos5l_buf_1_19.A sg13cmos5l_buf_1_18.A 0.07192f
C5565 sg13cmos5l_nor3_1_2.B sg13cmos5l_inv_1_747.Y 0.01029f
C5566 sg13cmos5l_inv_1_534.Y sg13cmos5l_inv_1_535.Y 0.90218f
C5567 a_1192_16122# VPWR 0.13632f
C5568 sg13cmos5l_buf_1_0.A sg13cmos5l_inv_1_82.Y 0.01477f
C5569 sg13cmos5l_inv_1_797.A sg13cmos5l_inv_1_797.Y 0.20065f
C5570 sg13cmos5l_inv_1_225.A sg13cmos5l_inv_1_184.A 0.51222f
C5571 sg13cmos5l_inv_1_616.A sg13cmos5l_a21oi_1_1.A2 0.04677f
C5572 sg13cmos5l_mux2_1_1.X sg13cmos5l_inv_1_394.Y 0.01048f
C5573 sg13cmos5l_inv_1_297.Y sg13cmos5l_inv_1_335.Y 0.03635f
C5574 sg13cmos5l_buf_1_9.A sg13cmos5l_inv_1_926.A 0.01923f
C5575 sg13cmos5l_inv_1_589.Y a_7144_16838# 0.01121f
C5576 sg13cmos5l_inv_1_76.A sg13cmos5l_inv_1_28.A 0.11311f
C5577 sg13cmos5l_inv_1_545.Y enable 0.18519f
C5578 sg13cmos5l_nor3_1_2.B sg13cmos5l_inv_1_492.A 0.03163f
C5579 sg13cmos5l_mux2_1_3.X a_10592_7766# 0.0174f
C5580 sg13cmos5l_inv_1_166.A a_18184_8562# 0.05409f
C5581 sg13cmos5l_inv_1_159.A sg13cmos5l_inv_1_171.A 0.01071f
C5582 sg13cmos5l_mux2_1_3.S a_9064_10790# 0.061f
C5583 sg13cmos5l_inv_1_645.A a_5984_13814# 0.03553f
C5584 sg13cmos5l_inv_1_220.A sg13cmos5l_inv_1_58.Y 0.05626f
C5585 sg13cmos5l_inv_1_6.Y sg13cmos5l_inv_1_40.Y 0.49301f
C5586 sg13cmos5l_inv_1_120.A sg13cmos5l_mux2_1_0.X 0.19561f
C5587 sg13cmos5l_inv_1_284.A VPWR 0.41034f
C5588 sg13cmos5l_inv_1_957.Y sg13cmos5l_inv_1_161.Y 0.0123f
C5589 sg13cmos5l_inv_1_807.Y sg13cmos5l_inv_1_890.A 0.71041f
C5590 a_9825_11776# VPWR 0.35103f
C5591 sg13cmos5l_inv_1_59.A sg13cmos5l_inv_1_66.A 0.03294f
C5592 sg13cmos5l_inv_1_608.A sg13cmos5l_inv_1_774.Y 0.02072f
C5593 sg13cmos5l_inv_1_445.A a_8776_5538# 0.03352f
C5594 sg13cmos5l_buf_1_0.A sg13cmos5l_inv_1_66.Y 0.07223f
C5595 sg13cmos5l_inv_1_480.A sg13cmos5l_inv_1_480.Y 0.18356f
C5596 sg13cmos5l_mux4_1_13.A0 sg13cmos5l_inv_1_862.A 0.33471f
C5597 sg13cmos5l_inv_1_141.Y sg13cmos5l_inv_1_195.Y 0.01253f
C5598 sg13cmos5l_inv_1_17.A sg13cmos5l_inv_1_14.A 0.3146f
C5599 sg13cmos5l_mux2_1_4.S sg13cmos5l_inv_1_915.A 0.04063f
C5600 sg13cmos5l_buf_1_9.A a_7582_15994# 0.03909f
C5601 sg13cmos5l_inv_1_29.A sg13cmos5l_inv_1_51.A 0.27879f
C5602 sg13cmos5l_a21oi_1_0.B1 sg13cmos5l_nand2_1_1.B 0.15143f
C5603 sg13cmos5l_inv_1_630.A VPWR 0.42829f
C5604 sg13cmos5l_mux4_1_11.A1 sg13cmos5l_inv_1_699.A 0.01286f
C5605 sg13cmos5l_inv_1_409.Y sg13cmos5l_inv_1_389.Y 0.01055f
C5606 a_15275_7644# a_15608_7680# 0.3824f
C5607 sg13cmos5l_inv_1_838.Y sg13cmos5l_inv_1_823.Y 0.25984f
C5608 sg13cmos5l_inv_1_526.A sg13cmos5l_inv_1_504.Y 0.04f
C5609 sg13cmos5l_inv_1_798.Y sg13cmos5l_inv_1_802.A 0.02885f
C5610 sg13cmos5l_buf_1_9.A sg13cmos5l_inv_1_643.A 0.31517f
C5611 sg13cmos5l_inv_1_345.Y a_1576_6254# 0.03631f
C5612 sg13cmos5l_inv_1_378.Y sg13cmos5l_inv_1_370.Y 0.0515f
C5613 sg13cmos5l_inv_1_254.Y sg13cmos5l_inv_1_252.A 0.16671f
C5614 sg13cmos5l_inv_1_738.A sg13cmos5l_inv_1_737.A 0.19518f
C5615 sg13cmos5l_inv_1_136.Y sg13cmos5l_inv_1_130.A 0.15863f
C5616 sg13cmos5l_inv_1_138.Y sg13cmos5l_inv_1_140.A 0.25582f
C5617 sg13cmos5l_mux4_1_5.S0 sg13cmos5l_inv_1_367.Y 0.16014f
C5618 sg13cmos5l_o21ai_1_0.Y sg13cmos5l_nand2_1_1.Y 0.02396f
C5619 sg13cmos5l_buf_1_9.A sg13cmos5l_inv_1_534.A 0.04299f
C5620 sg13cmos5l_buf_1_10.A sg13cmos5l_inv_1_467.Y 0.09974f
C5621 sg13cmos5l_inv_1_398.Y sg13cmos5l_inv_1_445.A 0.01822f
C5622 sg13cmos5l_inv_1_4.Y a_18560_1002# 0.03508f
C5623 sg13cmos5l_inv_1_800.A sg13cmos5l_inv_1_800.Y 0.21399f
C5624 a_9152_9278# VPWR 0.06263f
C5625 a_8638_6558# a_8845_6219# 0.01967f
C5626 sg13cmos5l_inv_1_384.Y sg13cmos5l_inv_1_124.A 0.10622f
C5627 sg13cmos5l_o21ai_1_0.B1 sg13cmos5l_inv_1_689.A 0.06931f
C5628 sg13cmos5l_inv_1_324.Y sg13cmos5l_inv_1_335.Y 0.26015f
C5629 a_1594_15610# sg13cmos5l_a21oi_1_0.B1 0.01547f
C5630 sg13cmos5l_inv_1_510.A sg13cmos5l_inv_1_525.A 0.06957f
C5631 sg13cmos5l_inv_1_806.Y VPWR 0.6019f
C5632 sg13cmos5l_inv_1_562.A sg13cmos5l_inv_1_562.Y 0.25556f
C5633 sg13cmos5l_buf_1_12.X sg13cmos5l_mux4_1_16.A1 0.07391f
C5634 sg13cmos5l_inv_1_372.Y sg13cmos5l_inv_1_362.A 0.0131f
C5635 sg13cmos5l_mux4_1_5.S1 sg13cmos5l_inv_1_110.A 0.03032f
C5636 sg13cmos5l_inv_1_553.Y sg13cmos5l_inv_1_545.Y 0.20452f
C5637 sg13cmos5l_inv_1_704.Y sg13cmos5l_inv_1_699.Y 0.40659f
C5638 sg13cmos5l_inv_1_737.A sg13cmos5l_inv_1_941.A 0.01776f
C5639 sg13cmos5l_inv_1_237.Y sg13cmos5l_inv_1_335.Y 0.01907f
C5640 sg13cmos5l_mux4_1_5.S0 sg13cmos5l_inv_1_69.A 0.01849f
C5641 sg13cmos5l_inv_1_165.Y sg13cmos5l_inv_1_168.A 0.23332f
C5642 sg13cmos5l_inv_1_510.A VPWR 0.53725f
C5643 sg13cmos5l_inv_1_305.A sg13cmos5l_inv_1_313.Y 0.08313f
C5644 sg13cmos5l_mux4_1_16.X sg13cmos5l_mux2_1_3.A0 0.55857f
C5645 sg13cmos5l_inv_1_61.Y sg13cmos5l_inv_1_61.A 0.23289f
C5646 sg13cmos5l_inv_1_655.Y sg13cmos5l_inv_1_656.Y 0.20077f
C5647 sg13cmos5l_inv_1_579.Y VPWR 0.4491f
C5648 sg13cmos5l_inv_1_861.A sg13cmos5l_inv_1_874.Y 0.08824f
C5649 sg13cmos5l_inv_1_668.A a_1376_14610# 0.01054f
C5650 sg13cmos5l_inv_1_507.A a_2152_10790# 0.03397f
C5651 sg13cmos5l_nor3_1_1.Y a_9948_10240# 0.01831f
C5652 sg13cmos5l_mux4_1_5.X sg13cmos5l_mux4_1_3.X 0.52452f
C5653 sg13cmos5l_inv_1_818.A sg13cmos5l_inv_1_868.A 0.03776f
C5654 a_13288_1718# a_13288_1002# 0.01275f
C5655 sg13cmos5l_buf_1_8.A sg13cmos5l_mux4_1_1.X 0.04469f
C5656 a_3934_15994# a_4929_16036# 0.48298f
C5657 sg13cmos5l_inv_1_626.Y sg13cmos5l_inv_1_584.A 0.09116f
C5658 sg13cmos5l_inv_1_923.Y a_8576_10074# 0.03571f
C5659 sg13cmos5l_nor3_1_0.Y sg13cmos5l_o21ai_1_0.Y 0.22416f
C5660 sg13cmos5l_nor4_1_0.A sg13cmos5l_mux2_1_0.X 0.1683f
C5661 sg13cmos5l_mux4_1_1.X a_15181_3418# 0.01138f
C5662 sg13cmos5l_mux2_1_4.S sg13cmos5l_inv_1_76.A 0.07784f
C5663 sg13cmos5l_mux4_1_13.A3 sg13cmos5l_inv_1_878.A 0.0203f
C5664 sg13cmos5l_inv_1_981.Y a_9640_1718# 0.01986f
C5665 sg13cmos5l_inv_1_819.Y VPWR 0.63432f
C5666 sg13cmos5l_inv_1_370.A sg13cmos5l_inv_1_362.A 0.01152f
C5667 a_13288_13098# VPWR 0.12833f
C5668 sg13cmos5l_inv_1_642.Y sg13cmos5l_inv_1_651.Y 0.01529f
C5669 a_11848_4026# VPWR 0.14231f
C5670 sg13cmos5l_inv_1_248.A sg13cmos5l_inv_1_258.A 0.73803f
C5671 sg13cmos5l_inv_1_105.Y sg13cmos5l_inv_1_78.A 0.02889f
C5672 sg13cmos5l_inv_1_213.A sg13cmos5l_inv_1_199.Y 0.02163f
C5673 sg13cmos5l_mux4_1_7.A2 a_10112_13814# 0.04511f
C5674 a_3304_9278# VPWR 0.14302f
C5675 sg13cmos5l_buf_1_9.A sg13cmos5l_inv_1_467.A 0.12981f
C5676 sg13cmos5l_mux2_1_3.X a_9659_7736# 0.02182f
C5677 sg13cmos5l_inv_1_322.A sg13cmos5l_inv_1_323.A 0.20757f
C5678 sg13cmos5l_inv_1_337.Y sg13cmos5l_inv_1_327.A 0.03577f
C5679 sg13cmos5l_inv_1_744.Y sg13cmos5l_buf_1_19.A 0.04314f
C5680 sg13cmos5l_inv_1_541.A sg13cmos5l_inv_1_544.Y 0.01325f
C5681 sg13cmos5l_mux2_1_4.X a_9326_3410# 0.2316f
C5682 sg13cmos5l_inv_1_775.A a_11456_17634# 0.03483f
C5683 sg13cmos5l_mux4_1_5.S1 sg13cmos5l_inv_1_293.Y 0.01389f
C5684 sg13cmos5l_inv_1_215.Y sg13cmos5l_inv_1_149.Y 0.17371f
C5685 sg13cmos5l_mux4_1_12.A3 a_13918_12606# 0.18909f
C5686 sg13cmos5l_inv_1_722.Y a_14827_11673# 0.01044f
C5687 sg13cmos5l_inv_1_88.A a_11848_4026# 0.03942f
C5688 sg13cmos5l_inv_1_689.Y VPWR 0.36276f
C5689 sg13cmos5l_inv_1_245.A sg13cmos5l_inv_1_240.A 0.02496f
C5690 sg13cmos5l_inv_1_532.A a_3934_12606# 0.0365f
C5691 sg13cmos5l_o21ai_1_0.B1 sg13cmos5l_inv_1_962.Y 0.02797f
C5692 sg13cmos5l_inv_1_205.A a_17896_6254# 0.01986f
C5693 a_13288_16838# a_13288_16122# 0.01275f
C5694 a_12808_1002# VPWR 0.20774f
C5695 sg13cmos5l_inv_1_677.A sg13cmos5l_inv_1_487.A 0.18436f
C5696 sg13cmos5l_inv_1_475.Y sg13cmos5l_inv_1_1007.Y 0.03631f
C5697 a_5005_3418# VPWR 0.12329f
C5698 sg13cmos5l_mux4_1_5.S1 sg13cmos5l_inv_1_225.Y 0.07399f
C5699 sg13cmos5l_inv_1_248.A sg13cmos5l_inv_1_433.A 0.02083f
C5700 a_3847_12267# VPWR 0.02464f
C5701 sg13cmos5l_mux4_1_16.X sg13cmos5l_inv_1_1004.Y 0.05263f
C5702 sg13cmos5l_a21oi_1_0.B1 a_8096_11586# 0.04155f
C5703 a_1664_3230# VPWR 0.08382f
C5704 sg13cmos5l_inv_1_973.Y sg13cmos5l_inv_1_974.Y 0.11738f
C5705 sg13cmos5l_inv_1_293.Y sg13cmos5l_inv_1_306.A 0.01179f
C5706 a_808_18264# VPWR 0.24765f
C5707 sg13cmos5l_mux4_1_5.S0 sg13cmos5l_inv_1_389.A 0.01315f
C5708 sg13cmos5l_inv_1_576.A sg13cmos5l_inv_1_575.A 0.23073f
C5709 sg13cmos5l_inv_1_887.Y VPWR 0.43195f
C5710 sg13cmos5l_inv_1_258.A sg13cmos5l_inv_1_285.Y 0.07366f
C5711 sg13cmos5l_nand2_1_1.B a_808_9980# 0.29561f
C5712 sg13cmos5l_inv_1_813.Y sg13cmos5l_inv_1_875.A 0.12718f
C5713 sg13cmos5l_inv_1_711.Y sg13cmos5l_buf_1_19.A 0.19193f
C5714 sg13cmos5l_buf_1_18.A VPWR 0.31329f
C5715 sg13cmos5l_buf_1_8.A sg13cmos5l_inv_1_414.A 0.06008f
C5716 sg13cmos5l_inv_1_381.Y sg13cmos5l_inv_1_393.A 0.01503f
C5717 sg13cmos5l_inv_1_136.Y VPWR 0.42565f
C5718 sg13cmos5l_inv_1_841.Y VPWR 0.47234f
C5719 sg13cmos5l_inv_1_177.A VPWR 0.41625f
C5720 sg13cmos5l_inv_1_95.A a_13799_3534# 0.23171f
C5721 sg13cmos5l_inv_1_679.A sg13cmos5l_inv_1_593.Y 0.02634f
C5722 sg13cmos5l_inv_1_696.A a_17416_11586# 0.01986f
C5723 sg13cmos5l_inv_1_610.Y sg13cmos5l_inv_1_535.Y 0.04257f
C5724 a_800_5538# VPWR 0.0675f
C5725 sg13cmos5l_inv_1_45.Y sg13cmos5l_inv_1_6.Y 0.04869f
C5726 sg13cmos5l_inv_1_975.A sg13cmos5l_inv_1_788.Y 0.01801f
C5727 sg13cmos5l_inv_1_579.Y sg13cmos5l_a21oi_1_1.A2 0.16306f
C5728 sg13cmos5l_inv_1_259.Y sg13cmos5l_inv_1_249.Y 0.02251f
C5729 sg13cmos5l_inv_1_166.A sg13cmos5l_inv_1_171.A 0.01308f
C5730 sg13cmos5l_buf_1_21.A osc_tap[7] 0.24212f
C5731 a_3623_3534# sg13cmos5l_inv_1_326.Y 0.20607f
C5732 sg13cmos5l_inv_1_645.A sg13cmos5l_inv_1_676.Y 0.0239f
C5733 sg13cmos5l_inv_1_692.A sg13cmos5l_inv_1_649.Y 0.01773f
C5734 sg13cmos5l_buf_1_8.A sg13cmos5l_inv_1_265.A 0.01038f
C5735 sg13cmos5l_inv_1_417.Y a_6368_4742# 0.03465f
C5736 sg13cmos5l_inv_1_120.A sg13cmos5l_o21ai_1_0.Y 0.02811f
C5737 a_14827_11673# a_15475_11725# 0.01074f
C5738 a_14389_11500# sg13cmos5l_inv_1_699.A 0.04679f
C5739 sg13cmos5l_inv_1_957.Y sg13cmos5l_inv_1_163.Y 0.01226f
C5740 sg13cmos5l_inv_1_807.Y sg13cmos5l_inv_1_808.A 0.07739f
C5741 sg13cmos5l_inv_1_756.Y VPWR 0.41985f
C5742 sg13cmos5l_inv_1_950.Y sg13cmos5l_inv_1_974.A 0.01441f
C5743 sg13cmos5l_inv_1_445.A sg13cmos5l_inv_1_447.A 0.12412f
C5744 a_17504_10074# VPWR 0.08325f
C5745 sg13cmos5l_mux4_1_5.S0 a_6910_12970# 0.06929f
C5746 sg13cmos5l_inv_1_532.A sg13cmos5l_buf_1_8.A 0.0547f
C5747 sg13cmos5l_buf_1_10.A sg13cmos5l_inv_1_677.Y 0.1707f
C5748 sg13cmos5l_mux4_1_14.A1 sg13cmos5l_inv_1_787.Y 0.06351f
C5749 sg13cmos5l_inv_1_825.A sg13cmos5l_inv_1_855.A 0.01538f
C5750 sg13cmos5l_buf_1_8.A sg13cmos5l_inv_1_362.A 0.13588f
C5751 sg13cmos5l_inv_1_775.Y a_11456_17634# 0.01059f
C5752 sg13cmos5l_inv_1_699.A sg13cmos5l_inv_1_703.Y 0.03618f
C5753 sg13cmos5l_mux4_1_13.A0 sg13cmos5l_inv_1_858.Y 0.01397f
C5754 sg13cmos5l_inv_1_602.Y a_9256_18350# 0.03488f
C5755 sg13cmos5l_inv_1_884.Y a_14422_14482# 0.02934f
C5756 sg13cmos5l_inv_1_17.A sg13cmos5l_inv_1_17.Y 0.24257f
C5757 sg13cmos5l_mux2_1_4.S sg13cmos5l_inv_1_912.A 0.03023f
C5758 sg13cmos5l_inv_1_761.A sg13cmos5l_inv_1_738.A 0.09825f
C5759 sg13cmos5l_inv_1_37.Y sg13cmos5l_inv_1_51.A 0.15905f
C5760 sg13cmos5l_inv_1_124.Y sg13cmos5l_inv_1_108.Y 0.01158f
C5761 sg13cmos5l_inv_1_400.Y sg13cmos5l_inv_1_1004.Y 0.17835f
C5762 sg13cmos5l_inv_1_810.Y a_13472_16838# 0.04656f
C5763 sg13cmos5l_inv_1_609.A VPWR 0.44984f
C5764 sg13cmos5l_inv_1_874.A sg13cmos5l_inv_1_874.Y 0.31859f
C5765 sg13cmos5l_mux4_1_6.A2 sg13cmos5l_inv_1_366.A 0.01645f
C5766 a_18764_18228# VPWR 0.25488f
C5767 sg13cmos5l_inv_1_409.Y sg13cmos5l_inv_1_392.A 0.02471f
C5768 sg13cmos5l_inv_1_830.A sg13cmos5l_inv_1_823.Y 0.12475f
C5769 a_13288_10790# a_13472_10790# 0.11523f
C5770 sg13cmos5l_inv_1_179.A sg13cmos5l_inv_1_78.A 0.08569f
C5771 sg13cmos5l_inv_1_526.Y sg13cmos5l_inv_1_504.Y 0.03554f
C5772 sg13cmos5l_inv_1_527.A sg13cmos5l_inv_1_513.A 0.11231f
C5773 a_8288_15326# VPWR 0.08805f
C5774 sg13cmos5l_inv_1_378.Y sg13cmos5l_inv_1_350.A 0.31567f
C5775 sg13cmos5l_inv_1_442.Y sg13cmos5l_inv_1_252.A 0.0108f
C5776 sg13cmos5l_inv_1_738.A sg13cmos5l_inv_1_998.Y 0.0381f
C5777 sg13cmos5l_inv_1_136.Y sg13cmos5l_inv_1_140.A 0.109f
C5778 sg13cmos5l_nor3_1_0.Y a_9341_9192# 0.02677f
C5779 sg13cmos5l_o21ai_1_0.Y sg13cmos5l_mux2_1_3.X 0.03151f
C5780 sg13cmos5l_inv_1_130.Y sg13cmos5l_inv_1_78.A 0.03032f
C5781 sg13cmos5l_inv_1_800.A sg13cmos5l_inv_1_786.Y 0.04971f
C5782 sg13cmos5l_inv_1_463.Y sg13cmos5l_inv_1_440.A 0.01538f
C5783 sg13cmos5l_o21ai_1_0.B1 a_10162_9570# 0.04242f
C5784 sg13cmos5l_inv_1_436.A sg13cmos5l_inv_1_437.A 0.24022f
C5785 a_17984_16122# VPWR 0.08f
C5786 sg13cmos5l_nor3_1_1.A sg13cmos5l_mux2_1_3.S 0.23745f
C5787 sg13cmos5l_o21ai_1_0.B1 sg13cmos5l_a21oi_1_0.B1 1.10532f
C5788 sg13cmos5l_inv_1_324.Y sg13cmos5l_inv_1_297.Y 0.22572f
C5789 sg13cmos5l_inv_1_804.A VPWR 0.44902f
C5790 a_12808_12302# VPWR 0.20554f
C5791 sg13cmos5l_buf_1_9.A a_14422_12606# 0.02901f
C5792 a_7501_8440# VPWR 0.12538f
C5793 sg13cmos5l_inv_1_562.A sg13cmos5l_inv_1_560.Y 0.0398f
C5794 sg13cmos5l_inv_1_535.A sg13cmos5l_inv_1_562.Y 0.17528f
C5795 sg13cmos5l_buf_1_12.X sg13cmos5l_inv_1_397.Y 0.9878f
C5796 sg13cmos5l_inv_1_580.A a_8653_16000# 0.01246f
C5797 sg13cmos5l_inv_1_933.Y sg13cmos5l_inv_1_933.A 0.20693f
C5798 sg13cmos5l_mux4_1_8.A1 sg13cmos5l_inv_1_618.A 0.05674f
C5799 sg13cmos5l_inv_1_320.Y sg13cmos5l_inv_1_314.Y 0.2185f
C5800 sg13cmos5l_mux4_1_5.S1 sg13cmos5l_inv_1_109.Y 0.06278f
C5801 sg13cmos5l_inv_1_553.Y sg13cmos5l_inv_1_543.Y 0.21522f
C5802 sg13cmos5l_mux4_1_15.X sg13cmos5l_inv_1_699.Y 0.02556f
C5803 sg13cmos5l_mux4_1_5.S0 sg13cmos5l_inv_1_284.A 0.02003f
C5804 sg13cmos5l_inv_1_237.Y sg13cmos5l_inv_1_297.Y 0.02011f
C5805 sg13cmos5l_inv_1_171.Y sg13cmos5l_inv_1_168.A 0.3873f
C5806 sg13cmos5l_buf_1_8.A sg13cmos5l_inv_1_212.Y 0.113f
C5807 sg13cmos5l_inv_1_59.Y sg13cmos5l_inv_1_102.Y 0.09448f
C5808 sg13cmos5l_mux4_1_4.A2 a_6119_8434# 0.20641f
C5809 sg13cmos5l_inv_1_665.A VPWR 0.60992f
C5810 sg13cmos5l_inv_1_402.A a_6430_8434# 0.01907f
C5811 sg13cmos5l_mux4_1_7.A3 a_7905_13012# 0.01364f
C5812 sg13cmos5l_buf_1_12.X sg13cmos5l_inv_1_346.Y 0.47964f
C5813 sg13cmos5l_inv_1_29.A sg13cmos5l_inv_1_37.A 0.01055f
C5814 sg13cmos5l_inv_1_861.A sg13cmos5l_inv_1_874.A 0.28945f
C5815 sg13cmos5l_inv_1_120.A sg13cmos5l_mux2_1_3.A0 0.02907f
C5816 a_14989_14488# a_14913_14524# 0.2611f
C5817 sg13cmos5l_inv_1_65.A sg13cmos5l_inv_1_70.Y 0.01156f
C5818 sg13cmos5l_mux4_1_5.S1 sg13cmos5l_inv_1_248.A 0.14631f
C5819 a_13918_14482# a_14125_14749# 0.01967f
C5820 sg13cmos5l_mux4_1_11.A3 sg13cmos5l_inv_1_699.A 0.03278f
C5821 a_6599_12970# a_6836_12970# 0.01012f
C5822 a_5792_6254# VPWR 0.07786f
C5823 sg13cmos5l_inv_1_507.A sg13cmos5l_inv_1_507.Y 0.88679f
C5824 sg13cmos5l_inv_1_217.A a_19048_5538# 0.06311f
C5825 sg13cmos5l_mux4_1_10.A2 sg13cmos5l_inv_1_568.A 0.23215f
C5826 sg13cmos5l_inv_1_990.Y sg13cmos5l_mux4_1_6.A2 0.03469f
C5827 sg13cmos5l_mux4_1_13.A3 a_15277_15514# 0.013f
C5828 sg13cmos5l_inv_1_818.A sg13cmos5l_inv_1_818.Y 0.23049f
C5829 sg13cmos5l_mux4_1_13.A0 sg13cmos5l_inv_1_787.Y 0.06053f
C5830 sg13cmos5l_buf_1_9.A sg13cmos5l_inv_1_202.Y 0.08414f
C5831 sg13cmos5l_inv_1_433.Y sg13cmos5l_inv_1_241.A 0.15937f
C5832 sg13cmos5l_inv_1_773.Y sg13cmos5l_inv_1_789.Y 0.01193f
C5833 sg13cmos5l_inv_1_612.Y sg13cmos5l_inv_1_584.A 0.1623f
C5834 sg13cmos5l_inv_1_626.Y sg13cmos5l_inv_1_614.A 0.04714f
C5835 sg13cmos5l_nor3_1_0.Y sg13cmos5l_nor3_1_1.Y 0.21204f
C5836 sg13cmos5l_nor4_1_0.A sg13cmos5l_o21ai_1_0.Y 0.04338f
C5837 sg13cmos5l_buf_1_7.X invsel[0] 0.01038f
C5838 sg13cmos5l_inv_1_326.Y sg13cmos5l_inv_1_301.A 0.19057f
C5839 sg13cmos5l_mux4_1_5.S1 sg13cmos5l_inv_1_85.A 0.90157f
C5840 sg13cmos5l_nor3_1_2.B a_14827_11673# 0.52132f
C5841 sg13cmos5l_inv_1_826.Y VPWR 0.35535f
C5842 sg13cmos5l_inv_1_235.A sg13cmos5l_inv_1_236.Y 0.27468f
C5843 sg13cmos5l_inv_1_234.A a_11456_4742# 0.01068f
C5844 a_13799_3534# a_14614_3534# 0.49917f
C5845 sg13cmos5l_inv_1_369.A sg13cmos5l_inv_1_362.A 0.04976f
C5846 sg13cmos5l_inv_1_370.A sg13cmos5l_inv_1_376.A 0.02517f
C5847 sg13cmos5l_inv_1_305.Y a_808_4656# 0.02402f
C5848 sg13cmos5l_inv_1_948.A sg13cmos5l_inv_1_882.Y 0.08133f
C5849 sg13cmos5l_inv_1_898.Y sg13cmos5l_inv_1_949.Y 0.15887f
C5850 sg13cmos5l_inv_1_237.Y sg13cmos5l_inv_1_416.A 0.05819f
C5851 a_7425_8476# VPWR 0.7093f
C5852 sg13cmos5l_inv_1_938.Y sg13cmos5l_inv_1_938.A 0.13628f
C5853 sg13cmos5l_inv_1_326.Y a_4438_3534# 0.01469f
C5854 sg13cmos5l_inv_1_576.A sg13cmos5l_inv_1_533.Y 0.19096f
C5855 sg13cmos5l_inv_1_580.A a_8577_16036# 0.0379f
C5856 sg13cmos5l_inv_1_744.Y VPWR 2.33938f
C5857 sg13cmos5l_mux4_1_7.A2 sg13cmos5l_inv_1_898.A 0.19189f
C5858 sg13cmos5l_inv_1_967.Y VPWR 0.44913f
C5859 a_13918_12606# a_13831_12267# 0.02548f
C5860 sg13cmos5l_mux2_1_3.X sg13cmos5l_mux2_1_3.A0 0.03858f
C5861 sg13cmos5l_inv_1_237.Y sg13cmos5l_inv_1_981.Y 0.01482f
C5862 a_14494_9582# a_14407_9243# 0.02548f
C5863 sg13cmos5l_inv_1_556.Y sg13cmos5l_inv_1_560.Y 0.01156f
C5864 sg13cmos5l_inv_1_744.Y sg13cmos5l_inv_1_708.A 0.02973f
C5865 sg13cmos5l_buf_1_9.A sg13cmos5l_inv_1_874.Y 0.03671f
C5866 sg13cmos5l_inv_1_772.A a_10592_18350# 0.01507f
C5867 sg13cmos5l_inv_1_215.Y sg13cmos5l_inv_1_173.Y 0.04835f
C5868 sg13cmos5l_mux4_1_8.A1 a_7582_15994# 0.17132f
C5869 sg13cmos5l_mux4_1_11.A2 a_14827_11673# 0.20566f
C5870 sg13cmos5l_inv_1_149.Y sg13cmos5l_inv_1_206.A 0.0429f
C5871 sg13cmos5l_inv_1_519.Y a_3934_12606# 0.03706f
C5872 sg13cmos5l_nor2b_1_0.B_N sg13cmos5l_inv_1_545.Y 0.24542f
C5873 sg13cmos5l_o21ai_1_0.B1 sg13cmos5l_inv_1_985.Y 0.7416f
C5874 sg13cmos5l_inv_1_237.Y sg13cmos5l_inv_1_324.Y 0.14736f
C5875 sg13cmos5l_inv_1_3.Y VPWR 0.3558f
C5876 sg13cmos5l_inv_1_344.Y sg13cmos5l_inv_1_433.A 0.03658f
C5877 sg13cmos5l_inv_1_283.A sg13cmos5l_inv_1_418.Y 0.2111f
C5878 sg13cmos5l_inv_1_498.A VPWR 0.60467f
C5879 sg13cmos5l_inv_1_391.A sg13cmos5l_inv_1_397.Y 0.02524f
C5880 sg13cmos5l_inv_1_113.A sg13cmos5l_inv_1_202.Y 0.21312f
C5881 sg13cmos5l_inv_1_323.A VPWR 0.42983f
C5882 sg13cmos5l_nor3_1_1.A sg13cmos5l_inv_1_964.Y 0.01519f
C5883 sg13cmos5l_inv_1_973.Y sg13cmos5l_inv_1_974.A 0.01076f
C5884 sg13cmos5l_inv_1_844.Y sg13cmos5l_inv_1_845.Y 0.20065f
C5885 sg13cmos5l_inv_1_293.Y sg13cmos5l_inv_1_304.A 0.02522f
C5886 a_13288_11586# a_13288_10790# 0.01095f
C5887 sg13cmos5l_inv_1_806.Y sg13cmos5l_inv_1_798.A 0.02464f
C5888 sg13cmos5l_inv_1_576.A sg13cmos5l_inv_1_563.A 0.25794f
C5889 sg13cmos5l_inv_1_711.Y VPWR 0.57514f
C5890 sg13cmos5l_inv_1_658.Y sg13cmos5l_inv_1_684.A 0.05555f
C5891 sg13cmos5l_mux4_1_7.A2 sg13cmos5l_nor3_1_2.B 0.2015f
C5892 a_15608_7680# VPWR 0.03013f
C5893 sg13cmos5l_mux4_1_5.S1 sg13cmos5l_inv_1_235.A 0.02214f
C5894 sg13cmos5l_inv_1_595.Y sg13cmos5l_inv_1_594.Y 0.20065f
C5895 sg13cmos5l_inv_1_876.Y sg13cmos5l_inv_1_875.A 0.14805f
C5896 sg13cmos5l_inv_1_531.A sg13cmos5l_inv_1_514.A 0.01292f
C5897 a_3934_15994# VPWR 0.88382f
C5898 sg13cmos5l_buf_1_9.A a_4438_15994# 0.02847f
C5899 sg13cmos5l_buf_1_8.A sg13cmos5l_inv_1_699.A 0.54201f
C5900 sg13cmos5l_buf_1_8.A sg13cmos5l_mux2_1_4.X 0.02371f
C5901 sg13cmos5l_mux4_1_5.S1 sg13cmos5l_inv_1_122.Y 0.01337f
C5902 sg13cmos5l_inv_1_304.A sg13cmos5l_inv_1_296.Y 0.24969f
C5903 sg13cmos5l_inv_1_871.Y VPWR 0.34823f
C5904 sg13cmos5l_inv_1_140.Y VPWR 0.56489f
C5905 sg13cmos5l_inv_1_141.Y VPWR 0.38586f
C5906 sg13cmos5l_inv_1_557.A a_3680_17634# 0.0363f
C5907 sg13cmos5l_inv_1_610.Y sg13cmos5l_inv_1_534.Y 0.17117f
C5908 sg13cmos5l_inv_1_421.Y VPWR 0.60063f
C5909 sg13cmos5l_inv_1_717.A a_17416_11586# 0.01986f
C5910 sg13cmos5l_inv_1_45.Y sg13cmos5l_inv_1_53.Y 0.16879f
C5911 sg13cmos5l_inv_1_103.A a_13288_2514# 0.05172f
C5912 sg13cmos5l_inv_1_16.A sg13cmos5l_inv_1_17.Y 0.0649f
C5913 sg13cmos5l_buf_1_8.A sg13cmos5l_inv_1_144.Y 0.01036f
C5914 sg13cmos5l_inv_1_799.A sg13cmos5l_inv_1_797.A 0.20065f
C5915 sg13cmos5l_buf_1_9.A sg13cmos5l_inv_1_173.Y 0.01284f
C5916 sg13cmos5l_inv_1_861.A sg13cmos5l_buf_1_9.A 0.01099f
C5917 a_13288_16838# VPWR 0.1312f
C5918 a_13895_15630# a_14119_15291# 0.01074f
C5919 sg13cmos5l_buf_1_9.A sg13cmos5l_mux4_1_7.A1 0.02148f
C5920 sg13cmos5l_inv_1_453.Y a_5032_1718# 0.01986f
C5921 sg13cmos5l_inv_1_645.A sg13cmos5l_inv_1_479.Y 0.01911f
C5922 sg13cmos5l_inv_1_63.A sg13cmos5l_inv_1_61.A 0.0562f
C5923 sg13cmos5l_nor3_1_2.B sg13cmos5l_mux2_1_3.S 0.1882f
C5924 sg13cmos5l_inv_1_101.Y a_10688_2514# 0.0147f
C5925 sg13cmos5l_inv_1_815.Y a_17984_16122# 0.04422f
C5926 sg13cmos5l_inv_1_748.Y VPWR 0.43125f
C5927 a_18664_3144# sg13cmos5l_inv_1_37.A 0.33634f
C5928 sg13cmos5l_mux4_1_5.S1 a_8638_6558# 0.03006f
C5929 sg13cmos5l_buf_1_10.A sg13cmos5l_inv_1_487.A 0.05565f
C5930 sg13cmos5l_inv_1_519.Y sg13cmos5l_buf_1_8.A 0.0664f
C5931 sg13cmos5l_inv_1_106.A sg13cmos5l_inv_1_148.Y 0.01299f
C5932 sg13cmos5l_buf_1_0.A sg13cmos5l_inv_1_66.A 1.43721f
C5933 sg13cmos5l_nand2_1_1.B sg13cmos5l_inv_1_1009.Y 0.03149f
C5934 a_4438_12606# a_5005_12490# 0.40359f
C5935 sg13cmos5l_mux2_1_4.S sg13cmos5l_inv_1_976.Y 0.07661f
C5936 sg13cmos5l_inv_1_730.Y sg13cmos5l_inv_1_716.A 0.01538f
C5937 sg13cmos5l_inv_1_773.Y a_11456_17634# 0.0363f
C5938 sg13cmos5l_buf_1_9.A sg13cmos5l_inv_1_346.Y 0.09436f
C5939 sg13cmos5l_mux4_1_13.A0 sg13cmos5l_inv_1_857.Y 0.01328f
C5940 sg13cmos5l_mux4_1_5.S0 a_5005_3418# 0.0102f
C5941 sg13cmos5l_inv_1_186.Y a_18764_5370# 0.0458f
C5942 sg13cmos5l_inv_1_402.A sg13cmos5l_inv_1_412.A 0.09073f
C5943 sg13cmos5l_inv_1_582.A VPWR 0.54818f
C5944 sg13cmos5l_inv_1_28.A sg13cmos5l_inv_1_51.A 0.02521f
C5945 sg13cmos5l_inv_1_610.A VPWR 0.42448f
C5946 sg13cmos5l_mux4_1_6.A2 sg13cmos5l_inv_1_370.A 0.28728f
C5947 a_5005_16000# sg13cmos5l_mux2_1_2.A0 0.01437f
C5948 sg13cmos5l_inv_1_113.A a_11368_8562# 0.03352f
C5949 sg13cmos5l_inv_1_479.Y a_6599_12970# 0.06398f
C5950 sg13cmos5l_inv_1_338.Y a_4736_2514# 0.01054f
C5951 sg13cmos5l_inv_1_421.A a_3872_4742# 0.01257f
C5952 sg13cmos5l_inv_1_830.A sg13cmos5l_inv_1_838.Y 0.2023f
C5953 sg13cmos5l_inv_1_527.A sg13cmos5l_inv_1_504.Y 0.01019f
C5954 sg13cmos5l_inv_1_531.A sg13cmos5l_inv_1_513.A 0.22732f
C5955 sg13cmos5l_inv_1_526.Y sg13cmos5l_inv_1_526.A 0.16846f
C5956 sg13cmos5l_inv_1_625.Y VPWR 0.53473f
C5957 sg13cmos5l_inv_1_978.A sg13cmos5l_inv_1_112.Y 0.2078f
C5958 sg13cmos5l_inv_1_787.Y a_12136_16122# 0.02369f
C5959 sg13cmos5l_mux4_1_11.A1 a_14827_11673# 0.19282f
C5960 sg13cmos5l_inv_1_442.Y sg13cmos5l_inv_1_254.Y 0.18681f
C5961 sg13cmos5l_inv_1_738.A sg13cmos5l_inv_1_735.Y 0.02887f
C5962 sg13cmos5l_inv_1_140.Y sg13cmos5l_inv_1_140.A 0.38001f
C5963 sg13cmos5l_inv_1_129.Y sg13cmos5l_inv_1_78.A 0.08863f
C5964 sg13cmos5l_inv_1_179.A sg13cmos5l_inv_1_149.Y 0.05908f
C5965 sg13cmos5l_mux4_1_13.A3 sg13cmos5l_mux4_1_14.A3 0.02346f
C5966 sg13cmos5l_inv_1_478.Y sg13cmos5l_a22oi_1_0.B1 0.20816f
C5967 sg13cmos5l_inv_1_794.A sg13cmos5l_inv_1_800.Y 0.01072f
C5968 sg13cmos5l_inv_1_241.A sg13cmos5l_inv_1_452.Y 0.08154f
C5969 sg13cmos5l_inv_1_216.Y a_13799_3534# 0.05019f
C5970 sg13cmos5l_inv_1_436.A sg13cmos5l_inv_1_451.A 0.34259f
C5971 sg13cmos5l_inv_1_828.Y sg13cmos5l_mux4_1_14.A1 0.09218f
C5972 sg13cmos5l_nor3_1_2.B a_9996_11500# 0.01613f
C5973 sg13cmos5l_nor3_1_1.A sg13cmos5l_inv_1_922.A 0.02083f
C5974 sg13cmos5l_buf_1_0.A sg13cmos5l_inv_1_85.A 0.15321f
C5975 sg13cmos5l_inv_1_563.Y a_1952_16122# 0.0143f
C5976 sg13cmos5l_inv_1_324.Y sg13cmos5l_inv_1_331.A 0.02528f
C5977 sg13cmos5l_buf_1_9.A sg13cmos5l_inv_1_704.Y 0.02125f
C5978 sg13cmos5l_inv_1_733.A VPWR 1.38692f
C5979 a_14206_15630# a_14629_15291# 0.01929f
C5980 sg13cmos5l_inv_1_562.A sg13cmos5l_inv_1_560.A 0.04075f
C5981 sg13cmos5l_buf_1_12.X sg13cmos5l_inv_1_391.A 0.03679f
C5982 a_3847_3195# VPWR 0.02431f
C5983 a_12808_1718# VPWR 0.20383f
C5984 sg13cmos5l_inv_1_382.A a_8327_6558# 0.23595f
C5985 sg13cmos5l_inv_1_681.Y sg13cmos5l_inv_1_681.A 0.30326f
C5986 sg13cmos5l_mux4_1_15.A3 VPWR 0.803f
C5987 sg13cmos5l_mux4_1_15.X sg13cmos5l_inv_1_704.Y 0.05096f
C5988 sg13cmos5l_inv_1_998.Y sg13cmos5l_inv_1_976.Y 0.04601f
C5989 sg13cmos5l_buf_1_10.A a_4929_12564# 0.23858f
C5990 sg13cmos5l_inv_1_947.A sg13cmos5l_nand2_1_1.B 0.02856f
C5991 sg13cmos5l_a22oi_1_0.B1 VPWR 1.57962f
C5992 a_8577_3492# sg13cmos5l_mux4_1_3.X 0.20257f
C5993 a_9326_3410# a_9432_3406# 0.55132f
C5994 sg13cmos5l_inv_1_16.Y osc 0.44497f
C5995 sg13cmos5l_inv_1_426.A sg13cmos5l_inv_1_416.A 1.56493f
C5996 sg13cmos5l_inv_1_202.Y a_14998_9582# 0.02364f
C5997 sg13cmos5l_inv_1_654.Y sg13cmos5l_inv_1_655.Y 0.20868f
C5998 sg13cmos5l_buf_1_17.X a_18664_13004# 0.29036f
C5999 sg13cmos5l_inv_1_37.Y sg13cmos5l_inv_1_37.A 0.09414f
C6000 sg13cmos5l_buf_1_8.A sg13cmos5l_inv_1_177.Y 0.01965f
C6001 sg13cmos5l_mux4_1_6.X sg13cmos5l_inv_1_403.A 0.13768f
C6002 sg13cmos5l_mux2_1_4.S a_14913_3940# 0.2429f
C6003 sg13cmos5l_inv_1_248.A sg13cmos5l_inv_1_454.Y 0.03093f
C6004 sg13cmos5l_inv_1_7.Y a_17024_1002# 0.01271f
C6005 sg13cmos5l_o21ai_1_0.B1 sg13cmos5l_inv_1_668.Y 0.10868f
C6006 sg13cmos5l_inv_1_383.Y VPWR 0.38145f
C6007 a_4929_16036# sg13cmos5l_mux2_1_2.A0 0.20743f
C6008 sg13cmos5l_inv_1_533.A sg13cmos5l_inv_1_568.A 0.0255f
C6009 sg13cmos5l_inv_1_112.Y sg13cmos5l_inv_1_113.A 0.0356f
C6010 a_14422_14482# VPWR 0.02986f
C6011 sg13cmos5l_inv_1_991.A sg13cmos5l_mux4_1_6.A2 0.2318f
C6012 sg13cmos5l_inv_1_818.A sg13cmos5l_mux4_1_11.A3 0.02522f
C6013 sg13cmos5l_buf_1_8.A sg13cmos5l_inv_1_348.A 0.02323f
C6014 sg13cmos5l_inv_1_72.Y sg13cmos5l_inv_1_70.Y 0.43523f
C6015 sg13cmos5l_inv_1_609.A sg13cmos5l_mux4_1_5.S0 0.03227f
C6016 sg13cmos5l_inv_1_296.A sg13cmos5l_inv_1_308.Y 0.03743f
C6017 sg13cmos5l_inv_1_416.Y sg13cmos5l_inv_1_241.A 0.15739f
C6018 sg13cmos5l_inv_1_790.Y sg13cmos5l_inv_1_789.Y 0.23289f
C6019 sg13cmos5l_buf_1_9.A sg13cmos5l_inv_1_237.Y 0.10713f
C6020 sg13cmos5l_inv_1_791.A a_10496_16838# 0.03553f
C6021 sg13cmos5l_inv_1_612.Y sg13cmos5l_inv_1_614.A 0.04434f
C6022 sg13cmos5l_inv_1_837.Y sg13cmos5l_inv_1_843.Y 0.06941f
C6023 sg13cmos5l_nor4_1_0.A sg13cmos5l_nor3_1_1.Y 0.01064f
C6024 sg13cmos5l_inv_1_783.A a_13472_18350# 0.03465f
C6025 sg13cmos5l_buf_1_9.A sg13cmos5l_buf_1_12.X 0.02747f
C6026 sg13cmos5l_inv_1_65.Y sg13cmos5l_inv_1_981.Y 0.02649f
C6027 sg13cmos5l_inv_1_981.A a_9640_1718# 0.03747f
C6028 sg13cmos5l_inv_1_234.A sg13cmos5l_inv_1_236.Y 0.09533f
C6029 sg13cmos5l_inv_1_369.A sg13cmos5l_inv_1_376.A 0.28561f
C6030 sg13cmos5l_inv_1_886.Y sg13cmos5l_inv_1_949.Y 0.19228f
C6031 sg13cmos5l_inv_1_986.Y sg13cmos5l_inv_1_988.A 0.01657f
C6032 sg13cmos5l_inv_1_237.Y sg13cmos5l_inv_1_426.A 0.19909f
C6033 sg13cmos5l_inv_1_267.Y sg13cmos5l_inv_1_416.A 0.0157f
C6034 sg13cmos5l_inv_1_152.Y sg13cmos5l_inv_1_217.A 0.01327f
C6035 sg13cmos5l_inv_1_875.A sg13cmos5l_inv_1_888.Y 0.0616f
C6036 sg13cmos5l_mux4_1_12.A3 VPWR 1.46858f
C6037 sg13cmos5l_nor3_1_1.A sg13cmos5l_nand2_1_1.B 0.19952f
C6038 sg13cmos5l_inv_1_482.Y sg13cmos5l_inv_1_498.A 0.09475f
C6039 sg13cmos5l_inv_1_346.Y a_2144_7050# 0.04598f
C6040 sg13cmos5l_inv_1_122.Y sg13cmos5l_buf_1_0.A 0.0869f
C6041 sg13cmos5l_inv_1_248.A a_7271_3534# 0.02995f
C6042 sg13cmos5l_buf_1_8.A sg13cmos5l_mux4_1_6.A2 0.68596f
C6043 a_13288_2514# a_13288_1718# 0.01095f
C6044 sg13cmos5l_inv_1_462.A a_5032_6254# 0.05062f
C6045 sg13cmos5l_inv_1_305.Y sg13cmos5l_inv_1_305.A 0.22245f
C6046 sg13cmos5l_inv_1_138.A sg13cmos5l_inv_1_78.A 0.02353f
C6047 sg13cmos5l_inv_1_743.Y VPWR 0.44832f
C6048 sg13cmos5l_inv_1_76.A a_13918_3898# 0.18895f
C6049 sg13cmos5l_inv_1_966.Y VPWR 0.44669f
C6050 sg13cmos5l_inv_1_532.A a_3304_12302# 0.04368f
C6051 sg13cmos5l_inv_1_498.A sg13cmos5l_inv_1_490.A 0.25109f
C6052 sg13cmos5l_nor3_1_1.B sg13cmos5l_mux2_1_3.S 0.05053f
C6053 sg13cmos5l_mux2_1_3.X sg13cmos5l_mux4_1_16.X 0.05772f
C6054 sg13cmos5l_inv_1_322.A sg13cmos5l_inv_1_321.A 0.03916f
C6055 sg13cmos5l_inv_1_744.Y sg13cmos5l_inv_1_725.Y 0.0102f
C6056 sg13cmos5l_mux4_1_5.S1 sg13cmos5l_mux4_1_5.X 4.04841f
C6057 sg13cmos5l_buf_1_8.A sg13cmos5l_inv_1_988.A 0.01004f
C6058 sg13cmos5l_a21oi_1_1.A2 sg13cmos5l_inv_1_625.Y 0.02869f
C6059 sg13cmos5l_inv_1_76.A a_11456_4026# 0.03539f
C6060 sg13cmos5l_inv_1_247.A sg13cmos5l_inv_1_240.Y 0.0123f
C6061 a_13288_7050# a_13288_6254# 0.01095f
C6062 sg13cmos5l_nor2b_1_0.B_N sg13cmos5l_inv_1_543.Y 0.19819f
C6063 sg13cmos5l_inv_1_762.Y a_13288_12302# 0.04353f
C6064 sg13cmos5l_inv_1_168.A sg13cmos5l_inv_1_177.Y 0.021f
C6065 sg13cmos5l_o21ai_1_0.B1 sg13cmos5l_inv_1_359.Y 0.02021f
C6066 sg13cmos5l_inv_1_4.Y VPWR 0.42189f
C6067 sg13cmos5l_inv_1_473.Y sg13cmos5l_inv_1_475.Y 0.20693f
C6068 sg13cmos5l_mux4_1_5.S1 sg13cmos5l_inv_1_224.Y 0.0222f
C6069 sg13cmos5l_inv_1_283.A sg13cmos5l_inv_1_433.A 0.01747f
C6070 a_14027_11654# a_14171_11488# 0.26108f
C6071 sg13cmos5l_inv_1_491.A VPWR 1.33288f
C6072 sg13cmos5l_inv_1_336.A VPWR 0.64821f
C6073 sg13cmos5l_inv_1_884.Y a_13607_14482# 0.22021f
C6074 sg13cmos5l_inv_1_292.Y a_6952_2514# 0.03352f
C6075 sg13cmos5l_inv_1_267.Y sg13cmos5l_inv_1_237.Y 0.03353f
C6076 a_6910_12970# a_7414_12970# 0.97548f
C6077 a_7981_12976# sg13cmos5l_a22oi_1_0.A1 0.01246f
C6078 a_18280_5444# osc_tap[1] 0.29988f
C6079 sg13cmos5l_mux4_1_16.X a_9709_6442# 0.01123f
C6080 sg13cmos5l_inv_1_896.Y VPWR 0.42581f
C6081 sg13cmos5l_buf_1_12.X sg13cmos5l_inv_1_267.Y 0.0365f
C6082 sg13cmos5l_inv_1_258.A sg13cmos5l_inv_1_292.Y 0.0699f
C6083 sg13cmos5l_inv_1_480.A sg13cmos5l_nor3_1_2.B 0.01099f
C6084 sg13cmos5l_mux4_1_5.S1 sg13cmos5l_inv_1_234.A 0.0408f
C6085 sg13cmos5l_inv_1_447.A a_8864_4742# 0.04437f
C6086 sg13cmos5l_mux2_1_0.X sg13cmos5l_inv_1_113.Y 0.03724f
C6087 sg13cmos5l_inv_1_816.Y sg13cmos5l_inv_1_875.A 0.01138f
C6088 a_12896_2514# VPWR 0.12634f
C6089 sg13cmos5l_buf_1_8.A sg13cmos5l_inv_1_441.A 0.1134f
C6090 sg13cmos5l_buf_1_10.A sg13cmos5l_inv_1_416.A 0.6309f
C6091 sg13cmos5l_inv_1_304.A sg13cmos5l_inv_1_294.Y 0.04416f
C6092 sg13cmos5l_inv_1_843.A VPWR 0.57793f
C6093 sg13cmos5l_inv_1_175.A VPWR 0.4248f
C6094 sg13cmos5l_inv_1_592.A sg13cmos5l_inv_1_534.Y 0.03128f
C6095 sg13cmos5l_inv_1_679.A sg13cmos5l_inv_1_535.Y 0.23111f
C6096 sg13cmos5l_inv_1_434.A VPWR 0.43298f
C6097 sg13cmos5l_mux2_1_3.X sg13cmos5l_nand2_1_1.Y 0.91344f
C6098 sg13cmos5l_inv_1_45.Y sg13cmos5l_inv_1_48.Y 0.024f
C6099 sg13cmos5l_inv_1_311.Y sg13cmos5l_inv_1_311.A 0.22537f
C6100 sg13cmos5l_inv_1_491.A sg13cmos5l_a22oi_1_0.A2 0.05318f
C6101 sg13cmos5l_inv_1_421.A sg13cmos5l_inv_1_346.Y 0.0773f
C6102 sg13cmos5l_inv_1_16.A sg13cmos5l_inv_1_17.A 0.05627f
C6103 sg13cmos5l_buf_1_8.A sg13cmos5l_inv_1_181.Y 0.31306f
C6104 sg13cmos5l_inv_1_684.A sg13cmos5l_inv_1_684.Y 0.28889f
C6105 sg13cmos5l_mux4_1_3.X VPWR 0.22138f
C6106 sg13cmos5l_inv_1_202.Y sg13cmos5l_inv_1_159.A 0.14161f
C6107 a_13472_11586# VPWR 0.0691f
C6108 sg13cmos5l_buf_1_9.A a_13856_11586# 0.01114f
C6109 sg13cmos5l_inv_1_690.A sg13cmos5l_inv_1_650.Y 0.03623f
C6110 sg13cmos5l_inv_1_349.A sg13cmos5l_inv_1_449.A 0.01501f
C6111 sg13cmos5l_inv_1_748.A VPWR 0.43958f
C6112 sg13cmos5l_inv_1_49.A sg13cmos5l_inv_1_37.A 0.06742f
C6113 a_18664_3144# sg13cmos5l_inv_1_39.A 0.11692f
C6114 sg13cmos5l_inv_1_445.A sg13cmos5l_inv_1_443.Y 0.21838f
C6115 sg13cmos5l_buf_1_10.A sg13cmos5l_inv_1_677.A 0.04362f
C6116 sg13cmos5l_inv_1_106.A sg13cmos5l_inv_1_148.A 0.01471f
C6117 a_14389_11500# a_14827_11673# 0.49675f
C6118 sg13cmos5l_inv_1_827.A sg13cmos5l_inv_1_863.Y 0.01538f
C6119 sg13cmos5l_mux2_1_4.S a_10888_9278# 0.02584f
C6120 a_1856_2514# VPWR 0.08475f
C6121 sg13cmos5l_mux4_1_13.A0 sg13cmos5l_inv_1_857.A 0.0186f
C6122 sg13cmos5l_buf_1_8.A sg13cmos5l_inv_1_30.A 0.01351f
C6123 sg13cmos5l_buf_1_10.A sg13cmos5l_inv_1_237.Y 0.50381f
C6124 sg13cmos5l_inv_1_887.Y sg13cmos5l_mux4_1_12.A1 0.08337f
C6125 sg13cmos5l_inv_1_220.Y sg13cmos5l_inv_1_17.A 0.01599f
C6126 sg13cmos5l_inv_1_453.Y sg13cmos5l_inv_1_442.Y 0.06188f
C6127 sg13cmos5l_mux4_1_5.S0 sg13cmos5l_inv_1_498.A 0.54192f
C6128 sg13cmos5l_inv_1_617.A a_8680_17634# 0.01986f
C6129 sg13cmos5l_inv_1_402.A sg13cmos5l_inv_1_401.Y 0.04358f
C6130 a_7905_13012# sg13cmos5l_a22oi_1_0.A1 0.20948f
C6131 sg13cmos5l_buf_1_10.A sg13cmos5l_buf_1_12.X 0.03318f
C6132 sg13cmos5l_inv_1_494.Y sg13cmos5l_inv_1_922.Y 0.01224f
C6133 sg13cmos5l_inv_1_925.A sg13cmos5l_inv_1_982.A 0.01651f
C6134 a_13607_14482# a_13831_14749# 0.01074f
C6135 sg13cmos5l_inv_1_399.Y sg13cmos5l_inv_1_400.Y 0.16776f
C6136 sg13cmos5l_inv_1_393.Y a_6752_7050# 0.01083f
C6137 sg13cmos5l_inv_1_796.Y sg13cmos5l_inv_1_874.A 0.03618f
C6138 sg13cmos5l_mux4_1_6.A2 sg13cmos5l_inv_1_369.A 0.03569f
C6139 a_10504_9192# a_10888_9278# 0.03269f
C6140 sg13cmos5l_inv_1_345.Y sg13cmos5l_inv_1_349.A 0.01559f
C6141 sg13cmos5l_inv_1_442.A sg13cmos5l_inv_1_254.Y 0.01919f
C6142 a_3304_16122# VPWR 0.13173f
C6143 sg13cmos5l_mux4_1_5.S0 a_3934_15994# 0.07558f
C6144 sg13cmos5l_inv_1_179.A sg13cmos5l_inv_1_173.Y 0.03049f
C6145 sg13cmos5l_inv_1_537.A VPWR 0.65904f
C6146 a_4798_12970# a_4912_12970# 0.03097f
C6147 sg13cmos5l_inv_1_482.Y sg13cmos5l_a22oi_1_0.B1 0.04968f
C6148 sg13cmos5l_inv_1_394.A VPWR 0.73754f
C6149 sg13cmos5l_inv_1_461.Y sg13cmos5l_inv_1_430.A 0.01538f
C6150 sg13cmos5l_inv_1_241.A sg13cmos5l_inv_1_266.Y 0.25803f
C6151 sg13cmos5l_a21oi_1_1.A2 sg13cmos5l_inv_1_491.A 0.01495f
C6152 sg13cmos5l_inv_1_338.Y a_3934_3534# 0.03432f
C6153 sg13cmos5l_inv_1_130.Y sg13cmos5l_inv_1_173.Y 0.02097f
C6154 a_7271_15994# a_7700_15994# 0.0289f
C6155 sg13cmos5l_nor3_1_2.B sg13cmos5l_nor4_1_0.Y 0.15495f
C6156 sg13cmos5l_inv_1_828.Y sg13cmos5l_inv_1_779.Y 0.06949f
C6157 sg13cmos5l_nor2b_1_0.B_N enable 0.18996f
C6158 sg13cmos5l_a21oi_1_1.A1 a_9064_10790# 0.01071f
C6159 a_6119_8434# VPWR 0.47826f
C6160 sg13cmos5l_mux4_1_9.X sg13cmos5l_inv_1_677.Y 0.01789f
C6161 sg13cmos5l_nor3_1_2.B sg13cmos5l_nand2_1_1.B 0.72984f
C6162 sg13cmos5l_inv_1_67.Y VPWR 0.70605f
C6163 sg13cmos5l_inv_1_935.A sg13cmos5l_inv_1_933.Y 0.20065f
C6164 sg13cmos5l_buf_1_18.A osc_tap[4] 0.24878f
C6165 sg13cmos5l_inv_1_681.Y sg13cmos5l_inv_1_510.Y 0.04506f
C6166 a_9659_7736# a_9885_7704# 0.02749f
C6167 sg13cmos5l_inv_1_738.Y sg13cmos5l_mux2_1_0.X 0.04638f
C6168 sg13cmos5l_inv_1_998.Y sg13cmos5l_inv_1_998.A 0.11231f
C6169 sg13cmos5l_inv_1_935.A sg13cmos5l_mux4_1_15.A2 0.01084f
C6170 sg13cmos5l_buf_1_8.A sg13cmos5l_inv_1_207.A 0.05033f
C6171 sg13cmos5l_buf_1_12.X sg13cmos5l_inv_1_421.A 0.02595f
C6172 sg13cmos5l_inv_1_959.A sg13cmos5l_inv_1_959.Y 0.09553f
C6173 sg13cmos5l_mux4_1_5.S1 sg13cmos5l_inv_1_283.A 0.01373f
C6174 sg13cmos5l_inv_1_248.A sg13cmos5l_inv_1_464.Y 0.01409f
C6175 sg13cmos5l_nand2_1_1.B sg13cmos5l_inv_1_924.Y 0.03489f
C6176 sg13cmos5l_inv_1_418.Y VPWR 0.51418f
C6177 sg13cmos5l_inv_1_599.Y sg13cmos5l_inv_1_584.A 0.01895f
C6178 sg13cmos5l_mux4_1_5.S0 sg13cmos5l_inv_1_582.A 0.11367f
C6179 sg13cmos5l_buf_1_8.A sg13cmos5l_inv_1_349.A 0.07165f
C6180 sg13cmos5l_inv_1_72.Y sg13cmos5l_inv_1_70.A 0.0198f
C6181 sg13cmos5l_inv_1_295.A sg13cmos5l_inv_1_308.Y 0.01297f
C6182 sg13cmos5l_mux4_1_11.A3 a_14827_11673# 0.08619f
C6183 sg13cmos5l_buf_1_9.A sg13cmos5l_inv_1_267.Y 0.24371f
C6184 sg13cmos5l_inv_1_427.A sg13cmos5l_inv_1_241.A 0.01818f
C6185 sg13cmos5l_inv_1_593.Y sg13cmos5l_inv_1_614.A 0.04696f
C6186 sg13cmos5l_inv_1_823.Y sg13cmos5l_inv_1_851.A 0.04217f
C6187 sg13cmos5l_nor4_1_0.A sg13cmos5l_nor3_1_0.Y 0.36216f
C6188 sg13cmos5l_inv_1_2.Y a_17512_2514# 0.0469f
C6189 sg13cmos5l_o21ai_1_0.B1 sg13cmos5l_inv_1_947.A 0.19875f
C6190 sg13cmos5l_inv_1_981.A sg13cmos5l_inv_1_981.Y 0.13623f
C6191 sg13cmos5l_inv_1_712.A a_18464_11586# 0.03605f
C6192 sg13cmos5l_buf_1_0.A sg13cmos5l_inv_1_22.A 0.01275f
C6193 sg13cmos5l_inv_1_283.A sg13cmos5l_inv_1_306.A 0.02566f
C6194 a_13831_12267# VPWR 0.02572f
C6195 sg13cmos5l_inv_1_948.A sg13cmos5l_inv_1_949.Y 0.92751f
C6196 sg13cmos5l_inv_1_886.Y sg13cmos5l_inv_1_898.Y 0.18584f
C6197 a_3623_8070# a_3860_8070# 0.01012f
C6198 sg13cmos5l_inv_1_267.Y sg13cmos5l_inv_1_426.A 0.01765f
C6199 sg13cmos5l_inv_1_237.Y sg13cmos5l_inv_1_425.A 0.08055f
C6200 sg13cmos5l_inv_1_216.Y sg13cmos5l_mux4_1_2.A2 0.28856f
C6201 sg13cmos5l_inv_1_753.A VPWR 0.64657f
C6202 a_13607_3898# a_14422_3898# 0.49917f
C6203 sg13cmos5l_inv_1_875.A sg13cmos5l_inv_1_876.A 0.06168f
C6204 sg13cmos5l_o21ai_1_0.B1 sg13cmos5l_inv_1_982.A 0.03815f
C6205 sg13cmos5l_inv_1_120.Y sg13cmos5l_buf_1_0.A 0.09311f
C6206 a_3623_3534# a_4438_3534# 0.49917f
C6207 sg13cmos5l_inv_1_462.A sg13cmos5l_inv_1_462.Y 0.18584f
C6208 sg13cmos5l_inv_1_741.Y VPWR 0.44376f
C6209 sg13cmos5l_inv_1_963.Y VPWR 0.44308f
C6210 sg13cmos5l_inv_1_498.A sg13cmos5l_inv_1_489.A 0.03603f
C6211 sg13cmos5l_nor3_1_1.B sg13cmos5l_inv_1_922.A 0.01504f
C6212 sg13cmos5l_mux4_1_6.X a_8123_8472# 0.15418f
C6213 sg13cmos5l_inv_1_124.Y a_10592_7766# 0.04632f
C6214 sg13cmos5l_inv_1_744.Y sg13cmos5l_inv_1_728.Y 0.01032f
C6215 a_8005_16261# a_7582_15994# 0.01929f
C6216 sg13cmos5l_mux4_1_14.A0 a_13607_14482# 0.21416f
C6217 sg13cmos5l_inv_1_105.Y sg13cmos5l_inv_1_215.Y 0.09193f
C6218 sg13cmos5l_inv_1_77.Y a_11456_4026# 0.0363f
C6219 sg13cmos5l_inv_1_120.A sg13cmos5l_mux2_1_3.X 0.09534f
C6220 sg13cmos5l_inv_1_124.Y sg13cmos5l_inv_1_133.Y 0.02033f
C6221 a_18764_18228# a_19048_18350# 0.01225f
C6222 sg13cmos5l_inv_1_5.Y VPWR 0.42562f
C6223 sg13cmos5l_inv_1_135.Y a_11944_7050# 0.03488f
C6224 sg13cmos5l_mux4_1_5.S0 sg13cmos5l_a22oi_1_0.B1 0.02578f
C6225 sg13cmos5l_mux4_1_5.S1 sg13cmos5l_inv_1_228.Y 0.62122f
C6226 sg13cmos5l_inv_1_485.A VPWR 0.49364f
C6227 sg13cmos5l_o21ai_1_0.B1 sg13cmos5l_nor3_1_1.A 0.06299f
C6228 sg13cmos5l_inv_1_717.A sg13cmos5l_inv_1_929.A 0.02374f
C6229 sg13cmos5l_inv_1_321.A VPWR 0.4641f
C6230 sg13cmos5l_inv_1_884.Y sg13cmos5l_inv_1_889.A 0.05532f
C6231 sg13cmos5l_inv_1_247.Y a_6952_2514# 0.0447f
C6232 sg13cmos5l_mux4_1_0.A0 sg13cmos5l_inv_1_162.A 0.0419f
C6233 sg13cmos5l_inv_1_367.Y a_3304_6254# 0.02188f
C6234 sg13cmos5l_buf_1_9.A sg13cmos5l_buf_1_10.A 0.96003f
C6235 sg13cmos5l_inv_1_114.A sg13cmos5l_inv_1_118.A 0.01549f
C6236 sg13cmos5l_mux2_1_2.A0 VPWR 0.66592f
C6237 sg13cmos5l_buf_1_6.A osc_tap[1] 0.25028f
C6238 sg13cmos5l_inv_1_891.Y VPWR 0.42912f
C6239 sg13cmos5l_inv_1_258.A sg13cmos5l_inv_1_247.Y 0.62704f
C6240 sg13cmos5l_inv_1_596.Y sg13cmos5l_inv_1_595.Y 0.20065f
C6241 sg13cmos5l_inv_1_186.Y sg13cmos5l_inv_1_213.Y 0.35788f
C6242 sg13cmos5l_mux2_1_0.X sg13cmos5l_inv_1_112.A 0.05015f
C6243 sg13cmos5l_mux4_1_5.X a_7271_3534# 0.02376f
C6244 sg13cmos5l_inv_1_816.A sg13cmos5l_inv_1_875.A 0.03639f
C6245 a_11456_4742# VPWR 0.07743f
C6246 a_15662_4084# a_15768_4088# 0.55132f
C6247 sg13cmos5l_inv_1_819.A sg13cmos5l_inv_1_827.Y 0.06042f
C6248 sg13cmos5l_inv_1_59.A VPWR 0.56242f
C6249 a_800_1002# VPWR 0.06732f
C6250 sg13cmos5l_buf_1_10.A sg13cmos5l_inv_1_426.A 0.15406f
C6251 sg13cmos5l_inv_1_836.Y VPWR 0.43475f
C6252 sg13cmos5l_inv_1_174.A VPWR 0.42465f
C6253 sg13cmos5l_mux4_1_12.A1 sg13cmos5l_inv_1_744.Y 0.37406f
C6254 sg13cmos5l_inv_1_679.A sg13cmos5l_inv_1_534.Y 0.24337f
C6255 sg13cmos5l_buf_1_8.A a_14827_11673# 0.03648f
C6256 sg13cmos5l_inv_1_553.A sg13cmos5l_inv_1_535.Y 0.0402f
C6257 sg13cmos5l_inv_1_592.A sg13cmos5l_inv_1_610.Y 0.22916f
C6258 sg13cmos5l_inv_1_450.Y VPWR 0.36556f
C6259 sg13cmos5l_inv_1_723.Y a_19136_11586# 0.0363f
C6260 sg13cmos5l_inv_1_311.Y sg13cmos5l_inv_1_312.Y 0.02938f
C6261 sg13cmos5l_inv_1_16.A sg13cmos5l_inv_1_220.Y 0.04862f
C6262 sg13cmos5l_inv_1_344.A sg13cmos5l_inv_1_346.Y 0.03018f
C6263 sg13cmos5l_inv_1_995.Y sg13cmos5l_inv_1_799.A 0.20065f
C6264 sg13cmos5l_buf_1_8.A sg13cmos5l_inv_1_211.Y 0.07768f
C6265 sg13cmos5l_inv_1_684.A sg13cmos5l_inv_1_633.A 0.07916f
C6266 sg13cmos5l_nor3_1_1.B sg13cmos5l_nand2_1_1.B 0.39225f
C6267 sg13cmos5l_mux2_1_4.S sg13cmos5l_inv_1_445.A 0.12391f
C6268 a_5024_13814# VPWR 0.0807f
C6269 sg13cmos5l_inv_1_120.A sg13cmos5l_nor4_1_0.A 0.03543f
C6270 sg13cmos5l_inv_1_862.A a_17312_16122# 0.0359f
C6271 sg13cmos5l_inv_1_736.Y VPWR 0.43364f
C6272 sg13cmos5l_inv_1_579.Y sg13cmos5l_inv_1_643.A 0.02831f
C6273 sg13cmos5l_buf_1_12.X a_4438_8070# 0.01418f
C6274 sg13cmos5l_inv_1_106.A sg13cmos5l_inv_1_106.Y 0.30132f
C6275 sg13cmos5l_inv_1_762.Y a_14171_11488# 0.01124f
C6276 a_16075_7649# a_16723_7731# 0.01074f
C6277 sg13cmos5l_inv_1_608.A sg13cmos5l_inv_1_608.Y 0.29156f
C6278 sg13cmos5l_buf_1_9.A sg13cmos5l_inv_1_421.A 0.13289f
C6279 sg13cmos5l_mux4_1_13.A0 sg13cmos5l_inv_1_847.Y 0.01963f
C6280 sg13cmos5l_buf_1_10.A sg13cmos5l_inv_1_267.Y 0.13573f
C6281 sg13cmos5l_inv_1_602.Y sg13cmos5l_inv_1_606.A 0.013f
C6282 sg13cmos5l_inv_1_711.Y sg13cmos5l_mux4_1_12.A1 0.42412f
C6283 sg13cmos5l_inv_1_256.A sg13cmos5l_inv_1_442.Y 0.0147f
C6284 sg13cmos5l_inv_1_453.Y sg13cmos5l_inv_1_442.A 0.23204f
C6285 sg13cmos5l_inv_1_747.Y sg13cmos5l_inv_1_738.A 0.18217f
C6286 sg13cmos5l_mux4_1_8.A0 sg13cmos5l_inv_1_975.A 0.04953f
C6287 sg13cmos5l_inv_1_402.A sg13cmos5l_inv_1_403.Y 0.15707f
C6288 a_17312_3230# VPWR 0.08331f
C6289 sg13cmos5l_inv_1_925.A sg13cmos5l_inv_1_924.Y 0.01802f
C6290 sg13cmos5l_inv_1_393.A a_6752_7050# 0.03589f
C6291 sg13cmos5l_buf_1_9.A a_14998_9582# 0.06104f
C6292 a_4264_16838# VPWR 0.14026f
C6293 a_3592_10790# VPWR 0.18186f
C6294 sg13cmos5l_mux2_1_3.S a_9536_7766# 0.03597f
C6295 sg13cmos5l_inv_1_820.A sg13cmos5l_inv_1_830.A 0.20065f
C6296 sg13cmos5l_inv_1_404.Y sg13cmos5l_inv_1_393.Y 0.11778f
C6297 sg13cmos5l_buf_1_9.A a_13472_14610# 0.0381f
C6298 a_13607_14482# VPWR 0.40949f
C6299 a_13664_3230# VPWR 0.11735f
C6300 sg13cmos5l_inv_1_527.A sg13cmos5l_inv_1_526.Y 0.04826f
C6301 sg13cmos5l_inv_1_977.A sg13cmos5l_inv_1_978.A 0.20065f
C6302 sg13cmos5l_inv_1_345.A sg13cmos5l_inv_1_349.A 0.0486f
C6303 sg13cmos5l_inv_1_337.A a_2248_3932# 0.0447f
C6304 sg13cmos5l_inv_1_442.A sg13cmos5l_inv_1_442.Y 0.29145f
C6305 sg13cmos5l_nor4_1_0.A sg13cmos5l_mux2_1_3.X 0.01026f
C6306 a_808_6956# invsel[2] 0.32102f
C6307 sg13cmos5l_buf_1_19.A a_18664_13004# 0.02342f
C6308 sg13cmos5l_inv_1_689.A VPWR 0.61353f
C6309 sg13cmos5l_inv_1_478.A sg13cmos5l_a22oi_1_0.B1 0.02806f
C6310 sg13cmos5l_inv_1_177.A sg13cmos5l_inv_1_78.A 0.02542f
C6311 sg13cmos5l_inv_1_904.Y a_12896_13814# 0.04398f
C6312 sg13cmos5l_inv_1_85.A a_13799_3534# 0.03262f
C6313 sg13cmos5l_inv_1_130.Y sg13cmos5l_inv_1_215.Y 0.08437f
C6314 sg13cmos5l_mux4_1_14.A1 sg13cmos5l_inv_1_890.A 0.71516f
C6315 a_6952_2514# VPWR 0.153f
C6316 sg13cmos5l_inv_1_828.Y sg13cmos5l_inv_1_780.A 0.01639f
C6317 sg13cmos5l_mux4_1_8.A0 sg13cmos5l_inv_1_775.A 0.09761f
C6318 sg13cmos5l_nor3_1_2.B sg13cmos5l_or2_1_0.X 0.04776f
C6319 sg13cmos5l_mux2_1_4.X sg13cmos5l_inv_1_394.Y 0.07198f
C6320 sg13cmos5l_mux4_1_5.S1 sg13cmos5l_inv_1_107.Y 0.68285f
C6321 sg13cmos5l_inv_1_411.Y VPWR 0.43575f
C6322 sg13cmos5l_mux2_1_4.S a_15565_9466# 0.38414f
C6323 sg13cmos5l_inv_1_1012.Y a_3680_10074# 0.04596f
C6324 sg13cmos5l_nor3_1_2.B sg13cmos5l_or2_1_0.B 5.33112f
C6325 sg13cmos5l_inv_1_258.A VPWR 1.21972f
C6326 sg13cmos5l_inv_1_176.A sg13cmos5l_buf_1_4.X 0.10719f
C6327 a_6752_17634# VPWR 0.07705f
C6328 sg13cmos5l_mux4_1_8.A1 sg13cmos5l_mux4_1_8.A2 0.48829f
C6329 sg13cmos5l_inv_1_681.Y sg13cmos5l_inv_1_685.Y 0.02806f
C6330 a_9982_8050# a_10096_8050# 0.03097f
C6331 sg13cmos5l_mux2_1_4.S sg13cmos5l_inv_1_878.A 0.15789f
C6332 sg13cmos5l_inv_1_421.A sg13cmos5l_inv_1_267.Y 0.01187f
C6333 sg13cmos5l_inv_1_344.A sg13cmos5l_inv_1_237.Y 0.04866f
C6334 sg13cmos5l_inv_1_735.Y sg13cmos5l_inv_1_998.A 0.01065f
C6335 sg13cmos5l_inv_1_998.Y sg13cmos5l_inv_1_940.A 0.04221f
C6336 sg13cmos5l_inv_1_423.A a_3872_4742# 0.03465f
C6337 sg13cmos5l_inv_1_425.A sg13cmos5l_inv_1_426.A 0.20204f
C6338 a_14183_9582# sg13cmos5l_mux4_1_15.A2 0.22316f
C6339 sg13cmos5l_buf_1_12.X sg13cmos5l_inv_1_344.A 0.08763f
C6340 sg13cmos5l_buf_1_12.X sg13cmos5l_inv_1_382.Y 0.02506f
C6341 sg13cmos5l_inv_1_731.Y a_13288_11586# 0.04348f
C6342 sg13cmos5l_inv_1_862.A sg13cmos5l_inv_1_875.A 0.01293f
C6343 sg13cmos5l_inv_1_40.Y a_17024_1002# 0.0359f
C6344 sg13cmos5l_inv_1_236.A a_11456_4742# 0.03553f
C6345 sg13cmos5l_inv_1_248.A sg13cmos5l_inv_1_463.Y 0.01296f
C6346 a_11656_10074# VPWR 0.13715f
C6347 sg13cmos5l_inv_1_680.A a_1376_14610# 0.03545f
C6348 sg13cmos5l_inv_1_510.Y sg13cmos5l_inv_1_681.A 0.09658f
C6349 sg13cmos5l_inv_1_433.A VPWR 0.41411f
C6350 sg13cmos5l_buf_1_9.A sg13cmos5l_inv_1_518.Y 0.08504f
C6351 sg13cmos5l_buf_1_0.A sg13cmos5l_inv_1_228.Y 0.05937f
C6352 a_3934_8070# a_4357_7731# 0.01929f
C6353 sg13cmos5l_o21ai_1_0.B1 sg13cmos5l_nor3_1_2.B 0.6471f
C6354 a_6599_12970# a_6823_13237# 0.01074f
C6355 a_14614_3534# a_15181_3418# 0.40359f
C6356 sg13cmos5l_inv_1_589.Y sg13cmos5l_inv_1_614.A 0.12744f
C6357 a_9260_9906# sg13cmos5l_nor3_1_1.Y 0.01523f
C6358 sg13cmos5l_mux2_1_4.S sg13cmos5l_inv_1_75.Y 0.02842f
C6359 sg13cmos5l_o21ai_1_0.B1 sg13cmos5l_inv_1_521.Y 0.04517f
C6360 sg13cmos5l_inv_1_800.A a_11464_16838# 0.01986f
C6361 sg13cmos5l_inv_1_30.A sg13cmos5l_inv_1_76.A 0.01202f
C6362 sg13cmos5l_inv_1_8.A a_18088_1718# 0.03631f
C6363 sg13cmos5l_inv_1_720.Y a_18764_12180# 0.02429f
C6364 sg13cmos5l_inv_1_981.A sg13cmos5l_inv_1_65.Y 0.19681f
C6365 a_13918_3898# a_14913_3940# 0.48298f
C6366 sg13cmos5l_nand2_1_1.Y a_10042_8434# 0.01572f
C6367 sg13cmos5l_inv_1_283.A sg13cmos5l_inv_1_304.A 0.09298f
C6368 sg13cmos5l_inv_1_730.A VPWR 0.60829f
C6369 sg13cmos5l_inv_1_929.A a_16744_10074# 0.03488f
C6370 sg13cmos5l_inv_1_948.A sg13cmos5l_inv_1_898.Y 0.04571f
C6371 sg13cmos5l_inv_1_693.A sg13cmos5l_inv_1_949.Y 0.02696f
C6372 sg13cmos5l_mux4_1_5.S1 a_8577_3492# 0.20774f
C6373 a_4438_3534# a_4929_3492# 0.3824f
C6374 sg13cmos5l_inv_1_149.A sg13cmos5l_inv_1_217.A 0.13786f
C6375 sg13cmos5l_inv_1_22.A a_16168_1718# 0.0501f
C6376 sg13cmos5l_nor3_1_1.A sg13cmos5l_a21oi_1_1.A1 0.58733f
C6377 sg13cmos5l_mux4_1_5.S0 sg13cmos5l_inv_1_394.A 0.1064f
C6378 sg13cmos5l_inv_1_1003.Y VPWR 0.44008f
C6379 sg13cmos5l_inv_1_962.Y VPWR 0.43116f
C6380 sg13cmos5l_mux4_1_9.X a_4929_12564# 0.23107f
C6381 sg13cmos5l_inv_1_7.Y sg13cmos5l_inv_1_0.A 0.01153f
C6382 sg13cmos5l_buf_1_10.A sg13cmos5l_inv_1_421.A 0.33769f
C6383 sg13cmos5l_mux4_1_4.X a_8123_8472# 0.23598f
C6384 sg13cmos5l_mux4_1_5.S0 a_6119_8434# 0.59793f
C6385 sg13cmos5l_mux4_1_8.A0 sg13cmos5l_inv_1_775.Y 0.11178f
C6386 sg13cmos5l_inv_1_744.Y sg13cmos5l_inv_1_706.A 0.02749f
C6387 sg13cmos5l_buf_1_9.A sg13cmos5l_inv_1_802.A 0.02326f
C6388 sg13cmos5l_inv_1_137.A sg13cmos5l_inv_1_215.Y 0.11846f
C6389 sg13cmos5l_inv_1_77.Y sg13cmos5l_inv_1_92.A 0.02661f
C6390 a_3488_18350# VPWR 0.06876f
C6391 sg13cmos5l_buf_1_9.A sg13cmos5l_inv_1_159.A 0.424f
C6392 sg13cmos5l_inv_1_824.A a_17888_18350# 0.01112f
C6393 sg13cmos5l_buf_1_9.A a_4438_8070# 0.04159f
C6394 sg13cmos5l_inv_1_124.Y sg13cmos5l_inv_1_132.Y 0.05987f
C6395 a_18764_18228# sg13cmos5l_buf_1_21.A 0.29248f
C6396 sg13cmos5l_inv_1_43.Y VPWR 0.36592f
C6397 sg13cmos5l_inv_1_967.Y sg13cmos5l_inv_1_467.Y 0.04466f
C6398 sg13cmos5l_inv_1_135.Y sg13cmos5l_inv_1_111.A 0.1118f
C6399 sg13cmos5l_inv_1_518.Y sg13cmos5l_inv_1_507.A 0.1636f
C6400 sg13cmos5l_inv_1_663.Y sg13cmos5l_inv_1_473.Y 0.17021f
C6401 sg13cmos5l_mux4_1_5.S1 sg13cmos5l_inv_1_224.A 0.0247f
C6402 sg13cmos5l_inv_1_485.Y VPWR 0.48743f
C6403 a_14710_15630# VPWR 0.02985f
C6404 sg13cmos5l_inv_1_320.A VPWR 0.41702f
C6405 sg13cmos5l_mux4_1_8.A1 sg13cmos5l_buf_1_9.A 0.08299f
C6406 sg13cmos5l_inv_1_884.Y sg13cmos5l_inv_1_902.Y 0.17825f
C6407 a_3488_1718# VPWR 0.06816f
C6408 sg13cmos5l_mux4_1_0.A0 sg13cmos5l_inv_1_157.Y 0.01983f
C6409 sg13cmos5l_inv_1_247.Y sg13cmos5l_inv_1_306.A 0.21883f
C6410 sg13cmos5l_inv_1_347.Y a_3304_6254# 0.03352f
C6411 sg13cmos5l_inv_1_341.Y sg13cmos5l_inv_1_267.Y 0.06307f
C6412 sg13cmos5l_inv_1_642.Y a_8672_15326# 0.04295f
C6413 sg13cmos5l_inv_1_619.A VPWR 0.45361f
C6414 a_15181_3418# a_15105_3492# 0.2611f
C6415 sg13cmos5l_inv_1_213.A osc_tap[1] 0.02155f
C6416 sg13cmos5l_inv_1_69.A sg13cmos5l_inv_1_981.Y 0.07209f
C6417 sg13cmos5l_inv_1_895.Y VPWR 0.4295f
C6418 sg13cmos5l_inv_1_583.A sg13cmos5l_inv_1_684.A 0.11122f
C6419 sg13cmos5l_mux4_1_5.S1 sg13cmos5l_inv_1_989.A 0.13539f
C6420 sg13cmos5l_inv_1_186.Y sg13cmos5l_inv_1_186.A 0.22625f
C6421 sg13cmos5l_inv_1_815.A sg13cmos5l_inv_1_875.A 0.18694f
C6422 sg13cmos5l_inv_1_895.Y sg13cmos5l_inv_1_708.A 0.02913f
C6423 sg13cmos5l_mux4_1_12.A1 sg13cmos5l_mux4_1_12.A3 0.7665f
C6424 sg13cmos5l_inv_1_236.Y VPWR 0.42866f
C6425 a_15662_4084# sg13cmos5l_mux4_1_2.X 0.5849f
C6426 sg13cmos5l_inv_1_1.Y VPWR 0.40363f
C6427 a_9536_8562# VPWR 0.07965f
C6428 sg13cmos5l_inv_1_308.Y VPWR 0.57194f
C6429 sg13cmos5l_buf_1_10.A sg13cmos5l_inv_1_425.A 0.07893f
C6430 sg13cmos5l_inv_1_848.Y VPWR 0.4235f
C6431 sg13cmos5l_nor3_1_2.B a_7905_13012# 0.01813f
C6432 sg13cmos5l_inv_1_150.A VPWR 0.42559f
C6433 sg13cmos5l_inv_1_745.A sg13cmos5l_inv_1_744.Y 0.6489f
C6434 sg13cmos5l_inv_1_439.Y VPWR 0.36676f
C6435 sg13cmos5l_inv_1_533.Y sg13cmos5l_inv_1_535.Y 0.16244f
C6436 sg13cmos5l_inv_1_679.A sg13cmos5l_inv_1_610.Y 0.03982f
C6437 sg13cmos5l_inv_1_730.A a_15584_12302# 0.01054f
C6438 sg13cmos5l_mux4_1_7.A3 VPWR 0.70799f
C6439 a_808_16028# VPWR 0.24809f
C6440 sg13cmos5l_mux4_1_13.A0 sg13cmos5l_mux4_1_14.A3 0.01419f
C6441 sg13cmos5l_inv_1_305.Y sg13cmos5l_inv_1_346.Y 0.29228f
C6442 sg13cmos5l_inv_1_237.Y sg13cmos5l_inv_1_69.A 0.31332f
C6443 sg13cmos5l_buf_1_0.A sg13cmos5l_inv_1_88.Y 0.08997f
C6444 sg13cmos5l_inv_1_645.Y VPWR 0.44041f
C6445 a_14710_15630# a_15201_15588# 0.3824f
C6446 sg13cmos5l_inv_1_453.A a_5032_1718# 0.03488f
C6447 sg13cmos5l_buf_1_8.A sg13cmos5l_inv_1_318.Y 0.04792f
C6448 sg13cmos5l_inv_1_642.A sg13cmos5l_inv_1_650.A 0.0273f
C6449 sg13cmos5l_inv_1_858.Y a_17312_16122# 0.03508f
C6450 sg13cmos5l_inv_1_105.A sg13cmos5l_inv_1_106.Y 0.02519f
C6451 sg13cmos5l_inv_1_827.Y sg13cmos5l_inv_1_863.A 0.01538f
C6452 sg13cmos5l_mux2_1_4.S sg13cmos5l_mux2_1_0.X 0.23998f
C6453 sg13cmos5l_buf_1_9.A sg13cmos5l_inv_1_344.A 0.16343f
C6454 sg13cmos5l_inv_1_853.Y sg13cmos5l_inv_1_857.Y 0.02913f
C6455 sg13cmos5l_mux4_1_13.A0 sg13cmos5l_inv_1_846.Y 0.01963f
C6456 sg13cmos5l_inv_1_602.Y sg13cmos5l_inv_1_598.A 0.11183f
C6457 sg13cmos5l_inv_1_58.Y sg13cmos5l_inv_1_220.Y 0.06758f
C6458 sg13cmos5l_mux4_1_7.A1 a_6910_12970# 0.16195f
C6459 sg13cmos5l_inv_1_600.A a_8680_17634# 0.03631f
C6460 sg13cmos5l_inv_1_402.A sg13cmos5l_inv_1_403.A 0.51304f
C6461 sg13cmos5l_inv_1_149.A sg13cmos5l_inv_1_152.Y 0.17612f
C6462 sg13cmos5l_inv_1_36.Y VPWR 0.62809f
C6463 a_3680_1002# VPWR 0.11519f
C6464 sg13cmos5l_o21ai_1_0.B1 sg13cmos5l_nor3_1_1.B 0.01314f
C6465 sg13cmos5l_a21oi_1_0.B1 sg13cmos5l_inv_1_525.A 0.01781f
C6466 sg13cmos5l_inv_1_398.Y sg13cmos5l_inv_1_399.Y 0.20065f
C6467 sg13cmos5l_inv_1_562.Y VPWR 0.39819f
C6468 sg13cmos5l_inv_1_959.Y sg13cmos5l_inv_1_953.Y 0.2282f
C6469 sg13cmos5l_mux4_1_5.S1 VPWR 4.55723f
C6470 sg13cmos5l_inv_1_500.Y VPWR 0.4262f
C6471 a_3680_5538# VPWR 0.11525f
C6472 sg13cmos5l_inv_1_404.Y sg13cmos5l_inv_1_393.A 0.17685f
C6473 sg13cmos5l_inv_1_889.A VPWR 0.53447f
C6474 sg13cmos5l_inv_1_531.A sg13cmos5l_inv_1_526.Y 0.16482f
C6475 a_18664_13004# VPWR 0.32014f
C6476 a_19136_11586# VPWR 0.06708f
C6477 a_10162_9570# VPWR 0.01374f
C6478 a_4556_3858# sg13cmos5l_inv_1_318.Y 0.01378f
C6479 sg13cmos5l_inv_1_140.Y sg13cmos5l_inv_1_78.A 0.0152f
C6480 sg13cmos5l_a21oi_1_0.B1 VPWR 4.86603f
C6481 sg13cmos5l_inv_1_141.Y sg13cmos5l_inv_1_78.A 0.07008f
C6482 sg13cmos5l_inv_1_564.Y a_3488_18350# 0.04587f
C6483 sg13cmos5l_inv_1_460.Y sg13cmos5l_inv_1_429.A 0.01538f
C6484 sg13cmos5l_inv_1_950.A a_808_9980# 0.03595f
C6485 sg13cmos5l_inv_1_779.Y sg13cmos5l_inv_1_890.A 0.03414f
C6486 sg13cmos5l_inv_1_140.Y a_12808_7050# 0.02093f
C6487 sg13cmos5l_inv_1_130.Y sg13cmos5l_inv_1_105.Y 0.15748f
C6488 sg13cmos5l_inv_1_306.A VPWR 0.93763f
C6489 sg13cmos5l_mux2_1_4.S sg13cmos5l_inv_1_185.A 0.51806f
C6490 sg13cmos5l_inv_1_828.Y sg13cmos5l_inv_1_780.Y 0.01345f
C6491 sg13cmos5l_inv_1_575.A a_1952_16122# 0.03508f
C6492 sg13cmos5l_nor2b_1_0.A sg13cmos5l_inv_1_563.Y 0.09107f
C6493 sg13cmos5l_inv_1_124.A a_9659_7736# 0.03319f
C6494 sg13cmos5l_inv_1_511.A a_1192_13098# 0.05052f
C6495 sg13cmos5l_inv_1_373.A sg13cmos5l_inv_1_362.Y 0.01475f
C6496 sg13cmos5l_inv_1_871.Y sg13cmos5l_inv_1_866.Y 0.10383f
C6497 sg13cmos5l_inv_1_843.A a_18184_16838# 0.01039f
C6498 a_11656_12302# VPWR 0.14923f
C6499 sg13cmos5l_mux2_1_4.S a_15277_15514# 0.37897f
C6500 sg13cmos5l_inv_1_357.A VPWR 0.423f
C6501 sg13cmos5l_buf_1_9.A sg13cmos5l_inv_1_424.A 0.05558f
C6502 sg13cmos5l_inv_1_535.Y sg13cmos5l_mux4_1_10.A3 0.06256f
C6503 sg13cmos5l_nor3_1_2.B sg13cmos5l_a21oi_1_1.A1 0.10723f
C6504 sg13cmos5l_inv_1_618.A sg13cmos5l_inv_1_582.A 0.01057f
C6505 sg13cmos5l_inv_1_936.A sg13cmos5l_inv_1_935.A 0.20065f
C6506 sg13cmos5l_inv_1_628.Y sg13cmos5l_mux4_1_8.A2 0.0114f
C6507 sg13cmos5l_mux2_1_3.A0 sg13cmos5l_inv_1_124.Y 0.01363f
C6508 a_18280_5444# VPWR 0.256f
C6509 sg13cmos5l_o21ai_1_0.B1 sg13cmos5l_inv_1_366.A 0.01372f
C6510 sg13cmos5l_inv_1_421.A sg13cmos5l_inv_1_341.Y 0.31969f
C6511 sg13cmos5l_inv_1_344.A sg13cmos5l_inv_1_267.Y 0.15191f
C6512 sg13cmos5l_mux2_1_4.S sg13cmos5l_inv_1_185.Y 0.14844f
C6513 a_808_13814# VPWR 0.12673f
C6514 sg13cmos5l_buf_1_12.X sg13cmos5l_inv_1_305.Y 0.429f
C6515 sg13cmos5l_inv_1_304.Y a_1480_1718# 0.06173f
C6516 sg13cmos5l_inv_1_309.Y sg13cmos5l_inv_1_313.Y 0.20973f
C6517 a_13288_8562# a_13288_7766# 0.01095f
C6518 sg13cmos5l_inv_1_248.A sg13cmos5l_inv_1_461.Y 0.01246f
C6519 sg13cmos5l_inv_1_236.A sg13cmos5l_inv_1_236.Y 0.22916f
C6520 sg13cmos5l_nand2_1_1.B sg13cmos5l_inv_1_925.Y 0.10589f
C6521 sg13cmos5l_inv_1_689.Y a_1376_14610# 0.03465f
C6522 sg13cmos5l_inv_1_959.A VPWR 0.37149f
C6523 a_19048_13814# a_19048_13098# 0.01275f
C6524 sg13cmos5l_mux4_1_5.S1 sg13cmos5l_inv_1_140.A 0.01939f
C6525 sg13cmos5l_buf_1_9.A sg13cmos5l_inv_1_520.A 0.1131f
C6526 sg13cmos5l_inv_1_748.A a_10880_11586# 0.01054f
C6527 sg13cmos5l_o21ai_1_0.B1 sg13cmos5l_inv_1_509.Y 0.02934f
C6528 sg13cmos5l_inv_1_350.Y sg13cmos5l_mux4_1_6.A2 0.04395f
C6529 a_4264_16838# sg13cmos5l_mux4_1_5.S0 0.01982f
C6530 sg13cmos5l_mux2_1_4.S a_9659_7736# 0.02718f
C6531 sg13cmos5l_inv_1_837.Y sg13cmos5l_inv_1_843.A 0.01924f
C6532 sg13cmos5l_inv_1_535.Y sg13cmos5l_inv_1_614.A 0.02461f
C6533 sg13cmos5l_mux2_1_1.X sg13cmos5l_nor3_1_1.Y 0.14847f
C6534 sg13cmos5l_mux2_1_4.S sg13cmos5l_inv_1_271.A 0.25794f
C6535 sg13cmos5l_inv_1_195.Y sg13cmos5l_inv_1_213.A 0.11137f
C6536 sg13cmos5l_inv_1_305.A a_3847_3195# 0.01057f
C6537 sg13cmos5l_inv_1_726.A sg13cmos5l_inv_1_714.A 0.27576f
C6538 sg13cmos5l_inv_1_875.A a_17512_14610# 0.03921f
C6539 sg13cmos5l_inv_1_715.Y VPWR 0.57811f
C6540 sg13cmos5l_inv_1_378.Y sg13cmos5l_inv_1_305.Y 0.02472f
C6541 sg13cmos5l_inv_1_537.Y a_3304_16122# 0.03352f
C6542 sg13cmos5l_inv_1_929.A sg13cmos5l_inv_1_988.A 0.1118f
C6543 sg13cmos5l_inv_1_961.Y a_16744_10074# 0.03601f
C6544 sg13cmos5l_inv_1_948.A sg13cmos5l_inv_1_886.Y 0.07123f
C6545 a_3623_8070# sg13cmos5l_inv_1_340.Y 0.08516f
C6546 sg13cmos5l_inv_1_563.Y a_2152_15326# 0.03631f
C6547 sg13cmos5l_inv_1_537.Y sg13cmos5l_inv_1_537.A 0.38461f
C6548 sg13cmos5l_inv_1_22.A sg13cmos5l_inv_1_22.Y 0.14823f
C6549 sg13cmos5l_o21ai_1_0.B1 sg13cmos5l_inv_1_972.Y 0.03607f
C6550 sg13cmos5l_inv_1_328.A a_1472_2514# 0.03508f
C6551 sg13cmos5l_inv_1_553.Y sg13cmos5l_inv_1_553.A 0.09058f
C6552 sg13cmos5l_inv_1_462.A sg13cmos5l_inv_1_344.Y 0.02467f
C6553 sg13cmos5l_inv_1_480.Y VPWR 0.45541f
C6554 sg13cmos5l_inv_1_7.Y sg13cmos5l_inv_1_8.Y 0.06836f
C6555 sg13cmos5l_inv_1_985.Y VPWR 0.57964f
C6556 a_4475_13008# sg13cmos5l_buf_1_10.A 0.01196f
C6557 sg13cmos5l_inv_1_124.A sg13cmos5l_inv_1_132.Y 0.18149f
C6558 sg13cmos5l_mux4_1_4.X sg13cmos5l_mux4_1_6.X 0.56209f
C6559 sg13cmos5l_mux4_1_9.A0 a_3623_12606# 0.24368f
C6560 sg13cmos5l_mux4_1_5.S0 sg13cmos5l_inv_1_411.Y 0.03271f
C6561 sg13cmos5l_inv_1_717.A a_17216_10790# 0.04552f
C6562 sg13cmos5l_inv_1_744.Y sg13cmos5l_inv_1_707.A 0.01874f
C6563 sg13cmos5l_mux4_1_8.A0 sg13cmos5l_inv_1_773.Y 0.05885f
C6564 sg13cmos5l_inv_1_872.A a_17984_16122# 0.03465f
C6565 sg13cmos5l_inv_1_582.A a_7582_15994# 0.14878f
C6566 sg13cmos5l_inv_1_137.A sg13cmos5l_inv_1_105.Y 0.28841f
C6567 sg13cmos5l_mux4_1_5.S0 sg13cmos5l_inv_1_258.A 0.03844f
C6568 sg13cmos5l_inv_1_75.A a_11456_4026# 0.01325f
C6569 sg13cmos5l_inv_1_99.Y sg13cmos5l_inv_1_92.A 0.04257f
C6570 sg13cmos5l_inv_1_249.Y sg13cmos5l_inv_1_273.Y 0.11204f
C6571 sg13cmos5l_buf_1_8.A sg13cmos5l_nand2_1_1.B 0.02449f
C6572 a_18664_9192# VPWR 0.31426f
C6573 sg13cmos5l_o21ai_1_0.B1 sg13cmos5l_inv_1_990.Y 0.02596f
C6574 a_8315_11752# VPWR 0.27789f
C6575 sg13cmos5l_inv_1_7.A VPWR 0.41281f
C6576 sg13cmos5l_inv_1_967.Y sg13cmos5l_inv_1_467.A 0.11574f
C6577 sg13cmos5l_inv_1_520.A sg13cmos5l_inv_1_507.A 0.03719f
C6578 sg13cmos5l_inv_1_582.A sg13cmos5l_inv_1_643.A 0.01433f
C6579 sg13cmos5l_inv_1_496.A VPWR 0.48598f
C6580 a_808_6956# VPWR 0.24835f
C6581 sg13cmos5l_inv_1_152.Y a_15637_8028# 0.12772f
C6582 sg13cmos5l_inv_1_328.Y VPWR 0.68552f
C6583 sg13cmos5l_mux4_1_0.A0 sg13cmos5l_inv_1_156.Y 0.01855f
C6584 sg13cmos5l_inv_1_247.Y sg13cmos5l_inv_1_304.A 0.02253f
C6585 sg13cmos5l_mux2_1_3.S sg13cmos5l_inv_1_384.Y 0.11093f
C6586 sg13cmos5l_inv_1_625.Y sg13cmos5l_inv_1_643.A 0.04186f
C6587 sg13cmos5l_inv_1_25.Y a_15768_4088# 0.1405f
C6588 sg13cmos5l_inv_1_411.Y a_3934_8070# 0.03097f
C6589 sg13cmos5l_inv_1_130.Y sg13cmos5l_inv_1_179.A 0.03455f
C6590 sg13cmos5l_inv_1_622.Y VPWR 0.43823f
C6591 sg13cmos5l_a22oi_1_0.A1 a_8383_12608# 0.01963f
C6592 sg13cmos5l_inv_1_894.Y VPWR 0.42584f
C6593 a_19136_2514# VPWR 0.07231f
C6594 sg13cmos5l_buf_1_12.X sg13cmos5l_inv_1_347.Y 0.07386f
C6595 sg13cmos5l_inv_1_585.Y sg13cmos5l_inv_1_596.Y 0.18584f
C6596 sg13cmos5l_mux4_1_5.S1 sg13cmos5l_inv_1_448.A 0.19662f
C6597 sg13cmos5l_inv_1_920.A sg13cmos5l_inv_1_875.A 0.03685f
C6598 sg13cmos5l_inv_1_745.A sg13cmos5l_mux4_1_12.A3 0.09703f
C6599 sg13cmos5l_mux4_1_1.A3 VPWR 0.86826f
C6600 sg13cmos5l_inv_1_495.A a_6464_12302# 0.03465f
C6601 sg13cmos5l_inv_1_36.A VPWR 0.50942f
C6602 sg13cmos5l_inv_1_306.Y VPWR 0.51894f
C6603 sg13cmos5l_inv_1_537.A sg13cmos5l_inv_1_682.A 0.02802f
C6604 sg13cmos5l_buf_1_10.A sg13cmos5l_inv_1_424.A 0.02444f
C6605 sg13cmos5l_buf_1_0.A VPWR 6.27563f
C6606 sg13cmos5l_inv_1_836.A VPWR 0.42092f
C6607 sg13cmos5l_inv_1_106.A VPWR 0.46288f
C6608 sg13cmos5l_inv_1_679.A sg13cmos5l_inv_1_592.A 0.10666f
C6609 sg13cmos5l_inv_1_439.A VPWR 0.41568f
C6610 sg13cmos5l_inv_1_637.A VPWR 0.42835f
C6611 sg13cmos5l_inv_1_344.A sg13cmos5l_inv_1_421.A 0.02371f
C6612 sg13cmos5l_inv_1_322.A sg13cmos5l_buf_1_7.X 0.5222f
C6613 sg13cmos5l_inv_1_616.Y sg13cmos5l_inv_1_995.Y 0.20065f
C6614 a_808_9980# VPWR 0.24925f
C6615 sg13cmos5l_inv_1_610.Y a_5600_16838# 0.01054f
C6616 a_2632_13098# a_2816_13098# 0.11523f
C6617 sg13cmos5l_nor3_1_1.B sg13cmos5l_a21oi_1_1.A1 0.1042f
C6618 sg13cmos5l_buf_1_0.A sg13cmos5l_inv_1_88.A 0.03081f
C6619 sg13cmos5l_mux2_1_4.S sg13cmos5l_inv_1_931.Y 0.03662f
C6620 sg13cmos5l_inv_1_159.A sg13cmos5l_inv_1_179.A 0.04817f
C6621 sg13cmos5l_inv_1_382.Y a_7136_6254# 0.01217f
C6622 sg13cmos5l_inv_1_671.A VPWR 0.42215f
C6623 sg13cmos5l_inv_1_326.Y sg13cmos5l_inv_1_332.A 0.02045f
C6624 sg13cmos5l_inv_1_453.A sg13cmos5l_inv_1_453.Y 0.19503f
C6625 sg13cmos5l_inv_1_251.A sg13cmos5l_inv_1_256.A 0.20111f
C6626 sg13cmos5l_mux4_1_5.S1 a_4072_3932# 0.29145f
C6627 sg13cmos5l_inv_1_858.Y sg13cmos5l_inv_1_818.A 0.23226f
C6628 a_7582_3534# a_7789_3195# 0.01967f
C6629 sg13cmos5l_mux4_1_5.S1 sg13cmos5l_mux4_1_16.A2 2.06303f
C6630 sg13cmos5l_mux2_1_4.S sg13cmos5l_mux4_1_14.A3 0.98862f
C6631 a_2920_3932# VPWR 0.30161f
C6632 sg13cmos5l_inv_1_105.A sg13cmos5l_inv_1_107.Y 0.0489f
C6633 sg13cmos5l_buf_1_9.A sg13cmos5l_mux4_1_9.X 0.16205f
C6634 sg13cmos5l_mux4_1_13.A0 sg13cmos5l_inv_1_845.Y 0.01963f
C6635 sg13cmos5l_buf_1_8.A sg13cmos5l_inv_1_189.Y 0.0128f
C6636 sg13cmos5l_inv_1_61.A sg13cmos5l_inv_1_220.Y 0.02521f
C6637 sg13cmos5l_inv_1_266.Y sg13cmos5l_inv_1_266.A 0.11027f
C6638 sg13cmos5l_inv_1_600.A sg13cmos5l_inv_1_617.A 0.21026f
C6639 sg13cmos5l_inv_1_128.Y a_13288_6254# 0.03352f
C6640 sg13cmos5l_mux4_1_8.A0 sg13cmos5l_inv_1_580.A 0.02446f
C6641 sg13cmos5l_inv_1_44.A VPWR 0.43067f
C6642 sg13cmos5l_inv_1_925.A sg13cmos5l_inv_1_925.Y 0.28985f
C6643 sg13cmos5l_inv_1_945.A VPWR 0.42347f
C6644 sg13cmos5l_a21oi_1_0.B1 sg13cmos5l_inv_1_490.A 0.02594f
C6645 sg13cmos5l_inv_1_560.Y VPWR 0.4304f
C6646 sg13cmos5l_inv_1_502.Y VPWR 0.41795f
C6647 sg13cmos5l_a21oi_1_1.A2 sg13cmos5l_inv_1_480.Y 0.04463f
C6648 sg13cmos5l_inv_1_114.Y VPWR 0.60973f
C6649 sg13cmos5l_nor2b_1_0.B_N sg13cmos5l_nor2b_1_0.A 0.73727f
C6650 sg13cmos5l_inv_1_454.Y VPWR 0.43247f
C6651 sg13cmos5l_inv_1_821.A sg13cmos5l_inv_1_820.A 0.20065f
C6652 sg13cmos5l_inv_1_902.Y VPWR 0.46549f
C6653 sg13cmos5l_inv_1_938.Y a_13472_10790# 0.03539f
C6654 sg13cmos5l_mux4_1_5.S0 sg13cmos5l_inv_1_619.A 0.14019f
C6655 sg13cmos5l_inv_1_531.A sg13cmos5l_inv_1_527.A 0.31289f
C6656 sg13cmos5l_inv_1_976.A sg13cmos5l_inv_1_977.A 0.20065f
C6657 sg13cmos5l_inv_1_337.A sg13cmos5l_inv_1_322.A 0.72982f
C6658 sg13cmos5l_mux4_1_9.A0 sg13cmos5l_inv_1_522.A 1.07047f
C6659 sg13cmos5l_buf_1_4.X osc_tap[2] 0.05994f
C6660 sg13cmos5l_inv_1_130.A sg13cmos5l_inv_1_105.A 0.03315f
C6661 sg13cmos5l_inv_1_130.Y sg13cmos5l_inv_1_137.A 0.08518f
C6662 sg13cmos5l_inv_1_129.Y sg13cmos5l_inv_1_105.Y 0.04468f
C6663 sg13cmos5l_inv_1_779.Y sg13cmos5l_inv_1_808.A 0.02247f
C6664 sg13cmos5l_mux4_1_14.A1 sg13cmos5l_inv_1_807.Y 0.04145f
C6665 sg13cmos5l_inv_1_304.A VPWR 0.75102f
C6666 sg13cmos5l_mux4_1_11.A3 sg13cmos5l_or2_1_0.B 0.01515f
C6667 sg13cmos5l_a22oi_1_0.B1 sg13cmos5l_inv_1_677.Y 0.01093f
C6668 sg13cmos5l_inv_1_828.Y sg13cmos5l_inv_1_783.A 0.01717f
C6669 sg13cmos5l_inv_1_563.A a_1952_16122# 0.03465f
C6670 sg13cmos5l_mux4_1_5.S0 sg13cmos5l_mux4_1_7.A3 1.09223f
C6671 sg13cmos5l_inv_1_394.A a_8446_8434# 0.0509f
C6672 sg13cmos5l_inv_1_124.A sg13cmos5l_mux2_1_3.A0 0.04324f
C6673 sg13cmos5l_inv_1_177.A sg13cmos5l_inv_1_141.A 0.0342f
C6674 sg13cmos5l_inv_1_141.Y a_17896_6254# 0.0283f
C6675 sg13cmos5l_inv_1_750.Y VPWR 0.54362f
C6676 sg13cmos5l_inv_1_356.A VPWR 0.43048f
C6677 sg13cmos5l_inv_1_534.Y sg13cmos5l_mux4_1_10.A3 0.41722f
C6678 a_2632_4742# VPWR 0.16057f
C6679 sg13cmos5l_buf_1_9.A sg13cmos5l_inv_1_423.A 0.10837f
C6680 sg13cmos5l_inv_1_947.Y sg13cmos5l_inv_1_1012.Y 0.21708f
C6681 sg13cmos5l_inv_1_120.A sg13cmos5l_inv_1_113.Y 0.02211f
C6682 a_7271_3534# VPWR 0.39293f
C6683 sg13cmos5l_mux4_1_4.A2 a_6934_8434# 0.02465f
C6684 sg13cmos5l_buf_1_9.A a_6910_12970# 0.04354f
C6685 a_13895_15630# a_14324_15630# 0.0289f
C6686 a_6430_8434# a_7157_8747# 0.01228f
C6687 a_14710_15630# a_14206_15630# 0.97548f
C6688 sg13cmos5l_mux4_1_16.X sg13cmos5l_inv_1_124.Y 0.05536f
C6689 sg13cmos5l_buf_1_6.A VPWR 0.26456f
C6690 sg13cmos5l_inv_1_344.A sg13cmos5l_inv_1_341.Y 0.29971f
C6691 sg13cmos5l_buf_1_8.A a_3488_12302# 0.04012f
C6692 sg13cmos5l_buf_1_8.A sg13cmos5l_inv_1_225.Y 0.09179f
C6693 sg13cmos5l_inv_1_467.Y a_6119_8434# 0.21854f
C6694 sg13cmos5l_inv_1_668.Y VPWR 0.43418f
C6695 a_9064_10790# VPWR 0.14377f
C6696 sg13cmos5l_inv_1_424.A sg13cmos5l_inv_1_425.A 0.20577f
C6697 sg13cmos5l_inv_1_623.Y a_6176_16122# 0.05751f
C6698 sg13cmos5l_inv_1_818.A sg13cmos5l_inv_1_920.A 0.0156f
C6699 sg13cmos5l_inv_1_304.Y sg13cmos5l_inv_1_313.Y 0.0181f
C6700 sg13cmos5l_inv_1_248.A sg13cmos5l_inv_1_460.Y 0.012f
C6701 sg13cmos5l_inv_1_689.Y sg13cmos5l_inv_1_668.A 0.16915f
C6702 sg13cmos5l_inv_1_685.Y sg13cmos5l_inv_1_510.Y 0.18166f
C6703 a_14110_3534# a_14023_3195# 0.02548f
C6704 a_2632_11586# VPWR 0.14359f
C6705 sg13cmos5l_inv_1_736.Y a_10880_11586# 0.03639f
C6706 sg13cmos5l_buf_1_0.A sg13cmos5l_inv_1_236.A 0.03114f
C6707 sg13cmos5l_o21ai_1_0.B1 sg13cmos5l_inv_1_509.A 0.05333f
C6708 sg13cmos5l_inv_1_306.A a_6088_1718# 0.01239f
C6709 sg13cmos5l_inv_1_556.Y a_5320_18350# 0.03488f
C6710 sg13cmos5l_inv_1_562.Y sg13cmos5l_mux4_1_5.S0 0.04174f
C6711 sg13cmos5l_mux2_1_4.S sg13cmos5l_mux2_1_3.A0 0.25543f
C6712 sg13cmos5l_mux4_1_5.S0 sg13cmos5l_mux4_1_5.S1 0.7482f
C6713 a_15768_4088# VPWR 0.96806f
C6714 sg13cmos5l_inv_1_837.Y sg13cmos5l_inv_1_836.Y 0.09644f
C6715 sg13cmos5l_inv_1_980.A sg13cmos5l_nor3_1_1.Y 0.01754f
C6716 a_9260_9906# sg13cmos5l_nor4_1_0.A 0.01245f
C6717 sg13cmos5l_inv_1_828.Y a_18280_18264# 0.01044f
C6718 a_4438_8070# a_4929_8028# 0.3824f
C6719 sg13cmos5l_inv_1_205.Y sg13cmos5l_inv_1_213.A 0.01058f
C6720 sg13cmos5l_inv_1_794.A a_11464_16838# 0.03398f
C6721 sg13cmos5l_inv_1_258.A sg13cmos5l_inv_1_257.A 0.20124f
C6722 a_6656_10074# VPWR 0.07775f
C6723 sg13cmos5l_inv_1_236.Y sg13cmos5l_inv_1_89.Y 0.01312f
C6724 sg13cmos5l_inv_1_813.Y sg13cmos5l_buf_1_17.X 0.01056f
C6725 sg13cmos5l_inv_1_702.Y VPWR 0.56737f
C6726 sg13cmos5l_inv_1_930.A a_16744_10074# 0.02316f
C6727 sg13cmos5l_inv_1_961.Y sg13cmos5l_inv_1_988.A 0.04439f
C6728 sg13cmos5l_inv_1_537.Y sg13cmos5l_inv_1_689.A 0.07035f
C6729 sg13cmos5l_mux4_1_5.S0 sg13cmos5l_a21oi_1_0.B1 0.0635f
C6730 sg13cmos5l_mux2_1_1.X a_8123_8472# 0.01206f
C6731 sg13cmos5l_o21ai_1_0.B1 sg13cmos5l_inv_1_925.Y 0.04177f
C6732 sg13cmos5l_inv_1_217.A sg13cmos5l_inv_1_228.A 0.01544f
C6733 sg13cmos5l_inv_1_982.A sg13cmos5l_inv_1_970.A 0.24462f
C6734 sg13cmos5l_inv_1_329.A a_1472_2514# 0.01054f
C6735 sg13cmos5l_inv_1_381.Y sg13cmos5l_inv_1_248.A 0.02929f
C6736 sg13cmos5l_inv_1_553.Y sg13cmos5l_inv_1_533.Y 0.01013f
C6737 sg13cmos5l_inv_1_76.A sg13cmos5l_inv_1_216.Y 0.01365f
C6738 sg13cmos5l_mux4_1_8.A1 sg13cmos5l_inv_1_616.Y 0.04543f
C6739 sg13cmos5l_a22oi_1_0.A1 VPWR 0.64179f
C6740 sg13cmos5l_inv_1_359.Y VPWR 0.69761f
C6741 sg13cmos5l_inv_1_2.A sg13cmos5l_inv_1_8.Y 0.01914f
C6742 sg13cmos5l_mux4_1_9.X sg13cmos5l_buf_1_10.A 0.24149f
C6743 sg13cmos5l_inv_1_648.Y sg13cmos5l_inv_1_480.A 0.11967f
C6744 sg13cmos5l_mux4_1_5.S1 a_3934_8070# 0.03068f
C6745 sg13cmos5l_inv_1_124.A sg13cmos5l_inv_1_1004.Y 0.12815f
C6746 sg13cmos5l_inv_1_717.A sg13cmos5l_inv_1_994.A 0.01742f
C6747 sg13cmos5l_inv_1_237.Y a_5005_3418# 0.01006f
C6748 sg13cmos5l_inv_1_696.A sg13cmos5l_inv_1_698.A 0.19825f
C6749 sg13cmos5l_mux4_1_8.A0 sg13cmos5l_inv_1_790.Y 0.11002f
C6750 sg13cmos5l_inv_1_138.A sg13cmos5l_inv_1_105.Y 0.20628f
C6751 sg13cmos5l_inv_1_772.A sg13cmos5l_inv_1_769.Y 0.02719f
C6752 sg13cmos5l_inv_1_305.Y sg13cmos5l_inv_1_313.Y 0.01659f
C6753 sg13cmos5l_inv_1_75.A sg13cmos5l_inv_1_92.A 0.06169f
C6754 sg13cmos5l_inv_1_249.Y sg13cmos5l_inv_1_273.A 0.18603f
C6755 sg13cmos5l_buf_1_8.A sg13cmos5l_or2_1_0.B 0.06574f
C6756 sg13cmos5l_inv_1_166.Y VPWR 0.48885f
C6757 sg13cmos5l_o21ai_1_0.B1 sg13cmos5l_inv_1_991.A 0.01541f
C6758 a_15637_8028# a_16531_7731# 0.01967f
C6759 sg13cmos5l_inv_1_18.Y VPWR 0.39914f
C6760 sg13cmos5l_inv_1_520.A sg13cmos5l_inv_1_518.Y 0.13692f
C6761 sg13cmos5l_inv_1_662.Y sg13cmos5l_inv_1_663.Y 0.20866f
C6762 sg13cmos5l_inv_1_447.A a_8776_5538# 0.02582f
C6763 sg13cmos5l_nand2_1_1.B a_9736_9278# 0.05129f
C6764 sg13cmos5l_buf_1_4.X VPWR 0.31447f
C6765 sg13cmos5l_inv_1_701.A a_16256_10790# 0.03508f
C6766 sg13cmos5l_inv_1_42.A sg13cmos5l_inv_1_55.Y 0.19738f
C6767 sg13cmos5l_mux2_1_4.X sg13cmos5l_inv_1_445.A 0.16495f
C6768 sg13cmos5l_mux2_1_4.S sg13cmos5l_inv_1_270.Y 0.02597f
C6769 sg13cmos5l_inv_1_466.Y sg13cmos5l_inv_1_306.A 0.01396f
C6770 sg13cmos5l_mux4_1_0.A0 sg13cmos5l_inv_1_155.Y 0.4138f
C6771 sg13cmos5l_inv_1_367.Y sg13cmos5l_inv_1_341.Y 0.27291f
C6772 sg13cmos5l_mux2_1_3.S sg13cmos5l_inv_1_394.Y 0.07785f
C6773 a_15275_7644# a_15016_7766# 0.03389f
C6774 sg13cmos5l_inv_1_623.Y VPWR 0.40819f
C6775 sg13cmos5l_a22oi_1_0.A1 sg13cmos5l_a22oi_1_0.A2 0.12841f
C6776 sg13cmos5l_mux4_1_12.A1 sg13cmos5l_inv_1_730.A 0.42512f
C6777 sg13cmos5l_inv_1_8.A VPWR 0.38092f
C6778 sg13cmos5l_inv_1_893.Y VPWR 0.42412f
C6779 sg13cmos5l_inv_1_645.Y sg13cmos5l_inv_1_478.A 0.02481f
C6780 sg13cmos5l_a21oi_1_0.B1 sg13cmos5l_inv_1_532.Y 0.05418f
C6781 sg13cmos5l_o21ai_1_0.B1 sg13cmos5l_buf_1_8.A 0.04274f
C6782 sg13cmos5l_inv_1_129.Y sg13cmos5l_inv_1_130.Y 0.29529f
C6783 sg13cmos5l_inv_1_894.Y sg13cmos5l_inv_1_725.Y 0.01362f
C6784 sg13cmos5l_mux2_1_4.S sg13cmos5l_inv_1_1004.Y 0.34463f
C6785 sg13cmos5l_inv_1_2.Y VPWR 0.41208f
C6786 a_9736_9278# a_9920_9278# 0.11523f
C6787 sg13cmos5l_inv_1_592.Y sg13cmos5l_inv_1_592.A 0.2715f
C6788 sg13cmos5l_inv_1_307.A VPWR 0.59529f
C6789 sg13cmos5l_inv_1_852.Y VPWR 0.42619f
C6790 sg13cmos5l_inv_1_338.Y a_3680_4026# 0.03544f
C6791 sg13cmos5l_inv_1_105.A VPWR 0.35562f
C6792 sg13cmos5l_mux2_1_0.X sg13cmos5l_inv_1_111.A 0.04744f
C6793 a_16168_1718# VPWR 0.15058f
C6794 sg13cmos5l_inv_1_636.A VPWR 0.44871f
C6795 sg13cmos5l_inv_1_267.Y sg13cmos5l_inv_1_284.A 0.06977f
C6796 a_10688_7050# VPWR 0.08175f
C6797 sg13cmos5l_mux2_1_4.S sg13cmos5l_inv_1_933.A 0.07901f
C6798 sg13cmos5l_a21oi_1_0.A1 sg13cmos5l_a21oi_1_1.A1 0.11522f
C6799 sg13cmos5l_inv_1_857.Y sg13cmos5l_inv_1_818.A 0.12391f
C6800 sg13cmos5l_buf_1_7.X VPWR 2.35735f
C6801 sg13cmos5l_inv_1_699.Y sg13cmos5l_mux4_1_15.A3 0.11708f
C6802 sg13cmos5l_inv_1_541.Y sg13cmos5l_inv_1_566.A 0.03186f
C6803 sg13cmos5l_inv_1_86.Y sg13cmos5l_inv_1_59.Y 0.04884f
C6804 sg13cmos5l_buf_1_8.A sg13cmos5l_inv_1_248.A 0.0306f
C6805 sg13cmos5l_buf_1_9.A sg13cmos5l_inv_1_579.Y 0.06768f
C6806 sg13cmos5l_mux4_1_13.A0 sg13cmos5l_inv_1_844.Y 0.01963f
C6807 sg13cmos5l_inv_1_854.Y sg13cmos5l_inv_1_857.A 0.02913f
C6808 sg13cmos5l_buf_1_8.A sg13cmos5l_inv_1_194.Y 0.34811f
C6809 sg13cmos5l_inv_1_61.A sg13cmos5l_inv_1_58.Y 0.1972f
C6810 sg13cmos5l_inv_1_453.A sg13cmos5l_inv_1_442.A 0.01087f
C6811 sg13cmos5l_inv_1_453.Y sg13cmos5l_inv_1_298.A 0.02004f
C6812 sg13cmos5l_inv_1_809.Y sg13cmos5l_inv_1_807.A 0.02521f
C6813 sg13cmos5l_buf_1_8.A sg13cmos5l_inv_1_156.Y 0.016f
C6814 sg13cmos5l_inv_1_584.A sg13cmos5l_inv_1_617.A 0.02457f
C6815 sg13cmos5l_inv_1_600.A sg13cmos5l_inv_1_608.Y 0.12814f
C6816 sg13cmos5l_nand2_1_1.B sg13cmos5l_inv_1_384.Y 0.12438f
C6817 sg13cmos5l_mux4_1_5.X a_9326_3410# 0.09422f
C6818 sg13cmos5l_inv_1_733.A sg13cmos5l_inv_1_731.A 0.25297f
C6819 sg13cmos5l_inv_1_945.Y VPWR 0.42057f
C6820 sg13cmos5l_a21oi_1_0.B1 sg13cmos5l_inv_1_489.A 0.30074f
C6821 sg13cmos5l_inv_1_560.A VPWR 0.41904f
C6822 sg13cmos5l_inv_1_70.Y a_11456_1718# 0.03553f
C6823 a_3934_15994# a_4438_15994# 0.97548f
C6824 sg13cmos5l_inv_1_953.Y VPWR 0.43198f
C6825 sg13cmos5l_inv_1_1009.Y VPWR 0.59199f
C6826 sg13cmos5l_a22oi_1_0.B1 a_8192_12302# 0.03153f
C6827 sg13cmos5l_inv_1_464.Y VPWR 0.42818f
C6828 sg13cmos5l_mux4_1_5.S0 sg13cmos5l_inv_1_622.Y 0.02716f
C6829 sg13cmos5l_a22oi_1_0.B1 a_5408_13098# 0.02134f
C6830 sg13cmos5l_inv_1_334.A sg13cmos5l_inv_1_322.A 0.44934f
C6831 sg13cmos5l_inv_1_845.Y sg13cmos5l_mux2_1_4.S 0.0169f
C6832 sg13cmos5l_inv_1_166.A sg13cmos5l_inv_1_159.A 0.05481f
C6833 sg13cmos5l_inv_1_118.Y a_12896_7766# 0.01086f
C6834 sg13cmos5l_inv_1_298.A sg13cmos5l_inv_1_442.Y 0.1669f
C6835 a_13831_4165# VPWR 0.02431f
C6836 sg13cmos5l_inv_1_666.Y sg13cmos5l_inv_1_522.A 0.02521f
C6837 a_10112_13814# VPWR 0.11907f
C6838 sg13cmos5l_inv_1_712.A sg13cmos5l_inv_1_723.Y 0.01477f
C6839 sg13cmos5l_inv_1_338.Y sg13cmos5l_inv_1_326.Y 0.02557f
C6840 sg13cmos5l_inv_1_130.Y sg13cmos5l_inv_1_138.A 0.47761f
C6841 sg13cmos5l_inv_1_779.Y sg13cmos5l_inv_1_807.Y 0.04586f
C6842 sg13cmos5l_nor3_1_2.B a_4264_13098# 0.04273f
C6843 sg13cmos5l_mux4_1_5.S0 sg13cmos5l_inv_1_637.A 0.32049f
C6844 sg13cmos5l_inv_1_563.A sg13cmos5l_inv_1_563.Y 0.10305f
C6845 sg13cmos5l_inv_1_327.A a_2240_2514# 0.04592f
C6846 sg13cmos5l_inv_1_124.A sg13cmos5l_mux4_1_16.X 0.24631f
C6847 sg13cmos5l_inv_1_848.Y a_18184_16838# 0.01986f
C6848 sg13cmos5l_inv_1_141.Y sg13cmos5l_inv_1_141.A 0.10368f
C6849 sg13cmos5l_inv_1_873.A sg13cmos5l_buf_1_17.X 0.03369f
C6850 sg13cmos5l_inv_1_888.Y a_18856_14516# 0.01386f
C6851 sg13cmos5l_inv_1_356.Y VPWR 0.42915f
C6852 sg13cmos5l_inv_1_337.A VPWR 1.01594f
C6853 sg13cmos5l_mux2_1_4.X a_8653_3418# 0.01751f
C6854 sg13cmos5l_mux4_1_12.A3 a_14422_12606# 0.23529f
C6855 a_18856_16752# a_18664_16838# 0.01225f
C6856 sg13cmos5l_inv_1_937.A sg13cmos5l_inv_1_936.A 0.20065f
C6857 sg13cmos5l_inv_1_628.Y sg13cmos5l_mux4_1_8.A1 0.19028f
C6858 sg13cmos5l_inv_1_402.A sg13cmos5l_mux4_1_6.X 0.77719f
C6859 a_5608_7050# VPWR 0.14701f
C6860 sg13cmos5l_inv_1_213.A VPWR 0.37675f
C6861 sg13cmos5l_inv_1_344.A sg13cmos5l_inv_1_367.Y 0.29558f
C6862 sg13cmos5l_mux2_1_0.X sg13cmos5l_inv_1_212.Y 0.24591f
C6863 a_14119_15291# VPWR 0.02431f
C6864 sg13cmos5l_inv_1_6.Y a_18560_1002# 0.01203f
C6865 sg13cmos5l_inv_1_120.A sg13cmos5l_inv_1_124.Y 0.01158f
C6866 a_808_9980# invsel[3] 0.3344f
C6867 sg13cmos5l_mux4_1_5.S0 a_2920_3932# 0.04537f
C6868 sg13cmos5l_inv_1_624.Y a_6176_16122# 0.03465f
C6869 sg13cmos5l_inv_1_304.Y sg13cmos5l_inv_1_309.Y 0.18759f
C6870 sg13cmos5l_mux4_1_5.S1 sg13cmos5l_inv_1_100.A 0.11451f
C6871 sg13cmos5l_inv_1_248.A sg13cmos5l_inv_1_459.Y 0.02342f
C6872 sg13cmos5l_inv_1_680.A sg13cmos5l_inv_1_510.Y 0.01932f
C6873 sg13cmos5l_inv_1_29.A sg13cmos5l_inv_1_30.Y 0.23488f
C6874 a_4929_16036# sg13cmos5l_inv_1_658.Y 0.04224f
C6875 sg13cmos5l_mux2_1_2.A0 sg13cmos5l_inv_1_534.A 0.10277f
C6876 sg13cmos5l_inv_1_694.A sg13cmos5l_inv_1_942.Y 0.01987f
C6877 sg13cmos5l_inv_1_947.A VPWR 1.84352f
C6878 sg13cmos5l_buf_1_0.A sg13cmos5l_inv_1_218.A 0.03101f
C6879 sg13cmos5l_inv_1_904.Y a_13288_13814# 0.03352f
C6880 sg13cmos5l_buf_1_8.A sg13cmos5l_inv_1_235.A 0.1511f
C6881 a_18764_5370# a_19048_5538# 0.01225f
C6882 sg13cmos5l_a21oi_1_0.B1 sg13cmos5l_inv_1_523.Y 0.47437f
C6883 sg13cmos5l_mux2_1_4.S sg13cmos5l_mux4_1_16.X 0.67865f
C6884 sg13cmos5l_inv_1_837.Y sg13cmos5l_inv_1_848.Y 0.01654f
C6885 sg13cmos5l_mux4_1_2.X VPWR 0.22458f
C6886 a_18280_12216# VPWR 0.28133f
C6887 sg13cmos5l_inv_1_828.Y sg13cmos5l_inv_1_834.Y 0.04776f
C6888 sg13cmos5l_inv_1_6.Y sg13cmos5l_inv_1_22.A 0.11347f
C6889 sg13cmos5l_inv_1_794.A sg13cmos5l_inv_1_800.A 0.11183f
C6890 sg13cmos5l_inv_1_982.A VPWR 0.35373f
C6891 a_12808_18350# VPWR 0.20191f
C6892 sg13cmos5l_inv_1_584.A sg13cmos5l_inv_1_612.A 0.03003f
C6893 sg13cmos5l_inv_1_614.A a_7144_16838# 0.0469f
C6894 sg13cmos5l_nand2_1_1.Y sg13cmos5l_inv_1_124.A 0.01532f
C6895 sg13cmos5l_inv_1_722.Y VPWR 0.59347f
C6896 sg13cmos5l_inv_1_930.A sg13cmos5l_inv_1_988.A 0.06976f
C6897 sg13cmos5l_inv_1_693.A sg13cmos5l_inv_1_948.A 0.18195f
C6898 sg13cmos5l_inv_1_207.Y a_15584_5538# 0.01054f
C6899 sg13cmos5l_inv_1_212.Y sg13cmos5l_inv_1_185.A 0.0355f
C6900 sg13cmos5l_inv_1_537.Y sg13cmos5l_a21oi_1_0.B1 0.02622f
C6901 sg13cmos5l_inv_1_728.Y sg13cmos5l_inv_1_715.Y 0.26123f
C6902 sg13cmos5l_inv_1_414.A a_8864_4742# 0.01165f
C6903 sg13cmos5l_inv_1_553.Y sg13cmos5l_inv_1_688.A 0.02095f
C6904 sg13cmos5l_a22oi_1_0.B1 a_4929_12564# 0.01117f
C6905 sg13cmos5l_mux2_1_3.X sg13cmos5l_inv_1_124.Y 0.07395f
C6906 sg13cmos5l_inv_1_362.A sg13cmos5l_inv_1_362.Y 0.15401f
C6907 sg13cmos5l_inv_1_922.A a_8200_10790# 0.01986f
C6908 sg13cmos5l_inv_1_972.Y sg13cmos5l_mux4_1_4.A2 0.01043f
C6909 sg13cmos5l_mux4_1_8.A1 sg13cmos5l_inv_1_616.A 0.01407f
C6910 a_14389_11500# a_15283_11725# 0.01967f
C6911 sg13cmos5l_inv_1_394.A sg13cmos5l_mux4_1_16.A1 0.01704f
C6912 sg13cmos5l_inv_1_168.A a_18464_7766# 0.03553f
C6913 sg13cmos5l_inv_1_124.A sg13cmos5l_inv_1_400.Y 0.02758f
C6914 sg13cmos5l_mux4_1_5.S1 sg13cmos5l_inv_1_325.Y 0.01054f
C6915 sg13cmos5l_inv_1_717.A sg13cmos5l_inv_1_698.A 0.02163f
C6916 a_13288_16122# a_13472_16122# 0.11523f
C6917 sg13cmos5l_mux4_1_8.A0 sg13cmos5l_inv_1_791.A 0.03038f
C6918 a_18664_16838# sg13cmos5l_inv_1_862.A 0.01033f
C6919 sg13cmos5l_buf_1_8.A a_2248_3932# 0.32394f
C6920 sg13cmos5l_inv_1_138.A sg13cmos5l_inv_1_137.A 0.23981f
C6921 sg13cmos5l_inv_1_212.Y sg13cmos5l_inv_1_185.Y 0.11185f
C6922 sg13cmos5l_inv_1_75.Y sg13cmos5l_inv_1_92.A 0.06073f
C6923 sg13cmos5l_mux4_1_5.S0 a_7271_3534# 0.51531f
C6924 sg13cmos5l_inv_1_14.A sg13cmos5l_inv_1_40.Y 0.03417f
C6925 sg13cmos5l_nor3_1_1.A VPWR 0.91159f
C6926 sg13cmos5l_inv_1_958.Y VPWR 0.42889f
C6927 sg13cmos5l_inv_1_19.A VPWR 0.42265f
C6928 sg13cmos5l_inv_1_518.A sg13cmos5l_inv_1_518.Y 0.23601f
C6929 sg13cmos5l_inv_1_884.Y a_13918_14482# 0.13182f
C6930 a_800_17634# VPWR 0.06732f
C6931 sg13cmos5l_inv_1_576.A a_3623_15994# 0.20876f
C6932 sg13cmos5l_inv_1_149.A a_15637_8028# 0.17433f
C6933 a_16075_7649# sg13cmos5l_inv_1_179.A 0.21257f
C6934 sg13cmos5l_mux2_1_4.S sg13cmos5l_nand2_1_1.Y 0.2605f
C6935 sg13cmos5l_inv_1_701.A sg13cmos5l_inv_1_716.A 0.20065f
C6936 sg13cmos5l_inv_1_38.Y sg13cmos5l_inv_1_16.A 0.15411f
C6937 sg13cmos5l_inv_1_517.A sg13cmos5l_inv_1_947.A 0.45412f
C6938 sg13cmos5l_inv_1_749.A sg13cmos5l_inv_1_120.A 0.01282f
C6939 sg13cmos5l_inv_1_113.A sg13cmos5l_inv_1_136.Y 0.0183f
C6940 sg13cmos5l_inv_1_624.Y VPWR 0.4239f
C6941 sg13cmos5l_mux4_1_12.A1 sg13cmos5l_inv_1_715.Y 0.02434f
C6942 sg13cmos5l_inv_1_684.A sg13cmos5l_inv_1_645.A 0.02423f
C6943 sg13cmos5l_inv_1_892.Y VPWR 0.43036f
C6944 sg13cmos5l_mux2_1_4.S sg13cmos5l_inv_1_217.A 0.01594f
C6945 sg13cmos5l_inv_1_585.A sg13cmos5l_inv_1_596.Y 0.02521f
C6946 sg13cmos5l_inv_1_592.Y sg13cmos5l_inv_1_585.Y 0.06231f
C6947 sg13cmos5l_inv_1_138.Y sg13cmos5l_inv_1_130.Y 0.03026f
C6948 a_13799_3534# VPWR 0.45419f
C6949 sg13cmos5l_mux2_1_4.S sg13cmos5l_inv_1_400.Y 0.03798f
C6950 sg13cmos5l_inv_1_700.Y sg13cmos5l_inv_1_931.Y 0.01366f
C6951 sg13cmos5l_inv_1_46.Y VPWR 0.69857f
C6952 sg13cmos5l_nand2_1_1.Y a_10504_9192# 0.02689f
C6953 sg13cmos5l_inv_1_592.Y sg13cmos5l_inv_1_679.A 0.04307f
C6954 sg13cmos5l_nor3_1_1.A sg13cmos5l_a22oi_1_0.A2 0.4293f
C6955 sg13cmos5l_inv_1_308.A VPWR 0.42156f
C6956 a_18856_3932# osc_tap[0] 0.28827f
C6957 sg13cmos5l_inv_1_292.Y sg13cmos5l_inv_1_259.Y 0.23292f
C6958 a_15475_11725# VPWR 0.02431f
C6959 sg13cmos5l_inv_1_825.A VPWR 0.42567f
C6960 sg13cmos5l_inv_1_338.Y sg13cmos5l_inv_1_319.Y 0.0945f
C6961 a_7912_11586# a_8096_11586# 0.11523f
C6962 sg13cmos5l_inv_1_722.Y a_15584_12302# 0.03465f
C6963 sg13cmos5l_inv_1_553.A sg13cmos5l_inv_1_679.A 0.22124f
C6964 sg13cmos5l_inv_1_394.Y a_9064_8562# 0.04537f
C6965 sg13cmos5l_mux4_1_9.X a_4475_13008# 0.15613f
C6966 sg13cmos5l_inv_1_635.A VPWR 0.4249f
C6967 sg13cmos5l_inv_1_22.Y VPWR 0.44578f
C6968 sg13cmos5l_inv_1_305.Y sg13cmos5l_inv_1_344.A 0.30314f
C6969 a_10784_17634# VPWR 0.08769f
C6970 sg13cmos5l_nand2_1_1.B a_8200_10790# 0.05637f
C6971 sg13cmos5l_inv_1_616.A sg13cmos5l_inv_1_616.Y 0.20065f
C6972 a_3304_12302# a_3488_12302# 0.11523f
C6973 sg13cmos5l_mux2_1_4.S sg13cmos5l_inv_1_933.Y 0.08876f
C6974 sg13cmos5l_inv_1_494.Y sg13cmos5l_inv_1_922.A 0.11167f
C6975 sg13cmos5l_inv_1_389.A sg13cmos5l_inv_1_382.Y 0.22566f
C6976 sg13cmos5l_inv_1_453.A sg13cmos5l_inv_1_251.A 0.20065f
C6977 sg13cmos5l_inv_1_641.A sg13cmos5l_inv_1_652.Y 0.01288f
C6978 a_18856_1632# osc 0.28823f
C6979 sg13cmos5l_mux2_1_4.S sg13cmos5l_mux4_1_15.A2 0.08911f
C6980 a_13288_12302# a_13288_11586# 0.01275f
C6981 sg13cmos5l_inv_1_857.A sg13cmos5l_inv_1_818.A 0.03206f
C6982 sg13cmos5l_inv_1_576.A sg13cmos5l_mux4_1_10.A2 0.67879f
C6983 a_18856_3932# a_18664_4026# 0.01225f
C6984 a_6119_8434# a_6343_8701# 0.01074f
C6985 sg13cmos5l_mux4_1_7.A3 a_7414_12970# 0.23663f
C6986 sg13cmos5l_inv_1_541.A sg13cmos5l_inv_1_566.A 0.04191f
C6987 a_2816_13098# VPWR 0.07862f
C6988 sg13cmos5l_inv_1_953.Y a_13472_9278# 0.04782f
C6989 a_808_7766# VPWR 0.12665f
C6990 sg13cmos5l_inv_1_892.A VPWR 0.34859f
C6991 a_13831_14749# a_13918_14482# 0.02548f
C6992 a_14989_14488# a_14422_14482# 0.40359f
C6993 sg13cmos5l_buf_1_8.A sg13cmos5l_inv_1_187.Y 0.01088f
C6994 sg13cmos5l_buf_1_4.X a_19048_7050# 0.02116f
C6995 sg13cmos5l_inv_1_305.A sg13cmos5l_inv_1_308.Y 0.03453f
C6996 sg13cmos5l_inv_1_217.A a_18764_5370# 0.32369f
C6997 sg13cmos5l_buf_1_8.A sg13cmos5l_inv_1_155.Y 0.32026f
C6998 sg13cmos5l_inv_1_238.A VPWR 0.42549f
C6999 sg13cmos5l_a21oi_1_0.B1 sg13cmos5l_inv_1_488.A 0.02531f
C7000 sg13cmos5l_inv_1_568.A VPWR 0.44404f
C7001 sg13cmos5l_buf_1_8.A a_15662_4084# 0.13042f
C7002 sg13cmos5l_inv_1_100.A sg13cmos5l_mux4_1_1.A3 0.05876f
C7003 sg13cmos5l_inv_1_681.A sg13cmos5l_inv_1_665.A 0.13562f
C7004 sg13cmos5l_inv_1_510.Y sg13cmos5l_inv_1_510.A 0.09832f
C7005 sg13cmos5l_nor2b_1_0.B_N sg13cmos5l_inv_1_563.A 0.019f
C7006 sg13cmos5l_inv_1_463.Y VPWR 0.42578f
C7007 sg13cmos5l_inv_1_821.Y sg13cmos5l_inv_1_821.A 0.20065f
C7008 sg13cmos5l_mux4_1_5.S0 sg13cmos5l_inv_1_623.Y 0.01481f
C7009 sg13cmos5l_nor3_1_2.B a_14360_11776# 0.052f
C7010 sg13cmos5l_inv_1_78.A sg13cmos5l_inv_1_236.Y 0.05353f
C7011 sg13cmos5l_mux4_1_5.S1 a_8446_8434# 0.01198f
C7012 sg13cmos5l_inv_1_844.Y sg13cmos5l_mux2_1_4.S 0.03128f
C7013 sg13cmos5l_inv_1_118.Y sg13cmos5l_inv_1_118.A 0.10815f
C7014 sg13cmos5l_inv_1_298.Y sg13cmos5l_inv_1_300.Y 0.2023f
C7015 sg13cmos5l_a21oi_1_1.A2 sg13cmos5l_nor3_1_1.A 0.41921f
C7016 sg13cmos5l_a21oi_1_0.Y sg13cmos5l_nor4_1_0.Y 0.05471f
C7017 sg13cmos5l_inv_1_898.A VPWR 0.44803f
C7018 sg13cmos5l_inv_1_467.Y sg13cmos5l_mux4_1_5.S1 0.33761f
C7019 sg13cmos5l_inv_1_988.A a_16640_9278# 0.03501f
C7020 sg13cmos5l_inv_1_150.A sg13cmos5l_inv_1_78.A 0.31061f
C7021 sg13cmos5l_inv_1_712.A sg13cmos5l_inv_1_723.A 0.01904f
C7022 sg13cmos5l_inv_1_956.Y sg13cmos5l_inv_1_957.Y 0.16343f
C7023 a_9832_4026# VPWR 0.14508f
C7024 a_6934_8434# VPWR 0.03029f
C7025 sg13cmos5l_nand2_1_1.B sg13cmos5l_a21oi_1_0.Y 0.2402f
C7026 sg13cmos5l_inv_1_216.Y sg13cmos5l_inv_1_97.Y 0.203f
C7027 sg13cmos5l_inv_1_129.Y sg13cmos5l_inv_1_138.A 0.06331f
C7028 sg13cmos5l_nor3_1_2.B sg13cmos5l_inv_1_478.Y 0.02072f
C7029 sg13cmos5l_inv_1_680.Y sg13cmos5l_inv_1_563.Y 0.07032f
C7030 sg13cmos5l_inv_1_580.A a_8086_15994# 0.03406f
C7031 sg13cmos5l_inv_1_730.A sg13cmos5l_inv_1_730.Y 0.19028f
C7032 sg13cmos5l_buf_1_9.A sg13cmos5l_inv_1_744.Y 0.02394f
C7033 sg13cmos5l_mux4_1_5.S0 sg13cmos5l_inv_1_636.A 0.04016f
C7034 sg13cmos5l_buf_1_9.A sg13cmos5l_inv_1_967.Y 0.32616f
C7035 sg13cmos5l_inv_1_141.Y sg13cmos5l_inv_1_205.A 0.09707f
C7036 sg13cmos5l_nand2_1_1.B sg13cmos5l_inv_1_494.Y 0.02464f
C7037 sg13cmos5l_inv_1_848.Y sg13cmos5l_inv_1_866.Y 0.01308f
C7038 a_11264_12302# VPWR 0.08307f
C7039 sg13cmos5l_inv_1_366.Y VPWR 0.6035f
C7040 sg13cmos5l_inv_1_876.A a_18856_14516# 0.11509f
C7041 sg13cmos5l_inv_1_888.Y sg13cmos5l_buf_1_17.X 0.33483f
C7042 sg13cmos5l_inv_1_334.A VPWR 0.55329f
C7043 sg13cmos5l_inv_1_129.A sg13cmos5l_inv_1_135.Y 0.01524f
C7044 sg13cmos5l_inv_1_990.A sg13cmos5l_inv_1_947.Y 0.15947f
C7045 sg13cmos5l_nor3_1_2.B sg13cmos5l_inv_1_525.A 0.01123f
C7046 sg13cmos5l_mux4_1_11.A2 a_14360_11776# 0.02744f
C7047 sg13cmos5l_mux2_1_4.X sg13cmos5l_inv_1_271.A 0.01644f
C7048 a_17224_15326# VPWR 0.13708f
C7049 a_18856_16752# sg13cmos5l_buf_1_23.X 0.32674f
C7050 sg13cmos5l_inv_1_495.A VPWR 0.7102f
C7051 sg13cmos5l_inv_1_453.Y a_5792_1002# 0.03646f
C7052 sg13cmos5l_inv_1_462.A VPWR 0.3628f
C7053 sg13cmos5l_inv_1_416.Y sg13cmos5l_inv_1_318.Y 0.01341f
C7054 sg13cmos5l_mux2_1_0.X sg13cmos5l_inv_1_207.Y 0.12319f
C7055 a_9536_16838# VPWR 0.1179f
C7056 sg13cmos5l_inv_1_868.A VPWR 0.42568f
C7057 sg13cmos5l_inv_1_467.A sg13cmos5l_inv_1_411.Y 0.119f
C7058 sg13cmos5l_inv_1_467.Y sg13cmos5l_inv_1_357.A 0.01827f
C7059 a_6848_1718# VPWR 0.08018f
C7060 sg13cmos5l_mux4_1_7.A2 a_6599_12970# 0.20566f
C7061 a_14422_14482# a_14913_14524# 0.3824f
C7062 sg13cmos5l_inv_1_423.A sg13cmos5l_inv_1_424.A 0.20065f
C7063 a_8086_3534# a_8653_3418# 0.40359f
C7064 sg13cmos5l_inv_1_676.Y a_5984_13814# 0.01091f
C7065 sg13cmos5l_mux4_1_5.S0 sg13cmos5l_buf_1_7.X 0.01285f
C7066 sg13cmos5l_nor3_1_2.B VPWR 3.87968f
C7067 a_5032_6254# sg13cmos5l_inv_1_416.Y 0.01059f
C7068 sg13cmos5l_inv_1_442.Y a_5792_1002# 0.04597f
C7069 sg13cmos5l_inv_1_283.A sg13cmos5l_inv_1_460.Y 0.01272f
C7070 sg13cmos5l_inv_1_276.A sg13cmos5l_inv_1_274.Y 0.18187f
C7071 sg13cmos5l_inv_1_680.A sg13cmos5l_inv_1_685.Y 0.16343f
C7072 a_3304_13814# a_3488_13814# 0.11523f
C7073 sg13cmos5l_mux2_1_2.A0 sg13cmos5l_inv_1_683.Y 0.02216f
C7074 sg13cmos5l_inv_1_521.Y VPWR 0.56102f
C7075 sg13cmos5l_inv_1_1000.Y sg13cmos5l_inv_1_942.Y 0.38021f
C7076 sg13cmos5l_inv_1_305.A sg13cmos5l_inv_1_306.A 0.05765f
C7077 sg13cmos5l_buf_1_8.A sg13cmos5l_inv_1_234.A 0.04813f
C7078 sg13cmos5l_mux4_1_5.S1 sg13cmos5l_inv_1_78.A 0.17507f
C7079 sg13cmos5l_inv_1_304.A sg13cmos5l_inv_1_257.A 0.02688f
C7080 a_15016_7766# VPWR 0.13328f
C7081 sg13cmos5l_buf_1_9.A a_15608_7680# 0.03085f
C7082 sg13cmos5l_inv_1_560.A sg13cmos5l_mux4_1_5.S0 0.07482f
C7083 sg13cmos5l_inv_1_25.Y sg13cmos5l_mux4_1_2.A2 0.18355f
C7084 a_19048_13098# a_19048_12302# 0.01095f
C7085 sg13cmos5l_buf_1_9.A a_3934_15994# 0.02851f
C7086 sg13cmos5l_inv_1_823.Y sg13cmos5l_inv_1_836.Y 0.01496f
C7087 sg13cmos5l_inv_1_835.A sg13cmos5l_inv_1_848.Y 0.01999f
C7088 sg13cmos5l_inv_1_837.Y sg13cmos5l_inv_1_836.A 0.01928f
C7089 sg13cmos5l_inv_1_712.A VPWR 0.6828f
C7090 sg13cmos5l_inv_1_828.Y sg13cmos5l_inv_1_823.A 0.01348f
C7091 sg13cmos5l_inv_1_301.A sg13cmos5l_inv_1_332.A 0.09435f
C7092 sg13cmos5l_inv_1_794.A sg13cmos5l_inv_1_793.A 0.2026f
C7093 sg13cmos5l_inv_1_194.Y sg13cmos5l_inv_1_76.A 0.01115f
C7094 sg13cmos5l_mux2_1_4.S sg13cmos5l_inv_1_120.A 0.19868f
C7095 sg13cmos5l_inv_1_924.Y VPWR 0.42914f
C7096 sg13cmos5l_inv_1_782.A VPWR 0.42394f
C7097 sg13cmos5l_mux2_1_3.X sg13cmos5l_inv_1_124.A 0.01127f
C7098 sg13cmos5l_mux4_1_11.A2 VPWR 0.33463f
C7099 sg13cmos5l_or2_1_0.B a_9454_11832# 0.01571f
C7100 sg13cmos5l_buf_1_0.A sg13cmos5l_inv_1_82.A 0.02121f
C7101 sg13cmos5l_inv_1_207.Y sg13cmos5l_inv_1_185.A 0.09475f
C7102 sg13cmos5l_inv_1_575.A a_2152_15326# 0.01078f
C7103 sg13cmos5l_inv_1_207.A a_15584_5538# 0.03483f
C7104 sg13cmos5l_inv_1_706.A sg13cmos5l_inv_1_715.Y 0.03177f
C7105 sg13cmos5l_inv_1_414.A sg13cmos5l_inv_1_270.Y 0.14496f
C7106 sg13cmos5l_nor3_1_2.B sg13cmos5l_a22oi_1_0.A2 0.2666f
C7107 a_18764_18228# osc_tap[7] 0.01127f
C7108 sg13cmos5l_inv_1_166.Y sg13cmos5l_inv_1_171.A 0.01483f
C7109 sg13cmos5l_mux4_1_14.A0 a_13918_14482# 0.02531f
C7110 sg13cmos5l_inv_1_553.Y sg13cmos5l_inv_1_557.A 0.02218f
C7111 a_800_9278# VPWR 0.0674f
C7112 sg13cmos5l_inv_1_394.A sg13cmos5l_inv_1_397.Y 0.08947f
C7113 sg13cmos5l_inv_1_168.A sg13cmos5l_inv_1_176.A 0.09123f
C7114 sg13cmos5l_mux4_1_5.S1 sg13cmos5l_inv_1_325.A 0.04815f
C7115 sg13cmos5l_mux4_1_5.S0 sg13cmos5l_inv_1_356.Y 0.0101f
C7116 sg13cmos5l_mux4_1_5.S0 sg13cmos5l_inv_1_337.A 0.16933f
C7117 sg13cmos5l_inv_1_774.Y a_11456_17634# 0.01054f
C7118 sg13cmos5l_mux4_1_13.A0 sg13cmos5l_mux4_1_13.A3 0.38599f
C7119 a_808_13004# sg13cmos5l_nor3_1_2.B 0.30029f
C7120 sg13cmos5l_mux4_1_5.S1 a_9142_6558# 0.02824f
C7121 sg13cmos5l_inv_1_772.A sg13cmos5l_inv_1_770.A 0.15536f
C7122 sg13cmos5l_inv_1_305.Y sg13cmos5l_inv_1_304.Y 0.06126f
C7123 sg13cmos5l_mux2_1_4.S sg13cmos5l_inv_1_16.A 0.07684f
C7124 a_13472_10074# VPWR 0.11552f
C7125 sg13cmos5l_inv_1_957.Y VPWR 0.41817f
C7126 sg13cmos5l_inv_1_55.Y sg13cmos5l_inv_1_49.A 0.05638f
C7127 sg13cmos5l_inv_1_18.A VPWR 0.41532f
C7128 sg13cmos5l_inv_1_518.A sg13cmos5l_inv_1_520.A 0.18584f
C7129 sg13cmos5l_inv_1_926.Y sg13cmos5l_inv_1_663.Y 0.01057f
C7130 sg13cmos5l_inv_1_499.Y sg13cmos5l_inv_1_662.Y 0.2023f
C7131 sg13cmos5l_mux4_1_5.S1 sg13cmos5l_inv_1_191.Y 0.02861f
C7132 sg13cmos5l_inv_1_523.Y a_2632_11586# 0.03427f
C7133 sg13cmos5l_inv_1_541.Y VPWR 0.43023f
C7134 sg13cmos5l_inv_1_448.Y sg13cmos5l_inv_1_447.A 0.02916f
C7135 sg13cmos5l_mux2_1_4.S sg13cmos5l_mux2_1_3.X 0.32392f
C7136 sg13cmos5l_buf_1_9.A sg13cmos5l_inv_1_582.A 0.66978f
C7137 sg13cmos5l_inv_1_317.Y invsel[1] 0.05666f
C7138 sg13cmos5l_inv_1_38.Y sg13cmos5l_inv_1_55.Y 0.04329f
C7139 sg13cmos5l_inv_1_31.A sg13cmos5l_inv_1_42.A 0.20065f
C7140 sg13cmos5l_mux2_1_4.X a_8327_6558# 0.04485f
C7141 sg13cmos5l_inv_1_517.A sg13cmos5l_inv_1_521.Y 0.02464f
C7142 sg13cmos5l_inv_1_347.Y sg13cmos5l_inv_1_367.Y 0.15171f
C7143 sg13cmos5l_inv_1_759.A sg13cmos5l_inv_1_120.A 0.01058f
C7144 sg13cmos5l_inv_1_658.Y VPWR 0.36924f
C7145 sg13cmos5l_mux4_1_12.A1 sg13cmos5l_inv_1_702.Y 0.04049f
C7146 sg13cmos5l_inv_1_503.Y a_808_10790# 0.02464f
C7147 sg13cmos5l_buf_1_9.A sg13cmos5l_inv_1_625.Y 0.29394f
C7148 sg13cmos5l_inv_1_707.Y VPWR 0.60915f
C7149 sg13cmos5l_inv_1_504.A sg13cmos5l_inv_1_505.Y 0.26388f
C7150 sg13cmos5l_inv_1_585.A sg13cmos5l_inv_1_585.Y 0.36701f
C7151 sg13cmos5l_inv_1_120.A sg13cmos5l_inv_1_998.Y 0.06571f
C7152 sg13cmos5l_inv_1_138.Y sg13cmos5l_inv_1_129.Y 0.67895f
C7153 sg13cmos5l_inv_1_216.Y a_15016_2514# 0.03921f
C7154 sg13cmos5l_inv_1_46.A VPWR 0.49907f
C7155 sg13cmos5l_mux2_1_3.X a_10504_9192# 0.02741f
C7156 sg13cmos5l_inv_1_592.Y sg13cmos5l_inv_1_553.A 0.02704f
C7157 sg13cmos5l_inv_1_688.A sg13cmos5l_inv_1_592.A 0.01831f
C7158 sg13cmos5l_inv_1_537.A sg13cmos5l_inv_1_681.Y 0.30144f
C7159 sg13cmos5l_buf_1_2.X osc_tap[0] 0.16242f
C7160 sg13cmos5l_inv_1_292.Y sg13cmos5l_inv_1_260.Y 0.0147f
C7161 sg13cmos5l_inv_1_827.A VPWR 0.42542f
C7162 sg13cmos5l_mux4_1_5.S0 sg13cmos5l_inv_1_982.A 0.12409f
C7163 sg13cmos5l_mux4_1_11.A2 a_15584_12302# 0.01502f
C7164 a_13472_16122# VPWR 0.0691f
C7165 sg13cmos5l_inv_1_634.A VPWR 0.42939f
C7166 sg13cmos5l_inv_1_16.Y VPWR 0.81424f
C7167 sg13cmos5l_mux2_1_4.S a_9709_6442# 0.06232f
C7168 sg13cmos5l_inv_1_787.Y a_13895_15630# 0.21302f
C7169 sg13cmos5l_a21oi_1_1.A2 sg13cmos5l_nor3_1_2.B 1.30619f
C7170 sg13cmos5l_inv_1_809.Y VPWR 0.70838f
C7171 sg13cmos5l_inv_1_235.Y sg13cmos5l_inv_1_77.Y 0.01067f
C7172 sg13cmos5l_buf_1_9.A sg13cmos5l_inv_1_733.A 0.29361f
C7173 a_14206_15630# a_14119_15291# 0.02548f
C7174 sg13cmos5l_o21ai_1_0.B1 sg13cmos5l_inv_1_971.Y 0.02683f
C7175 a_13288_10790# VPWR 0.12921f
C7176 sg13cmos5l_buf_1_9.A sg13cmos5l_mux4_1_15.A3 0.58631f
C7177 sg13cmos5l_mux4_1_5.S1 a_9633_6516# 0.23937f
C7178 sg13cmos5l_buf_1_9.A sg13cmos5l_a22oi_1_0.B1 0.03112f
C7179 a_8577_3492# a_9326_3410# 0.03454f
C7180 sg13cmos5l_inv_1_762.Y a_13607_12606# 0.2139f
C7181 sg13cmos5l_inv_1_576.A sg13cmos5l_inv_1_533.A 0.28196f
C7182 sg13cmos5l_buf_1_2.X a_18664_4026# 0.06451f
C7183 sg13cmos5l_inv_1_883.A sg13cmos5l_inv_1_883.Y 0.14761f
C7184 sg13cmos5l_inv_1_431.A sg13cmos5l_inv_1_349.A 0.0899f
C7185 sg13cmos5l_mux4_1_15.X sg13cmos5l_mux4_1_15.A3 0.53679f
C7186 sg13cmos5l_nor3_1_1.B VPWR 0.55216f
C7187 sg13cmos5l_inv_1_377.Y VPWR 0.3636f
C7188 sg13cmos5l_mux4_1_6.X a_5005_7954# 0.01015f
C7189 sg13cmos5l_inv_1_84.Y sg13cmos5l_inv_1_86.Y 0.20065f
C7190 sg13cmos5l_inv_1_855.Y sg13cmos5l_inv_1_847.Y 0.02913f
C7191 sg13cmos5l_mux4_1_11.A1 VPWR 0.69009f
C7192 sg13cmos5l_inv_1_815.Y a_17224_15326# 0.02089f
C7193 sg13cmos5l_buf_1_8.A sg13cmos5l_inv_1_187.A 0.02736f
C7194 sg13cmos5l_buf_1_8.A sg13cmos5l_inv_1_283.A 0.03819f
C7195 sg13cmos5l_mux2_1_4.S a_14422_3898# 0.04749f
C7196 sg13cmos5l_inv_1_305.A sg13cmos5l_inv_1_306.Y 0.13689f
C7197 sg13cmos5l_inv_1_295.Y sg13cmos5l_inv_1_300.Y 0.05845f
C7198 a_4438_15994# sg13cmos5l_mux2_1_2.A0 0.02868f
C7199 sg13cmos5l_nor4_1_0.A a_9544_10074# 0.04431f
C7200 sg13cmos5l_inv_1_31.Y sg13cmos5l_inv_1_16.A 0.02658f
C7201 sg13cmos5l_inv_1_751.A sg13cmos5l_inv_1_752.A 0.19345f
C7202 a_13918_14482# VPWR 0.88382f
C7203 sg13cmos5l_inv_1_244.A VPWR 0.42164f
C7204 sg13cmos5l_buf_1_9.A a_14422_14482# 0.02946f
C7205 sg13cmos5l_inv_1_391.Y sg13cmos5l_inv_1_396.Y 0.2023f
C7206 sg13cmos5l_a21oi_1_0.B1 sg13cmos5l_inv_1_677.Y 0.08f
C7207 sg13cmos5l_buf_1_10.A sg13cmos5l_inv_1_421.Y 0.06555f
C7208 sg13cmos5l_inv_1_70.A sg13cmos5l_inv_1_66.Y 0.06077f
C7209 sg13cmos5l_inv_1_680.A a_1576_13814# 0.01166f
C7210 sg13cmos5l_inv_1_510.Y sg13cmos5l_inv_1_665.A 0.16711f
C7211 sg13cmos5l_inv_1_461.Y VPWR 0.42645f
C7212 sg13cmos5l_nor2b_1_0.B_N sg13cmos5l_inv_1_680.Y 0.1999f
C7213 sg13cmos5l_inv_1_418.Y sg13cmos5l_inv_1_416.A 0.0252f
C7214 sg13cmos5l_inv_1_298.A sg13cmos5l_inv_1_300.Y 0.01377f
C7215 sg13cmos5l_mux4_1_2.A2 VPWR 0.58087f
C7216 sg13cmos5l_a21oi_1_0.Y sg13cmos5l_or2_1_0.X 0.16992f
C7217 sg13cmos5l_buf_1_12.X sg13cmos5l_inv_1_394.A 0.08772f
C7218 sg13cmos5l_buf_1_0.A sg13cmos5l_inv_1_78.A 0.04562f
C7219 sg13cmos5l_inv_1_467.A sg13cmos5l_mux4_1_5.S1 0.0169f
C7220 sg13cmos5l_inv_1_389.Y sg13cmos5l_inv_1_382.A 0.03819f
C7221 sg13cmos5l_inv_1_712.A sg13cmos5l_inv_1_721.A 0.23204f
C7222 sg13cmos5l_inv_1_106.A sg13cmos5l_inv_1_78.A 0.05245f
C7223 sg13cmos5l_buf_1_9.A sg13cmos5l_mux4_1_12.A3 0.56471f
C7224 sg13cmos5l_inv_1_338.Y a_3623_3534# 0.10643f
C7225 sg13cmos5l_inv_1_216.Y sg13cmos5l_inv_1_61.Y 0.01101f
C7226 sg13cmos5l_inv_1_138.Y sg13cmos5l_inv_1_138.A 0.14083f
C7227 sg13cmos5l_nor3_1_2.B sg13cmos5l_inv_1_482.Y 0.04526f
C7228 sg13cmos5l_inv_1_730.A sg13cmos5l_inv_1_699.Y 0.05599f
C7229 sg13cmos5l_inv_1_149.Y sg13cmos5l_inv_1_150.A 0.15743f
C7230 sg13cmos5l_inv_1_563.A sg13cmos5l_nor2b_1_0.A 0.08663f
C7231 sg13cmos5l_inv_1_848.Y sg13cmos5l_inv_1_872.A 0.03039f
C7232 sg13cmos5l_inv_1_876.A sg13cmos5l_buf_1_17.X 0.02854f
C7233 sg13cmos5l_inv_1_366.A VPWR 0.39753f
C7234 sg13cmos5l_inv_1_186.Y a_19048_6254# 0.03921f
C7235 sg13cmos5l_inv_1_422.A VPWR 0.46063f
C7236 sg13cmos5l_mux2_1_4.X sg13cmos5l_inv_1_270.A 0.01411f
C7237 sg13cmos5l_inv_1_509.Y sg13cmos5l_inv_1_525.A 0.12215f
C7238 sg13cmos5l_inv_1_813.Y VPWR 0.42567f
C7239 sg13cmos5l_inv_1_937.Y sg13cmos5l_inv_1_937.A 0.20065f
C7240 sg13cmos5l_inv_1_532.A a_3623_12606# 0.04237f
C7241 sg13cmos5l_inv_1_630.A sg13cmos5l_inv_1_628.Y 0.20065f
C7242 sg13cmos5l_a21oi_1_0.A2 VPWR 0.22554f
C7243 sg13cmos5l_inv_1_386.Y VPWR 0.40462f
C7244 sg13cmos5l_mux2_1_0.X sg13cmos5l_inv_1_207.A 0.05827f
C7245 sg13cmos5l_inv_1_975.A VPWR 0.4881f
C7246 sg13cmos5l_inv_1_818.Y VPWR 0.51069f
C7247 sg13cmos5l_inv_1_259.Y VPWR 0.42571f
C7248 sg13cmos5l_inv_1_467.A sg13cmos5l_inv_1_357.A 0.01698f
C7249 sg13cmos5l_buf_1_8.A sg13cmos5l_inv_1_228.Y 0.07997f
C7250 a_14407_9243# VPWR 0.02431f
C7251 sg13cmos5l_inv_1_479.Y a_5984_13814# 0.03646f
C7252 sg13cmos5l_inv_1_421.A sg13cmos5l_inv_1_421.Y 0.14622f
C7253 sg13cmos5l_inv_1_509.Y VPWR 0.45083f
C7254 sg13cmos5l_inv_1_883.A a_11936_14610# 0.0359f
C7255 sg13cmos5l_inv_1_442.A a_5792_1002# 0.01083f
C7256 sg13cmos5l_inv_1_283.A sg13cmos5l_inv_1_459.Y 0.36517f
C7257 sg13cmos5l_inv_1_241.Y sg13cmos5l_inv_1_274.Y 0.48254f
C7258 sg13cmos5l_inv_1_37.Y sg13cmos5l_inv_1_29.A 0.07935f
C7259 sg13cmos5l_inv_1_1000.Y sg13cmos5l_inv_1_986.Y 0.01535f
C7260 sg13cmos5l_mux4_1_0.A0 VPWR 0.50146f
C7261 sg13cmos5l_inv_1_305.A sg13cmos5l_inv_1_304.A 0.06795f
C7262 sg13cmos5l_inv_1_568.A sg13cmos5l_mux4_1_5.S0 0.01853f
C7263 a_808_6254# VPWR 0.12665f
C7264 sg13cmos5l_mux2_1_1.X a_9260_9906# 0.03894f
C7265 sg13cmos5l_inv_1_714.A VPWR 0.49419f
C7266 sg13cmos5l_inv_1_828.Y sg13cmos5l_inv_1_819.A 0.71051f
C7267 sg13cmos5l_a22oi_1_0.A2 sg13cmos5l_a21oi_1_0.A2 0.01625f
C7268 sg13cmos5l_inv_1_972.Y VPWR 0.43954f
C7269 sg13cmos5l_inv_1_775.A VPWR 0.69748f
C7270 sg13cmos5l_inv_1_725.Y sg13cmos5l_inv_1_712.A 0.16384f
C7271 sg13cmos5l_inv_1_708.A sg13cmos5l_inv_1_714.A 0.01158f
C7272 sg13cmos5l_inv_1_644.A sg13cmos5l_inv_1_693.A 0.20065f
C7273 sg13cmos5l_mux2_1_4.X sg13cmos5l_inv_1_270.Y 0.47695f
C7274 sg13cmos5l_inv_1_227.A a_15584_5538# 0.03484f
C7275 a_9326_3410# VPWR 0.10893f
C7276 sg13cmos5l_a22oi_1_0.B1 sg13cmos5l_buf_1_10.A 0.04103f
C7277 sg13cmos5l_mux4_1_5.S0 a_6934_8434# 0.11479f
C7278 a_12808_11586# VPWR 0.202f
C7279 a_3847_7731# VPWR 0.02431f
C7280 sg13cmos5l_inv_1_990.Y VPWR 0.53059f
C7281 sg13cmos5l_mux4_1_5.S0 sg13cmos5l_inv_1_366.Y 0.01656f
C7282 sg13cmos5l_inv_1_806.Y a_12136_17634# 0.02235f
C7283 sg13cmos5l_inv_1_152.Y sg13cmos5l_inv_1_209.Y 0.01438f
C7284 sg13cmos5l_buf_1_10.A sg13cmos5l_inv_1_383.Y 0.05328f
C7285 sg13cmos5l_inv_1_942.Y VPWR 0.41565f
C7286 sg13cmos5l_mux4_1_5.S0 sg13cmos5l_inv_1_495.A 0.49374f
C7287 a_14360_11776# a_14389_11500# 0.97548f
C7288 sg13cmos5l_inv_1_145.Y sg13cmos5l_inv_1_217.A 0.01094f
C7289 a_7271_3534# a_7495_3195# 0.01074f
C7290 sg13cmos5l_inv_1_24.Y VPWR 0.41555f
C7291 a_800_2514# VPWR 0.07235f
C7292 sg13cmos5l_inv_1_42.A sg13cmos5l_inv_1_49.A 0.01392f
C7293 sg13cmos5l_inv_1_541.A VPWR 0.35927f
C7294 a_15608_7680# sg13cmos5l_inv_1_179.A 0.03098f
C7295 a_6848_16122# VPWR 0.08323f
C7296 sg13cmos5l_inv_1_699.A sg13cmos5l_inv_1_933.A 0.01069f
C7297 sg13cmos5l_mux4_1_15.A3 a_16256_10790# 0.01231f
C7298 sg13cmos5l_mux4_1_5.S0 sg13cmos5l_nor3_1_2.B 0.039f
C7299 sg13cmos5l_inv_1_135.Y sg13cmos5l_inv_1_110.A 0.01109f
C7300 sg13cmos5l_mux4_1_13.A3 sg13cmos5l_mux2_1_4.S 0.18698f
C7301 sg13cmos5l_mux4_1_12.A1 sg13cmos5l_inv_1_722.Y 0.0221f
C7302 a_4936_15326# VPWR 0.14815f
C7303 sg13cmos5l_inv_1_503.Y sg13cmos5l_inv_1_505.Y 0.11766f
C7304 sg13cmos5l_inv_1_950.Y a_808_10790# 0.03586f
C7305 sg13cmos5l_inv_1_914.A VPWR 0.55414f
C7306 sg13cmos5l_inv_1_585.A sg13cmos5l_inv_1_592.Y 0.2307f
C7307 sg13cmos5l_inv_1_688.A sg13cmos5l_inv_1_585.Y 0.06961f
C7308 sg13cmos5l_inv_1_120.A sg13cmos5l_inv_1_735.Y 0.03039f
C7309 sg13cmos5l_inv_1_217.A sg13cmos5l_inv_1_213.Y 0.01505f
C7310 sg13cmos5l_inv_1_510.A a_1576_13814# 0.01986f
C7311 sg13cmos5l_inv_1_136.Y sg13cmos5l_inv_1_129.Y 0.02875f
C7312 sg13cmos5l_inv_1_216.Y sg13cmos5l_inv_1_220.A 0.15506f
C7313 sg13cmos5l_inv_1_6.Y VPWR 0.69852f
C7314 sg13cmos5l_inv_1_688.A sg13cmos5l_inv_1_679.A 0.04185f
C7315 sg13cmos5l_inv_1_874.Y a_14710_15630# 0.08286f
C7316 sg13cmos5l_inv_1_689.A sg13cmos5l_inv_1_681.Y 0.02487f
C7317 sg13cmos5l_inv_1_51.A osc_tap[0] 0.01516f
C7318 sg13cmos5l_inv_1_247.Y sg13cmos5l_inv_1_260.Y 0.41082f
C7319 sg13cmos5l_inv_1_66.Y sg13cmos5l_inv_1_57.Y 0.15546f
C7320 sg13cmos5l_inv_1_827.Y VPWR 0.42379f
C7321 sg13cmos5l_mux2_1_3.A0 a_15419_8040# 0.01044f
C7322 sg13cmos5l_inv_1_338.Y a_4438_3534# 0.0649f
C7323 sg13cmos5l_mux4_1_15.A3 a_14998_9582# 0.23273f
C7324 sg13cmos5l_inv_1_533.Y sg13cmos5l_inv_1_553.A 0.05967f
C7325 sg13cmos5l_inv_1_95.A sg13cmos5l_inv_1_102.Y 1.92507f
C7326 sg13cmos5l_inv_1_15.Y VPWR 0.49335f
C7327 sg13cmos5l_inv_1_787.Y sg13cmos5l_inv_1_883.Y 0.02307f
C7328 sg13cmos5l_inv_1_684.Y VPWR 0.41442f
C7329 a_14389_11500# VPWR 0.88384f
C7330 sg13cmos5l_mux2_1_0.X sg13cmos5l_inv_1_211.Y 0.03743f
C7331 sg13cmos5l_inv_1_775.Y VPWR 0.43033f
C7332 sg13cmos5l_inv_1_579.Y sg13cmos5l_inv_1_616.A 0.18584f
C7333 sg13cmos5l_buf_1_8.A sg13cmos5l_inv_1_205.Y 0.02463f
C7334 a_18280_12216# osc_tap[4] 0.29166f
C7335 sg13cmos5l_inv_1_537.A sg13cmos5l_inv_1_681.A 0.01431f
C7336 sg13cmos5l_inv_1_689.A sg13cmos5l_inv_1_668.A 0.01436f
C7337 sg13cmos5l_inv_1_640.A sg13cmos5l_inv_1_656.Y 0.02413f
C7338 sg13cmos5l_inv_1_703.Y VPWR 0.42599f
C7339 sg13cmos5l_mux2_1_4.S a_14183_9582# 0.01376f
C7340 sg13cmos5l_buf_1_8.A a_15489_9540# 0.01232f
C7341 sg13cmos5l_mux4_1_5.S1 sg13cmos5l_inv_1_202.Y 0.04199f
C7342 sg13cmos5l_a21oi_1_0.A1 VPWR 0.1758f
C7343 sg13cmos5l_inv_1_72.Y sg13cmos5l_inv_1_59.Y 0.02552f
C7344 sg13cmos5l_inv_1_372.Y VPWR 0.53123f
C7345 sg13cmos5l_inv_1_873.A VPWR 0.41046f
C7346 sg13cmos5l_inv_1_875.Y sg13cmos5l_inv_1_876.Y 0.03259f
C7347 sg13cmos5l_inv_1_115.A VPWR 0.50625f
C7348 sg13cmos5l_buf_1_8.A sg13cmos5l_inv_1_25.Y 0.24672f
C7349 sg13cmos5l_buf_1_4.X sg13cmos5l_inv_1_78.A 0.01102f
C7350 sg13cmos5l_inv_1_599.Y sg13cmos5l_inv_1_598.A 0.01691f
C7351 sg13cmos5l_inv_1_588.Y sg13cmos5l_inv_1_589.A 0.16506f
C7352 sg13cmos5l_inv_1_804.A sg13cmos5l_inv_1_793.A 0.24769f
C7353 sg13cmos5l_mux4_1_1.X sg13cmos5l_inv_1_16.A 0.08505f
C7354 sg13cmos5l_inv_1_589.A sg13cmos5l_inv_1_593.Y 0.04417f
C7355 sg13cmos5l_inv_1_239.A VPWR 0.42358f
C7356 sg13cmos5l_mux2_1_4.S a_14989_12490# 0.37458f
C7357 sg13cmos5l_a21oi_1_0.B1 sg13cmos5l_inv_1_487.A 0.03138f
C7358 sg13cmos5l_inv_1_70.Y sg13cmos5l_inv_1_66.A 0.0188f
C7359 sg13cmos5l_mux4_1_11.A3 a_14360_11776# 0.23584f
C7360 sg13cmos5l_inv_1_100.A a_13799_3534# 0.27833f
C7361 sg13cmos5l_inv_1_228.A a_12136_4742# 0.03609f
C7362 sg13cmos5l_inv_1_460.Y VPWR 0.43097f
C7363 sg13cmos5l_inv_1_819.Y sg13cmos5l_inv_1_821.Y 0.04871f
C7364 sg13cmos5l_inv_1_782.A a_13288_18350# 0.05184f
C7365 sg13cmos5l_mux4_1_5.S0 sg13cmos5l_inv_1_658.Y 0.02448f
C7366 sg13cmos5l_buf_1_27.X a_18664_9192# 0.28895f
C7367 sg13cmos5l_inv_1_112.A sg13cmos5l_inv_1_113.Y 0.22785f
C7368 sg13cmos5l_inv_1_642.Y sg13cmos5l_inv_1_690.A 0.01908f
C7369 sg13cmos5l_inv_1_418.Y sg13cmos5l_inv_1_426.A 0.10293f
C7370 sg13cmos5l_inv_1_298.A sg13cmos5l_inv_1_298.Y 0.21204f
C7371 sg13cmos5l_inv_1_108.Y sg13cmos5l_inv_1_109.Y 0.11145f
C7372 sg13cmos5l_buf_1_9.A a_13831_12267# 0.01266f
C7373 sg13cmos5l_inv_1_311.Y sg13cmos5l_inv_1_326.Y 0.02646f
C7374 sg13cmos5l_inv_1_105.A sg13cmos5l_inv_1_78.A 0.44375f
C7375 sg13cmos5l_inv_1_712.A sg13cmos5l_inv_1_713.A 0.06274f
C7376 a_10208_13098# VPWR 0.08155f
C7377 a_13607_3898# a_13918_3898# 0.49675f
C7378 sg13cmos5l_inv_1_237.Y sg13cmos5l_inv_1_258.A 0.63928f
C7379 sg13cmos5l_a21oi_1_1.A1 sg13cmos5l_a21oi_1_0.Y 0.02692f
C7380 sg13cmos5l_buf_1_7.X sg13cmos5l_inv_1_305.A 1.28243f
C7381 sg13cmos5l_inv_1_783.A sg13cmos5l_inv_1_807.Y 0.01511f
C7382 sg13cmos5l_buf_1_12.X sg13cmos5l_inv_1_411.Y 0.03583f
C7383 a_13288_7050# a_13472_7050# 0.11523f
C7384 sg13cmos5l_inv_1_173.Y sg13cmos5l_inv_1_150.A 0.16221f
C7385 sg13cmos5l_inv_1_149.Y sg13cmos5l_inv_1_106.A 0.13873f
C7386 sg13cmos5l_nor3_1_2.B sg13cmos5l_inv_1_478.A 0.02965f
C7387 sg13cmos5l_inv_1_828.Y sg13cmos5l_mux4_1_8.A0 0.09433f
C7388 sg13cmos5l_inv_1_680.Y sg13cmos5l_nor2b_1_0.A 0.53304f
C7389 sg13cmos5l_inv_1_715.Y sg13cmos5l_inv_1_699.Y 0.0136f
C7390 sg13cmos5l_nand2_1_1.B sg13cmos5l_inv_1_472.Y 0.01176f
C7391 sg13cmos5l_inv_1_370.A VPWR 0.41579f
C7392 sg13cmos5l_inv_1_449.A VPWR 0.41719f
C7393 sg13cmos5l_inv_1_142.A a_19048_6254# 0.02074f
C7394 sg13cmos5l_inv_1_997.A sg13cmos5l_inv_1_990.A 0.11738f
C7395 sg13cmos5l_inv_1_876.Y VPWR 0.68179f
C7396 sg13cmos5l_inv_1_519.Y a_3623_12606# 0.05049f
C7397 sg13cmos5l_inv_1_525.A a_3934_12606# 0.14666f
C7398 sg13cmos5l_mux4_1_7.A3 sg13cmos5l_mux4_1_7.A1 0.44757f
C7399 sg13cmos5l_inv_1_381.Y VPWR 0.49598f
C7400 sg13cmos5l_mux2_1_4.S sg13cmos5l_inv_1_149.A 1.95745f
C7401 sg13cmos5l_mux2_1_0.X sg13cmos5l_inv_1_227.A 0.04575f
C7402 sg13cmos5l_inv_1_627.A VPWR 0.43539f
C7403 sg13cmos5l_mux4_1_11.A3 VPWR 1.07489f
C7404 sg13cmos5l_inv_1_260.Y VPWR 0.38987f
C7405 a_808_16028# invsel[5] 0.32347f
C7406 sg13cmos5l_inv_1_479.Y sg13cmos5l_inv_1_676.Y 0.24279f
C7407 sg13cmos5l_inv_1_509.A VPWR 0.43889f
C7408 a_3934_12606# VPWR 0.90867f
C7409 sg13cmos5l_mux4_1_5.S1 sg13cmos5l_inv_1_184.Y 0.02821f
C7410 sg13cmos5l_inv_1_283.A sg13cmos5l_inv_1_459.A 0.36247f
C7411 sg13cmos5l_inv_1_241.Y sg13cmos5l_inv_1_276.A 0.02163f
C7412 a_15768_4088# a_16094_4192# 0.02749f
C7413 sg13cmos5l_buf_1_9.A sg13cmos5l_mux2_1_2.A0 0.3929f
C7414 sg13cmos5l_inv_1_159.Y VPWR 0.42254f
C7415 sg13cmos5l_inv_1_345.Y VPWR 0.37003f
C7416 a_13288_13814# a_13288_13098# 0.01275f
C7417 sg13cmos5l_mux2_1_0.X sg13cmos5l_inv_1_129.A 0.66272f
C7418 sg13cmos5l_inv_1_724.Y VPWR 0.50941f
C7419 sg13cmos5l_inv_1_828.Y sg13cmos5l_inv_1_779.A 0.05083f
C7420 sg13cmos5l_inv_1_12.Y sg13cmos5l_inv_1_22.A 0.0304f
C7421 sg13cmos5l_inv_1_168.A osc_tap[2] 0.01186f
C7422 sg13cmos5l_inv_1_925.Y VPWR 0.48671f
C7423 sg13cmos5l_buf_1_8.A a_14360_11776# 0.05814f
C7424 sg13cmos5l_inv_1_505.Y sg13cmos5l_inv_1_944.Y 0.04363f
C7425 a_9536_7766# VPWR 0.07693f
C7426 sg13cmos5l_inv_1_227.A sg13cmos5l_inv_1_185.A 0.13944f
C7427 a_15201_15588# sg13cmos5l_mux4_1_11.A3 0.20762f
C7428 sg13cmos5l_inv_1_757.Y VPWR 0.42217f
C7429 sg13cmos5l_inv_1_407.Y VPWR 0.42451f
C7430 a_7582_15994# a_8309_16307# 0.01228f
C7431 sg13cmos5l_inv_1_553.Y sg13cmos5l_inv_1_544.Y 0.13609f
C7432 sg13cmos5l_inv_1_991.A VPWR 0.7342f
C7433 sg13cmos5l_mux4_1_5.S0 sg13cmos5l_inv_1_366.A 0.07549f
C7434 sg13cmos5l_mux4_1_5.S0 sg13cmos5l_inv_1_422.A 0.02315f
C7435 sg13cmos5l_inv_1_804.A a_12136_17634# 0.02334f
C7436 sg13cmos5l_buf_1_10.A sg13cmos5l_inv_1_418.Y 0.25956f
C7437 sg13cmos5l_inv_1_606.A sg13cmos5l_inv_1_770.A 0.0121f
C7438 sg13cmos5l_inv_1_606.Y sg13cmos5l_inv_1_608.A 0.13132f
C7439 sg13cmos5l_inv_1_986.Y VPWR 0.33884f
C7440 sg13cmos5l_inv_1_525.A sg13cmos5l_buf_1_8.A 0.05143f
C7441 sg13cmos5l_inv_1_762.Y a_14027_11654# 0.02875f
C7442 sg13cmos5l_inv_1_144.Y sg13cmos5l_inv_1_217.A 0.01571f
C7443 sg13cmos5l_inv_1_311.A VPWR 0.41334f
C7444 sg13cmos5l_inv_1_13.Y VPWR 0.42458f
C7445 sg13cmos5l_inv_1_926.Y sg13cmos5l_inv_1_499.Y 0.21399f
C7446 sg13cmos5l_inv_1_571.Y VPWR 0.41805f
C7447 sg13cmos5l_inv_1_523.Y sg13cmos5l_inv_1_521.Y 0.1988f
C7448 sg13cmos5l_inv_1_443.Y sg13cmos5l_inv_1_448.Y 0.18584f
C7449 sg13cmos5l_inv_1_38.Y sg13cmos5l_inv_1_31.A 0.05736f
C7450 a_2632_10790# a_2816_10790# 0.11523f
C7451 sg13cmos5l_buf_1_8.A VPWR 8.80718f
C7452 sg13cmos5l_mux2_1_3.S a_9659_7736# 0.18589f
C7453 a_15181_3418# VPWR 0.12248f
C7454 sg13cmos5l_buf_1_9.A a_13607_14482# 0.5545f
C7455 sg13cmos5l_inv_1_179.A sg13cmos5l_inv_1_175.A 0.01109f
C7456 sg13cmos5l_buf_1_18.A a_18088_12302# 0.06129f
C7457 sg13cmos5l_mux4_1_12.A1 sg13cmos5l_mux4_1_11.A2 0.4182f
C7458 a_18764_12180# a_19048_12302# 0.01225f
C7459 sg13cmos5l_inv_1_581.A VPWR 0.4344f
C7460 sg13cmos5l_inv_1_503.Y sg13cmos5l_inv_1_504.A 0.0485f
C7461 sg13cmos5l_inv_1_913.A VPWR 0.40633f
C7462 sg13cmos5l_inv_1_688.A sg13cmos5l_inv_1_592.Y 0.04055f
C7463 sg13cmos5l_inv_1_140.Y sg13cmos5l_inv_1_129.Y 0.7494f
C7464 sg13cmos5l_inv_1_136.Y sg13cmos5l_inv_1_138.Y 0.2163f
C7465 sg13cmos5l_inv_1_841.Y sg13cmos5l_inv_1_843.Y 0.12106f
C7466 a_11360_3230# VPWR 0.06786f
C7467 sg13cmos5l_nor3_1_0.Y sg13cmos5l_mux2_1_4.X 0.12958f
C7468 sg13cmos5l_inv_1_53.Y VPWR 0.52316f
C7469 a_4475_13008# sg13cmos5l_a22oi_1_0.B1 0.01611f
C7470 a_4798_12970# a_4975_13264# 0.01068f
C7471 sg13cmos5l_inv_1_688.A sg13cmos5l_inv_1_553.A 0.10233f
C7472 sg13cmos5l_inv_1_576.A sg13cmos5l_inv_1_535.A 0.03307f
C7473 sg13cmos5l_a21oi_1_0.B1 sg13cmos5l_inv_1_681.Y 0.13305f
C7474 sg13cmos5l_inv_1_66.Y sg13cmos5l_inv_1_73.A 0.01926f
C7475 a_8327_6558# a_8551_6219# 0.01074f
C7476 sg13cmos5l_inv_1_584.A sg13cmos5l_mux4_1_10.A3 0.03748f
C7477 sg13cmos5l_inv_1_412.A sg13cmos5l_inv_1_462.Y 0.01022f
C7478 sg13cmos5l_inv_1_82.Y sg13cmos5l_inv_1_102.Y 0.07919f
C7479 sg13cmos5l_inv_1_771.A a_12808_18350# 0.02436f
C7480 sg13cmos5l_nor3_1_2.B a_9160_11586# 0.0229f
C7481 sg13cmos5l_inv_1_481.Y a_6464_12302# 0.03508f
C7482 sg13cmos5l_inv_1_633.A VPWR 0.4031f
C7483 sg13cmos5l_inv_1_773.Y VPWR 0.47699f
C7484 sg13cmos5l_inv_1_235.A sg13cmos5l_inv_1_99.Y 0.01061f
C7485 sg13cmos5l_mux2_1_3.A0 sg13cmos5l_inv_1_118.A 0.74001f
C7486 sg13cmos5l_buf_1_9.A sg13cmos5l_inv_1_411.Y 0.06238f
C7487 a_5320_18350# VPWR 0.13489f
C7488 sg13cmos5l_mux4_1_14.A1 sg13cmos5l_mux4_1_13.A0 0.55074f
C7489 sg13cmos5l_mux4_1_4.A2 sg13cmos5l_inv_1_971.Y 0.21549f
C7490 sg13cmos5l_inv_1_970.A a_5992_9278# 0.02104f
C7491 sg13cmos5l_inv_1_901.Y VPWR 0.42576f
C7492 sg13cmos5l_inv_1_961.Y sg13cmos5l_inv_1_156.Y 0.01384f
C7493 sg13cmos5l_mux4_1_5.S1 sg13cmos5l_inv_1_324.Y 0.05439f
C7494 a_4556_3858# VPWR 0.3148f
C7495 sg13cmos5l_mux2_1_4.S a_15637_8028# 0.04694f
C7496 sg13cmos5l_inv_1_186.Y osc_tap[1] 0.10395f
C7497 sg13cmos5l_inv_1_576.A sg13cmos5l_inv_1_565.Y 1.6837f
C7498 sg13cmos5l_inv_1_535.Y a_3623_15994# 0.02865f
C7499 sg13cmos5l_inv_1_884.Y a_12896_15326# 0.03646f
C7500 sg13cmos5l_inv_1_61.Y sg13cmos5l_inv_1_66.A 0.02672f
C7501 sg13cmos5l_inv_1_310.Y a_3304_1718# 0.03352f
C7502 sg13cmos5l_buf_1_17.X sg13cmos5l_inv_1_720.Y 0.05412f
C7503 sg13cmos5l_inv_1_571.Y sg13cmos5l_inv_1_572.A 0.01258f
C7504 sg13cmos5l_inv_1_798.Y a_13472_16122# 0.04569f
C7505 sg13cmos5l_inv_1_37.Y sg13cmos5l_inv_1_49.A 0.0907f
C7506 sg13cmos5l_inv_1_84.A sg13cmos5l_inv_1_84.Y 0.2026f
C7507 sg13cmos5l_inv_1_168.A VPWR 0.35697f
C7508 sg13cmos5l_inv_1_855.A sg13cmos5l_inv_1_846.Y 0.02913f
C7509 sg13cmos5l_inv_1_888.Y VPWR 0.40246f
C7510 sg13cmos5l_inv_1_959.A sg13cmos5l_inv_1_112.Y 0.10356f
C7511 sg13cmos5l_mux4_1_5.S1 sg13cmos5l_inv_1_237.Y 0.15309f
C7512 sg13cmos5l_inv_1_707.Y sg13cmos5l_mux4_1_12.A1 0.01342f
C7513 sg13cmos5l_inv_1_114.A VPWR 0.65754f
C7514 sg13cmos5l_inv_1_599.Y sg13cmos5l_inv_1_589.A 0.04391f
C7515 sg13cmos5l_inv_1_332.A sg13cmos5l_inv_1_298.Y 0.02353f
C7516 sg13cmos5l_inv_1_295.Y sg13cmos5l_inv_1_298.A 0.45507f
C7517 sg13cmos5l_inv_1_804.A sg13cmos5l_inv_1_794.A 0.02406f
C7518 a_9260_9906# a_9544_10074# 0.01225f
C7519 sg13cmos5l_inv_1_31.Y sg13cmos5l_inv_1_42.A 0.03238f
C7520 sg13cmos5l_inv_1_589.A sg13cmos5l_inv_1_589.Y 0.30678f
C7521 sg13cmos5l_inv_1_749.A sg13cmos5l_inv_1_751.A 0.20065f
C7522 sg13cmos5l_buf_1_12.X sg13cmos5l_mux4_1_5.S1 0.0696f
C7523 sg13cmos5l_inv_1_240.A VPWR 0.42176f
C7524 sg13cmos5l_a21oi_1_0.B1 sg13cmos5l_inv_1_677.A 0.02802f
C7525 a_3934_8070# a_3847_7731# 0.02548f
C7526 a_800_16838# VPWR 0.06734f
C7527 sg13cmos5l_buf_1_10.A sg13cmos5l_inv_1_450.Y 0.18472f
C7528 sg13cmos5l_inv_1_70.A sg13cmos5l_inv_1_66.A 0.01017f
C7529 sg13cmos5l_inv_1_668.A a_808_13814# 0.03601f
C7530 sg13cmos5l_inv_1_111.Y sg13cmos5l_inv_1_128.Y 0.242f
C7531 sg13cmos5l_inv_1_459.Y VPWR 0.42519f
C7532 sg13cmos5l_mux4_1_7.A1 sg13cmos5l_inv_1_496.A 0.01594f
C7533 sg13cmos5l_inv_1_642.Y sg13cmos5l_inv_1_642.A 0.12159f
C7534 sg13cmos5l_inv_1_283.A sg13cmos5l_inv_1_417.Y 0.03952f
C7535 sg13cmos5l_inv_1_317.Y sg13cmos5l_inv_1_322.A 0.06737f
C7536 a_13918_3898# a_14422_3898# 0.97548f
C7537 sg13cmos5l_inv_1_237.Y sg13cmos5l_inv_1_306.A 0.53892f
C7538 a_14989_3904# VPWR 0.12172f
C7539 sg13cmos5l_inv_1_666.Y sg13cmos5l_mux4_1_9.A0 0.1871f
C7540 sg13cmos5l_inv_1_737.A sg13cmos5l_inv_1_738.Y 0.23383f
C7541 a_6664_13814# VPWR 0.13949f
C7542 sg13cmos5l_inv_1_714.A sg13cmos5l_inv_1_713.A 0.02496f
C7543 sg13cmos5l_inv_1_712.A sg13cmos5l_inv_1_729.Y 0.01436f
C7544 sg13cmos5l_inv_1_216.Y sg13cmos5l_inv_1_102.Y 0.05224f
C7545 sg13cmos5l_inv_1_1002.A sg13cmos5l_inv_1_959.A 0.01823f
C7546 sg13cmos5l_inv_1_722.Y sg13cmos5l_inv_1_730.Y 0.02527f
C7547 sg13cmos5l_inv_1_702.Y sg13cmos5l_inv_1_699.Y 0.54739f
C7548 sg13cmos5l_inv_1_173.Y sg13cmos5l_inv_1_106.A 0.11229f
C7549 sg13cmos5l_inv_1_542.A sg13cmos5l_inv_1_541.Y 0.07288f
C7550 sg13cmos5l_inv_1_369.A VPWR 0.4079f
C7551 sg13cmos5l_inv_1_420.A VPWR 0.44516f
C7552 sg13cmos5l_inv_1_816.Y VPWR 0.42341f
C7553 sg13cmos5l_inv_1_76.A sg13cmos5l_inv_1_88.Y 0.01941f
C7554 sg13cmos5l_inv_1_938.A sg13cmos5l_inv_1_937.Y 0.20065f
C7555 sg13cmos5l_mux4_1_11.A1 sg13cmos5l_mux4_1_12.A1 0.03646f
C7556 sg13cmos5l_inv_1_609.A sg13cmos5l_inv_1_630.A 0.20866f
C7557 sg13cmos5l_inv_1_637.A sg13cmos5l_mux4_1_7.A1 0.01712f
C7558 sg13cmos5l_inv_1_411.A VPWR 0.42541f
C7559 sg13cmos5l_inv_1_580.A VPWR 0.51992f
C7560 sg13cmos5l_inv_1_260.A VPWR 0.47062f
C7561 sg13cmos5l_mux4_1_0.A0 sg13cmos5l_inv_1_171.A 0.01903f
C7562 sg13cmos5l_inv_1_267.Y sg13cmos5l_inv_1_433.A 0.22197f
C7563 sg13cmos5l_mux2_1_4.S sg13cmos5l_inv_1_113.Y 0.09152f
C7564 sg13cmos5l_a22oi_1_0.A1 a_8192_12302# 0.03429f
C7565 sg13cmos5l_buf_1_9.A a_14710_15630# 0.0264f
C7566 sg13cmos5l_inv_1_248.A sg13cmos5l_inv_1_427.A 0.01061f
C7567 sg13cmos5l_inv_1_283.A sg13cmos5l_inv_1_433.Y 0.10601f
C7568 sg13cmos5l_inv_1_344.Y sg13cmos5l_inv_1_416.Y 0.12273f
C7569 sg13cmos5l_inv_1_268.A sg13cmos5l_inv_1_276.A 0.11322f
C7570 sg13cmos5l_buf_1_9.A sg13cmos5l_inv_1_619.A 0.01343f
C7571 sg13cmos5l_inv_1_28.A sg13cmos5l_inv_1_37.Y 0.18584f
C7572 sg13cmos5l_inv_1_45.Y sg13cmos5l_inv_1_16.A 0.15777f
C7573 sg13cmos5l_inv_1_337.A a_3304_3230# 0.03352f
C7574 sg13cmos5l_inv_1_158.Y VPWR 0.42886f
C7575 sg13cmos5l_buf_1_8.A sg13cmos5l_inv_1_448.A 0.0286f
C7576 sg13cmos5l_inv_1_447.A sg13cmos5l_inv_1_446.A 0.15191f
C7577 sg13cmos5l_inv_1_100.A sg13cmos5l_mux4_1_2.A2 0.02745f
C7578 sg13cmos5l_inv_1_345.A VPWR 0.60227f
C7579 a_14913_3940# a_15662_4084# 0.03454f
C7580 sg13cmos5l_inv_1_823.Y sg13cmos5l_inv_1_852.Y 0.04062f
C7581 sg13cmos5l_inv_1_980.A sg13cmos5l_mux2_1_1.X 0.04882f
C7582 sg13cmos5l_inv_1_779.Y sg13cmos5l_mux4_1_14.A1 0.07744f
C7583 sg13cmos5l_buf_1_10.A sg13cmos5l_inv_1_411.Y 0.02724f
C7584 sg13cmos5l_nor3_1_2.B a_7414_12970# 0.0179f
C7585 sg13cmos5l_inv_1_725.Y sg13cmos5l_inv_1_724.Y 0.1118f
C7586 a_10592_18350# VPWR 0.06567f
C7587 a_11176_3230# a_11360_3230# 0.11523f
C7588 sg13cmos5l_buf_1_9.A sg13cmos5l_mux4_1_7.A3 0.12058f
C7589 sg13cmos5l_inv_1_692.A sg13cmos5l_inv_1_644.A 0.20862f
C7590 a_14827_11673# a_15292_11458# 0.0289f
C7591 sg13cmos5l_inv_1_988.A sg13cmos5l_mux4_1_15.A2 0.15375f
C7592 sg13cmos5l_nor3_1_2.B a_9360_11832# 0.03333f
C7593 sg13cmos5l_inv_1_731.Y VPWR 0.42654f
C7594 sg13cmos5l_inv_1_407.A VPWR 0.42608f
C7595 sg13cmos5l_inv_1_974.Y VPWR 0.42909f
C7596 sg13cmos5l_inv_1_804.A sg13cmos5l_inv_1_806.Y 0.06925f
C7597 sg13cmos5l_mux2_1_4.S sg13cmos5l_inv_1_448.Y 0.21358f
C7598 sg13cmos5l_inv_1_36.Y a_18272_3230# 0.04632f
C7599 sg13cmos5l_buf_1_10.A sg13cmos5l_inv_1_433.A 0.62542f
C7600 sg13cmos5l_inv_1_606.A sg13cmos5l_inv_1_608.A 0.19614f
C7601 sg13cmos5l_inv_1_994.Y VPWR 0.42579f
C7602 sg13cmos5l_inv_1_181.Y sg13cmos5l_inv_1_217.A 0.08228f
C7603 sg13cmos5l_inv_1_312.Y VPWR 0.49666f
C7604 sg13cmos5l_inv_1_20.Y VPWR 0.35788f
C7605 sg13cmos5l_buf_1_12.X a_808_6956# 0.29139f
C7606 sg13cmos5l_inv_1_141.A sg13cmos5l_buf_1_6.A 0.02372f
C7607 sg13cmos5l_inv_1_549.A VPWR 0.42442f
C7608 a_15608_7680# a_16075_7649# 0.49917f
C7609 sg13cmos5l_mux4_1_15.A3 sg13cmos5l_inv_1_701.A 0.11259f
C7610 a_13607_14482# a_13472_14610# 0.01143f
C7611 sg13cmos5l_inv_1_274.Y sg13cmos5l_inv_1_1011.A 0.77548f
C7612 sg13cmos5l_inv_1_177.Y a_17896_7050# 0.01986f
C7613 sg13cmos5l_mux4_1_12.A1 sg13cmos5l_inv_1_714.A 0.01181f
C7614 a_8576_10074# VPWR 0.08148f
C7615 sg13cmos5l_inv_1_297.Y sg13cmos5l_inv_1_304.A 0.04726f
C7616 a_13472_18350# VPWR 0.06615f
C7617 sg13cmos5l_inv_1_382.A sg13cmos5l_inv_1_414.A 0.0225f
C7618 sg13cmos5l_buf_1_9.A sg13cmos5l_inv_1_500.Y 0.01959f
C7619 sg13cmos5l_inv_1_169.Y sg13cmos5l_inv_1_130.A 0.03987f
C7620 sg13cmos5l_buf_1_9.A sg13cmos5l_mux4_1_5.S1 0.28728f
C7621 sg13cmos5l_mux2_1_3.S sg13cmos5l_mux2_1_3.A0 0.02865f
C7622 sg13cmos5l_buf_1_9.A sg13cmos5l_inv_1_889.A 0.5456f
C7623 sg13cmos5l_inv_1_915.A VPWR 0.40117f
C7624 sg13cmos5l_inv_1_583.A VPWR 0.42626f
C7625 a_17416_11586# VPWR 0.13851f
C7626 a_9736_9278# VPWR 0.13077f
C7627 a_4072_3932# a_4556_3858# 0.03472f
C7628 sg13cmos5l_inv_1_707.Y sg13cmos5l_inv_1_706.A 0.03264f
C7629 sg13cmos5l_inv_1_140.Y sg13cmos5l_inv_1_138.Y 0.27363f
C7630 sg13cmos5l_inv_1_871.Y sg13cmos5l_inv_1_843.Y 0.05345f
C7631 sg13cmos5l_inv_1_836.Y a_16840_17634# 0.02295f
C7632 sg13cmos5l_buf_1_9.A sg13cmos5l_a21oi_1_0.B1 0.0341f
C7633 sg13cmos5l_inv_1_48.Y VPWR 0.62144f
C7634 sg13cmos5l_mux4_1_9.X sg13cmos5l_a22oi_1_0.B1 0.20538f
C7635 sg13cmos5l_inv_1_67.A sg13cmos5l_inv_1_73.A 0.01087f
C7636 a_5992_9278# VPWR 0.13773f
C7637 sg13cmos5l_buf_1_12.X sg13cmos5l_inv_1_439.A 0.02937f
C7638 sg13cmos5l_inv_1_66.Y sg13cmos5l_inv_1_68.A 0.02456f
C7639 sg13cmos5l_nor3_1_2.B invsel[4] 0.04365f
C7640 sg13cmos5l_inv_1_454.Y sg13cmos5l_inv_1_416.A 0.01054f
C7641 sg13cmos5l_mux4_1_5.S0 sg13cmos5l_inv_1_925.Y 0.17419f
C7642 a_5408_4742# VPWR 0.08074f
C7643 sg13cmos5l_inv_1_568.Y sg13cmos5l_inv_1_533.Y 0.24449f
C7644 sg13cmos5l_inv_1_771.A sg13cmos5l_inv_1_782.A 0.15663f
C7645 sg13cmos5l_inv_1_771.Y sg13cmos5l_inv_1_775.A 0.1285f
C7646 sg13cmos5l_inv_1_632.A VPWR 0.42563f
C7647 sg13cmos5l_inv_1_981.Y sg13cmos5l_inv_1_945.A 0.21375f
C7648 sg13cmos5l_inv_1_790.Y VPWR 0.3618f
C7649 sg13cmos5l_inv_1_92.A a_10496_3230# 0.04504f
C7650 sg13cmos5l_inv_1_892.A a_16456_14610# 0.01366f
C7651 sg13cmos5l_buf_1_9.A sg13cmos5l_inv_1_357.A 0.05581f
C7652 sg13cmos5l_inv_1_602.Y VPWR 0.42411f
C7653 sg13cmos5l_inv_1_731.A sg13cmos5l_inv_1_953.Y 0.02602f
C7654 a_18856_7680# sg13cmos5l_inv_1_176.A 0.01481f
C7655 sg13cmos5l_mux2_1_0.X sg13cmos5l_inv_1_110.A 0.03071f
C7656 sg13cmos5l_inv_1_734.Y VPWR 0.42545f
C7657 sg13cmos5l_inv_1_639.A sg13cmos5l_inv_1_655.Y 0.02439f
C7658 sg13cmos5l_a21oi_1_0.B1 sg13cmos5l_inv_1_681.A 0.15771f
C7659 sg13cmos5l_inv_1_332.A sg13cmos5l_inv_1_295.Y 0.27565f
C7660 sg13cmos5l_mux4_1_15.A2 a_14494_9582# 0.10871f
C7661 sg13cmos5l_inv_1_576.A sg13cmos5l_inv_1_575.Y 0.07201f
C7662 sg13cmos5l_inv_1_884.Y sg13cmos5l_inv_1_883.A 0.84287f
C7663 sg13cmos5l_inv_1_549.A sg13cmos5l_inv_1_572.A 0.02673f
C7664 sg13cmos5l_inv_1_532.Y a_3934_12606# 0.18296f
C7665 sg13cmos5l_inv_1_571.Y sg13cmos5l_inv_1_571.A 0.11589f
C7666 sg13cmos5l_mux4_1_14.A1 sg13cmos5l_mux2_1_4.S 0.02097f
C7667 sg13cmos5l_mux4_1_5.S1 sg13cmos5l_inv_1_113.A 3.0262f
C7668 sg13cmos5l_inv_1_72.Y sg13cmos5l_inv_1_84.Y 0.03099f
C7669 sg13cmos5l_inv_1_876.A VPWR 0.35038f
C7670 sg13cmos5l_inv_1_959.A sg13cmos5l_inv_1_978.A 0.02425f
C7671 sg13cmos5l_inv_1_815.Y sg13cmos5l_inv_1_816.Y 0.03778f
C7672 sg13cmos5l_inv_1_875.Y sg13cmos5l_inv_1_816.A 0.01106f
C7673 a_10437_10240# VPWR 0.01365f
C7674 sg13cmos5l_inv_1_332.A sg13cmos5l_inv_1_298.A 0.09034f
C7675 sg13cmos5l_inv_1_947.A sg13cmos5l_inv_1_507.Y 0.10174f
C7676 sg13cmos5l_inv_1_31.Y sg13cmos5l_inv_1_31.A 0.23332f
C7677 sg13cmos5l_inv_1_589.A sg13cmos5l_inv_1_535.Y 0.01037f
C7678 sg13cmos5l_inv_1_240.Y VPWR 0.423f
C7679 sg13cmos5l_a21oi_1_0.B1 sg13cmos5l_inv_1_507.A 0.02107f
C7680 sg13cmos5l_inv_1_392.A sg13cmos5l_inv_1_391.Y 0.09475f
C7681 sg13cmos5l_inv_1_313.Y sg13cmos5l_inv_1_308.Y 0.01772f
C7682 sg13cmos5l_inv_1_217.A sg13cmos5l_inv_1_207.A 0.05808f
C7683 sg13cmos5l_mux4_1_5.S0 sg13cmos5l_buf_1_8.A 1.40817f
C7684 sg13cmos5l_inv_1_668.A sg13cmos5l_inv_1_668.Y 0.27489f
C7685 sg13cmos5l_inv_1_459.A VPWR 0.44749f
C7686 sg13cmos5l_inv_1_826.Y sg13cmos5l_inv_1_819.Y 0.2129f
C7687 sg13cmos5l_buf_1_0.A sg13cmos5l_inv_1_83.Y 0.16926f
C7688 sg13cmos5l_inv_1_642.Y sg13cmos5l_inv_1_641.A 0.02617f
C7689 sg13cmos5l_inv_1_283.A sg13cmos5l_inv_1_452.Y 0.01321f
C7690 sg13cmos5l_inv_1_237.Y sg13cmos5l_inv_1_304.A 0.23125f
C7691 sg13cmos5l_inv_1_384.Y VPWR 0.40425f
C7692 sg13cmos5l_inv_1_998.Y sg13cmos5l_inv_1_738.Y 0.03895f
C7693 sg13cmos5l_inv_1_735.Y a_10880_10790# 0.03553f
C7694 sg13cmos5l_inv_1_648.Y VPWR 0.43344f
C7695 sg13cmos5l_inv_1_152.Y sg13cmos5l_inv_1_181.Y 0.21407f
C7696 sg13cmos5l_inv_1_124.A sg13cmos5l_inv_1_124.Y 0.09424f
C7697 sg13cmos5l_inv_1_76.A VPWR 0.75176f
C7698 sg13cmos5l_inv_1_85.A sg13cmos5l_inv_1_103.A 0.01133f
C7699 sg13cmos5l_inv_1_542.A sg13cmos5l_inv_1_541.A 0.29099f
C7700 sg13cmos5l_inv_1_774.Y sg13cmos5l_mux4_1_8.A0 0.09834f
C7701 sg13cmos5l_inv_1_722.Y sg13cmos5l_inv_1_699.Y 0.12117f
C7702 sg13cmos5l_inv_1_215.Y sg13cmos5l_inv_1_106.A 0.23046f
C7703 sg13cmos5l_inv_1_702.Y sg13cmos5l_inv_1_704.Y 0.12487f
C7704 sg13cmos5l_inv_1_305.Y sg13cmos5l_inv_1_336.A 0.10257f
C7705 sg13cmos5l_inv_1_680.Y sg13cmos5l_inv_1_563.A 0.26522f
C7706 sg13cmos5l_inv_1_317.Y VPWR 0.46958f
C7707 sg13cmos5l_mux2_1_2.A0 a_4475_13008# 0.05412f
C7708 sg13cmos5l_inv_1_944.Y sg13cmos5l_inv_1_997.A 0.2026f
C7709 sg13cmos5l_inv_1_973.Y sg13cmos5l_inv_1_990.A 0.04388f
C7710 a_7271_15994# a_7495_16261# 0.01074f
C7711 sg13cmos5l_inv_1_816.A VPWR 0.42782f
C7712 sg13cmos5l_inv_1_76.A sg13cmos5l_inv_1_88.A 0.26559f
C7713 sg13cmos5l_mux4_1_11.A1 sg13cmos5l_inv_1_745.A 0.01315f
C7714 sg13cmos5l_inv_1_636.A sg13cmos5l_mux4_1_7.A1 0.01289f
C7715 sg13cmos5l_inv_1_364.A VPWR 0.42263f
C7716 a_7912_11586# VPWR 0.14006f
C7717 sg13cmos5l_inv_1_834.Y a_17888_18350# 0.03646f
C7718 a_18280_18264# sg13cmos5l_inv_1_824.A 0.01443f
C7719 sg13cmos5l_mux2_1_3.S sg13cmos5l_nor3_1_1.Y 0.06741f
C7720 sg13cmos5l_mux2_1_0.X sg13cmos5l_inv_1_225.Y 0.01889f
C7721 sg13cmos5l_buf_1_10.A sg13cmos5l_mux4_1_5.S1 0.08239f
C7722 sg13cmos5l_inv_1_850.Y sg13cmos5l_mux4_1_13.A0 0.06286f
C7723 sg13cmos5l_mux2_1_4.S a_14110_3534# 0.0433f
C7724 a_13288_15326# a_13288_14610# 0.01275f
C7725 a_3304_12302# VPWR 0.14204f
C7726 a_4640_10790# VPWR 0.07835f
C7727 sg13cmos5l_mux4_1_11.A3 sg13cmos5l_inv_1_728.Y 0.03525f
C7728 sg13cmos5l_inv_1_532.Y sg13cmos5l_buf_1_8.A 0.06767f
C7729 a_18856_3932# VPWR 0.25511f
C7730 a_12896_15326# VPWR 0.12196f
C7731 sg13cmos5l_inv_1_351.A sg13cmos5l_inv_1_370.A 0.07149f
C7732 sg13cmos5l_inv_1_268.A sg13cmos5l_inv_1_241.Y 0.07498f
C7733 sg13cmos5l_inv_1_411.Y a_4438_8070# 0.04362f
C7734 sg13cmos5l_a21oi_1_0.B1 sg13cmos5l_buf_1_10.A 0.1144f
C7735 sg13cmos5l_inv_1_571.A a_800_16838# 0.03508f
C7736 sg13cmos5l_buf_1_9.A sg13cmos5l_inv_1_622.Y 0.01289f
C7737 sg13cmos5l_inv_1_31.Y sg13cmos5l_inv_1_37.Y 0.04086f
C7738 sg13cmos5l_inv_1_95.A a_14023_3195# 0.01228f
C7739 sg13cmos5l_inv_1_658.Y sg13cmos5l_inv_1_534.A 0.21549f
C7740 sg13cmos5l_mux2_1_4.X a_8776_5538# 0.01329f
C7741 sg13cmos5l_inv_1_169.Y VPWR 0.34668f
C7742 sg13cmos5l_or2_1_0.B a_14171_11488# 0.01454f
C7743 sg13cmos5l_inv_1_447.A sg13cmos5l_inv_1_414.A 0.18581f
C7744 sg13cmos5l_inv_1_779.A sg13cmos5l_inv_1_890.A 0.02784f
C7745 sg13cmos5l_inv_1_557.Y a_3680_17634# 0.01054f
C7746 sg13cmos5l_inv_1_89.Y a_11360_3230# 0.01069f
C7747 sg13cmos5l_inv_1_720.Y sg13cmos5l_inv_1_723.Y 0.11279f
C7748 a_18368_6254# VPWR 0.08066f
C7749 a_18856_16752# VPWR 0.25395f
C7750 sg13cmos5l_inv_1_206.Y sg13cmos5l_inv_1_184.A 0.1647f
C7751 sg13cmos5l_inv_1_445.A a_8638_6558# 0.18804f
C7752 sg13cmos5l_inv_1_322.A a_1480_4026# 0.01986f
C7753 sg13cmos5l_mux4_1_5.S0 a_6664_13814# 0.02194f
C7754 sg13cmos5l_inv_1_257.A sg13cmos5l_inv_1_260.Y 0.01945f
C7755 sg13cmos5l_inv_1_241.A sg13cmos5l_inv_1_241.Y 2.61666f
C7756 sg13cmos5l_inv_1_738.A VPWR 0.40951f
C7757 sg13cmos5l_inv_1_409.Y VPWR 0.426f
C7758 a_3304_13814# VPWR 0.13577f
C7759 sg13cmos5l_mux4_1_11.A3 sg13cmos5l_mux4_1_12.A1 0.09829f
C7760 sg13cmos5l_inv_1_326.Y a_3304_1718# 0.01986f
C7761 sg13cmos5l_inv_1_63.A sg13cmos5l_inv_1_66.A 0.14899f
C7762 sg13cmos5l_nor4_1_0.Y sg13cmos5l_o21ai_1_0.Y 0.38736f
C7763 sg13cmos5l_inv_1_974.A VPWR 0.36853f
C7764 sg13cmos5l_inv_1_655.Y sg13cmos5l_mux4_1_7.A2 0.01271f
C7765 sg13cmos5l_inv_1_862.A sg13cmos5l_inv_1_875.Y 1.08565f
C7766 a_9454_11832# VPWR 0.01332f
C7767 sg13cmos5l_inv_1_598.A sg13cmos5l_inv_1_608.A 0.0699f
C7768 sg13cmos5l_nand2_1_1.B sg13cmos5l_o21ai_1_0.Y 0.10871f
C7769 sg13cmos5l_inv_1_579.Y sg13cmos5l_inv_1_625.Y 0.09052f
C7770 sg13cmos5l_inv_1_928.A VPWR 0.42582f
C7771 a_3623_12606# a_4052_12606# 0.0289f
C7772 sg13cmos5l_inv_1_523.Y a_3934_12606# 0.12461f
C7773 sg13cmos5l_inv_1_211.Y sg13cmos5l_inv_1_217.A 0.12186f
C7774 sg13cmos5l_inv_1_828.Y sg13cmos5l_inv_1_792.Y 0.01408f
C7775 sg13cmos5l_mux4_1_5.S1 a_14998_9582# 0.0264f
C7776 sg13cmos5l_inv_1_606.Y sg13cmos5l_inv_1_608.Y 0.01725f
C7777 sg13cmos5l_inv_1_328.A VPWR 0.53937f
C7778 sg13cmos5l_inv_1_56.Y VPWR 0.3987f
C7779 sg13cmos5l_inv_1_711.Y sg13cmos5l_inv_1_887.Y 0.13014f
C7780 sg13cmos5l_a21oi_1_1.A2 sg13cmos5l_inv_1_648.Y 0.02092f
C7781 sg13cmos5l_inv_1_205.A sg13cmos5l_buf_1_6.A 0.0102f
C7782 sg13cmos5l_inv_1_545.A VPWR 0.42214f
C7783 sg13cmos5l_inv_1_411.Y a_4929_8028# 0.05334f
C7784 sg13cmos5l_inv_1_311.Y sg13cmos5l_inv_1_301.A 0.20095f
C7785 sg13cmos5l_mux2_1_4.X sg13cmos5l_inv_1_382.A 0.06217f
C7786 sg13cmos5l_mux4_1_12.A1 sg13cmos5l_inv_1_724.Y 0.19459f
C7787 sg13cmos5l_inv_1_941.A VPWR 0.46822f
C7788 sg13cmos5l_inv_1_991.A sg13cmos5l_inv_1_351.A 0.03493f
C7789 sg13cmos5l_inv_1_116.Y sg13cmos5l_inv_1_130.A 0.02164f
C7790 sg13cmos5l_buf_1_9.A sg13cmos5l_inv_1_502.Y 0.01308f
C7791 sg13cmos5l_mux2_1_3.S sg13cmos5l_mux4_1_16.X 0.05297f
C7792 sg13cmos5l_buf_1_9.A sg13cmos5l_inv_1_902.Y 0.58297f
C7793 sg13cmos5l_inv_1_179.A sg13cmos5l_inv_1_150.A 0.14384f
C7794 sg13cmos5l_inv_1_950.Y sg13cmos5l_inv_1_503.Y 0.31125f
C7795 sg13cmos5l_inv_1_912.A VPWR 0.43958f
C7796 sg13cmos5l_inv_1_875.Y sg13cmos5l_inv_1_881.A 0.07055f
C7797 sg13cmos5l_inv_1_889.A sg13cmos5l_inv_1_904.Y 0.0131f
C7798 sg13cmos5l_inv_1_236.A sg13cmos5l_inv_1_76.A 0.01061f
C7799 a_17128_13098# VPWR 0.16253f
C7800 sg13cmos5l_inv_1_319.Y sg13cmos5l_inv_1_318.Y 0.13421f
C7801 sg13cmos5l_inv_1_707.Y sg13cmos5l_inv_1_707.A 0.11746f
C7802 sg13cmos5l_inv_1_914.A sg13cmos5l_inv_1_706.A 0.0111f
C7803 sg13cmos5l_inv_1_140.Y sg13cmos5l_inv_1_136.Y 0.03727f
C7804 sg13cmos5l_inv_1_836.Y sg13cmos5l_inv_1_851.A 0.07408f
C7805 sg13cmos5l_inv_1_843.A sg13cmos5l_inv_1_843.Y 0.21557f
C7806 sg13cmos5l_inv_1_871.Y sg13cmos5l_inv_1_841.Y 0.20978f
C7807 sg13cmos5l_buf_1_19.A sg13cmos5l_inv_1_720.Y 1.23172f
C7808 a_808_15326# VPWR 0.12469f
C7809 sg13cmos5l_inv_1_12.Y VPWR 0.40828f
C7810 sg13cmos5l_inv_1_141.Y sg13cmos5l_inv_1_177.A 0.01724f
C7811 sg13cmos5l_inv_1_971.Y VPWR 0.43106f
C7812 sg13cmos5l_inv_1_66.Y sg13cmos5l_inv_1_74.A 0.05124f
C7813 sg13cmos5l_inv_1_417.Y VPWR 0.41726f
C7814 sg13cmos5l_inv_1_322.A a_3934_3534# 0.02003f
C7815 sg13cmos5l_inv_1_557.A sg13cmos5l_inv_1_533.Y 0.04502f
C7816 sg13cmos5l_inv_1_862.A VPWR 0.61089f
C7817 a_4736_2514# VPWR 0.08311f
C7818 sg13cmos5l_inv_1_771.A sg13cmos5l_inv_1_775.A 0.01356f
C7819 a_10408_18350# a_10592_18350# 0.11523f
C7820 sg13cmos5l_inv_1_787.Y sg13cmos5l_inv_1_884.Y 0.06854f
C7821 sg13cmos5l_inv_1_631.A VPWR 0.42417f
C7822 sg13cmos5l_inv_1_981.Y sg13cmos5l_inv_1_945.Y 0.0392f
C7823 sg13cmos5l_inv_1_372.A a_1184_7050# 0.03508f
C7824 sg13cmos5l_inv_1_65.Y sg13cmos5l_inv_1_945.A 0.01389f
C7825 sg13cmos5l_inv_1_791.A VPWR 0.47841f
C7826 sg13cmos5l_o21ai_1_0.B1 sg13cmos5l_inv_1_984.Y 0.02883f
C7827 sg13cmos5l_inv_1_601.Y VPWR 0.42347f
C7828 sg13cmos5l_buf_1_9.A sg13cmos5l_inv_1_356.A 0.06089f
C7829 a_10696_1718# VPWR 0.13941f
C7830 sg13cmos5l_inv_1_1007.Y sg13cmos5l_inv_1_922.A 0.02019f
C7831 sg13cmos5l_inv_1_474.Y sg13cmos5l_inv_1_925.A 0.16138f
C7832 sg13cmos5l_inv_1_171.A sg13cmos5l_inv_1_168.A 0.0103f
C7833 sg13cmos5l_mux4_1_4.A2 a_6430_8434# 0.13191f
C7834 a_3680_17634# VPWR 0.11571f
C7835 sg13cmos5l_mux4_1_5.S0 sg13cmos5l_inv_1_407.A 0.01474f
C7836 a_13895_15630# a_14132_15630# 0.01012f
C7837 sg13cmos5l_a21oi_1_0.B1 sg13cmos5l_inv_1_510.Y 0.60034f
C7838 sg13cmos5l_inv_1_689.A sg13cmos5l_inv_1_685.Y 0.04117f
C7839 a_7501_8440# a_7425_8476# 0.2611f
C7840 a_6430_8434# a_6637_8701# 0.01967f
C7841 sg13cmos5l_inv_1_734.A VPWR 0.42685f
C7842 a_8104_6254# VPWR 0.13836f
C7843 sg13cmos5l_inv_1_739.A sg13cmos5l_inv_1_758.A 0.18681f
C7844 sg13cmos5l_mux4_1_8.A1 sg13cmos5l_inv_1_619.A 0.03507f
C7845 sg13cmos5l_inv_1_72.Y sg13cmos5l_inv_1_65.A 0.02323f
C7846 sg13cmos5l_inv_1_1010.Y a_10304_2514# 0.05751f
C7847 sg13cmos5l_inv_1_576.A sg13cmos5l_inv_1_566.A 0.08537f
C7848 sg13cmos5l_inv_1_553.Y sg13cmos5l_mux4_1_10.A2 0.06756f
C7849 sg13cmos5l_inv_1_747.Y a_13607_12606# 0.21907f
C7850 sg13cmos5l_mux4_1_13.A3 sg13cmos5l_inv_1_875.A 0.02824f
C7851 sg13cmos5l_inv_1_916.A sg13cmos5l_inv_1_883.A 0.02152f
C7852 a_8200_10790# VPWR 0.14202f
C7853 sg13cmos5l_inv_1_507.A sg13cmos5l_inv_1_502.Y 0.0774f
C7854 sg13cmos5l_buf_1_8.A sg13cmos5l_inv_1_523.Y 0.05948f
C7855 sg13cmos5l_inv_1_72.Y sg13cmos5l_inv_1_84.A 0.24901f
C7856 sg13cmos5l_inv_1_114.Y sg13cmos5l_inv_1_113.A 0.16293f
C7857 sg13cmos5l_inv_1_815.Y sg13cmos5l_inv_1_816.A 0.02829f
C7858 sg13cmos5l_inv_1_863.Y sg13cmos5l_inv_1_845.Y 0.02913f
C7859 sg13cmos5l_inv_1_875.Y sg13cmos5l_inv_1_815.A 0.17056f
C7860 sg13cmos5l_inv_1_881.A VPWR 0.36647f
C7861 sg13cmos5l_buf_1_8.A sg13cmos5l_inv_1_100.A 0.02748f
C7862 sg13cmos5l_inv_1_594.Y sg13cmos5l_inv_1_589.A 0.12137f
C7863 sg13cmos5l_inv_1_31.Y sg13cmos5l_inv_1_38.Y 0.0334f
C7864 sg13cmos5l_mux4_1_5.S1 sg13cmos5l_inv_1_130.Y 0.02832f
C7865 sg13cmos5l_inv_1_759.A sg13cmos5l_inv_1_749.A 0.20065f
C7866 sg13cmos5l_inv_1_748.Y sg13cmos5l_inv_1_756.Y 0.20065f
C7867 sg13cmos5l_inv_1_243.A VPWR 0.42336f
C7868 sg13cmos5l_a21oi_1_0.B1 sg13cmos5l_inv_1_518.Y 0.06831f
C7869 a_12808_1718# a_12808_1002# 0.01275f
C7870 sg13cmos5l_inv_1_392.A sg13cmos5l_inv_1_389.Y 0.22916f
C7871 sg13cmos5l_inv_1_810.Y sg13cmos5l_inv_1_792.Y 0.01258f
C7872 sg13cmos5l_buf_1_10.A sg13cmos5l_inv_1_439.A 0.04875f
C7873 a_6599_12970# a_6376_13098# 0.02107f
C7874 sg13cmos5l_inv_1_535.Y sg13cmos5l_inv_1_562.A 0.31127f
C7875 sg13cmos5l_inv_1_433.Y VPWR 0.35598f
C7876 sg13cmos5l_mux2_1_3.S sg13cmos5l_inv_1_400.Y 0.01386f
C7877 sg13cmos5l_inv_1_283.A sg13cmos5l_inv_1_266.Y 0.15943f
C7878 a_13472_4026# VPWR 0.07144f
C7879 sg13cmos5l_inv_1_394.Y VPWR 0.43158f
C7880 sg13cmos5l_inv_1_735.Y sg13cmos5l_inv_1_738.Y 0.16564f
C7881 sg13cmos5l_inv_1_649.Y VPWR 0.42724f
C7882 sg13cmos5l_inv_1_929.A sg13cmos5l_inv_1_956.Y 0.01506f
C7883 sg13cmos5l_inv_1_152.Y sg13cmos5l_inv_1_211.Y 0.17759f
C7884 sg13cmos5l_inv_1_724.Y sg13cmos5l_inv_1_729.Y 0.0123f
C7885 sg13cmos5l_inv_1_0.Y a_18088_1718# 0.02074f
C7886 sg13cmos5l_mux4_1_5.S0 a_5992_9278# 0.01814f
C7887 sg13cmos5l_inv_1_478.Y sg13cmos5l_inv_1_481.Y 0.02018f
C7888 sg13cmos5l_inv_1_77.Y VPWR 0.46831f
C7889 sg13cmos5l_mux4_1_12.A3 a_13288_13098# 0.05166f
C7890 sg13cmos5l_inv_1_105.Y sg13cmos5l_inv_1_106.A 0.08346f
C7891 sg13cmos5l_inv_1_770.A sg13cmos5l_mux4_1_8.A0 0.19566f
C7892 sg13cmos5l_inv_1_542.A sg13cmos5l_inv_1_571.Y 0.03674f
C7893 sg13cmos5l_inv_1_215.Y sg13cmos5l_inv_1_105.A 0.1659f
C7894 sg13cmos5l_inv_1_702.Y sg13cmos5l_mux4_1_15.X 0.02993f
C7895 sg13cmos5l_inv_1_722.Y sg13cmos5l_inv_1_704.Y 0.03228f
C7896 sg13cmos5l_buf_1_9.A sg13cmos5l_a22oi_1_0.A1 0.02063f
C7897 sg13cmos5l_inv_1_2.A a_16936_1718# 0.03631f
C7898 sg13cmos5l_nand2_1_1.B sg13cmos5l_inv_1_1007.Y 0.06305f
C7899 sg13cmos5l_mux4_1_5.S1 a_4438_8070# 0.03458f
C7900 sg13cmos5l_mux2_1_2.A0 sg13cmos5l_mux4_1_9.X 0.42024f
C7901 sg13cmos5l_inv_1_122.A sg13cmos5l_inv_1_135.Y 0.02913f
C7902 sg13cmos5l_inv_1_120.Y sg13cmos5l_inv_1_134.Y 0.01104f
C7903 sg13cmos5l_mux2_1_4.X sg13cmos5l_inv_1_274.Y 0.01643f
C7904 sg13cmos5l_inv_1_815.A VPWR 0.46335f
C7905 sg13cmos5l_inv_1_888.Y sg13cmos5l_mux4_1_12.A1 0.02899f
C7906 sg13cmos5l_inv_1_610.A sg13cmos5l_inv_1_609.A 0.21232f
C7907 sg13cmos5l_inv_1_368.Y VPWR 0.41164f
C7908 sg13cmos5l_a21oi_1_0.Y VPWR 0.22707f
C7909 sg13cmos5l_inv_1_69.A a_6952_2514# 0.01776f
C7910 sg13cmos5l_inv_1_834.Y sg13cmos5l_inv_1_824.A 0.22826f
C7911 a_15637_8028# a_16304_7685# 0.01929f
C7912 sg13cmos5l_mux2_1_3.S sg13cmos5l_nor3_1_0.Y 0.3813f
C7913 sg13cmos5l_inv_1_582.A a_8288_15326# 0.01467f
C7914 sg13cmos5l_inv_1_481.Y VPWR 0.48285f
C7915 sg13cmos5l_inv_1_494.Y VPWR 0.42949f
C7916 sg13cmos5l_mux2_1_4.S sg13cmos5l_inv_1_124.A 0.68332f
C7917 sg13cmos5l_mux4_1_11.A3 sg13cmos5l_inv_1_706.A 0.07893f
C7918 a_13288_18350# a_13472_18350# 0.11523f
C7919 sg13cmos5l_inv_1_69.A sg13cmos5l_inv_1_258.A 0.04478f
C7920 sg13cmos5l_inv_1_305.Y sg13cmos5l_inv_1_450.Y 0.04119f
C7921 sg13cmos5l_inv_1_883.A VPWR 0.84028f
C7922 sg13cmos5l_buf_1_2.X VPWR 0.22466f
C7923 sg13cmos5l_inv_1_883.Y sg13cmos5l_inv_1_882.A 0.09861f
C7924 sg13cmos5l_mux2_1_3.S a_8123_8472# 0.19657f
C7925 sg13cmos5l_inv_1_351.Y sg13cmos5l_inv_1_370.A 0.23056f
C7926 sg13cmos5l_inv_1_37.A a_18088_1718# 0.01065f
C7927 sg13cmos5l_inv_1_283.A sg13cmos5l_inv_1_427.A 0.07926f
C7928 a_12808_11586# a_12808_10790# 0.01095f
C7929 sg13cmos5l_inv_1_669.A a_3488_13814# 0.03508f
C7930 sg13cmos5l_buf_1_9.A sg13cmos5l_inv_1_623.Y 0.01425f
C7931 sg13cmos5l_mux4_1_2.A2 a_17120_4026# 0.01173f
C7932 sg13cmos5l_inv_1_31.Y sg13cmos5l_inv_1_28.A 0.01907f
C7933 sg13cmos5l_nor3_1_2.B a_14913_12564# 0.01467f
C7934 sg13cmos5l_mux2_1_4.X sg13cmos5l_inv_1_447.A 0.58215f
C7935 sg13cmos5l_inv_1_116.Y VPWR 0.41736f
C7936 sg13cmos5l_inv_1_534.A a_4936_15326# 0.05397f
C7937 sg13cmos5l_mux2_1_0.X sg13cmos5l_inv_1_122.Y 0.08524f
C7938 sg13cmos5l_inv_1_923.Y sg13cmos5l_inv_1_980.A 0.10384f
C7939 sg13cmos5l_inv_1_780.A sg13cmos5l_inv_1_779.Y 0.25973f
C7940 sg13cmos5l_inv_1_304.A sg13cmos5l_inv_1_313.Y 0.32476f
C7941 sg13cmos5l_inv_1_818.Y a_16256_15326# 0.01162f
C7942 sg13cmos5l_inv_1_711.Y sg13cmos5l_inv_1_744.Y 0.02903f
C7943 a_13288_7050# VPWR 0.12833f
C7944 sg13cmos5l_inv_1_720.Y sg13cmos5l_inv_1_723.A 0.01039f
C7945 sg13cmos5l_inv_1_186.Y VPWR 0.50725f
C7946 sg13cmos5l_inv_1_713.A a_17416_11586# 0.03352f
C7947 sg13cmos5l_inv_1_950.Y sg13cmos5l_inv_1_944.Y 0.02521f
C7948 sg13cmos5l_inv_1_690.A sg13cmos5l_inv_1_692.A 0.21202f
C7949 sg13cmos5l_inv_1_618.Y sg13cmos5l_inv_1_580.A 0.14297f
C7950 sg13cmos5l_inv_1_225.Y sg13cmos5l_inv_1_184.A 1.04267f
C7951 sg13cmos5l_inv_1_337.Y a_2248_3932# 0.02242f
C7952 a_6752_7050# VPWR 0.11946f
C7953 a_14913_12564# sg13cmos5l_mux4_1_11.A2 0.25001f
C7954 a_13288_12302# a_13472_12302# 0.11523f
C7955 sg13cmos5l_mux4_1_5.S1 a_4929_8028# 0.20228f
C7956 sg13cmos5l_inv_1_818.A sg13cmos5l_mux4_1_13.A3 0.03181f
C7957 sg13cmos5l_inv_1_387.Y VPWR 0.4913f
C7958 sg13cmos5l_inv_1_672.A VPWR 0.38677f
C7959 sg13cmos5l_nor4_1_0.Y sg13cmos5l_nor3_1_1.Y 0.07769f
C7960 sg13cmos5l_inv_1_350.Y VPWR 0.56689f
C7961 sg13cmos5l_inv_1_862.A sg13cmos5l_inv_1_815.Y 0.01866f
C7962 sg13cmos5l_mux2_1_4.X sg13cmos5l_inv_1_396.Y 0.063f
C7963 sg13cmos5l_inv_1_733.A a_12808_12302# 0.01986f
C7964 sg13cmos5l_nor3_1_1.A sg13cmos5l_buf_1_12.X 0.24325f
C7965 sg13cmos5l_nand2_1_1.B sg13cmos5l_nor3_1_1.Y 0.50482f
C7966 sg13cmos5l_inv_1_929.A VPWR 0.427f
C7967 a_1480_4026# VPWR 0.13531f
C7968 sg13cmos5l_inv_1_147.A sg13cmos5l_inv_1_217.A 0.10903f
C7969 sg13cmos5l_mux2_1_4.S a_10504_9192# 0.29375f
C7970 sg13cmos5l_inv_1_329.A VPWR 1.00148f
C7971 sg13cmos5l_inv_1_58.A VPWR 0.35594f
C7972 sg13cmos5l_inv_1_896.Y sg13cmos5l_inv_1_887.Y 0.11155f
C7973 sg13cmos5l_a21oi_1_1.A2 sg13cmos5l_inv_1_649.Y 0.01203f
C7974 sg13cmos5l_nor3_1_1.Y a_8805_10240# 0.02344f
C7975 sg13cmos5l_inv_1_274.Y sg13cmos5l_inv_1_287.A 0.6432f
C7976 sg13cmos5l_inv_1_991.A sg13cmos5l_inv_1_351.Y 0.04324f
C7977 sg13cmos5l_inv_1_875.Y a_17512_14610# 0.01986f
C7978 sg13cmos5l_inv_1_976.Y VPWR 0.35981f
C7979 a_2632_10790# VPWR 0.15515f
C7980 sg13cmos5l_buf_1_9.A sg13cmos5l_inv_1_1009.Y 0.04796f
C7981 sg13cmos5l_inv_1_731.A a_13288_10790# 0.05184f
C7982 a_10888_14610# VPWR 0.1531f
C7983 sg13cmos5l_inv_1_882.Y sg13cmos5l_inv_1_908.A 0.19007f
C7984 sg13cmos5l_inv_1_241.Y sg13cmos5l_inv_1_245.A 0.02765f
C7985 sg13cmos5l_inv_1_882.A a_11936_14610# 0.01182f
C7986 sg13cmos5l_mux4_1_14.A0 sg13cmos5l_inv_1_787.Y 0.17425f
C7987 sg13cmos5l_inv_1_911.A VPWR 0.43245f
C7988 sg13cmos5l_inv_1_720.Y VPWR 0.60408f
C7989 sg13cmos5l_mux4_1_7.A1 sg13cmos5l_nor3_1_2.B 0.01151f
C7990 a_18664_9192# sg13cmos5l_inv_1_159.A 0.32955f
C7991 sg13cmos5l_o21ai_1_0.B1 sg13cmos5l_o21ai_1_0.Y 0.21102f
C7992 sg13cmos5l_inv_1_836.A a_16840_17634# 0.03352f
C7993 sg13cmos5l_inv_1_836.Y sg13cmos5l_inv_1_843.Y 0.01739f
C7994 sg13cmos5l_inv_1_843.A sg13cmos5l_inv_1_841.Y 0.33252f
C7995 sg13cmos5l_inv_1_848.Y sg13cmos5l_inv_1_851.A 0.02995f
C7996 sg13cmos5l_mux2_1_1.X a_8968_9278# 0.0245f
C7997 a_18856_7680# osc_tap[2] 0.29285f
C7998 sg13cmos5l_inv_1_725.Y a_17128_13098# 0.0469f
C7999 sg13cmos5l_inv_1_140.A a_13288_7050# 0.04368f
C8000 sg13cmos5l_inv_1_97.Y VPWR 0.52151f
C8001 sg13cmos5l_inv_1_174.A a_16928_7050# 0.03465f
C8002 sg13cmos5l_mux4_1_9.A0 sg13cmos5l_inv_1_532.A 0.22864f
C8003 sg13cmos5l_inv_1_66.A sg13cmos5l_inv_1_68.A 0.01493f
C8004 sg13cmos5l_inv_1_85.Y sg13cmos5l_inv_1_95.A 0.02885f
C8005 sg13cmos5l_inv_1_452.Y VPWR 0.42846f
C8006 sg13cmos5l_inv_1_557.A sg13cmos5l_inv_1_568.Y 0.23031f
C8007 sg13cmos5l_inv_1_858.Y VPWR 0.42422f
C8008 sg13cmos5l_inv_1_631.Y VPWR 0.42638f
C8009 sg13cmos5l_mux2_1_0.X sg13cmos5l_inv_1_148.A 0.02149f
C8010 sg13cmos5l_inv_1_372.A sg13cmos5l_inv_1_373.A 0.20065f
C8011 sg13cmos5l_inv_1_77.Y a_11176_3230# 0.01054f
C8012 sg13cmos5l_inv_1_904.A sg13cmos5l_inv_1_739.A 0.01236f
C8013 sg13cmos5l_o21ai_1_0.B1 sg13cmos5l_inv_1_969.Y 0.0519f
C8014 sg13cmos5l_inv_1_604.Y VPWR 0.42086f
C8015 sg13cmos5l_buf_1_9.A sg13cmos5l_inv_1_356.Y 0.01152f
C8016 sg13cmos5l_inv_1_241.A sg13cmos5l_inv_1_237.A 0.04895f
C8017 sg13cmos5l_inv_1_1007.Y sg13cmos5l_inv_1_925.A 0.05879f
C8018 sg13cmos5l_inv_1_70.Y VPWR 0.36462f
C8019 sg13cmos5l_inv_1_626.Y VPWR 0.40921f
C8020 sg13cmos5l_inv_1_383.Y a_5792_6254# 0.01083f
C8021 sg13cmos5l_inv_1_702.Y a_16256_10790# 0.01054f
C8022 sg13cmos5l_inv_1_689.A sg13cmos5l_inv_1_680.A 0.02219f
C8023 sg13cmos5l_inv_1_938.Y VPWR 0.51974f
C8024 a_14183_9582# a_14494_9582# 0.49675f
C8025 sg13cmos5l_inv_1_108.Y VPWR 0.43385f
C8026 a_3934_3534# VPWR 0.88997f
C8027 sg13cmos5l_inv_1_628.Y sg13cmos5l_inv_1_619.A 0.0214f
C8028 sg13cmos5l_inv_1_1010.Y sg13cmos5l_inv_1_65.A 0.06058f
C8029 sg13cmos5l_inv_1_278.Y a_10304_2514# 0.03603f
C8030 sg13cmos5l_inv_1_576.A sg13cmos5l_inv_1_573.A 0.17917f
C8031 sg13cmos5l_inv_1_553.Y sg13cmos5l_inv_1_533.A 0.01718f
C8032 a_17512_14610# VPWR 0.13747f
C8033 sg13cmos5l_inv_1_1011.A sg13cmos5l_inv_1_65.A 0.09818f
C8034 sg13cmos5l_inv_1_0.A a_18560_1002# 0.01312f
C8035 sg13cmos5l_inv_1_422.A a_3872_4742# 0.01386f
C8036 sg13cmos5l_inv_1_30.A sg13cmos5l_inv_1_30.Y 0.18432f
C8037 sg13cmos5l_inv_1_518.Y sg13cmos5l_inv_1_502.Y 0.01167f
C8038 sg13cmos5l_inv_1_520.A sg13cmos5l_inv_1_500.Y 0.1808f
C8039 sg13cmos5l_inv_1_545.A sg13cmos5l_inv_1_571.A 0.03462f
C8040 sg13cmos5l_inv_1_880.A VPWR 0.426f
C8041 sg13cmos5l_inv_1_815.Y sg13cmos5l_inv_1_815.A 0.09402f
C8042 sg13cmos5l_inv_1_875.Y sg13cmos5l_inv_1_920.A 0.06751f
C8043 a_14614_3534# sg13cmos5l_inv_1_16.A 0.01438f
C8044 sg13cmos5l_mux4_1_5.S1 sg13cmos5l_inv_1_129.Y 0.01557f
C8045 a_9996_11500# sg13cmos5l_inv_1_120.A 0.22891f
C8046 sg13cmos5l_inv_1_273.Y VPWR 0.36621f
C8047 sg13cmos5l_buf_1_8.A sg13cmos5l_inv_1_78.A 0.10766f
C8048 sg13cmos5l_a21oi_1_0.B1 sg13cmos5l_inv_1_520.A 0.01403f
C8049 sg13cmos5l_mux2_1_0.X a_15662_4084# 0.23202f
C8050 sg13cmos5l_inv_1_309.Y sg13cmos5l_inv_1_306.Y 0.01242f
C8051 sg13cmos5l_nor3_1_2.B sg13cmos5l_inv_1_704.Y 0.12152f
C8052 sg13cmos5l_mux4_1_6.A2 a_3623_8070# 0.22946f
C8053 sg13cmos5l_inv_1_535.Y sg13cmos5l_inv_1_535.A 0.70061f
C8054 sg13cmos5l_inv_1_416.Y VPWR 0.41975f
C8055 a_14913_3940# VPWR 0.7061f
C8056 sg13cmos5l_inv_1_942.Y sg13cmos5l_buf_1_27.X 0.06895f
C8057 a_3304_2514# a_3304_1718# 0.01095f
C8058 sg13cmos5l_inv_1_8.A a_17696_1718# 0.04394f
C8059 sg13cmos5l_a22oi_1_0.B1 sg13cmos5l_inv_1_498.A 0.02859f
C8060 sg13cmos5l_inv_1_350.A sg13cmos5l_inv_1_377.Y 0.0474f
C8061 sg13cmos5l_inv_1_311.Y sg13cmos5l_inv_1_251.A 0.01663f
C8062 sg13cmos5l_inv_1_650.Y VPWR 0.42427f
C8063 sg13cmos5l_inv_1_149.A sg13cmos5l_inv_1_181.Y 0.14142f
C8064 sg13cmos5l_inv_1_152.Y sg13cmos5l_inv_1_147.A 0.03205f
C8065 sg13cmos5l_mux4_1_5.S1 sg13cmos5l_inv_1_69.A 0.01372f
C8066 a_13607_3898# sg13cmos5l_inv_1_216.Y 0.22734f
C8067 sg13cmos5l_inv_1_0.A a_18088_1718# 0.0383f
C8068 sg13cmos5l_mux4_1_5.S0 sg13cmos5l_inv_1_971.Y 0.01153f
C8069 sg13cmos5l_inv_1_482.Y sg13cmos5l_inv_1_481.Y 0.14159f
C8070 sg13cmos5l_inv_1_478.Y sg13cmos5l_inv_1_486.Y 0.05951f
C8071 sg13cmos5l_inv_1_99.Y VPWR 0.35555f
C8072 a_8446_8434# a_8349_8728# 0.02925f
C8073 a_8123_8472# a_8623_8728# 0.03336f
C8074 sg13cmos5l_inv_1_105.Y sg13cmos5l_inv_1_105.A 0.65075f
C8075 sg13cmos5l_inv_1_137.A sg13cmos5l_inv_1_106.A 0.01679f
C8076 sg13cmos5l_mux4_1_11.A2 sg13cmos5l_inv_1_704.Y 0.0114f
C8077 sg13cmos5l_inv_1_462.A sg13cmos5l_inv_1_237.Y 0.03426f
C8078 sg13cmos5l_inv_1_40.Y a_16936_1718# 0.01986f
C8079 sg13cmos5l_inv_1_2.A sg13cmos5l_inv_1_7.Y 0.23201f
C8080 sg13cmos5l_buf_1_17.X a_19048_13814# 0.01107f
C8081 sg13cmos5l_inv_1_744.Y sg13cmos5l_mux4_1_12.A3 0.0217f
C8082 sg13cmos5l_inv_1_787.Y VPWR 0.72471f
C8083 sg13cmos5l_inv_1_973.Y sg13cmos5l_inv_1_944.Y 0.20994f
C8084 a_17024_1002# VPWR 0.07701f
C8085 a_3488_3230# VPWR 0.0719f
C8086 sg13cmos5l_inv_1_920.A VPWR 0.53473f
C8087 sg13cmos5l_inv_1_75.A sg13cmos5l_inv_1_88.Y 0.01531f
C8088 sg13cmos5l_inv_1_415.A sg13cmos5l_inv_1_276.A 0.0123f
C8089 sg13cmos5l_inv_1_584.A sg13cmos5l_inv_1_641.A 0.0246f
C8090 sg13cmos5l_inv_1_363.Y VPWR 0.43915f
C8091 sg13cmos5l_inv_1_69.A sg13cmos5l_inv_1_306.A 0.02526f
C8092 sg13cmos5l_inv_1_743.Y sg13cmos5l_inv_1_744.Y 0.20001f
C8093 sg13cmos5l_inv_1_823.A sg13cmos5l_inv_1_824.A 0.08964f
C8094 sg13cmos5l_mux4_1_5.S0 a_8104_6254# 0.04848f
C8095 sg13cmos5l_inv_1_966.Y sg13cmos5l_inv_1_967.Y 0.20866f
C8096 sg13cmos5l_mux2_1_0.X sg13cmos5l_inv_1_224.Y 0.03799f
C8097 sg13cmos5l_inv_1_947.A sg13cmos5l_inv_1_507.A 0.66581f
C8098 sg13cmos5l_inv_1_851.Y sg13cmos5l_inv_1_850.Y 0.20065f
C8099 sg13cmos5l_inv_1_582.A sg13cmos5l_inv_1_625.Y 0.47563f
C8100 sg13cmos5l_inv_1_305.Y sg13cmos5l_inv_1_308.Y 0.56442f
C8101 sg13cmos5l_nand2_1_1.B sg13cmos5l_nand2_1_1.Y 0.17045f
C8102 sg13cmos5l_inv_1_484.Y VPWR 0.4533f
C8103 sg13cmos5l_inv_1_486.Y VPWR 0.51277f
C8104 a_18856_7680# VPWR 0.3117f
C8105 sg13cmos5l_nor3_1_2.B sg13cmos5l_buf_1_12.X 0.01557f
C8106 sg13cmos5l_mux4_1_11.A3 sg13cmos5l_inv_1_707.A 0.26992f
C8107 a_15105_3492# sg13cmos5l_inv_1_16.A 0.06887f
C8108 sg13cmos5l_inv_1_274.Y a_8086_3534# 0.24093f
C8109 sg13cmos5l_inv_1_305.Y sg13cmos5l_inv_1_439.Y 0.05402f
C8110 sg13cmos5l_inv_1_51.A VPWR 0.42291f
C8111 sg13cmos5l_inv_1_884.Y sg13cmos5l_inv_1_889.Y 0.10897f
C8112 sg13cmos5l_mux2_1_3.S sg13cmos5l_mux4_1_6.X 0.05931f
C8113 sg13cmos5l_inv_1_370.Y sg13cmos5l_inv_1_370.A 0.76393f
C8114 sg13cmos5l_inv_1_283.A sg13cmos5l_inv_1_427.Y 0.01571f
C8115 a_808_4656# sg13cmos5l_inv_1_317.Y 0.03685f
C8116 sg13cmos5l_inv_1_264.A sg13cmos5l_inv_1_268.A 0.18585f
C8117 sg13cmos5l_inv_1_664.A a_3488_13814# 0.01094f
C8118 sg13cmos5l_buf_1_9.A sg13cmos5l_inv_1_624.Y 0.01197f
C8119 a_15016_2514# VPWR 0.15015f
C8120 sg13cmos5l_mux2_1_4.X sg13cmos5l_inv_1_448.Y 0.01574f
C8121 sg13cmos5l_inv_1_115.Y VPWR 0.39071f
C8122 sg13cmos5l_inv_1_674.A a_4264_13098# 0.01059f
C8123 sg13cmos5l_mux2_1_0.X sg13cmos5l_inv_1_120.Y 0.01669f
C8124 sg13cmos5l_inv_1_779.A sg13cmos5l_inv_1_807.Y 0.18161f
C8125 sg13cmos5l_inv_1_922.Y sg13cmos5l_inv_1_980.A 0.01927f
C8126 sg13cmos5l_inv_1_780.Y sg13cmos5l_inv_1_779.Y 0.12843f
C8127 sg13cmos5l_inv_1_4.Y sg13cmos5l_inv_1_3.Y 0.01873f
C8128 sg13cmos5l_buf_1_10.A sg13cmos5l_inv_1_337.A 0.04584f
C8129 a_18856_1632# VPWR 0.25145f
C8130 sg13cmos5l_inv_1_304.A sg13cmos5l_inv_1_309.Y 0.03596f
C8131 sg13cmos5l_mux4_1_5.S1 sg13cmos5l_inv_1_138.A 0.02884f
C8132 sg13cmos5l_inv_1_100.A sg13cmos5l_inv_1_76.A 0.10125f
C8133 sg13cmos5l_inv_1_90.Y a_11360_3230# 0.03646f
C8134 sg13cmos5l_inv_1_142.A VPWR 0.36977f
C8135 sg13cmos5l_inv_1_729.Y a_17416_11586# 0.03488f
C8136 a_8446_8434# a_8560_8434# 0.03097f
C8137 a_8327_6558# a_8638_6558# 0.49675f
C8138 sg13cmos5l_inv_1_225.Y sg13cmos5l_inv_1_225.A 0.19685f
C8139 sg13cmos5l_inv_1_316.A a_2248_3932# 0.01378f
C8140 sg13cmos5l_inv_1_618.A sg13cmos5l_inv_1_580.A 0.1823f
C8141 sg13cmos5l_inv_1_190.A sg13cmos5l_inv_1_184.A 0.0285f
C8142 sg13cmos5l_inv_1_534.A sg13cmos5l_inv_1_633.A 0.04363f
C8143 sg13cmos5l_inv_1_135.Y VPWR 0.42728f
C8144 sg13cmos5l_inv_1_95.A sg13cmos5l_inv_1_59.Y 0.10008f
C8145 sg13cmos5l_inv_1_525.A a_2240_13098# 0.01056f
C8146 a_3934_12606# a_4357_12267# 0.01929f
C8147 sg13cmos5l_inv_1_394.A a_7501_8440# 0.01534f
C8148 sg13cmos5l_inv_1_404.Y VPWR 0.50804f
C8149 sg13cmos5l_inv_1_672.Y VPWR 0.42596f
C8150 sg13cmos5l_inv_1_321.A a_1664_3230# 0.04857f
C8151 sg13cmos5l_inv_1_296.Y a_5032_1718# 0.03546f
C8152 sg13cmos5l_nor4_1_0.Y sg13cmos5l_nor3_1_0.Y 0.10525f
C8153 a_3623_12606# a_3488_12302# 0.01143f
C8154 sg13cmos5l_mux2_1_4.X sg13cmos5l_inv_1_391.Y 0.02925f
C8155 a_14989_14488# sg13cmos5l_mux4_1_11.A1 0.0116f
C8156 sg13cmos5l_inv_1_382.Y sg13cmos5l_inv_1_454.Y 0.01055f
C8157 sg13cmos5l_nand2_1_1.B sg13cmos5l_nor3_1_0.Y 0.34127f
C8158 osc VGND 0.69048f
C8159 osc_tap[0] VGND 1.0191f
C8160 osc_tap[1] VGND 0.66845f
C8161 osc_tap[2] VGND 0.73151f
C8162 osc_tap[3] VGND 0.77775f
C8163 osc_tap[4] VGND 0.70781f
C8164 osc_tap[5] VGND 0.9326f
C8165 osc_tap[6] VGND 0.77016f
C8166 osc_tap[7] VGND 0.71943f
C8167 VPWR VGND 0.14992p
C8168 a_18560_1002# VGND 0.04544f ; **FLOATING
C8169 a_17024_1002# VGND 0.04484f ; **FLOATING
C8170 a_13472_1002# VGND 0.04174f ; **FLOATING
C8171 a_13288_1002# VGND 0.10832f ; **FLOATING
C8172 a_12808_1002# VGND 0.10017f ; **FLOATING
C8173 sg13cmos5l_inv_1_7.A VGND 0.20993f
C8174 sg13cmos5l_inv_1_13.Y VGND 0.11944f
C8175 sg13cmos5l_inv_1_73.A VGND 0.09097f
C8176 sg13cmos5l_inv_1_68.A VGND 0.35314f
C8177 a_7328_1002# VGND 0.0448f ; **FLOATING
C8178 a_5792_1002# VGND 0.04364f ; **FLOATING
C8179 a_3680_1002# VGND 0.06243f ; **FLOATING
C8180 sg13cmos5l_inv_1_945.Y VGND 0.39274f
C8181 sg13cmos5l_inv_1_244.A VGND 0.09499f
C8182 sg13cmos5l_inv_1_239.A VGND 0.09712f
C8183 sg13cmos5l_inv_1_240.Y VGND 0.14243f
C8184 sg13cmos5l_inv_1_273.Y VGND 0.3162f
C8185 sg13cmos5l_inv_1_250.Y VGND 0.08395f
C8186 sg13cmos5l_inv_1_442.Y VGND 0.07919f
C8187 sg13cmos5l_inv_1_298.A VGND 0.38918f
C8188 a_800_1002# VGND 0.08135f ; **FLOATING
C8189 sg13cmos5l_inv_1_308.Y VGND 0.14508f
C8190 sg13cmos5l_inv_1_306.Y VGND 0.88584f
C8191 sg13cmos5l_inv_1_308.A VGND 0.27948f
C8192 a_18088_1718# VGND 0.08593f ; **FLOATING
C8193 a_18856_1632# VGND 0.91921f
C8194 a_17696_1718# VGND 0.04316f ; **FLOATING
C8195 a_16936_1718# VGND 0.08582f ; **FLOATING
C8196 a_16168_1718# VGND 0.08267f ; **FLOATING
C8197 sg13cmos5l_inv_1_22.Y VGND 0.2267f
C8198 sg13cmos5l_inv_1_16.Y VGND 0.42374f
C8199 a_13472_1718# VGND 0.04253f ; **FLOATING
C8200 a_13288_1718# VGND 0.10398f ; **FLOATING
C8201 sg13cmos5l_inv_1_14.A VGND 0.18979f
C8202 sg13cmos5l_inv_1_17.A VGND 0.28454f
C8203 sg13cmos5l_inv_1_220.Y VGND 0.4154f
C8204 sg13cmos5l_inv_1_61.A VGND 0.40325f
C8205 a_12808_1718# VGND 0.10221f ; **FLOATING
C8206 a_11456_1718# VGND 0.04415f ; **FLOATING
C8207 a_10696_1718# VGND 0.08655f ; **FLOATING
C8208 sg13cmos5l_inv_1_70.A VGND 0.29728f
C8209 a_9640_1718# VGND 0.08493f ; **FLOATING
C8210 sg13cmos5l_inv_1_65.Y VGND 0.39814f
C8211 a_7808_1718# VGND 0.04157f ; **FLOATING
C8212 sg13cmos5l_inv_1_245.A VGND 0.8373f
C8213 sg13cmos5l_inv_1_247.A VGND 0.17915f
C8214 a_6848_1718# VGND 0.04245f ; **FLOATING
C8215 sg13cmos5l_inv_1_259.Y VGND 0.18337f
C8216 sg13cmos5l_inv_1_260.Y VGND 0.3361f
C8217 a_6088_1718# VGND 0.08476f ; **FLOATING
C8218 a_5032_1718# VGND 0.08567f ; **FLOATING
C8219 sg13cmos5l_inv_1_453.Y VGND 0.18002f
C8220 sg13cmos5l_inv_1_256.A VGND 0.32431f
C8221 sg13cmos5l_inv_1_453.A VGND 0.26409f
C8222 sg13cmos5l_inv_1_295.Y VGND 0.36299f
C8223 a_3488_1718# VGND 0.04512f ; **FLOATING
C8224 a_3304_1718# VGND 0.11601f ; **FLOATING
C8225 a_2912_1718# VGND 0.0593f ; **FLOATING
C8226 a_1480_1718# VGND 0.08408f ; **FLOATING
C8227 sg13cmos5l_inv_1_309.Y VGND 0.44708f
C8228 a_808_1632# VGND 0.1808f
C8229 a_19136_2514# VGND 0.08064f ; **FLOATING
C8230 sg13cmos5l_inv_1_8.A VGND 0.43243f
C8231 a_17512_2514# VGND 0.08254f ; **FLOATING
C8232 a_15016_2514# VGND 0.08381f ; **FLOATING
C8233 sg13cmos5l_inv_1_63.A VGND 0.32067f
C8234 a_13472_2514# VGND 0.0474f ; **FLOATING
C8235 a_13288_2514# VGND 0.11369f ; **FLOATING
C8236 a_12896_2514# VGND 0.06042f ; **FLOATING
C8237 sg13cmos5l_inv_1_1.Y VGND 0.1834f
C8238 sg13cmos5l_inv_1_36.A VGND 0.31467f
C8239 sg13cmos5l_inv_1_2.Y VGND 0.15975f
C8240 sg13cmos5l_inv_1_46.A VGND 0.33514f
C8241 sg13cmos5l_inv_1_6.Y VGND 0.32958f
C8242 sg13cmos5l_inv_1_48.Y VGND 0.25175f
C8243 sg13cmos5l_inv_1_12.Y VGND 0.27858f
C8244 a_10688_2514# VGND 0.04376f ; **FLOATING
C8245 a_10304_2514# VGND 0.04246f ; **FLOATING
C8246 a_6952_2514# VGND 0.08238f ; **FLOATING
C8247 sg13cmos5l_inv_1_304.A VGND 0.29653f
C8248 a_5696_2514# VGND 0.0406f ; **FLOATING
C8249 a_4736_2514# VGND 0.04386f ; **FLOATING
C8250 a_3488_2514# VGND 0.04209f ; **FLOATING
C8251 a_3304_2514# VGND 0.10399f ; **FLOATING
C8252 sg13cmos5l_inv_1_301.A VGND 0.40152f
C8253 sg13cmos5l_inv_1_59.Y VGND 0.68051f
C8254 sg13cmos5l_inv_1_84.Y VGND 0.29702f
C8255 sg13cmos5l_inv_1_72.Y VGND 0.29088f
C8256 sg13cmos5l_inv_1_1010.Y VGND 0.16957f
C8257 sg13cmos5l_inv_1_278.Y VGND 0.26498f
C8258 sg13cmos5l_inv_1_279.Y VGND 0.39329f
C8259 sg13cmos5l_inv_1_292.Y VGND 0.17233f
C8260 sg13cmos5l_inv_1_325.Y VGND 0.22476f
C8261 sg13cmos5l_inv_1_297.Y VGND 0.15194f
C8262 a_2240_2514# VGND 0.0413f ; **FLOATING
C8263 a_1856_2514# VGND 0.04216f ; **FLOATING
C8264 a_1472_2514# VGND 0.04391f ; **FLOATING
C8265 a_800_2514# VGND 0.08055f ; **FLOATING
C8266 sg13cmos5l_inv_1_311.A VGND 0.31315f
C8267 sg13cmos5l_inv_1_312.Y VGND 0.28244f
C8268 sg13cmos5l_inv_1_328.A VGND 0.36749f
C8269 a_19048_3230# VGND 0.12252f ; **FLOATING
C8270 a_18272_3230# VGND 0.04264f ; **FLOATING
C8271 a_17312_3230# VGND 0.04012f ; **FLOATING
C8272 a_14837_3149# VGND 0.09308f
C8273 a_14533_3195# VGND 0.34751f
C8274 a_14317_3195# VGND 0.16989f
C8275 sg13cmos5l_inv_1_55.Y VGND 0.10173f
C8276 a_13664_3230# VGND 0.0617f ; **FLOATING
C8277 a_15105_3492# VGND 0.47637f
C8278 a_14110_3534# VGND 1.46576f
C8279 a_14036_3534# VGND 1.18566f
C8280 a_14614_3534# VGND 0.81225f
C8281 sg13cmos5l_mux4_1_1.A3 VGND 0.15957f
C8282 a_11360_3230# VGND 0.04044f ; **FLOATING
C8283 a_11176_3230# VGND 0.08292f ; **FLOATING
C8284 a_10496_3230# VGND 0.04196f ; **FLOATING
C8285 a_9758_3168# VGND 5.94077f
C8286 a_9498_3168# VGND 0.20974f
C8287 a_7495_3195# VGND 0.17852f
C8288 a_9498_3514# VGND 0.09389f
C8289 sg13cmos5l_mux4_1_3.X VGND 0.37242f
C8290 a_9326_3410# VGND 0.62214f
C8291 a_8223_3534# VGND 0.51329f
C8292 a_8010_3534# VGND 0.52752f
C8293 a_7700_3534# VGND 0.18614f
C8294 a_7582_3534# VGND 0.55241f
C8295 a_7508_3534# VGND 0.56973f
C8296 a_5896_3230# VGND 0.08641f ; **FLOATING
C8297 a_4661_3149# VGND 0.24281f
C8298 a_8086_3534# VGND 1.71467f
C8299 sg13cmos5l_inv_1_286.Y VGND 0.04153f
C8300 sg13cmos5l_inv_1_293.Y VGND 0.31891f
C8301 sg13cmos5l_inv_1_272.A VGND 0.48455f
C8302 a_3488_3230# VGND 0.04256f ; **FLOATING
C8303 a_3304_3230# VGND 0.10784f ; **FLOATING
C8304 a_4929_3492# VGND 0.51234f
C8305 a_4575_3534# VGND 0.19533f
C8306 a_4362_3534# VGND 0.41025f
C8307 a_4052_3534# VGND 0.31365f
C8308 a_3934_3534# VGND 0.95329f
C8309 a_3860_3534# VGND 0.81876f
C8310 a_4438_3534# VGND 1.3231f
C8311 sg13cmos5l_inv_1_326.Y VGND 0.4898f
C8312 sg13cmos5l_inv_1_305.A VGND 0.25375f
C8313 sg13cmos5l_inv_1_327.A VGND 0.05573f
C8314 a_1664_3230# VGND 0.04171f ; **FLOATING
C8315 sg13cmos5l_inv_1_336.A VGND 0.08962f
C8316 a_18664_4026# VGND 0.09248f ; **FLOATING
C8317 sg13cmos5l_buf_1_2.X VGND 0.24775f
C8318 a_17120_4026# VGND 0.04673f ; **FLOATING
C8319 a_16156_3898# VGND 0.36255f
C8320 a_15834_3898# VGND 0.51471f
C8321 a_14036_3898# VGND 0.03187f
C8322 a_16094_4192# VGND 0.03672f
C8323 a_15834_4192# VGND 0.41547f
C8324 sg13cmos5l_inv_1_37.Y VGND 0.18346f
C8325 sg13cmos5l_mux4_1_1.X VGND 0.05993f
C8326 a_14645_4211# VGND 0.67205f
C8327 a_14422_3898# VGND 2.55454f
C8328 a_14125_4165# VGND 0.15625f
C8329 a_13918_3898# VGND 0.05518f
C8330 a_13831_4165# VGND 0.57943f
C8331 a_14341_4165# VGND 0.92823f
C8332 a_13472_4026# VGND 0.04988f ; **FLOATING
C8333 a_13288_4026# VGND 0.11559f ; **FLOATING
C8334 sg13cmos5l_inv_1_85.Y VGND 0.2303f
C8335 a_11848_4026# VGND 0.09217f ; **FLOATING
C8336 a_11456_4026# VGND 0.04717f ; **FLOATING
C8337 a_9832_4026# VGND 0.09233f ; **FLOATING
C8338 a_9152_4026# VGND 0.06386f ; **FLOATING
C8339 sg13cmos5l_inv_1_88.Y VGND 0.78676f
C8340 sg13cmos5l_inv_1_77.Y VGND 0.15646f
C8341 a_7424_4026# VGND 0.04551f ; **FLOATING
C8342 sg13cmos5l_inv_1_241.Y VGND 0.46326f
C8343 sg13cmos5l_inv_1_266.A VGND 0.23236f
C8344 a_3680_4026# VGND 0.0625f ; **FLOATING
C8345 sg13cmos5l_inv_1_319.Y VGND 0.45613f
C8346 a_2816_4026# VGND 0.03653f ; **FLOATING
C8347 a_2632_4026# VGND 0.0806f ; **FLOATING
C8348 sg13cmos5l_buf_1_7.X VGND 0.12936f
C8349 a_1480_4026# VGND 0.09501f ; **FLOATING
C8350 sg13cmos5l_inv_1_322.A VGND 0.31714f
C8351 a_800_4026# VGND 0.08332f ; **FLOATING
C8352 sg13cmos5l_inv_1_337.Y VGND 0.50954f
C8353 sg13cmos5l_inv_1_314.Y VGND 0.40805f
C8354 sg13cmos5l_inv_1_320.Y VGND 0.1566f
C8355 a_19136_4742# VGND 0.08138f ; **FLOATING
C8356 a_18176_4742# VGND 0.04263f ; **FLOATING
C8357 sg13cmos5l_inv_1_213.Y VGND 0.14219f
C8358 sg13cmos5l_inv_1_186.A VGND 0.12311f
C8359 sg13cmos5l_inv_1_30.A VGND 0.35519f
C8360 sg13cmos5l_inv_1_194.Y VGND 0.10089f
C8361 a_15104_4742# VGND 0.0433f ; **FLOATING
C8362 a_12136_4742# VGND 0.08384f ; **FLOATING
C8363 a_11456_4742# VGND 0.04418f ; **FLOATING
C8364 sg13cmos5l_inv_1_236.Y VGND 0.18437f
C8365 a_10784_4742# VGND 0.04357f ; **FLOATING
C8366 sg13cmos5l_inv_1_235.Y VGND 0.13668f
C8367 sg13cmos5l_inv_1_233.A VGND 0.12838f
C8368 a_8864_4742# VGND 0.04674f ; **FLOATING
C8369 sg13cmos5l_inv_1_270.Y VGND 0.20921f
C8370 a_8480_4742# VGND 0.04627f ; **FLOATING
C8371 a_6368_4742# VGND 0.0443f ; **FLOATING
C8372 sg13cmos5l_inv_1_446.A VGND 0.34995f
C8373 sg13cmos5l_inv_1_415.A VGND 0.433f
C8374 sg13cmos5l_inv_1_429.A VGND 0.16201f
C8375 a_5408_4742# VGND 0.04292f ; **FLOATING
C8376 sg13cmos5l_inv_1_452.Y VGND 0.19104f
C8377 a_3872_4742# VGND 0.04346f ; **FLOATING
C8378 sg13cmos5l_inv_1_426.A VGND 0.09156f
C8379 sg13cmos5l_inv_1_424.A VGND 0.12307f
C8380 sg13cmos5l_inv_1_423.A VGND 0.0892f
C8381 a_2816_4742# VGND 0.03732f ; **FLOATING
C8382 a_2632_4742# VGND 0.07543f ; **FLOATING
C8383 sg13cmos5l_inv_1_334.A VGND 0.32625f
C8384 sg13cmos5l_inv_1_449.A VGND 0.13462f
C8385 sg13cmos5l_inv_1_420.A VGND 0.07104f
C8386 a_808_4656# VGND 0.2178f
C8387 a_19048_5538# VGND 0.11773f ; **FLOATING
C8388 a_18176_5538# VGND 0.04282f ; **FLOATING
C8389 sg13cmos5l_buf_1_6.A VGND 0.38275f
C8390 a_17216_5538# VGND 0.06038f ; **FLOATING
C8391 sg13cmos5l_inv_1_205.Y VGND 0.3335f
C8392 a_15584_5538# VGND 0.04414f ; **FLOATING
C8393 sg13cmos5l_inv_1_184.A VGND 0.46942f
C8394 a_13472_5538# VGND 0.04026f ; **FLOATING
C8395 a_13288_5538# VGND 0.10369f ; **FLOATING
C8396 sg13cmos5l_inv_1_212.Y VGND 0.1639f
C8397 sg13cmos5l_inv_1_207.Y VGND 0.41582f
C8398 sg13cmos5l_inv_1_227.A VGND 0.12961f
C8399 sg13cmos5l_inv_1_224.Y VGND 0.41411f
C8400 sg13cmos5l_inv_1_228.Y VGND 0.49922f
C8401 a_8776_5538# VGND 0.12833f ; **FLOATING
C8402 sg13cmos5l_inv_1_448.Y VGND 0.07006f
C8403 sg13cmos5l_inv_1_241.A VGND 0.37237f
C8404 a_3680_5538# VGND 0.05879f ; **FLOATING
C8405 sg13cmos5l_inv_1_463.Y VGND 0.18339f
C8406 sg13cmos5l_inv_1_416.Y VGND 0.0893f
C8407 sg13cmos5l_inv_1_427.A VGND 0.12894f
C8408 sg13cmos5l_inv_1_438.A VGND 0.05554f
C8409 sg13cmos5l_inv_1_437.A VGND 0.13639f
C8410 a_800_5538# VGND 0.08025f ; **FLOATING
C8411 sg13cmos5l_inv_1_439.A VGND 0.14161f
C8412 a_19048_6254# VGND 0.11716f ; **FLOATING
C8413 a_18368_6254# VGND 0.04272f ; **FLOATING
C8414 sg13cmos5l_inv_1_186.Y VGND 0.31353f
C8415 a_17896_6254# VGND 0.08311f ; **FLOATING
C8416 sg13cmos5l_inv_1_206.A VGND 0.11908f
C8417 a_13472_6254# VGND 0.0407f ; **FLOATING
C8418 a_13288_6254# VGND 0.1057f ; **FLOATING
C8419 sg13cmos5l_inv_1_181.Y VGND 0.13534f
C8420 sg13cmos5l_inv_1_147.Y VGND 0.11815f
C8421 sg13cmos5l_inv_1_148.A VGND 0.08627f
C8422 sg13cmos5l_inv_1_107.Y VGND 0.15855f
C8423 a_12808_6254# VGND 0.10778f ; **FLOATING
C8424 a_9365_6173# VGND 0.24326f
C8425 a_8551_6219# VGND 0.42767f
C8426 sg13cmos5l_inv_1_111.Y VGND 0.13466f
C8427 a_8104_6254# VGND 0.09319f ; **FLOATING
C8428 a_9633_6516# VGND 0.63075f
C8429 a_9279_6558# VGND 0.77519f
C8430 a_9066_6558# VGND 0.14744f
C8431 a_8756_6558# VGND 0.35131f
C8432 a_8638_6558# VGND 0.43213f
C8433 a_8564_6558# VGND 0.41605f
C8434 a_9142_6558# VGND 2.21093f
C8435 a_7136_6254# VGND 0.08619f ; **FLOATING
C8436 sg13cmos5l_inv_1_382.A VGND 0.023f
C8437 a_5792_6254# VGND 0.04493f ; **FLOATING
C8438 sg13cmos5l_inv_1_418.Y VGND 0.29499f
C8439 a_5032_6254# VGND 0.07989f ; **FLOATING
C8440 sg13cmos5l_inv_1_248.A VGND 0.31629f
C8441 sg13cmos5l_inv_1_344.Y VGND 0.49372f
C8442 a_3488_6254# VGND 0.04597f ; **FLOATING
C8443 a_3304_6254# VGND 0.11303f ; **FLOATING
C8444 a_1576_6254# VGND 0.08517f ; **FLOATING
C8445 sg13cmos5l_inv_1_348.A VGND 0.43756f
C8446 a_808_6254# VGND 0.11895f ; **FLOATING
C8447 sg13cmos5l_inv_1_345.Y VGND 0.07582f
C8448 a_19048_7050# VGND 0.11985f ; **FLOATING
C8449 a_18664_6956# VGND 0.98965f
C8450 a_17896_7050# VGND 0.08248f ; **FLOATING
C8451 a_16928_7050# VGND 0.06072f ; **FLOATING
C8452 sg13cmos5l_inv_1_175.A VGND 0.0959f
C8453 sg13cmos5l_inv_1_174.A VGND 0.17295f
C8454 sg13cmos5l_inv_1_106.A VGND 0.1007f
C8455 a_13472_7050# VGND 0.04253f ; **FLOATING
C8456 a_13288_7050# VGND 0.10398f ; **FLOATING
C8457 a_12808_7050# VGND 0.10008f ; **FLOATING
C8458 sg13cmos5l_inv_1_149.Y VGND 0.09195f
C8459 sg13cmos5l_inv_1_215.Y VGND 0.18631f
C8460 sg13cmos5l_inv_1_138.A VGND 0.19633f
C8461 a_11944_7050# VGND 0.08408f ; **FLOATING
C8462 a_10688_7050# VGND 0.04201f ; **FLOATING
C8463 a_8000_7050# VGND 0.04495f ; **FLOATING
C8464 a_6752_7050# VGND 0.06024f ; **FLOATING
C8465 sg13cmos5l_inv_1_134.Y VGND 0.37117f
C8466 sg13cmos5l_inv_1_389.Y VGND 0.26426f
C8467 sg13cmos5l_inv_1_393.A VGND 0.28738f
C8468 a_5608_7050# VGND 0.08248f ; **FLOATING
C8469 sg13cmos5l_inv_1_462.A VGND 0.187f
C8470 sg13cmos5l_inv_1_386.Y VGND 0.44745f
C8471 a_2144_7050# VGND 0.04006f ; **FLOATING
C8472 a_1184_7050# VGND 0.04521f ; **FLOATING
C8473 sg13cmos5l_buf_1_4.X VGND 0.11396f
C8474 a_18464_7766# VGND 0.04156f ; **FLOATING
C8475 a_16531_7731# VGND 0.27959f
C8476 a_16021_7685# VGND 0.45085f
C8477 a_16304_7685# VGND 0.76909f
C8478 sg13cmos5l_inv_1_177.Y VGND 0.34282f
C8479 a_16113_8070# VGND 0.04662f
C8480 a_15637_8028# VGND 0.24949f
C8481 sg13cmos5l_inv_1_179.A VGND 0.28096f
C8482 a_15608_7680# VGND 2.14515f
C8483 a_15016_7766# VGND 0.0845f ; **FLOATING
C8484 a_15275_7644# VGND 0.22839f
C8485 sg13cmos5l_inv_1_130.A VGND 0.37652f
C8486 sg13cmos5l_inv_1_140.A VGND 0.37045f
C8487 a_13472_7766# VGND 0.0407f ; **FLOATING
C8488 a_13288_7766# VGND 0.10398f ; **FLOATING
C8489 sg13cmos5l_inv_1_140.Y VGND 0.24205f
C8490 a_12896_7766# VGND 0.05994f ; **FLOATING
C8491 a_10976_7766# VGND 0.04279f ; **FLOATING
C8492 sg13cmos5l_inv_1_122.Y VGND 0.33347f
C8493 sg13cmos5l_inv_1_120.Y VGND 0.79793f
C8494 a_10592_7766# VGND 0.04295f ; **FLOATING
C8495 a_10159_7704# VGND 1.97504f
C8496 a_9885_7704# VGND 0.05669f
C8497 a_10096_8050# VGND 0.32844f
C8498 a_9536_7766# VGND 0.04419f ; **FLOATING
C8499 a_9982_8050# VGND 0.05669f
C8500 sg13cmos5l_inv_1_397.Y VGND 0.35817f
C8501 sg13cmos5l_inv_1_391.A VGND 0.16378f
C8502 a_4661_7685# VGND 0.1155f
C8503 a_4357_7731# VGND 0.3554f
C8504 a_4141_7731# VGND 0.80535f
C8505 a_3847_7731# VGND 0.53673f
C8506 sg13cmos5l_inv_1_387.Y VGND 0.31135f
C8507 sg13cmos5l_inv_1_403.Y VGND 0.37677f
C8508 a_4929_8028# VGND 0.37352f
C8509 a_3934_8070# VGND 0.95888f
C8510 a_3860_8070# VGND 0.39066f
C8511 a_4438_8070# VGND 1.06206f
C8512 sg13cmos5l_inv_1_421.A VGND 0.22427f
C8513 a_1568_7766# VGND 0.04382f ; **FLOATING
C8514 sg13cmos5l_inv_1_362.A VGND 0.37816f
C8515 a_808_7766# VGND 0.11936f ; **FLOATING
C8516 sg13cmos5l_inv_1_372.Y VGND 0.13031f
C8517 sg13cmos5l_inv_1_168.A VGND 0.38206f
C8518 a_18184_8562# VGND 0.08332f ; **FLOATING
C8519 sg13cmos5l_inv_1_171.A VGND 0.33279f
C8520 a_13472_8562# VGND 0.04253f ; **FLOATING
C8521 a_13288_8562# VGND 0.10398f ; **FLOATING
C8522 a_12808_8562# VGND 0.10049f ; **FLOATING
C8523 sg13cmos5l_inv_1_162.A VGND 0.38396f
C8524 sg13cmos5l_inv_1_169.Y VGND 0.31022f
C8525 sg13cmos5l_inv_1_118.Y VGND 0.34182f
C8526 a_11368_8562# VGND 0.10061f ; **FLOATING
C8527 sg13cmos5l_inv_1_124.A VGND 0.18504f
C8528 a_9536_8562# VGND 0.04183f ; **FLOATING
C8529 a_9064_8562# VGND 0.08385f ; **FLOATING
C8530 a_8560_8434# VGND 0.30167f
C8531 a_7071_8434# VGND 0.77514f
C8532 a_6858_8434# VGND 0.45065f
C8533 a_6548_8434# VGND 0.09398f
C8534 a_8623_8728# VGND 0.3498f
C8535 sg13cmos5l_inv_1_384.Y VGND 0.38189f
C8536 sg13cmos5l_mux4_1_4.X VGND 0.37653f
C8537 a_6934_8434# VGND 2.66351f
C8538 a_6637_8701# VGND 0.25766f
C8539 a_6430_8434# VGND 0.0198f
C8540 sg13cmos5l_inv_1_411.Y VGND 0.34276f
C8541 sg13cmos5l_inv_1_356.A VGND 0.10094f
C8542 sg13cmos5l_inv_1_366.Y VGND 0.43906f
C8543 sg13cmos5l_inv_1_366.A VGND 0.04529f
C8544 a_800_8562# VGND 0.08001f ; **FLOATING
C8545 sg13cmos5l_inv_1_351.Y VGND 0.2489f
C8546 sg13cmos5l_inv_1_370.Y VGND 0.33605f
C8547 sg13cmos5l_inv_1_378.Y VGND 0.3625f
C8548 a_19048_9278# VGND 0.12099f ; **FLOATING
C8549 sg13cmos5l_inv_1_159.A VGND 0.26951f
C8550 sg13cmos5l_inv_1_166.A VGND 0.16041f
C8551 a_17696_9278# VGND 0.04151f ; **FLOATING
C8552 a_17312_9278# VGND 0.04187f ; **FLOATING
C8553 a_16640_9278# VGND 0.03901f ; **FLOATING
C8554 a_16456_9278# VGND 0.07749f ; **FLOATING
C8555 a_14917_9243# VGND 0.84686f
C8556 a_14701_9243# VGND 0.17154f
C8557 a_14407_9243# VGND 0.49446f
C8558 a_14494_9582# VGND 0.427f
C8559 a_14420_9582# VGND 0.41072f
C8560 a_13472_9278# VGND 0.0407f ; **FLOATING
C8561 a_13288_9278# VGND 0.10524f ; **FLOATING
C8562 a_14998_9582# VGND 1.76981f
C8563 sg13cmos5l_mux4_1_5.S1 VGND 14.21058f
C8564 sg13cmos5l_inv_1_114.Y VGND 0.57303f
C8565 sg13cmos5l_inv_1_953.Y VGND 0.36541f
C8566 a_12896_9278# VGND 0.05783f ; **FLOATING
C8567 a_10888_9278# VGND 0.08637f ; **FLOATING
C8568 a_10268_9172# VGND 0.687f
C8569 sg13cmos5l_inv_1_112.Y VGND 0.32269f
C8570 sg13cmos5l_inv_1_978.A VGND 0.17145f
C8571 sg13cmos5l_inv_1_976.A VGND 0.27f
C8572 a_10162_9570# VGND 0.28433f
C8573 a_9920_9278# VGND 0.0387f ; **FLOATING
C8574 a_9736_9278# VGND 0.07866f ; **FLOATING
C8575 a_9341_9192# VGND 0.15719f
C8576 a_9152_9278# VGND 0.03578f ; **FLOATING
C8577 a_8968_9278# VGND 0.07849f ; **FLOATING
C8578 sg13cmos5l_mux2_1_4.X VGND 0.10487f
C8579 sg13cmos5l_inv_1_394.A VGND 0.34262f
C8580 a_8000_9278# VGND 0.08624f ; **FLOATING
C8581 a_5992_9278# VGND 0.08642f ; **FLOATING
C8582 sg13cmos5l_inv_1_970.A VGND 0.39999f
C8583 a_5024_9278# VGND 0.04449f ; **FLOATING
C8584 sg13cmos5l_inv_1_467.A VGND 0.345f
C8585 a_3488_9278# VGND 0.04468f ; **FLOATING
C8586 a_3304_9278# VGND 0.11566f ; **FLOATING
C8587 sg13cmos5l_inv_1_985.Y VGND 0.5601f
C8588 a_800_9278# VGND 0.08014f ; **FLOATING
C8589 sg13cmos5l_inv_1_990.Y VGND 0.35414f
C8590 sg13cmos5l_inv_1_350.Y VGND 0.3534f
C8591 sg13cmos5l_buf_1_27.X VGND 0.11469f
C8592 a_18176_10074# VGND 0.04413f ; **FLOATING
C8593 a_17504_10074# VGND 0.04017f ; **FLOATING
C8594 a_16744_10074# VGND 0.08357f ; **FLOATING
C8595 a_13472_10074# VGND 0.06455f ; **FLOATING
C8596 sg13cmos5l_inv_1_994.Y VGND 0.17971f
C8597 sg13cmos5l_inv_1_929.A VGND 0.34673f
C8598 sg13cmos5l_inv_1_930.A VGND 0.20719f
C8599 sg13cmos5l_inv_1_931.Y VGND 0.13759f
C8600 sg13cmos5l_inv_1_933.Y VGND 0.13263f
C8601 sg13cmos5l_inv_1_936.A VGND 0.31231f
C8602 sg13cmos5l_inv_1_937.Y VGND 0.26281f
C8603 a_11656_10074# VGND 0.08334f ; **FLOATING
C8604 sg13cmos5l_inv_1_959.A VGND 0.29399f
C8605 a_10551_10240# VGND 0.62683f
C8606 a_10050_10240# VGND 0.26669f
C8607 a_9948_10240# VGND 0.98099f
C8608 a_9846_10240# VGND 0.98126f
C8609 a_9544_10074# VGND 0.08981f ; **FLOATING
C8610 a_8919_10240# VGND 0.31011f
C8611 a_8805_10240# VGND 0.40525f
C8612 a_8576_10074# VGND 0.04365f ; **FLOATING
C8613 sg13cmos5l_inv_1_941.A VGND 0.11261f
C8614 sg13cmos5l_mux2_1_0.X VGND 0.76419f
C8615 sg13cmos5l_nor3_1_1.Y VGND 0.31011f
C8616 sg13cmos5l_buf_1_12.X VGND 0.09582f
C8617 a_9260_9906# VGND 0.06467f
C8618 sg13cmos5l_mux2_1_1.X VGND 0.28193f
C8619 sg13cmos5l_inv_1_980.A VGND 0.30764f
C8620 sg13cmos5l_inv_1_922.Y VGND 0.30705f
C8621 a_6656_10074# VGND 0.04458f ; **FLOATING
C8622 a_4736_10074# VGND 0.08657f ; **FLOATING
C8623 sg13cmos5l_inv_1_983.Y VGND 0.29023f
C8624 a_3680_10074# VGND 0.05708f ; **FLOATING
C8625 sg13cmos5l_inv_1_1012.Y VGND 0.21012f
C8626 sg13cmos5l_inv_1_973.Y VGND 0.34939f
C8627 a_19136_10790# VGND 0.0804f ; **FLOATING
C8628 sg13cmos5l_inv_1_694.Y VGND 0.36119f
C8629 sg13cmos5l_inv_1_1000.Y VGND 0.18639f
C8630 a_17216_10790# VGND 0.04228f ; **FLOATING
C8631 a_16256_10790# VGND 0.04423f ; **FLOATING
C8632 a_15584_10790# VGND 0.04049f ; **FLOATING
C8633 sg13cmos5l_mux4_1_15.A3 VGND 0.35668f
C8634 a_13472_10790# VGND 0.04253f ; **FLOATING
C8635 a_13288_10790# VGND 0.11341f ; **FLOATING
C8636 sg13cmos5l_inv_1_703.Y VGND 0.17795f
C8637 sg13cmos5l_inv_1_901.Y VGND 0.26592f
C8638 sg13cmos5l_inv_1_734.A VGND 0.64158f
C8639 a_12808_10790# VGND 0.11654f ; **FLOATING
C8640 sg13cmos5l_inv_1_731.A VGND 0.38324f
C8641 a_10880_10790# VGND 0.08534f ; **FLOATING
C8642 sg13cmos5l_inv_1_738.Y VGND 0.47456f
C8643 sg13cmos5l_inv_1_737.A VGND 0.18579f
C8644 sg13cmos5l_inv_1_735.Y VGND 0.33334f
C8645 a_9064_10790# VGND 0.08215f ; **FLOATING
C8646 a_8200_10790# VGND 0.08333f ; **FLOATING
C8647 a_4640_10790# VGND 0.0447f ; **FLOATING
C8648 sg13cmos5l_inv_1_484.Y VGND 0.2016f
C8649 sg13cmos5l_inv_1_472.Y VGND 0.32065f
C8650 sg13cmos5l_inv_1_474.Y VGND 0.20135f
C8651 sg13cmos5l_inv_1_475.Y VGND 0.27681f
C8652 sg13cmos5l_inv_1_663.Y VGND 0.17775f
C8653 sg13cmos5l_inv_1_662.Y VGND 0.3318f
C8654 sg13cmos5l_inv_1_926.Y VGND 0.15866f
C8655 a_3592_10790# VGND 0.10088f ; **FLOATING
C8656 sg13cmos5l_inv_1_502.Y VGND 0.42417f
C8657 a_2816_10790# VGND 0.0408f ; **FLOATING
C8658 a_2632_10790# VGND 0.0852f ; **FLOATING
C8659 a_2152_10790# VGND 0.08545f ; **FLOATING
C8660 a_808_10790# VGND 0.11942f ; **FLOATING
C8661 sg13cmos5l_inv_1_504.A VGND 0.14449f
C8662 sg13cmos5l_inv_1_950.Y VGND 0.38198f
C8663 a_19136_11586# VGND 0.08007f ; **FLOATING
C8664 a_18464_11586# VGND 0.04432f ; **FLOATING
C8665 a_17416_11586# VGND 0.08571f ; **FLOATING
C8666 a_15076_11458# VGND 0.30752f
C8667 sg13cmos5l_inv_1_717.A VGND 0.09247f
C8668 a_15475_11725# VGND 0.28113f
C8669 a_15283_11725# VGND 1.25426f
C8670 sg13cmos5l_inv_1_723.Y VGND 0.38788f
C8671 sg13cmos5l_inv_1_713.A VGND 0.37405f
C8672 sg13cmos5l_inv_1_730.Y VGND 0.31936f
C8673 sg13cmos5l_inv_1_699.Y VGND 0.37615f
C8674 sg13cmos5l_mux4_1_15.X VGND 0.11335f
C8675 a_15056_11771# VGND 0.02913f
C8676 a_14773_11771# VGND 0.61903f
C8677 a_14389_11500# VGND 0.87522f
C8678 a_14360_11776# VGND 1.38758f
C8679 a_13856_11586# VGND 0.04366f ; **FLOATING
C8680 a_13472_11586# VGND 0.0407f ; **FLOATING
C8681 a_13288_11586# VGND 0.10398f ; **FLOATING
C8682 a_12808_11586# VGND 0.09812f ; **FLOATING
C8683 sg13cmos5l_inv_1_731.Y VGND 0.30586f
C8684 a_10880_11586# VGND 0.05977f ; **FLOATING
C8685 a_9919_11500# VGND 0.83526f
C8686 a_9825_11776# VGND 1.14956f
C8687 sg13cmos5l_inv_1_748.Y VGND 0.33041f
C8688 sg13cmos5l_inv_1_736.Y VGND 0.1913f
C8689 a_9996_11500# VGND 0.97726f
C8690 a_9454_11832# VGND 0.15169f
C8691 a_9160_11586# VGND 0.08596f ; **FLOATING
C8692 a_8897_11480# VGND 0.12563f
C8693 a_8417_11480# VGND 0.11059f
C8694 a_8795_11752# VGND 1.19802f
C8695 a_8315_11752# VGND 1.22688f
C8696 a_8096_11586# VGND 0.03735f ; **FLOATING
C8697 a_7912_11586# VGND 0.12122f ; **FLOATING
C8698 a_9360_11832# VGND 0.02913f
C8699 a_5984_11586# VGND 0.04344f ; **FLOATING
C8700 sg13cmos5l_inv_1_487.A VGND 0.36477f
C8701 sg13cmos5l_inv_1_507.A VGND 0.23684f
C8702 sg13cmos5l_inv_1_518.Y VGND 0.29563f
C8703 sg13cmos5l_inv_1_520.A VGND 0.28795f
C8704 a_2816_11586# VGND 0.03826f ; **FLOATING
C8705 a_2632_11586# VGND 0.09337f ; **FLOATING
C8706 a_1664_11586# VGND 0.04409f ; **FLOATING
C8707 sg13cmos5l_inv_1_517.A VGND 0.33954f
C8708 sg13cmos5l_inv_1_515.Y VGND 0.31964f
C8709 sg13cmos5l_inv_1_514.Y VGND 0.19677f
C8710 sg13cmos5l_inv_1_514.A VGND 0.27557f
C8711 a_19048_12302# VGND 0.1183f ; **FLOATING
C8712 a_18088_12302# VGND 0.08505f ; **FLOATING
C8713 sg13cmos5l_inv_1_714.A VGND 0.168f
C8714 sg13cmos5l_inv_1_724.Y VGND 0.11395f
C8715 a_15584_12302# VGND 0.04325f ; **FLOATING
C8716 a_14645_12221# VGND 0.80863f
C8717 sg13cmos5l_inv_1_702.Y VGND 0.31357f
C8718 a_13472_12302# VGND 0.04277f ; **FLOATING
C8719 a_13288_12302# VGND 0.10398f ; **FLOATING
C8720 a_14559_12606# VGND 0.22148f
C8721 a_14036_12606# VGND 0.75481f
C8722 a_13918_12606# VGND 0.01958f
C8723 a_14422_12606# VGND 2.2074f
C8724 a_12808_12302# VGND 0.09812f ; **FLOATING
C8725 a_11656_12302# VGND 0.0831f ; **FLOATING
C8726 sg13cmos5l_inv_1_747.Y VGND 0.09019f
C8727 a_11264_12302# VGND 0.04288f ; **FLOATING
C8728 a_8383_12192# VGND 0.43f
C8729 a_8192_12302# VGND 0.0366f ; **FLOATING
C8730 a_8008_12302# VGND 0.07435f ; **FLOATING
C8731 sg13cmos5l_inv_1_751.A VGND 0.31304f
C8732 sg13cmos5l_inv_1_987.A VGND 0.13621f
C8733 sg13cmos5l_inv_1_492.A VGND 0.31206f
C8734 a_8654_12608# VGND 0.74844f
C8735 a_8383_12608# VGND 0.1877f
C8736 a_6464_12302# VGND 0.04386f ; **FLOATING
C8737 a_4661_12221# VGND 0.58526f
C8738 a_4141_12267# VGND 0.43086f
C8739 a_3847_12267# VGND 0.65603f
C8740 sg13cmos5l_inv_1_485.Y VGND 0.31602f
C8741 a_3488_12302# VGND 0.04362f ; **FLOATING
C8742 a_3304_12302# VGND 0.11807f ; **FLOATING
C8743 sg13cmos5l_inv_1_483.Y VGND 0.32586f
C8744 a_4575_12606# VGND 0.20624f
C8745 a_4362_12606# VGND 0.35067f
C8746 a_4052_12606# VGND 0.31803f
C8747 a_3934_12606# VGND 0.45194f
C8748 a_4438_12606# VGND 2.33384f
C8749 a_2912_12302# VGND 0.06083f ; **FLOATING
C8750 sg13cmos5l_inv_1_504.Y VGND 0.27788f
C8751 sg13cmos5l_inv_1_526.Y VGND 0.17796f
C8752 sg13cmos5l_inv_1_527.A VGND 0.32094f
C8753 a_19048_13098# VGND 0.12099f ; **FLOATING
C8754 a_17896_13098# VGND 0.08447f ; **FLOATING
C8755 a_17128_13098# VGND 0.12728f ; **FLOATING
C8756 sg13cmos5l_inv_1_707.A VGND 0.41431f
C8757 a_13472_13098# VGND 0.04298f ; **FLOATING
C8758 a_13288_13098# VGND 0.10398f ; **FLOATING
C8759 a_12808_13098# VGND 0.10204f ; **FLOATING
C8760 sg13cmos5l_inv_1_753.A VGND 0.27386f
C8761 a_10592_13098# VGND 0.04355f ; **FLOATING
C8762 a_10208_13098# VGND 0.04244f ; **FLOATING
C8763 a_6836_12970# VGND 0.41736f
C8764 sg13cmos5l_inv_1_739.A VGND 0.55081f
C8765 sg13cmos5l_inv_1_744.Y VGND 0.13626f
C8766 sg13cmos5l_inv_1_741.Y VGND 0.19256f
C8767 a_7414_12970# VGND 2.03703f
C8768 a_6910_12970# VGND 0.55107f
C8769 a_6823_13237# VGND 0.41075f
C8770 a_7333_13237# VGND 2.28478f
C8771 a_6376_13098# VGND 0.08717f ; **FLOATING
C8772 a_5408_13098# VGND 0.04513f ; **FLOATING
C8773 a_4701_12970# VGND 0.23479f
C8774 sg13cmos5l_a22oi_1_0.B1 VGND 0.64096f
C8775 a_4975_13264# VGND 0.10337f
C8776 a_4701_13264# VGND 0.43145f
C8777 a_4264_13098# VGND 0.08382f ; **FLOATING
C8778 sg13cmos5l_inv_1_482.Y VGND 0.3041f
C8779 sg13cmos5l_inv_1_478.A VGND 0.22454f
C8780 sg13cmos5l_mux4_1_9.X VGND 0.6281f
C8781 a_3872_13098# VGND 0.08704f ; **FLOATING
C8782 sg13cmos5l_inv_1_532.A VGND 0.08772f
C8783 a_2816_13098# VGND 0.04127f ; **FLOATING
C8784 a_2632_13098# VGND 0.08567f ; **FLOATING
C8785 a_2240_13098# VGND 0.04334f ; **FLOATING
C8786 sg13cmos5l_inv_1_525.A VGND 0.26767f
C8787 a_1192_13098# VGND 0.08792f ; **FLOATING
C8788 sg13cmos5l_inv_1_509.A VGND 0.43957f
C8789 a_19048_13814# VGND 0.13262f ; **FLOATING
C8790 a_13472_13814# VGND 0.04566f ; **FLOATING
C8791 a_13288_13814# VGND 0.10679f ; **FLOATING
C8792 sg13cmos5l_inv_1_711.Y VGND 0.20344f
C8793 sg13cmos5l_inv_1_891.Y VGND 0.34825f
C8794 sg13cmos5l_inv_1_894.Y VGND 0.35874f
C8795 sg13cmos5l_inv_1_892.Y VGND 0.49241f
C8796 sg13cmos5l_inv_1_914.A VGND 0.34584f
C8797 sg13cmos5l_inv_1_913.A VGND 0.31385f
C8798 sg13cmos5l_inv_1_912.A VGND 0.47379f
C8799 sg13cmos5l_inv_1_909.A VGND 0.18076f
C8800 a_12896_13814# VGND 0.06409f ; **FLOATING
C8801 a_11176_13814# VGND 0.11687f ; **FLOATING
C8802 sg13cmos5l_inv_1_904.A VGND 0.43992f
C8803 a_10112_13814# VGND 0.06367f ; **FLOATING
C8804 a_6664_13814# VGND 0.09292f ; **FLOATING
C8805 sg13cmos5l_inv_1_648.Y VGND 0.26905f
C8806 sg13cmos5l_inv_1_649.Y VGND 0.43661f
C8807 sg13cmos5l_inv_1_650.A VGND 0.44643f
C8808 sg13cmos5l_inv_1_652.Y VGND 0.34745f
C8809 sg13cmos5l_inv_1_655.Y VGND 0.54418f
C8810 a_5984_13814# VGND 0.05065f ; **FLOATING
C8811 sg13cmos5l_inv_1_676.Y VGND 0.36535f
C8812 a_5024_13814# VGND 0.04813f ; **FLOATING
C8813 sg13cmos5l_inv_1_671.A VGND 0.48015f
C8814 a_3488_13814# VGND 0.04674f ; **FLOATING
C8815 a_3304_13814# VGND 0.12186f ; **FLOATING
C8816 sg13cmos5l_inv_1_674.A VGND 0.46554f
C8817 sg13cmos5l_inv_1_669.A VGND 0.35326f
C8818 sg13cmos5l_inv_1_522.A VGND 0.83858f
C8819 a_1576_13814# VGND 0.10109f ; **FLOATING
C8820 sg13cmos5l_mux4_1_9.A0 VGND 0.23523f
C8821 a_808_13814# VGND 0.133f ; **FLOATING
C8822 a_17512_14610# VGND 0.08863f ; **FLOATING
C8823 a_16456_14610# VGND 0.08238f ; **FLOATING
C8824 a_14559_14482# VGND 0.08872f
C8825 a_14346_14482# VGND 0.45057f
C8826 a_14036_14482# VGND 0.08471f
C8827 sg13cmos5l_inv_1_873.A VGND 0.23948f
C8828 sg13cmos5l_inv_1_879.A VGND 0.16752f
C8829 sg13cmos5l_inv_1_878.A VGND 0.09053f
C8830 a_14913_14524# VGND 0.35663f
C8831 a_14645_14795# VGND 0.8162f
C8832 a_14422_14482# VGND 1.63354f
C8833 a_13918_14482# VGND 0.38131f
C8834 a_13831_14749# VGND 0.44229f
C8835 sg13cmos5l_mux4_1_14.A3 VGND 0.09722f
C8836 a_13472_14610# VGND 0.0428f ; **FLOATING
C8837 a_13288_14610# VGND 0.10398f ; **FLOATING
C8838 sg13cmos5l_inv_1_902.Y VGND 0.32087f
C8839 a_11936_14610# VGND 0.04533f ; **FLOATING
C8840 sg13cmos5l_inv_1_908.A VGND 0.40104f
C8841 a_10888_14610# VGND 0.0946f ; **FLOATING
C8842 sg13cmos5l_inv_1_948.A VGND 0.20481f
C8843 sg13cmos5l_inv_1_693.A VGND 0.09104f
C8844 sg13cmos5l_inv_1_692.A VGND 0.34846f
C8845 sg13cmos5l_inv_1_640.A VGND 0.17554f
C8846 sg13cmos5l_mux4_1_7.A3 VGND 0.1473f
C8847 sg13cmos5l_inv_1_635.A VGND 0.24299f
C8848 sg13cmos5l_inv_1_633.A VGND 0.13367f
C8849 sg13cmos5l_inv_1_631.A VGND 0.15488f
C8850 sg13cmos5l_inv_1_683.A VGND 0.32047f
C8851 a_1376_14610# VGND 0.04488f ; **FLOATING
C8852 sg13cmos5l_inv_1_668.A VGND 0.12923f
C8853 sg13cmos5l_inv_1_510.Y VGND 0.34127f
C8854 sg13cmos5l_inv_1_689.Y VGND 0.15067f
C8855 a_19136_15326# VGND 0.08056f ; **FLOATING
C8856 sg13cmos5l_inv_1_875.A VGND 0.39908f
C8857 a_17224_15326# VGND 0.08567f ; **FLOATING
C8858 sg13cmos5l_inv_1_816.Y VGND 0.2905f
C8859 a_16256_15326# VGND 0.05875f ; **FLOATING
C8860 a_14413_15291# VGND 0.41379f
C8861 a_14119_15291# VGND 0.18323f
C8862 sg13cmos5l_inv_1_868.A VGND 0.3882f
C8863 a_15201_15588# VGND 0.11708f
C8864 a_14634_15630# VGND 1.10968f
C8865 a_14206_15630# VGND 0.13749f
C8866 a_14132_15630# VGND 0.4713f
C8867 a_13472_15326# VGND 0.0407f ; **FLOATING
C8868 a_13288_15326# VGND 0.10398f ; **FLOATING
C8869 a_14710_15630# VGND 2.06642f
C8870 a_12896_15326# VGND 0.06033f ; **FLOATING
C8871 sg13cmos5l_inv_1_883.A VGND 0.3363f
C8872 sg13cmos5l_inv_1_916.A VGND 0.32781f
C8873 sg13cmos5l_inv_1_768.A VGND 0.13869f
C8874 a_8672_15326# VGND 0.03947f ; **FLOATING
C8875 sg13cmos5l_inv_1_642.Y VGND 0.14276f
C8876 a_8288_15326# VGND 0.08609f ; **FLOATING
C8877 sg13cmos5l_inv_1_625.Y VGND 0.35327f
C8878 a_7232_15326# VGND 0.08386f ; **FLOATING
C8879 sg13cmos5l_inv_1_684.A VGND 0.21133f
C8880 a_4936_15326# VGND 0.07743f ; **FLOATING
C8881 a_3680_15326# VGND 0.06162f ; **FLOATING
C8882 sg13cmos5l_inv_1_682.A VGND 0.3149f
C8883 sg13cmos5l_inv_1_534.A VGND 0.58064f
C8884 a_2152_15326# VGND 0.08405f ; **FLOATING
C8885 a_1228_15240# VGND 0.44697f
C8886 a_1594_15610# VGND 0.64564f
C8887 a_808_15326# VGND 0.1175f ; **FLOATING
C8888 a_19048_16122# VGND 0.12121f ; **FLOATING
C8889 sg13cmos5l_mux4_1_13.A3 VGND 0.125f
C8890 a_17984_16122# VGND 0.04244f ; **FLOATING
C8891 a_17312_16122# VGND 0.0445f ; **FLOATING
C8892 a_13472_16122# VGND 0.0407f ; **FLOATING
C8893 a_13288_16122# VGND 0.10398f ; **FLOATING
C8894 sg13cmos5l_inv_1_815.Y VGND 0.31751f
C8895 sg13cmos5l_inv_1_858.Y VGND 0.08744f
C8896 sg13cmos5l_inv_1_857.A VGND 0.2638f
C8897 sg13cmos5l_inv_1_846.Y VGND 0.26373f
C8898 sg13cmos5l_inv_1_845.Y VGND 0.08934f
C8899 a_12136_16122# VGND 0.08497f ; **FLOATING
C8900 a_8010_15994# VGND 0.40848f
C8901 a_7700_15994# VGND 0.91451f
C8902 a_7508_15994# VGND 0.33881f
C8903 sg13cmos5l_inv_1_798.A VGND 0.19605f
C8904 sg13cmos5l_inv_1_786.Y VGND 0.27364f
C8905 sg13cmos5l_inv_1_797.A VGND 0.26767f
C8906 sg13cmos5l_inv_1_995.Y VGND 0.27166f
C8907 sg13cmos5l_inv_1_616.A VGND 0.39891f
C8908 a_8086_15994# VGND 1.55594f
C8909 a_7582_15994# VGND 0.79382f
C8910 a_7495_16261# VGND 0.4079f
C8911 sg13cmos5l_inv_1_619.Y VGND 0.08872f
C8912 a_6848_16122# VGND 0.04302f ; **FLOATING
C8913 a_6176_16122# VGND 0.04307f ; **FLOATING
C8914 a_4575_15994# VGND 0.42456f
C8915 a_4362_15994# VGND 0.81967f
C8916 a_4052_15994# VGND 0.65244f
C8917 a_3860_15994# VGND 0.30923f
C8918 sg13cmos5l_mux2_1_2.A0 VGND 0.34234f
C8919 sg13cmos5l_inv_1_622.Y VGND 0.269f
C8920 sg13cmos5l_inv_1_624.Y VGND 0.25084f
C8921 a_4438_15994# VGND 2.19541f
C8922 a_3934_15994# VGND 0.02056f
C8923 a_3847_16261# VGND 0.31552f
C8924 a_4357_16261# VGND 0.56235f
C8925 a_3488_16122# VGND 0.04675f ; **FLOATING
C8926 a_3304_16122# VGND 0.11641f ; **FLOATING
C8927 sg13cmos5l_mux4_1_5.S0 VGND 16.88483f
C8928 a_1952_16122# VGND 0.04409f ; **FLOATING
C8929 sg13cmos5l_inv_1_563.Y VGND 0.20741f
C8930 a_1192_16122# VGND 0.08561f ; **FLOATING
C8931 sg13cmos5l_nor2b_1_0.A VGND 0.13425f
C8932 a_18664_16838# VGND 0.0834f ; **FLOATING
C8933 a_18184_16838# VGND 0.08402f ; **FLOATING
C8934 a_13472_16838# VGND 0.0407f ; **FLOATING
C8935 a_13288_16838# VGND 0.10398f ; **FLOATING
C8936 sg13cmos5l_inv_1_850.Y VGND 0.33093f
C8937 sg13cmos5l_inv_1_854.Y VGND 0.17613f
C8938 sg13cmos5l_inv_1_855.Y VGND 0.26458f
C8939 sg13cmos5l_inv_1_863.Y VGND 0.31221f
C8940 sg13cmos5l_inv_1_792.Y VGND 0.2209f
C8941 a_12896_16838# VGND 0.06042f ; **FLOATING
C8942 sg13cmos5l_inv_1_811.Y VGND 0.47415f
C8943 a_11464_16838# VGND 0.08592f ; **FLOATING
C8944 sg13cmos5l_inv_1_800.A VGND 0.17868f
C8945 sg13cmos5l_inv_1_794.A VGND 0.33279f
C8946 a_10496_16838# VGND 0.04144f ; **FLOATING
C8947 sg13cmos5l_inv_1_789.Y VGND 0.18052f
C8948 a_9536_16838# VGND 0.05992f ; **FLOATING
C8949 sg13cmos5l_inv_1_975.A VGND 0.45722f
C8950 sg13cmos5l_inv_1_580.A VGND 0.29477f
C8951 a_8192_16838# VGND 0.04395f ; **FLOATING
C8952 sg13cmos5l_inv_1_618.A VGND 0.45187f
C8953 a_7144_16838# VGND 0.08256f ; **FLOATING
C8954 sg13cmos5l_mux4_1_8.A2 VGND 0.38289f
C8955 a_5600_16838# VGND 0.04461f ; **FLOATING
C8956 sg13cmos5l_inv_1_609.A VGND 0.32738f
C8957 a_4264_16838# VGND 0.08266f ; **FLOATING
C8958 sg13cmos5l_inv_1_560.A VGND 0.37444f
C8959 sg13cmos5l_mux4_1_10.A2 VGND 0.18162f
C8960 a_800_16838# VGND 0.0804f ; **FLOATING
C8961 sg13cmos5l_inv_1_575.Y VGND 0.18356f
C8962 sg13cmos5l_inv_1_572.A VGND 0.26717f
C8963 a_17896_17634# VGND 0.08582f ; **FLOATING
C8964 a_16840_17634# VGND 0.08271f ; **FLOATING
C8965 sg13cmos5l_inv_1_851.A VGND 0.41662f
C8966 sg13cmos5l_inv_1_841.Y VGND 0.39013f
C8967 sg13cmos5l_inv_1_827.A VGND 0.33148f
C8968 a_13472_17634# VGND 0.04253f ; **FLOATING
C8969 a_13288_17634# VGND 0.1057f ; **FLOATING
C8970 sg13cmos5l_inv_1_890.A VGND 0.4515f
C8971 a_12136_17634# VGND 0.08378f ; **FLOATING
C8972 sg13cmos5l_inv_1_806.Y VGND 0.69044f
C8973 sg13cmos5l_inv_1_804.A VGND 0.16866f
C8974 a_11456_17634# VGND 0.04466f ; **FLOATING
C8975 a_10784_17634# VGND 0.08557f ; **FLOATING
C8976 sg13cmos5l_inv_1_809.Y VGND 0.47903f
C8977 sg13cmos5l_inv_1_775.Y VGND 0.48571f
C8978 a_9440_17634# VGND 0.04451f ; **FLOATING
C8979 a_8680_17634# VGND 0.09892f ; **FLOATING
C8980 a_6752_17634# VGND 0.04429f ; **FLOATING
C8981 a_4928_17634# VGND 0.04305f ; **FLOATING
C8982 sg13cmos5l_inv_1_535.A VGND 0.47251f
C8983 a_3680_17634# VGND 0.06172f ; **FLOATING
C8984 sg13cmos5l_inv_1_626.Y VGND 0.22651f
C8985 sg13cmos5l_inv_1_612.Y VGND 0.28012f
C8986 sg13cmos5l_inv_1_589.Y VGND 0.14249f
C8987 sg13cmos5l_inv_1_610.Y VGND 0.25701f
C8988 sg13cmos5l_inv_1_553.A VGND 0.18245f
C8989 sg13cmos5l_inv_1_568.Y VGND 0.18535f
C8990 sg13cmos5l_inv_1_544.Y VGND 0.18268f
C8991 a_800_17634# VGND 0.08074f ; **FLOATING
C8992 sg13cmos5l_inv_1_571.Y VGND 0.26731f
C8993 sg13cmos5l_inv_1_545.A VGND 0.14415f
C8994 a_19048_18350# VGND 0.12203f ; **FLOATING
C8995 a_17888_18350# VGND 0.04306f ; **FLOATING
C8996 a_18764_18228# VGND 0.13555f
C8997 a_18280_18264# VGND 0.19082f
C8998 sg13cmos5l_inv_1_834.Y VGND 0.36213f
C8999 sg13cmos5l_inv_1_823.A VGND 0.12807f
C9000 sg13cmos5l_inv_1_819.A VGND 0.2848f
C9001 a_13472_18350# VGND 0.04357f ; **FLOATING
C9002 a_13288_18350# VGND 0.10661f ; **FLOATING
C9003 sg13cmos5l_inv_1_837.Y VGND 0.15366f
C9004 sg13cmos5l_inv_1_823.Y VGND 0.26279f
C9005 sg13cmos5l_inv_1_821.A VGND 0.36169f
C9006 sg13cmos5l_inv_1_780.Y VGND 0.11335f
C9007 a_12808_18350# VGND 0.11261f ; **FLOATING
C9008 sg13cmos5l_inv_1_782.A VGND 0.17936f
C9009 a_10592_18350# VGND 0.04368f ; **FLOATING
C9010 a_10408_18350# VGND 0.08786f ; **FLOATING
C9011 sg13cmos5l_inv_1_774.Y VGND 0.3531f
C9012 sg13cmos5l_inv_1_608.A VGND 0.39415f
C9013 a_9440_18350# VGND 0.0388f ; **FLOATING
C9014 a_9256_18350# VGND 0.08106f ; **FLOATING
C9015 sg13cmos5l_inv_1_606.A VGND 0.18744f
C9016 sg13cmos5l_inv_1_598.A VGND 0.07371f
C9017 a_5320_18350# VGND 0.08782f ; **FLOATING
C9018 sg13cmos5l_inv_1_604.Y VGND 0.10577f
C9019 sg13cmos5l_inv_1_605.Y VGND 0.13611f
C9020 sg13cmos5l_inv_1_599.Y VGND 0.22607f
C9021 sg13cmos5l_inv_1_595.Y VGND 0.35995f
C9022 sg13cmos5l_inv_1_585.Y VGND 0.36681f
C9023 a_3488_18350# VGND 0.04616f ; **FLOATING
C9024 a_3304_18350# VGND 0.11697f ; **FLOATING
C9025 sg13cmos5l_inv_1_556.Y VGND 0.28556f
C9026 sg13cmos5l_inv_1_551.Y VGND 0.4517f
C9027 sg13cmos5l_inv_1_564.Y VGND 0.18968f
C9028 sg13cmos5l_inv_1_545.Y VGND 0.26127f
C9029 sg13cmos5l_inv_1_553.Y VGND 0.3414f
C9030 a_808_18264# VGND 0.1954f
C9031 sg13cmos5l_mux4_1_5.S0.n0 VGND 5.85287f
C9032 sg13cmos5l_mux4_1_5.S0.t0 VGND 4.84441f
C9033 sg13cmos5l_mux4_1_5.S0.n1 VGND 3.76163f
C9034 sg13cmos5l_mux4_1_5.S0.n2 VGND 4.53465f
C9035 sg13cmos5l_mux4_1_5.S0.n3 VGND 2.97296f
C9036 sg13cmos5l_mux4_1_5.S0.n4 VGND 2.60545f
C9037 sg13cmos5l_mux4_1_5.S0.n5 VGND 2.69899f
C9038 sg13cmos5l_buf_1_9.A.t0 VGND 0.46957f
C9039 sg13cmos5l_buf_1_9.A.n0 VGND 4.73047f
C9040 sg13cmos5l_buf_1_9.A.n1 VGND 1.17826f
C9041 sg13cmos5l_buf_1_9.A.n2 VGND 2.47528f
C9042 sg13cmos5l_buf_1_9.A.n3 VGND 3.16166f
C9043 sg13cmos5l_buf_1_9.A.n4 VGND 3.03216f
C9044 sg13cmos5l_buf_1_9.A.n5 VGND 6.71907f
C9045 sg13cmos5l_buf_1_9.A.n6 VGND 5.84364f
C9046 sg13cmos5l_mux2_1_4.S.n0 VGND 5.97526f
C9047 sg13cmos5l_mux2_1_4.S.n1 VGND 4.13649f
C9048 sg13cmos5l_mux2_1_4.S.n2 VGND 2.1068f
C9049 sg13cmos5l_mux2_1_4.S.n3 VGND 4.17811f
C9050 sg13cmos5l_mux2_1_4.S.n4 VGND 3.33603f
C9051 sg13cmos5l_mux2_1_4.S.n5 VGND 2.98799f
C9052 sg13cmos5l_mux2_1_4.S.t0 VGND 0.46643f
C9053 sg13cmos5l_nor3_1_2.B.t0 VGND 0.65927f
C9054 sg13cmos5l_nor3_1_2.B.n0 VGND 1.58107f
C9055 sg13cmos5l_nor3_1_2.B.n1 VGND 5.3807f
C9056 sg13cmos5l_nor3_1_2.B.n2 VGND 2.79839f
C9057 sg13cmos5l_nor3_1_2.B.n3 VGND 4.96762f
C9058 sg13cmos5l_buf_1_8.A.t0 VGND 0.34953f
C9059 sg13cmos5l_buf_1_8.A.n0 VGND 5.44617f
C9060 sg13cmos5l_buf_1_8.A.n1 VGND 6.90237f
C9061 sg13cmos5l_buf_1_8.A.n2 VGND 4.43267f
C9062 sg13cmos5l_buf_1_8.A.n3 VGND 5.8515f
C9063 sg13cmos5l_mux4_1_5.S1.t0 VGND 3.39783f
C9064 sg13cmos5l_mux4_1_5.S1.n0 VGND 6.11351f
C9065 sg13cmos5l_mux4_1_5.S1.n1 VGND 3.64079f
C9066 sg13cmos5l_mux4_1_5.S1.n2 VGND 2.14714f
C9067 sg13cmos5l_mux4_1_5.S1.n3 VGND 3.69938f
C9068 sg13cmos5l_mux4_1_5.S1.n4 VGND 3.74357f
C9069 sg13cmos5l_mux4_1_5.S1.n5 VGND 3.68301f
C9070 sg13cmos5l_mux4_1_5.S1.n6 VGND 3.27173f
C9071 VGND.t335 VGND 2.68396f
C9072 VGND.t1369 VGND 0.35871f
C9073 VGND.t54 VGND 0.37286f
C9074 VGND.t288 VGND 0.71279f
C9075 VGND.t43 VGND 2.90373f
C9076 VGND.t78 VGND 0.42752f
C9077 VGND.t435 VGND 1.57664f
C9078 VGND.t1274 VGND 0.58381f
C9079 VGND.t28 VGND 3.55505f
C9080 VGND.t428 VGND 0.26572f
C9081 VGND.t396 VGND 4.04769f
C9082 VGND.t242 VGND 0.21964f
C9083 VGND.t19 VGND 3.31136f
C9084 VGND.t352 VGND 0.58626f
C9085 VGND.t246 VGND 0.78156f
C9086 VGND.t240 VGND 0.83084f
C9087 VGND.t244 VGND 0.95244f
C9088 VGND.t536 VGND 0.88067f
C9089 VGND.t1272 VGND 0.14544f
C9090 VGND.t492 VGND 0.6505f
C9091 VGND.t1203 VGND 0.24646f
C9092 VGND.t256 VGND 1.45643f
C9093 VGND.t233 VGND 0.09861f
C9094 VGND.t16 VGND 2.09907f
C9095 VGND.t225 VGND 0.12838f
C9096 VGND.t212 VGND 0.76159f
C9097 VGND.t939 VGND 0.35546f
C9098 VGND.t134 VGND 0.43528f
C9099 VGND.t343 VGND 1.43f
C9100 VGND.t693 VGND 0.04088f
C9101 VGND.t440 VGND 0.82907f
C9102 VGND.t117 VGND 1.7204f
C9103 VGND.t1611 VGND 0.0493f
C9104 VGND.t1156 VGND 0.0493f
C9105 VGND.t449 VGND 1.07546f
C9106 VGND.t1588 VGND 0.0493f
C9107 VGND.t540 VGND 0.14791f
C9108 VGND.t430 VGND 0.0493f
C9109 VGND.t201 VGND 1.77057f
C9110 VGND.t614 VGND 0.98907f
C9111 VGND.t354 VGND 0.48825f
C9112 VGND.t1599 VGND 0.09962f
C9113 VGND.t947 VGND 0.13466f
C9114 VGND.t1 VGND 1.40139f
C9115 VGND.t157 VGND 0.49387f
C9116 VGND.t130 VGND 2.30967f
C9117 VGND.t165 VGND 0.98033f
C9118 VGND.t514 VGND 0.85912f
C9119 VGND.t8 VGND 1.37498f
C9120 VGND.t10 VGND 2.13686f
C9121 VGND.t1058 VGND 0.17408f
C9122 VGND.t149 VGND 1.60027f
C9123 VGND.t6 VGND 0.27107f
C9124 VGND.t191 VGND 4.17283f
C9125 VGND.t5 VGND 1.90603f
C9126 VGND.t1072 VGND 0.23058f
C9127 VGND.t1529 VGND 0.09962f
C9128 VGND.t322 VGND 1.03197f
C9129 VGND.t160 VGND 0.77649f
C9130 VGND.t102 VGND 0.7123f
C9131 VGND.t174 VGND 0.13621f
C9132 VGND.t480 VGND 0.53478f
C9133 VGND.t26 VGND 0.49089f
C9134 VGND.t155 VGND 0.47272f
C9135 VGND.t315 VGND 0.98863f
C9136 VGND.t876 VGND 0.43992f
C9137 VGND.t88 VGND 1.08979f
C9138 VGND.t250 VGND 2.52081f
C9139 VGND.t412 VGND 1.54193f
C9140 VGND.t723 VGND 1.45669f
C9141 VGND.t329 VGND 2.32352f
C9142 VGND.t437 VGND 0.60474f
C9143 VGND.t1521 VGND 0.09861f
C9144 VGND.t529 VGND 0.83858f
C9145 VGND.t987 VGND 0.84667f
C9146 VGND.t527 VGND 1.59217f
C9147 VGND.t503 VGND 1.44773f
C9148 VGND.t140 VGND 0.09861f
C9149 VGND.t100 VGND 1.7379f
C9150 VGND.t44 VGND 1.79095f
C9151 VGND.t56 VGND 0.61378f
C9152 VGND.t197 VGND 0.83882f
C9153 VGND.t567 VGND 0.09861f
C9154 VGND.t23 VGND 1.38941f
C9155 VGND.t116 VGND 1.77488f
C9156 VGND.t37 VGND 1.20968f
C9157 VGND.t363 VGND 0.61402f
C9158 VGND.t578 VGND 0.72261f
C9159 VGND.t1194 VGND 1.64471f
C9160 VGND.t69 VGND 0.80807f
C9161 VGND.t194 VGND 0.34098f
C9162 VGND.t325 VGND 1.21727f
C9163 VGND.t310 VGND 1.52193f
C9164 VGND.t558 VGND 1.83326f
C9165 VGND.t29 VGND 1.05205f
C9166 VGND.t587 VGND 1.46156f
C9167 VGND.t94 VGND 2.05928f
C9168 VGND.t1503 VGND 0.09861f
C9169 VGND.t263 VGND 3.72554f
C9170 VGND.t207 VGND 0.48033f
C9171 VGND.t1505 VGND 0.09962f
C9172 VGND.t1204 VGND 0.68856f
C9173 VGND.t1510 VGND 0.09962f
C9174 VGND.t670 VGND 0.37128f
C9175 VGND.t1513 VGND 0.09962f
C9176 VGND.t96 VGND 0.60145f
C9177 VGND.t171 VGND 1.73129f
C9178 VGND.t66 VGND 0.09861f
C9179 VGND.t59 VGND 0.43185f
C9180 VGND.t285 VGND 1.07021f
C9181 VGND.t35 VGND 3.29319f
C9182 VGND.t98 VGND 0.09962f
C9183 VGND.t1225 VGND 0.26767f
C9184 VGND.t92 VGND 6.24489f
C9185 VGND.t229 VGND 2.92098f
C9186 VGND.t345 VGND 0.47896f
C9187 VGND.t552 VGND 0.51793f
C9188 VGND.t1546 VGND 0.0493f
C9189 VGND.t854 VGND 0.33545f
C9190 VGND.t145 VGND 2.89444f
C9191 VGND.t444 VGND 0.67979f
C9192 VGND.t347 VGND 1.9098f
C9193 VGND.t41 VGND 0.09019f
C9194 VGND.t414 VGND 0.11433f
C9195 VGND.t269 VGND 1.27406f
C9196 VGND.t199 VGND 1.54452f
C9197 VGND.t147 VGND 2.58046f
C9198 VGND.t1097 VGND 0.19677f
C9199 VGND.t184 VGND 3.54428f
C9200 VGND.t39 VGND 0.09247f
C9201 VGND.t1163 VGND 0.34989f
C9202 VGND.t153 VGND 1.40732f
C9203 VGND.t143 VGND 2.22987f
C9204 VGND.t1564 VGND 0.14892f
C9205 VGND.t508 VGND 0.81971f
C9206 VGND.t971 VGND 0.09962f
C9207 VGND.t76 VGND 1.25319f
C9208 VGND.t342 VGND 0.04529f
C9209 VGND.t984 VGND 0.68352f
C9210 VGND.t1094 VGND 0.39299f
C9211 VGND.t360 VGND 0.38206f
C9212 VGND.t113 VGND 2.47202f
C9213 VGND.t214 VGND 1.20724f
C9214 VGND.t1628 VGND 0.09861f
C9215 VGND.t292 VGND 0.90339f
C9216 VGND.t621 VGND 2.2798f
C9217 VGND.t123 VGND 1.19087f
C9218 VGND.t64 VGND 1.36678f
C9219 VGND.t21 VGND 1.27588f
C9220 VGND.t547 VGND 0.31346f
C9221 VGND.t596 VGND 0.67035f
C9222 VGND.t373 VGND 0.34752f
C9223 VGND.t111 VGND 1.55999f
C9224 VGND.t617 VGND 0.26422f
C9225 VGND.t501 VGND 0.88103f
C9226 VGND.t399 VGND 0.75248f
C9227 VGND.t52 VGND 1.1802f
C9228 VGND.t610 VGND 0.40152f
C9229 VGND.t1626 VGND 0.0493f
C9230 VGND.t260 VGND 0.84978f
C9231 VGND.t119 VGND 0.5983f
C9232 VGND.t646 VGND 0.26358f
C9233 VGND.t248 VGND 0.8871f
C9234 VPWR.n1 VGND 0.5005f
C9235 VPWR.n2 VGND 0.06812f
C9236 VPWR.n3 VGND 0.05675f
C9237 VPWR.t26 VGND 40.7969f
C9238 VPWR.n4 VGND 0.09953f
C9239 VPWR.t42 VGND 39.7801f
C9240 VPWR.n5 VGND 0.09425f
C9241 VPWR.t49 VGND 40.4192f
C9242 VPWR.n6 VGND 0.06782f
C9243 VPWR.n7 VGND 0.1039f
C9244 VPWR.n8 VGND 0.77578f
C9245 VPWR.n9 VGND 0.09428f
C9246 VPWR.n10 VGND 0.74331f
C9247 VPWR.n11 VGND 0.05471f
C9248 VPWR.n13 VGND 0.09425f
C9249 VPWR.n14 VGND 0.09428f
C9250 VPWR.n15 VGND 0.17993f
C9251 VPWR.t0 VGND 39.7328f
C9252 VPWR.n16 VGND 0.12014f
C9253 VPWR.n17 VGND 0.05673f
C9254 VPWR.n18 VGND 0.7215f
C9255 VPWR.n19 VGND 0.096f
C9256 VPWR.n20 VGND 0.01038f
C9257 VPWR.n21 VGND 0.81497f
C9258 VPWR.n22 VGND 0.01183f
C9259 VPWR.n23 VGND 0.31886f
C9260 VPWR.n24 VGND 0.3948f
C9261 VPWR.t2 VGND 39.8318f
C9262 VPWR.n25 VGND 0.23566f
C9263 VPWR.n26 VGND 0.56371f
C9264 VPWR.n28 VGND 0.10235f
C9265 VPWR.n29 VGND 0.39815f
C9266 VPWR.n30 VGND 0.06526f
C9267 VPWR.n32 VGND 0.31714f
C9268 VPWR.n35 VGND 0.06721f
C9269 VPWR.n37 VGND 0.25246f
C9270 VPWR.n38 VGND 0.31606f
C9271 VPWR.n40 VGND 0.25922f
C9272 VPWR.n42 VGND 0.05567f
C9273 VPWR.n44 VGND 0.0858f
C9274 VPWR.n45 VGND 0.08581f
C9275 VPWR.n46 VGND 0.25333f
C9276 VPWR.n48 VGND 0.08763f
C9277 VPWR.t29 VGND 39.7811f
C9278 VPWR.n49 VGND 0.09428f
C9279 VPWR.n50 VGND 0.25676f
C9280 VPWR.n51 VGND 0.05393f
C9281 VPWR.n52 VGND 0.10053f
C9282 VPWR.n53 VGND 0.06721f
C9283 VPWR.n55 VGND 0.06634f
C9284 VPWR.n57 VGND 0.38594f
C9285 VPWR.n58 VGND 0.06667f
C9286 VPWR.n59 VGND 0.24844f
C9287 VPWR.n60 VGND 0.06667f
C9288 VPWR.n61 VGND 0.24844f
C9289 VPWR.n62 VGND 0.01539f
C9290 VPWR.n63 VGND 0.0858f
C9291 VPWR.n64 VGND 0.28022f
C9292 VPWR.n65 VGND 0.24781f
C9293 VPWR.n67 VGND 0.255f
C9294 VPWR.n69 VGND 0.07783f
C9295 VPWR.t14 VGND 39.7801f
C9296 VPWR.n71 VGND 0.07318f
C9297 VPWR.n73 VGND 0.24664f
C9298 VPWR.n74 VGND 0.12172f
C9299 VPWR.n76 VGND 0.24766f
C9300 VPWR.n77 VGND 0.19885f
C9301 VPWR.n79 VGND 0.07266f
C9302 VPWR.n80 VGND 0.19885f
C9303 VPWR.n82 VGND 0.1423f
C9304 VPWR.n83 VGND 0.09428f
C9305 VPWR.n84 VGND 0.28805f
C9306 VPWR.n86 VGND 0.05629f
C9307 VPWR.n87 VGND 0.0858f
C9308 VPWR.n88 VGND 0.27849f
C9309 VPWR.n90 VGND 0.02f
C9310 VPWR.n91 VGND 0.21948f
C9311 VPWR.n93 VGND 0.40698f
C9312 VPWR.n94 VGND 0.20666f
C9313 VPWR.n95 VGND 0.01221f
C9314 VPWR.n96 VGND 0.56394f
C9315 VPWR.n98 VGND 0.04899f
C9316 VPWR.n99 VGND 0.15728f
C9317 VPWR.n100 VGND 0.26289f
C9318 VPWR.n101 VGND 0.01029f
C9319 VPWR.n102 VGND 0.07891f
C9320 VPWR.n103 VGND 0.19538f
C9321 VPWR.n105 VGND 0.19439f
C9322 VPWR.n106 VGND 0.07947f
C9323 VPWR.n107 VGND 0.18717f
C9324 VPWR.n108 VGND 0.02479f
C9325 VPWR.n109 VGND 0.07165f
C9326 VPWR.n110 VGND 0.20931f
C9327 VPWR.n111 VGND 0.18825f
C9328 VPWR.n112 VGND 0.1872f
C9329 VPWR.n113 VGND 0.19541f
C9330 VPWR.n114 VGND 0.25397f
C9331 VPWR.n116 VGND 0.06111f
C9332 VPWR.n118 VGND 0.15728f
C9333 VPWR.n119 VGND 0.22227f
C9334 VPWR.n120 VGND 0.05086f
C9335 VPWR.n121 VGND 0.15725f
C9336 VPWR.n122 VGND 0.25466f
C9337 VPWR.n124 VGND 0.15725f
C9338 VPWR.n125 VGND 0.25466f
C9339 VPWR.n127 VGND 0.19642f
C9340 VPWR.n129 VGND 0.15728f
C9341 VPWR.n130 VGND 0.24495f
C9342 VPWR.n132 VGND 0.06334f
C9343 VPWR.n133 VGND 0.16702f
C9344 VPWR.n135 VGND 0.17472f
C9345 VPWR.n137 VGND 0.0858f
C9346 VPWR.n138 VGND 0.21836f
C9347 VPWR.n140 VGND 0.16676f
C9348 VPWR.n142 VGND 0.3138f
C9349 VPWR.n144 VGND 0.11293f
C9350 VPWR.n145 VGND 0.05978f
C9351 VPWR.n147 VGND 0.11586f
C9352 VPWR.n148 VGND 0.10455f
C9353 VPWR.n150 VGND 0.16293f
C9354 VPWR.n153 VGND 0.16034f
C9355 VPWR.n155 VGND 0.15725f
C9356 VPWR.n156 VGND 0.18061f
C9357 VPWR.n158 VGND 0.12248f
C9358 VPWR.n159 VGND 0.1191f
C9359 VPWR.n160 VGND 0.11196f
C9360 VPWR.n162 VGND 0.13927f
C9361 VPWR.n163 VGND 0.11196f
C9362 VPWR.n165 VGND 0.74292f
C9363 VPWR.n166 VGND 0.11935f
C9364 VPWR.n167 VGND 8.47594f
C9365 VPWR.n168 VGND 8.3427f
C9366 VPWR.n169 VGND 10.4937f
C9367 VPWR.n170 VGND 9.66075f
C9368 VPWR.n171 VGND 0.35659f
C9369 VPWR.n173 VGND 0.14331f
C9370 VPWR.n174 VGND 0.01524f
C9371 VPWR.n175 VGND 0.11298f
C9372 VPWR.n176 VGND 0.09594f
C9373 VPWR.n177 VGND 0.12234f
C9374 VPWR.t139 VGND 5.67372f
C9375 VPWR.n178 VGND 0.1362f
C9376 VPWR.n179 VGND 0.10526f
C9377 VPWR.n181 VGND 0.02189f
C9378 VPWR.n182 VGND 0.10656f
C9379 VPWR.n183 VGND 0.02189f
C9380 VPWR.n184 VGND 0.10656f
C9381 VPWR.n185 VGND 0.11245f
C9382 VPWR.n186 VGND 0.02189f
C9383 VPWR.n187 VGND 0.02077f
C9384 VPWR.n188 VGND 0.10654f
C9385 VPWR.n189 VGND 0.12065f
C9386 VPWR.n190 VGND 0.11446f
C9387 VPWR.n191 VGND 0.02077f
C9388 VPWR.n192 VGND 0.10656f
C9389 VPWR.n193 VGND 0.11354f
C9390 VPWR.n194 VGND 0.15133f
C9391 VPWR.n195 VGND 0.01264f
C9392 VPWR.n196 VGND 0.02077f
C9393 VPWR.n197 VGND 0.11357f
C9394 VPWR.n198 VGND 0.02077f
C9395 VPWR.n199 VGND 0.10656f
C9396 VPWR.n200 VGND 0.05495f
C9397 VPWR.n202 VGND 0.02315f
C9398 VPWR.n203 VGND 0.12798f
C9399 VPWR.n205 VGND 0.07323f
C9400 VPWR.n206 VGND 0.09081f
C9401 VPWR.n207 VGND 0.01147f
C9402 VPWR.n208 VGND 0.15728f
C9403 VPWR.n209 VGND 0.1218f
C9404 VPWR.n210 VGND 0.04362f
C9405 VPWR.n211 VGND 0.15725f
C9406 VPWR.n212 VGND 0.08938f
C9407 VPWR.n213 VGND 0.04291f
C9408 VPWR.n214 VGND 0.15728f
C9409 VPWR.n215 VGND 0.08945f
C9410 VPWR.t21 VGND 39.7802f
C9411 VPWR.t39 VGND 39.6787f
C9412 VPWR.t5 VGND 39.6788f
C9413 VPWR.n217 VGND 0.74292f
C9414 VPWR.t8 VGND 39.8318f
C9415 VPWR.n219 VGND 0.01178f
C9416 VPWR.n220 VGND 0.10333f
C9417 VPWR.n221 VGND 0.09494f
C9418 VPWR.n222 VGND 0.07094f
C9419 VPWR.n223 VGND 0.08359f
C9420 VPWR.n225 VGND 0.09504f
C9421 VPWR.n227 VGND 0.01105f
C9422 VPWR.n229 VGND 0.01209f
C9423 VPWR.n231 VGND 0.01209f
C9424 VPWR.n232 VGND 0.01209f
C9425 VPWR.n233 VGND 0.01209f
C9426 VPWR.n234 VGND 0.01209f
C9427 VPWR.n235 VGND 0.01209f
C9428 VPWR.n236 VGND 0.01209f
C9429 VPWR.n239 VGND 0.45131f
C9430 VPWR.t1158 VGND 0.29952f
C9431 VPWR.n240 VGND 0.02189f
C9432 VPWR.n241 VGND 0.02189f
C9433 VPWR.n242 VGND 0.01038f
C9434 VPWR.n244 VGND 0.01124f
C9435 VPWR.n245 VGND 0.01444f
C9436 VPWR.t1302 VGND 0.1934f
C9437 VPWR.n246 VGND 0.05083f
C9438 VPWR.n247 VGND 0.01124f
C9439 VPWR.n248 VGND 0.01444f
C9440 VPWR.t525 VGND 0.27763f
C9441 VPWR.n249 VGND 0.05083f
C9442 VPWR.n250 VGND 0.01124f
C9443 VPWR.n251 VGND 0.01444f
C9444 VPWR.t1390 VGND 0.44199f
C9445 VPWR.t706 VGND 0.03874f
C9446 VPWR.n252 VGND 0.09824f
C9447 VPWR.n253 VGND 0.02189f
C9448 VPWR.n254 VGND 0.01444f
C9449 VPWR.t1154 VGND 0.35317f
C9450 VPWR.n255 VGND 0.05083f
C9451 VPWR.n256 VGND 0.01124f
C9452 VPWR.n257 VGND 0.01124f
C9453 VPWR.n258 VGND 0.01147f
C9454 VPWR.t12 VGND 0.03477f
C9455 VPWR.t87 VGND 0.72375f
C9456 VPWR.n259 VGND 0.09449f
C9457 VPWR.t1162 VGND 0.03874f
C9458 VPWR.n261 VGND 0.05083f
C9459 VPWR.n262 VGND 0.01124f
C9460 VPWR.n263 VGND 0.02189f
C9461 VPWR.n265 VGND 0.01583f
C9462 VPWR.t531 VGND 0.43689f
C9463 VPWR.t693 VGND 0.43148f
C9464 VPWR.t516 VGND 0.30571f
C9465 VPWR.n266 VGND 0.01038f
C9466 VPWR.n267 VGND 0.0166f
C9467 VPWR.t948 VGND 0.87604f
C9468 VPWR.n268 VGND 0.05061f
C9469 VPWR.t738 VGND 0.68298f
C9470 VPWR.n270 VGND 0.36472f
C9471 VPWR.t411 VGND 4.03505f
C9472 VPWR.t414 VGND 1.55774f
C9473 VPWR.t143 VGND 2.96468f
C9474 VPWR.n271 VGND 0.65727f
C9475 VPWR.t662 VGND 0.96196f
C9476 VPWR.t413 VGND 0.22705f
C9477 VPWR.n272 VGND 0.04291f
C9478 VPWR.t1280 VGND 0.21789f
C9479 VPWR.n273 VGND 0.01038f
C9480 VPWR.t764 VGND 0.32361f
C9481 VPWR.n274 VGND 0.05061f
C9482 VPWR.t753 VGND 0.502f
C9483 VPWR.n276 VGND 0.05061f
C9484 VPWR.n277 VGND 0.0166f
C9485 VPWR.t1498 VGND 0.13586f
C9486 VPWR.n278 VGND 0.05852f
C9487 VPWR.t1495 VGND 0.67133f
C9488 VPWR.n279 VGND 0.05061f
C9489 VPWR.n280 VGND 0.01552f
C9490 VPWR.t1361 VGND 0.13373f
C9491 VPWR.t1171 VGND 0.03874f
C9492 VPWR.t1287 VGND 0.3382f
C9493 VPWR.n281 VGND 0.05564f
C9494 VPWR.n282 VGND 0.01038f
C9495 VPWR.t733 VGND 0.21633f
C9496 VPWR.n283 VGND 0.05061f
C9497 VPWR.t650 VGND 0.03874f
C9498 VPWR.n284 VGND 0.06569f
C9499 VPWR.n285 VGND 0.01552f
C9500 VPWR.t1164 VGND 0.23651f
C9501 VPWR.n286 VGND 0.04291f
C9502 VPWR.t63 VGND 0.03477f
C9503 VPWR.n287 VGND 0.06155f
C9504 VPWR.n288 VGND 0.01546f
C9505 VPWR.t62 VGND 0.03341f
C9506 VPWR.n289 VGND 0.08581f
C9507 VPWR.n290 VGND 0.04468f
C9508 VPWR.n291 VGND 0.01027f
C9509 VPWR.t1413 VGND 0.32962f
C9510 VPWR.n292 VGND 0.05061f
C9511 VPWR.t1284 VGND 0.23989f
C9512 VPWR.n293 VGND 0.06573f
C9513 VPWR.n294 VGND 0.0166f
C9514 VPWR.t480 VGND 0.47673f
C9515 VPWR.t434 VGND 0.23101f
C9516 VPWR.n295 VGND 0.10544f
C9517 VPWR.n296 VGND 0.02189f
C9518 VPWR.t1281 VGND 0.22067f
C9519 VPWR.t1462 VGND 0.03874f
C9520 VPWR.n297 VGND 0.09824f
C9521 VPWR.t1282 VGND 0.23197f
C9522 VPWR.n298 VGND 0.05083f
C9523 VPWR.n299 VGND 0.01444f
C9524 VPWR.t13 VGND 0.03341f
C9525 VPWR.n300 VGND 0.09425f
C9526 VPWR.t86 VGND 0.72239f
C9527 VPWR.n301 VGND 0.09428f
C9528 VPWR.n302 VGND 0.09331f
C9529 VPWR.n303 VGND 0.74292f
C9530 VPWR.t9 VGND 0.03341f
C9531 VPWR.t224 VGND 0.78547f
C9532 VPWR.t328 VGND 0.03874f
C9533 VPWR.n304 VGND 0.07294f
C9534 VPWR.t610 VGND 0.03874f
C9535 VPWR.t497 VGND 0.03874f
C9536 VPWR.t1494 VGND 0.03874f
C9537 VPWR.t1509 VGND 0.03874f
C9538 VPWR.n305 VGND 0.07069f
C9539 VPWR.t1400 VGND 0.16264f
C9540 VPWR.t652 VGND 0.03874f
C9541 VPWR.n306 VGND 0.02301f
C9542 VPWR.n307 VGND 0.01181f
C9543 VPWR.t319 VGND 0.28332f
C9544 VPWR.n308 VGND 0.06575f
C9545 VPWR.n309 VGND 0.02189f
C9546 VPWR.n310 VGND 0.01892f
C9547 VPWR.t1440 VGND 0.03874f
C9548 VPWR.n311 VGND 0.05852f
C9549 VPWR.n312 VGND 0.01199f
C9550 VPWR.t299 VGND 0.06807f
C9551 VPWR.n313 VGND 0.04329f
C9552 VPWR.n314 VGND 0.01308f
C9553 VPWR.n315 VGND 0.01822f
C9554 VPWR.t1426 VGND 0.03354f
C9555 VPWR.n316 VGND 0.03875f
C9556 VPWR.n318 VGND 0.01405f
C9557 VPWR.n319 VGND 0.02189f
C9558 VPWR.n320 VGND 0.02189f
C9559 VPWR.n321 VGND 0.01307f
C9560 VPWR.t742 VGND 0.06807f
C9561 VPWR.n322 VGND 0.05062f
C9562 VPWR.n323 VGND 0.0188f
C9563 VPWR.t285 VGND 0.03874f
C9564 VPWR.n324 VGND 0.05852f
C9565 VPWR.n325 VGND 0.01444f
C9566 VPWR.t1454 VGND 0.03874f
C9567 VPWR.n326 VGND 0.05852f
C9568 VPWR.n327 VGND 0.0193f
C9569 VPWR.t727 VGND 0.27635f
C9570 VPWR.n328 VGND 0.05473f
C9571 VPWR.n329 VGND 0.01878f
C9572 VPWR.t423 VGND 0.03874f
C9573 VPWR.n330 VGND 0.0745f
C9574 VPWR.n331 VGND 0.01785f
C9575 VPWR.t954 VGND 0.09242f
C9576 VPWR.n332 VGND 0.04967f
C9577 VPWR.n333 VGND 0.01124f
C9578 VPWR.t1205 VGND 0.03874f
C9579 VPWR.n334 VGND 0.07877f
C9580 VPWR.t1177 VGND 0.03874f
C9581 VPWR.t286 VGND 0.81976f
C9582 VPWR.n335 VGND 0.05617f
C9583 VPWR.n336 VGND 0.07674f
C9584 VPWR.n337 VGND 0.04263f
C9585 VPWR.t728 VGND 0.03874f
C9586 VPWR.t1176 VGND 0.05766f
C9587 VPWR.t803 VGND 0.03874f
C9588 VPWR.n338 VGND 0.07216f
C9589 VPWR.t625 VGND 0.03874f
C9590 VPWR.n339 VGND 0.05061f
C9591 VPWR.t1398 VGND 0.30086f
C9592 VPWR.n341 VGND 0.05061f
C9593 VPWR.t720 VGND 0.03874f
C9594 VPWR.n342 VGND 0.06569f
C9595 VPWR.n343 VGND 0.01552f
C9596 VPWR.t1461 VGND 0.03874f
C9597 VPWR.n344 VGND 0.05805f
C9598 VPWR.n345 VGND 0.01124f
C9599 VPWR.t1292 VGND 0.03874f
C9600 VPWR.n346 VGND 0.05083f
C9601 VPWR.t1425 VGND 0.19102f
C9602 VPWR.t1121 VGND 0.46359f
C9603 VPWR.n347 VGND 0.09822f
C9604 VPWR.n348 VGND 0.01444f
C9605 VPWR.t1295 VGND 0.298f
C9606 VPWR.n349 VGND 0.05805f
C9607 VPWR.n350 VGND 0.01124f
C9608 VPWR.t1470 VGND 0.03874f
C9609 VPWR.n351 VGND 0.05083f
C9610 VPWR.t545 VGND 0.03874f
C9611 VPWR.n352 VGND 0.08013f
C9612 VPWR.n353 VGND 0.01444f
C9613 VPWR.t714 VGND 0.22399f
C9614 VPWR.t620 VGND 0.03874f
C9615 VPWR.t715 VGND 0.03874f
C9616 VPWR.t847 VGND 0.2176f
C9617 VPWR.n354 VGND 0.07221f
C9618 VPWR.t318 VGND 0.05766f
C9619 VPWR.n355 VGND 0.0361f
C9620 VPWR.n356 VGND 0.01027f
C9621 VPWR.t1306 VGND 0.03874f
C9622 VPWR.n357 VGND 0.05777f
C9623 VPWR.t410 VGND 0.03874f
C9624 VPWR.n358 VGND 0.05805f
C9625 VPWR.n359 VGND 0.02189f
C9626 VPWR.t877 VGND 0.03874f
C9627 VPWR.n360 VGND 0.06569f
C9628 VPWR.t808 VGND 0.03874f
C9629 VPWR.n361 VGND 0.05805f
C9630 VPWR.n362 VGND 0.02189f
C9631 VPWR.t566 VGND 0.03874f
C9632 VPWR.n363 VGND 0.05777f
C9633 VPWR.t355 VGND 0.35925f
C9634 VPWR.n364 VGND 0.04513f
C9635 VPWR.t1221 VGND 0.03874f
C9636 VPWR.n366 VGND 0.05777f
C9637 VPWR.t1237 VGND 5.36854f
C9638 VPWR.n367 VGND 0.03904f
C9639 VPWR.n368 VGND 0.01308f
C9640 VPWR.t1169 VGND 0.39576f
C9641 VPWR.n369 VGND 0.05779f
C9642 VPWR.t560 VGND 0.03874f
C9643 VPWR.n371 VGND 0.05061f
C9644 VPWR.t1178 VGND 0.03874f
C9645 VPWR.n372 VGND 0.07165f
C9646 VPWR.n373 VGND 0.01552f
C9647 VPWR.t443 VGND 0.17575f
C9648 VPWR.t450 VGND 0.03874f
C9649 VPWR.t665 VGND 0.03874f
C9650 VPWR.t10 VGND 0.03477f
C9651 VPWR.t1279 VGND 0.03874f
C9652 VPWR.n374 VGND 0.0173f
C9653 VPWR.t741 VGND 0.56857f
C9654 VPWR.t546 VGND 0.2046f
C9655 VPWR.t333 VGND 0.29186f
C9656 VPWR.t457 VGND 0.03874f
C9657 VPWR.t1412 VGND 0.1869f
C9658 VPWR.t1506 VGND 0.03874f
C9659 VPWR.n375 VGND 0.11137f
C9660 VPWR.n376 VGND 0.02189f
C9661 VPWR.t1203 VGND 0.22491f
C9662 VPWR.n377 VGND 0.05803f
C9663 VPWR.n378 VGND 0.01124f
C9664 VPWR.t565 VGND 0.03874f
C9665 VPWR.n379 VGND 0.05805f
C9666 VPWR.n380 VGND 0.02189f
C9667 VPWR.t699 VGND 0.03874f
C9668 VPWR.n381 VGND 0.05777f
C9669 VPWR.t694 VGND 0.03874f
C9670 VPWR.n383 VGND 0.05061f
C9671 VPWR.n384 VGND 0.01552f
C9672 VPWR.t514 VGND 0.03874f
C9673 VPWR.n385 VGND 0.05852f
C9674 VPWR.n386 VGND 0.0166f
C9675 VPWR.t685 VGND 0.20829f
C9676 VPWR.n387 VGND 0.05061f
C9677 VPWR.t422 VGND 0.03874f
C9678 VPWR.n389 VGND 0.04291f
C9679 VPWR.n390 VGND 0.01038f
C9680 VPWR.t732 VGND 0.03874f
C9681 VPWR.n391 VGND 0.05061f
C9682 VPWR.n392 VGND 0.01552f
C9683 VPWR.t1285 VGND 0.18939f
C9684 VPWR.n393 VGND 0.05083f
C9685 VPWR.n394 VGND 0.01038f
C9686 VPWR.t659 VGND 0.03874f
C9687 VPWR.n395 VGND 0.05061f
C9688 VPWR.n396 VGND 0.01552f
C9689 VPWR.t1490 VGND 0.20521f
C9690 VPWR.n397 VGND 0.05852f
C9691 VPWR.n398 VGND 0.0166f
C9692 VPWR.t1360 VGND 0.03874f
C9693 VPWR.n399 VGND 0.05061f
C9694 VPWR.n400 VGND 0.01027f
C9695 VPWR.t158 VGND 0.03341f
C9696 VPWR.n401 VGND 0.0858f
C9697 VPWR.n402 VGND 0.05258f
C9698 VPWR.n403 VGND 0.01566f
C9699 VPWR.t157 VGND 0.03477f
C9700 VPWR.t1159 VGND 0.03874f
C9701 VPWR.n404 VGND 0.05007f
C9702 VPWR.n405 VGND 0.05593f
C9703 VPWR.n406 VGND 0.01223f
C9704 VPWR.t1432 VGND 0.03874f
C9705 VPWR.t568 VGND 0.128f
C9706 VPWR.n407 VGND 0.04577f
C9707 VPWR.n408 VGND 0.04791f
C9708 VPWR.n409 VGND 0.01444f
C9709 VPWR.t701 VGND 0.03874f
C9710 VPWR.n410 VGND 0.07268f
C9711 VPWR.n411 VGND 0.03268f
C9712 VPWR.t700 VGND 0.12663f
C9713 VPWR.n412 VGND 0.06144f
C9714 VPWR.n413 VGND 0.01245f
C9715 VPWR.t1396 VGND 0.03874f
C9716 VPWR.n414 VGND 0.06573f
C9717 VPWR.n415 VGND 0.02189f
C9718 VPWR.t1145 VGND 0.57506f
C9719 VPWR.t1358 VGND 0.08229f
C9720 VPWR.n416 VGND 0.05671f
C9721 VPWR.n417 VGND 0.03765f
C9722 VPWR.n418 VGND 0.01669f
C9723 VPWR.t1328 VGND 0.12585f
C9724 VPWR.n419 VGND 0.07289f
C9725 VPWR.n420 VGND 0.01671f
C9726 VPWR.t762 VGND 0.03874f
C9727 VPWR.t301 VGND 0.04547f
C9728 VPWR.n421 VGND 0.05706f
C9729 VPWR.n422 VGND 0.04899f
C9730 VPWR.n423 VGND 0.01444f
C9731 VPWR.t1146 VGND 0.03874f
C9732 VPWR.n424 VGND 0.05747f
C9733 VPWR.t226 VGND 0.03341f
C9734 VPWR.n425 VGND 0.09425f
C9735 VPWR.n426 VGND 0.07266f
C9736 VPWR.t225 VGND 0.03477f
C9737 VPWR.n428 VGND 0.05447f
C9738 VPWR.t739 VGND 0.03874f
C9739 VPWR.n430 VGND 0.05083f
C9740 VPWR.n431 VGND 0.01124f
C9741 VPWR.t541 VGND 0.03874f
C9742 VPWR.n432 VGND 0.05083f
C9743 VPWR.t223 VGND 0.78411f
C9744 VPWR.n433 VGND 0.0858f
C9745 VPWR.n434 VGND 0.05662f
C9746 VPWR.n435 VGND 0.01539f
C9747 VPWR.t53 VGND 1.02095f
C9748 VPWR.n436 VGND 0.09425f
C9749 VPWR.t203 VGND 0.03341f
C9750 VPWR.n437 VGND 0.09428f
C9751 VPWR.n438 VGND 0.09504f
C9752 VPWR.n439 VGND 0.74292f
C9753 VPWR.t138 VGND 0.14825f
C9754 VPWR.n440 VGND 0.09425f
C9755 VPWR.t120 VGND 0.86156f
C9756 VPWR.n441 VGND 0.09428f
C9757 VPWR.t137 VGND 0.14961f
C9758 VPWR.t119 VGND 0.86291f
C9759 VPWR.n442 VGND 0.08866f
C9760 VPWR.n443 VGND 0.01444f
C9761 VPWR.t778 VGND 0.3229f
C9762 VPWR.n444 VGND 0.05083f
C9763 VPWR.n445 VGND 0.01124f
C9764 VPWR.t1325 VGND 0.34224f
C9765 VPWR.t997 VGND 0.32232f
C9766 VPWR.n447 VGND 0.04695f
C9767 VPWR.n448 VGND 0.10516f
C9768 VPWR.t957 VGND 0.19037f
C9769 VPWR.n449 VGND 0.04291f
C9770 VPWR.n450 VGND 0.01038f
C9771 VPWR.t713 VGND 0.03874f
C9772 VPWR.n451 VGND 0.05061f
C9773 VPWR.n452 VGND 0.01552f
C9774 VPWR.t259 VGND 0.18035f
C9775 VPWR.n453 VGND 0.07268f
C9776 VPWR.n454 VGND 0.02975f
C9777 VPWR.t1258 VGND 0.29592f
C9778 VPWR.t915 VGND 0.21511f
C9779 VPWR.n455 VGND 0.10525f
C9780 VPWR.t564 VGND 0.03874f
C9781 VPWR.n456 VGND 0.05083f
C9782 VPWR.n457 VGND 0.01444f
C9783 VPWR.t1100 VGND 0.03874f
C9784 VPWR.n458 VGND 0.05083f
C9785 VPWR.n459 VGND 0.01124f
C9786 VPWR.t600 VGND 0.5531f
C9787 VPWR.n460 VGND 0.05083f
C9788 VPWR.t1350 VGND 0.03874f
C9789 VPWR.t1316 VGND 0.37224f
C9790 VPWR.t1345 VGND 0.03874f
C9791 VPWR.t850 VGND 0.25148f
C9792 VPWR.t614 VGND 0.32312f
C9793 VPWR.t590 VGND 0.21651f
C9794 VPWR.t533 VGND 0.04168f
C9795 VPWR.t1321 VGND 0.03874f
C9796 VPWR.t1254 VGND 0.03874f
C9797 VPWR.t390 VGND 0.17381f
C9798 VPWR.n462 VGND 0.0648f
C9799 VPWR.n463 VGND 0.01765f
C9800 VPWR.n464 VGND 0.04305f
C9801 VPWR.n465 VGND 0.01332f
C9802 VPWR.n466 VGND 0.0657f
C9803 VPWR.n467 VGND 0.02301f
C9804 VPWR.n468 VGND 0.07291f
C9805 VPWR.n469 VGND 0.02189f
C9806 VPWR.n470 VGND 0.09822f
C9807 VPWR.n471 VGND 0.01444f
C9808 VPWR.n472 VGND 0.05083f
C9809 VPWR.n473 VGND 0.01124f
C9810 VPWR.n474 VGND 0.05812f
C9811 VPWR.t1422 VGND 0.03897f
C9812 VPWR.t236 VGND 0.08875f
C9813 VPWR.n475 VGND 0.09428f
C9814 VPWR.t235 VGND 0.09011f
C9815 VPWR.t1067 VGND 0.37726f
C9816 VPWR.t776 VGND 0.42681f
C9817 VPWR.n476 VGND 0.05822f
C9818 VPWR.n477 VGND 0.01038f
C9819 VPWR.t1310 VGND 0.03874f
C9820 VPWR.n478 VGND 0.05083f
C9821 VPWR.n479 VGND 0.01552f
C9822 VPWR.t403 VGND 0.42809f
C9823 VPWR.n480 VGND 0.06019f
C9824 VPWR.t391 VGND 0.03874f
C9825 VPWR.t604 VGND 0.23435f
C9826 VPWR.t263 VGND 0.21128f
C9827 VPWR.t594 VGND 0.45456f
C9828 VPWR.t272 VGND 0.21702f
C9829 VPWR.t374 VGND 0.15782f
C9830 VPWR.t317 VGND 0.30237f
C9831 VPWR.n481 VGND 0.11568f
C9832 VPWR.n482 VGND 0.01444f
C9833 VPWR.t682 VGND 0.03874f
C9834 VPWR.n483 VGND 0.05083f
C9835 VPWR.n484 VGND 0.01124f
C9836 VPWR.t796 VGND 0.16835f
C9837 VPWR.n485 VGND 0.05083f
C9838 VPWR.n486 VGND 0.01444f
C9839 VPWR.t1403 VGND 0.13069f
C9840 VPWR.t1253 VGND 0.29796f
C9841 VPWR.n487 VGND 0.10522f
C9842 VPWR.n488 VGND 0.02979f
C9843 VPWR.t1 VGND 0.24449f
C9844 VPWR.t389 VGND 0.43214f
C9845 VPWR.n489 VGND 0.10522f
C9846 VPWR.n490 VGND 0.01444f
C9847 VPWR.t487 VGND 0.17348f
C9848 VPWR.n491 VGND 0.05083f
C9849 VPWR.n492 VGND 0.01124f
C9850 VPWR.t477 VGND 0.34285f
C9851 VPWR.n493 VGND 0.05083f
C9852 VPWR.n494 VGND 0.01444f
C9853 VPWR.t770 VGND 0.25491f
C9854 VPWR.n495 VGND 0.05083f
C9855 VPWR.n496 VGND 0.01124f
C9856 VPWR.t1085 VGND 0.30577f
C9857 VPWR.n497 VGND 0.05803f
C9858 VPWR.n498 VGND 0.02189f
C9859 VPWR.t539 VGND 0.15355f
C9860 VPWR.t609 VGND 0.33889f
C9861 VPWR.n499 VGND 0.11938f
C9862 VPWR.n500 VGND 0.03441f
C9863 VPWR.t405 VGND 0.45285f
C9864 VPWR.n501 VGND 0.07197f
C9865 VPWR.n502 VGND 0.01124f
C9866 VPWR.t349 VGND 0.19729f
C9867 VPWR.t18 VGND 0.24126f
C9868 VPWR.t194 VGND 0.05806f
C9869 VPWR.t252 VGND 1.09614f
C9870 VPWR.t106 VGND 0.03341f
C9871 VPWR.n504 VGND 0.01552f
C9872 VPWR.t256 VGND 0.03874f
C9873 VPWR.n505 VGND 0.05083f
C9874 VPWR.n506 VGND 0.01038f
C9875 VPWR.t357 VGND 0.03874f
C9876 VPWR.n507 VGND 0.06586f
C9877 VPWR.t453 VGND 0.03874f
C9878 VPWR.n508 VGND 0.05061f
C9879 VPWR.n509 VGND 0.01552f
C9880 VPWR.t1437 VGND 0.03874f
C9881 VPWR.n510 VGND 0.04291f
C9882 VPWR.t883 VGND 0.03874f
C9883 VPWR.n511 VGND 0.05061f
C9884 VPWR.n512 VGND 0.01038f
C9885 VPWR.t943 VGND 0.03874f
C9886 VPWR.n513 VGND 0.04291f
C9887 VPWR.n514 VGND 0.01038f
C9888 VPWR.t996 VGND 0.03874f
C9889 VPWR.n515 VGND 0.05775f
C9890 VPWR.t107 VGND 0.03477f
C9891 VPWR.t253 VGND 1.0975f
C9892 VPWR.t505 VGND 0.03958f
C9893 VPWR.n516 VGND 0.09795f
C9894 VPWR.t432 VGND 0.15638f
C9895 VPWR.n517 VGND 0.03981f
C9896 VPWR.t1127 VGND 0.03874f
C9897 VPWR.n519 VGND 0.05083f
C9898 VPWR.n520 VGND 0.01444f
C9899 VPWR.t1139 VGND 0.03874f
C9900 VPWR.n521 VGND 0.05083f
C9901 VPWR.n522 VGND 0.01124f
C9902 VPWR.t953 VGND 0.03874f
C9903 VPWR.n523 VGND 0.05803f
C9904 VPWR.n524 VGND 0.02189f
C9905 VPWR.t596 VGND 0.22402f
C9906 VPWR.n525 VGND 0.0657f
C9907 VPWR.n526 VGND 0.01552f
C9908 VPWR.t1185 VGND 0.03874f
C9909 VPWR.n527 VGND 0.05061f
C9910 VPWR.n528 VGND 0.01038f
C9911 VPWR.t559 VGND 0.03874f
C9912 VPWR.n529 VGND 0.05083f
C9913 VPWR.n530 VGND 0.01552f
C9914 VPWR.t595 VGND 0.03874f
C9915 VPWR.n531 VGND 0.05852f
C9916 VPWR.n532 VGND 0.01552f
C9917 VPWR.t782 VGND 0.03874f
C9918 VPWR.n533 VGND 0.05061f
C9919 VPWR.n534 VGND 0.01038f
C9920 VPWR.t771 VGND 0.03874f
C9921 VPWR.n535 VGND 0.05805f
C9922 VPWR.n536 VGND 0.02189f
C9923 VPWR.t1044 VGND 0.03874f
C9924 VPWR.t1389 VGND 0.03874f
C9925 VPWR.n537 VGND 0.09822f
C9926 VPWR.n538 VGND 0.01444f
C9927 VPWR.t346 VGND 0.12874f
C9928 VPWR.n539 VGND 0.05083f
C9929 VPWR.n540 VGND 0.01124f
C9930 VPWR.t1057 VGND 0.03874f
C9931 VPWR.n541 VGND 0.05805f
C9932 VPWR.n542 VGND 0.02189f
C9933 VPWR.t1123 VGND 0.03874f
C9934 VPWR.n543 VGND 0.07289f
C9935 VPWR.n544 VGND 0.02189f
C9936 VPWR.t1267 VGND 0.03874f
C9937 VPWR.t1059 VGND 0.03874f
C9938 VPWR.n545 VGND 0.10546f
C9939 VPWR.n546 VGND 0.01828f
C9940 VPWR.t332 VGND 0.03874f
C9941 VPWR.t258 VGND 0.06807f
C9942 VPWR.n547 VGND 0.04577f
C9943 VPWR.n548 VGND 0.05511f
C9944 VPWR.n549 VGND 0.02189f
C9945 VPWR.t585 VGND 0.03874f
C9946 VPWR.n550 VGND 0.07293f
C9947 VPWR.n551 VGND 0.02189f
C9948 VPWR.t1076 VGND 0.03354f
C9949 VPWR.t928 VGND 0.03874f
C9950 VPWR.n552 VGND 0.05529f
C9951 VPWR.n553 VGND 0.04181f
C9952 VPWR.n554 VGND 0.01879f
C9953 VPWR.t350 VGND 0.03874f
C9954 VPWR.n555 VGND 0.0657f
C9955 VPWR.n556 VGND 0.01444f
C9956 VPWR.t1043 VGND 0.2292f
C9957 VPWR.t1120 VGND 0.03874f
C9958 VPWR.n557 VGND 0.04974f
C9959 VPWR.n558 VGND 0.0455f
C9960 VPWR.n559 VGND 0.02343f
C9961 VPWR.t1098 VGND 0.03874f
C9962 VPWR.n560 VGND 0.07271f
C9963 VPWR.n561 VGND 0.0104f
C9964 VPWR.t303 VGND 0.53993f
C9965 VPWR.n562 VGND 0.05458f
C9966 VPWR.n563 VGND 0.01416f
C9967 VPWR.t921 VGND 0.03874f
C9968 VPWR.n564 VGND 0.05803f
C9969 VPWR.n565 VGND 0.02189f
C9970 VPWR.t532 VGND 0.03874f
C9971 VPWR.t488 VGND 0.03874f
C9972 VPWR.n566 VGND 0.09824f
C9973 VPWR.n567 VGND 0.01444f
C9974 VPWR.t975 VGND 0.03874f
C9975 VPWR.n568 VGND 0.05083f
C9976 VPWR.n569 VGND 0.01124f
C9977 VPWR.t938 VGND 0.03874f
C9978 VPWR.n570 VGND 0.07197f
C9979 VPWR.n571 VGND 0.03441f
C9980 VPWR.t1042 VGND 0.03874f
C9981 VPWR.n572 VGND 0.07197f
C9982 VPWR.t959 VGND 0.03874f
C9983 VPWR.n573 VGND 0.06523f
C9984 VPWR.n574 VGND 0.01124f
C9985 VPWR.n575 VGND 0.0133f
C9986 VPWR.n576 VGND 0.01444f
C9987 VPWR.t664 VGND 0.03874f
C9988 VPWR.t1014 VGND 0.11155f
C9989 VPWR.n577 VGND 0.09824f
C9990 VPWR.n578 VGND 0.02189f
C9991 VPWR.n579 VGND 0.01124f
C9992 VPWR.t1191 VGND 0.03874f
C9993 VPWR.t1062 VGND 0.03874f
C9994 VPWR.n580 VGND 0.13941f
C9995 VPWR.t255 VGND 0.03874f
C9996 VPWR.t1036 VGND 0.03874f
C9997 VPWR.n582 VGND 0.10362f
C9998 VPWR.t393 VGND 0.03874f
C9999 VPWR.n583 VGND 0.05805f
C10000 VPWR.n584 VGND 0.02189f
C10001 VPWR.t1018 VGND 0.03874f
C10002 VPWR.n585 VGND 0.05803f
C10003 VPWR.t891 VGND 0.03874f
C10004 VPWR.t1175 VGND 0.03874f
C10005 VPWR.n586 VGND 0.10544f
C10006 VPWR.n587 VGND 0.02189f
C10007 VPWR.t598 VGND 0.03874f
C10008 VPWR.n588 VGND 0.05083f
C10009 VPWR.n589 VGND 0.01124f
C10010 VPWR.t1406 VGND 0.03874f
C10011 VPWR.n590 VGND 0.05083f
C10012 VPWR.t58 VGND 0.37494f
C10013 VPWR.t96 VGND 0.03477f
C10014 VPWR.n591 VGND 0.08866f
C10015 VPWR.t660 VGND 0.03874f
C10016 VPWR.t530 VGND 0.03874f
C10017 VPWR.t177 VGND 0.3036f
C10018 VPWR.t178 VGND 0.30224f
C10019 VPWR.n593 VGND 0.08581f
C10020 VPWR.t1270 VGND 0.03874f
C10021 VPWR.t1013 VGND 0.03874f
C10022 VPWR.t1005 VGND 0.03874f
C10023 VPWR.t492 VGND 0.30635f
C10024 VPWR.t1444 VGND 0.03874f
C10025 VPWR.t939 VGND 0.12932f
C10026 VPWR.t347 VGND 0.03874f
C10027 VPWR.t592 VGND 0.13968f
C10028 VPWR.t1049 VGND 0.03874f
C10029 VPWR.t352 VGND 0.03874f
C10030 VPWR.t369 VGND 0.03874f
C10031 VPWR.t542 VGND 0.03874f
C10032 VPWR.t207 VGND 0.07867f
C10033 VPWR.t1507 VGND 0.03874f
C10034 VPWR.t340 VGND 0.03892f
C10035 VPWR.t210 VGND 0.22217f
C10036 VPWR.t396 VGND 0.04547f
C10037 VPWR.t977 VGND 0.03874f
C10038 VPWR.t1307 VGND 0.03874f
C10039 VPWR.t543 VGND 0.31532f
C10040 VPWR.t580 VGND 0.03874f
C10041 VPWR.t1051 VGND 0.03874f
C10042 VPWR.t835 VGND 0.03354f
C10043 VPWR.t114 VGND 0.03479f
C10044 VPWR.t60 VGND 0.17439f
C10045 VPWR.n594 VGND 0.15725f
C10046 VPWR.t300 VGND 0.06807f
C10047 VPWR.t61 VGND 0.17183f
C10048 VPWR.t626 VGND 0.03874f
C10049 VPWR.t1082 VGND 0.04991f
C10050 VPWR.t1056 VGND 0.03874f
C10051 VPWR.t809 VGND 0.03874f
C10052 VPWR.t787 VGND 0.32679f
C10053 VPWR.t401 VGND 0.03874f
C10054 VPWR.t827 VGND 0.0388f
C10055 VPWR.t956 VGND 0.03874f
C10056 VPWR.t824 VGND 0.03903f
C10057 VPWR.t1332 VGND 1.10569f
C10058 VPWR.t836 VGND 0.03903f
C10059 VPWR.t246 VGND 0.23842f
C10060 VPWR.t489 VGND 0.19217f
C10061 VPWR.t772 VGND 0.1503f
C10062 VPWR.t31 VGND 0.03478f
C10063 VPWR.t104 VGND 0.17778f
C10064 VPWR.t465 VGND 0.03897f
C10065 VPWR.t105 VGND 0.17642f
C10066 VPWR.n595 VGND 0.09428f
C10067 VPWR.n596 VGND 0.1122f
C10068 VPWR.n597 VGND 0.0173f
C10069 VPWR.n598 VGND 0.05447f
C10070 VPWR.n600 VGND 0.06155f
C10071 VPWR.n601 VGND 0.01168f
C10072 VPWR.t30 VGND 0.24097f
C10073 VPWR.n602 VGND 0.15728f
C10074 VPWR.n603 VGND 0.11118f
C10075 VPWR.n605 VGND 0.04929f
C10076 VPWR.n606 VGND 0.05234f
C10077 VPWR.n608 VGND 0.05455f
C10078 VPWR.n610 VGND 0.03294f
C10079 VPWR.n611 VGND 0.01254f
C10080 VPWR.n612 VGND 0.06179f
C10081 VPWR.n613 VGND 0.0216f
C10082 VPWR.n614 VGND 0.05777f
C10083 VPWR.n615 VGND 0.01049f
C10084 VPWR.n616 VGND 0.05879f
C10085 VPWR.n617 VGND 0.02175f
C10086 VPWR.n618 VGND 0.08687f
C10087 VPWR.n619 VGND 0.03805f
C10088 VPWR.n620 VGND 0.066f
C10089 VPWR.n622 VGND 0.05805f
C10090 VPWR.n623 VGND 0.02189f
C10091 VPWR.n624 VGND 0.06569f
C10092 VPWR.n625 VGND 0.01073f
C10093 VPWR.n626 VGND 0.03342f
C10094 VPWR.n627 VGND 0.06275f
C10095 VPWR.n628 VGND 0.02333f
C10096 VPWR.n629 VGND 0.05968f
C10097 VPWR.n630 VGND 0.04247f
C10098 VPWR.n632 VGND 0.1036f
C10099 VPWR.n633 VGND 0.0758f
C10100 VPWR.t208 VGND 0.26862f
C10101 VPWR.n634 VGND 0.04291f
C10102 VPWR.n635 VGND 0.01438f
C10103 VPWR.n636 VGND 0.05278f
C10104 VPWR.n637 VGND 0.01007f
C10105 VPWR.n638 VGND 0.05083f
C10106 VPWR.n639 VGND 0.01124f
C10107 VPWR.n640 VGND 0.05083f
C10108 VPWR.n641 VGND 0.01444f
C10109 VPWR.n642 VGND 0.05852f
C10110 VPWR.n643 VGND 0.0166f
C10111 VPWR.n644 VGND 0.05061f
C10112 VPWR.n646 VGND 0.05061f
C10113 VPWR.n647 VGND 0.0166f
C10114 VPWR.n648 VGND 0.05061f
C10115 VPWR.n650 VGND 0.05061f
C10116 VPWR.n651 VGND 0.0166f
C10117 VPWR.n652 VGND 0.05061f
C10118 VPWR.n654 VGND 0.05061f
C10119 VPWR.n655 VGND 0.0166f
C10120 VPWR.n656 VGND 0.05852f
C10121 VPWR.n657 VGND 0.01552f
C10122 VPWR.n658 VGND 0.05061f
C10123 VPWR.n659 VGND 0.01038f
C10124 VPWR.n660 VGND 0.04291f
C10125 VPWR.n661 VGND 0.01027f
C10126 VPWR.n662 VGND 0.05257f
C10127 VPWR.n663 VGND 0.02057f
C10128 VPWR.n664 VGND 0.06147f
C10129 VPWR.n666 VGND 0.0984f
C10130 VPWR.t59 VGND 0.37358f
C10131 VPWR.n667 VGND 0.09425f
C10132 VPWR.t97 VGND 0.03341f
C10133 VPWR.n668 VGND 0.09428f
C10134 VPWR.t156 VGND 0.12916f
C10135 VPWR.n669 VGND 0.09425f
C10136 VPWR.t155 VGND 0.13052f
C10137 VPWR.n670 VGND 0.05447f
C10138 VPWR.t404 VGND 0.03874f
C10139 VPWR.t963 VGND 0.03874f
C10140 VPWR.t784 VGND 0.03874f
C10141 VPWR.n671 VGND 0.01124f
C10142 VPWR.t632 VGND 0.03874f
C10143 VPWR.t1129 VGND 0.03874f
C10144 VPWR.n672 VGND 0.11961f
C10145 VPWR.t1002 VGND 0.03874f
C10146 VPWR.t1443 VGND 0.03874f
C10147 VPWR.n674 VGND 0.10304f
C10148 VPWR.t999 VGND 0.03874f
C10149 VPWR.n675 VGND 0.05805f
C10150 VPWR.n676 VGND 0.02189f
C10151 VPWR.t599 VGND 0.03874f
C10152 VPWR.t581 VGND 0.03874f
C10153 VPWR.t986 VGND 0.03874f
C10154 VPWR.n677 VGND 0.05564f
C10155 VPWR.n678 VGND 0.01038f
C10156 VPWR.t1088 VGND 0.03874f
C10157 VPWR.n679 VGND 0.05061f
C10158 VPWR.t1198 VGND 0.03898f
C10159 VPWR.n681 VGND 0.01583f
C10160 VPWR.n682 VGND 0.01444f
C10161 VPWR.t1141 VGND 0.03874f
C10162 VPWR.n683 VGND 0.05083f
C10163 VPWR.n684 VGND 0.01416f
C10164 VPWR.n685 VGND 0.03726f
C10165 VPWR.t601 VGND 0.05766f
C10166 VPWR.n686 VGND 0.05702f
C10167 VPWR.n687 VGND 0.01247f
C10168 VPWR.t1410 VGND 0.35495f
C10169 VPWR.n688 VGND 0.06494f
C10170 VPWR.n689 VGND 0.02095f
C10171 VPWR.t616 VGND 0.04547f
C10172 VPWR.n690 VGND 0.06878f
C10173 VPWR.n691 VGND 0.01416f
C10174 VPWR.n692 VGND 0.02919f
C10175 VPWR.t79 VGND 0.80816f
C10176 VPWR.n693 VGND 0.09425f
C10177 VPWR.t244 VGND 0.35707f
C10178 VPWR.t76 VGND 0.41955f
C10179 VPWR.t634 VGND 0.03874f
C10180 VPWR.t992 VGND 0.03874f
C10181 VPWR.t976 VGND 0.03874f
C10182 VPWR.t589 VGND 0.3126f
C10183 VPWR.t1179 VGND 0.22512f
C10184 VPWR.t934 VGND 0.03874f
C10185 VPWR.t330 VGND 0.58955f
C10186 VPWR.t1194 VGND 0.03874f
C10187 VPWR.t77 VGND 0.42091f
C10188 VPWR.t245 VGND 0.35843f
C10189 VPWR.t168 VGND 1.03771f
C10190 VPWR.t1265 VGND 0.03874f
C10191 VPWR.t170 VGND 0.66084f
C10192 VPWR.n694 VGND 0.06362f
C10193 VPWR.t854 VGND 0.2761f
C10194 VPWR.t171 VGND 0.18042f
C10195 VPWR.n696 VGND 0.04802f
C10196 VPWR.n697 VGND 0.05051f
C10197 VPWR.t1259 VGND 0.03892f
C10198 VPWR.t172 VGND 0.29326f
C10199 VPWR.n699 VGND 0.15728f
C10200 VPWR.t174 VGND 0.14507f
C10201 VPWR.t356 VGND 0.03874f
C10202 VPWR.t175 VGND 0.03477f
C10203 VPWR.t167 VGND 0.40909f
C10204 VPWR.t1000 VGND 0.03874f
C10205 VPWR.t833 VGND 0.47991f
C10206 VPWR.n700 VGND 0.05399f
C10207 VPWR.n701 VGND 0.01124f
C10208 VPWR.t1257 VGND 0.58543f
C10209 VPWR.t1031 VGND 0.69799f
C10210 VPWR.t364 VGND 0.03874f
C10211 VPWR.t1187 VGND 0.03897f
C10212 VPWR.t48 VGND 0.74821f
C10213 VPWR.t47 VGND 0.74957f
C10214 VPWR.t1192 VGND 0.03874f
C10215 VPWR.t46 VGND 0.21612f
C10216 VPWR.t416 VGND 0.03892f
C10217 VPWR.t45 VGND 1.05782f
C10218 VPWR.t461 VGND 0.03874f
C10219 VPWR.t237 VGND 0.87392f
C10220 VPWR.t792 VGND 0.06807f
C10221 VPWR.t562 VGND 0.03874f
C10222 VPWR.t1010 VGND 0.03874f
C10223 VPWR.t1115 VGND 0.03874f
C10224 VPWR.t629 VGND 0.03354f
C10225 VPWR.t1415 VGND 0.03874f
C10226 VPWR.t548 VGND 1.5682f
C10227 VPWR.t981 VGND 0.03874f
C10228 VPWR.t549 VGND 0.03874f
C10229 VPWR.t313 VGND 0.45622f
C10230 VPWR.t1052 VGND 0.03874f
C10231 VPWR.t1101 VGND 0.03874f
C10232 VPWR.t1077 VGND 0.34209f
C10233 VPWR.t627 VGND 0.26328f
C10234 VPWR.t799 VGND 0.03874f
C10235 VPWR.t607 VGND 0.21086f
C10236 VPWR.t1048 VGND 0.03874f
C10237 VPWR.t1125 VGND 0.03874f
C10238 VPWR.t886 VGND 0.7872f
C10239 VPWR.t998 VGND 0.03874f
C10240 VPWR.t1473 VGND 0.04991f
C10241 VPWR.t1204 VGND 0.03874f
C10242 VPWR.t1096 VGND 0.03874f
C10243 VPWR.t925 VGND 0.12646f
C10244 VPWR.t1186 VGND 0.03874f
C10245 VPWR.t28 VGND 1.02518f
C10246 VPWR.t973 VGND 0.03874f
C10247 VPWR.t27 VGND 1.02774f
C10248 VPWR.t32 VGND 0.03479f
C10249 VPWR.t1038 VGND 0.03874f
C10250 VPWR.t989 VGND 0.27397f
C10251 VPWR.t83 VGND 0.03341f
C10252 VPWR.n702 VGND 0.0858f
C10253 VPWR.t82 VGND 0.03477f
C10254 VPWR.t1122 VGND 0.03874f
C10255 VPWR.t529 VGND 0.26479f
C10256 VPWR.t966 VGND 0.03874f
C10257 VPWR.t476 VGND 0.30641f
C10258 VPWR.t1264 VGND 0.03874f
C10259 VPWR.t1148 VGND 0.22115f
C10260 VPWR.t1195 VGND 0.47831f
C10261 VPWR.t1143 VGND 0.03874f
C10262 VPWR.t643 VGND 0.03874f
C10263 VPWR.t351 VGND 0.30383f
C10264 VPWR.n703 VGND 0.08077f
C10265 VPWR.n704 VGND 0.0647f
C10266 VPWR.n705 VGND 0.01444f
C10267 VPWR.n706 VGND 0.05083f
C10268 VPWR.n707 VGND 0.01038f
C10269 VPWR.n708 VGND 0.05777f
C10270 VPWR.n709 VGND 0.02189f
C10271 VPWR.n710 VGND 0.06575f
C10272 VPWR.n711 VGND 0.0166f
C10273 VPWR.n712 VGND 0.05061f
C10274 VPWR.n714 VGND 0.05061f
C10275 VPWR.n715 VGND 0.0166f
C10276 VPWR.n716 VGND 0.05852f
C10277 VPWR.n717 VGND 0.01444f
C10278 VPWR.n718 VGND 0.05083f
C10279 VPWR.n719 VGND 0.01124f
C10280 VPWR.n720 VGND 0.05083f
C10281 VPWR.n722 VGND 0.05447f
C10282 VPWR.n723 VGND 0.0133f
C10283 VPWR.n724 VGND 0.10593f
C10284 VPWR.t162 VGND 0.35746f
C10285 VPWR.n725 VGND 0.09425f
C10286 VPWR.t182 VGND 0.08272f
C10287 VPWR.n726 VGND 0.09428f
C10288 VPWR.t161 VGND 0.35882f
C10289 VPWR.t181 VGND 0.08407f
C10290 VPWR.n727 VGND 0.08866f
C10291 VPWR.n728 VGND 0.02189f
C10292 VPWR.n729 VGND 0.01038f
C10293 VPWR.t307 VGND 0.1711f
C10294 VPWR.n730 VGND 0.06879f
C10295 VPWR.t1224 VGND 0.30605f
C10296 VPWR.n731 VGND 0.0633f
C10297 VPWR.n732 VGND 0.02189f
C10298 VPWR.t1223 VGND 0.21696f
C10299 VPWR.n733 VGND 0.0657f
C10300 VPWR.t1229 VGND 0.12517f
C10301 VPWR.n734 VGND 0.05061f
C10302 VPWR.n735 VGND 0.01552f
C10303 VPWR.t292 VGND 0.30591f
C10304 VPWR.n736 VGND 0.04291f
C10305 VPWR.t1246 VGND 0.19951f
C10306 VPWR.n738 VGND 0.05061f
C10307 VPWR.t291 VGND 0.27448f
C10308 VPWR.n739 VGND 0.06573f
C10309 VPWR.n740 VGND 0.0166f
C10310 VPWR.t1354 VGND 0.19043f
C10311 VPWR.t1245 VGND 0.03874f
C10312 VPWR.n741 VGND 0.10544f
C10313 VPWR.n742 VGND 0.02189f
C10314 VPWR.t1352 VGND 0.03874f
C10315 VPWR.t1210 VGND 0.03874f
C10316 VPWR.n743 VGND 0.09824f
C10317 VPWR.t276 VGND 0.45208f
C10318 VPWR.t888 VGND 0.31277f
C10319 VPWR.n745 VGND 0.0692f
C10320 VPWR.n746 VGND 0.01444f
C10321 VPWR.t871 VGND 0.37153f
C10322 VPWR.n747 VGND 0.05852f
C10323 VPWR.n748 VGND 0.0166f
C10324 VPWR.t1343 VGND 0.03874f
C10325 VPWR.n749 VGND 0.05061f
C10326 VPWR.n751 VGND 0.02975f
C10327 VPWR.t1344 VGND 0.03874f
C10328 VPWR.n752 VGND 0.06477f
C10329 VPWR.n753 VGND 0.01038f
C10330 VPWR.n754 VGND 0.01552f
C10331 VPWR.t309 VGND 0.03874f
C10332 VPWR.n755 VGND 0.05061f
C10333 VPWR.n756 VGND 0.01038f
C10334 VPWR.n758 VGND 0.0166f
C10335 VPWR.t759 VGND 0.03874f
C10336 VPWR.n759 VGND 0.05852f
C10337 VPWR.t44 VGND 0.30082f
C10338 VPWR.t1327 VGND 0.49061f
C10339 VPWR.t336 VGND 0.75351f
C10340 VPWR.t455 VGND 0.33351f
C10341 VPWR.n760 VGND 0.08243f
C10342 VPWR.n761 VGND 0.01444f
C10343 VPWR.t814 VGND 0.03354f
C10344 VPWR.t456 VGND 0.22625f
C10345 VPWR.n762 VGND 0.04834f
C10346 VPWR.n763 VGND 0.05668f
C10347 VPWR.n764 VGND 0.03242f
C10348 VPWR.n765 VGND 0.01673f
C10349 VPWR.n766 VGND 0.01124f
C10350 VPWR.n767 VGND 0.01444f
C10351 VPWR.t674 VGND 0.2102f
C10352 VPWR.n768 VGND 0.05852f
C10353 VPWR.n769 VGND 0.0166f
C10354 VPWR.t724 VGND 0.03874f
C10355 VPWR.n770 VGND 0.05061f
C10356 VPWR.n772 VGND 0.02189f
C10357 VPWR.n773 VGND 0.01137f
C10358 VPWR.t859 VGND 0.41737f
C10359 VPWR.n774 VGND 0.0657f
C10360 VPWR.n775 VGND 0.02752f
C10361 VPWR.t1273 VGND 1.13523f
C10362 VPWR.t220 VGND 0.26666f
C10363 VPWR.t219 VGND 0.26802f
C10364 VPWR.t337 VGND 0.22036f
C10365 VPWR.t695 VGND 0.30499f
C10366 VPWR.t1377 VGND 0.22409f
C10367 VPWR.t1379 VGND 0.03874f
C10368 VPWR.n776 VGND 0.07333f
C10369 VPWR.t1211 VGND 0.62f
C10370 VPWR.n777 VGND 0.05013f
C10371 VPWR.t1448 VGND 0.03354f
C10372 VPWR.n779 VGND 0.0402f
C10373 VPWR.n780 VGND 0.01351f
C10374 VPWR.t1456 VGND 0.19328f
C10375 VPWR.n781 VGND 0.05083f
C10376 VPWR.t1455 VGND 0.33241f
C10377 VPWR.n782 VGND 0.06569f
C10378 VPWR.n783 VGND 0.01444f
C10379 VPWR.t760 VGND 0.06807f
C10380 VPWR.t1453 VGND 0.41318f
C10381 VPWR.n784 VGND 0.05513f
C10382 VPWR.n785 VGND 0.04577f
C10383 VPWR.n786 VGND 0.01828f
C10384 VPWR.t725 VGND 0.03874f
C10385 VPWR.n787 VGND 0.06575f
C10386 VPWR.t1446 VGND 0.29576f
C10387 VPWR.n788 VGND 0.05061f
C10388 VPWR.n789 VGND 0.0166f
C10389 VPWR.t386 VGND 0.03874f
C10390 VPWR.n790 VGND 0.05083f
C10391 VPWR.n791 VGND 0.01124f
C10392 VPWR.t673 VGND 0.36612f
C10393 VPWR.n792 VGND 0.05083f
C10394 VPWR.t385 VGND 0.03874f
C10395 VPWR.n793 VGND 0.05083f
C10396 VPWR.n794 VGND 0.01444f
C10397 VPWR.t282 VGND 0.34178f
C10398 VPWR.n795 VGND 0.05803f
C10399 VPWR.t280 VGND 0.28815f
C10400 VPWR.t816 VGND 0.21459f
C10401 VPWR.t678 VGND 0.42163f
C10402 VPWR.t1227 VGND 0.45337f
C10403 VPWR.n796 VGND 0.05703f
C10404 VPWR.n797 VGND 0.06324f
C10405 VPWR.n798 VGND 0.02748f
C10406 VPWR.t289 VGND 0.25671f
C10407 VPWR.n799 VGND 0.07291f
C10408 VPWR.t281 VGND 0.05766f
C10409 VPWR.t1356 VGND 0.31886f
C10410 VPWR.n800 VGND 0.07059f
C10411 VPWR.n801 VGND 0.03765f
C10412 VPWR.n802 VGND 0.01669f
C10413 VPWR.t335 VGND 0.03874f
C10414 VPWR.t43 VGND 0.30218f
C10415 VPWR.t1342 VGND 0.30686f
C10416 VPWR.n803 VGND 0.05061f
C10417 VPWR.t758 VGND 0.03874f
C10418 VPWR.n805 VGND 0.05061f
C10419 VPWR.t1341 VGND 0.21062f
C10420 VPWR.n806 VGND 0.05061f
C10421 VPWR.n807 VGND 0.0166f
C10422 VPWR.t1248 VGND 0.03874f
C10423 VPWR.n808 VGND 0.04291f
C10424 VPWR.n809 VGND 0.01038f
C10425 VPWR.t378 VGND 0.49596f
C10426 VPWR.n810 VGND 0.05061f
C10427 VPWR.n811 VGND 0.01552f
C10428 VPWR.t1247 VGND 0.03874f
C10429 VPWR.n812 VGND 0.05852f
C10430 VPWR.t1228 VGND 0.03874f
C10431 VPWR.n813 VGND 0.05083f
C10432 VPWR.n814 VGND 0.01552f
C10433 VPWR.t692 VGND 0.21926f
C10434 VPWR.n815 VGND 0.05083f
C10435 VPWR.n816 VGND 0.01038f
C10436 VPWR.t308 VGND 0.03874f
C10437 VPWR.n817 VGND 0.05061f
C10438 VPWR.t1309 VGND 0.20861f
C10439 VPWR.n818 VGND 0.05083f
C10440 VPWR.n819 VGND 0.01552f
C10441 VPWR.t872 VGND 0.21742f
C10442 VPWR.n820 VGND 0.04291f
C10443 VPWR.t1209 VGND 0.03874f
C10444 VPWR.n821 VGND 0.06481f
C10445 VPWR.n822 VGND 0.01038f
C10446 VPWR.t1478 VGND 0.14406f
C10447 VPWR.t551 VGND 0.26189f
C10448 VPWR.t1477 VGND 0.1427f
C10449 VPWR.t1475 VGND 0.42794f
C10450 VPWR.n823 VGND 0.09428f
C10451 VPWR.n824 VGND 0.06745f
C10452 VPWR.t249 VGND 0.46323f
C10453 VPWR.n825 VGND 0.09425f
C10454 VPWR.t1476 VGND 0.42953f
C10455 VPWR.t1216 VGND 0.03874f
C10456 VPWR.n826 VGND 0.04863f
C10457 VPWR.n827 VGND 0.01444f
C10458 VPWR.t909 VGND 0.03874f
C10459 VPWR.n828 VGND 0.05083f
C10460 VPWR.n829 VGND 0.01124f
C10461 VPWR.n831 VGND 0.01552f
C10462 VPWR.t376 VGND 0.03874f
C10463 VPWR.n832 VGND 0.06132f
C10464 VPWR.t75 VGND 0.38555f
C10465 VPWR.n833 VGND 0.01438f
C10466 VPWR.n834 VGND 0.01444f
C10467 VPWR.t1235 VGND 0.15257f
C10468 VPWR.t377 VGND 0.03874f
C10469 VPWR.n835 VGND 0.12407f
C10470 VPWR.n836 VGND 0.01539f
C10471 VPWR.t40 VGND 0.25664f
C10472 VPWR.n837 VGND 0.08581f
C10473 VPWR.n838 VGND 0.05241f
C10474 VPWR.n839 VGND 0.01049f
C10475 VPWR.t1392 VGND 0.22988f
C10476 VPWR.n841 VGND 0.05932f
C10477 VPWR.t321 VGND 0.11592f
C10478 VPWR.t684 VGND 0.03874f
C10479 VPWR.t828 VGND 0.1931f
C10480 VPWR.n842 VGND 0.01552f
C10481 VPWR.t892 VGND 0.03874f
C10482 VPWR.n843 VGND 0.05061f
C10483 VPWR.n844 VGND 0.01038f
C10484 VPWR.n846 VGND 0.01552f
C10485 VPWR.t311 VGND 0.28134f
C10486 VPWR.n847 VGND 0.0657f
C10487 VPWR.n848 VGND 0.02189f
C10488 VPWR.n849 VGND 0.01038f
C10489 VPWR.n851 VGND 0.02301f
C10490 VPWR.n852 VGND 0.02057f
C10491 VPWR.t217 VGND 0.08407f
C10492 VPWR.n853 VGND 0.06147f
C10493 VPWR.t621 VGND 0.29635f
C10494 VPWR.n855 VGND 0.05083f
C10495 VPWR.n856 VGND 0.01124f
C10496 VPWR.t338 VGND 0.03874f
C10497 VPWR.n857 VGND 0.04967f
C10498 VPWR.t85 VGND 0.95026f
C10499 VPWR.n858 VGND 0.09425f
C10500 VPWR.t160 VGND 0.26434f
C10501 VPWR.n859 VGND 0.09428f
C10502 VPWR.n860 VGND 0.09504f
C10503 VPWR.t874 VGND 0.03874f
C10504 VPWR.n861 VGND 0.05777f
C10505 VPWR.t218 VGND 0.08272f
C10506 VPWR.n862 VGND 0.08581f
C10507 VPWR.n863 VGND 0.05257f
C10508 VPWR.n864 VGND 0.01027f
C10509 VPWR.t873 VGND 0.03874f
C10510 VPWR.n865 VGND 0.04291f
C10511 VPWR.t483 VGND 0.18484f
C10512 VPWR.n866 VGND 0.05779f
C10513 VPWR.n867 VGND 0.01038f
C10514 VPWR.t482 VGND 0.03874f
C10515 VPWR.n868 VGND 0.04291f
C10516 VPWR.n869 VGND 0.01038f
C10517 VPWR.t752 VGND 0.03874f
C10518 VPWR.n870 VGND 0.05061f
C10519 VPWR.t1232 VGND 0.03874f
C10520 VPWR.n871 VGND 0.05083f
C10521 VPWR.n872 VGND 0.01552f
C10522 VPWR.t751 VGND 0.03874f
C10523 VPWR.n873 VGND 0.05777f
C10524 VPWR.t668 VGND 0.03874f
C10525 VPWR.t1231 VGND 0.03874f
C10526 VPWR.n874 VGND 0.02189f
C10527 VPWR.t1370 VGND 0.03874f
C10528 VPWR.n875 VGND 0.05803f
C10529 VPWR.t667 VGND 0.03874f
C10530 VPWR.n876 VGND 0.05805f
C10531 VPWR.n877 VGND 0.01124f
C10532 VPWR.t310 VGND 0.15565f
C10533 VPWR.n878 VGND 0.04291f
C10534 VPWR.t1369 VGND 0.11203f
C10535 VPWR.n879 VGND 0.05061f
C10536 VPWR.n880 VGND 0.01038f
C10537 VPWR.t672 VGND 0.18532f
C10538 VPWR.n881 VGND 0.04291f
C10539 VPWR.n882 VGND 0.01038f
C10540 VPWR.t893 VGND 0.03874f
C10541 VPWR.n883 VGND 0.05061f
C10542 VPWR.t671 VGND 0.03874f
C10543 VPWR.n884 VGND 0.05083f
C10544 VPWR.n885 VGND 0.01552f
C10545 VPWR.t1452 VGND 0.03874f
C10546 VPWR.n886 VGND 0.05083f
C10547 VPWR.n887 VGND 0.01038f
C10548 VPWR.t322 VGND 0.03874f
C10549 VPWR.n888 VGND 0.05061f
C10550 VPWR.t1451 VGND 0.03874f
C10551 VPWR.n889 VGND 0.07165f
C10552 VPWR.n890 VGND 0.01552f
C10553 VPWR.t683 VGND 0.03874f
C10554 VPWR.t1430 VGND 0.26525f
C10555 VPWR.n891 VGND 0.05905f
C10556 VPWR.n892 VGND 0.0166f
C10557 VPWR.t467 VGND 0.03874f
C10558 VPWR.t1429 VGND 0.03874f
C10559 VPWR.t466 VGND 0.17485f
C10560 VPWR.t750 VGND 0.14873f
C10561 VPWR.t1391 VGND 0.03874f
C10562 VPWR.n893 VGND 0.04291f
C10563 VPWR.t41 VGND 0.258f
C10564 VPWR.n894 VGND 0.05447f
C10565 VPWR.n895 VGND 0.01459f
C10566 VPWR.t479 VGND 0.23017f
C10567 VPWR.t1250 VGND 0.19215f
C10568 VPWR.t478 VGND 0.11245f
C10569 VPWR.t1236 VGND 0.03874f
C10570 VPWR.t528 VGND 0.09565f
C10571 VPWR.t1249 VGND 0.03874f
C10572 VPWR.n896 VGND 0.09822f
C10573 VPWR.t72 VGND 0.03479f
C10574 VPWR.n897 VGND 0.06f
C10575 VPWR.n898 VGND 0.01751f
C10576 VPWR.t73 VGND 0.38811f
C10577 VPWR.t527 VGND 0.22618f
C10578 VPWR.t1335 VGND 0.19524f
C10579 VPWR.n899 VGND 0.04291f
C10580 VPWR.t1244 VGND 0.03874f
C10581 VPWR.n900 VGND 0.05061f
C10582 VPWR.n901 VGND 0.01038f
C10583 VPWR.t1243 VGND 0.03874f
C10584 VPWR.n902 VGND 0.04291f
C10585 VPWR.n903 VGND 0.01038f
C10586 VPWR.t1334 VGND 0.35494f
C10587 VPWR.n904 VGND 0.06477f
C10588 VPWR.n905 VGND 0.02975f
C10589 VPWR.t910 VGND 0.70933f
C10590 VPWR.t508 VGND 0.03874f
C10591 VPWR.n906 VGND 0.10525f
C10592 VPWR.t1217 VGND 0.03874f
C10593 VPWR.n907 VGND 0.05083f
C10594 VPWR.n908 VGND 0.01444f
C10595 VPWR.t484 VGND 0.29114f
C10596 VPWR.n909 VGND 0.06569f
C10597 VPWR.t248 VGND 0.46458f
C10598 VPWR.n910 VGND 0.05679f
C10599 VPWR.n911 VGND 0.01583f
C10600 VPWR.n912 VGND 0.0133f
C10601 VPWR.n913 VGND 0.02189f
C10602 VPWR.n914 VGND 0.02189f
C10603 VPWR.t867 VGND 0.36802f
C10604 VPWR.n915 VGND 0.06879f
C10605 VPWR.t271 VGND 0.03874f
C10606 VPWR.n916 VGND 0.0633f
C10607 VPWR.n917 VGND 0.02189f
C10608 VPWR.t284 VGND 0.03874f
C10609 VPWR.t270 VGND 0.19513f
C10610 VPWR.n918 VGND 0.09824f
C10611 VPWR.t283 VGND 0.03874f
C10612 VPWR.t469 VGND 0.03874f
C10613 VPWR.n919 VGND 0.09822f
C10614 VPWR.n920 VGND 0.01444f
C10615 VPWR.t474 VGND 0.03874f
C10616 VPWR.n921 VGND 0.05805f
C10617 VPWR.n922 VGND 0.01124f
C10618 VPWR.t622 VGND 0.03874f
C10619 VPWR.n923 VGND 0.05083f
C10620 VPWR.t473 VGND 0.03874f
C10621 VPWR.t468 VGND 0.03874f
C10622 VPWR.n924 VGND 0.09822f
C10623 VPWR.n925 VGND 0.01444f
C10624 VPWR.t1212 VGND 0.03874f
C10625 VPWR.t1368 VGND 0.22874f
C10626 VPWR.n926 VGND 0.10544f
C10627 VPWR.t84 VGND 0.95162f
C10628 VPWR.t159 VGND 0.26569f
C10629 VPWR.n927 VGND 0.09574f
C10630 VPWR.n928 VGND 0.01583f
C10631 VPWR.t418 VGND 0.03958f
C10632 VPWR.t911 VGND 0.30074f
C10633 VPWR.n929 VGND 0.04023f
C10634 VPWR.n930 VGND 0.01211f
C10635 VPWR.t1382 VGND 0.03874f
C10636 VPWR.n931 VGND 0.05083f
C10637 VPWR.n932 VGND 0.01444f
C10638 VPWR.t1383 VGND 0.03874f
C10639 VPWR.n933 VGND 0.05083f
C10640 VPWR.n934 VGND 0.01211f
C10641 VPWR.t858 VGND 0.34672f
C10642 VPWR.n935 VGND 0.03553f
C10643 VPWR.n936 VGND 0.01332f
C10644 VPWR.t897 VGND 0.03874f
C10645 VPWR.n937 VGND 0.05083f
C10646 VPWR.n938 VGND 0.01038f
C10647 VPWR.t471 VGND 0.03874f
C10648 VPWR.n939 VGND 0.06477f
C10649 VPWR.n940 VGND 0.02865f
C10650 VPWR.t297 VGND 0.03874f
C10651 VPWR.n941 VGND 0.06504f
C10652 VPWR.n942 VGND 0.01124f
C10653 VPWR.t898 VGND 0.23948f
C10654 VPWR.n943 VGND 0.05083f
C10655 VPWR.n944 VGND 0.01444f
C10656 VPWR.t298 VGND 0.22855f
C10657 VPWR.t1384 VGND 0.3002f
C10658 VPWR.n945 VGND 0.09824f
C10659 VPWR.n946 VGND 0.02189f
C10660 VPWR.t1385 VGND 0.03874f
C10661 VPWR.n947 VGND 0.05803f
C10662 VPWR.n948 VGND 0.01124f
C10663 VPWR.t1330 VGND 0.03874f
C10664 VPWR.n949 VGND 0.05083f
C10665 VPWR.n950 VGND 0.01444f
C10666 VPWR.t1331 VGND 0.34813f
C10667 VPWR.n951 VGND 0.05852f
C10668 VPWR.n952 VGND 0.01552f
C10669 VPWR.t472 VGND 0.03874f
C10670 VPWR.n953 VGND 0.05083f
C10671 VPWR.n954 VGND 0.01038f
C10672 VPWR.t1459 VGND 0.03874f
C10673 VPWR.n955 VGND 0.05061f
C10674 VPWR.n956 VGND 0.01552f
C10675 VPWR.t810 VGND 0.03874f
C10676 VPWR.n957 VGND 0.05083f
C10677 VPWR.n958 VGND 0.01038f
C10678 VPWR.t1460 VGND 0.03874f
C10679 VPWR.n959 VGND 0.05061f
C10680 VPWR.n960 VGND 0.01552f
C10681 VPWR.t323 VGND 0.03874f
C10682 VPWR.n961 VGND 0.05083f
C10683 VPWR.n962 VGND 0.01038f
C10684 VPWR.t1218 VGND 0.03874f
C10685 VPWR.n963 VGND 0.05061f
C10686 VPWR.n964 VGND 0.01552f
C10687 VPWR.t811 VGND 0.03874f
C10688 VPWR.n965 VGND 0.05083f
C10689 VPWR.n966 VGND 0.01038f
C10690 VPWR.t1219 VGND 0.03874f
C10691 VPWR.n967 VGND 0.05061f
C10692 VPWR.n968 VGND 0.01552f
C10693 VPWR.t680 VGND 0.03874f
C10694 VPWR.n969 VGND 0.05852f
C10695 VPWR.n970 VGND 0.0166f
C10696 VPWR.t1241 VGND 0.03874f
C10697 VPWR.n971 VGND 0.05061f
C10698 VPWR.t681 VGND 0.03874f
C10699 VPWR.n973 VGND 0.04291f
C10700 VPWR.n974 VGND 0.01038f
C10701 VPWR.t1242 VGND 0.26063f
C10702 VPWR.n975 VGND 0.05061f
C10703 VPWR.n976 VGND 0.01552f
C10704 VPWR.t266 VGND 0.03874f
C10705 VPWR.n977 VGND 0.05083f
C10706 VPWR.n978 VGND 0.01038f
C10707 VPWR.t686 VGND 0.14968f
C10708 VPWR.n979 VGND 0.05061f
C10709 VPWR.n980 VGND 0.01008f
C10710 VPWR.t166 VGND 0.31646f
C10711 VPWR.n981 VGND 0.06214f
C10712 VPWR.t688 VGND 0.26562f
C10713 VPWR.t164 VGND 0.31903f
C10714 VPWR.t1372 VGND 0.37712f
C10715 VPWR.t163 VGND 0.03479f
C10716 VPWR.t1373 VGND 0.03874f
C10717 VPWR.t267 VGND 0.03874f
C10718 VPWR.n982 VGND 0.10156f
C10719 VPWR.n983 VGND 0.02189f
C10720 VPWR.t1411 VGND 0.23104f
C10721 VPWR.t849 VGND 0.03874f
C10722 VPWR.n984 VGND 0.12617f
C10723 VPWR.n985 VGND 0.04267f
C10724 VPWR.t507 VGND 0.03874f
C10725 VPWR.n986 VGND 0.07879f
C10726 VPWR.n987 VGND 0.01124f
C10727 VPWR.t887 VGND 0.03874f
C10728 VPWR.n988 VGND 0.04967f
C10729 VPWR.n990 VGND 0.10144f
C10730 VPWR.n991 VGND 0.10355f
C10731 VPWR.n992 VGND 1.40899f
C10732 VPWR.t239 VGND 1.31252f
C10733 VPWR.t438 VGND 0.14629f
C10734 VPWR.n993 VGND 0.06166f
C10735 VPWR.n994 VGND 0.02742f
C10736 VPWR.t1387 VGND 0.34312f
C10737 VPWR.t878 VGND 0.31535f
C10738 VPWR.n995 VGND 0.11247f
C10739 VPWR.n996 VGND 0.02189f
C10740 VPWR.t879 VGND 0.03874f
C10741 VPWR.n997 VGND 0.06569f
C10742 VPWR.n998 VGND 0.01552f
C10743 VPWR.t360 VGND 0.03874f
C10744 VPWR.n999 VGND 0.05852f
C10745 VPWR.n1000 VGND 0.01552f
C10746 VPWR.t1388 VGND 0.03874f
C10747 VPWR.n1001 VGND 0.05061f
C10748 VPWR.n1002 VGND 0.01038f
C10749 VPWR.t868 VGND 0.2188f
C10750 VPWR.n1003 VGND 0.04291f
C10751 VPWR.t437 VGND 0.03874f
C10752 VPWR.n1005 VGND 0.05061f
C10753 VPWR.n1006 VGND 0.0166f
C10754 VPWR.t869 VGND 0.36967f
C10755 VPWR.n1007 VGND 0.06573f
C10756 VPWR.n1008 VGND 0.02189f
C10757 VPWR.t417 VGND 0.33551f
C10758 VPWR.t439 VGND 0.03874f
C10759 VPWR.n1009 VGND 0.10546f
C10760 VPWR.n1010 VGND 0.02189f
C10761 VPWR.t818 VGND 0.29238f
C10762 VPWR.t444 VGND 0.20677f
C10763 VPWR.n1011 VGND 0.10542f
C10764 VPWR.n1012 VGND 0.02189f
C10765 VPWR.t819 VGND 0.20903f
C10766 VPWR.t445 VGND 0.03874f
C10767 VPWR.n1013 VGND 0.10546f
C10768 VPWR.n1014 VGND 0.02189f
C10769 VPWR.t447 VGND 0.21488f
C10770 VPWR.t295 VGND 0.03874f
C10771 VPWR.n1015 VGND 0.10542f
C10772 VPWR.n1016 VGND 0.02189f
C10773 VPWR.t448 VGND 0.30332f
C10774 VPWR.t296 VGND 0.03874f
C10775 VPWR.n1017 VGND 0.10546f
C10776 VPWR.n1018 VGND 0.02189f
C10777 VPWR.t362 VGND 0.21587f
C10778 VPWR.t1336 VGND 0.03874f
C10779 VPWR.n1019 VGND 0.10542f
C10780 VPWR.n1020 VGND 0.02189f
C10781 VPWR.t363 VGND 0.35095f
C10782 VPWR.t1337 VGND 0.21315f
C10783 VPWR.n1021 VGND 0.10546f
C10784 VPWR.n1022 VGND 0.02189f
C10785 VPWR.t852 VGND 0.3097f
C10786 VPWR.t704 VGND 0.21741f
C10787 VPWR.n1023 VGND 0.10542f
C10788 VPWR.n1024 VGND 0.02189f
C10789 VPWR.t853 VGND 0.22695f
C10790 VPWR.t1225 VGND 0.16203f
C10791 VPWR.n1025 VGND 0.09824f
C10792 VPWR.n1026 VGND 0.01444f
C10793 VPWR.t705 VGND 0.03874f
C10794 VPWR.n1027 VGND 0.05083f
C10795 VPWR.n1028 VGND 0.01124f
C10796 VPWR.t371 VGND 0.28533f
C10797 VPWR.n1029 VGND 0.05803f
C10798 VPWR.n1030 VGND 0.02189f
C10799 VPWR.t475 VGND 0.45774f
C10800 VPWR.t617 VGND 0.03874f
C10801 VPWR.n1031 VGND 0.10546f
C10802 VPWR.n1032 VGND 0.02189f
C10803 VPWR.t372 VGND 0.52226f
C10804 VPWR.t863 VGND 0.03874f
C10805 VPWR.n1033 VGND 0.10542f
C10806 VPWR.n1034 VGND 0.02189f
C10807 VPWR.t675 VGND 0.30435f
C10808 VPWR.t435 VGND 0.15031f
C10809 VPWR.n1035 VGND 0.11941f
C10810 VPWR.n1036 VGND 0.03439f
C10811 VPWR.t676 VGND 0.46558f
C10812 VPWR.t618 VGND 0.2348f
C10813 VPWR.n1037 VGND 0.11936f
C10814 VPWR.t238 VGND 1.31117f
C10815 VPWR.n1038 VGND 0.08581f
C10816 VPWR.n1039 VGND 0.06644f
C10817 VPWR.n1040 VGND 0.02287f
C10818 VPWR.n1041 VGND 0.0133f
C10819 VPWR.n1043 VGND 1.40899f
C10820 VPWR.t184 VGND 0.03341f
C10821 VPWR.n1044 VGND 0.09425f
C10822 VPWR.t81 VGND 0.19794f
C10823 VPWR.n1045 VGND 0.09428f
C10824 VPWR.n1046 VGND 0.09504f
C10825 VPWR.t183 VGND 0.03477f
C10826 VPWR.t80 VGND 0.19929f
C10827 VPWR.n1047 VGND 0.08866f
C10828 VPWR.t696 VGND 0.19026f
C10829 VPWR.t866 VGND 0.16777f
C10830 VPWR.t1431 VGND 0.16797f
C10831 VPWR.t865 VGND 0.03903f
C10832 VPWR.t645 VGND 0.21161f
C10833 VPWR.t1340 VGND 0.03903f
C10834 VPWR.t876 VGND 0.03874f
C10835 VPWR.t644 VGND 0.38447f
C10836 VPWR.t844 VGND 0.36233f
C10837 VPWR.n1048 VGND 0.08058f
C10838 VPWR.n1049 VGND 0.02189f
C10839 VPWR.t1333 VGND 0.03874f
C10840 VPWR.t843 VGND 0.51185f
C10841 VPWR.n1050 VGND 0.09824f
C10842 VPWR.t663 VGND 0.24415f
C10843 VPWR.n1052 VGND 0.02189f
C10844 VPWR.n1053 VGND 0.01444f
C10845 VPWR.t452 VGND 0.03874f
C10846 VPWR.n1054 VGND 0.05083f
C10847 VPWR.n1055 VGND 0.01124f
C10848 VPWR.t193 VGND 0.12722f
C10849 VPWR.t201 VGND 0.32646f
C10850 VPWR.n1056 VGND 0.0166f
C10851 VPWR.t805 VGND 0.03874f
C10852 VPWR.n1057 VGND 0.05061f
C10853 VPWR.n1059 VGND 0.01654f
C10854 VPWR.t149 VGND 0.25459f
C10855 VPWR.n1060 VGND 0.01008f
C10856 VPWR.t103 VGND 0.12894f
C10857 VPWR.n1061 VGND 0.06148f
C10858 VPWR.n1062 VGND 0.02189f
C10859 VPWR.n1063 VGND 0.01124f
C10860 VPWR.n1064 VGND 0.01444f
C10861 VPWR.t908 VGND 0.34851f
C10862 VPWR.n1065 VGND 0.05852f
C10863 VPWR.n1066 VGND 0.01552f
C10864 VPWR.t552 VGND 0.03874f
C10865 VPWR.n1067 VGND 0.05083f
C10866 VPWR.n1068 VGND 0.01038f
C10867 VPWR.t23 VGND 0.03341f
C10868 VPWR.n1069 VGND 0.09425f
C10869 VPWR.t34 VGND 0.03341f
C10870 VPWR.n1070 VGND 0.09428f
C10871 VPWR.t22 VGND 0.03477f
C10872 VPWR.t33 VGND 0.03477f
C10873 VPWR.t1222 VGND 0.49815f
C10874 VPWR.t1329 VGND 0.03874f
C10875 VPWR.n1071 VGND 0.04967f
C10876 VPWR.n1072 VGND 0.01124f
C10877 VPWR.n1073 VGND 0.05083f
C10878 VPWR.n1075 VGND 0.08866f
C10879 VPWR.n1076 VGND 0.0173f
C10880 VPWR.n1077 VGND 0.11571f
C10881 VPWR.t570 VGND 0.23626f
C10882 VPWR.t553 VGND 0.03874f
C10883 VPWR.t426 VGND 0.03874f
C10884 VPWR.t569 VGND 0.35921f
C10885 VPWR.t831 VGND 0.31231f
C10886 VPWR.n1078 VGND 0.0648f
C10887 VPWR.n1079 VGND 0.01038f
C10888 VPWR.t860 VGND 0.03874f
C10889 VPWR.n1080 VGND 0.05083f
C10890 VPWR.t830 VGND 0.19362f
C10891 VPWR.n1081 VGND 0.05061f
C10892 VPWR.n1082 VGND 0.01552f
C10893 VPWR.t1447 VGND 0.03874f
C10894 VPWR.n1083 VGND 0.05083f
C10895 VPWR.n1084 VGND 0.01124f
C10896 VPWR.t481 VGND 0.03874f
C10897 VPWR.n1085 VGND 0.05083f
C10898 VPWR.t907 VGND 0.38416f
C10899 VPWR.n1086 VGND 0.05083f
C10900 VPWR.n1087 VGND 0.01444f
C10901 VPWR.t677 VGND 0.03874f
C10902 VPWR.n1088 VGND 0.05803f
C10903 VPWR.t1214 VGND 0.21543f
C10904 VPWR.t1054 VGND 0.17241f
C10905 VPWR.n1089 VGND 0.10544f
C10906 VPWR.n1090 VGND 0.02189f
C10907 VPWR.t1213 VGND 0.03874f
C10908 VPWR.t1053 VGND 0.30608f
C10909 VPWR.n1091 VGND 0.10544f
C10910 VPWR.n1092 VGND 0.02189f
C10911 VPWR.t815 VGND 0.13322f
C10912 VPWR.t1376 VGND 0.28173f
C10913 VPWR.n1093 VGND 0.09824f
C10914 VPWR.t144 VGND 0.61613f
C10915 VPWR.n1094 VGND 0.05747f
C10916 VPWR.n1095 VGND 0.01007f
C10917 VPWR.t1375 VGND 0.52471f
C10918 VPWR.t102 VGND 0.71285f
C10919 VPWR.t630 VGND 0.64012f
C10920 VPWR.t628 VGND 0.18604f
C10921 VPWR.n1096 VGND 0.05061f
C10922 VPWR.t1233 VGND 0.03874f
C10923 VPWR.n1098 VGND 0.06111f
C10924 VPWR.t606 VGND 0.33335f
C10925 VPWR.t150 VGND 0.55523f
C10926 VPWR.t605 VGND 0.21447f
C10927 VPWR.t765 VGND 0.2584f
C10928 VPWR.t152 VGND 0.33286f
C10929 VPWR.n1099 VGND 0.05457f
C10930 VPWR.t535 VGND 0.1815f
C10931 VPWR.n1100 VGND 0.05779f
C10932 VPWR.n1101 VGND 0.01038f
C10933 VPWR.t293 VGND 0.03874f
C10934 VPWR.n1102 VGND 0.05083f
C10935 VPWR.t534 VGND 0.32425f
C10936 VPWR.n1103 VGND 0.05061f
C10937 VPWR.n1104 VGND 0.01552f
C10938 VPWR.t1173 VGND 0.24771f
C10939 VPWR.n1105 VGND 0.05061f
C10940 VPWR.t1215 VGND 0.03874f
C10941 VPWR.n1107 VGND 0.06111f
C10942 VPWR.t768 VGND 0.3872f
C10943 VPWR.t115 VGND 0.32902f
C10944 VPWR.t913 VGND 0.22993f
C10945 VPWR.t116 VGND 0.03478f
C10946 VPWR.t1408 VGND 0.12978f
C10947 VPWR.n1108 VGND 0.05086f
C10948 VPWR.n1109 VGND 0.05131f
C10949 VPWR.t1256 VGND 0.17373f
C10950 VPWR.t1500 VGND 0.44837f
C10951 VPWR.t729 VGND 0.17629f
C10952 VPWR.t1015 VGND 0.47993f
C10953 VPWR.t375 VGND 0.24355f
C10954 VPWR.t730 VGND 0.03478f
C10955 VPWR.t94 VGND 0.27148f
C10956 VPWR.n1110 VGND 0.15725f
C10957 VPWR.n1111 VGND 0.10281f
C10958 VPWR.t95 VGND 0.17647f
C10959 VPWR.t254 VGND 0.3677f
C10960 VPWR.n1113 VGND 0.05086f
C10961 VPWR.n1114 VGND 0.04745f
C10962 VPWR.t637 VGND 0.43978f
C10963 VPWR.n1115 VGND 0.05083f
C10964 VPWR.t451 VGND 0.03874f
C10965 VPWR.n1117 VGND 0.05803f
C10966 VPWR.t689 VGND 0.24366f
C10967 VPWR.n1118 VGND 0.05083f
C10968 VPWR.n1119 VGND 0.01124f
C10969 VPWR.t690 VGND 0.03874f
C10970 VPWR.n1120 VGND 0.05779f
C10971 VPWR.n1121 VGND 0.01038f
C10972 VPWR.t304 VGND 0.26728f
C10973 VPWR.t861 VGND 0.17744f
C10974 VPWR.t241 VGND 0.17213f
C10975 VPWR.t408 VGND 0.71134f
C10976 VPWR.t240 VGND 0.17078f
C10977 VPWR.t243 VGND 0.03477f
C10978 VPWR.n1122 VGND 0.01308f
C10979 VPWR.t855 VGND 0.03874f
C10980 VPWR.n1123 VGND 0.06105f
C10981 VPWR.n1124 VGND 0.02189f
C10982 VPWR.t856 VGND 0.03874f
C10983 VPWR.t587 VGND 0.38607f
C10984 VPWR.n1125 VGND 0.09824f
C10985 VPWR.n1126 VGND 0.01444f
C10986 VPWR.t485 VGND 0.27822f
C10987 VPWR.n1127 VGND 0.05083f
C10988 VPWR.n1128 VGND 0.01124f
C10989 VPWR.t274 VGND 0.03874f
C10990 VPWR.n1129 VGND 0.05083f
C10991 VPWR.n1130 VGND 0.01444f
C10992 VPWR.t406 VGND 0.49248f
C10993 VPWR.n1131 VGND 0.05083f
C10994 VPWR.n1132 VGND 0.01124f
C10995 VPWR.t275 VGND 0.22222f
C10996 VPWR.n1133 VGND 0.05083f
C10997 VPWR.n1134 VGND 0.01444f
C10998 VPWR.t1351 VGND 0.03874f
C10999 VPWR.n1135 VGND 0.05083f
C11000 VPWR.n1136 VGND 0.01124f
C11001 VPWR.t669 VGND 0.03874f
C11002 VPWR.n1137 VGND 0.05083f
C11003 VPWR.n1138 VGND 0.01444f
C11004 VPWR.t1416 VGND 0.03874f
C11005 VPWR.n1139 VGND 0.06569f
C11006 VPWR.n1140 VGND 0.02301f
C11007 VPWR.t1417 VGND 0.12759f
C11008 VPWR.n1141 VGND 0.0657f
C11009 VPWR.n1142 VGND 0.01444f
C11010 VPWR.t1419 VGND 0.32935f
C11011 VPWR.n1143 VGND 0.05083f
C11012 VPWR.n1144 VGND 0.01124f
C11013 VPWR.t290 VGND 0.03874f
C11014 VPWR.n1145 VGND 0.05083f
C11015 VPWR.n1146 VGND 0.01444f
C11016 VPWR.t804 VGND 0.20626f
C11017 VPWR.n1147 VGND 0.05083f
C11018 VPWR.n1148 VGND 0.01124f
C11019 VPWR.t611 VGND 0.03874f
C11020 VPWR.n1149 VGND 0.05083f
C11021 VPWR.n1150 VGND 0.01444f
C11022 VPWR.t1346 VGND 0.03874f
C11023 VPWR.n1151 VGND 0.05852f
C11024 VPWR.n1152 VGND 0.01552f
C11025 VPWR.t1022 VGND 0.12927f
C11026 VPWR.n1153 VGND 0.05747f
C11027 VPWR.t192 VGND 0.38444f
C11028 VPWR.n1154 VGND 0.09425f
C11029 VPWR.n1155 VGND 0.07266f
C11030 VPWR.t191 VGND 0.3858f
C11031 VPWR.t558 VGND 0.33332f
C11032 VPWR.n1157 VGND 0.04237f
C11033 VPWR.n1158 VGND 0.04885f
C11034 VPWR.t588 VGND 0.13596f
C11035 VPWR.n1160 VGND 0.05083f
C11036 VPWR.t1386 VGND 0.37707f
C11037 VPWR.n1162 VGND 0.04917f
C11038 VPWR.n1163 VGND 0.02169f
C11039 VPWR.t1152 VGND 0.12417f
C11040 VPWR.n1164 VGND 0.06497f
C11041 VPWR.n1165 VGND 0.02813f
C11042 VPWR.t670 VGND 0.03354f
C11043 VPWR.n1166 VGND 0.06174f
C11044 VPWR.n1167 VGND 0.02162f
C11045 VPWR.t557 VGND 0.03354f
C11046 VPWR.n1168 VGND 0.05451f
C11047 VPWR.n1169 VGND 0.01676f
C11048 VPWR.t703 VGND 0.47118f
C11049 VPWR.n1170 VGND 0.05034f
C11050 VPWR.n1171 VGND 0.02119f
C11051 VPWR.t306 VGND 0.05766f
C11052 VPWR.n1172 VGND 0.05726f
C11053 VPWR.n1173 VGND 0.01153f
C11054 VPWR.t359 VGND 0.98375f
C11055 VPWR.n1174 VGND 0.076f
C11056 VPWR.n1175 VGND 0.02146f
C11057 VPWR.t734 VGND 0.48776f
C11058 VPWR.n1176 VGND 0.06179f
C11059 VPWR.n1177 VGND 0.01416f
C11060 VPWR.t1374 VGND 0.03874f
C11061 VPWR.n1178 VGND 0.07197f
C11062 VPWR.n1179 VGND 0.03441f
C11063 VPWR.t305 VGND 0.03874f
C11064 VPWR.t987 VGND 0.03874f
C11065 VPWR.n1180 VGND 0.11937f
C11066 VPWR.t242 VGND 0.03341f
C11067 VPWR.n1181 VGND 0.08581f
C11068 VPWR.n1182 VGND 0.06835f
C11069 VPWR.n1183 VGND 0.02287f
C11070 VPWR.n1184 VGND 0.0133f
C11071 VPWR.n1186 VGND 0.74292f
C11072 VPWR.n1187 VGND 0.58517f
C11073 VPWR.n1188 VGND 0.01038f
C11074 VPWR.n1189 VGND 0.01178f
C11075 VPWR.n1190 VGND 0.04469f
C11076 VPWR.n1191 VGND 0.01027f
C11077 VPWR.n1192 VGND 0.05086f
C11078 VPWR.n1193 VGND 0.05457f
C11079 VPWR.n1194 VGND 0.01654f
C11080 VPWR.n1195 VGND 0.05779f
C11081 VPWR.n1196 VGND 0.01038f
C11082 VPWR.n1197 VGND 0.05083f
C11083 VPWR.n1198 VGND 0.01552f
C11084 VPWR.n1199 VGND 0.06573f
C11085 VPWR.n1200 VGND 0.02189f
C11086 VPWR.n1201 VGND 0.05574f
C11087 VPWR.n1202 VGND 0.04064f
C11088 VPWR.n1203 VGND 0.01817f
C11089 VPWR.n1204 VGND 0.07291f
C11090 VPWR.n1205 VGND 0.01812f
C11091 VPWR.n1206 VGND 0.05364f
C11092 VPWR.n1207 VGND 0.01319f
C11093 VPWR.n1208 VGND 0.05803f
C11094 VPWR.n1209 VGND 0.02189f
C11095 VPWR.n1210 VGND 0.05779f
C11096 VPWR.n1211 VGND 0.01038f
C11097 VPWR.n1212 VGND 0.04291f
C11098 VPWR.n1214 VGND 0.05061f
C11099 VPWR.n1215 VGND 0.0166f
C11100 VPWR.n1216 VGND 0.05852f
C11101 VPWR.n1217 VGND 0.01444f
C11102 VPWR.n1218 VGND 0.05083f
C11103 VPWR.n1219 VGND 0.01124f
C11104 VPWR.n1220 VGND 0.05083f
C11105 VPWR.n1221 VGND 0.01444f
C11106 VPWR.n1222 VGND 0.06569f
C11107 VPWR.n1223 VGND 0.02662f
C11108 VPWR.n1224 VGND 0.06876f
C11109 VPWR.n1225 VGND 0.0104f
C11110 VPWR.n1226 VGND 0.05548f
C11111 VPWR.n1227 VGND 0.05529f
C11112 VPWR.n1228 VGND 0.02189f
C11113 VPWR.n1229 VGND 0.07291f
C11114 VPWR.n1230 VGND 0.02189f
C11115 VPWR.n1231 VGND 0.05513f
C11116 VPWR.n1232 VGND 0.04577f
C11117 VPWR.n1233 VGND 0.0139f
C11118 VPWR.n1234 VGND 0.05438f
C11119 VPWR.t1466 VGND 1.04318f
C11120 VPWR.t993 VGND 0.4332f
C11121 VPWR.t881 VGND 0.03874f
C11122 VPWR.t593 VGND 0.23143f
C11123 VPWR.t582 VGND 0.03874f
C11124 VPWR.t1124 VGND 0.31127f
C11125 VPWR.t1468 VGND 0.03477f
C11126 VPWR.t1469 VGND 0.03341f
C11127 VPWR.n1235 VGND 0.09425f
C11128 VPWR.t597 VGND 0.17523f
C11129 VPWR.n1236 VGND 0.07378f
C11130 VPWR.t1467 VGND 1.04183f
C11131 VPWR.t1197 VGND 0.22686f
C11132 VPWR.n1237 VGND 0.02189f
C11133 VPWR.n1238 VGND 0.01444f
C11134 VPWR.t522 VGND 0.03874f
C11135 VPWR.t470 VGND 0.45305f
C11136 VPWR.n1239 VGND 0.09824f
C11137 VPWR.n1240 VGND 0.02189f
C11138 VPWR.t945 VGND 0.03897f
C11139 VPWR.t176 VGND 0.03341f
C11140 VPWR.n1241 VGND 0.09428f
C11141 VPWR.n1242 VGND 0.1191f
C11142 VPWR.t1142 VGND 0.03874f
C11143 VPWR.t1068 VGND 0.23281f
C11144 VPWR.n1243 VGND 0.1056f
C11145 VPWR.t366 VGND 0.03874f
C11146 VPWR.n1244 VGND 0.05083f
C11147 VPWR.n1245 VGND 0.01124f
C11148 VPWR.t1105 VGND 0.33567f
C11149 VPWR.n1246 VGND 0.05083f
C11150 VPWR.n1247 VGND 0.01007f
C11151 VPWR.t721 VGND 0.03874f
C11152 VPWR.t129 VGND 0.03479f
C11153 VPWR.n1248 VGND 0.04715f
C11154 VPWR.t578 VGND 0.03892f
C11155 VPWR.t130 VGND 0.13696f
C11156 VPWR.t773 VGND 0.03874f
C11157 VPWR.t132 VGND 0.1344f
C11158 VPWR.t802 VGND 0.03874f
C11159 VPWR.t1063 VGND 0.24947f
C11160 VPWR.n1249 VGND 0.11704f
C11161 VPWR.t521 VGND 0.03874f
C11162 VPWR.t785 VGND 0.37474f
C11163 VPWR.n1250 VGND 0.10544f
C11164 VPWR.n1251 VGND 0.02189f
C11165 VPWR.t402 VGND 0.03874f
C11166 VPWR.n1252 VGND 0.07291f
C11167 VPWR.t526 VGND 0.03874f
C11168 VPWR.t1118 VGND 0.24218f
C11169 VPWR.n1253 VGND 0.02189f
C11170 VPWR.t268 VGND 0.44561f
C11171 VPWR.t1137 VGND 0.03874f
C11172 VPWR.t494 VGND 0.03874f
C11173 VPWR.t397 VGND 0.20528f
C11174 VPWR.n1254 VGND 0.58532f
C11175 VPWR.n1255 VGND 0.53908f
C11176 VPWR.n1256 VGND 0.02999f
C11177 VPWR.t146 VGND 0.62649f
C11178 VPWR.n1257 VGND 0.09428f
C11179 VPWR.t78 VGND 0.80952f
C11180 VPWR.t145 VGND 0.62784f
C11181 VPWR.t316 VGND 0.03874f
C11182 VPWR.t427 VGND 0.03874f
C11183 VPWR.t615 VGND 0.03874f
C11184 VPWR.t278 VGND 0.21297f
C11185 VPWR.t1502 VGND 0.03874f
C11186 VPWR.t1182 VGND 0.03874f
C11187 VPWR.t712 VGND 0.03874f
C11188 VPWR.t1407 VGND 0.03874f
C11189 VPWR.t1268 VGND 0.03874f
C11190 VPWR.t1464 VGND 0.03874f
C11191 VPWR.t228 VGND 0.3423f
C11192 VPWR.n1258 VGND 0.09428f
C11193 VPWR.t361 VGND 0.03874f
C11194 VPWR.t227 VGND 0.34365f
C11195 VPWR.t951 VGND 0.21749f
C11196 VPWR.t1131 VGND 0.4495f
C11197 VPWR.t1064 VGND 0.03874f
C11198 VPWR.t576 VGND 0.17446f
C11199 VPWR.t794 VGND 0.03874f
C11200 VPWR.t826 VGND 0.56986f
C11201 VPWR.t1438 VGND 0.03874f
C11202 VPWR.t1106 VGND 0.04098f
C11203 VPWR.t550 VGND 0.94622f
C11204 VPWR.t1501 VGND 0.26836f
C11205 VPWR.t373 VGND 0.75776f
C11206 VPWR.t1260 VGND 0.03857f
C11207 VPWR.t518 VGND 0.03874f
C11208 VPWR.t214 VGND 0.3131f
C11209 VPWR.t442 VGND 0.03892f
C11210 VPWR.t111 VGND 0.6711f
C11211 VPWR.t1308 VGND 0.03874f
C11212 VPWR.t110 VGND 0.39022f
C11213 VPWR.t658 VGND 0.03874f
C11214 VPWR.t430 VGND 0.03874f
C11215 VPWR.t1206 VGND 0.13165f
C11216 VPWR.t312 VGND 0.03874f
C11217 VPWR.t790 VGND 0.03874f
C11218 VPWR.t555 VGND 0.03874f
C11219 VPWR.t608 VGND 0.03874f
C11220 VPWR.t1149 VGND 0.03874f
C11221 VPWR.t1144 VGND 0.03874f
C11222 VPWR.t379 VGND 0.03874f
C11223 VPWR.t1147 VGND 0.03874f
C11224 VPWR.t661 VGND 0.69617f
C11225 VPWR.t574 VGND 0.03874f
C11226 VPWR.t216 VGND 0.14182f
C11227 VPWR.n1259 VGND 0.09428f
C11228 VPWR.t1263 VGND 0.23426f
C11229 VPWR.t215 VGND 0.14317f
C11230 VPWR.t1200 VGND 0.03874f
C11231 VPWR.t666 VGND 0.03874f
C11232 VPWR.t964 VGND 0.05766f
C11233 VPWR.t1070 VGND 0.03874f
C11234 VPWR.t965 VGND 0.70151f
C11235 VPWR.t920 VGND 0.03874f
C11236 VPWR.t4 VGND 0.03341f
C11237 VPWR.t3 VGND 0.03477f
C11238 VPWR.t822 VGND 0.03874f
C11239 VPWR.t491 VGND 0.03874f
C11240 VPWR.n1260 VGND 0.0735f
C11241 VPWR.n1261 VGND 0.01785f
C11242 VPWR.n1262 VGND 0.07291f
C11243 VPWR.n1263 VGND 0.01557f
C11244 VPWR.n1264 VGND 0.03851f
C11245 VPWR.n1265 VGND 0.04974f
C11246 VPWR.n1266 VGND 0.01444f
C11247 VPWR.n1267 VGND 0.06569f
C11248 VPWR.n1268 VGND 0.01583f
C11249 VPWR.n1269 VGND 0.05366f
C11250 VPWR.n1270 VGND 0.03095f
C11251 VPWR.n1271 VGND 0.01535f
C11252 VPWR.n1272 VGND 0.07989f
C11253 VPWR.n1273 VGND 0.05795f
C11254 VPWR.n1274 VGND 0.01221f
C11255 VPWR.n1275 VGND 0.05428f
C11256 VPWR.n1276 VGND 0.02189f
C11257 VPWR.n1277 VGND 0.08421f
C11258 VPWR.n1278 VGND 0.0147f
C11259 VPWR.n1279 VGND 0.04233f
C11260 VPWR.n1280 VGND 0.02547f
C11261 VPWR.n1281 VGND 0.06476f
C11262 VPWR.n1282 VGND 0.01137f
C11263 VPWR.n1283 VGND 0.04274f
C11264 VPWR.n1284 VGND 0.01319f
C11265 VPWR.n1285 VGND 0.06605f
C11266 VPWR.n1286 VGND 0.02383f
C11267 VPWR.n1287 VGND 0.0657f
C11268 VPWR.n1288 VGND 0.01471f
C11269 VPWR.n1289 VGND 0.04832f
C11270 VPWR.n1290 VGND 0.01103f
C11271 VPWR.n1291 VGND 0.05803f
C11272 VPWR.n1292 VGND 0.01735f
C11273 VPWR.n1293 VGND 0.04608f
C11274 VPWR.n1294 VGND 0.05576f
C11275 VPWR.n1295 VGND 0.02189f
C11276 VPWR.n1296 VGND 0.10768f
C11277 VPWR.n1297 VGND 0.01472f
C11278 VPWR.n1298 VGND 0.05679f
C11279 VPWR.n1299 VGND 0.04863f
C11280 VPWR.n1300 VGND 0.06788f
C11281 VPWR.n1301 VGND 0.05565f
C11282 VPWR.n1302 VGND 0.02189f
C11283 VPWR.n1303 VGND 0.09824f
C11284 VPWR.n1304 VGND 0.01444f
C11285 VPWR.n1305 VGND 0.05852f
C11286 VPWR.n1306 VGND 0.0166f
C11287 VPWR.n1307 VGND 0.05061f
C11288 VPWR.n1309 VGND 0.05777f
C11289 VPWR.n1310 VGND 0.02189f
C11290 VPWR.n1311 VGND 0.05805f
C11291 VPWR.n1312 VGND 0.01124f
C11292 VPWR.n1313 VGND 0.05083f
C11293 VPWR.n1314 VGND 0.01444f
C11294 VPWR.n1315 VGND 0.05083f
C11295 VPWR.n1316 VGND 0.01124f
C11296 VPWR.n1317 VGND 0.05083f
C11297 VPWR.n1319 VGND 0.09449f
C11298 VPWR.n1320 VGND 0.09331f
C11299 VPWR.t602 VGND 0.13114f
C11300 VPWR.t1058 VGND 0.03874f
C11301 VPWR.n1321 VGND 0.12637f
C11302 VPWR.t584 VGND 0.22355f
C11303 VPWR.n1322 VGND 0.07201f
C11304 VPWR.n1323 VGND 0.0344f
C11305 VPWR.t612 VGND 0.65258f
C11306 VPWR.n1324 VGND 0.05276f
C11307 VPWR.t1030 VGND 0.03354f
C11308 VPWR.n1326 VGND 0.05273f
C11309 VPWR.n1327 VGND 0.03726f
C11310 VPWR.t370 VGND 0.48541f
C11311 VPWR.n1328 VGND 0.05704f
C11312 VPWR.n1329 VGND 0.01247f
C11313 VPWR.t1006 VGND 0.12632f
C11314 VPWR.n1330 VGND 0.06488f
C11315 VPWR.t840 VGND 0.3266f
C11316 VPWR.n1331 VGND 0.06884f
C11317 VPWR.n1332 VGND 0.02094f
C11318 VPWR.t1504 VGND 0.03874f
C11319 VPWR.n1333 VGND 0.05083f
C11320 VPWR.n1334 VGND 0.01124f
C11321 VPWR.t722 VGND 0.03874f
C11322 VPWR.n1335 VGND 0.05083f
C11323 VPWR.t1465 VGND 0.03874f
C11324 VPWR.t1119 VGND 0.03874f
C11325 VPWR.n1336 VGND 0.09822f
C11326 VPWR.n1337 VGND 0.01444f
C11327 VPWR.t812 VGND 0.52308f
C11328 VPWR.n1338 VGND 0.03151f
C11329 VPWR.n1339 VGND 0.01124f
C11330 VPWR.t1087 VGND 0.03874f
C11331 VPWR.n1340 VGND 0.05779f
C11332 VPWR.n1341 VGND 0.0241f
C11333 VPWR.t821 VGND 0.25688f
C11334 VPWR.n1342 VGND 0.05017f
C11335 VPWR.n1343 VGND 0.0144f
C11336 VPWR.t277 VGND 0.03874f
C11337 VPWR.n1344 VGND 0.05852f
C11338 VPWR.n1345 VGND 0.01444f
C11339 VPWR.t458 VGND 0.20251f
C11340 VPWR.n1346 VGND 0.05852f
C11341 VPWR.n1347 VGND 0.0166f
C11342 VPWR.t441 VGND 0.27077f
C11343 VPWR.n1348 VGND 0.05061f
C11344 VPWR.t851 VGND 0.03874f
C11345 VPWR.n1350 VGND 0.04291f
C11346 VPWR.n1351 VGND 0.01038f
C11347 VPWR.t1071 VGND 0.03874f
C11348 VPWR.n1352 VGND 0.06477f
C11349 VPWR.n1353 VGND 0.02979f
C11350 VPWR.t348 VGND 0.03874f
C11351 VPWR.n1354 VGND 0.06477f
C11352 VPWR.n1355 VGND 0.01038f
C11353 VPWR.t775 VGND 0.21535f
C11354 VPWR.n1356 VGND 0.05083f
C11355 VPWR.n1357 VGND 0.01552f
C11356 VPWR.t635 VGND 0.03874f
C11357 VPWR.n1358 VGND 0.05061f
C11358 VPWR.n1359 VGND 0.01038f
C11359 VPWR.t523 VGND 0.03874f
C11360 VPWR.n1360 VGND 0.04291f
C11361 VPWR.n1361 VGND 0.01027f
C11362 VPWR.t134 VGND 0.26615f
C11363 VPWR.n1362 VGND 0.0858f
C11364 VPWR.n1363 VGND 0.05258f
C11365 VPWR.t983 VGND 0.03874f
C11366 VPWR.t133 VGND 0.2675f
C11367 VPWR.n1364 VGND 0.05593f
C11368 VPWR.n1365 VGND 0.05007f
C11369 VPWR.n1366 VGND 0.01566f
C11370 VPWR.n1367 VGND 0.0173f
C11371 VPWR.n1368 VGND 0.08628f
C11372 VPWR.n1369 VGND 0.53879f
C11373 VPWR.t56 VGND 0.33969f
C11374 VPWR.n1370 VGND 0.05447f
C11375 VPWR.n1371 VGND 0.0166f
C11376 VPWR.t586 VGND 0.03874f
C11377 VPWR.n1372 VGND 0.05061f
C11378 VPWR.n1374 VGND 0.01654f
C11379 VPWR.t125 VGND 0.1344f
C11380 VPWR.t342 VGND 0.03874f
C11381 VPWR.n1376 VGND 0.04899f
C11382 VPWR.n1377 VGND 0.04715f
C11383 VPWR.n1378 VGND 0.01007f
C11384 VPWR.t1012 VGND 0.03874f
C11385 VPWR.n1379 VGND 0.05083f
C11386 VPWR.n1380 VGND 0.01124f
C11387 VPWR.n1381 VGND 0.01038f
C11388 VPWR.t57 VGND 0.33833f
C11389 VPWR.n1382 VGND 0.08581f
C11390 VPWR.n1383 VGND 0.04468f
C11391 VPWR.n1384 VGND 0.01027f
C11392 VPWR.t1109 VGND 0.28837f
C11393 VPWR.t1367 VGND 0.03874f
C11394 VPWR.t1016 VGND 0.03874f
C11395 VPWR.t748 VGND 0.42072f
C11396 VPWR.t1366 VGND 0.03874f
C11397 VPWR.n1386 VGND 0.04291f
C11398 VPWR.t428 VGND 0.03874f
C11399 VPWR.n1387 VGND 0.06377f
C11400 VPWR.n1388 VGND 0.01038f
C11401 VPWR.t1326 VGND 0.03874f
C11402 VPWR.n1389 VGND 0.04291f
C11403 VPWR.n1390 VGND 0.01038f
C11404 VPWR.t341 VGND 0.20006f
C11405 VPWR.n1391 VGND 0.05061f
C11406 VPWR.n1392 VGND 0.01552f
C11407 VPWR.t1047 VGND 0.36236f
C11408 VPWR.n1393 VGND 0.07268f
C11409 VPWR.n1394 VGND 0.02975f
C11410 VPWR.t1023 VGND 0.03874f
C11411 VPWR.t1099 VGND 0.45899f
C11412 VPWR.n1395 VGND 0.10525f
C11413 VPWR.t524 VGND 0.03874f
C11414 VPWR.n1397 VGND 0.04291f
C11415 VPWR.n1398 VGND 0.01038f
C11416 VPWR.t719 VGND 0.26446f
C11417 VPWR.n1399 VGND 0.05061f
C11418 VPWR.t6 VGND 0.05942f
C11419 VPWR.n1400 VGND 0.05447f
C11420 VPWR.t7 VGND 0.05806f
C11421 VPWR.n1402 VGND 0.0858f
C11422 VPWR.n1403 VGND 0.0523f
C11423 VPWR.t123 VGND 0.14371f
C11424 VPWR.t124 VGND 0.14236f
C11425 VPWR.n1404 VGND 0.08581f
C11426 VPWR.n1405 VGND 0.05958f
C11427 VPWR.t1220 VGND 0.50237f
C11428 VPWR.n1406 VGND 0.05805f
C11429 VPWR.n1407 VGND 0.02175f
C11430 VPWR.t955 VGND 0.03892f
C11431 VPWR.t126 VGND 0.13696f
C11432 VPWR.n1408 VGND 0.15728f
C11433 VPWR.n1409 VGND 0.12659f
C11434 VPWR.t128 VGND 0.03478f
C11435 VPWR.n1410 VGND 0.06866f
C11436 VPWR.n1411 VGND 0.01168f
C11437 VPWR.t1009 VGND 0.22044f
C11438 VPWR.n1412 VGND 0.04291f
C11439 VPWR.t896 VGND 0.03874f
C11440 VPWR.n1413 VGND 0.05779f
C11441 VPWR.n1414 VGND 0.01038f
C11442 VPWR.t968 VGND 0.03874f
C11443 VPWR.n1415 VGND 0.05061f
C11444 VPWR.t1111 VGND 0.03874f
C11445 VPWR.n1417 VGND 0.06087f
C11446 VPWR.t1037 VGND 0.03874f
C11447 VPWR.t189 VGND 0.58538f
C11448 VPWR.t640 VGND 0.03874f
C11449 VPWR.t780 VGND 0.03874f
C11450 VPWR.t935 VGND 0.03874f
C11451 VPWR.t962 VGND 0.37559f
C11452 VPWR.t234 VGND 0.03478f
C11453 VPWR.n1418 VGND 0.01448f
C11454 VPWR.n1419 VGND 0.01282f
C11455 VPWR.t205 VGND 0.30844f
C11456 VPWR.n1420 VGND 0.06714f
C11457 VPWR.n1421 VGND 0.01038f
C11458 VPWR.n1422 VGND 0.0166f
C11459 VPWR.t926 VGND 0.03874f
C11460 VPWR.n1423 VGND 0.05061f
C11461 VPWR.n1424 VGND 0.01027f
C11462 VPWR.n1425 VGND 0.01444f
C11463 VPWR.t1078 VGND 0.03874f
C11464 VPWR.n1426 VGND 0.06101f
C11465 VPWR.t384 VGND 0.03897f
C11466 VPWR.t190 VGND 0.58402f
C11467 VPWR.n1427 VGND 0.09428f
C11468 VPWR.n1428 VGND 0.12645f
C11469 VPWR.t1128 VGND 0.28846f
C11470 VPWR.t931 VGND 0.03874f
C11471 VPWR.t1251 VGND 0.1636f
C11472 VPWR.t1180 VGND 0.23967f
C11473 VPWR.t960 VGND 0.03874f
C11474 VPWR.t1040 VGND 0.03874f
C11475 VPWR.t930 VGND 0.26575f
C11476 VPWR.n1429 VGND 0.09822f
C11477 VPWR.n1430 VGND 0.01583f
C11478 VPWR.t1021 VGND 0.03874f
C11479 VPWR.t112 VGND 0.05942f
C11480 VPWR.n1431 VGND 0.05593f
C11481 VPWR.n1432 VGND 0.05007f
C11482 VPWR.t113 VGND 0.05806f
C11483 VPWR.n1433 VGND 0.08581f
C11484 VPWR.n1434 VGND 0.05257f
C11485 VPWR.n1435 VGND 0.01566f
C11486 VPWR.t1060 VGND 0.23019f
C11487 VPWR.n1436 VGND 0.05061f
C11488 VPWR.t940 VGND 0.03874f
C11489 VPWR.n1438 VGND 0.05061f
C11490 VPWR.n1439 VGND 0.0166f
C11491 VPWR.t1133 VGND 0.03874f
C11492 VPWR.n1440 VGND 0.05852f
C11493 VPWR.t746 VGND 0.25066f
C11494 VPWR.n1441 VGND 0.05083f
C11495 VPWR.n1442 VGND 0.01444f
C11496 VPWR.t825 VGND 0.03874f
C11497 VPWR.n1443 VGND 0.05777f
C11498 VPWR.t1108 VGND 0.04098f
C11499 VPWR.t1107 VGND 0.44352f
C11500 VPWR.t1471 VGND 5.20589f
C11501 VPWR.t383 VGND 0.50349f
C11502 VPWR.n1444 VGND 0.0406f
C11503 VPWR.t206 VGND 1.05501f
C11504 VPWR.n1445 VGND 0.15725f
C11505 VPWR.t1041 VGND 0.03896f
C11506 VPWR.n1446 VGND 0.12698f
C11507 VPWR.n1447 VGND 0.01168f
C11508 VPWR.t230 VGND 0.77879f
C11509 VPWR.n1448 VGND 0.06155f
C11510 VPWR.t231 VGND 0.25176f
C11511 VPWR.n1449 VGND 0.05278f
C11512 VPWR.t232 VGND 0.25432f
C11513 VPWR.t823 VGND 0.0388f
C11514 VPWR.t517 VGND 0.03874f
C11515 VPWR.t933 VGND 0.03874f
C11516 VPWR.t345 VGND 0.24072f
C11517 VPWR.n1451 VGND 0.08295f
C11518 VPWR.n1452 VGND 0.02189f
C11519 VPWR.t1074 VGND 0.03874f
C11520 VPWR.t795 VGND 0.03874f
C11521 VPWR.n1453 VGND 0.09824f
C11522 VPWR.t1090 VGND 0.03874f
C11523 VPWR.t382 VGND 0.15135f
C11524 VPWR.n1454 VGND 0.09822f
C11525 VPWR.n1455 VGND 0.01444f
C11526 VPWR.t251 VGND 0.03479f
C11527 VPWR.t148 VGND 0.17426f
C11528 VPWR.n1456 VGND 0.01221f
C11529 VPWR.t1138 VGND 0.03874f
C11530 VPWR.t1126 VGND 0.25547f
C11531 VPWR.t919 VGND 0.03874f
C11532 VPWR.t1026 VGND 0.22513f
C11533 VPWR.t1188 VGND 0.03874f
C11534 VPWR.t343 VGND 0.26047f
C11535 VPWR.n1457 VGND 0.07093f
C11536 VPWR.n1458 VGND 0.06107f
C11537 VPWR.n1459 VGND 0.02189f
C11538 VPWR.n1460 VGND 0.09822f
C11539 VPWR.n1461 VGND 0.01444f
C11540 VPWR.n1462 VGND 0.0984f
C11541 VPWR.t141 VGND 1.7374f
C11542 VPWR.n1463 VGND 0.09425f
C11543 VPWR.n1464 VGND 0.07992f
C11544 VPWR.n1465 VGND 0.01308f
C11545 VPWR.t140 VGND 1.73876f
C11546 VPWR.t929 VGND 0.03874f
C11547 VPWR.n1466 VGND 0.04237f
C11548 VPWR.n1467 VGND 0.04885f
C11549 VPWR.t980 VGND 0.03874f
C11550 VPWR.n1469 VGND 0.05083f
C11551 VPWR.n1470 VGND 0.01124f
C11552 VPWR.t1097 VGND 0.21846f
C11553 VPWR.n1471 VGND 0.05083f
C11554 VPWR.n1472 VGND 0.01444f
C11555 VPWR.t367 VGND 0.03874f
C11556 VPWR.n1473 VGND 0.05083f
C11557 VPWR.n1474 VGND 0.01038f
C11558 VPWR.t1193 VGND 0.03874f
C11559 VPWR.n1475 VGND 0.05779f
C11560 VPWR.n1476 VGND 0.02189f
C11561 VPWR.t327 VGND 0.03874f
C11562 VPWR.t260 VGND 0.21873f
C11563 VPWR.n1477 VGND 0.10542f
C11564 VPWR.n1478 VGND 0.02189f
C11565 VPWR.t1134 VGND 0.03874f
C11566 VPWR.t1423 VGND 0.24593f
C11567 VPWR.t1130 VGND 0.03874f
C11568 VPWR.t344 VGND 0.1541f
C11569 VPWR.t723 VGND 0.03874f
C11570 VPWR.t519 VGND 0.2183f
C11571 VPWR.t1075 VGND 0.03874f
C11572 VPWR.t515 VGND 0.30399f
C11573 VPWR.n1479 VGND 0.02077f
C11574 VPWR.t1380 VGND 0.03874f
C11575 VPWR.t368 VGND 0.17137f
C11576 VPWR.n1480 VGND 0.10546f
C11577 VPWR.n1481 VGND 0.02189f
C11578 VPWR.t257 VGND 0.13482f
C11579 VPWR.n1482 VGND 0.05803f
C11580 VPWR.n1483 VGND 0.01124f
C11581 VPWR.t509 VGND 0.03874f
C11582 VPWR.n1484 VGND 0.05083f
C11583 VPWR.n1485 VGND 0.01444f
C11584 VPWR.t433 VGND 0.35105f
C11585 VPWR.n1486 VGND 0.05083f
C11586 VPWR.n1487 VGND 0.01124f
C11587 VPWR.t1190 VGND 0.03874f
C11588 VPWR.n1488 VGND 0.05083f
C11589 VPWR.n1489 VGND 0.01444f
C11590 VPWR.t1035 VGND 0.2137f
C11591 VPWR.n1490 VGND 0.05083f
C11592 VPWR.n1491 VGND 0.01124f
C11593 VPWR.t573 VGND 0.03874f
C11594 VPWR.n1492 VGND 0.05083f
C11595 VPWR.n1493 VGND 0.01444f
C11596 VPWR.t1150 VGND 0.03874f
C11597 VPWR.n1494 VGND 0.05083f
C11598 VPWR.n1495 VGND 0.01124f
C11599 VPWR.t991 VGND 0.03874f
C11600 VPWR.n1496 VGND 0.05083f
C11601 VPWR.n1497 VGND 0.01444f
C11602 VPWR.t1362 VGND 0.21684f
C11603 VPWR.n1498 VGND 0.05083f
C11604 VPWR.n1499 VGND 0.01124f
C11605 VPWR.t1151 VGND 0.03874f
C11606 VPWR.n1500 VGND 0.05083f
C11607 VPWR.n1501 VGND 0.01444f
C11608 VPWR.t495 VGND 0.08326f
C11609 VPWR.t1094 VGND 0.12779f
C11610 VPWR.n1502 VGND 0.10636f
C11611 VPWR.t38 VGND 0.26542f
C11612 VPWR.n1503 VGND 0.09428f
C11613 VPWR.n1504 VGND 0.08689f
C11614 VPWR.n1505 VGND 0.01788f
C11615 VPWR.t37 VGND 0.26678f
C11616 VPWR.t969 VGND 0.03874f
C11617 VPWR.n1506 VGND 0.04237f
C11618 VPWR.n1507 VGND 0.04971f
C11619 VPWR.t36 VGND 0.08459f
C11620 VPWR.n1509 VGND 0.06407f
C11621 VPWR.t35 VGND 0.08715f
C11622 VPWR.t147 VGND 0.1729f
C11623 VPWR.n1510 VGND 0.0133f
C11624 VPWR.n1511 VGND 0.01038f
C11625 VPWR.n1512 VGND 0.74292f
C11626 VPWR.n1513 VGND 0.74292f
C11627 VPWR.n1515 VGND 0.10229f
C11628 VPWR.n1516 VGND 0.74292f
C11629 VPWR.t108 VGND 0.29337f
C11630 VPWR.t15 VGND 0.08272f
C11631 VPWR.n1517 VGND 0.02189f
C11632 VPWR.n1518 VGND 0.01038f
C11633 VPWR.n1519 VGND 0.01232f
C11634 VPWR.n1521 VGND 0.02189f
C11635 VPWR.n1522 VGND 0.01459f
C11636 VPWR.n1524 VGND 0.01444f
C11637 VPWR.t1008 VGND 0.32612f
C11638 VPWR.n1525 VGND 0.05083f
C11639 VPWR.n1526 VGND 0.01124f
C11640 VPWR.t326 VGND 0.26171f
C11641 VPWR.n1527 VGND 0.04967f
C11642 VPWR.n1528 VGND 0.01124f
C11643 VPWR.t949 VGND 0.35009f
C11644 VPWR.n1529 VGND 0.05083f
C11645 VPWR.t1061 VGND 0.26282f
C11646 VPWR.n1530 VGND 0.05083f
C11647 VPWR.n1531 VGND 0.01444f
C11648 VPWR.t561 VGND 0.32822f
C11649 VPWR.t571 VGND 0.29362f
C11650 VPWR.n1532 VGND 0.09822f
C11651 VPWR.n1533 VGND 0.02189f
C11652 VPWR.t870 VGND 0.3663f
C11653 VPWR.n1534 VGND 0.06575f
C11654 VPWR.t786 VGND 0.03874f
C11655 VPWR.n1535 VGND 0.05061f
C11656 VPWR.n1536 VGND 0.0166f
C11657 VPWR.t1199 VGND 0.20252f
C11658 VPWR.n1537 VGND 0.04291f
C11659 VPWR.n1538 VGND 0.01038f
C11660 VPWR.t1069 VGND 0.37283f
C11661 VPWR.n1539 VGND 0.05061f
C11662 VPWR.t54 VGND 0.22327f
C11663 VPWR.n1540 VGND 0.05447f
C11664 VPWR.t513 VGND 0.39691f
C11665 VPWR.n1542 VGND 0.04291f
C11666 VPWR.n1543 VGND 0.01049f
C11667 VPWR.t55 VGND 0.22191f
C11668 VPWR.n1544 VGND 0.0858f
C11669 VPWR.n1545 VGND 0.05242f
C11670 VPWR.t834 VGND 0.3492f
C11671 VPWR.t1080 VGND 0.03874f
C11672 VPWR.n1546 VGND 0.09822f
C11673 VPWR.n1547 VGND 0.01539f
C11674 VPWR.t1104 VGND 0.20958f
C11675 VPWR.t944 VGND 0.03874f
C11676 VPWR.n1548 VGND 0.10544f
C11677 VPWR.n1549 VGND 0.02189f
C11678 VPWR.t979 VGND 0.03874f
C11679 VPWR.n1550 VGND 0.06575f
C11680 VPWR.t1081 VGND 3.17622f
C11681 VPWR.n1551 VGND 0.03732f
C11682 VPWR.n1552 VGND 0.0198f
C11683 VPWR.t961 VGND 0.22511f
C11684 VPWR.n1553 VGND 0.05777f
C11685 VPWR.n1554 VGND 0.02189f
C11686 VPWR.t1102 VGND 0.39066f
C11687 VPWR.n1555 VGND 0.06575f
C11688 VPWR.t314 VGND 2.0233f
C11689 VPWR.n1556 VGND 0.04637f
C11690 VPWR.n1557 VGND 0.01292f
C11691 VPWR.t942 VGND 0.26707f
C11692 VPWR.n1558 VGND 0.05777f
C11693 VPWR.t1024 VGND 0.32703f
C11694 VPWR.n1559 VGND 0.05805f
C11695 VPWR.n1560 VGND 0.02189f
C11696 VPWR.t958 VGND 0.24378f
C11697 VPWR.n1561 VGND 0.05777f
C11698 VPWR.t498 VGND 0.83667f
C11699 VPWR.t1487 VGND 0.40991f
C11700 VPWR.n1562 VGND 0.10544f
C11701 VPWR.n1563 VGND 0.02189f
C11702 VPWR.t1103 VGND 0.35314f
C11703 VPWR.t1001 VGND 0.22139f
C11704 VPWR.n1564 VGND 0.10544f
C11705 VPWR.t885 VGND 0.37221f
C11706 VPWR.t1202 VGND 0.30806f
C11707 VPWR.n1565 VGND 0.12259f
C11708 VPWR.n1566 VGND 0.02189f
C11709 VPWR.t429 VGND 0.21881f
C11710 VPWR.t820 VGND 0.3839f
C11711 VPWR.t1019 VGND 0.28523f
C11712 VPWR.t16 VGND 0.08407f
C11713 VPWR.t109 VGND 0.29472f
C11714 VPWR.t118 VGND 1.10451f
C11715 VPWR.t186 VGND 0.48852f
C11716 VPWR.t1066 VGND 0.33725f
C11717 VPWR.t187 VGND 0.18211f
C11718 VPWR.t117 VGND 0.64821f
C11719 VPWR.t1404 VGND 0.03354f
C11720 VPWR.t1092 VGND 0.03874f
C11721 VPWR.t761 VGND 0.52484f
C11722 VPWR.t591 VGND 0.25945f
C11723 VPWR.t353 VGND 0.30821f
C11724 VPWR.t387 VGND 0.34896f
C11725 VPWR.t537 VGND 0.35376f
C11726 VPWR.n1567 VGND 0.13f
C11727 VPWR.n1568 VGND 0.02189f
C11728 VPWR.t1262 VGND 0.41526f
C11729 VPWR.t832 VGND 0.35264f
C11730 VPWR.n1569 VGND 0.09824f
C11731 VPWR.n1570 VGND 0.01444f
C11732 VPWR.t431 VGND 0.23507f
C11733 VPWR.n1571 VGND 0.05083f
C11734 VPWR.n1572 VGND 0.01124f
C11735 VPWR.t407 VGND 0.35811f
C11736 VPWR.n1573 VGND 0.05083f
C11737 VPWR.n1574 VGND 0.01444f
C11738 VPWR.t354 VGND 0.40919f
C11739 VPWR.t974 VGND 0.24442f
C11740 VPWR.n1575 VGND 0.09822f
C11741 VPWR.n1576 VGND 0.02189f
C11742 VPWR.t520 VGND 0.32708f
C11743 VPWR.n1577 VGND 0.05805f
C11744 VPWR.n1578 VGND 0.01124f
C11745 VPWR.t631 VGND 0.38056f
C11746 VPWR.t1510 VGND 0.28079f
C11747 VPWR.t1091 VGND 0.25519f
C11748 VPWR.n1579 VGND 0.07197f
C11749 VPWR.n1580 VGND 0.03441f
C11750 VPWR.n1581 VGND 0.0173f
C11751 VPWR.t99 VGND 0.52699f
C11752 VPWR.n1582 VGND 0.09425f
C11753 VPWR.t136 VGND 0.27833f
C11754 VPWR.n1583 VGND 0.09428f
C11755 VPWR.t98 VGND 0.52835f
C11756 VPWR.t135 VGND 0.27969f
C11757 VPWR.t504 VGND 0.37479f
C11758 VPWR.t654 VGND 0.21296f
C11759 VPWR.t1073 VGND 0.22001f
C11760 VPWR.t1020 VGND 0.39723f
C11761 VPWR.t950 VGND 0.4169f
C11762 VPWR.t1110 VGND 0.20873f
C11763 VPWR.t985 VGND 0.16905f
C11764 VPWR.t261 VGND 0.40124f
C11765 VPWR.t1255 VGND 0.22866f
C11766 VPWR.t978 VGND 0.1713f
C11767 VPWR.n1584 VGND 0.08077f
C11768 VPWR.n1585 VGND 0.0647f
C11769 VPWR.n1586 VGND 0.01444f
C11770 VPWR.n1587 VGND 0.05083f
C11771 VPWR.n1588 VGND 0.01124f
C11772 VPWR.n1589 VGND 0.11235f
C11773 VPWR.n1590 VGND 0.01583f
C11774 VPWR.n1591 VGND 0.09574f
C11775 VPWR.n1592 VGND 0.0173f
C11776 VPWR.n1593 VGND 0.0985f
C11777 VPWR.t1112 VGND 1.02619f
C11778 VPWR.t653 VGND 0.35074f
C11779 VPWR.n1594 VGND 0.09706f
C11780 VPWR.t179 VGND 0.76415f
C11781 VPWR.t64 VGND 0.22124f
C11782 VPWR.n1595 VGND 0.09574f
C11783 VPWR.n1596 VGND 0.01583f
C11784 VPWR.t971 VGND 0.03874f
C11785 VPWR.t924 VGND 0.5822f
C11786 VPWR.t577 VGND 0.42462f
C11787 VPWR.t503 VGND 0.41036f
C11788 VPWR.t1072 VGND 0.7836f
C11789 VPWR.t381 VGND 0.41273f
C11790 VPWR.t972 VGND 0.14905f
C11791 VPWR.t918 VGND 0.22574f
C11792 VPWR.t1347 VGND 0.29323f
C11793 VPWR.t717 VGND 0.63652f
C11794 VPWR.t583 VGND 0.21528f
C11795 VPWR.t395 VGND 0.30363f
C11796 VPWR.t510 VGND 0.48619f
C11797 VPWR.t392 VGND 0.2428f
C11798 VPWR.t398 VGND 0.2561f
C11799 VPWR.t490 VGND 0.21513f
C11800 VPWR.t89 VGND 0.03477f
C11801 VPWR.t641 VGND 0.38416f
C11802 VPWR.t88 VGND 0.03341f
C11803 VPWR.n1597 VGND 0.08581f
C11804 VPWR.t211 VGND 0.31546f
C11805 VPWR.t212 VGND 0.31411f
C11806 VPWR.n1598 VGND 0.09425f
C11807 VPWR.t1086 VGND 0.22219f
C11808 VPWR.n1599 VGND 0.10497f
C11809 VPWR.n1600 VGND 0.0173f
C11810 VPWR.n1601 VGND 0.05447f
C11811 VPWR.n1603 VGND 0.05241f
C11812 VPWR.n1604 VGND 0.01049f
C11813 VPWR.n1605 VGND 0.04291f
C11814 VPWR.n1606 VGND 0.01459f
C11815 VPWR.n1607 VGND 0.05447f
C11816 VPWR.n1609 VGND 0.05061f
C11817 VPWR.n1610 VGND 0.01038f
C11818 VPWR.n1611 VGND 0.04291f
C11819 VPWR.n1613 VGND 0.04291f
C11820 VPWR.n1614 VGND 0.01038f
C11821 VPWR.n1615 VGND 0.05061f
C11822 VPWR.n1616 VGND 0.01552f
C11823 VPWR.n1617 VGND 0.0657f
C11824 VPWR.n1618 VGND 0.02189f
C11825 VPWR.n1619 VGND 0.05803f
C11826 VPWR.n1621 VGND 0.0421f
C11827 VPWR.n1622 VGND 0.01772f
C11828 VPWR.n1623 VGND 0.07272f
C11829 VPWR.n1624 VGND 0.02975f
C11830 VPWR.n1625 VGND 0.06228f
C11831 VPWR.n1626 VGND 0.05548f
C11832 VPWR.n1627 VGND 0.07266f
C11833 VPWR.n1628 VGND 0.0104f
C11834 VPWR.n1629 VGND 0.04896f
C11835 VPWR.n1630 VGND 0.05611f
C11836 VPWR.t180 VGND 0.76279f
C11837 VPWR.n1631 VGND 0.09425f
C11838 VPWR.t65 VGND 0.21988f
C11839 VPWR.n1632 VGND 0.09428f
C11840 VPWR.n1633 VGND 0.10575f
C11841 VPWR.t331 VGND 0.04548f
C11842 VPWR.t188 VGND 0.18076f
C11843 VPWR.t1479 VGND 1.15354f
C11844 VPWR.t1113 VGND 0.22264f
C11845 VPWR.t1004 VGND 0.3197f
C11846 VPWR.t1045 VGND 0.38463f
C11847 VPWR.t603 VGND 0.26626f
C11848 VPWR.t848 VGND 0.38156f
C11849 VPWR.t1011 VGND 0.20552f
C11850 VPWR.t941 VGND 0.36563f
C11851 VPWR.t1261 VGND 0.34088f
C11852 VPWR.t936 VGND 0.04168f
C11853 VPWR.t638 VGND 0.39762f
C11854 VPWR.n1634 VGND 0.08359f
C11855 VPWR.n1635 VGND 0.03919f
C11856 VPWR.n1637 VGND 0.05061f
C11857 VPWR.n1638 VGND 0.01552f
C11858 VPWR.n1639 VGND 0.05852f
C11859 VPWR.n1640 VGND 0.01552f
C11860 VPWR.n1641 VGND 0.05083f
C11861 VPWR.n1642 VGND 0.01038f
C11862 VPWR.n1643 VGND 0.05061f
C11863 VPWR.n1644 VGND 0.01552f
C11864 VPWR.n1645 VGND 0.0657f
C11865 VPWR.n1646 VGND 0.02189f
C11866 VPWR.n1647 VGND 0.1056f
C11867 VPWR.t1480 VGND 1.15218f
C11868 VPWR.n1648 VGND 0.09425f
C11869 VPWR.t486 VGND 0.22188f
C11870 VPWR.n1649 VGND 0.11912f
C11871 VPWR.n1650 VGND 0.74292f
C11872 VPWR.n1651 VGND 0.74292f
C11873 VPWR.t195 VGND 0.05966f
C11874 VPWR.t756 VGND 0.09614f
C11875 VPWR.t17 VGND 0.24262f
C11876 VPWR.t781 VGND 0.23515f
C11877 VPWR.t1409 VGND 0.03874f
C11878 VPWR.t1181 VGND 0.26924f
C11879 VPWR.t1364 VGND 0.40748f
C11880 VPWR.t1140 VGND 0.03874f
C11881 VPWR.t917 VGND 0.43019f
C11882 VPWR.t25 VGND 0.17793f
C11883 VPWR.t24 VGND 0.81631f
C11884 VPWR.t889 VGND 0.43194f
C11885 VPWR.t994 VGND 0.03874f
C11886 VPWR.t198 VGND 0.6706f
C11887 VPWR.t903 VGND 0.53723f
C11888 VPWR.n1652 VGND 0.08581f
C11889 VPWR.t1017 VGND 0.03874f
C11890 VPWR.t904 VGND 0.53858f
C11891 VPWR.t902 VGND 0.41635f
C11892 VPWR.t501 VGND 0.36292f
C11893 VPWR.t744 VGND 0.06817f
C11894 VPWR.t900 VGND 0.62326f
C11895 VPWR.n1653 VGND 0.15728f
C11896 VPWR.t899 VGND 0.23913f
C11897 VPWR.t857 VGND 0.42763f
C11898 VPWR.t1441 VGND 0.27681f
C11899 VPWR.t1032 VGND 0.22075f
C11900 VPWR.t1442 VGND 0.12975f
C11901 VPWR.t500 VGND 0.05766f
C11902 VPWR.t19 VGND 0.13168f
C11903 VPWR.t923 VGND 0.47314f
C11904 VPWR.t20 VGND 0.38741f
C11905 VPWR.n1654 VGND 0.14635f
C11906 VPWR.t247 VGND 0.28795f
C11907 VPWR.t339 VGND 0.24849f
C11908 VPWR.t779 VGND 0.06174f
C11909 VPWR.t1114 VGND 0.03874f
C11910 VPWR.t1323 VGND 0.08474f
C11911 VPWR.t1311 VGND 0.03874f
C11912 VPWR.t914 VGND 0.21921f
C11913 VPWR.t93 VGND 0.59358f
C11914 VPWR.t946 VGND 0.22213f
C11915 VPWR.t91 VGND 0.72828f
C11916 VPWR.n1655 VGND 0.15725f
C11917 VPWR.t967 VGND 0.38526f
C11918 VPWR.t90 VGND 0.16692f
C11919 VPWR.t777 VGND 0.35869f
C11920 VPWR.t315 VGND 0.15338f
C11921 VPWR.t710 VGND 0.29821f
C11922 VPWR.t502 VGND 0.03874f
C11923 VPWR.t875 VGND 0.2054f
C11924 VPWR.t656 VGND 0.36575f
C11925 VPWR.t1428 VGND 0.39333f
C11926 VPWR.t506 VGND 0.38532f
C11927 VPWR.t1034 VGND 0.41111f
C11928 VPWR.t1029 VGND 0.2609f
C11929 VPWR.t1007 VGND 0.35503f
C11930 VPWR.t1208 VGND 0.22423f
C11931 VPWR.t774 VGND 0.09428f
C11932 VPWR.t380 VGND 0.78349f
C11933 VPWR.t1095 VGND 0.37008f
C11934 VPWR.t1319 VGND 0.17513f
C11935 VPWR.t1317 VGND 0.32134f
C11936 VPWR.t1363 VGND 0.21372f
C11937 VPWR.t882 VGND 0.03874f
C11938 VPWR.t200 VGND 0.21951f
C11939 VPWR.n1656 VGND 0.08581f
C11940 VPWR.t199 VGND 0.22086f
C11941 VPWR.t1314 VGND 0.48729f
C11942 VPWR.t1003 VGND 0.03874f
C11943 VPWR.n1657 VGND 0.04967f
C11944 VPWR.n1658 VGND 0.01124f
C11945 VPWR.n1659 VGND 0.05083f
C11946 VPWR.n1661 VGND 0.06147f
C11947 VPWR.n1662 VGND 0.02057f
C11948 VPWR.n1663 VGND 0.05257f
C11949 VPWR.n1664 VGND 0.01027f
C11950 VPWR.n1665 VGND 0.05777f
C11951 VPWR.n1666 VGND 0.0648f
C11952 VPWR.n1667 VGND 0.01038f
C11953 VPWR.n1668 VGND 0.05083f
C11954 VPWR.n1669 VGND 0.01552f
C11955 VPWR.n1670 VGND 0.05852f
C11956 VPWR.n1671 VGND 0.01444f
C11957 VPWR.n1672 VGND 0.09822f
C11958 VPWR.n1673 VGND 0.02189f
C11959 VPWR.n1674 VGND 0.05805f
C11960 VPWR.n1675 VGND 0.01124f
C11961 VPWR.n1676 VGND 0.05083f
C11962 VPWR.n1677 VGND 0.01444f
C11963 VPWR.n1678 VGND 0.05852f
C11964 VPWR.n1679 VGND 0.0166f
C11965 VPWR.n1680 VGND 0.05061f
C11966 VPWR.n1682 VGND 0.04291f
C11967 VPWR.n1683 VGND 0.01038f
C11968 VPWR.n1684 VGND 0.13243f
C11969 VPWR.n1686 VGND 0.051f
C11970 VPWR.n1687 VGND 0.05543f
C11971 VPWR.n1688 VGND 0.01542f
C11972 VPWR.n1689 VGND 0.05805f
C11973 VPWR.n1690 VGND 0.01124f
C11974 VPWR.n1691 VGND 0.05083f
C11975 VPWR.n1692 VGND 0.01444f
C11976 VPWR.n1693 VGND 0.05083f
C11977 VPWR.n1694 VGND 0.01124f
C11978 VPWR.n1695 VGND 0.05083f
C11979 VPWR.n1696 VGND 0.01444f
C11980 VPWR.n1697 VGND 0.09822f
C11981 VPWR.n1698 VGND 0.01751f
C11982 VPWR.n1699 VGND 0.07414f
C11983 VPWR.n1700 VGND 0.01899f
C11984 VPWR.n1701 VGND 0.0699f
C11985 VPWR.n1702 VGND 0.05447f
C11986 VPWR.n1703 VGND 0.01591f
C11987 VPWR.n1704 VGND 0.07419f
C11988 VPWR.n1705 VGND 0.01703f
C11989 VPWR.n1706 VGND 0.05026f
C11990 VPWR.n1707 VGND 0.01492f
C11991 VPWR.n1708 VGND 0.05803f
C11992 VPWR.n1709 VGND 0.02189f
C11993 VPWR.n1710 VGND 0.05779f
C11994 VPWR.n1712 VGND 0.03875f
C11995 VPWR.n1713 VGND 0.0193f
C11996 VPWR.n1714 VGND 0.05852f
C11997 VPWR.n1715 VGND 0.01007f
C11998 VPWR.n1716 VGND 0.05992f
C11999 VPWR.n1717 VGND 0.01282f
C12000 VPWR.n1718 VGND 0.11853f
C12001 VPWR.n1720 VGND 0.051f
C12002 VPWR.n1721 VGND 0.04831f
C12003 VPWR.n1723 VGND 0.05447f
C12004 VPWR.n1724 VGND 0.01459f
C12005 VPWR.n1725 VGND 0.04291f
C12006 VPWR.n1726 VGND 0.01049f
C12007 VPWR.n1727 VGND 0.05241f
C12008 VPWR.n1728 VGND 0.01101f
C12009 VPWR.n1729 VGND 0.04715f
C12010 VPWR.n1730 VGND 0.0133f
C12011 VPWR.n1732 VGND 0.74292f
C12012 VPWR.t1322 VGND 0.25345f
C12013 VPWR.n1733 VGND 0.05803f
C12014 VPWR.t66 VGND 0.2909f
C12015 VPWR.t334 VGND 0.03874f
C12016 VPWR.n1734 VGND 0.06157f
C12017 VPWR.n1735 VGND 0.01038f
C12018 VPWR.n1736 VGND 0.01552f
C12019 VPWR.t1485 VGND 0.03874f
C12020 VPWR.n1737 VGND 0.05083f
C12021 VPWR.n1738 VGND 0.01038f
C12022 VPWR.n1739 VGND 0.01552f
C12023 VPWR.t264 VGND 0.2711f
C12024 VPWR.n1740 VGND 0.0657f
C12025 VPWR.n1741 VGND 0.01038f
C12026 VPWR.n1742 VGND 0.0166f
C12027 VPWR.t1286 VGND 0.03874f
C12028 VPWR.n1743 VGND 0.05852f
C12029 VPWR.n1744 VGND 0.01444f
C12030 VPWR.t788 VGND 0.29662f
C12031 VPWR.n1745 VGND 0.05083f
C12032 VPWR.n1746 VGND 0.01124f
C12033 VPWR.n1747 VGND 0.01444f
C12034 VPWR.t1315 VGND 0.16181f
C12035 VPWR.n1748 VGND 0.05083f
C12036 VPWR.n1750 VGND 0.01552f
C12037 VPWR.t1304 VGND 0.03874f
C12038 VPWR.n1751 VGND 0.0657f
C12039 VPWR.n1752 VGND 0.02301f
C12040 VPWR.n1753 VGND 0.01038f
C12041 VPWR.n1754 VGND 0.01332f
C12042 VPWR.t698 VGND 0.21455f
C12043 VPWR.n1755 VGND 0.05083f
C12044 VPWR.n1756 VGND 0.01038f
C12045 VPWR.n1757 VGND 0.01552f
C12046 VPWR.t789 VGND 0.18543f
C12047 VPWR.n1758 VGND 0.0657f
C12048 VPWR.n1759 VGND 0.02189f
C12049 VPWR.n1760 VGND 0.01444f
C12050 VPWR.t783 VGND 0.39023f
C12051 VPWR.t415 VGND 0.03874f
C12052 VPWR.n1761 VGND 0.0561f
C12053 VPWR.n1762 VGND 0.06879f
C12054 VPWR.t697 VGND 0.03874f
C12055 VPWR.n1763 VGND 0.05803f
C12056 VPWR.t1168 VGND 0.03874f
C12057 VPWR.n1764 VGND 0.05083f
C12058 VPWR.n1765 VGND 0.01124f
C12059 VPWR.t1294 VGND 0.26165f
C12060 VPWR.n1766 VGND 0.05061f
C12061 VPWR.n1767 VGND 0.01038f
C12062 VPWR.t916 VGND 0.10978f
C12063 VPWR.n1768 VGND 0.05083f
C12064 VPWR.t716 VGND 0.03874f
C12065 VPWR.n1769 VGND 0.05061f
C12066 VPWR.n1770 VGND 0.01552f
C12067 VPWR.t358 VGND 13.26552f
C12068 VPWR.n1771 VGND 0.03553f
C12069 VPWR.n1772 VGND 0.01211f
C12070 VPWR.t1183 VGND 0.03874f
C12071 VPWR.t657 VGND 0.43018f
C12072 VPWR.t153 VGND 0.03477f
C12073 VPWR.t154 VGND 0.03341f
C12074 VPWR.n1773 VGND 0.0858f
C12075 VPWR.n1774 VGND 0.05753f
C12076 VPWR.t50 VGND 0.4688f
C12077 VPWR.t556 VGND 0.35912f
C12078 VPWR.n1775 VGND 0.05777f
C12079 VPWR.t51 VGND 0.46744f
C12080 VPWR.n1776 VGND 0.08581f
C12081 VPWR.n1777 VGND 0.04468f
C12082 VPWR.n1778 VGND 0.01027f
C12083 VPWR.t394 VGND 0.12974f
C12084 VPWR.n1779 VGND 0.05061f
C12085 VPWR.t446 VGND 8.82719f
C12086 VPWR.n1781 VGND 0.03488f
C12087 VPWR.n1782 VGND 0.01765f
C12088 VPWR.t988 VGND 0.12794f
C12089 VPWR.n1783 VGND 0.05852f
C12090 VPWR.t1136 VGND 0.16811f
C12091 VPWR.n1784 VGND 0.03488f
C12092 VPWR.n1785 VGND 0.01657f
C12093 VPWR.t1420 VGND 0.03874f
C12094 VPWR.n1786 VGND 0.05083f
C12095 VPWR.n1787 VGND 0.01124f
C12096 VPWR.t324 VGND 0.03874f
C12097 VPWR.n1788 VGND 0.05083f
C12098 VPWR.t623 VGND 0.03874f
C12099 VPWR.n1789 VGND 0.05083f
C12100 VPWR.n1790 VGND 0.01444f
C12101 VPWR.t1163 VGND 0.03874f
C12102 VPWR.n1791 VGND 0.04291f
C12103 VPWR.t1207 VGND 0.22978f
C12104 VPWR.n1792 VGND 0.05061f
C12105 VPWR.t1439 VGND 0.1226f
C12106 VPWR.n1794 VGND 0.05777f
C12107 VPWR.t572 VGND 0.08067f
C12108 VPWR.t365 VGND 0.15101f
C12109 VPWR.n1795 VGND 0.02189f
C12110 VPWR.t493 VGND 0.21887f
C12111 VPWR.n1796 VGND 0.05061f
C12112 VPWR.n1797 VGND 0.01038f
C12113 VPWR.t279 VGND 0.03874f
C12114 VPWR.n1798 VGND 0.05083f
C12115 VPWR.t1320 VGND 0.22186f
C12116 VPWR.n1799 VGND 0.05061f
C12117 VPWR.n1800 VGND 0.01552f
C12118 VPWR.t970 VGND 0.03874f
C12119 VPWR.n1801 VGND 0.05061f
C12120 VPWR.n1802 VGND 0.01038f
C12121 VPWR.t1357 VGND 0.03874f
C12122 VPWR.n1803 VGND 0.05083f
C12123 VPWR.n1804 VGND 0.01552f
C12124 VPWR.t648 VGND 0.03874f
C12125 VPWR.n1805 VGND 0.05852f
C12126 VPWR.t679 VGND 0.26753f
C12127 VPWR.n1806 VGND 0.05061f
C12128 VPWR.n1807 VGND 0.01552f
C12129 VPWR.t575 VGND 0.13608f
C12130 VPWR.t1427 VGND 0.03874f
C12131 VPWR.t995 VGND 0.03892f
C12132 VPWR.t67 VGND 0.48808f
C12133 VPWR.n1808 VGND 0.15728f
C12134 VPWR.t69 VGND 0.2294f
C12135 VPWR.t70 VGND 0.67731f
C12136 VPWR.t1324 VGND 0.13286f
C12137 VPWR.t388 VGND 0.03874f
C12138 VPWR.n1810 VGND 0.05083f
C12139 VPWR.n1811 VGND 0.01124f
C12140 VPWR.n1812 VGND 0.01444f
C12141 VPWR.t1025 VGND 0.26685f
C12142 VPWR.t845 VGND 1.5068f
C12143 VPWR.n1813 VGND 0.11218f
C12144 VPWR.n1814 VGND 0.03669f
C12145 VPWR.n1815 VGND 0.01038f
C12146 VPWR.n1816 VGND 0.01552f
C12147 VPWR.t412 VGND 0.65593f
C12148 VPWR.n1817 VGND 0.05083f
C12149 VPWR.n1818 VGND 0.01038f
C12150 VPWR.n1819 VGND 0.01038f
C12151 VPWR.t817 VGND 0.34948f
C12152 VPWR.n1820 VGND 0.05061f
C12153 VPWR.n1821 VGND 0.01647f
C12154 VPWR.n1822 VGND 0.01546f
C12155 VPWR.t420 VGND 0.262f
C12156 VPWR.t71 VGND 0.67595f
C12157 VPWR.t905 VGND 0.13439f
C12158 VPWR.n1823 VGND 0.0616f
C12159 VPWR.t906 VGND 0.13303f
C12160 VPWR.n1824 VGND 0.0858f
C12161 VPWR.n1825 VGND 0.05242f
C12162 VPWR.t807 VGND 0.24795f
C12163 VPWR.n1826 VGND 0.04291f
C12164 VPWR.t1305 VGND 0.1088f
C12165 VPWR.n1828 VGND 0.05803f
C12166 VPWR.t1445 VGND 0.21864f
C12167 VPWR.n1829 VGND 0.05779f
C12168 VPWR.n1830 VGND 0.02189f
C12169 VPWR.t1318 VGND 0.03874f
C12170 VPWR.n1831 VGND 0.05061f
C12171 VPWR.n1832 VGND 0.01038f
C12172 VPWR.t547 VGND 0.03874f
C12173 VPWR.n1833 VGND 0.05083f
C12174 VPWR.t1349 VGND 0.23851f
C12175 VPWR.n1834 VGND 0.05061f
C12176 VPWR.n1835 VGND 0.01552f
C12177 VPWR.t937 VGND 0.03874f
C12178 VPWR.n1836 VGND 0.05803f
C12179 VPWR.n1837 VGND 0.02189f
C12180 VPWR.t399 VGND 0.21718f
C12181 VPWR.t536 VGND 0.34881f
C12182 VPWR.n1838 VGND 0.09824f
C12183 VPWR.t1481 VGND 0.03874f
C12184 VPWR.t1402 VGND 0.03874f
C12185 VPWR.n1839 VGND 0.11212f
C12186 VPWR.n1840 VGND 0.01444f
C12187 VPWR.t624 VGND 0.03874f
C12188 VPWR.n1841 VGND 0.06569f
C12189 VPWR.n1842 VGND 0.02301f
C12190 VPWR.t1355 VGND 0.03874f
C12191 VPWR.n1843 VGND 0.0657f
C12192 VPWR.t1293 VGND 0.03874f
C12193 VPWR.n1844 VGND 0.05083f
C12194 VPWR.n1845 VGND 0.01444f
C12195 VPWR.t463 VGND 0.03874f
C12196 VPWR.t1497 VGND 0.03874f
C12197 VPWR.t121 VGND 0.28681f
C12198 VPWR.t302 VGND 0.62328f
C12199 VPWR.t1508 VGND 0.19079f
C12200 VPWR.t262 VGND 0.03874f
C12201 VPWR.t1300 VGND 0.29374f
C12202 VPWR.t1033 VGND 0.03874f
C12203 VPWR.t797 VGND 0.03874f
C12204 VPWR.t846 VGND 0.23786f
C12205 VPWR.t440 VGND 0.03879f
C12206 VPWR.t1503 VGND 0.17056f
C12207 VPWR.t798 VGND 0.78989f
C12208 VPWR.t1046 VGND 0.21675f
C12209 VPWR.t642 VGND 0.04486f
C12210 VPWR.t100 VGND 0.08407f
C12211 VPWR.t101 VGND 0.08272f
C12212 VPWR.n1847 VGND 0.01444f
C12213 VPWR.t709 VGND 0.03874f
C12214 VPWR.n1848 VGND 0.0657f
C12215 VPWR.n1849 VGND 0.02301f
C12216 VPWR.t1424 VGND 0.03874f
C12217 VPWR.t459 VGND 0.03874f
C12218 VPWR.t1482 VGND 0.03874f
C12219 VPWR.t1289 VGND 0.03874f
C12220 VPWR.t1433 VGND 0.04991f
C12221 VPWR.t1239 VGND 0.23086f
C12222 VPWR.t1299 VGND 0.03874f
C12223 VPWR.t691 VGND 0.31701f
C12224 VPWR.t269 VGND 0.41407f
C12225 VPWR.t511 VGND 0.03874f
C12226 VPWR.n1850 VGND 0.07343f
C12227 VPWR.t409 VGND 0.22206f
C12228 VPWR.t320 VGND 0.03874f
C12229 VPWR.t567 VGND 0.03874f
C12230 VPWR.t890 VGND 0.03874f
C12231 VPWR.n1851 VGND 0.02077f
C12232 VPWR.t1486 VGND 0.03874f
C12233 VPWR.n1852 VGND 0.06698f
C12234 VPWR.t1252 VGND 0.28495f
C12235 VPWR.t512 VGND 0.24692f
C12236 VPWR.n1853 VGND 0.05385f
C12237 VPWR.t563 VGND 0.31666f
C12238 VPWR.n1854 VGND 0.07093f
C12239 VPWR.n1855 VGND 0.04482f
C12240 VPWR.n1856 VGND 0.01245f
C12241 VPWR.n1857 VGND 0.06575f
C12242 VPWR.n1858 VGND 0.02189f
C12243 VPWR.n1859 VGND 0.05669f
C12244 VPWR.n1860 VGND 0.03048f
C12245 VPWR.n1862 VGND 0.07333f
C12246 VPWR.t122 VGND 0.28545f
C12247 VPWR.t197 VGND 0.17009f
C12248 VPWR.n1863 VGND 0.09425f
C12249 VPWR.t222 VGND 0.58385f
C12250 VPWR.n1864 VGND 0.09428f
C12251 VPWR.n1865 VGND 0.09331f
C12252 VPWR.t196 VGND 0.17145f
C12253 VPWR.t221 VGND 0.58521f
C12254 VPWR.n1867 VGND 0.08866f
C12255 VPWR.n1868 VGND 0.01503f
C12256 VPWR.n1869 VGND 0.01903f
C12257 VPWR.n1870 VGND 0.046f
C12258 VPWR.n1871 VGND 0.74292f
C12259 VPWR.n1872 VGND 0.44861f
C12260 VPWR.n1874 VGND 0.0133f
C12261 VPWR.n1875 VGND 0.01444f
C12262 VPWR.t1457 VGND 0.46768f
C12263 VPWR.n1876 VGND 0.05083f
C12264 VPWR.n1877 VGND 0.01038f
C12265 VPWR.t763 VGND 0.22243f
C12266 VPWR.t1393 VGND 0.03874f
C12267 VPWR.t1414 VGND 0.22791f
C12268 VPWR.t1301 VGND 0.03874f
C12269 VPWR.t745 VGND 0.35193f
C12270 VPWR.n1879 VGND 0.07777f
C12271 VPWR.t737 VGND 0.03874f
C12272 VPWR.n1880 VGND 0.05061f
C12273 VPWR.n1881 VGND 0.01552f
C12274 VPWR.t496 VGND 0.03874f
C12275 VPWR.n1882 VGND 0.05777f
C12276 VPWR.t731 VGND 0.03874f
C12277 VPWR.n1883 VGND 0.05779f
C12278 VPWR.n1884 VGND 0.02301f
C12279 VPWR.t619 VGND 0.03874f
C12280 VPWR.n1885 VGND 0.05083f
C12281 VPWR.n1886 VGND 0.01124f
C12282 VPWR.t287 VGND 0.1502f
C12283 VPWR.n1887 VGND 0.05083f
C12284 VPWR.t52 VGND 1.02231f
C12285 VPWR.t202 VGND 0.03477f
C12286 VPWR.n1888 VGND 0.08866f
C12287 VPWR.t294 VGND 0.04453f
C12288 VPWR.n1890 VGND 0.44841f
C12289 VPWR.n1891 VGND 0.0993f
C12290 VPWR.t1189 VGND 0.32975f
C12291 VPWR.n1892 VGND 0.05805f
C12292 VPWR.n1893 VGND 0.02133f
C12293 VPWR.t718 VGND 0.3444f
C12294 VPWR.n1894 VGND 0.07194f
C12295 VPWR.t273 VGND 0.03874f
C12296 VPWR.n1895 VGND 0.07201f
C12297 VPWR.n1896 VGND 0.0344f
C12298 VPWR.t912 VGND 0.21295f
C12299 VPWR.n1897 VGND 0.05803f
C12300 VPWR.t1155 VGND 0.23404f
C12301 VPWR.n1898 VGND 0.05083f
C12302 VPWR.n1899 VGND 0.01124f
C12303 VPWR.t1174 VGND 0.1928f
C12304 VPWR.n1900 VGND 0.05083f
C12305 VPWR.n1901 VGND 0.01124f
C12306 VPWR.t800 VGND 0.45414f
C12307 VPWR.n1902 VGND 0.05083f
C12308 VPWR.t801 VGND 0.21624f
C12309 VPWR.n1903 VGND 0.05083f
C12310 VPWR.n1904 VGND 0.01444f
C12311 VPWR.t436 VGND 0.15818f
C12312 VPWR.n1905 VGND 0.05083f
C12313 VPWR.n1906 VGND 0.01124f
C12314 VPWR.t449 VGND 0.46248f
C12315 VPWR.n1907 VGND 0.05083f
C12316 VPWR.t747 VGND 0.34023f
C12317 VPWR.n1908 VGND 0.05083f
C12318 VPWR.n1909 VGND 0.01444f
C12319 VPWR.t757 VGND 0.31732f
C12320 VPWR.t421 VGND 0.37688f
C12321 VPWR.n1910 VGND 0.09822f
C12322 VPWR.t767 VGND 0.39613f
C12323 VPWR.n1911 VGND 0.05805f
C12324 VPWR.n1912 VGND 0.02189f
C12325 VPWR.t1291 VGND 0.32329f
C12326 VPWR.n1913 VGND 0.05803f
C12327 VPWR.t639 VGND 0.27509f
C12328 VPWR.n1914 VGND 0.05779f
C12329 VPWR.n1915 VGND 0.02189f
C12330 VPWR.t1348 VGND 0.26544f
C12331 VPWR.n1916 VGND 0.04291f
C12332 VPWR.n1917 VGND 0.01038f
C12333 VPWR.t1499 VGND 0.41833f
C12334 VPWR.n1918 VGND 0.05061f
C12335 VPWR.t265 VGND 0.21553f
C12336 VPWR.n1919 VGND 0.05083f
C12337 VPWR.n1920 VGND 0.01552f
C12338 VPWR.t1226 VGND 0.03874f
C12339 VPWR.n1921 VGND 0.07167f
C12340 VPWR.n1922 VGND 0.03669f
C12341 VPWR.t1458 VGND 0.19849f
C12342 VPWR.t1167 VGND 0.37005f
C12343 VPWR.n1923 VGND 0.11218f
C12344 VPWR.t460 VGND 0.35824f
C12345 VPWR.t1157 VGND 0.16197f
C12346 VPWR.n1924 VGND 0.09822f
C12347 VPWR.n1925 VGND 0.01444f
C12348 VPWR.t613 VGND 0.24867f
C12349 VPWR.n1926 VGND 0.05805f
C12350 VPWR.n1927 VGND 0.01038f
C12351 VPWR.t419 VGND 0.2551f
C12352 VPWR.n1928 VGND 0.05061f
C12353 VPWR.t1496 VGND 0.20852f
C12354 VPWR.n1929 VGND 0.06569f
C12355 VPWR.n1930 VGND 0.01552f
C12356 VPWR.t1394 VGND 0.31423f
C12357 VPWR.n1931 VGND 0.05805f
C12358 VPWR.n1932 VGND 0.01124f
C12359 VPWR.t425 VGND 0.40555f
C12360 VPWR.n1933 VGND 0.05083f
C12361 VPWR.n1934 VGND 0.01444f
C12362 VPWR.t1298 VGND 0.22214f
C12363 VPWR.n1935 VGND 0.05852f
C12364 VPWR.n1936 VGND 0.0166f
C12365 VPWR.t740 VGND 0.16913f
C12366 VPWR.n1937 VGND 0.06295f
C12367 VPWR.t329 VGND 1.07127f
C12368 VPWR.t11 VGND 39.6787f
C12369 VPWR.n1938 VGND 0.50571f
.ends
