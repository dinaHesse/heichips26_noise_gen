** sch_path: /home/dhesse/heichips26_noise_gen/macros/heichips26_digital_project/macros/config_ro/testbenches/xschem/config_ro_tb_tran.sch
**.subckt config_ro_tb_tran
VDD VDD GND {VDD}
ven enable GND {VDD}
C1 vosc GND 0.1f
x3 VDD GND enable vosc VDD VDD VDD VDD config_ro_pex
**** begin user architecture code

.include ../../../netlist/xspice/config_ro.xspice
.include ../../../netlist/pex/config_ro_magic_pex_3.spice
.param VDD=1.5
.param temp=27
.options klu method=gear reltol=1e-4 abstol=1e-12 gmin=1e-15
.control

set num_threads=8

*save all

* User Constants
let tstop = 8n
let tstep = 100p

* Operating Point Analysis
*op
*remzerovec
*write config_ro_tb_tran.raw
*set appendwrite

* Transient Analysis
tran $&tstep $&tstop 1n uic
write config_ro_tb_tran.raw

plot v(enable) v(vosc)

meas tran t_rise1 when v(vosc)=1.1 rise=1
meas tran t_rise2 when v(vosc)=1.1 rise=2
let T_osc = t_rise2 - t_rise1
let f_osc = 1/T_osc
print T_osc
print f_osc

* Writing Data
unset appendwrite
set wr_vecnames
set wr_singlescale
wrdata ../plot_simulations/data/config_ro_tb_tran.txt enable vosc
*quit
.endc

.lib cornerMOSlv.lib mos_tt
.lib cornerMOShv.lib mos_tt
.lib cornerRES.lib res_typ
.lib cornerDIO.lib dio_tt

**** end user architecture code
**.ends
.GLOBAL GND
.GLOBAL VDD
.end
