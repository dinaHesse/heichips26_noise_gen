* PEX produced on Thu Oct  1 10:18:33 PM CEST 2026 using scripts/sak-pex.sh with m=3 and s=1 (extresist threshold=10000 mOhm, minres=1000 mOhm, mindelay=1 ps)
* NGSPICE file created from e_load_uniform_pex.ext - technology: ihp-sg13cmos5l

.subckt e_load_uniform_pex VPWR VGND osc[0] osc[1] osc[2] osc[3] osc[4] osc[5]
+ osc[6] osc[7] en[0] en[1] en[2] en[3] en[4] en[5] en[6] en[7]
X0 sg13cmos5l_inv_16_11.A sg13cmos5l_inv_16_96.Y VGND.t953 VGND.t380 sg13_lv_nmos ad=0.1406p pd=1.12u as=0.1406p ps=1.12u w=0.74u l=0.13u
X1 sg13cmos5l_inv_16_75.Y sg13cmos5l_inv_16_75.A VPWR.t820 VPWR.t25 sg13_lv_pmos ad=0.2128p pd=1.5u as=0.2128p ps=1.5u w=1.12u l=0.13u
X2 VGND.t1100 sg13cmos5l_inv_16_105.A sg13cmos5l_inv_16_105.Y VGND.t1101 sg13_lv_nmos ad=0.1406p pd=1.12u as=0.1406p ps=1.12u w=0.74u l=0.13u
X3 VGND.t588 sg13cmos5l_inv_4_0.Y sg13cmos5l_inv_8_0.Y VGND.t1800 sg13_lv_nmos ad=0.1406p pd=1.12u as=0.1406p ps=1.12u w=0.74u l=0.13u
X4 sg13cmos5l_inv_16_54.Y sg13cmos5l_inv_16_101.Y VPWR.t2326 VPWR.t25 sg13_lv_pmos ad=0.2128p pd=1.5u as=0.2128p ps=1.5u w=1.12u l=0.13u
X5 VPWR.t514 sg13cmos5l_inv_16_23.Y sg13cmos5l_inv_16_14.A VPWR.t0 sg13_lv_pmos ad=0.2128p pd=1.5u as=0.2128p ps=1.5u w=1.12u l=0.13u
X6 VPWR.t1326 sg13cmos5l_inv_16_69.Y sg13cmos5l_inv_16_58.Y VPWR.t9 sg13_lv_pmos ad=0.4368p pd=3.02u as=0.2128p ps=1.5u w=1.12u l=0.13u
X7 VPWR.t1596 sg13cmos5l_inv_16_61.A sg13cmos5l_inv_16_61.Y VPWR.t9 sg13_lv_pmos ad=0.2128p pd=1.5u as=0.2128p ps=1.5u w=1.12u l=0.13u
X8 VGND.t1010 sg13cmos5l_inv_16_87.A sg13cmos5l_inv_16_87.Y VGND.t881 sg13_lv_nmos ad=0.1406p pd=1.12u as=0.1406p ps=1.12u w=0.74u l=0.13u
X9 VGND.t1792 VPWR.t2560 VGND.t1792 VGND.t380 sg13_lv_nmos ad=0.1428p pd=1.52u as=0 ps=0 w=0.42u l=1u
X10 VGND.t353 sg13cmos5l_inv_16_103.A sg13cmos5l_inv_16_103.Y VGND.t357 sg13_lv_nmos ad=0.1406p pd=1.12u as=0.1406p ps=1.12u w=0.74u l=0.13u
X11 VGND.t122 VPWR.t2511 VGND.t122 VGND.t2041 sg13_lv_nmos ad=0.1428p pd=1.52u as=0 ps=0 w=0.42u l=1u
X12 sg13cmos5l_inv_16_104.Y sg13cmos5l_inv_16_14.A VGND.t472 VGND.t479 sg13_lv_nmos ad=0.1406p pd=1.12u as=0.1406p ps=1.12u w=0.74u l=0.13u
X13 VPWR.t2174 sg13cmos5l_inv_16_79.A sg13cmos5l_inv_16_79.Y VPWR.t16 sg13_lv_pmos ad=0.4368p pd=3.02u as=0.2128p ps=1.5u w=1.12u l=0.13u
X14 VPWR.t169 VGND.t20 VPWR.t170 VPWR.t25 sg13_lv_pmos ad=0.19p pd=1.38u as=0 ps=0 w=1u l=1u
X15 VPWR.t329 a_17516_834# sg13cmos5l_buf_1_3.X VPWR.t177 sg13_lv_pmos ad=0.2114p pd=1.54u as=0.42p ps=2.99u w=1.12u l=0.13u
X16 VPWR.t2154 sg13cmos5l_inv_16_79.A sg13cmos5l_inv_16_91.Y VPWR.t16 sg13_lv_pmos ad=0.2128p pd=1.5u as=0.2128p ps=1.5u w=1.12u l=0.13u
X17 VPWR.t707 sg13cmos5l_inv_16_29.A sg13cmos5l_inv_16_29.Y VPWR.t177 sg13_lv_pmos ad=0.2128p pd=1.5u as=0.2128p ps=1.5u w=1.12u l=0.13u
X18 sg13cmos5l_inv_16_75.A sg13cmos5l_inv_16_76.A VGND.t390 VGND.t380 sg13_lv_nmos ad=0.1406p pd=1.12u as=0.1406p ps=1.12u w=0.74u l=0.13u
X19 VPWR.t925 sg13cmos5l_inv_16_14.A sg13cmos5l_inv_16_14.Y VPWR.t4 sg13_lv_pmos ad=0.2128p pd=1.5u as=0.2128p ps=1.5u w=1.12u l=0.13u
X20 VGND.t1201 sg13cmos5l_inv_4_7.Y sg13cmos5l_inv_16_88.A VGND.t1223 sg13_lv_nmos ad=0.1406p pd=1.12u as=0.1406p ps=1.12u w=0.74u l=0.13u
X21 sg13cmos5l_inv_16_52.Y sg13cmos5l_inv_16_56.Y VPWR.t2046 VPWR.t16 sg13_lv_pmos ad=0.2128p pd=1.5u as=0.2128p ps=1.5u w=1.12u l=0.13u
X22 VPWR.t666 sg13cmos5l_inv_16_41.A sg13cmos5l_inv_16_34.Y VPWR.t0 sg13_lv_pmos ad=0.2128p pd=1.5u as=0.2128p ps=1.5u w=1.12u l=0.13u
X23 VPWR.t49 VGND.t1820 VPWR.t47 VPWR.t16 sg13_lv_pmos ad=0.19p pd=1.38u as=0 ps=0 w=1u l=1u
X24 sg13cmos5l_inv_16_20.A sg13cmos5l_inv_16_8.Y VGND.t353 VGND.t543 sg13_lv_nmos ad=0.1406p pd=1.12u as=0.1406p ps=1.12u w=0.74u l=0.13u
X25 sg13cmos5l_inv_16_101.Y sg13cmos5l_inv_16_34.Y VGND.t593 VGND.t595 sg13_lv_nmos ad=0.1406p pd=1.12u as=0.1406p ps=1.12u w=0.74u l=0.13u
X26 sg13cmos5l_inv_2_0.A sg13cmos5l_and2_1_1.X VPWR.t1778 VPWR.t4 sg13_lv_pmos ad=0.3808p pd=2.92u as=0.3808p ps=2.92u w=1.12u l=0.13u
X27 VPWR.t1294 sg13cmos5l_inv_16_68.A sg13cmos5l_inv_16_68.Y VPWR.t16 sg13_lv_pmos ad=0.2128p pd=1.5u as=0.2128p ps=1.5u w=1.12u l=0.13u
X28 VGND.t343 sg13cmos5l_inv_16_30.A sg13cmos5l_inv_16_30.Y VGND.t1297 sg13_lv_nmos ad=0.1406p pd=1.12u as=0.1406p ps=1.12u w=0.74u l=0.13u
X29 sg13cmos5l_inv_16_13.Y sg13cmos5l_inv_16_15.A VGND.t450 VGND.t503 sg13_lv_nmos ad=0.1406p pd=1.12u as=0.1406p ps=1.12u w=0.74u l=0.13u
X30 sg13cmos5l_inv_16_6.Y sg13cmos5l_inv_16_6.A VGND.t1411 VGND.t1412 sg13_lv_nmos ad=0.1406p pd=1.12u as=0.1406p ps=1.12u w=0.74u l=0.13u
X31 VGND.t866 sg13cmos5l_inv_16_68.A sg13cmos5l_inv_16_66.Y VGND.t870 sg13_lv_nmos ad=0.1406p pd=1.12u as=0.1406p ps=1.12u w=0.74u l=0.13u
X32 sg13cmos5l_inv_16_79.Y sg13cmos5l_inv_16_79.A VPWR.t2170 VPWR.t16 sg13_lv_pmos ad=0.2128p pd=1.5u as=0.2128p ps=1.5u w=1.12u l=0.13u
X33 sg13cmos5l_inv_16_109.Y sg13cmos5l_inv_16_48.A VGND.t1147 VGND.t881 sg13_lv_nmos ad=0.1406p pd=1.12u as=0.1406p ps=1.12u w=0.74u l=0.13u
X34 sg13cmos5l_inv_16_73.A sg13cmos5l_inv_16_94.A VGND.t1507 VGND.t881 sg13_lv_nmos ad=0.1406p pd=1.12u as=0.1406p ps=1.12u w=0.74u l=0.13u
X35 sg13cmos5l_inv_16_91.Y sg13cmos5l_inv_16_79.A VPWR.t2150 VPWR.t16 sg13_lv_pmos ad=0.2128p pd=1.5u as=0.2128p ps=1.5u w=1.12u l=0.13u
X36 VPWR.t239 VGND.t162 VPWR.t238 VPWR.t4 sg13_lv_pmos ad=0.34p pd=2.68u as=0 ps=0 w=1u l=1u
X37 sg13cmos5l_inv_16_36.Y sg13cmos5l_inv_16_36.A VGND.t146 VGND.t152 sg13_lv_nmos ad=0.1406p pd=1.12u as=0.1406p ps=1.12u w=0.74u l=0.13u
X38 VPWR.t1583 sg13cmos5l_inv_16_61.A sg13cmos5l_inv_16_59.Y VPWR.t9 sg13_lv_pmos ad=0.4368p pd=3.02u as=0.2128p ps=1.5u w=1.12u l=0.13u
X39 sg13cmos5l_inv_16_67.Y sg13cmos5l_inv_16_67.A VPWR.t1977 VPWR.t16 sg13_lv_pmos ad=0.2128p pd=1.5u as=0.3808p ps=2.92u w=1.12u l=0.13u
X40 VPWR.t2178 sg13cmos5l_inv_4_0.Y sg13cmos5l_inv_8_0.Y VPWR.t177 sg13_lv_pmos ad=0.2128p pd=1.5u as=0.2128p ps=1.5u w=1.12u l=0.13u
X41 sg13cmos5l_inv_16_14.Y sg13cmos5l_inv_16_14.A VPWR.t921 VPWR.t4 sg13_lv_pmos ad=0.2128p pd=1.5u as=0.2128p ps=1.5u w=1.12u l=0.13u
X42 VPWR.t2044 sg13cmos5l_inv_16_56.Y sg13cmos5l_inv_16_52.Y VPWR.t16 sg13_lv_pmos ad=0.2128p pd=1.5u as=0.2128p ps=1.5u w=1.12u l=0.13u
X43 sg13cmos5l_inv_16_34.Y sg13cmos5l_inv_16_41.A VPWR.t662 VPWR.t0 sg13_lv_pmos ad=0.2128p pd=1.5u as=0.2128p ps=1.5u w=1.12u l=0.13u
X44 sg13cmos5l_inv_16_10.Y sg13cmos5l_inv_16_9.A VPWR.t1147 VPWR.t0 sg13_lv_pmos ad=0.2128p pd=1.5u as=0.2128p ps=1.5u w=1.12u l=0.13u
X45 VGND.t1469 VPWR.t2594 VGND.t1469 VGND.t1898 sg13_lv_nmos ad=79.8f pd=0.8u as=0 ps=0 w=0.42u l=1u
X46 VGND.t862 sg13cmos5l_inv_16_6.A sg13cmos5l_inv_16_6.Y VGND.t1406 sg13_lv_nmos ad=0.1406p pd=1.12u as=0.1406p ps=1.12u w=0.74u l=0.13u
X47 VPWR.t1404 sg13cmos5l_inv_16_87.A sg13cmos5l_inv_16_93.Y VPWR.t9 sg13_lv_pmos ad=0.2128p pd=1.5u as=0.2128p ps=1.5u w=1.12u l=0.13u
X48 VPWR.t2392 sg13cmos5l_inv_16_76.A sg13cmos5l_inv_16_75.A VPWR.t25 sg13_lv_pmos ad=0.2128p pd=1.5u as=0.2128p ps=1.5u w=1.12u l=0.13u
X49 sg13cmos5l_inv_16_103.A sg13cmos5l_inv_16_11.A VPWR.t800 VPWR.t0 sg13_lv_pmos ad=0.2128p pd=1.5u as=0.2128p ps=1.5u w=1.12u l=0.13u
X50 VPWR.t1094 sg13cmos5l_inv_16_1.A sg13cmos5l_inv_16_17.A VPWR.t177 sg13_lv_pmos ad=0.2128p pd=1.5u as=0.2128p ps=1.5u w=1.12u l=0.13u
X51 sg13cmos5l_inv_16_111.Y sg13cmos5l_inv_16_111.A VPWR.t1953 VPWR.t16 sg13_lv_pmos ad=0.2128p pd=1.5u as=0.2128p ps=1.5u w=1.12u l=0.13u
X52 VPWR.t2009 a_20588_834# sg13cmos5l_buf_1_2.X VPWR.t177 sg13_lv_pmos ad=0.2114p pd=1.54u as=0.42p ps=2.99u w=1.12u l=0.13u
X53 sg13cmos5l_inv_16_88.A sg13cmos5l_inv_4_7.Y VPWR.t1619 VPWR.t9 sg13_lv_pmos ad=0.2128p pd=1.5u as=0.2128p ps=1.5u w=1.12u l=0.13u
X54 VGND.t1663 sg13cmos5l_inv_16_56.Y sg13cmos5l_inv_16_52.Y VGND.t380 sg13_lv_nmos ad=0.1406p pd=1.12u as=0.1406p ps=1.12u w=0.74u l=0.13u
X55 VGND.t226 sg13cmos5l_inv_8_3.Y sg13cmos5l_inv_16_41.A VGND.t825 sg13_lv_nmos ad=0.2516p pd=2.16u as=0.1406p ps=1.12u w=0.74u l=0.13u
X56 VPWR.t538 sg13cmos5l_inv_16_17.A sg13cmos5l_inv_16_17.Y VPWR.t177 sg13_lv_pmos ad=0.2128p pd=1.5u as=0.2128p ps=1.5u w=1.12u l=0.13u
X57 sg13cmos5l_inv_16_110.Y sg13cmos5l_inv_16_5.Y VPWR.t1060 VPWR.t4 sg13_lv_pmos ad=0.2128p pd=1.5u as=0.2128p ps=1.5u w=1.12u l=0.13u
X58 VGND.t146 sg13cmos5l_inv_16_36.A sg13cmos5l_inv_16_36.Y VGND.t149 sg13_lv_nmos ad=0.1406p pd=1.12u as=0.1406p ps=1.12u w=0.74u l=0.13u
X59 sg13cmos5l_inv_16_59.Y sg13cmos5l_inv_16_61.A VPWR.t1579 VPWR.t9 sg13_lv_pmos ad=0.2128p pd=1.5u as=0.2128p ps=1.5u w=1.12u l=0.13u
X60 sg13cmos5l_inv_16_87.Y sg13cmos5l_inv_16_87.A VPWR.t1416 VPWR.t9 sg13_lv_pmos ad=0.2128p pd=1.5u as=0.2128p ps=1.5u w=1.12u l=0.13u
X61 VPWR.t246 sg13cmos5l_inv_16_6.A sg13cmos5l_inv_16_5.Y VPWR.t177 sg13_lv_pmos ad=0.2128p pd=1.5u as=0.2128p ps=1.5u w=1.12u l=0.13u
X62 VPWR.t919 sg13cmos5l_inv_16_14.A sg13cmos5l_inv_16_14.Y VPWR.t4 sg13_lv_pmos ad=0.2128p pd=1.5u as=0.2128p ps=1.5u w=1.12u l=0.13u
X63 VGND.t3 sg13cmos5l_inv_16_37.A sg13cmos5l_inv_16_37.Y VGND.t31 sg13_lv_nmos ad=0.1406p pd=1.12u as=0.1406p ps=1.12u w=0.74u l=0.13u
X64 VPWR.t1145 sg13cmos5l_inv_16_9.A sg13cmos5l_inv_16_10.Y VPWR.t0 sg13_lv_pmos ad=0.2128p pd=1.5u as=0.2128p ps=1.5u w=1.12u l=0.13u
X65 VPWR.t362 VGND.t756 VPWR.t124 VPWR.t16 sg13_lv_pmos ad=0.19p pd=1.38u as=0 ps=0 w=1u l=1u
X66 VPWR.t1260 sg13cmos5l_inv_16_0.A sg13cmos5l_inv_16_1.A VPWR.t177 sg13_lv_pmos ad=0.2128p pd=1.5u as=0.2128p ps=1.5u w=1.12u l=0.13u
X67 sg13cmos5l_inv_16_4.Y sg13cmos5l_inv_8_1.Y VGND.t310 VGND.t1451 sg13_lv_nmos ad=0.1406p pd=1.12u as=0.1406p ps=1.12u w=0.74u l=0.13u
X68 VPWR.t296 VGND.t45 VPWR.t295 VPWR.t4 sg13_lv_pmos ad=0.34p pd=2.68u as=0 ps=0 w=1u l=1u
X69 sg13cmos5l_inv_16_93.Y sg13cmos5l_inv_16_87.A VPWR.t1400 VPWR.t9 sg13_lv_pmos ad=0.2128p pd=1.5u as=0.2128p ps=1.5u w=1.12u l=0.13u
X70 sg13cmos5l_inv_16_71.Y sg13cmos5l_inv_16_56.Y VGND.t963 VGND.t881 sg13_lv_nmos ad=0.1406p pd=1.12u as=0.2516p ps=2.16u w=0.74u l=0.13u
X71 VPWR.t798 sg13cmos5l_inv_16_11.A sg13cmos5l_inv_16_103.A VPWR.t0 sg13_lv_pmos ad=0.2128p pd=1.5u as=0.2128p ps=1.5u w=1.12u l=0.13u
X72 sg13cmos5l_inv_16_17.A sg13cmos5l_inv_16_1.A VPWR.t1090 VPWR.t177 sg13_lv_pmos ad=0.2128p pd=1.5u as=0.2128p ps=1.5u w=1.12u l=0.13u
X73 sg13cmos5l_inv_16_67.A sg13cmos5l_inv_16_109.Y VGND.t1132 VGND.t881 sg13_lv_nmos ad=0.1406p pd=1.12u as=0.1406p ps=1.12u w=0.74u l=0.13u
X74 VGND.t1178 VPWR.t2605 VGND.t1178 VGND.t1874 sg13_lv_nmos ad=0.1428p pd=1.52u as=0 ps=0 w=0.42u l=1u
X75 VPWR.t2066 sg13cmos5l_inv_16_53.A sg13cmos5l_inv_16_53.Y VPWR.t16 sg13_lv_pmos ad=0.2128p pd=1.5u as=0.2128p ps=1.5u w=1.12u l=0.13u
X76 VGND.t593 sg13cmos5l_inv_16_34.Y sg13cmos5l_inv_16_99.A VGND.t602 sg13_lv_nmos ad=0.1406p pd=1.12u as=0.1406p ps=1.12u w=0.74u l=0.13u
X77 VGND.t259 sg13cmos5l_inv_16_28.A sg13cmos5l_inv_16_44.A VGND.t267 sg13_lv_nmos ad=0.1406p pd=1.12u as=0.1406p ps=1.12u w=0.74u l=0.13u
X78 VGND.t866 sg13cmos5l_inv_16_68.A sg13cmos5l_inv_16_66.Y VGND.t865 sg13_lv_nmos ad=0.1406p pd=1.12u as=0.1406p ps=1.12u w=0.74u l=0.13u
X79 sg13cmos5l_inv_16_22.Y sg13cmos5l_inv_16_20.A VGND.t375 VGND.t441 sg13_lv_nmos ad=0.1406p pd=1.12u as=0.1406p ps=1.12u w=0.74u l=0.13u
X80 VPWR.t767 sg13cmos5l_inv_16_27.Y sg13cmos5l_inv_16_26.A VPWR.t177 sg13_lv_pmos ad=0.2128p pd=1.5u as=0.2128p ps=1.5u w=1.12u l=0.13u
X81 sg13cmos5l_inv_16_9.Y sg13cmos5l_inv_16_9.A VPWR.t1159 VPWR.t4 sg13_lv_pmos ad=0.2128p pd=1.5u as=0.2128p ps=1.5u w=1.12u l=0.13u
X82 sg13cmos5l_inv_16_35.Y sg13cmos5l_inv_16_29.A VGND.t259 VGND.t260 sg13_lv_nmos ad=0.1406p pd=1.12u as=0.1406p ps=1.12u w=0.74u l=0.13u
X83 VPWR.t1058 sg13cmos5l_inv_16_5.Y sg13cmos5l_inv_16_110.Y VPWR.t4 sg13_lv_pmos ad=0.2128p pd=1.5u as=0.2128p ps=1.5u w=1.12u l=0.13u
X84 sg13cmos5l_inv_16_68.A sg13cmos5l_inv_16_71.Y VGND.t882 VGND.t881 sg13_lv_nmos ad=0.1406p pd=1.12u as=0.1406p ps=1.12u w=0.74u l=0.13u
X85 VGND.t353 sg13cmos5l_inv_16_11.A sg13cmos5l_inv_16_105.A VGND.t361 sg13_lv_nmos ad=0.2516p pd=2.16u as=0.1406p ps=1.12u w=0.74u l=0.13u
X86 sg13cmos5l_inv_16_110.Y sg13cmos5l_inv_16_5.Y VGND.t637 VGND.t648 sg13_lv_nmos ad=0.1406p pd=1.12u as=0.1406p ps=1.12u w=0.74u l=0.13u
X87 VPWR.t1673 osc[7] a_3592_9192# VPWR.t9 sg13_lv_pmos ad=0.2114p pd=1.54u as=0.2856p ps=2.36u w=0.84u l=0.13u
X88 sg13cmos5l_inv_16_54.Y sg13cmos5l_inv_16_101.Y VPWR.t2322 VPWR.t25 sg13_lv_pmos ad=0.2128p pd=1.5u as=0.2128p ps=1.5u w=1.12u l=0.13u
X89 sg13cmos5l_inv_16_1.A sg13cmos5l_inv_16_0.A VPWR.t1257 VPWR.t177 sg13_lv_pmos ad=0.2128p pd=1.5u as=0.3808p ps=2.92u w=1.12u l=0.13u
X90 VGND.t1885 VPWR.t2601 VGND.t1882 VGND.t1884 sg13_lv_nmos ad=0.1428p pd=1.52u as=0 ps=0 w=0.42u l=1u
X91 sg13cmos5l_inv_16_45.Y sg13cmos5l_inv_16_47.A VPWR.t2299 VPWR.t16 sg13_lv_pmos ad=0.2128p pd=1.5u as=0.2128p ps=1.5u w=1.12u l=0.13u
X92 VGND.t2012 VPWR.t2529 VGND.t472 VGND.t2011 sg13_lv_nmos ad=0.1428p pd=1.52u as=0 ps=0 w=0.42u l=1u
X93 a_23648_4915# sg13cmos5l_buf_1_1.X a_23785_5004# VGND.t809 sg13_lv_nmos ad=0.2176p pd=1.96u as=0.1216p ps=1.02u w=0.64u l=0.13u
X94 VPWR.t510 sg13cmos5l_inv_16_23.Y sg13cmos5l_inv_16_14.A VPWR.t0 sg13_lv_pmos ad=0.2128p pd=1.5u as=0.2128p ps=1.5u w=1.12u l=0.13u
X95 VGND.t198 sg13cmos5l_inv_16_28.A sg13cmos5l_inv_16_29.A VGND.t199 sg13_lv_nmos ad=0.1406p pd=1.12u as=0.1406p ps=1.12u w=0.74u l=0.13u
X96 sg13cmos5l_inv_16_104.Y sg13cmos5l_inv_16_14.A VGND.t472 VGND.t475 sg13_lv_nmos ad=0.1406p pd=1.12u as=0.1406p ps=1.12u w=0.74u l=0.13u
X97 sg13cmos5l_inv_2_2.Y sg13cmos5l_inv_2_2.A VPWR.t844 VPWR.t177 sg13_lv_pmos ad=0.2128p pd=1.5u as=0.3808p ps=2.92u w=1.12u l=0.13u
X98 sg13cmos5l_inv_16_44.Y sg13cmos5l_inv_16_44.A VPWR.t629 VPWR.t4 sg13_lv_pmos ad=0.2128p pd=1.5u as=0.2128p ps=1.5u w=1.12u l=0.13u
X99 VPWR.t1894 sg13cmos5l_inv_16_94.A sg13cmos5l_inv_16_73.A VPWR.t9 sg13_lv_pmos ad=0.2128p pd=1.5u as=0.2128p ps=1.5u w=1.12u l=0.13u
X100 sg13cmos5l_inv_16_53.Y sg13cmos5l_inv_16_53.A VPWR.t2062 VPWR.t16 sg13_lv_pmos ad=0.2128p pd=1.5u as=0.2128p ps=1.5u w=1.12u l=0.13u
X101 VGND.t291 sg13cmos5l_inv_16_8.Y sg13cmos5l_inv_16_9.A VGND.t559 sg13_lv_nmos ad=0.1406p pd=1.12u as=0.1406p ps=1.12u w=0.74u l=0.13u
X102 a_17516_834# en[4] VPWR.t329 VPWR.t177 sg13_lv_pmos ad=0.2856p pd=2.36u as=0.2114p ps=1.54u w=0.84u l=0.13u
X103 sg13cmos5l_inv_16_37.Y sg13cmos5l_inv_16_37.A VPWR.t469 VPWR.t4 sg13_lv_pmos ad=0.2128p pd=1.5u as=0.2128p ps=1.5u w=1.12u l=0.13u
X104 sg13cmos5l_inv_16_61.A sg13cmos5l_inv_16_71.Y VGND.t963 VGND.t881 sg13_lv_nmos ad=0.1406p pd=1.12u as=0.1406p ps=1.12u w=0.74u l=0.13u
X105 sg13cmos5l_inv_16_53.A sg13cmos5l_inv_16_52.Y VPWR.t1755 VPWR.t16 sg13_lv_pmos ad=0.2128p pd=1.5u as=0.4368p ps=3.02u w=1.12u l=0.13u
X106 sg13cmos5l_inv_8_1.Y sg13cmos5l_inv_8_1.A VGND.t1423 VGND.t1422 sg13_lv_nmos ad=0.1406p pd=1.12u as=0.2516p ps=2.16u w=0.74u l=0.13u
X107 sg13cmos5l_inv_16_44.A sg13cmos5l_inv_16_28.A VGND.t259 VGND.t264 sg13_lv_nmos ad=0.1406p pd=1.12u as=0.1406p ps=1.12u w=0.74u l=0.13u
X108 sg13cmos5l_inv_16_77.A sg13cmos5l_inv_16_76.A VPWR.t2379 VPWR.t16 sg13_lv_pmos ad=0.2128p pd=1.5u as=0.2128p ps=1.5u w=1.12u l=0.13u
X109 sg13cmos5l_inv_16_47.A sg13cmos5l_inv_16_46.A VPWR.t2121 VPWR.t16 sg13_lv_pmos ad=0.2128p pd=1.5u as=0.2128p ps=1.5u w=1.12u l=0.13u
X110 VGND.t375 sg13cmos5l_inv_16_20.A sg13cmos5l_inv_16_22.Y VGND.t438 sg13_lv_nmos ad=0.1406p pd=1.12u as=0.1406p ps=1.12u w=0.74u l=0.13u
X111 sg13cmos5l_inv_16_26.A sg13cmos5l_inv_16_27.Y VPWR.t767 VPWR.t177 sg13_lv_pmos ad=0.2128p pd=1.5u as=0.3808p ps=2.92u w=1.12u l=0.13u
X112 VGND.t1334 sg13cmos5l_inv_16_26.A sg13cmos5l_inv_16_26.Y VGND.t1336 sg13_lv_nmos ad=0.1406p pd=1.12u as=0.1406p ps=1.12u w=0.74u l=0.13u
X113 sg13cmos5l_inv_16_110.Y sg13cmos5l_inv_16_5.Y VPWR.t1055 VPWR.t4 sg13_lv_pmos ad=0.2128p pd=1.5u as=0.3808p ps=2.92u w=1.12u l=0.13u
X114 VGND.t882 sg13cmos5l_inv_16_71.Y sg13cmos5l_inv_16_68.A VGND.t881 sg13_lv_nmos ad=0.1406p pd=1.12u as=0.1406p ps=1.12u w=0.74u l=0.13u
X115 VPWR.t1526 sg13cmos5l_inv_16_105.A sg13cmos5l_inv_16_105.Y VPWR.t0 sg13_lv_pmos ad=0.2128p pd=1.5u as=0.2128p ps=1.5u w=1.12u l=0.13u
X116 VGND.t1100 VPWR.t2520 VGND.t1100 VGND.t2027 sg13_lv_nmos ad=79.8f pd=0.8u as=0 ps=0 w=0.42u l=1u
X117 VPWR.t707 sg13cmos5l_inv_16_28.A sg13cmos5l_inv_16_29.A VPWR.t177 sg13_lv_pmos ad=0.2128p pd=1.5u as=0.2128p ps=1.5u w=1.12u l=0.13u
X118 sg13cmos5l_inv_16_53.Y sg13cmos5l_inv_16_53.A VGND.t1680 VGND.t380 sg13_lv_nmos ad=0.1406p pd=1.12u as=0.1406p ps=1.12u w=0.74u l=0.13u
X119 VPWR.t2297 sg13cmos5l_inv_16_47.A sg13cmos5l_inv_16_45.Y VPWR.t16 sg13_lv_pmos ad=0.2128p pd=1.5u as=0.2128p ps=1.5u w=1.12u l=0.13u
X120 VGND.t326 sg13cmos5l_inv_16_26.Y sg13cmos5l_inv_16_40.Y VGND.t333 sg13_lv_nmos ad=0.1406p pd=1.12u as=0.1406p ps=1.12u w=0.74u l=0.13u
X121 VPWR.t627 sg13cmos5l_inv_16_44.A sg13cmos5l_inv_16_44.Y VPWR.t4 sg13_lv_pmos ad=0.2128p pd=1.5u as=0.2128p ps=1.5u w=1.12u l=0.13u
X122 VPWR.t895 sg13cmos5l_inv_16_20.A sg13cmos5l_inv_16_20.Y VPWR.t4 sg13_lv_pmos ad=0.2128p pd=1.5u as=0.2128p ps=1.5u w=1.12u l=0.13u
X123 sg13cmos5l_inv_16_73.A sg13cmos5l_inv_16_94.A VPWR.t1891 VPWR.t9 sg13_lv_pmos ad=0.2128p pd=1.5u as=0.3808p ps=2.92u w=1.12u l=0.13u
X124 sg13cmos5l_inv_16_44.Y sg13cmos5l_inv_16_44.A VGND.t198 VGND.t212 sg13_lv_nmos ad=0.1406p pd=1.12u as=0.1406p ps=1.12u w=0.74u l=0.13u
X125 sg13cmos5l_inv_16_109.Y sg13cmos5l_inv_16_48.A VGND.t1147 VGND.t881 sg13_lv_nmos ad=0.1406p pd=1.12u as=0.1406p ps=1.12u w=0.74u l=0.13u
X126 sg13cmos5l_inv_16_91.Y sg13cmos5l_inv_16_79.A VPWR.t2146 VPWR.t16 sg13_lv_pmos ad=0.2128p pd=1.5u as=0.2128p ps=1.5u w=1.12u l=0.13u
X127 VPWR.t2377 sg13cmos5l_inv_16_76.A sg13cmos5l_inv_16_77.A VPWR.t16 sg13_lv_pmos ad=0.2128p pd=1.5u as=0.2128p ps=1.5u w=1.12u l=0.13u
X128 VGND.t20 sg13cmos5l_inv_16_36.A sg13cmos5l_inv_16_100.Y VGND.t127 sg13_lv_nmos ad=0.1406p pd=1.12u as=0.1406p ps=1.12u w=0.74u l=0.13u
X129 VGND.t2361 sg13cmos5l_inv_16_6.Y sg13cmos5l_inv_16_108.Y VGND.t2360 sg13_lv_nmos ad=0.1406p pd=1.12u as=0.1406p ps=1.12u w=0.74u l=0.13u
X130 sg13cmos5l_inv_16_101.Y sg13cmos5l_inv_16_34.Y VPWR.t1038 VPWR.t0 sg13_lv_pmos ad=0.2128p pd=1.5u as=0.2128p ps=1.5u w=1.12u l=0.13u
X131 VPWR.t1546 sg13cmos5l_inv_16_109.Y sg13cmos5l_inv_16_67.A VPWR.t9 sg13_lv_pmos ad=0.2128p pd=1.5u as=0.2128p ps=1.5u w=1.12u l=0.13u
X132 sg13cmos5l_inv_16_111.A sg13cmos5l_inv_16_109.Y VGND.t1147 VGND.t881 sg13_lv_nmos ad=0.1406p pd=1.12u as=0.1406p ps=1.12u w=0.74u l=0.13u
X133 VGND.t635 sg13cmos5l_inv_16_6.Y sg13cmos5l_inv_16_25.Y VGND.t2346 sg13_lv_nmos ad=0.2516p pd=2.16u as=0.1406p ps=1.12u w=0.74u l=0.13u
X134 sg13cmos5l_inv_16_29.A sg13cmos5l_inv_16_28.A VPWR.t707 VPWR.t177 sg13_lv_pmos ad=0.2128p pd=1.5u as=0.2128p ps=1.5u w=1.12u l=0.13u
X135 sg13cmos5l_inv_16_15.Y sg13cmos5l_inv_16_15.A VGND.t450 VGND.t503 sg13_lv_nmos ad=0.1406p pd=1.12u as=0.1406p ps=1.12u w=0.74u l=0.13u
X136 sg13cmos5l_inv_16_99.A sg13cmos5l_inv_16_34.Y VPWR.t1024 VPWR.t25 sg13_lv_pmos ad=0.2128p pd=1.5u as=0.2128p ps=1.5u w=1.12u l=0.13u
X137 sg13cmos5l_inv_16_103.Y sg13cmos5l_inv_16_103.A VPWR.t1615 VPWR.t0 sg13_lv_pmos ad=0.2128p pd=1.5u as=0.2128p ps=1.5u w=1.12u l=0.13u
X138 a_20588_834# en[5] VPWR.t2009 VPWR.t177 sg13_lv_pmos ad=0.2856p pd=2.36u as=0.2114p ps=1.54u w=0.84u l=0.13u
X139 sg13cmos5l_inv_16_111.Y sg13cmos5l_inv_16_111.A VPWR.t1949 VPWR.t16 sg13_lv_pmos ad=0.2128p pd=1.5u as=0.2128p ps=1.5u w=1.12u l=0.13u
X140 VGND.t1970 sg13cmos5l_inv_16_76.A sg13cmos5l_inv_16_77.A VGND.t380 sg13_lv_nmos ad=0.1406p pd=1.12u as=0.1406p ps=1.12u w=0.74u l=0.13u
X141 sg13cmos5l_inv_16_30.Y sg13cmos5l_inv_16_30.A VPWR.t178 VPWR.t177 sg13_lv_pmos ad=0.2128p pd=1.5u as=0.2128p ps=1.5u w=1.12u l=0.13u
X142 VGND.t198 sg13cmos5l_inv_16_44.A sg13cmos5l_inv_16_44.Y VGND.t209 sg13_lv_nmos ad=0.1406p pd=1.12u as=0.1406p ps=1.12u w=0.74u l=0.13u
X143 VPWR.t1398 sg13cmos5l_inv_16_71.Y sg13cmos5l_inv_16_68.A VPWR.t9 sg13_lv_pmos ad=0.3808p pd=2.92u as=0.2128p ps=1.5u w=1.12u l=0.13u
X144 VGND.t1147 sg13cmos5l_inv_16_48.A sg13cmos5l_inv_16_109.Y VGND.t881 sg13_lv_nmos ad=0.1406p pd=1.12u as=0.1406p ps=1.12u w=0.74u l=0.13u
X145 VGND.t953 sg13cmos5l_inv_16_96.Y sg13cmos5l_inv_16_81.Y VGND.t380 sg13_lv_nmos ad=0.1406p pd=1.12u as=0.1406p ps=1.12u w=0.74u l=0.13u
X146 sg13cmos5l_inv_16_80.Y sg13cmos5l_inv_16_105.A VGND.t1100 VGND.t1104 sg13_lv_nmos ad=0.1406p pd=1.12u as=0.1406p ps=1.12u w=0.74u l=0.13u
X147 VGND.t122 VPWR.t2514 VGND.t122 VGND.t2036 sg13_lv_nmos ad=79.8f pd=0.8u as=0 ps=0 w=0.42u l=1u
X148 VPWR.t621 a_13664_4097# sg13cmos5l_inv_1_7.A VPWR.t0 sg13_lv_pmos ad=0.1918p pd=1.5u as=0.3808p ps=2.92u w=1.12u l=0.13u
X149 VGND.t125 sg13cmos5l_and2_1_2.B a_3691_916# VGND.t860 sg13_lv_nmos ad=0.1331p pd=1.12u as=0.1216p ps=1.02u w=0.64u l=0.13u
X150 sg13cmos5l_inv_16_37.Y sg13cmos5l_inv_16_37.A VPWR.t465 VPWR.t4 sg13_lv_pmos ad=0.2128p pd=1.5u as=0.2128p ps=1.5u w=1.12u l=0.13u
X151 sg13cmos5l_inv_16_77.A sg13cmos5l_inv_16_76.A VPWR.t2373 VPWR.t16 sg13_lv_pmos ad=0.2128p pd=1.5u as=0.2128p ps=1.5u w=1.12u l=0.13u
X152 VPWR.t243 VGND.t162 VPWR.t242 VPWR.t4 sg13_lv_pmos ad=0.34p pd=2.68u as=0 ps=0 w=1u l=1u
X153 VPWR.t1036 sg13cmos5l_inv_16_34.Y sg13cmos5l_inv_16_101.Y VPWR.t0 sg13_lv_pmos ad=0.2128p pd=1.5u as=0.2128p ps=1.5u w=1.12u l=0.13u
X154 sg13cmos5l_inv_16_102.Y sg13cmos5l_inv_16_37.A VGND.t5 VGND.t9 sg13_lv_nmos ad=0.1406p pd=1.12u as=0.1406p ps=1.12u w=0.74u l=0.13u
X155 VGND.t1147 sg13cmos5l_inv_16_109.Y sg13cmos5l_inv_16_111.A VGND.t881 sg13_lv_nmos ad=0.1406p pd=1.12u as=0.1406p ps=1.12u w=0.74u l=0.13u
X156 VGND.t1132 sg13cmos5l_inv_16_67.A sg13cmos5l_inv_16_67.Y VGND.t881 sg13_lv_nmos ad=0.1406p pd=1.12u as=0.1406p ps=1.12u w=0.74u l=0.13u
X157 sg13cmos5l_inv_2_5.Y sg13cmos5l_inv_2_5.A VGND.t898 VGND.t881 sg13_lv_nmos ad=0.1406p pd=1.12u as=0.2516p ps=2.16u w=0.74u l=0.13u
X158 VGND.t1398 sg13cmos5l_inv_16_6.A sg13cmos5l_inv_16_5.Y VGND.t1397 sg13_lv_nmos ad=0.1406p pd=1.12u as=0.1406p ps=1.12u w=0.74u l=0.13u
X159 sg13cmos5l_inv_16_50.Y sg13cmos5l_inv_16_46.Y VGND.t1715 VGND.t380 sg13_lv_nmos ad=0.1406p pd=1.12u as=0.1406p ps=1.12u w=0.74u l=0.13u
X160 sg13cmos5l_inv_16_25.Y sg13cmos5l_inv_16_6.Y VGND.t1260 VGND.t2343 sg13_lv_nmos ad=0.1406p pd=1.12u as=0.1406p ps=1.12u w=0.74u l=0.13u
X161 VPWR.t1957 sg13cmos5l_inv_4_0.A sg13cmos5l_inv_4_0.Y VPWR.t177 sg13_lv_pmos ad=0.2128p pd=1.5u as=0.2128p ps=1.5u w=1.12u l=0.13u
X162 VGND.t827 sg13cmos5l_inv_16_0.A sg13cmos5l_inv_16_1.A VGND.t857 sg13_lv_nmos ad=0.1406p pd=1.12u as=0.1406p ps=1.12u w=0.74u l=0.13u
X163 sg13cmos5l_inv_16_77.A sg13cmos5l_inv_16_76.A VGND.t1970 VGND.t380 sg13_lv_nmos ad=0.1406p pd=1.12u as=0.1406p ps=1.12u w=0.74u l=0.13u
X164 VGND.t1164 sg13cmos5l_inv_16_52.Y sg13cmos5l_inv_16_53.A VGND.t881 sg13_lv_nmos ad=0.1406p pd=1.12u as=0.1406p ps=1.12u w=0.74u l=0.13u
X165 sg13cmos5l_inv_16_23.Y sg13cmos5l_inv_16_0.A VPWR.t1244 VPWR.t4 sg13_lv_pmos ad=0.2128p pd=1.5u as=0.2128p ps=1.5u w=1.12u l=0.13u
X166 VPWR.t891 sg13cmos5l_inv_16_20.A sg13cmos5l_inv_16_20.Y VPWR.t4 sg13_lv_pmos ad=0.2128p pd=1.5u as=0.2128p ps=1.5u w=1.12u l=0.13u
X167 VGND.t916 osc[7] a_3592_9192# VGND.t1795 sg13_lv_nmos ad=0.14875p pd=1.16u as=0.187p ps=1.78u w=0.55u l=0.13u
X168 sg13cmos5l_inv_16_68.A sg13cmos5l_inv_16_71.Y VPWR.t1394 VPWR.t9 sg13_lv_pmos ad=0.2128p pd=1.5u as=0.2128p ps=1.5u w=1.12u l=0.13u
X169 VPWR.t308 VGND.t427 VPWR.t298 VPWR.t16 sg13_lv_pmos ad=0.19p pd=1.38u as=0 ps=0 w=1u l=1u
X170 sg13cmos5l_inv_16_81.Y sg13cmos5l_inv_16_96.Y VGND.t953 VGND.t380 sg13_lv_nmos ad=0.1406p pd=1.12u as=0.1406p ps=1.12u w=0.74u l=0.13u
X171 VPWR.t82 VGND.t1944 VPWR.t80 VPWR.t25 sg13_lv_pmos ad=0.19p pd=1.38u as=0 ps=0 w=1u l=1u
X172 VGND.t20 VPWR.t2535 VGND.t20 VGND.t2002 sg13_lv_nmos ad=79.8f pd=0.8u as=0 ps=0 w=0.42u l=1u
X173 VGND.t827 sg13cmos5l_inv_16_0.A sg13cmos5l_inv_16_23.Y VGND.t840 sg13_lv_nmos ad=0.1406p pd=1.12u as=0.1406p ps=1.12u w=0.74u l=0.13u
X174 VGND.t1100 sg13cmos5l_inv_16_105.A sg13cmos5l_inv_16_80.Y VGND.t1101 sg13_lv_nmos ad=0.1406p pd=1.12u as=0.1406p ps=1.12u w=0.74u l=0.13u
X175 VGND.t353 sg13cmos5l_inv_16_11.A sg13cmos5l_inv_16_105.A VGND.t357 sg13_lv_nmos ad=0.1406p pd=1.12u as=0.1406p ps=1.12u w=0.74u l=0.13u
X176 sg13cmos5l_inv_16_67.Y sg13cmos5l_inv_16_67.A VGND.t1132 VGND.t881 sg13_lv_nmos ad=0.1406p pd=1.12u as=0.1406p ps=1.12u w=0.74u l=0.13u
X177 sg13cmos5l_inv_16_5.Y sg13cmos5l_inv_16_6.A VGND.t637 VGND.t1394 sg13_lv_nmos ad=0.1406p pd=1.12u as=0.1406p ps=1.12u w=0.74u l=0.13u
X178 sg13cmos5l_inv_16_68.Y sg13cmos5l_inv_16_68.A VGND.t882 VGND.t881 sg13_lv_nmos ad=0.1406p pd=1.12u as=0.1406p ps=1.12u w=0.74u l=0.13u
X179 sg13cmos5l_inv_16_19.Y sg13cmos5l_inv_16_17.A VGND.t86 VGND.t94 sg13_lv_nmos ad=0.1406p pd=1.12u as=0.1406p ps=1.12u w=0.74u l=0.13u
X180 sg13cmos5l_inv_16_80.Y sg13cmos5l_inv_16_105.A VPWR.t1510 VPWR.t25 sg13_lv_pmos ad=0.2128p pd=1.5u as=0.2128p ps=1.5u w=1.12u l=0.13u
X181 sg13cmos5l_inv_16_1.A sg13cmos5l_inv_16_0.A VGND.t827 VGND.t854 sg13_lv_nmos ad=0.1406p pd=1.12u as=0.1406p ps=1.12u w=0.74u l=0.13u
X182 sg13cmos5l_inv_16_41.A sg13cmos5l_inv_8_3.Y VPWR.t1232 VPWR.t4 sg13_lv_pmos ad=0.2128p pd=1.5u as=0.2128p ps=1.5u w=1.12u l=0.13u
X183 VPWR.t1863 sg13cmos5l_inv_16_73.A sg13cmos5l_inv_16_87.A VPWR.t9 sg13_lv_pmos ad=0.2128p pd=1.5u as=0.2128p ps=1.5u w=1.12u l=0.13u
X184 VGND.t255 sg13cmos5l_and2_1_1.B a_20491_1980# VGND.t1695 sg13_lv_nmos ad=0.1331p pd=1.12u as=0.1216p ps=1.02u w=0.64u l=0.13u
X185 VGND.t196 a_13664_4097# sg13cmos5l_inv_1_7.A VGND.t195 sg13_lv_nmos ad=0.1331p pd=1.12u as=0.2516p ps=2.16u w=0.74u l=0.13u
X186 sg13cmos5l_inv_16_2.A sg13cmos5l_inv_16_1.A VPWR.t1081 VPWR.t4 sg13_lv_pmos ad=0.2128p pd=1.5u as=0.2128p ps=1.5u w=1.12u l=0.13u
X187 sg13cmos5l_inv_16_53.A sg13cmos5l_inv_16_52.Y VGND.t1164 VGND.t881 sg13_lv_nmos ad=0.1406p pd=1.12u as=0.1406p ps=1.12u w=0.74u l=0.13u
X188 VPWR.t135 VGND.t1010 VPWR.t134 VPWR.t16 sg13_lv_pmos ad=0.34p pd=2.68u as=0 ps=0 w=1u l=1u
X189 sg13cmos5l_inv_16_73.Y sg13cmos5l_inv_16_73.A VPWR.t1871 VPWR.t16 sg13_lv_pmos ad=0.2128p pd=1.5u as=0.2128p ps=1.5u w=1.12u l=0.13u
X190 VPWR.t1242 sg13cmos5l_inv_16_0.A sg13cmos5l_inv_16_23.Y VPWR.t4 sg13_lv_pmos ad=0.2128p pd=1.5u as=0.2128p ps=1.5u w=1.12u l=0.13u
X191 sg13cmos5l_inv_16_99.A sg13cmos5l_inv_16_34.Y VGND.t593 VGND.t595 sg13_lv_nmos ad=0.1406p pd=1.12u as=0.1406p ps=1.12u w=0.74u l=0.13u
X192 VPWR.t480 sg13cmos5l_inv_2_3.Y sg13cmos5l_inv_4_2.Y VPWR.t177 sg13_lv_pmos ad=0.3808p pd=2.92u as=0.2128p ps=1.5u w=1.12u l=0.13u
X193 sg13cmos5l_inv_16_23.Y sg13cmos5l_inv_16_0.A VGND.t827 VGND.t837 sg13_lv_nmos ad=0.1406p pd=1.12u as=0.1406p ps=1.12u w=0.74u l=0.13u
X194 sg13cmos5l_inv_16_44.A sg13cmos5l_inv_16_28.A VGND.t259 VGND.t260 sg13_lv_nmos ad=0.1406p pd=1.12u as=0.1406p ps=1.12u w=0.74u l=0.13u
X195 VPWR.t1536 sg13cmos5l_inv_16_109.Y sg13cmos5l_inv_16_111.A VPWR.t9 sg13_lv_pmos ad=0.2128p pd=1.5u as=0.2128p ps=1.5u w=1.12u l=0.13u
X196 sg13cmos5l_inv_16_69.Y sg13cmos5l_inv_16_52.Y VGND.t922 VGND.t881 sg13_lv_nmos ad=0.1406p pd=1.12u as=0.1406p ps=1.12u w=0.74u l=0.13u
X197 sg13cmos5l_inv_16_36.A sg13cmos5l_inv_16_43.Y VPWR.t612 VPWR.t0 sg13_lv_pmos ad=0.2128p pd=1.5u as=0.2128p ps=1.5u w=1.12u l=0.13u
X198 VPWR.t1522 sg13cmos5l_inv_16_105.A sg13cmos5l_inv_16_105.Y VPWR.t0 sg13_lv_pmos ad=0.2128p pd=1.5u as=0.2128p ps=1.5u w=1.12u l=0.13u
X199 sg13cmos5l_inv_16_4.Y sg13cmos5l_inv_8_1.Y VGND.t423 VGND.t1464 sg13_lv_nmos ad=0.1406p pd=1.12u as=0.1406p ps=1.12u w=0.74u l=0.13u
X200 sg13cmos5l_inv_16_73.Y sg13cmos5l_inv_16_73.A VGND.t381 VGND.t380 sg13_lv_nmos ad=0.1406p pd=1.12u as=0.1406p ps=1.12u w=0.74u l=0.13u
X201 sg13cmos5l_inv_16_102.Y sg13cmos5l_inv_16_37.A VGND.t5 VGND.t4 sg13_lv_nmos ad=0.1406p pd=1.12u as=0.2516p ps=2.16u w=0.74u l=0.13u
X202 VPWR.t1230 sg13cmos5l_inv_8_3.Y sg13cmos5l_inv_16_41.A VPWR.t4 sg13_lv_pmos ad=0.2128p pd=1.5u as=0.2128p ps=1.5u w=1.12u l=0.13u
X203 VGND.t922 sg13cmos5l_inv_16_69.Y sg13cmos5l_inv_16_62.Y VGND.t881 sg13_lv_nmos ad=0.1406p pd=1.12u as=0.1406p ps=1.12u w=0.74u l=0.13u
X204 VPWR.t1488 sg13cmos5l_inv_16_84.A sg13cmos5l_inv_16_84.Y VPWR.t9 sg13_lv_pmos ad=0.2128p pd=1.5u as=0.2128p ps=1.5u w=1.12u l=0.13u
X205 VPWR.t1508 sg13cmos5l_inv_16_105.A sg13cmos5l_inv_16_80.Y VPWR.t25 sg13_lv_pmos ad=0.2128p pd=1.5u as=0.2128p ps=1.5u w=1.12u l=0.13u
X206 sg13cmos5l_inv_16_104.Y sg13cmos5l_inv_16_14.A VPWR.t909 VPWR.t0 sg13_lv_pmos ad=0.2128p pd=1.5u as=0.2128p ps=1.5u w=1.12u l=0.13u
X207 VGND.t827 sg13cmos5l_inv_16_0.A sg13cmos5l_inv_16_1.A VGND.t851 sg13_lv_nmos ad=0.1406p pd=1.12u as=0.1406p ps=1.12u w=0.74u l=0.13u
X208 sg13cmos5l_inv_16_87.A sg13cmos5l_inv_16_73.A VPWR.t1859 VPWR.t9 sg13_lv_pmos ad=0.2128p pd=1.5u as=0.2128p ps=1.5u w=1.12u l=0.13u
X209 sg13cmos5l_inv_16_48.A sg13cmos5l_inv_8_7.Y VPWR.t1185 VPWR.t25 sg13_lv_pmos ad=0.2128p pd=1.5u as=0.2128p ps=1.5u w=1.12u l=0.13u
X210 VGND.t545 sg13cmos5l_inv_16_96.A sg13cmos5l_inv_16_96.Y VGND.t948 sg13_lv_nmos ad=0.1406p pd=1.12u as=0.1406p ps=1.12u w=0.74u l=0.13u
X211 VPWR.t51 VGND.t1873 VPWR.t50 VPWR.t9 sg13_lv_pmos ad=0.19p pd=1.38u as=0 ps=0 w=1u l=1u
X212 sg13cmos5l_inv_16_111.A sg13cmos5l_inv_16_109.Y VPWR.t1561 VPWR.t9 sg13_lv_pmos ad=0.2128p pd=1.5u as=0.2128p ps=1.5u w=1.12u l=0.13u
X213 VPWR.t2188 sg13cmos5l_inv_16_73.Y sg13cmos5l_inv_16_95.Y VPWR.t16 sg13_lv_pmos ad=0.2128p pd=1.5u as=0.2128p ps=1.5u w=1.12u l=0.13u
X214 sg13cmos5l_inv_16_91.Y sg13cmos5l_inv_16_79.A VGND.t1026 VGND.t881 sg13_lv_nmos ad=0.1406p pd=1.12u as=0.1406p ps=1.12u w=0.74u l=0.13u
X215 VPWR.t1542 sg13cmos5l_inv_16_109.Y sg13cmos5l_inv_16_67.A VPWR.t9 sg13_lv_pmos ad=0.2128p pd=1.5u as=0.2128p ps=1.5u w=1.12u l=0.13u
X216 sg13cmos5l_inv_16_105.Y sg13cmos5l_inv_16_105.A VPWR.t1519 VPWR.t0 sg13_lv_pmos ad=0.2128p pd=1.5u as=0.3808p ps=2.92u w=1.12u l=0.13u
X217 VGND.t1541 sg13cmos5l_inv_16_111.A sg13cmos5l_inv_16_98.Y VGND.t1542 sg13_lv_nmos ad=0.1406p pd=1.12u as=0.1406p ps=1.12u w=0.74u l=0.13u
X218 sg13cmos5l_inv_16_62.Y sg13cmos5l_inv_16_69.Y VGND.t922 VGND.t881 sg13_lv_nmos ad=0.1406p pd=1.12u as=0.1406p ps=1.12u w=0.74u l=0.13u
X219 VGND.t381 sg13cmos5l_inv_16_73.A sg13cmos5l_inv_16_73.Y VGND.t380 sg13_lv_nmos ad=0.1406p pd=1.12u as=0.1406p ps=1.12u w=0.74u l=0.13u
X220 VGND.t1792 sg13cmos5l_inv_16_96.Y sg13cmos5l_inv_16_11.A VGND.t380 sg13_lv_nmos ad=0.1406p pd=1.12u as=0.1406p ps=1.12u w=0.74u l=0.13u
X221 VPWR.t907 sg13cmos5l_inv_16_14.A sg13cmos5l_inv_16_104.Y VPWR.t0 sg13_lv_pmos ad=0.2128p pd=1.5u as=0.2128p ps=1.5u w=1.12u l=0.13u
X222 VPWR.t246 sg13cmos5l_inv_16_6.A sg13cmos5l_inv_16_6.Y VPWR.t177 sg13_lv_pmos ad=0.2128p pd=1.5u as=0.2128p ps=1.5u w=1.12u l=0.13u
X223 sg13cmos5l_inv_16_29.A sg13cmos5l_inv_16_28.A VGND.t198 VGND.t212 sg13_lv_nmos ad=0.1406p pd=1.12u as=0.1406p ps=1.12u w=0.74u l=0.13u
X224 VPWR.t1633 sg13cmos5l_inv_4_2.Y sg13cmos5l_inv_8_3.Y VPWR.t4 sg13_lv_pmos ad=0.2128p pd=1.5u as=0.2128p ps=1.5u w=1.12u l=0.13u
X225 sg13cmos5l_inv_16_99.A sg13cmos5l_inv_16_34.Y VPWR.t1020 VPWR.t25 sg13_lv_pmos ad=0.2128p pd=1.5u as=0.2128p ps=1.5u w=1.12u l=0.13u
X226 sg13cmos5l_inv_16_80.Y sg13cmos5l_inv_16_105.A VPWR.t1504 VPWR.t25 sg13_lv_pmos ad=0.2128p pd=1.5u as=0.2128p ps=1.5u w=1.12u l=0.13u
X227 sg13cmos5l_inv_16_40.Y sg13cmos5l_inv_16_26.Y VGND.t326 VGND.t325 sg13_lv_nmos ad=0.1406p pd=1.12u as=0.2516p ps=2.16u w=0.74u l=0.13u
X228 VPWR.t490 sg13cmos5l_inv_16_23.Y sg13cmos5l_inv_16_15.A VPWR.t0 sg13_lv_pmos ad=0.2128p pd=1.5u as=0.2128p ps=1.5u w=1.12u l=0.13u
X229 sg13cmos5l_inv_16_28.A sg13cmos5l_inv_16_41.A VPWR.t681 VPWR.t4 sg13_lv_pmos ad=0.2128p pd=1.5u as=0.2128p ps=1.5u w=1.12u l=0.13u
X230 VGND.t1944 sg13cmos5l_inv_8_4.Y sg13cmos5l_inv_16_56.Y VGND.t380 sg13_lv_nmos ad=0.1406p pd=1.12u as=0.1406p ps=1.12u w=0.74u l=0.13u
X231 sg13cmos5l_inv_16_105.A sg13cmos5l_inv_16_11.A VPWR.t782 VPWR.t25 sg13_lv_pmos ad=0.2128p pd=1.5u as=0.2128p ps=1.5u w=1.12u l=0.13u
X232 sg13cmos5l_inv_16_79.Y sg13cmos5l_inv_16_79.A VGND.t1779 VGND.t380 sg13_lv_nmos ad=0.1406p pd=1.12u as=0.2516p ps=2.16u w=0.74u l=0.13u
X233 sg13cmos5l_inv_2_2.A sg13cmos5l_and2_1_3.X VPWR.t1627 VPWR.t4 sg13_lv_pmos ad=0.3808p pd=2.92u as=0.3808p ps=2.92u w=1.12u l=0.13u
X234 VPWR.t55 VGND.t1067 VPWR.t52 VPWR.t9 sg13_lv_pmos ad=0.19p pd=1.38u as=0 ps=0 w=1u l=1u
X235 sg13cmos5l_inv_16_53.A sg13cmos5l_inv_16_52.Y VGND.t1164 VGND.t881 sg13_lv_nmos ad=0.1406p pd=1.12u as=0.1406p ps=1.12u w=0.74u l=0.13u
X236 sg13cmos5l_inv_16_90.Y sg13cmos5l_inv_16_73.Y VGND.t1029 VGND.t881 sg13_lv_nmos ad=0.1406p pd=1.12u as=0.2516p ps=2.16u w=0.74u l=0.13u
X237 sg13cmos5l_inv_16_95.Y sg13cmos5l_inv_16_73.Y VPWR.t2187 VPWR.t16 sg13_lv_pmos ad=0.2128p pd=1.5u as=0.4368p ps=3.02u w=1.12u l=0.13u
X238 VPWR.t1032 sg13cmos5l_inv_16_34.Y sg13cmos5l_inv_16_101.Y VPWR.t0 sg13_lv_pmos ad=0.2128p pd=1.5u as=0.2128p ps=1.5u w=1.12u l=0.13u
X239 VGND.t1100 VPWR.t2520 VGND.t432 VGND.t2026 sg13_lv_nmos ad=0.1428p pd=1.52u as=0 ps=0 w=0.42u l=1u
X240 VPWR.t970 sg13cmos5l_inv_16_8.Y sg13cmos5l_inv_16_20.A VPWR.t0 sg13_lv_pmos ad=0.2128p pd=1.5u as=0.2128p ps=1.5u w=1.12u l=0.13u
X241 sg13cmos5l_inv_16_67.A sg13cmos5l_inv_16_109.Y VPWR.t1538 VPWR.t9 sg13_lv_pmos ad=0.2128p pd=1.5u as=0.2128p ps=1.5u w=1.12u l=0.13u
X242 VPWR.t2108 sg13cmos5l_inv_16_48.A sg13cmos5l_inv_16_46.A VPWR.t25 sg13_lv_pmos ad=0.2128p pd=1.5u as=0.2128p ps=1.5u w=1.12u l=0.13u
X243 VGND.t609 sg13cmos5l_inv_16_34.Y sg13cmos5l_inv_16_101.Y VGND.t608 sg13_lv_nmos ad=0.2516p pd=2.16u as=0.1406p ps=1.12u w=0.74u l=0.13u
X244 sg13cmos5l_inv_16_36.A sg13cmos5l_inv_16_43.Y VPWR.t608 VPWR.t0 sg13_lv_pmos ad=0.2128p pd=1.5u as=0.2128p ps=1.5u w=1.12u l=0.13u
X245 sg13cmos5l_inv_16_43.Y sg13cmos5l_inv_16_27.Y VPWR.t1652 VPWR.t4 sg13_lv_pmos ad=0.2128p pd=1.5u as=0.2128p ps=1.5u w=1.12u l=0.13u
X246 sg13cmos5l_inv_16_74.Y sg13cmos5l_inv_16_75.A VGND.t390 VGND.t380 sg13_lv_nmos ad=0.1406p pd=1.12u as=0.1406p ps=1.12u w=0.74u l=0.13u
X247 VPWR.t1358 sg13cmos5l_inv_16_96.A sg13cmos5l_inv_16_96.Y VPWR.t25 sg13_lv_pmos ad=0.4368p pd=3.02u as=0.2128p ps=1.5u w=1.12u l=0.13u
X248 sg13cmos5l_inv_16_6.Y sg13cmos5l_inv_16_6.A VPWR.t246 VPWR.t177 sg13_lv_pmos ad=0.2128p pd=1.5u as=0.2128p ps=1.5u w=1.12u l=0.13u
X249 VGND.t198 sg13cmos5l_inv_16_28.A sg13cmos5l_inv_16_29.A VGND.t209 sg13_lv_nmos ad=0.1406p pd=1.12u as=0.1406p ps=1.12u w=0.74u l=0.13u
X250 VPWR.t1018 sg13cmos5l_inv_16_34.Y sg13cmos5l_inv_16_99.A VPWR.t25 sg13_lv_pmos ad=0.2128p pd=1.5u as=0.2128p ps=1.5u w=1.12u l=0.13u
X251 VPWR.t1486 sg13cmos5l_inv_16_84.A sg13cmos5l_inv_16_85.Y VPWR.t9 sg13_lv_pmos ad=0.4368p pd=3.02u as=0.2128p ps=1.5u w=1.12u l=0.13u
X252 VPWR.t2090 sg13cmos5l_inv_16_48.A sg13cmos5l_inv_16_109.Y VPWR.t16 sg13_lv_pmos ad=0.2128p pd=1.5u as=0.2128p ps=1.5u w=1.12u l=0.13u
X253 VPWR.t1922 sg13cmos5l_inv_16_94.A sg13cmos5l_inv_16_76.A VPWR.t16 sg13_lv_pmos ad=0.4368p pd=3.02u as=0.2128p ps=1.5u w=1.12u l=0.13u
X254 sg13cmos5l_inv_16_75.Y sg13cmos5l_inv_16_75.A VGND.t122 VGND.t407 sg13_lv_nmos ad=0.1406p pd=1.12u as=0.1406p ps=1.12u w=0.74u l=0.13u
X255 VGND.t472 sg13cmos5l_inv_16_77.A sg13cmos5l_inv_16_77.Y VGND.t2163 sg13_lv_nmos ad=0.1406p pd=1.12u as=0.1406p ps=1.12u w=0.74u l=0.13u
X256 sg13cmos5l_inv_16_103.A sg13cmos5l_inv_16_11.A VPWR.t794 VPWR.t0 sg13_lv_pmos ad=0.2128p pd=1.5u as=0.2128p ps=1.5u w=1.12u l=0.13u
X257 sg13cmos5l_inv_16_56.Y sg13cmos5l_inv_8_4.Y VGND.t1944 VGND.t380 sg13_lv_nmos ad=0.1406p pd=1.12u as=0.1406p ps=1.12u w=0.74u l=0.13u
X258 VGND.t1398 VPWR.t2475 VGND.t308 VGND.t2106 sg13_lv_nmos ad=79.8f pd=0.8u as=0 ps=0 w=0.42u l=1u
X259 sg13cmos5l_inv_16_68.A sg13cmos5l_inv_16_71.Y VPWR.t1390 VPWR.t9 sg13_lv_pmos ad=0.2128p pd=1.5u as=0.2128p ps=1.5u w=1.12u l=0.13u
X260 VGND.t122 VPWR.t2513 VGND.t122 VGND.t2038 sg13_lv_nmos ad=79.8f pd=0.8u as=0 ps=0 w=0.42u l=1u
X261 sg13cmos5l_inv_16_62.Y sg13cmos5l_inv_16_69.Y VPWR.t1334 VPWR.t9 sg13_lv_pmos ad=0.2128p pd=1.5u as=0.2128p ps=1.5u w=1.12u l=0.13u
X262 sg13cmos5l_inv_16_5.Y sg13cmos5l_inv_16_6.A VGND.t637 VGND.t1390 sg13_lv_nmos ad=0.1406p pd=1.12u as=0.1406p ps=1.12u w=0.74u l=0.13u
X263 VGND.t390 sg13cmos5l_inv_16_75.A sg13cmos5l_inv_16_74.Y VGND.t380 sg13_lv_nmos ad=0.1406p pd=1.12u as=0.1406p ps=1.12u w=0.74u l=0.13u
X264 VPWR.t233 VGND.t635 VPWR.t233 VPWR.t177 sg13_lv_pmos ad=0.19p pd=1.38u as=0 ps=0 w=1u l=1u
X265 VPWR.t1650 sg13cmos5l_inv_16_27.Y sg13cmos5l_inv_16_43.Y VPWR.t4 sg13_lv_pmos ad=0.2128p pd=1.5u as=0.2128p ps=1.5u w=1.12u l=0.13u
X266 sg13cmos5l_inv_16_96.Y sg13cmos5l_inv_16_96.A VPWR.t1354 VPWR.t25 sg13_lv_pmos ad=0.2128p pd=1.5u as=0.2128p ps=1.5u w=1.12u l=0.13u
X267 sg13cmos5l_inv_8_0.Y sg13cmos5l_inv_4_0.Y VGND.t588 VGND.t1801 sg13_lv_nmos ad=0.1406p pd=1.12u as=0.1406p ps=1.12u w=0.74u l=0.13u
X268 VGND.t122 sg13cmos5l_inv_16_75.A sg13cmos5l_inv_16_75.Y VGND.t404 sg13_lv_nmos ad=0.1406p pd=1.12u as=0.1406p ps=1.12u w=0.74u l=0.13u
X269 VPWR.t792 sg13cmos5l_inv_16_11.A sg13cmos5l_inv_16_103.A VPWR.t0 sg13_lv_pmos ad=0.2128p pd=1.5u as=0.2128p ps=1.5u w=1.12u l=0.13u
X270 sg13cmos5l_inv_16_53.Y sg13cmos5l_inv_16_53.A VPWR.t2059 VPWR.t16 sg13_lv_pmos ad=0.2128p pd=1.5u as=0.3808p ps=2.92u w=1.12u l=0.13u
X271 sg13cmos5l_inv_16_17.Y sg13cmos5l_inv_16_17.A VPWR.t550 VPWR.t177 sg13_lv_pmos ad=0.2128p pd=1.5u as=0.2128p ps=1.5u w=1.12u l=0.13u
X272 VGND.t655 sg13cmos5l_inv_16_2.A sg13cmos5l_inv_16_2.Y VGND.t1439 sg13_lv_nmos ad=0.1406p pd=1.12u as=0.1406p ps=1.12u w=0.74u l=0.13u
X273 sg13cmos5l_inv_16_28.A sg13cmos5l_inv_16_41.A VPWR.t677 VPWR.t4 sg13_lv_pmos ad=0.2128p pd=1.5u as=0.2128p ps=1.5u w=1.12u l=0.13u
X274 VGND.t756 sg13cmos5l_inv_8_7.Y sg13cmos5l_inv_16_48.A VGND.t380 sg13_lv_nmos ad=0.1406p pd=1.12u as=0.1406p ps=1.12u w=0.74u l=0.13u
X275 VPWR.t456 sg13cmos5l_inv_16_37.A sg13cmos5l_inv_16_102.Y VPWR.t0 sg13_lv_pmos ad=0.2128p pd=1.5u as=0.2128p ps=1.5u w=1.12u l=0.13u
X276 VPWR.t1332 sg13cmos5l_inv_16_69.Y sg13cmos5l_inv_16_62.Y VPWR.t9 sg13_lv_pmos ad=0.2128p pd=1.5u as=0.2128p ps=1.5u w=1.12u l=0.13u
X277 sg13cmos5l_inv_16_75.Y sg13cmos5l_inv_16_75.A VPWR.t832 VPWR.t25 sg13_lv_pmos ad=0.2128p pd=1.5u as=0.2128p ps=1.5u w=1.12u l=0.13u
X278 VGND.t345 sg13cmos5l_inv_16_105.A sg13cmos5l_inv_16_105.Y VGND.t1113 sg13_lv_nmos ad=0.1406p pd=1.12u as=0.1406p ps=1.12u w=0.74u l=0.13u
X279 VGND.t86 sg13cmos5l_inv_16_17.A sg13cmos5l_inv_16_19.Y VGND.t87 sg13_lv_nmos ad=0.1406p pd=1.12u as=0.1406p ps=1.12u w=0.74u l=0.13u
X280 sg13cmos5l_inv_16_14.A sg13cmos5l_inv_16_23.Y VGND.t52 VGND.t71 sg13_lv_nmos ad=0.1406p pd=1.12u as=0.1406p ps=1.12u w=0.74u l=0.13u
X281 VPWR.t24 VGND.t1779 VPWR.t22 VPWR.t16 sg13_lv_pmos ad=0.19p pd=1.38u as=0 ps=0 w=1u l=1u
X282 sg13cmos5l_inv_16_74.Y sg13cmos5l_inv_16_75.A VGND.t381 VGND.t380 sg13_lv_nmos ad=0.1406p pd=1.12u as=0.1406p ps=1.12u w=0.74u l=0.13u
X283 sg13cmos5l_inv_16_103.A sg13cmos5l_inv_16_11.A VPWR.t788 VPWR.t0 sg13_lv_pmos ad=0.2128p pd=1.5u as=0.2128p ps=1.5u w=1.12u l=0.13u
X284 VPWR.t623 sg13cmos5l_inv_16_44.A sg13cmos5l_inv_16_44.Y VPWR.t4 sg13_lv_pmos ad=0.2128p pd=1.5u as=0.2128p ps=1.5u w=1.12u l=0.13u
X285 sg13cmos5l_inv_16_30.Y sg13cmos5l_inv_16_30.A VGND.t343 VGND.t1298 sg13_lv_nmos ad=0.1406p pd=1.12u as=0.1406p ps=1.12u w=0.74u l=0.13u
X286 VPWR.t2350 sg13cmos5l_inv_16_101.Y sg13cmos5l_inv_16_55.Y VPWR.t25 sg13_lv_pmos ad=0.2128p pd=1.5u as=0.2128p ps=1.5u w=1.12u l=0.13u
X287 VGND.t1411 sg13cmos5l_inv_16_6.A sg13cmos5l_inv_16_6.Y VGND.t1413 sg13_lv_nmos ad=0.1406p pd=1.12u as=0.1406p ps=1.12u w=0.74u l=0.13u
X288 sg13cmos5l_inv_16_2.Y sg13cmos5l_inv_16_2.A VGND.t655 VGND.t1436 sg13_lv_nmos ad=0.1406p pd=1.12u as=0.1406p ps=1.12u w=0.74u l=0.13u
X289 VGND.t922 sg13cmos5l_inv_16_52.Y sg13cmos5l_inv_16_69.Y VGND.t881 sg13_lv_nmos ad=0.1406p pd=1.12u as=0.1406p ps=1.12u w=0.74u l=0.13u
X290 VGND.t1010 sg13cmos5l_inv_16_73.Y sg13cmos5l_inv_16_95.Y VGND.t881 sg13_lv_nmos ad=0.1406p pd=1.12u as=0.1406p ps=1.12u w=0.74u l=0.13u
X291 sg13cmos5l_inv_16_48.A sg13cmos5l_inv_8_7.Y VGND.t756 VGND.t380 sg13_lv_nmos ad=0.1406p pd=1.12u as=0.2516p ps=2.16u w=0.74u l=0.13u
X292 VGND.t259 sg13cmos5l_inv_16_29.A sg13cmos5l_inv_16_35.Y VGND.t273 sg13_lv_nmos ad=0.2516p pd=2.16u as=0.1406p ps=1.12u w=0.74u l=0.13u
X293 VPWR.t1304 sg13cmos5l_inv_16_68.A sg13cmos5l_inv_16_68.Y VPWR.t16 sg13_lv_pmos ad=0.2128p pd=1.5u as=0.2128p ps=1.5u w=1.12u l=0.13u
X294 VPWR.t830 sg13cmos5l_inv_16_75.A sg13cmos5l_inv_16_75.Y VPWR.t25 sg13_lv_pmos ad=0.2128p pd=1.5u as=0.2128p ps=1.5u w=1.12u l=0.13u
X295 sg13cmos5l_inv_16_105.Y sg13cmos5l_inv_16_105.A VGND.t345 VGND.t1110 sg13_lv_nmos ad=0.1406p pd=1.12u as=0.1406p ps=1.12u w=0.74u l=0.13u
X296 VPWR.t78 VGND.t1944 VPWR.t75 VPWR.t16 sg13_lv_pmos ad=0.19p pd=1.38u as=0 ps=0 w=1u l=1u
X297 VGND.t1954 VPWR.t2562 VGND.t1954 VGND.t380 sg13_lv_nmos ad=0.1428p pd=1.52u as=0 ps=0 w=0.42u l=1u
X298 VGND.t381 sg13cmos5l_inv_16_73.A sg13cmos5l_inv_16_73.Y VGND.t380 sg13_lv_nmos ad=0.1406p pd=1.12u as=0.1406p ps=1.12u w=0.74u l=0.13u
X299 VPWR.t2336 sg13cmos5l_inv_16_101.Y sg13cmos5l_inv_16_54.Y VPWR.t25 sg13_lv_pmos ad=0.4368p pd=3.02u as=0.2128p ps=1.5u w=1.12u l=0.13u
X300 sg13cmos5l_inv_16_29.A sg13cmos5l_inv_16_28.A VPWR.t706 VPWR.t177 sg13_lv_pmos ad=0.2128p pd=1.5u as=0.3808p ps=2.92u w=1.12u l=0.13u
X301 VGND.t1944 VPWR.t2566 VGND.t1944 VGND.t380 sg13_lv_nmos ad=79.8f pd=0.8u as=0 ps=0 w=0.42u l=1u
X302 sg13cmos5l_inv_16_9.A sg13cmos5l_inv_16_8.Y VGND.t291 VGND.t572 sg13_lv_nmos ad=0.1406p pd=1.12u as=0.1406p ps=1.12u w=0.74u l=0.13u
X303 sg13cmos5l_inv_16_6.Y sg13cmos5l_inv_16_6.A VGND.t862 VGND.t1407 sg13_lv_nmos ad=0.1406p pd=1.12u as=0.1406p ps=1.12u w=0.74u l=0.13u
X304 sg13cmos5l_inv_16_67.Y sg13cmos5l_inv_16_67.A VPWR.t1986 VPWR.t16 sg13_lv_pmos ad=0.2128p pd=1.5u as=0.2128p ps=1.5u w=1.12u l=0.13u
X305 VGND.t291 sg13cmos5l_inv_16_4.Y sg13cmos5l_inv_16_8.Y VGND.t300 sg13_lv_nmos ad=0.1406p pd=1.12u as=0.1406p ps=1.12u w=0.74u l=0.13u
X306 VGND.t221 sg13cmos5l_inv_16_41.A sg13cmos5l_inv_16_34.Y VGND.t220 sg13_lv_nmos ad=0.1406p pd=1.12u as=0.1406p ps=1.12u w=0.74u l=0.13u
X307 VGND.t2123 VPWR.t2467 VGND.t2123 VGND.t2124 sg13_lv_nmos ad=0.1428p pd=1.52u as=0 ps=0 w=0.42u l=1u
X308 sg13cmos5l_inv_16_95.Y sg13cmos5l_inv_16_73.Y VGND.t1010 VGND.t881 sg13_lv_nmos ad=0.1406p pd=1.12u as=0.1406p ps=1.12u w=0.74u l=0.13u
X309 VPWR.t207 VGND.t52 VPWR.t205 VPWR.t4 sg13_lv_pmos ad=0.19p pd=1.38u as=0 ps=0 w=1u l=1u
X310 VPWR.t280 VGND.t291 VPWR.t278 VPWR.t4 sg13_lv_pmos ad=0.19p pd=1.38u as=0 ps=0 w=1u l=1u
X311 VPWR.t452 sg13cmos5l_inv_16_37.A sg13cmos5l_inv_16_102.Y VPWR.t0 sg13_lv_pmos ad=0.2128p pd=1.5u as=0.2128p ps=1.5u w=1.12u l=0.13u
X312 VGND.t2108 VPWR.t2474 VGND.t255 VGND.t2109 sg13_lv_nmos ad=79.8f pd=0.8u as=0 ps=0 w=0.42u l=1u
X313 sg13cmos5l_inv_16_75.Y sg13cmos5l_inv_16_75.A VPWR.t826 VPWR.t25 sg13_lv_pmos ad=0.2128p pd=1.5u as=0.2128p ps=1.5u w=1.12u l=0.13u
X314 VGND.t593 sg13cmos5l_inv_16_34.Y sg13cmos5l_inv_16_101.Y VGND.t604 sg13_lv_nmos ad=0.1406p pd=1.12u as=0.1406p ps=1.12u w=0.74u l=0.13u
X315 VGND.t1010 sg13cmos5l_inv_16_87.A sg13cmos5l_inv_16_87.Y VGND.t881 sg13_lv_nmos ad=0.1406p pd=1.12u as=0.1406p ps=1.12u w=0.74u l=0.13u
X316 sg13cmos5l_inv_16_40.Y sg13cmos5l_inv_16_26.Y VPWR.t178 VPWR.t177 sg13_lv_pmos ad=0.2128p pd=1.5u as=0.2128p ps=1.5u w=1.12u l=0.13u
X317 VGND.t45 sg13cmos5l_inv_16_15.A sg13cmos5l_inv_16_13.Y VGND.t512 sg13_lv_nmos ad=0.1406p pd=1.12u as=0.1406p ps=1.12u w=0.74u l=0.13u
X318 sg13cmos5l_inv_16_65.Y sg13cmos5l_inv_16_67.A VGND.t1580 VGND.t1588 sg13_lv_nmos ad=0.1406p pd=1.12u as=0.1406p ps=1.12u w=0.74u l=0.13u
X319 sg13cmos5l_inv_16_66.Y sg13cmos5l_inv_16_68.A VGND.t866 VGND.t879 sg13_lv_nmos ad=0.1406p pd=1.12u as=0.1406p ps=1.12u w=0.74u l=0.13u
X320 VPWR.t1482 sg13cmos5l_inv_16_84.A sg13cmos5l_inv_16_85.Y VPWR.t9 sg13_lv_pmos ad=0.2128p pd=1.5u as=0.2128p ps=1.5u w=1.12u l=0.13u
X321 sg13cmos5l_inv_16_56.Y sg13cmos5l_inv_8_4.Y VGND.t1663 VGND.t380 sg13_lv_nmos ad=0.1406p pd=1.12u as=0.2516p ps=2.16u w=0.74u l=0.13u
X322 VGND.t146 sg13cmos5l_inv_16_36.A sg13cmos5l_inv_16_36.Y VGND.t159 sg13_lv_nmos ad=0.1406p pd=1.12u as=0.1406p ps=1.12u w=0.74u l=0.13u
X323 VGND.t134 sg13cmos5l_inv_16_46.A sg13cmos5l_inv_16_46.Y VGND.t1756 sg13_lv_nmos ad=0.1406p pd=1.12u as=0.1406p ps=1.12u w=0.74u l=0.13u
X324 VGND.t423 sg13cmos5l_inv_2_1.Y sg13cmos5l_inv_8_1.A VGND.t422 sg13_lv_nmos ad=0.2516p pd=2.16u as=0.1406p ps=1.12u w=0.74u l=0.13u
X325 VGND.t1507 sg13cmos5l_inv_16_94.A sg13cmos5l_inv_16_73.A VGND.t881 sg13_lv_nmos ad=0.1406p pd=1.12u as=0.1406p ps=1.12u w=0.74u l=0.13u
X326 sg13cmos5l_inv_16_100.Y sg13cmos5l_inv_16_36.A VPWR.t557 VPWR.t0 sg13_lv_pmos ad=0.2128p pd=1.5u as=0.3808p ps=2.92u w=1.12u l=0.13u
X327 sg13cmos5l_inv_16_10.Y sg13cmos5l_inv_16_9.A VGND.t723 VGND.t727 sg13_lv_nmos ad=0.1406p pd=1.12u as=0.1406p ps=1.12u w=0.74u l=0.13u
X328 sg13cmos5l_inv_16_27.Y sg13cmos5l_inv_16_27.A VGND.t425 VGND.t1614 sg13_lv_nmos ad=0.1406p pd=1.12u as=0.1406p ps=1.12u w=0.74u l=0.13u
X329 sg13cmos5l_inv_16_52.Y sg13cmos5l_inv_16_56.Y VPWR.t2052 VPWR.t16 sg13_lv_pmos ad=0.2128p pd=1.5u as=0.2128p ps=1.5u w=1.12u l=0.13u
X330 sg13cmos5l_inv_8_4.Y sg13cmos5l_inv_4_5.Y VGND.t5 VGND.t1064 sg13_lv_nmos ad=0.1443p pd=1.13u as=0.1406p ps=1.12u w=0.74u l=0.13u
X331 sg13cmos5l_inv_16_71.Y sg13cmos5l_inv_16_56.Y VGND.t963 VGND.t881 sg13_lv_nmos ad=0.1406p pd=1.12u as=0.1406p ps=1.12u w=0.74u l=0.13u
X332 sg13cmos5l_inv_16_20.A sg13cmos5l_inv_16_8.Y VGND.t545 VGND.t550 sg13_lv_nmos ad=0.1406p pd=1.12u as=0.1406p ps=1.12u w=0.74u l=0.13u
X333 sg13cmos5l_inv_16_6.A sg13cmos5l_inv_16_4.Y VGND.t310 VGND.t311 sg13_lv_nmos ad=0.1406p pd=1.12u as=0.1406p ps=1.12u w=0.74u l=0.13u
X334 sg13cmos5l_inv_16_87.Y sg13cmos5l_inv_16_87.A VGND.t1010 VGND.t881 sg13_lv_nmos ad=0.1406p pd=1.12u as=0.1406p ps=1.12u w=0.74u l=0.13u
X335 sg13cmos5l_inv_16_75.A sg13cmos5l_inv_16_76.A VPWR.t2400 VPWR.t25 sg13_lv_pmos ad=0.2128p pd=1.5u as=0.2128p ps=1.5u w=1.12u l=0.13u
X336 VGND.t2144 VPWR.t329 VGND.t1419 VGND.t2143 sg13_lv_nmos ad=0.1428p pd=1.52u as=0 ps=0 w=0.42u l=1u
X337 VPWR.t178 sg13cmos5l_inv_16_26.Y sg13cmos5l_inv_16_40.Y VPWR.t177 sg13_lv_pmos ad=0.2128p pd=1.5u as=0.2128p ps=1.5u w=1.12u l=0.13u
X338 sg13cmos5l_inv_16_13.Y sg13cmos5l_inv_16_15.A VGND.t45 VGND.t509 sg13_lv_nmos ad=0.1406p pd=1.12u as=0.1406p ps=1.12u w=0.74u l=0.13u
X339 VGND.t866 sg13cmos5l_inv_16_68.A sg13cmos5l_inv_16_66.Y VGND.t876 sg13_lv_nmos ad=0.1406p pd=1.12u as=0.1406p ps=1.12u w=0.74u l=0.13u
X340 sg13cmos5l_inv_16_109.Y sg13cmos5l_inv_16_48.A VPWR.t2082 VPWR.t16 sg13_lv_pmos ad=0.2128p pd=1.5u as=0.2128p ps=1.5u w=1.12u l=0.13u
X341 sg13cmos5l_inv_8_1.A sg13cmos5l_inv_2_1.Y VGND.t310 VGND.t419 sg13_lv_nmos ad=0.1406p pd=1.12u as=0.2516p ps=2.16u w=0.74u l=0.13u
X342 sg13cmos5l_inv_16_73.A sg13cmos5l_inv_16_94.A VGND.t1507 VGND.t881 sg13_lv_nmos ad=0.1406p pd=1.12u as=0.1406p ps=1.12u w=0.74u l=0.13u
X343 VPWR.t1426 sg13cmos5l_inv_16_87.A sg13cmos5l_inv_16_87.Y VPWR.t9 sg13_lv_pmos ad=0.2128p pd=1.5u as=0.2128p ps=1.5u w=1.12u l=0.13u
X344 sg13cmos5l_inv_16_67.Y sg13cmos5l_inv_16_67.A VPWR.t1982 VPWR.t16 sg13_lv_pmos ad=0.2128p pd=1.5u as=0.2128p ps=1.5u w=1.12u l=0.13u
X345 sg13cmos5l_inv_16_55.Y sg13cmos5l_inv_16_101.Y VGND.t427 VGND.t380 sg13_lv_nmos ad=0.1406p pd=1.12u as=0.1406p ps=1.12u w=0.74u l=0.13u
X346 VGND.t5 sg13cmos5l_inv_4_5.Y sg13cmos5l_inv_8_4.Y VGND.t1061 sg13_lv_nmos ad=0.1406p pd=1.12u as=0.1406p ps=1.12u w=0.74u l=0.13u
X347 sg13cmos5l_inv_16_34.Y sg13cmos5l_inv_16_41.A VPWR.t668 VPWR.t0 sg13_lv_pmos ad=0.2128p pd=1.5u as=0.2128p ps=1.5u w=1.12u l=0.13u
X348 VGND.t84 sg13cmos5l_inv_8_1.A sg13cmos5l_inv_8_1.Y VGND.t1424 sg13_lv_nmos ad=0.1406p pd=1.12u as=0.1406p ps=1.12u w=0.74u l=0.13u
X349 sg13cmos5l_inv_16_5.Y sg13cmos5l_inv_16_6.A VPWR.t246 VPWR.t177 sg13_lv_pmos ad=0.2128p pd=1.5u as=0.2128p ps=1.5u w=1.12u l=0.13u
X350 VPWR.t2050 sg13cmos5l_inv_16_56.Y sg13cmos5l_inv_16_52.Y VPWR.t16 sg13_lv_pmos ad=0.2128p pd=1.5u as=0.2128p ps=1.5u w=1.12u l=0.13u
X351 sg13cmos5l_inv_16_19.Y sg13cmos5l_inv_16_17.A VPWR.t531 VPWR.t177 sg13_lv_pmos ad=0.2128p pd=1.5u as=0.2128p ps=1.5u w=1.12u l=0.13u
X352 VPWR.t844 sg13cmos5l_inv_16_6.Y sg13cmos5l_inv_16_25.Y VPWR.t177 sg13_lv_pmos ad=0.2128p pd=1.5u as=0.2128p ps=1.5u w=1.12u l=0.13u
X353 VGND.t291 sg13cmos5l_inv_16_4.Y sg13cmos5l_inv_16_8.Y VGND.t296 sg13_lv_nmos ad=0.1406p pd=1.12u as=0.1406p ps=1.12u w=0.74u l=0.13u
X354 VGND.t545 sg13cmos5l_inv_16_8.Y sg13cmos5l_inv_16_20.A VGND.t547 sg13_lv_nmos ad=0.1406p pd=1.12u as=0.1406p ps=1.12u w=0.74u l=0.13u
X355 sg13cmos5l_inv_16_14.A sg13cmos5l_inv_16_23.Y VGND.t50 VGND.t49 sg13_lv_nmos ad=0.1406p pd=1.12u as=0.1406p ps=1.12u w=0.74u l=0.13u
X356 VPWR.t1410 sg13cmos5l_inv_16_87.A sg13cmos5l_inv_16_93.Y VPWR.t9 sg13_lv_pmos ad=0.2128p pd=1.5u as=0.2128p ps=1.5u w=1.12u l=0.13u
X357 sg13cmos5l_inv_16_26.Y sg13cmos5l_inv_16_26.A VGND.t1334 VGND.t1337 sg13_lv_nmos ad=0.1406p pd=1.12u as=0.1406p ps=1.12u w=0.74u l=0.13u
X358 sg13cmos5l_inv_16_53.A sg13cmos5l_inv_16_52.Y VPWR.t1764 VPWR.t16 sg13_lv_pmos ad=0.2128p pd=1.5u as=0.2128p ps=1.5u w=1.12u l=0.13u
X359 VPWR.t2398 sg13cmos5l_inv_16_76.A sg13cmos5l_inv_16_75.A VPWR.t25 sg13_lv_pmos ad=0.2128p pd=1.5u as=0.2128p ps=1.5u w=1.12u l=0.13u
X360 VGND.t450 sg13cmos5l_inv_16_15.A sg13cmos5l_inv_16_13.Y VGND.t506 sg13_lv_nmos ad=0.1406p pd=1.12u as=0.1406p ps=1.12u w=0.74u l=0.13u
X361 sg13cmos5l_and2_1_3.X a_5133_916# VPWR.t480 VPWR.t177 sg13_lv_pmos ad=0.3808p pd=2.92u as=0.1918p ps=1.5u w=1.12u l=0.13u
X362 sg13cmos5l_inv_16_66.Y sg13cmos5l_inv_16_68.A VGND.t866 VGND.t873 sg13_lv_nmos ad=0.1406p pd=1.12u as=0.1406p ps=1.12u w=0.74u l=0.13u
X363 VGND.t353 VPWR.t2518 VGND.t353 VGND.t2007 sg13_lv_nmos ad=0.1428p pd=1.52u as=0 ps=0 w=0.42u l=1u
X364 sg13cmos5l_inv_16_27.A sg13cmos5l_inv_8_2.A VGND.t575 VGND.t579 sg13_lv_nmos ad=0.1406p pd=1.12u as=0.1406p ps=1.12u w=0.74u l=0.13u
X365 sg13cmos5l_inv_16_6.Y sg13cmos5l_inv_16_6.A VGND.t1411 VGND.t1414 sg13_lv_nmos ad=0.1406p pd=1.12u as=0.1406p ps=1.12u w=0.74u l=0.13u
X366 VPWR.t1832 sg13cmos5l_inv_16_2.A sg13cmos5l_inv_16_2.Y VPWR.t177 sg13_lv_pmos ad=0.2128p pd=1.5u as=0.2128p ps=1.5u w=1.12u l=0.13u
X367 VGND.t45 sg13cmos5l_inv_16_23.Y sg13cmos5l_inv_16_15.A VGND.t64 sg13_lv_nmos ad=0.2516p pd=2.16u as=0.1406p ps=1.12u w=0.74u l=0.13u
X368 VGND.t122 VPWR.t2513 VGND.t122 VGND.t2037 sg13_lv_nmos ad=0.1428p pd=1.52u as=0 ps=0 w=0.42u l=1u
X369 VGND.t1507 sg13cmos5l_inv_16_94.A sg13cmos5l_inv_16_73.A VGND.t881 sg13_lv_nmos ad=0.1406p pd=1.12u as=0.1406p ps=1.12u w=0.74u l=0.13u
X370 VGND.t1026 sg13cmos5l_inv_16_81.Y sg13cmos5l_inv_16_79.A VGND.t881 sg13_lv_nmos ad=0.1406p pd=1.12u as=0.1406p ps=1.12u w=0.74u l=0.13u
X371 VGND.t1792 sg13cmos5l_inv_16_96.Y sg13cmos5l_inv_16_81.Y VGND.t380 sg13_lv_nmos ad=0.1406p pd=1.12u as=0.1406p ps=1.12u w=0.74u l=0.13u
X372 sg13cmos5l_inv_16_74.Y sg13cmos5l_inv_16_75.A VPWR.t806 VPWR.t25 sg13_lv_pmos ad=0.2128p pd=1.5u as=0.2128p ps=1.5u w=1.12u l=0.13u
X373 sg13cmos5l_inv_16_110.Y sg13cmos5l_inv_16_5.Y VPWR.t1066 VPWR.t4 sg13_lv_pmos ad=0.2128p pd=1.5u as=0.2128p ps=1.5u w=1.12u l=0.13u
X374 sg13cmos5l_inv_16_87.Y sg13cmos5l_inv_16_87.A VPWR.t1422 VPWR.t9 sg13_lv_pmos ad=0.2128p pd=1.5u as=0.2128p ps=1.5u w=1.12u l=0.13u
X375 VPWR.t1980 sg13cmos5l_inv_16_67.A sg13cmos5l_inv_16_67.Y VPWR.t16 sg13_lv_pmos ad=0.2128p pd=1.5u as=0.2128p ps=1.5u w=1.12u l=0.13u
X376 sg13cmos5l_inv_8_4.Y sg13cmos5l_inv_4_5.Y VGND.t5 VGND.t1058 sg13_lv_nmos ad=0.1406p pd=1.12u as=0.2516p ps=2.16u w=0.74u l=0.13u
X377 VPWR.t246 sg13cmos5l_inv_16_6.A sg13cmos5l_inv_16_5.Y VPWR.t177 sg13_lv_pmos ad=0.2128p pd=1.5u as=0.2128p ps=1.5u w=1.12u l=0.13u
X378 VPWR.t1300 sg13cmos5l_inv_16_68.A sg13cmos5l_inv_16_68.Y VPWR.t16 sg13_lv_pmos ad=0.2128p pd=1.5u as=0.2128p ps=1.5u w=1.12u l=0.13u
X379 VPWR.t529 sg13cmos5l_inv_16_17.A sg13cmos5l_inv_16_19.Y VPWR.t177 sg13_lv_pmos ad=0.2128p pd=1.5u as=0.2128p ps=1.5u w=1.12u l=0.13u
X380 VPWR.t2425 VGND.t1178 VPWR.t2423 VPWR.t9 sg13_lv_pmos ad=0.19p pd=1.38u as=0 ps=0 w=1u l=1u
X381 sg13cmos5l_inv_16_10.Y sg13cmos5l_inv_16_9.A VGND.t723 VGND.t722 sg13_lv_nmos ad=0.1406p pd=1.12u as=0.2516p ps=2.16u w=0.74u l=0.13u
X382 VPWR.t1266 sg13cmos5l_inv_16_0.A sg13cmos5l_inv_16_1.A VPWR.t177 sg13_lv_pmos ad=0.2128p pd=1.5u as=0.2128p ps=1.5u w=1.12u l=0.13u
X383 sg13cmos5l_inv_16_4.Y sg13cmos5l_inv_8_1.Y VGND.t310 VGND.t1457 sg13_lv_nmos ad=0.1406p pd=1.12u as=0.1406p ps=1.12u w=0.74u l=0.13u
X384 sg13cmos5l_inv_16_62.Y sg13cmos5l_inv_16_69.Y VGND.t921 VGND.t881 sg13_lv_nmos ad=0.1406p pd=1.12u as=0.2516p ps=2.16u w=0.74u l=0.13u
X385 VGND.t862 sg13cmos5l_inv_16_6.A sg13cmos5l_inv_16_6.Y VGND.t1408 sg13_lv_nmos ad=0.1406p pd=1.12u as=0.1406p ps=1.12u w=0.74u l=0.13u
X386 sg13cmos5l_inv_16_73.A sg13cmos5l_inv_16_94.A VPWR.t1902 VPWR.t9 sg13_lv_pmos ad=0.2128p pd=1.5u as=0.2128p ps=1.5u w=1.12u l=0.13u
X387 VPWR.t1762 sg13cmos5l_inv_16_52.Y sg13cmos5l_inv_16_53.A VPWR.t16 sg13_lv_pmos ad=0.2128p pd=1.5u as=0.2128p ps=1.5u w=1.12u l=0.13u
X388 sg13cmos5l_inv_16_9.A sg13cmos5l_inv_16_8.Y VGND.t291 VGND.t568 sg13_lv_nmos ad=0.1406p pd=1.12u as=0.1406p ps=1.12u w=0.74u l=0.13u
X389 VPWR.t582 sg13cmos5l_inv_16_36.A sg13cmos5l_inv_16_36.Y VPWR.t4 sg13_lv_pmos ad=0.2128p pd=1.5u as=0.2128p ps=1.5u w=1.12u l=0.13u
X390 VPWR.t479 sg13cmos5l_inv_16_37.A sg13cmos5l_inv_16_37.Y VPWR.t4 sg13_lv_pmos ad=0.4368p pd=3.02u as=0.2128p ps=1.5u w=1.12u l=0.13u
X391 VPWR.t2072 sg13cmos5l_inv_16_53.A sg13cmos5l_inv_16_53.Y VPWR.t16 sg13_lv_pmos ad=0.2128p pd=1.5u as=0.2128p ps=1.5u w=1.12u l=0.13u
X392 sg13cmos5l_and2_1_6.X a_26445_9540# VPWR.t1601 VPWR.t9 sg13_lv_pmos ad=0.3808p pd=2.92u as=0.1918p ps=1.5u w=1.12u l=0.13u
X393 VGND.t1680 VPWR.t2569 VGND.t1680 VGND.t380 sg13_lv_nmos ad=0.1428p pd=1.52u as=0 ps=0 w=0.42u l=1u
X394 VGND.t259 sg13cmos5l_inv_16_28.A sg13cmos5l_inv_16_44.A VGND.t273 sg13_lv_nmos ad=0.2516p pd=2.16u as=0.1406p ps=1.12u w=0.74u l=0.13u
X395 VGND.t609 sg13cmos5l_inv_16_34.Y sg13cmos5l_inv_16_99.A VGND.t608 sg13_lv_nmos ad=0.2516p pd=2.16u as=0.1406p ps=1.12u w=0.74u l=0.13u
X396 sg13cmos5l_inv_16_2.Y sg13cmos5l_inv_16_2.A VPWR.t1828 VPWR.t177 sg13_lv_pmos ad=0.2128p pd=1.5u as=0.2128p ps=1.5u w=1.12u l=0.13u
X397 VPWR.t1748 sg13cmos5l_inv_16_52.Y sg13cmos5l_inv_16_69.Y VPWR.t16 sg13_lv_pmos ad=0.2128p pd=1.5u as=0.2128p ps=1.5u w=1.12u l=0.13u
X398 VPWR.t804 sg13cmos5l_inv_16_75.A sg13cmos5l_inv_16_74.Y VPWR.t25 sg13_lv_pmos ad=0.2128p pd=1.5u as=0.2128p ps=1.5u w=1.12u l=0.13u
X399 sg13cmos5l_inv_16_14.Y sg13cmos5l_inv_16_14.A VGND.t45 VGND.t489 sg13_lv_nmos ad=0.1406p pd=1.12u as=0.1406p ps=1.12u w=0.74u l=0.13u
X400 VPWR.t1420 sg13cmos5l_inv_16_87.A sg13cmos5l_inv_16_87.Y VPWR.t9 sg13_lv_pmos ad=0.2128p pd=1.5u as=0.2128p ps=1.5u w=1.12u l=0.13u
X401 sg13cmos5l_inv_16_95.Y sg13cmos5l_inv_16_73.Y VGND.t1010 VGND.t881 sg13_lv_nmos ad=0.1406p pd=1.12u as=0.1406p ps=1.12u w=0.74u l=0.13u
X402 VGND.t84 sg13cmos5l_inv_8_1.A sg13cmos5l_inv_8_1.Y VGND.t1430 sg13_lv_nmos ad=0.2516p pd=2.16u as=0.1443p ps=1.13u w=0.74u l=0.13u
X403 sg13cmos5l_inv_16_19.Y sg13cmos5l_inv_16_17.A VPWR.t525 VPWR.t177 sg13_lv_pmos ad=0.2128p pd=1.5u as=0.2128p ps=1.5u w=1.12u l=0.13u
X404 sg13cmos5l_inv_16_1.A sg13cmos5l_inv_16_0.A VPWR.t1262 VPWR.t177 sg13_lv_pmos ad=0.2128p pd=1.5u as=0.2128p ps=1.5u w=1.12u l=0.13u
X405 VGND.t310 sg13cmos5l_inv_8_1.Y sg13cmos5l_inv_16_4.Y VGND.t1454 sg13_lv_nmos ad=0.1406p pd=1.12u as=0.1406p ps=1.12u w=0.74u l=0.13u
X406 sg13cmos5l_inv_16_44.Y sg13cmos5l_inv_16_44.A VPWR.t635 VPWR.t4 sg13_lv_pmos ad=0.2128p pd=1.5u as=0.2128p ps=1.5u w=1.12u l=0.13u
X407 VPWR.t1900 sg13cmos5l_inv_16_94.A sg13cmos5l_inv_16_73.A VPWR.t9 sg13_lv_pmos ad=0.2128p pd=1.5u as=0.2128p ps=1.5u w=1.12u l=0.13u
X408 VGND.t1147 sg13cmos5l_inv_16_48.A sg13cmos5l_inv_16_109.Y VGND.t881 sg13_lv_nmos ad=0.2516p pd=2.16u as=0.1406p ps=1.12u w=0.74u l=0.13u
X409 sg13cmos5l_inv_16_37.Y sg13cmos5l_inv_16_37.A VPWR.t475 VPWR.t4 sg13_lv_pmos ad=0.2128p pd=1.5u as=0.2128p ps=1.5u w=1.12u l=0.13u
X410 VGND.t291 VPWR.t2488 VGND.t291 VGND.t2081 sg13_lv_nmos ad=0.1428p pd=1.52u as=0 ps=0 w=0.42u l=1u
X411 sg13cmos5l_inv_16_11.A sg13cmos5l_inv_16_96.Y VPWR.t2246 VPWR.t25 sg13_lv_pmos ad=0.2128p pd=1.5u as=0.2128p ps=1.5u w=1.12u l=0.13u
X412 sg13cmos5l_inv_8_4.Y sg13cmos5l_inv_4_5.Y VPWR.t1466 VPWR.t25 sg13_lv_pmos ad=0.2128p pd=1.5u as=0.2128p ps=1.5u w=1.12u l=0.13u
X413 sg13cmos5l_inv_16_69.Y sg13cmos5l_inv_16_52.Y VPWR.t1744 VPWR.t16 sg13_lv_pmos ad=0.2128p pd=1.5u as=0.2128p ps=1.5u w=1.12u l=0.13u
X414 sg13cmos5l_inv_16_77.A sg13cmos5l_inv_16_76.A VPWR.t2385 VPWR.t16 sg13_lv_pmos ad=0.2128p pd=1.5u as=0.2128p ps=1.5u w=1.12u l=0.13u
X415 VGND.t20 sg13cmos5l_inv_16_46.A sg13cmos5l_inv_16_46.Y VGND.t1752 sg13_lv_nmos ad=0.1406p pd=1.12u as=0.1406p ps=1.12u w=0.74u l=0.13u
X416 sg13cmos5l_inv_16_26.A sg13cmos5l_inv_16_27.Y VGND.t1245 VGND.t1275 sg13_lv_nmos ad=0.1406p pd=1.12u as=0.1406p ps=1.12u w=0.74u l=0.13u
X417 sg13cmos5l_inv_16_71.Y sg13cmos5l_inv_16_56.Y VGND.t963 VGND.t881 sg13_lv_nmos ad=0.1406p pd=1.12u as=0.1406p ps=1.12u w=0.74u l=0.13u
X418 sg13cmos5l_inv_16_98.Y sg13cmos5l_inv_16_111.A VGND.t1553 VGND.t1556 sg13_lv_nmos ad=0.1406p pd=1.12u as=0.1406p ps=1.12u w=0.74u l=0.13u
X419 VPWR.t707 sg13cmos5l_inv_16_28.A sg13cmos5l_inv_16_29.A VPWR.t177 sg13_lv_pmos ad=0.2128p pd=1.5u as=0.2128p ps=1.5u w=1.12u l=0.13u
X420 VGND.t45 sg13cmos5l_inv_16_15.A sg13cmos5l_inv_16_15.Y VGND.t512 sg13_lv_nmos ad=0.1406p pd=1.12u as=0.1406p ps=1.12u w=0.74u l=0.13u
X421 VGND.t1143 VPWR.t2577 VGND.t1143 VGND.t881 sg13_lv_nmos ad=79.8f pd=0.8u as=0 ps=0 w=0.42u l=1u
X422 VGND.t1026 sg13cmos5l_inv_16_84.A sg13cmos5l_inv_16_84.Y VGND.t881 sg13_lv_nmos ad=0.1406p pd=1.12u as=0.1406p ps=1.12u w=0.74u l=0.13u
X423 sg13cmos5l_inv_16_27.Y sg13cmos5l_inv_16_27.A VPWR.t844 VPWR.t177 sg13_lv_pmos ad=0.2128p pd=1.5u as=0.3808p ps=2.92u w=1.12u l=0.13u
X424 VGND.t326 sg13cmos5l_inv_16_26.Y sg13cmos5l_inv_16_40.Y VGND.t339 sg13_lv_nmos ad=0.1406p pd=1.12u as=0.1406p ps=1.12u w=0.74u l=0.13u
X425 VPWR.t365 VGND.t255 VPWR.t411 VPWR.t4 sg13_lv_pmos ad=0.19p pd=1.38u as=0 ps=0 w=1u l=1u
X426 VPWR.t633 sg13cmos5l_inv_16_44.A sg13cmos5l_inv_16_44.Y VPWR.t4 sg13_lv_pmos ad=0.2128p pd=1.5u as=0.2128p ps=1.5u w=1.12u l=0.13u
X427 VPWR.t486 VGND.t2151 VPWR.t329 VPWR.t177 sg13_lv_pmos ad=0.19p pd=1.38u as=0 ps=0 w=1u l=1u
X428 VPWR.t2244 sg13cmos5l_inv_16_96.Y sg13cmos5l_inv_16_11.A VPWR.t25 sg13_lv_pmos ad=0.2128p pd=1.5u as=0.2128p ps=1.5u w=1.12u l=0.13u
X429 VGND.t345 sg13cmos5l_inv_16_105.A sg13cmos5l_inv_16_80.Y VGND.t1113 sg13_lv_nmos ad=0.1406p pd=1.12u as=0.1406p ps=1.12u w=0.74u l=0.13u
X430 sg13cmos5l_inv_16_9.Y sg13cmos5l_inv_16_9.A VGND.t723 VGND.t727 sg13_lv_nmos ad=0.1406p pd=1.12u as=0.1406p ps=1.12u w=0.74u l=0.13u
X431 sg13cmos5l_inv_16_67.Y sg13cmos5l_inv_16_67.A VGND.t1143 VGND.t881 sg13_lv_nmos ad=0.1406p pd=1.12u as=0.1406p ps=1.12u w=0.74u l=0.13u
X432 VPWR.t2383 sg13cmos5l_inv_16_76.A sg13cmos5l_inv_16_77.A VPWR.t16 sg13_lv_pmos ad=0.2128p pd=1.5u as=0.2128p ps=1.5u w=1.12u l=0.13u
X433 VGND.t134 sg13cmos5l_inv_16_36.A sg13cmos5l_inv_16_100.Y VGND.t133 sg13_lv_nmos ad=0.1406p pd=1.12u as=0.1406p ps=1.12u w=0.74u l=0.13u
X434 VGND.t1243 sg13cmos5l_inv_16_27.Y sg13cmos5l_inv_16_26.A VGND.t1272 sg13_lv_nmos ad=0.1406p pd=1.12u as=0.1406p ps=1.12u w=0.74u l=0.13u
X435 VPWR.t1962 sg13cmos5l_inv_16_67.A sg13cmos5l_inv_16_65.Y VPWR.t9 sg13_lv_pmos ad=0.2128p pd=1.5u as=0.2128p ps=1.5u w=1.12u l=0.13u
X436 VPWR.t1328 sg13cmos5l_inv_16_69.Y sg13cmos5l_inv_16_62.Y VPWR.t9 sg13_lv_pmos ad=0.2128p pd=1.5u as=0.2128p ps=1.5u w=1.12u l=0.13u
X437 VPWR.t2231 sg13cmos5l_inv_16_96.Y sg13cmos5l_inv_16_81.Y VPWR.t16 sg13_lv_pmos ad=0.2128p pd=1.5u as=0.2128p ps=1.5u w=1.12u l=0.13u
X438 sg13cmos5l_inv_16_101.Y sg13cmos5l_inv_16_34.Y VPWR.t1044 VPWR.t0 sg13_lv_pmos ad=0.2128p pd=1.5u as=0.2128p ps=1.5u w=1.12u l=0.13u
X439 sg13cmos5l_inv_16_37.A sg13cmos5l_inv_16_43.Y VPWR.t596 VPWR.t0 sg13_lv_pmos ad=0.2128p pd=1.5u as=0.2128p ps=1.5u w=1.12u l=0.13u
X440 VGND.t963 sg13cmos5l_inv_16_56.Y sg13cmos5l_inv_16_71.Y VGND.t881 sg13_lv_nmos ad=0.1406p pd=1.12u as=0.1406p ps=1.12u w=0.74u l=0.13u
X441 sg13cmos5l_inv_16_103.Y sg13cmos5l_inv_16_103.A VGND.t345 VGND.t344 sg13_lv_nmos ad=0.1406p pd=1.12u as=0.2516p ps=2.16u w=0.74u l=0.13u
X442 VGND.t1143 sg13cmos5l_inv_16_109.Y sg13cmos5l_inv_16_67.A VGND.t881 sg13_lv_nmos ad=0.1406p pd=1.12u as=0.1406p ps=1.12u w=0.74u l=0.13u
X443 VGND.t1970 VPWR.t2540 VGND.t1970 VGND.t380 sg13_lv_nmos ad=79.8f pd=0.8u as=0 ps=0 w=0.42u l=1u
X444 sg13cmos5l_inv_16_15.Y sg13cmos5l_inv_16_15.A VGND.t45 VGND.t509 sg13_lv_nmos ad=0.1406p pd=1.12u as=0.1406p ps=1.12u w=0.74u l=0.13u
X445 VGND.t905 sg13cmos5l_inv_16_69.Y sg13cmos5l_inv_16_58.Y VGND.t911 sg13_lv_nmos ad=0.1406p pd=1.12u as=0.1406p ps=1.12u w=0.74u l=0.13u
X446 VPWR.t2394 sg13cmos5l_inv_16_76.A sg13cmos5l_inv_16_75.A VPWR.t25 sg13_lv_pmos ad=0.2128p pd=1.5u as=0.2128p ps=1.5u w=1.12u l=0.13u
X447 VPWR.t178 VGND.t2135 VPWR.t178 VPWR.t177 sg13_lv_pmos ad=0.34p pd=2.68u as=0 ps=0 w=1u l=1u
X448 VGND.t575 sg13cmos5l_inv_8_2.A sg13cmos5l_inv_16_27.A VGND.t580 sg13_lv_nmos ad=0.1406p pd=1.12u as=0.1406p ps=1.12u w=0.74u l=0.13u
X449 VPWR.t41 VGND.t1029 VPWR.t62 VPWR.t9 sg13_lv_pmos ad=0.34p pd=2.68u as=0 ps=0 w=1u l=1u
X450 sg13cmos5l_inv_16_0.A sg13cmos5l_inv_8_0.Y VGND.t827 VGND.t2319 sg13_lv_nmos ad=0.1406p pd=1.12u as=0.1406p ps=1.12u w=0.74u l=0.13u
X451 VPWR.t1254 sg13cmos5l_inv_16_0.A sg13cmos5l_inv_16_23.Y VPWR.t4 sg13_lv_pmos ad=0.2128p pd=1.5u as=0.2128p ps=1.5u w=1.12u l=0.13u
X452 VPWR.t723 sg13cmos5l_inv_16_4.Y sg13cmos5l_inv_16_8.Y VPWR.t4 sg13_lv_pmos ad=0.2128p pd=1.5u as=0.2128p ps=1.5u w=1.12u l=0.13u
X453 sg13cmos5l_inv_16_80.Y sg13cmos5l_inv_16_105.A VGND.t345 VGND.t1110 sg13_lv_nmos ad=0.1406p pd=1.12u as=0.1406p ps=1.12u w=0.74u l=0.13u
X454 sg13cmos5l_inv_16_11.A sg13cmos5l_inv_16_96.Y VPWR.t2240 VPWR.t25 sg13_lv_pmos ad=0.2128p pd=1.5u as=0.2128p ps=1.5u w=1.12u l=0.13u
X455 VGND.t1236 sg13cmos5l_inv_16_30.A sg13cmos5l_inv_16_31.Y VGND.t1282 sg13_lv_nmos ad=0.1406p pd=1.12u as=0.1406p ps=1.12u w=0.74u l=0.13u
X456 sg13cmos5l_inv_16_102.Y sg13cmos5l_inv_16_37.A VGND.t15 VGND.t16 sg13_lv_nmos ad=0.1406p pd=1.12u as=0.1406p ps=1.12u w=0.74u l=0.13u
X457 sg13cmos5l_inv_16_100.Y sg13cmos5l_inv_16_36.A VGND.t20 VGND.t130 sg13_lv_nmos ad=0.1406p pd=1.12u as=0.1406p ps=1.12u w=0.74u l=0.13u
X458 VPWR.t594 sg13cmos5l_inv_16_43.Y sg13cmos5l_inv_16_37.A VPWR.t0 sg13_lv_pmos ad=0.2128p pd=1.5u as=0.2128p ps=1.5u w=1.12u l=0.13u
X459 sg13cmos5l_inv_16_27.A sg13cmos5l_inv_8_2.A VGND.t575 VGND.t574 sg13_lv_nmos ad=0.1406p pd=1.12u as=0.2516p ps=2.16u w=0.74u l=0.13u
X460 sg13cmos5l_inv_16_66.Y sg13cmos5l_inv_16_68.A VPWR.t1278 VPWR.t9 sg13_lv_pmos ad=0.2128p pd=1.5u as=0.2128p ps=1.5u w=1.12u l=0.13u
X461 VGND.t450 sg13cmos5l_inv_16_15.A sg13cmos5l_inv_16_15.Y VGND.t506 sg13_lv_nmos ad=0.1406p pd=1.12u as=0.1406p ps=1.12u w=0.74u l=0.13u
X462 VGND.t898 VPWR.t2570 VGND.t898 VGND.t881 sg13_lv_nmos ad=0.1428p pd=1.52u as=0 ps=0 w=0.42u l=1u
X463 sg13cmos5l_inv_16_58.Y sg13cmos5l_inv_16_69.Y VGND.t905 VGND.t908 sg13_lv_nmos ad=0.1406p pd=1.12u as=0.1406p ps=1.12u w=0.74u l=0.13u
X464 sg13cmos5l_inv_16_46.Y sg13cmos5l_inv_16_46.A VPWR.t2132 VPWR.t25 sg13_lv_pmos ad=0.2128p pd=1.5u as=0.2128p ps=1.5u w=1.12u l=0.13u
X465 VPWR.t578 sg13cmos5l_inv_16_36.A sg13cmos5l_inv_16_36.Y VPWR.t4 sg13_lv_pmos ad=0.2128p pd=1.5u as=0.2128p ps=1.5u w=1.12u l=0.13u
X466 VGND.t963 sg13cmos5l_inv_16_71.Y sg13cmos5l_inv_16_61.A VGND.t881 sg13_lv_nmos ad=0.1406p pd=1.12u as=0.1406p ps=1.12u w=0.74u l=0.13u
X467 VPWR.t1881 sg13cmos5l_inv_16_73.A sg13cmos5l_inv_16_73.Y VPWR.t16 sg13_lv_pmos ad=0.2128p pd=1.5u as=0.2128p ps=1.5u w=1.12u l=0.13u
X468 sg13cmos5l_inv_16_23.Y sg13cmos5l_inv_16_0.A VPWR.t1250 VPWR.t4 sg13_lv_pmos ad=0.2128p pd=1.5u as=0.2128p ps=1.5u w=1.12u l=0.13u
X469 VGND.t1026 sg13cmos5l_inv_16_84.A sg13cmos5l_inv_16_84.Y VGND.t881 sg13_lv_nmos ad=0.1406p pd=1.12u as=0.1406p ps=1.12u w=0.74u l=0.13u
X470 VGND.t593 sg13cmos5l_inv_16_34.Y sg13cmos5l_inv_16_99.A VGND.t604 sg13_lv_nmos ad=0.1406p pd=1.12u as=0.1406p ps=1.12u w=0.74u l=0.13u
X471 sg13cmos5l_inv_16_99.Y sg13cmos5l_inv_16_99.A VGND.t773 VGND.t784 sg13_lv_nmos ad=0.1406p pd=1.12u as=0.1406p ps=1.12u w=0.74u l=0.13u
X472 sg13cmos5l_inv_16_2.Y sg13cmos5l_inv_16_2.A VPWR.t1824 VPWR.t177 sg13_lv_pmos ad=0.2128p pd=1.5u as=0.2128p ps=1.5u w=1.12u l=0.13u
X473 VPWR.t1552 sg13cmos5l_inv_16_109.Y sg13cmos5l_inv_16_67.A VPWR.t9 sg13_lv_pmos ad=0.4368p pd=3.02u as=0.2128p ps=1.5u w=1.12u l=0.13u
X474 VPWR.t70 VGND.t1944 VPWR.t69 VPWR.t16 sg13_lv_pmos ad=0.19p pd=1.38u as=0 ps=0 w=1u l=1u
X475 VGND.t122 VPWR.t2512 VGND.t122 VGND.t2039 sg13_lv_nmos ad=0.1428p pd=1.52u as=0 ps=0 w=0.42u l=1u
X476 VGND.t2045 VPWR.t2509 VGND.t217 VGND.t2046 sg13_lv_nmos ad=79.8f pd=0.8u as=0 ps=0 w=0.42u l=1u
X477 sg13cmos5l_inv_16_31.Y sg13cmos5l_inv_16_30.A VGND.t39 VGND.t1279 sg13_lv_nmos ad=0.1406p pd=1.12u as=0.2516p ps=2.16u w=0.74u l=0.13u
X478 sg13cmos5l_inv_16_9.Y sg13cmos5l_inv_16_9.A VGND.t723 VGND.t722 sg13_lv_nmos ad=0.1406p pd=1.12u as=0.2516p ps=2.16u w=0.74u l=0.13u
X479 sg13cmos5l_inv_16_84.Y sg13cmos5l_inv_16_84.A VPWR.t1494 VPWR.t9 sg13_lv_pmos ad=0.2128p pd=1.5u as=0.2128p ps=1.5u w=1.12u l=0.13u
X480 sg13cmos5l_inv_16_26.Y sg13cmos5l_inv_16_26.A VGND.t1334 VGND.t1343 sg13_lv_nmos ad=0.1406p pd=1.12u as=0.1406p ps=1.12u w=0.74u l=0.13u
X481 sg13cmos5l_inv_16_19.Y sg13cmos5l_inv_16_17.A VGND.t101 VGND.t102 sg13_lv_nmos ad=0.1406p pd=1.12u as=0.1406p ps=1.12u w=0.74u l=0.13u
X482 sg13cmos5l_inv_16_41.A sg13cmos5l_inv_8_3.Y VPWR.t1238 VPWR.t4 sg13_lv_pmos ad=0.2128p pd=1.5u as=0.2128p ps=1.5u w=1.12u l=0.13u
X483 sg13cmos5l_inv_16_80.Y sg13cmos5l_inv_16_105.A VPWR.t1516 VPWR.t25 sg13_lv_pmos ad=0.2128p pd=1.5u as=0.2128p ps=1.5u w=1.12u l=0.13u
X484 VPWR.t1869 sg13cmos5l_inv_16_73.A sg13cmos5l_inv_16_87.A VPWR.t9 sg13_lv_pmos ad=0.4368p pd=3.02u as=0.2128p ps=1.5u w=1.12u l=0.13u
X485 VPWR.t1112 sg13cmos5l_inv_16_29.A sg13cmos5l_inv_16_35.Y VPWR.t0 sg13_lv_pmos ad=0.2128p pd=1.5u as=0.2128p ps=1.5u w=1.12u l=0.13u
X486 sg13cmos5l_inv_16_36.Y sg13cmos5l_inv_16_36.A VPWR.t574 VPWR.t4 sg13_lv_pmos ad=0.2128p pd=1.5u as=0.2128p ps=1.5u w=1.12u l=0.13u
X487 sg13cmos5l_inv_16_53.A sg13cmos5l_inv_16_52.Y VGND.t1164 VGND.t881 sg13_lv_nmos ad=0.1406p pd=1.12u as=0.1406p ps=1.12u w=0.74u l=0.13u
X488 VGND.t146 sg13cmos5l_inv_16_43.Y sg13cmos5l_inv_16_37.A VGND.t178 sg13_lv_nmos ad=0.2516p pd=2.16u as=0.1406p ps=1.12u w=0.74u l=0.13u
X489 VPWR.t306 VGND.t2156 VPWR.t305 VPWR.t177 sg13_lv_pmos ad=0.19p pd=1.38u as=0 ps=0 w=1u l=1u
X490 sg13cmos5l_inv_16_26.Y sg13cmos5l_inv_16_26.A VPWR.t767 VPWR.t177 sg13_lv_pmos ad=0.2128p pd=1.5u as=0.2128p ps=1.5u w=1.12u l=0.13u
X491 sg13cmos5l_inv_16_95.Y sg13cmos5l_inv_16_73.Y VPWR.t2215 VPWR.t16 sg13_lv_pmos ad=0.2128p pd=1.5u as=0.2128p ps=1.5u w=1.12u l=0.13u
X492 VGND.t427 VPWR.t2568 VGND.t427 VGND.t380 sg13_lv_nmos ad=0.1428p pd=1.52u as=0 ps=0 w=0.42u l=1u
X493 VPWR.t980 sg13cmos5l_inv_16_8.Y sg13cmos5l_inv_16_20.A VPWR.t0 sg13_lv_pmos ad=0.2128p pd=1.5u as=0.2128p ps=1.5u w=1.12u l=0.13u
X494 sg13cmos5l_inv_16_59.Y sg13cmos5l_inv_16_61.A VGND.t1166 VGND.t1170 sg13_lv_nmos ad=0.1406p pd=1.12u as=0.1406p ps=1.12u w=0.74u l=0.13u
X495 sg13cmos5l_inv_16_67.A sg13cmos5l_inv_16_109.Y VPWR.t1548 VPWR.t9 sg13_lv_pmos ad=0.2128p pd=1.5u as=0.2128p ps=1.5u w=1.12u l=0.13u
X496 sg13cmos5l_inv_16_69.Y sg13cmos5l_inv_16_52.Y VPWR.t1740 VPWR.t16 sg13_lv_pmos ad=0.2128p pd=1.5u as=0.2128p ps=1.5u w=1.12u l=0.13u
X497 VPWR.t2283 sg13cmos5l_inv_16_46.Y sg13cmos5l_inv_16_50.Y VPWR.t25 sg13_lv_pmos ad=0.4368p pd=3.02u as=0.2128p ps=1.5u w=1.12u l=0.13u
X498 sg13cmos5l_inv_16_47.Y sg13cmos5l_inv_16_47.A VGND.t5 VGND.t2220 sg13_lv_nmos ad=0.1406p pd=1.12u as=0.1406p ps=1.12u w=0.74u l=0.13u
X499 sg13cmos5l_inv_16_36.A sg13cmos5l_inv_16_43.Y VPWR.t618 VPWR.t0 sg13_lv_pmos ad=0.2128p pd=1.5u as=0.2128p ps=1.5u w=1.12u l=0.13u
X500 sg13cmos5l_inv_16_0.A sg13cmos5l_inv_8_0.Y VGND.t827 VGND.t2315 sg13_lv_nmos ad=0.1406p pd=1.12u as=0.2516p ps=2.16u w=0.74u l=0.13u
X501 sg13cmos5l_inv_16_9.A sg13cmos5l_inv_16_8.Y VPWR.t992 VPWR.t0 sg13_lv_pmos ad=0.2128p pd=1.5u as=0.2128p ps=1.5u w=1.12u l=0.13u
X502 VPWR.t1377 sg13cmos5l_inv_16_71.Y sg13cmos5l_inv_16_61.A VPWR.t9 sg13_lv_pmos ad=0.2128p pd=1.5u as=0.2128p ps=1.5u w=1.12u l=0.13u
X503 VGND.t1083 VPWR.t2586 VGND.t1083 VGND.t881 sg13_lv_nmos ad=79.8f pd=0.8u as=0 ps=0 w=0.42u l=1u
X504 VPWR.t2160 sg13cmos5l_inv_16_79.A sg13cmos5l_inv_16_79.Y VPWR.t16 sg13_lv_pmos ad=0.2128p pd=1.5u as=0.2128p ps=1.5u w=1.12u l=0.13u
X505 sg13cmos5l_inv_16_98.Y sg13cmos5l_inv_16_111.A VGND.t1541 VGND.t1551 sg13_lv_nmos ad=0.1406p pd=1.12u as=0.1406p ps=1.12u w=0.74u l=0.13u
X506 VPWR.t161 VGND.t5 VPWR.t159 VPWR.t0 sg13_lv_pmos ad=0.19p pd=1.38u as=0 ps=0 w=1u l=1u
X507 VPWR.t1847 sg13cmos5l_inv_8_1.Y sg13cmos5l_inv_16_4.Y VPWR.t177 sg13_lv_pmos ad=0.2128p pd=1.5u as=0.2128p ps=1.5u w=1.12u l=0.13u
X508 VGND.t922 sg13cmos5l_inv_16_69.Y sg13cmos5l_inv_16_62.Y VGND.t881 sg13_lv_nmos ad=0.1406p pd=1.12u as=0.1406p ps=1.12u w=0.74u l=0.13u
X509 sg13cmos5l_inv_16_44.A sg13cmos5l_inv_16_28.A VPWR.t697 VPWR.t4 sg13_lv_pmos ad=0.2128p pd=1.5u as=0.2128p ps=1.5u w=1.12u l=0.13u
X510 sg13cmos5l_inv_16_66.Y sg13cmos5l_inv_16_68.A VPWR.t1275 VPWR.t9 sg13_lv_pmos ad=0.2128p pd=1.5u as=0.3808p ps=2.92u w=1.12u l=0.13u
X511 sg13cmos5l_inv_16_56.Y sg13cmos5l_inv_8_4.Y VGND.t1944 VGND.t380 sg13_lv_nmos ad=0.1406p pd=1.12u as=0.1406p ps=1.12u w=0.74u l=0.13u
X512 VPWR.t1514 sg13cmos5l_inv_16_105.A sg13cmos5l_inv_16_80.Y VPWR.t25 sg13_lv_pmos ad=0.2128p pd=1.5u as=0.2128p ps=1.5u w=1.12u l=0.13u
X513 sg13cmos5l_inv_16_22.Y sg13cmos5l_inv_16_20.A VPWR.t876 VPWR.t0 sg13_lv_pmos ad=0.2128p pd=1.5u as=0.2128p ps=1.5u w=1.12u l=0.13u
X514 VGND.t326 sg13cmos5l_inv_16_26.Y sg13cmos5l_inv_16_40.Y VGND.t335 sg13_lv_nmos ad=0.1406p pd=1.12u as=0.1406p ps=1.12u w=0.74u l=0.13u
X515 VPWR.t897 sg13cmos5l_inv_16_20.A sg13cmos5l_inv_16_20.Y VPWR.t4 sg13_lv_pmos ad=0.4368p pd=3.02u as=0.2128p ps=1.5u w=1.12u l=0.13u
X516 sg13cmos5l_inv_16_35.Y sg13cmos5l_inv_16_29.A VPWR.t1108 VPWR.t0 sg13_lv_pmos ad=0.2128p pd=1.5u as=0.2128p ps=1.5u w=1.12u l=0.13u
X517 sg13cmos5l_inv_16_15.A sg13cmos5l_inv_16_23.Y VPWR.t498 VPWR.t0 sg13_lv_pmos ad=0.2128p pd=1.5u as=0.2128p ps=1.5u w=1.12u l=0.13u
X518 VGND.t427 osc[4] a_2920_6168# VGND.t380 sg13_lv_nmos ad=0.14875p pd=1.16u as=0.187p ps=1.78u w=0.55u l=0.13u
X519 sg13cmos5l_inv_16_46.Y sg13cmos5l_inv_16_46.A VPWR.t2128 VPWR.t25 sg13_lv_pmos ad=0.2128p pd=1.5u as=0.2128p ps=1.5u w=1.12u l=0.13u
X520 VGND.t1779 sg13cmos5l_inv_16_79.A sg13cmos5l_inv_16_79.Y VGND.t380 sg13_lv_nmos ad=0.1406p pd=1.12u as=0.1406p ps=1.12u w=0.74u l=0.13u
X521 sg13cmos5l_and2_1_2.B a_2920_1632# VPWR.t687 VPWR.t177 sg13_lv_pmos ad=0.42p pd=2.99u as=0.2114p ps=1.54u w=1.12u l=0.13u
X522 VGND.t1553 VPWR.t2599 VGND.t1553 VGND.t1890 sg13_lv_nmos ad=79.8f pd=0.8u as=0 ps=0 w=0.42u l=1u
X523 VGND.t1029 sg13cmos5l_inv_16_81.Y sg13cmos5l_inv_16_84.A VGND.t881 sg13_lv_nmos ad=0.1406p pd=1.12u as=0.1406p ps=1.12u w=0.74u l=0.13u
X524 VPWR.t2213 sg13cmos5l_inv_16_73.Y sg13cmos5l_inv_16_95.Y VPWR.t16 sg13_lv_pmos ad=0.2128p pd=1.5u as=0.2128p ps=1.5u w=1.12u l=0.13u
X525 VGND.t432 VPWR.t2521 VGND.t432 VGND.t2024 sg13_lv_nmos ad=0.1428p pd=1.52u as=0 ps=0 w=0.42u l=1u
X526 VGND.t1166 sg13cmos5l_inv_16_61.A sg13cmos5l_inv_16_59.Y VGND.t1167 sg13_lv_nmos ad=0.1406p pd=1.12u as=0.1406p ps=1.12u w=0.74u l=0.13u
X527 sg13cmos5l_inv_16_5.Y sg13cmos5l_inv_16_6.A VGND.t308 VGND.t1401 sg13_lv_nmos ad=0.1406p pd=1.12u as=0.1406p ps=1.12u w=0.74u l=0.13u
X528 sg13cmos5l_inv_16_47.A sg13cmos5l_inv_16_46.A VGND.t1715 VGND.t380 sg13_lv_nmos ad=0.1406p pd=1.12u as=0.1406p ps=1.12u w=0.74u l=0.13u
X529 VPWR.t2227 sg13cmos5l_inv_16_96.Y sg13cmos5l_inv_16_81.Y VPWR.t16 sg13_lv_pmos ad=0.2128p pd=1.5u as=0.2128p ps=1.5u w=1.12u l=0.13u
X530 VGND.t1469 VPWR.t2594 VGND.t1469 VGND.t1897 sg13_lv_nmos ad=0.1428p pd=1.52u as=0 ps=0 w=0.42u l=1u
X531 sg13cmos5l_inv_16_61.A sg13cmos5l_inv_16_71.Y VPWR.t1373 VPWR.t9 sg13_lv_pmos ad=0.2128p pd=1.5u as=0.2128p ps=1.5u w=1.12u l=0.13u
X532 sg13cmos5l_inv_4_4.Y sg13cmos5l_inv_2_6.Y VGND.t432 VGND.t536 sg13_lv_nmos ad=0.1406p pd=1.12u as=0.2516p ps=2.16u w=0.74u l=0.13u
X533 sg13cmos5l_buf_1_15.X a_2920_4656# VGND.t1 VGND.t430 sg13_lv_nmos ad=0.2886p pd=2.26u as=0.14875p ps=1.16u w=0.74u l=0.13u
X534 VPWR.t695 sg13cmos5l_inv_16_28.A sg13cmos5l_inv_16_44.A VPWR.t4 sg13_lv_pmos ad=0.2128p pd=1.5u as=0.2128p ps=1.5u w=1.12u l=0.13u
X535 sg13cmos5l_inv_16_84.Y sg13cmos5l_inv_16_84.A VPWR.t1490 VPWR.t9 sg13_lv_pmos ad=0.2128p pd=1.5u as=0.2128p ps=1.5u w=1.12u l=0.13u
X536 VGND.t1944 VPWR.t2565 VGND.t1944 VGND.t380 sg13_lv_nmos ad=0.1428p pd=1.52u as=0 ps=0 w=0.42u l=1u
X537 sg13cmos5l_inv_16_99.A sg13cmos5l_inv_16_34.Y VPWR.t1026 VPWR.t25 sg13_lv_pmos ad=0.2128p pd=1.5u as=0.2128p ps=1.5u w=1.12u l=0.13u
X538 VPWR.t913 sg13cmos5l_inv_16_14.A sg13cmos5l_inv_16_104.Y VPWR.t0 sg13_lv_pmos ad=0.4368p pd=3.02u as=0.2128p ps=1.5u w=1.12u l=0.13u
X539 sg13cmos5l_inv_16_103.A sg13cmos5l_inv_16_11.A VGND.t291 VGND.t362 sg13_lv_nmos ad=0.1406p pd=1.12u as=0.2516p ps=2.16u w=0.74u l=0.13u
X540 sg13cmos5l_inv_16_77.Y sg13cmos5l_inv_16_77.A VGND.t472 VGND.t2172 sg13_lv_nmos ad=0.1406p pd=1.12u as=0.1406p ps=1.12u w=0.74u l=0.13u
X541 VPWR.t1931 sg13cmos5l_inv_16_111.A sg13cmos5l_inv_16_98.Y VPWR.t9 sg13_lv_pmos ad=0.2128p pd=1.5u as=0.2128p ps=1.5u w=1.12u l=0.13u
X542 sg13cmos5l_inv_16_84.A sg13cmos5l_inv_16_81.Y VGND.t1029 VGND.t881 sg13_lv_nmos ad=0.1406p pd=1.12u as=0.1406p ps=1.12u w=0.74u l=0.13u
X543 sg13cmos5l_inv_16_79.Y sg13cmos5l_inv_16_79.A VGND.t1779 VGND.t380 sg13_lv_nmos ad=0.1406p pd=1.12u as=0.1406p ps=1.12u w=0.74u l=0.13u
X544 VPWR.t649 VGND.t1083 VPWR.t648 VPWR.t16 sg13_lv_pmos ad=0.19p pd=1.38u as=0 ps=0 w=1u l=1u
X545 sg13cmos5l_inv_16_90.Y sg13cmos5l_inv_16_73.Y VGND.t1029 VGND.t881 sg13_lv_nmos ad=0.1406p pd=1.12u as=0.1406p ps=1.12u w=0.74u l=0.13u
X546 VPWR.t2036 sg13cmos5l_inv_16_56.Y sg13cmos5l_inv_16_71.Y VPWR.t16 sg13_lv_pmos ad=0.2128p pd=1.5u as=0.2128p ps=1.5u w=1.12u l=0.13u
X547 VPWR.t976 sg13cmos5l_inv_16_8.Y sg13cmos5l_inv_16_20.A VPWR.t0 sg13_lv_pmos ad=0.2128p pd=1.5u as=0.2128p ps=1.5u w=1.12u l=0.13u
X548 sg13cmos5l_inv_4_0.A sg13cmos5l_inv_2_0.A VGND.t586 VGND.t585 sg13_lv_nmos ad=0.1406p pd=1.12u as=0.2516p ps=2.16u w=0.74u l=0.13u
X549 sg13cmos5l_inv_16_81.Y sg13cmos5l_inv_16_96.Y VPWR.t2223 VPWR.t16 sg13_lv_pmos ad=0.2128p pd=1.5u as=0.2128p ps=1.5u w=1.12u l=0.13u
X550 sg13cmos5l_inv_16_13.Y sg13cmos5l_inv_16_15.A VPWR.t931 VPWR.t0 sg13_lv_pmos ad=0.2128p pd=1.5u as=0.2128p ps=1.5u w=1.12u l=0.13u
X551 VGND.t343 sg13cmos5l_inv_16_30.A sg13cmos5l_inv_16_30.Y VGND.t1299 sg13_lv_nmos ad=0.1406p pd=1.12u as=0.1406p ps=1.12u w=0.74u l=0.13u
X552 VGND.t221 sg13cmos5l_inv_8_3.Y sg13cmos5l_inv_16_41.A VGND.t811 sg13_lv_nmos ad=0.1406p pd=1.12u as=0.1406p ps=1.12u w=0.74u l=0.13u
X553 sg13cmos5l_inv_16_87.A sg13cmos5l_inv_16_73.A VGND.t1469 VGND.t1471 sg13_lv_nmos ad=0.1406p pd=1.12u as=0.1406p ps=1.12u w=0.74u l=0.13u
X554 VGND.t1132 VPWR.t2578 VGND.t882 VGND.t881 sg13_lv_nmos ad=0.1428p pd=1.52u as=0 ps=0 w=0.42u l=1u
X555 sg13cmos5l_inv_16_108.Y sg13cmos5l_inv_16_6.Y VGND.t635 VGND.t2349 sg13_lv_nmos ad=0.1406p pd=1.12u as=0.1406p ps=1.12u w=0.74u l=0.13u
X556 VGND.t1779 sg13cmos5l_inv_16_79.A sg13cmos5l_inv_16_79.Y VGND.t380 sg13_lv_nmos ad=0.1406p pd=1.12u as=0.1406p ps=1.12u w=0.74u l=0.13u
X557 VGND.t1243 sg13cmos5l_inv_16_26.A sg13cmos5l_inv_16_30.A VGND.t1328 sg13_lv_nmos ad=0.2516p pd=2.16u as=0.1406p ps=1.12u w=0.74u l=0.13u
X558 sg13cmos5l_inv_16_98.Y sg13cmos5l_inv_16_111.A VPWR.t1927 VPWR.t9 sg13_lv_pmos ad=0.2128p pd=1.5u as=0.2128p ps=1.5u w=1.12u l=0.13u
X559 VGND.t1029 sg13cmos5l_inv_16_81.Y sg13cmos5l_inv_16_84.A VGND.t881 sg13_lv_nmos ad=0.1406p pd=1.12u as=0.1406p ps=1.12u w=0.74u l=0.13u
X560 VPWR.t1450 sg13cmos5l_inv_16_81.Y sg13cmos5l_inv_16_79.A VPWR.t16 sg13_lv_pmos ad=0.2128p pd=1.5u as=0.2128p ps=1.5u w=1.12u l=0.13u
X561 VPWR.t947 sg13cmos5l_inv_16_15.A sg13cmos5l_inv_16_15.Y VPWR.t4 sg13_lv_pmos ad=0.2128p pd=1.5u as=0.2128p ps=1.5u w=1.12u l=0.13u
X562 sg13cmos5l_inv_16_62.Y sg13cmos5l_inv_16_69.Y VPWR.t1340 VPWR.t9 sg13_lv_pmos ad=0.2128p pd=1.5u as=0.2128p ps=1.5u w=1.12u l=0.13u
X563 VGND.t1029 sg13cmos5l_inv_16_73.Y sg13cmos5l_inv_16_90.Y VGND.t881 sg13_lv_nmos ad=0.1406p pd=1.12u as=0.1406p ps=1.12u w=0.74u l=0.13u
X564 sg13cmos5l_inv_16_20.A sg13cmos5l_inv_16_8.Y VPWR.t972 VPWR.t0 sg13_lv_pmos ad=0.2128p pd=1.5u as=0.2128p ps=1.5u w=1.12u l=0.13u
X565 sg13cmos5l_and2_1_3.A a_4744_908# VPWR.t480 VPWR.t177 sg13_lv_pmos ad=0.42p pd=2.99u as=0.2114p ps=1.54u w=1.12u l=0.13u
X566 VGND.t52 sg13cmos5l_inv_16_23.Y sg13cmos5l_inv_16_14.A VGND.t79 sg13_lv_nmos ad=0.2516p pd=2.16u as=0.1406p ps=1.12u w=0.74u l=0.13u
X567 VGND.t217 VPWR.t2496 VGND.t217 VGND.t2068 sg13_lv_nmos ad=79.8f pd=0.8u as=0 ps=0 w=0.42u l=1u
X568 sg13cmos5l_inv_16_84.A sg13cmos5l_inv_16_81.Y VPWR.t1440 VPWR.t9 sg13_lv_pmos ad=0.2128p pd=1.5u as=0.2128p ps=1.5u w=1.12u l=0.13u
X569 VGND.t953 VPWR.t2557 VGND.t1965 VGND.t380 sg13_lv_nmos ad=79.8f pd=0.8u as=0 ps=0 w=0.42u l=1u
X570 sg13cmos5l_inv_16_73.Y sg13cmos5l_inv_16_73.A VPWR.t1873 VPWR.t16 sg13_lv_pmos ad=0.2128p pd=1.5u as=0.2128p ps=1.5u w=1.12u l=0.13u
X571 sg13cmos5l_inv_16_30.A sg13cmos5l_inv_16_26.A VGND.t326 VGND.t1325 sg13_lv_nmos ad=0.1406p pd=1.12u as=0.1406p ps=1.12u w=0.74u l=0.13u
X572 VPWR.t965 sg13cmos5l_inv_2_6.Y sg13cmos5l_inv_4_4.Y VPWR.t25 sg13_lv_pmos ad=0.2128p pd=1.5u as=0.2128p ps=1.5u w=1.12u l=0.13u
X573 VGND.t773 sg13cmos5l_inv_16_99.A sg13cmos5l_inv_16_99.Y VGND.t777 sg13_lv_nmos ad=0.1406p pd=1.12u as=0.1406p ps=1.12u w=0.74u l=0.13u
X574 sg13cmos5l_inv_16_79.A sg13cmos5l_inv_16_81.Y VPWR.t1447 VPWR.t16 sg13_lv_pmos ad=0.2128p pd=1.5u as=0.3808p ps=2.92u w=1.12u l=0.13u
X575 VPWR.t1338 sg13cmos5l_inv_16_69.Y sg13cmos5l_inv_16_62.Y VPWR.t9 sg13_lv_pmos ad=0.2128p pd=1.5u as=0.2128p ps=1.5u w=1.12u l=0.13u
X576 sg13cmos5l_inv_16_69.Y sg13cmos5l_inv_16_52.Y VGND.t922 VGND.t881 sg13_lv_nmos ad=0.1406p pd=1.12u as=0.1406p ps=1.12u w=0.74u l=0.13u
X577 VGND.t756 sg13cmos5l_inv_8_7.Y sg13cmos5l_inv_16_48.A VGND.t380 sg13_lv_nmos ad=0.1406p pd=1.12u as=0.1406p ps=1.12u w=0.74u l=0.13u
X578 VPWR.t154 VGND.t609 VPWR.t401 VPWR.t25 sg13_lv_pmos ad=0.34p pd=2.68u as=0 ps=0 w=1u l=1u
X579 VPWR.t462 sg13cmos5l_inv_16_37.A sg13cmos5l_inv_16_102.Y VPWR.t0 sg13_lv_pmos ad=0.2128p pd=1.5u as=0.2128p ps=1.5u w=1.12u l=0.13u
X580 VGND.t2161 VPWR.t2462 VGND.t1539 VGND.t2160 sg13_lv_nmos ad=0.1428p pd=1.52u as=0 ps=0 w=0.42u l=1u
X581 VGND.t1507 sg13cmos5l_inv_16_94.A sg13cmos5l_inv_16_76.A VGND.t881 sg13_lv_nmos ad=0.1406p pd=1.12u as=0.1406p ps=1.12u w=0.74u l=0.13u
X582 VPWR.t2262 sg13cmos5l_inv_16_77.A sg13cmos5l_inv_16_77.Y VPWR.t25 sg13_lv_pmos ad=0.2128p pd=1.5u as=0.2128p ps=1.5u w=1.12u l=0.13u
X583 VPWR.t1843 sg13cmos5l_inv_8_1.Y sg13cmos5l_inv_16_4.Y VPWR.t177 sg13_lv_pmos ad=0.2128p pd=1.5u as=0.2128p ps=1.5u w=1.12u l=0.13u
X584 VGND.t425 sg13cmos5l_inv_16_27.A sg13cmos5l_inv_16_27.Y VGND.t1615 sg13_lv_nmos ad=0.1406p pd=1.12u as=0.1406p ps=1.12u w=0.74u l=0.13u
X585 sg13cmos5l_inv_16_56.Y sg13cmos5l_inv_8_4.Y VGND.t1944 VGND.t380 sg13_lv_nmos ad=0.1406p pd=1.12u as=0.1406p ps=1.12u w=0.74u l=0.13u
X586 sg13cmos5l_inv_16_22.Y sg13cmos5l_inv_16_20.A VPWR.t872 VPWR.t0 sg13_lv_pmos ad=0.2128p pd=1.5u as=0.2128p ps=1.5u w=1.12u l=0.13u
X587 VPWR.t1438 sg13cmos5l_inv_16_81.Y sg13cmos5l_inv_16_84.A VPWR.t9 sg13_lv_pmos ad=0.2128p pd=1.5u as=0.2128p ps=1.5u w=1.12u l=0.13u
X588 sg13cmos5l_inv_16_45.Y sg13cmos5l_inv_16_47.A VGND.t1944 VGND.t380 sg13_lv_nmos ad=0.1406p pd=1.12u as=0.1406p ps=1.12u w=0.74u l=0.13u
X589 sg13cmos5l_inv_16_35.Y sg13cmos5l_inv_16_29.A VPWR.t1104 VPWR.t0 sg13_lv_pmos ad=0.2128p pd=1.5u as=0.2128p ps=1.5u w=1.12u l=0.13u
X590 sg13cmos5l_inv_16_100.Y sg13cmos5l_inv_16_36.A VPWR.t566 VPWR.t0 sg13_lv_pmos ad=0.2128p pd=1.5u as=0.2128p ps=1.5u w=1.12u l=0.13u
X591 VGND.t375 sg13cmos5l_inv_16_20.A sg13cmos5l_inv_16_20.Y VGND.t453 sg13_lv_nmos ad=0.1406p pd=1.12u as=0.1406p ps=1.12u w=0.74u l=0.13u
X592 sg13cmos5l_inv_16_105.A sg13cmos5l_inv_16_11.A VGND.t345 VGND.t344 sg13_lv_nmos ad=0.1406p pd=1.12u as=0.2516p ps=2.16u w=0.74u l=0.13u
X593 sg13cmos5l_inv_16_48.A sg13cmos5l_inv_8_7.Y VGND.t756 VGND.t380 sg13_lv_nmos ad=0.1406p pd=1.12u as=0.1406p ps=1.12u w=0.74u l=0.13u
X594 sg13cmos5l_inv_16_34.Y sg13cmos5l_inv_16_41.A VGND.t226 VGND.t231 sg13_lv_nmos ad=0.1406p pd=1.12u as=0.1406p ps=1.12u w=0.74u l=0.13u
X595 sg13cmos5l_inv_16_47.A sg13cmos5l_inv_16_46.A VGND.t1715 VGND.t380 sg13_lv_nmos ad=0.1406p pd=1.12u as=0.1406p ps=1.12u w=0.74u l=0.13u
X596 VGND.t898 sg13cmos5l_inv_16_88.A sg13cmos5l_inv_16_94.A VGND.t881 sg13_lv_nmos ad=0.1406p pd=1.12u as=0.1406p ps=1.12u w=0.74u l=0.13u
X597 VPWR.t85 VGND.t953 VPWR.t87 VPWR.t16 sg13_lv_pmos ad=0.19p pd=1.38u as=0 ps=0 w=1u l=1u
X598 VGND.t609 VPWR.t2536 VGND.t5 VGND.t2000 sg13_lv_nmos ad=79.8f pd=0.8u as=0 ps=0 w=0.42u l=1u
X599 VPWR.t986 sg13cmos5l_inv_16_8.Y sg13cmos5l_inv_16_9.A VPWR.t0 sg13_lv_pmos ad=0.2128p pd=1.5u as=0.2128p ps=1.5u w=1.12u l=0.13u
X600 sg13cmos5l_inv_16_6.A sg13cmos5l_inv_16_4.Y VGND.t310 VGND.t323 sg13_lv_nmos ad=0.1406p pd=1.12u as=0.1406p ps=1.12u w=0.74u l=0.13u
X601 VPWR.t65 VGND.t1178 VPWR.t2426 VPWR.t9 sg13_lv_pmos ad=0.34p pd=2.68u as=0 ps=0 w=1u l=1u
X602 sg13cmos5l_inv_16_4.Y sg13cmos5l_inv_8_1.Y VPWR.t1839 VPWR.t177 sg13_lv_pmos ad=0.2128p pd=1.5u as=0.2128p ps=1.5u w=1.12u l=0.13u
X603 VPWR.t767 sg13cmos5l_inv_16_26.Y sg13cmos5l_inv_16_40.Y VPWR.t177 sg13_lv_pmos ad=0.4368p pd=3.02u as=0.2128p ps=1.5u w=1.12u l=0.13u
X604 sg13cmos5l_inv_16_46.A sg13cmos5l_inv_16_48.A VGND.t1718 VGND.t380 sg13_lv_nmos ad=0.1406p pd=1.12u as=0.1406p ps=1.12u w=0.74u l=0.13u
X605 sg13cmos5l_inv_8_1.Y sg13cmos5l_inv_8_1.A VGND.t84 VGND.t1425 sg13_lv_nmos ad=0.1406p pd=1.12u as=0.1406p ps=1.12u w=0.74u l=0.13u
X606 sg13cmos5l_inv_16_109.Y sg13cmos5l_inv_16_48.A VPWR.t2092 VPWR.t16 sg13_lv_pmos ad=0.2128p pd=1.5u as=0.2128p ps=1.5u w=1.12u l=0.13u
X607 VPWR.t870 sg13cmos5l_inv_16_20.A sg13cmos5l_inv_16_22.Y VPWR.t0 sg13_lv_pmos ad=0.2128p pd=1.5u as=0.2128p ps=1.5u w=1.12u l=0.13u
X608 VPWR.t843 sg13cmos5l_inv_2_1.Y sg13cmos5l_inv_8_1.A VPWR.t4 sg13_lv_pmos ad=0.3808p pd=2.92u as=0.2128p ps=1.5u w=1.12u l=0.13u
X609 VGND.t1334 sg13cmos5l_inv_16_26.A sg13cmos5l_inv_16_26.Y VGND.t1338 sg13_lv_nmos ad=0.1406p pd=1.12u as=0.1406p ps=1.12u w=0.74u l=0.13u
X610 VGND.t84 sg13cmos5l_inv_16_17.A sg13cmos5l_inv_16_17.Y VGND.t104 sg13_lv_nmos ad=0.1406p pd=1.12u as=0.1406p ps=1.12u w=0.74u l=0.13u
X611 sg13cmos5l_inv_16_55.Y sg13cmos5l_inv_16_101.Y VGND.t1663 VGND.t380 sg13_lv_nmos ad=0.1406p pd=1.12u as=0.1406p ps=1.12u w=0.74u l=0.13u
X612 VGND.t122 VPWR.t2514 VGND.t122 VGND.t2035 sg13_lv_nmos ad=0.1428p pd=1.52u as=0 ps=0 w=0.42u l=1u
X613 VPWR.t2238 sg13cmos5l_inv_16_96.Y sg13cmos5l_inv_16_11.A VPWR.t25 sg13_lv_pmos ad=0.2128p pd=1.5u as=0.2128p ps=1.5u w=1.12u l=0.13u
X614 VPWR.t844 sg13cmos5l_inv_16_27.Y sg13cmos5l_inv_16_26.A VPWR.t177 sg13_lv_pmos ad=0.2128p pd=1.5u as=0.2128p ps=1.5u w=1.12u l=0.13u
X615 VGND.t291 sg13cmos5l_inv_16_4.Y sg13cmos5l_inv_16_8.Y VGND.t306 sg13_lv_nmos ad=0.2516p pd=2.16u as=0.1406p ps=1.12u w=0.74u l=0.13u
X616 VGND.t545 sg13cmos5l_inv_16_8.Y sg13cmos5l_inv_16_20.A VGND.t557 sg13_lv_nmos ad=0.2516p pd=2.16u as=0.1406p ps=1.12u w=0.74u l=0.13u
X617 VGND.t226 sg13cmos5l_inv_16_41.A sg13cmos5l_inv_16_34.Y VGND.t228 sg13_lv_nmos ad=0.1406p pd=1.12u as=0.1406p ps=1.12u w=0.74u l=0.13u
X618 VGND.t738 sg13cmos5l_inv_16_9.A sg13cmos5l_inv_16_10.Y VGND.t737 sg13_lv_nmos ad=0.1406p pd=1.12u as=0.1406p ps=1.12u w=0.74u l=0.13u
X619 VGND.t1715 sg13cmos5l_inv_16_46.A sg13cmos5l_inv_16_47.A VGND.t380 sg13_lv_nmos ad=0.1406p pd=1.12u as=0.1406p ps=1.12u w=0.74u l=0.13u
X620 VGND.t1416 sg13cmos5l_inv_16_6.A sg13cmos5l_inv_16_6.Y VGND.t1415 sg13_lv_nmos ad=0.1406p pd=1.12u as=0.1406p ps=1.12u w=0.74u l=0.13u
X621 sg13cmos5l_inv_16_6.A sg13cmos5l_inv_16_4.Y VPWR.t739 VPWR.t4 sg13_lv_pmos ad=0.2128p pd=1.5u as=0.2128p ps=1.5u w=1.12u l=0.13u
X622 sg13cmos5l_inv_16_94.A sg13cmos5l_inv_16_88.A VGND.t1507 VGND.t881 sg13_lv_nmos ad=0.1406p pd=1.12u as=0.1406p ps=1.12u w=0.74u l=0.13u
X623 VGND.t310 sg13cmos5l_inv_16_4.Y sg13cmos5l_inv_16_6.A VGND.t320 sg13_lv_nmos ad=0.1406p pd=1.12u as=0.1406p ps=1.12u w=0.74u l=0.13u
X624 sg13cmos5l_inv_16_40.Y sg13cmos5l_inv_16_26.Y VPWR.t178 VPWR.t177 sg13_lv_pmos ad=0.2128p pd=1.5u as=0.2128p ps=1.5u w=1.12u l=0.13u
X625 sg13cmos5l_inv_16_51.Y sg13cmos5l_inv_16_99.A VGND.t773 VGND.t784 sg13_lv_nmos ad=0.1406p pd=1.12u as=0.1406p ps=1.12u w=0.74u l=0.13u
X626 VGND.t375 sg13cmos5l_inv_16_11.A sg13cmos5l_inv_16_103.A VGND.t379 sg13_lv_nmos ad=0.2516p pd=2.16u as=0.1406p ps=1.12u w=0.74u l=0.13u
X627 sg13cmos5l_inv_16_58.Y sg13cmos5l_inv_16_69.Y VGND.t903 VGND.t902 sg13_lv_nmos ad=0.1406p pd=1.12u as=0.2516p ps=2.16u w=0.74u l=0.13u
X628 VPWR.t2306 sg13cmos5l_inv_16_47.A sg13cmos5l_inv_16_47.Y VPWR.t25 sg13_lv_pmos ad=0.2128p pd=1.5u as=0.2128p ps=1.5u w=1.12u l=0.13u
X629 VGND.t472 sg13cmos5l_inv_16_77.A sg13cmos5l_inv_16_77.Y VGND.t2165 sg13_lv_nmos ad=0.1406p pd=1.12u as=0.1406p ps=1.12u w=0.74u l=0.13u
X630 sg13cmos5l_inv_8_1.A sg13cmos5l_inv_2_1.Y VPWR.t840 VPWR.t4 sg13_lv_pmos ad=0.2128p pd=1.5u as=0.3808p ps=2.92u w=1.12u l=0.13u
X631 VGND.t20 VPWR.t2535 VGND.t20 VGND.t2001 sg13_lv_nmos ad=0.1428p pd=1.52u as=0 ps=0 w=0.42u l=1u
X632 sg13cmos5l_inv_16_6.Y sg13cmos5l_inv_16_6.A VGND.t862 VGND.t1409 sg13_lv_nmos ad=0.1406p pd=1.12u as=0.1406p ps=1.12u w=0.74u l=0.13u
X633 sg13cmos5l_inv_16_98.Y sg13cmos5l_inv_16_111.A VPWR.t1924 VPWR.t9 sg13_lv_pmos ad=0.2128p pd=1.5u as=0.3808p ps=2.92u w=1.12u l=0.13u
X634 VPWR.t1990 sg13cmos5l_inv_16_67.A sg13cmos5l_inv_16_67.Y VPWR.t16 sg13_lv_pmos ad=0.2128p pd=1.5u as=0.2128p ps=1.5u w=1.12u l=0.13u
X635 sg13cmos5l_inv_16_45.Y sg13cmos5l_inv_16_47.A VGND.t1944 VGND.t380 sg13_lv_nmos ad=0.1406p pd=1.12u as=0.1406p ps=1.12u w=0.74u l=0.13u
X636 VGND.t1663 sg13cmos5l_inv_16_101.Y sg13cmos5l_inv_16_55.Y VGND.t380 sg13_lv_nmos ad=0.1406p pd=1.12u as=0.1406p ps=1.12u w=0.74u l=0.13u
X637 VPWR.t1360 sg13cmos5l_inv_4_6.Y sg13cmos5l_inv_16_96.A VPWR.t25 sg13_lv_pmos ad=0.2128p pd=1.5u as=0.2184p ps=1.51u w=1.12u l=0.13u
X638 sg13cmos5l_inv_16_100.Y sg13cmos5l_inv_16_36.A VPWR.t562 VPWR.t0 sg13_lv_pmos ad=0.2128p pd=1.5u as=0.2128p ps=1.5u w=1.12u l=0.13u
X639 VGND.t1029 sg13cmos5l_inv_16_81.Y sg13cmos5l_inv_16_79.A VGND.t881 sg13_lv_nmos ad=0.1406p pd=1.12u as=0.1406p ps=1.12u w=0.74u l=0.13u
X640 sg13cmos5l_inv_16_11.A sg13cmos5l_inv_16_96.Y VPWR.t2219 VPWR.t25 sg13_lv_pmos ad=0.2128p pd=1.5u as=0.3808p ps=2.92u w=1.12u l=0.13u
X641 sg13cmos5l_inv_16_26.A sg13cmos5l_inv_16_27.Y VPWR.t767 VPWR.t177 sg13_lv_pmos ad=0.2128p pd=1.5u as=0.2128p ps=1.5u w=1.12u l=0.13u
X642 sg13cmos5l_inv_16_71.Y sg13cmos5l_inv_16_56.Y VPWR.t2028 VPWR.t16 sg13_lv_pmos ad=0.2128p pd=1.5u as=0.2128p ps=1.5u w=1.12u l=0.13u
X643 VPWR.t653 VGND.t1083 VPWR.t651 VPWR.t16 sg13_lv_pmos ad=0.19p pd=1.38u as=0 ps=0 w=1u l=1u
X644 sg13cmos5l_inv_16_10.Y sg13cmos5l_inv_16_9.A VGND.t723 VGND.t733 sg13_lv_nmos ad=0.1406p pd=1.12u as=0.1406p ps=1.12u w=0.74u l=0.13u
X645 sg13cmos5l_inv_16_25.Y sg13cmos5l_inv_16_6.Y VGND.t1245 VGND.t2331 sg13_lv_nmos ad=0.1406p pd=1.12u as=0.2516p ps=2.16u w=0.74u l=0.13u
X646 sg13cmos5l_inv_16_56.Y sg13cmos5l_inv_8_4.Y VPWR.t2360 VPWR.t25 sg13_lv_pmos ad=0.2128p pd=1.5u as=0.2128p ps=1.5u w=1.12u l=0.13u
X647 sg13cmos5l_inv_16_29.Y sg13cmos5l_inv_16_29.A VGND.t705 VGND.t704 sg13_lv_nmos ad=0.1406p pd=1.12u as=0.2516p ps=2.16u w=0.74u l=0.13u
X648 sg13cmos5l_inv_16_103.A sg13cmos5l_inv_16_11.A VGND.t375 VGND.t376 sg13_lv_nmos ad=0.1406p pd=1.12u as=0.1406p ps=1.12u w=0.74u l=0.13u
X649 VPWR.t112 VGND.t994 VPWR.t110 VPWR.t9 sg13_lv_pmos ad=0.19p pd=1.38u as=0 ps=0 w=1u l=1u
X650 VPWR.t106 VGND.t1970 VPWR.t104 VPWR.t25 sg13_lv_pmos ad=0.19p pd=1.38u as=0 ps=0 w=1u l=1u
X651 VGND.t122 VPWR.t2530 VGND.t122 VGND.t2010 sg13_lv_nmos ad=0.1428p pd=1.52u as=0 ps=0 w=0.42u l=1u
X652 VGND.t1164 VPWR.t2591 VGND.t1241 VGND.t881 sg13_lv_nmos ad=0.1428p pd=1.52u as=0 ps=0 w=0.42u l=1u
X653 sg13cmos5l_inv_16_47.Y sg13cmos5l_inv_16_47.A VPWR.t2287 VPWR.t25 sg13_lv_pmos ad=0.2128p pd=1.5u as=0.3808p ps=2.92u w=1.12u l=0.13u
X654 VPWR.t2409 sg13cmos5l_inv_8_0.Y sg13cmos5l_inv_16_0.A VPWR.t177 sg13_lv_pmos ad=0.2128p pd=1.5u as=0.2128p ps=1.5u w=1.12u l=0.13u
X655 sg13cmos5l_inv_16_13.Y sg13cmos5l_inv_16_15.A VGND.t45 VGND.t515 sg13_lv_nmos ad=0.1406p pd=1.12u as=0.1406p ps=1.12u w=0.74u l=0.13u
X656 VGND.t756 sg13cmos5l_inv_16_111.A sg13cmos5l_inv_16_111.Y VGND.t380 sg13_lv_nmos ad=0.1406p pd=1.12u as=0.1406p ps=1.12u w=0.74u l=0.13u
X657 VPWR.t2199 sg13cmos5l_inv_16_73.Y sg13cmos5l_inv_16_90.Y VPWR.t16 sg13_lv_pmos ad=0.2128p pd=1.5u as=0.2128p ps=1.5u w=1.12u l=0.13u
X658 sg13cmos5l_inv_16_30.A sg13cmos5l_inv_16_26.A VGND.t326 VGND.t1321 sg13_lv_nmos ad=0.1406p pd=1.12u as=0.1406p ps=1.12u w=0.74u l=0.13u
X659 VPWR.t560 sg13cmos5l_inv_16_36.A sg13cmos5l_inv_16_100.Y VPWR.t0 sg13_lv_pmos ad=0.2128p pd=1.5u as=0.2128p ps=1.5u w=1.12u l=0.13u
X660 sg13cmos5l_inv_16_31.Y sg13cmos5l_inv_16_30.A VPWR.t480 VPWR.t177 sg13_lv_pmos ad=0.2128p pd=1.5u as=0.2128p ps=1.5u w=1.12u l=0.13u
X661 sg13cmos5l_inv_16_79.A sg13cmos5l_inv_16_81.Y VGND.t1026 VGND.t881 sg13_lv_nmos ad=0.1406p pd=1.12u as=0.1406p ps=1.12u w=0.74u l=0.13u
X662 VPWR.t458 sg13cmos5l_inv_16_37.A sg13cmos5l_inv_16_102.Y VPWR.t0 sg13_lv_pmos ad=0.2128p pd=1.5u as=0.2128p ps=1.5u w=1.12u l=0.13u
X663 VPWR.t2358 sg13cmos5l_inv_8_4.Y sg13cmos5l_inv_16_56.Y VPWR.t25 sg13_lv_pmos ad=0.2128p pd=1.5u as=0.2128p ps=1.5u w=1.12u l=0.13u
X664 VGND.t655 sg13cmos5l_inv_16_1.A sg13cmos5l_inv_16_2.A VGND.t660 sg13_lv_nmos ad=0.1406p pd=1.12u as=0.1406p ps=1.12u w=0.74u l=0.13u
X665 sg13cmos5l_inv_16_96.Y sg13cmos5l_inv_16_96.A VGND.t353 VGND.t937 sg13_lv_nmos ad=0.1406p pd=1.12u as=0.2516p ps=2.16u w=0.74u l=0.13u
X666 VPWR.t2258 sg13cmos5l_inv_16_77.A sg13cmos5l_inv_16_77.Y VPWR.t25 sg13_lv_pmos ad=0.2128p pd=1.5u as=0.2128p ps=1.5u w=1.12u l=0.13u
X667 sg13cmos5l_inv_16_14.A sg13cmos5l_inv_16_23.Y VGND.t52 VGND.t72 sg13_lv_nmos ad=0.1406p pd=1.12u as=0.1406p ps=1.12u w=0.74u l=0.13u
X668 sg13cmos5l_inv_16_96.A sg13cmos5l_inv_4_6.Y VPWR.t1359 VPWR.t25 sg13_lv_pmos ad=0.2184p pd=1.51u as=0.3808p ps=2.92u w=1.12u l=0.13u
X669 VGND.t1067 sg13cmos5l_inv_16_84.A sg13cmos5l_inv_16_85.Y VGND.t1074 sg13_lv_nmos ad=0.1406p pd=1.12u as=0.1406p ps=1.12u w=0.74u l=0.13u
X670 VPWR.t153 VGND.t898 VPWR.t152 VPWR.t16 sg13_lv_pmos ad=0.34p pd=2.68u as=0 ps=0 w=1u l=1u
X671 sg13cmos5l_inv_2_7.Y sg13cmos5l_inv_1_3.Y VGND.t5 VGND.t1198 sg13_lv_nmos ad=0.1406p pd=1.12u as=0.2516p ps=2.16u w=0.74u l=0.13u
X672 a_5133_916# sg13cmos5l_and2_1_3.A VPWR.t480 VPWR.t177 sg13_lv_pmos ad=0.1596p pd=1.22u as=0.2856p ps=2.36u w=0.84u l=0.13u
X673 VPWR.t1462 sg13cmos5l_inv_16_81.Y sg13cmos5l_inv_16_79.A VPWR.t16 sg13_lv_pmos ad=0.4368p pd=3.02u as=0.2128p ps=1.5u w=1.12u l=0.13u
X674 VPWR.t1213 sg13cmos5l_inv_16_99.A sg13cmos5l_inv_16_99.Y VPWR.t0 sg13_lv_pmos ad=0.2128p pd=1.5u as=0.2128p ps=1.5u w=1.12u l=0.13u
X675 VPWR.t50 VGND.t916 VPWR.t125 VPWR.t9 sg13_lv_pmos ad=0.34p pd=2.68u as=0 ps=0 w=1u l=1u
X676 VPWR.t2014 sg13cmos5l_inv_16_88.A sg13cmos5l_inv_16_94.A VPWR.t9 sg13_lv_pmos ad=0.2128p pd=1.5u as=0.2128p ps=1.5u w=1.12u l=0.13u
X677 sg13cmos5l_inv_16_74.Y sg13cmos5l_inv_16_75.A VPWR.t812 VPWR.t25 sg13_lv_pmos ad=0.2128p pd=1.5u as=0.2128p ps=1.5u w=1.12u l=0.13u
X678 VGND.t52 sg13cmos5l_inv_16_14.A sg13cmos5l_inv_16_14.Y VGND.t498 sg13_lv_nmos ad=0.1406p pd=1.12u as=0.1406p ps=1.12u w=0.74u l=0.13u
X679 sg13cmos5l_inv_16_87.Y sg13cmos5l_inv_16_87.A VPWR.t1428 VPWR.t9 sg13_lv_pmos ad=0.2128p pd=1.5u as=0.2128p ps=1.5u w=1.12u l=0.13u
X680 VPWR.t535 sg13cmos5l_inv_16_17.A sg13cmos5l_inv_16_19.Y VPWR.t177 sg13_lv_pmos ad=0.2128p pd=1.5u as=0.2128p ps=1.5u w=1.12u l=0.13u
X681 VPWR.t329 sg13cmos5l_inv_16_6.A sg13cmos5l_inv_16_5.Y VPWR.t177 sg13_lv_pmos ad=0.2128p pd=1.5u as=0.2128p ps=1.5u w=1.12u l=0.13u
X682 sg13cmos5l_inv_16_27.Y sg13cmos5l_inv_16_27.A VPWR.t844 VPWR.t177 sg13_lv_pmos ad=0.2128p pd=1.5u as=0.2128p ps=1.5u w=1.12u l=0.13u
X683 sg13cmos5l_inv_16_2.A sg13cmos5l_inv_16_1.A VGND.t655 VGND.t657 sg13_lv_nmos ad=0.1406p pd=1.12u as=0.1406p ps=1.12u w=0.74u l=0.13u
X684 VGND.t1580 sg13cmos5l_inv_16_67.A sg13cmos5l_inv_16_65.Y VGND.t1591 sg13_lv_nmos ad=0.1406p pd=1.12u as=0.1406p ps=1.12u w=0.74u l=0.13u
X685 sg13cmos5l_inv_16_93.Y sg13cmos5l_inv_16_87.A VGND.t994 VGND.t1004 sg13_lv_nmos ad=0.1406p pd=1.12u as=0.1406p ps=1.12u w=0.74u l=0.13u
X686 sg13cmos5l_inv_16_77.Y sg13cmos5l_inv_16_77.A VPWR.t2254 VPWR.t25 sg13_lv_pmos ad=0.2128p pd=1.5u as=0.2128p ps=1.5u w=1.12u l=0.13u
X687 VPWR.t1272 sg13cmos5l_inv_16_0.A sg13cmos5l_inv_16_1.A VPWR.t177 sg13_lv_pmos ad=0.4368p pd=3.02u as=0.2128p ps=1.5u w=1.12u l=0.13u
X688 VPWR.t691 sg13cmos5l_inv_16_28.A sg13cmos5l_inv_16_44.A VPWR.t4 sg13_lv_pmos ad=0.2128p pd=1.5u as=0.2128p ps=1.5u w=1.12u l=0.13u
X689 VPWR.t1768 sg13cmos5l_inv_16_52.Y sg13cmos5l_inv_16_53.A VPWR.t16 sg13_lv_pmos ad=0.2128p pd=1.5u as=0.2128p ps=1.5u w=1.12u l=0.13u
X690 sg13cmos5l_inv_16_91.Y sg13cmos5l_inv_16_79.A VGND.t1083 VGND.t881 sg13_lv_nmos ad=0.1406p pd=1.12u as=0.2516p ps=2.16u w=0.74u l=0.13u
X691 VPWR.t53 VGND.t1067 VPWR.t52 VPWR.t9 sg13_lv_pmos ad=0.34p pd=2.68u as=0 ps=0 w=1u l=1u
X692 sg13cmos5l_inv_16_99.Y sg13cmos5l_inv_16_99.A VPWR.t1209 VPWR.t0 sg13_lv_pmos ad=0.2128p pd=1.5u as=0.2128p ps=1.5u w=1.12u l=0.13u
X693 VPWR.t1754 sg13cmos5l_inv_16_52.Y sg13cmos5l_inv_16_69.Y VPWR.t16 sg13_lv_pmos ad=0.4368p pd=3.02u as=0.2128p ps=1.5u w=1.12u l=0.13u
X694 VGND.t1715 sg13cmos5l_inv_16_46.Y sg13cmos5l_inv_16_50.Y VGND.t380 sg13_lv_nmos ad=0.1406p pd=1.12u as=0.1406p ps=1.12u w=0.74u l=0.13u
X695 sg13cmos5l_inv_16_27.A sg13cmos5l_inv_8_2.A VGND.t575 VGND.t581 sg13_lv_nmos ad=0.1443p pd=1.13u as=0.1406p ps=1.12u w=0.74u l=0.13u
X696 VGND.t291 sg13cmos5l_inv_16_4.Y sg13cmos5l_inv_16_8.Y VGND.t302 sg13_lv_nmos ad=0.1406p pd=1.12u as=0.1406p ps=1.12u w=0.74u l=0.13u
X697 VPWR.t72 VGND.t1944 VPWR.t71 VPWR.t16 sg13_lv_pmos ad=0.34p pd=2.68u as=0 ps=0 w=1u l=1u
X698 VPWR.t810 sg13cmos5l_inv_16_75.A sg13cmos5l_inv_16_74.Y VPWR.t25 sg13_lv_pmos ad=0.2128p pd=1.5u as=0.2128p ps=1.5u w=1.12u l=0.13u
X699 sg13cmos5l_inv_16_103.Y sg13cmos5l_inv_16_103.A VGND.t353 VGND.t356 sg13_lv_nmos ad=0.1406p pd=1.12u as=0.1406p ps=1.12u w=0.74u l=0.13u
X700 VGND.t221 sg13cmos5l_inv_16_41.A sg13cmos5l_inv_16_34.Y VGND.t223 sg13_lv_nmos ad=0.1406p pd=1.12u as=0.1406p ps=1.12u w=0.74u l=0.13u
X701 sg13cmos5l_inv_16_14.Y sg13cmos5l_inv_16_14.A VGND.t50 VGND.t495 sg13_lv_nmos ad=0.1406p pd=1.12u as=0.1406p ps=1.12u w=0.74u l=0.13u
X702 VGND.t45 VPWR.t2483 VGND.t45 VGND.t2091 sg13_lv_nmos ad=0.1428p pd=1.52u as=0 ps=0 w=0.42u l=1u
X703 sg13cmos5l_inv_16_76.A sg13cmos5l_inv_16_94.A VPWR.t1910 VPWR.t16 sg13_lv_pmos ad=0.2128p pd=1.5u as=0.2128p ps=1.5u w=1.12u l=0.13u
X704 VGND.t994 sg13cmos5l_inv_16_87.A sg13cmos5l_inv_16_93.Y VGND.t1001 sg13_lv_nmos ad=0.1406p pd=1.12u as=0.1406p ps=1.12u w=0.74u l=0.13u
X705 sg13cmos5l_inv_16_88.A sg13cmos5l_inv_4_7.Y VGND.t1201 VGND.t1222 sg13_lv_nmos ad=0.1406p pd=1.12u as=0.1406p ps=1.12u w=0.74u l=0.13u
X706 VGND.t575 sg13cmos5l_inv_8_2.A sg13cmos5l_inv_16_27.A VGND.t576 sg13_lv_nmos ad=0.1406p pd=1.12u as=0.1406p ps=1.12u w=0.74u l=0.13u
X707 VPWR.t1906 sg13cmos5l_inv_16_94.A sg13cmos5l_inv_16_73.A VPWR.t9 sg13_lv_pmos ad=0.4368p pd=3.02u as=0.2128p ps=1.5u w=1.12u l=0.13u
X708 VGND.t1067 sg13cmos5l_inv_16_84.A sg13cmos5l_inv_16_85.Y VGND.t1070 sg13_lv_nmos ad=0.1406p pd=1.12u as=0.1406p ps=1.12u w=0.74u l=0.13u
X709 VGND.t1663 sg13cmos5l_inv_16_101.Y sg13cmos5l_inv_16_55.Y VGND.t380 sg13_lv_nmos ad=0.1406p pd=1.12u as=0.1406p ps=1.12u w=0.74u l=0.13u
X710 VGND.t139 sg13cmos5l_inv_16_46.A sg13cmos5l_inv_16_46.Y VGND.t1758 sg13_lv_nmos ad=0.1406p pd=1.12u as=0.1406p ps=1.12u w=0.74u l=0.13u
X711 sg13cmos5l_inv_16_100.Y sg13cmos5l_inv_16_36.A VGND.t139 VGND.t142 sg13_lv_nmos ad=0.1406p pd=1.12u as=0.1406p ps=1.12u w=0.74u l=0.13u
X712 VGND.t738 sg13cmos5l_inv_16_9.A sg13cmos5l_inv_16_9.Y VGND.t737 sg13_lv_nmos ad=0.1406p pd=1.12u as=0.1406p ps=1.12u w=0.74u l=0.13u
X713 sg13cmos5l_inv_16_50.Y sg13cmos5l_inv_16_46.Y VGND.t1944 VGND.t380 sg13_lv_nmos ad=0.1406p pd=1.12u as=0.2516p ps=2.16u w=0.74u l=0.13u
X714 VPWR.t2096 sg13cmos5l_inv_16_48.A sg13cmos5l_inv_16_46.A VPWR.t25 sg13_lv_pmos ad=0.2128p pd=1.5u as=0.2128p ps=1.5u w=1.12u l=0.13u
X715 VGND.t1245 sg13cmos5l_inv_16_27.Y sg13cmos5l_inv_16_43.Y VGND.t1251 sg13_lv_nmos ad=0.1406p pd=1.12u as=0.1406p ps=1.12u w=0.74u l=0.13u
X716 sg13cmos5l_inv_16_84.A sg13cmos5l_inv_16_81.Y VGND.t1026 VGND.t881 sg13_lv_nmos ad=0.1406p pd=1.12u as=0.2516p ps=2.16u w=0.74u l=0.13u
X717 VGND.t953 VPWR.t2542 VGND.t1965 VGND.t380 sg13_lv_nmos ad=79.8f pd=0.8u as=0 ps=0 w=0.42u l=1u
X718 VGND.t609 VPWR.t2536 VGND.t609 VGND.t1999 sg13_lv_nmos ad=0.1428p pd=1.52u as=0 ps=0 w=0.42u l=1u
X719 VGND.t1083 VPWR.t2585 VGND.t1083 VGND.t881 sg13_lv_nmos ad=0.1428p pd=1.52u as=0 ps=0 w=0.42u l=1u
X720 VGND.t432 sg13cmos5l_inv_1_7.Y sg13cmos5l_inv_2_6.Y VGND.t433 sg13_lv_nmos ad=0.2516p pd=2.16u as=0.1406p ps=1.12u w=0.74u l=0.13u
X721 VGND.t1164 sg13cmos5l_inv_16_61.A sg13cmos5l_inv_16_61.Y VGND.t881 sg13_lv_nmos ad=0.1406p pd=1.12u as=0.1406p ps=1.12u w=0.74u l=0.13u
X722 sg13cmos5l_inv_16_71.Y sg13cmos5l_inv_16_56.Y VGND.t963 VGND.t881 sg13_lv_nmos ad=0.1406p pd=1.12u as=0.1406p ps=1.12u w=0.74u l=0.13u
X723 VGND.t1680 sg13cmos5l_inv_16_101.Y sg13cmos5l_inv_16_54.Y VGND.t380 sg13_lv_nmos ad=0.1406p pd=1.12u as=0.1406p ps=1.12u w=0.74u l=0.13u
X724 VPWR.t588 sg13cmos5l_inv_16_36.A sg13cmos5l_inv_16_36.Y VPWR.t4 sg13_lv_pmos ad=0.4368p pd=3.02u as=0.2128p ps=1.5u w=1.12u l=0.13u
X725 sg13cmos5l_inv_16_93.Y sg13cmos5l_inv_16_87.A VGND.t994 VGND.t998 sg13_lv_nmos ad=0.1406p pd=1.12u as=0.1406p ps=1.12u w=0.74u l=0.13u
X726 VPWR.t233 VGND.t635 VPWR.t233 VPWR.t177 sg13_lv_pmos ad=0.34p pd=2.68u as=0 ps=0 w=1u l=1u
X727 VGND.t773 sg13cmos5l_inv_16_99.A sg13cmos5l_inv_16_51.Y VGND.t777 sg13_lv_nmos ad=0.1406p pd=1.12u as=0.1406p ps=1.12u w=0.74u l=0.13u
X728 sg13cmos5l_inv_16_8.Y sg13cmos5l_inv_16_4.Y VPWR.t729 VPWR.t4 sg13_lv_pmos ad=0.2128p pd=1.5u as=0.2128p ps=1.5u w=1.12u l=0.13u
X729 VGND.t1026 sg13cmos5l_inv_16_84.A sg13cmos5l_inv_16_84.Y VGND.t881 sg13_lv_nmos ad=0.1406p pd=1.12u as=0.1406p ps=1.12u w=0.74u l=0.13u
X730 VPWR.t102 VGND.t1970 VPWR.t101 VPWR.t16 sg13_lv_pmos ad=0.34p pd=2.68u as=0 ps=0 w=1u l=1u
X731 sg13cmos5l_inv_16_27.Y sg13cmos5l_inv_16_27.A VPWR.t844 VPWR.t177 sg13_lv_pmos ad=0.2128p pd=1.5u as=0.2128p ps=1.5u w=1.12u l=0.13u
X732 VPWR.t6 VGND.t2045 VPWR.t5 VPWR.t4 sg13_lv_pmos ad=0.19p pd=1.38u as=0 ps=0 w=1u l=1u
X733 VGND.t1334 sg13cmos5l_inv_16_26.A sg13cmos5l_inv_16_26.Y VGND.t1344 sg13_lv_nmos ad=0.2516p pd=2.16u as=0.1406p ps=1.12u w=0.74u l=0.13u
X734 VGND.t2123 sg13cmos5l_inv_8_0.Y sg13cmos5l_inv_16_0.A VGND.t2328 sg13_lv_nmos ad=0.1406p pd=1.12u as=0.1406p ps=1.12u w=0.74u l=0.13u
X735 VPWR.t2250 sg13cmos5l_inv_16_96.Y sg13cmos5l_inv_16_11.A VPWR.t25 sg13_lv_pmos ad=0.4368p pd=3.02u as=0.2128p ps=1.5u w=1.12u l=0.13u
X736 VGND.t1132 VPWR.t2578 VGND.t1132 VGND.t881 sg13_lv_nmos ad=79.8f pd=0.8u as=0 ps=0 w=0.42u l=1u
X737 VPWR.t2195 sg13cmos5l_inv_16_73.Y sg13cmos5l_inv_16_90.Y VPWR.t16 sg13_lv_pmos ad=0.2128p pd=1.5u as=0.2128p ps=1.5u w=1.12u l=0.13u
X738 VPWR.t345 VGND.t390 VPWR.t343 VPWR.t16 sg13_lv_pmos ad=0.19p pd=1.38u as=0 ps=0 w=1u l=1u
X739 sg13cmos5l_inv_16_9.Y sg13cmos5l_inv_16_9.A VGND.t723 VGND.t733 sg13_lv_nmos ad=0.1406p pd=1.12u as=0.1406p ps=1.12u w=0.74u l=0.13u
X740 sg13cmos5l_inv_16_31.Y sg13cmos5l_inv_16_30.A VGND.t326 VGND.t1291 sg13_lv_nmos ad=0.1406p pd=1.12u as=0.1406p ps=1.12u w=0.74u l=0.13u
X741 sg13cmos5l_inv_16_43.Y sg13cmos5l_inv_16_27.Y VGND.t1245 VGND.t1248 sg13_lv_nmos ad=0.1406p pd=1.12u as=0.1406p ps=1.12u w=0.74u l=0.13u
X742 VPWR.t1968 sg13cmos5l_inv_16_67.A sg13cmos5l_inv_16_65.Y VPWR.t9 sg13_lv_pmos ad=0.2128p pd=1.5u as=0.2128p ps=1.5u w=1.12u l=0.13u
X743 sg13cmos5l_inv_16_61.Y sg13cmos5l_inv_16_61.A VGND.t1164 VGND.t881 sg13_lv_nmos ad=0.1406p pd=1.12u as=0.1406p ps=1.12u w=0.74u l=0.13u
X744 sg13cmos5l_inv_16_54.Y sg13cmos5l_inv_16_101.Y VGND.t1680 VGND.t380 sg13_lv_nmos ad=0.1406p pd=1.12u as=0.1406p ps=1.12u w=0.74u l=0.13u
X745 sg13cmos5l_inv_16_15.Y sg13cmos5l_inv_16_15.A VGND.t45 VGND.t515 sg13_lv_nmos ad=0.1406p pd=1.12u as=0.1406p ps=1.12u w=0.74u l=0.13u
X746 sg13cmos5l_inv_16_36.Y sg13cmos5l_inv_16_36.A VPWR.t584 VPWR.t4 sg13_lv_pmos ad=0.2128p pd=1.5u as=0.2128p ps=1.5u w=1.12u l=0.13u
X747 VGND.t916 sg13cmos5l_inv_16_69.Y sg13cmos5l_inv_16_58.Y VGND.t918 sg13_lv_nmos ad=0.1406p pd=1.12u as=0.1406p ps=1.12u w=0.74u l=0.13u
X748 sg13cmos5l_inv_16_85.Y sg13cmos5l_inv_16_84.A VPWR.t1471 VPWR.t9 sg13_lv_pmos ad=0.2128p pd=1.5u as=0.3808p ps=2.92u w=1.12u l=0.13u
X749 VPWR.t22 VGND.t1779 VPWR.t21 VPWR.t16 sg13_lv_pmos ad=0.34p pd=2.68u as=0 ps=0 w=1u l=1u
X750 VPWR.t2142 sg13cmos5l_inv_16_46.A sg13cmos5l_inv_16_46.Y VPWR.t25 sg13_lv_pmos ad=0.3808p pd=2.92u as=0.2128p ps=1.5u w=1.12u l=0.13u
X751 VPWR.t1001 sg13cmos5l_inv_16_6.Y sg13cmos5l_inv_16_108.Y VPWR.t177 sg13_lv_pmos ad=0.2128p pd=1.5u as=0.2128p ps=1.5u w=1.12u l=0.13u
X752 sg13cmos5l_inv_8_2.A sg13cmos5l_inv_2_2.Y VGND.t1381 VGND.t1382 sg13_lv_nmos ad=0.1406p pd=1.12u as=0.1406p ps=1.12u w=0.74u l=0.13u
X753 VGND.t215 sg13cmos5l_inv_16_41.A sg13cmos5l_inv_16_28.A VGND.t237 sg13_lv_nmos ad=0.1406p pd=1.12u as=0.1406p ps=1.12u w=0.74u l=0.13u
X754 sg13cmos5l_inv_16_61.A sg13cmos5l_inv_16_71.Y VGND.t963 VGND.t881 sg13_lv_nmos ad=0.1406p pd=1.12u as=0.1406p ps=1.12u w=0.74u l=0.13u
X755 VPWR.t844 sg13cmos5l_inv_16_27.A sg13cmos5l_inv_16_27.Y VPWR.t177 sg13_lv_pmos ad=0.2128p pd=1.5u as=0.2128p ps=1.5u w=1.12u l=0.13u
X756 VPWR.t968 sg13cmos5l_inv_1_7.A sg13cmos5l_inv_1_7.Y VPWR.t0 sg13_lv_pmos ad=0.3808p pd=2.92u as=0.3808p ps=2.92u w=1.12u l=0.13u
X757 sg13cmos5l_inv_16_0.A sg13cmos5l_inv_8_0.Y VGND.t827 VGND.t2325 sg13_lv_nmos ad=0.1406p pd=1.12u as=0.1406p ps=1.12u w=0.74u l=0.13u
X758 sg13cmos5l_inv_16_90.Y sg13cmos5l_inv_16_73.Y VPWR.t2191 VPWR.t16 sg13_lv_pmos ad=0.2128p pd=1.5u as=0.2128p ps=1.5u w=1.12u l=0.13u
X759 VGND.t545 VPWR.t2516 VGND.t429 VGND.t2033 sg13_lv_nmos ad=79.8f pd=0.8u as=0 ps=0 w=0.42u l=1u
X760 VGND.t146 sg13cmos5l_inv_16_43.Y sg13cmos5l_inv_16_36.A VGND.t188 sg13_lv_nmos ad=0.1406p pd=1.12u as=0.1406p ps=1.12u w=0.74u l=0.13u
X761 VPWR.t1196 sg13cmos5l_inv_16_99.A sg13cmos5l_inv_16_51.Y VPWR.t25 sg13_lv_pmos ad=0.2128p pd=1.5u as=0.2128p ps=1.5u w=1.12u l=0.13u
X762 VGND.t326 sg13cmos5l_inv_16_30.A sg13cmos5l_inv_16_31.Y VGND.t1288 sg13_lv_nmos ad=0.1406p pd=1.12u as=0.1406p ps=1.12u w=0.74u l=0.13u
X763 sg13cmos5l_inv_16_65.Y sg13cmos5l_inv_16_67.A VPWR.t1964 VPWR.t9 sg13_lv_pmos ad=0.2128p pd=1.5u as=0.2128p ps=1.5u w=1.12u l=0.13u
X764 sg13cmos5l_inv_16_66.Y sg13cmos5l_inv_16_68.A VPWR.t1284 VPWR.t9 sg13_lv_pmos ad=0.2128p pd=1.5u as=0.2128p ps=1.5u w=1.12u l=0.13u
X765 VPWR.t707 sg13cmos5l_inv_16_29.A sg13cmos5l_inv_16_29.Y VPWR.t177 sg13_lv_pmos ad=0.2128p pd=1.5u as=0.2128p ps=1.5u w=1.12u l=0.13u
X766 sg13cmos5l_inv_16_46.Y sg13cmos5l_inv_16_46.A VPWR.t2138 VPWR.t25 sg13_lv_pmos ad=0.2128p pd=1.5u as=0.2128p ps=1.5u w=1.12u l=0.13u
X767 VGND.t39 VPWR.t272 VGND.t242 VGND.t2125 sg13_lv_nmos ad=0.1428p pd=1.52u as=0 ps=0 w=0.42u l=1u
X768 VPWR.t1432 sg13cmos5l_inv_16_81.Y sg13cmos5l_inv_16_84.A VPWR.t9 sg13_lv_pmos ad=0.2128p pd=1.5u as=0.2128p ps=1.5u w=1.12u l=0.13u
X769 VPWR.t2338 sg13cmos5l_inv_16_101.Y sg13cmos5l_inv_16_55.Y VPWR.t25 sg13_lv_pmos ad=0.2128p pd=1.5u as=0.2128p ps=1.5u w=1.12u l=0.13u
X770 sg13cmos5l_inv_16_99.Y sg13cmos5l_inv_16_99.A VPWR.t1205 VPWR.t0 sg13_lv_pmos ad=0.2128p pd=1.5u as=0.2128p ps=1.5u w=1.12u l=0.13u
X771 sg13cmos5l_inv_16_8.Y sg13cmos5l_inv_16_4.Y VPWR.t725 VPWR.t4 sg13_lv_pmos ad=0.2128p pd=1.5u as=0.2128p ps=1.5u w=1.12u l=0.13u
X772 VPWR.t2286 osc[2] a_2920_3932# VPWR.t0 sg13_lv_pmos ad=0.2114p pd=1.54u as=0.2856p ps=2.36u w=0.84u l=0.13u
X773 sg13cmos5l_inv_16_14.A sg13cmos5l_inv_16_23.Y VPWR.t508 VPWR.t0 sg13_lv_pmos ad=0.2128p pd=1.5u as=0.2128p ps=1.5u w=1.12u l=0.13u
X774 sg13cmos5l_inv_4_0.Y sg13cmos5l_inv_4_0.A VGND.t588 VGND.t1574 sg13_lv_nmos ad=0.1406p pd=1.12u as=0.2516p ps=2.16u w=0.74u l=0.13u
X775 sg13cmos5l_inv_16_58.Y sg13cmos5l_inv_16_69.Y VPWR.t1320 VPWR.t9 sg13_lv_pmos ad=0.2128p pd=1.5u as=0.2128p ps=1.5u w=1.12u l=0.13u
X776 VGND.t1178 sg13cmos5l_inv_16_61.A sg13cmos5l_inv_16_59.Y VGND.t1180 sg13_lv_nmos ad=0.1406p pd=1.12u as=0.1406p ps=1.12u w=0.74u l=0.13u
X777 sg13cmos5l_inv_16_61.Y sg13cmos5l_inv_16_61.A VPWR.t1590 VPWR.t9 sg13_lv_pmos ad=0.2128p pd=1.5u as=0.2128p ps=1.5u w=1.12u l=0.13u
X778 sg13cmos5l_inv_16_103.Y sg13cmos5l_inv_16_103.A VGND.t345 VGND.t351 sg13_lv_nmos ad=0.1406p pd=1.12u as=0.1406p ps=1.12u w=0.74u l=0.13u
X779 VPWR.t205 VGND.t52 VPWR.t204 VPWR.t4 sg13_lv_pmos ad=0.34p pd=2.68u as=0 ps=0 w=1u l=1u
X780 sg13cmos5l_inv_16_14.Y sg13cmos5l_inv_16_14.A VGND.t45 VGND.t491 sg13_lv_nmos ad=0.1406p pd=1.12u as=0.1406p ps=1.12u w=0.74u l=0.13u
X781 sg13cmos5l_inv_16_51.Y sg13cmos5l_inv_16_99.A VPWR.t1192 VPWR.t25 sg13_lv_pmos ad=0.2128p pd=1.5u as=0.2128p ps=1.5u w=1.12u l=0.13u
X782 sg13cmos5l_inv_16_84.Y sg13cmos5l_inv_16_84.A VPWR.t1500 VPWR.t9 sg13_lv_pmos ad=0.2128p pd=1.5u as=0.2128p ps=1.5u w=1.12u l=0.13u
X783 sg13cmos5l_inv_16_76.A sg13cmos5l_inv_16_94.A VGND.t898 VGND.t881 sg13_lv_nmos ad=0.1406p pd=1.12u as=0.1406p ps=1.12u w=0.74u l=0.13u
X784 sg13cmos5l_inv_16_79.Y sg13cmos5l_inv_16_79.A VPWR.t2168 VPWR.t16 sg13_lv_pmos ad=0.2128p pd=1.5u as=0.2128p ps=1.5u w=1.12u l=0.13u
X785 VGND.t390 sg13cmos5l_inv_16_76.A sg13cmos5l_inv_16_75.A VGND.t380 sg13_lv_nmos ad=0.1406p pd=1.12u as=0.1406p ps=1.12u w=0.74u l=0.13u
X786 sg13cmos5l_inv_16_29.Y sg13cmos5l_inv_16_29.A VPWR.t707 VPWR.t177 sg13_lv_pmos ad=0.2128p pd=1.5u as=0.2128p ps=1.5u w=1.12u l=0.13u
X787 VGND.t588 sg13cmos5l_inv_2_0.A sg13cmos5l_inv_4_0.A VGND.t587 sg13_lv_nmos ad=0.2516p pd=2.16u as=0.1406p ps=1.12u w=0.74u l=0.13u
X788 sg13cmos5l_inv_16_30.Y sg13cmos5l_inv_16_30.A VGND.t343 VGND.t1300 sg13_lv_nmos ad=0.1406p pd=1.12u as=0.1406p ps=1.12u w=0.74u l=0.13u
X789 VGND.t1553 VPWR.t2600 VGND.t1553 VGND.t1888 sg13_lv_nmos ad=79.8f pd=0.8u as=0 ps=0 w=0.42u l=1u
X790 sg13cmos5l_inv_16_88.A sg13cmos5l_inv_4_7.Y VGND.t1201 VGND.t1218 sg13_lv_nmos ad=0.1406p pd=1.12u as=0.2516p ps=2.16u w=0.74u l=0.13u
X791 VPWR.t1118 sg13cmos5l_inv_16_29.A sg13cmos5l_inv_16_35.Y VPWR.t0 sg13_lv_pmos ad=0.4368p pd=3.02u as=0.2128p ps=1.5u w=1.12u l=0.13u
X792 sg13cmos5l_inv_16_59.Y sg13cmos5l_inv_16_61.A VGND.t1166 VGND.t1176 sg13_lv_nmos ad=0.1406p pd=1.12u as=0.1406p ps=1.12u w=0.74u l=0.13u
X793 VPWR.t1588 sg13cmos5l_inv_16_61.A sg13cmos5l_inv_16_61.Y VPWR.t9 sg13_lv_pmos ad=0.2128p pd=1.5u as=0.2128p ps=1.5u w=1.12u l=0.13u
X794 VPWR.t2166 sg13cmos5l_inv_16_79.A sg13cmos5l_inv_16_79.Y VPWR.t16 sg13_lv_pmos ad=0.2128p pd=1.5u as=0.2128p ps=1.5u w=1.12u l=0.13u
X795 sg13cmos5l_inv_16_9.A sg13cmos5l_inv_16_8.Y VPWR.t998 VPWR.t0 sg13_lv_pmos ad=0.2128p pd=1.5u as=0.2128p ps=1.5u w=1.12u l=0.13u
X796 sg13cmos5l_and2_1_2.B a_2920_1632# VGND.t82 VGND.t81 sg13_lv_nmos ad=0.2886p pd=2.26u as=0.14875p ps=1.16u w=0.74u l=0.13u
X797 VPWR.t1383 sg13cmos5l_inv_16_71.Y sg13cmos5l_inv_16_61.A VPWR.t9 sg13_lv_pmos ad=0.4368p pd=3.02u as=0.2128p ps=1.5u w=1.12u l=0.13u
X798 sg13cmos5l_inv_16_44.A sg13cmos5l_inv_16_28.A VPWR.t703 VPWR.t4 sg13_lv_pmos ad=0.2128p pd=1.5u as=0.2128p ps=1.5u w=1.12u l=0.13u
X799 sg13cmos5l_inv_16_75.A sg13cmos5l_inv_16_76.A VGND.t390 VGND.t380 sg13_lv_nmos ad=0.1406p pd=1.12u as=0.2516p ps=2.16u w=0.74u l=0.13u
X800 VGND.t146 sg13cmos5l_inv_16_36.A sg13cmos5l_inv_16_36.Y VGND.t147 sg13_lv_nmos ad=0.1406p pd=1.12u as=0.1406p ps=1.12u w=0.74u l=0.13u
X801 VPWR.t658 sg13cmos5l_inv_16_41.A sg13cmos5l_inv_16_34.Y VPWR.t0 sg13_lv_pmos ad=0.2128p pd=1.5u as=0.2128p ps=1.5u w=1.12u l=0.13u
X802 VGND.t370 sg13cmos5l_inv_16_11.A sg13cmos5l_inv_16_103.A VGND.t372 sg13_lv_nmos ad=0.1406p pd=1.12u as=0.1406p ps=1.12u w=0.74u l=0.13u
X803 VPWR.t917 sg13cmos5l_inv_16_14.A sg13cmos5l_inv_16_14.Y VPWR.t4 sg13_lv_pmos ad=0.2128p pd=1.5u as=0.2128p ps=1.5u w=1.12u l=0.13u
X804 VGND.t864 VPWR.t2604 VGND.t864 VGND.t1877 sg13_lv_nmos ad=79.8f pd=0.8u as=0 ps=0 w=0.42u l=1u
X805 VGND.t1792 sg13cmos5l_inv_16_79.A sg13cmos5l_inv_16_79.Y VGND.t380 sg13_lv_nmos ad=0.2516p pd=2.16u as=0.1406p ps=1.12u w=0.74u l=0.13u
X806 VPWR.t228 VGND.t144 VPWR.t227 VPWR.t0 sg13_lv_pmos ad=0.34p pd=2.68u as=0 ps=0 w=1u l=1u
X807 VGND.t1029 sg13cmos5l_inv_16_81.Y sg13cmos5l_inv_16_84.A VGND.t881 sg13_lv_nmos ad=0.2516p pd=2.16u as=0.1406p ps=1.12u w=0.74u l=0.13u
X808 sg13cmos5l_inv_16_20.A sg13cmos5l_inv_16_8.Y VPWR.t982 VPWR.t0 sg13_lv_pmos ad=0.2128p pd=1.5u as=0.2128p ps=1.5u w=1.12u l=0.13u
X809 sg13cmos5l_inv_2_3.Y sg13cmos5l_inv_1_2.Y VGND.t215 VGND.t583 sg13_lv_nmos ad=0.1406p pd=1.12u as=0.2516p ps=2.16u w=0.74u l=0.13u
X810 sg13cmos5l_inv_16_93.Y sg13cmos5l_inv_16_87.A VPWR.t1399 VPWR.t9 sg13_lv_pmos ad=0.2128p pd=1.5u as=0.3808p ps=2.92u w=1.12u l=0.13u
X811 VGND.t1820 sg13cmos5l_inv_16_73.Y sg13cmos5l_inv_16_90.Y VGND.t881 sg13_lv_nmos ad=0.2516p pd=2.16u as=0.1406p ps=1.12u w=0.74u l=0.13u
X812 VPWR.t2218 sg13cmos5l_inv_16_73.Y sg13cmos5l_inv_16_95.Y VPWR.t16 sg13_lv_pmos ad=0.3808p pd=2.92u as=0.2128p ps=1.5u w=1.12u l=0.13u
X813 sg13cmos5l_inv_16_17.A sg13cmos5l_inv_16_1.A VPWR.t1088 VPWR.t177 sg13_lv_pmos ad=0.2128p pd=1.5u as=0.2128p ps=1.5u w=1.12u l=0.13u
X814 VPWR.t941 sg13cmos5l_inv_16_15.A sg13cmos5l_inv_16_13.Y VPWR.t0 sg13_lv_pmos ad=0.2128p pd=1.5u as=0.2128p ps=1.5u w=1.12u l=0.13u
X815 VGND.t635 VPWR.t2479 VGND.t635 VGND.t2099 sg13_lv_nmos ad=79.8f pd=0.8u as=0 ps=0 w=0.42u l=1u
X816 VGND.t259 VPWR.t2498 VGND.t259 VGND.t2063 sg13_lv_nmos ad=0.1428p pd=1.52u as=0 ps=0 w=0.42u l=1u
X817 sg13cmos5l_inv_16_61.A sg13cmos5l_inv_16_71.Y VPWR.t1379 VPWR.t9 sg13_lv_pmos ad=0.2128p pd=1.5u as=0.2128p ps=1.5u w=1.12u l=0.13u
X818 sg13cmos5l_inv_16_52.Y sg13cmos5l_inv_16_56.Y VGND.t1663 VGND.t380 sg13_lv_nmos ad=0.1406p pd=1.12u as=0.1406p ps=1.12u w=0.74u l=0.13u
X819 sg13cmos5l_inv_16_103.Y sg13cmos5l_inv_16_103.A VGND.t345 VGND.t347 sg13_lv_nmos ad=0.1406p pd=1.12u as=0.1406p ps=1.12u w=0.74u l=0.13u
X820 sg13cmos5l_inv_16_41.A sg13cmos5l_inv_8_3.Y VGND.t226 VGND.t820 sg13_lv_nmos ad=0.1406p pd=1.12u as=0.1406p ps=1.12u w=0.74u l=0.13u
X821 VPWR.t701 sg13cmos5l_inv_16_28.A sg13cmos5l_inv_16_44.A VPWR.t4 sg13_lv_pmos ad=0.2128p pd=1.5u as=0.2128p ps=1.5u w=1.12u l=0.13u
X822 VGND.t1469 sg13cmos5l_inv_16_73.A sg13cmos5l_inv_16_87.A VGND.t1480 sg13_lv_nmos ad=0.1406p pd=1.12u as=0.1406p ps=1.12u w=0.74u l=0.13u
X823 VPWR.t1575 sg13cmos5l_inv_16_61.A sg13cmos5l_inv_16_59.Y VPWR.t9 sg13_lv_pmos ad=0.2128p pd=1.5u as=0.2128p ps=1.5u w=1.12u l=0.13u
X824 sg13cmos5l_inv_16_103.A sg13cmos5l_inv_16_11.A VGND.t291 VGND.t368 sg13_lv_nmos ad=0.1406p pd=1.12u as=0.1406p ps=1.12u w=0.74u l=0.13u
X825 VPWR.t1723 sg13cmos5l_inv_16_26.A sg13cmos5l_inv_16_30.A VPWR.t4 sg13_lv_pmos ad=0.4368p pd=3.02u as=0.2128p ps=1.5u w=1.12u l=0.13u
X826 sg13cmos5l_inv_16_14.Y sg13cmos5l_inv_16_14.A VPWR.t914 VPWR.t4 sg13_lv_pmos ad=0.2128p pd=1.5u as=0.3808p ps=2.92u w=1.12u l=0.13u
X827 sg13cmos5l_inv_16_37.Y sg13cmos5l_inv_16_37.A VGND.t3 VGND.t26 sg13_lv_nmos ad=0.1406p pd=1.12u as=0.1406p ps=1.12u w=0.74u l=0.13u
X828 a_26539_9540# sg13cmos5l_buf_1_0.X a_26445_9540# VGND.t1384 sg13_lv_nmos ad=0.1216p pd=1.02u as=0.2176p ps=1.96u w=0.64u l=0.13u
X829 sg13cmos5l_inv_16_10.Y sg13cmos5l_inv_16_9.A VPWR.t1139 VPWR.t0 sg13_lv_pmos ad=0.2128p pd=1.5u as=0.2128p ps=1.5u w=1.12u l=0.13u
X830 sg13cmos5l_inv_16_27.Y sg13cmos5l_inv_16_27.A VGND.t425 VGND.t1616 sg13_lv_nmos ad=0.1406p pd=1.12u as=0.1406p ps=1.12u w=0.74u l=0.13u
X831 sg13cmos5l_inv_16_0.A sg13cmos5l_inv_8_0.Y VGND.t827 VGND.t2321 sg13_lv_nmos ad=0.1406p pd=1.12u as=0.1406p ps=1.12u w=0.74u l=0.13u
X832 VGND.t635 sg13cmos5l_inv_16_6.Y sg13cmos5l_inv_16_108.Y VGND.t2358 sg13_lv_nmos ad=0.1406p pd=1.12u as=0.1406p ps=1.12u w=0.74u l=0.13u
X833 sg13cmos5l_inv_16_79.Y sg13cmos5l_inv_16_79.A VGND.t1779 VGND.t380 sg13_lv_nmos ad=0.1406p pd=1.12u as=0.1406p ps=1.12u w=0.74u l=0.13u
X834 VPWR.t1937 sg13cmos5l_inv_16_111.A sg13cmos5l_inv_16_98.Y VPWR.t9 sg13_lv_pmos ad=0.2128p pd=1.5u as=0.2128p ps=1.5u w=1.12u l=0.13u
X835 sg13cmos5l_inv_16_79.A sg13cmos5l_inv_16_81.Y VPWR.t1458 VPWR.t16 sg13_lv_pmos ad=0.2128p pd=1.5u as=0.2128p ps=1.5u w=1.12u l=0.13u
X836 VGND.t146 sg13cmos5l_inv_16_43.Y sg13cmos5l_inv_16_36.A VGND.t184 sg13_lv_nmos ad=0.1406p pd=1.12u as=0.1406p ps=1.12u w=0.74u l=0.13u
X837 sg13cmos5l_inv_16_90.Y sg13cmos5l_inv_16_73.Y VGND.t1029 VGND.t881 sg13_lv_nmos ad=0.1406p pd=1.12u as=0.1406p ps=1.12u w=0.74u l=0.13u
X838 VPWR.t2042 sg13cmos5l_inv_16_56.Y sg13cmos5l_inv_16_71.Y VPWR.t16 sg13_lv_pmos ad=0.3808p pd=2.92u as=0.2128p ps=1.5u w=1.12u l=0.13u
X839 sg13cmos5l_inv_16_13.Y sg13cmos5l_inv_16_15.A VPWR.t937 VPWR.t0 sg13_lv_pmos ad=0.2128p pd=1.5u as=0.2128p ps=1.5u w=1.12u l=0.13u
X840 VGND.t1663 sg13cmos5l_inv_16_56.Y sg13cmos5l_inv_16_52.Y VGND.t380 sg13_lv_nmos ad=0.1406p pd=1.12u as=0.1406p ps=1.12u w=0.74u l=0.13u
X841 VGND.t375 sg13cmos5l_inv_16_20.A sg13cmos5l_inv_16_22.Y VGND.t436 sg13_lv_nmos ad=0.1406p pd=1.12u as=0.1406p ps=1.12u w=0.74u l=0.13u
X842 VGND.t375 sg13cmos5l_inv_16_20.A sg13cmos5l_inv_16_20.Y VGND.t463 sg13_lv_nmos ad=0.1406p pd=1.12u as=0.1406p ps=1.12u w=0.74u l=0.13u
X843 VPWR.t1155 sg13cmos5l_inv_16_9.A sg13cmos5l_inv_16_9.Y VPWR.t4 sg13_lv_pmos ad=0.2128p pd=1.5u as=0.2128p ps=1.5u w=1.12u l=0.13u
X844 sg13cmos5l_inv_16_105.A sg13cmos5l_inv_16_11.A VGND.t353 VGND.t356 sg13_lv_nmos ad=0.1406p pd=1.12u as=0.1406p ps=1.12u w=0.74u l=0.13u
X845 VGND.t637 sg13cmos5l_inv_16_5.Y sg13cmos5l_inv_16_110.Y VGND.t643 sg13_lv_nmos ad=0.1406p pd=1.12u as=0.1406p ps=1.12u w=0.74u l=0.13u
X846 sg13cmos5l_inv_16_30.A sg13cmos5l_inv_16_26.A VPWR.t1719 VPWR.t4 sg13_lv_pmos ad=0.2128p pd=1.5u as=0.2128p ps=1.5u w=1.12u l=0.13u
X847 sg13cmos5l_inv_16_111.Y sg13cmos5l_inv_16_111.A VGND.t756 VGND.t380 sg13_lv_nmos ad=0.1406p pd=1.12u as=0.1406p ps=1.12u w=0.74u l=0.13u
X848 VPWR.t1883 sg13cmos5l_inv_16_73.A sg13cmos5l_inv_16_73.Y VPWR.t16 sg13_lv_pmos ad=0.2128p pd=1.5u as=0.2128p ps=1.5u w=1.12u l=0.13u
X849 VGND.t15 sg13cmos5l_inv_16_47.A sg13cmos5l_inv_16_47.Y VGND.t2223 sg13_lv_nmos ad=0.1406p pd=1.12u as=0.1406p ps=1.12u w=0.74u l=0.13u
X850 VGND.t84 sg13cmos5l_inv_8_1.A sg13cmos5l_inv_8_1.Y VGND.t1426 sg13_lv_nmos ad=0.1406p pd=1.12u as=0.1406p ps=1.12u w=0.74u l=0.13u
X851 VGND.t432 sg13cmos5l_inv_4_4.Y sg13cmos5l_inv_8_7.Y VGND.t633 sg13_lv_nmos ad=0.2516p pd=2.16u as=0.1443p ps=1.13u w=0.74u l=0.13u
X852 sg13cmos5l_inv_16_99.Y sg13cmos5l_inv_16_99.A VGND.t773 VGND.t786 sg13_lv_nmos ad=0.1406p pd=1.12u as=0.1406p ps=1.12u w=0.74u l=0.13u
X853 sg13cmos5l_inv_16_14.A sg13cmos5l_inv_16_23.Y VPWR.t504 VPWR.t0 sg13_lv_pmos ad=0.2128p pd=1.5u as=0.2128p ps=1.5u w=1.12u l=0.13u
X854 sg13cmos5l_inv_8_1.Y sg13cmos5l_inv_8_1.A VPWR.t1811 VPWR.t177 sg13_lv_pmos ad=0.2128p pd=1.5u as=0.3808p ps=2.92u w=1.12u l=0.13u
X855 VPWR.t178 sg13cmos5l_inv_16_30.A sg13cmos5l_inv_16_31.Y VPWR.t177 sg13_lv_pmos ad=0.4368p pd=3.02u as=0.2128p ps=1.5u w=1.12u l=0.13u
X856 VPWR.t1456 sg13cmos5l_inv_16_81.Y sg13cmos5l_inv_16_79.A VPWR.t16 sg13_lv_pmos ad=0.2128p pd=1.5u as=0.2128p ps=1.5u w=1.12u l=0.13u
X857 VPWR.t953 sg13cmos5l_inv_16_15.A sg13cmos5l_inv_16_15.Y VPWR.t4 sg13_lv_pmos ad=0.2128p pd=1.5u as=0.2128p ps=1.5u w=1.12u l=0.13u
X858 VPWR.t127 VGND.t922 VPWR.t126 VPWR.t9 sg13_lv_pmos ad=0.34p pd=2.68u as=0 ps=0 w=1u l=1u
X859 VPWR.t157 VGND.t609 VPWR.t402 VPWR.t0 sg13_lv_pmos ad=0.34p pd=2.68u as=0 ps=0 w=1u l=1u
X860 VGND.t122 sg13cmos5l_inv_16_14.A sg13cmos5l_inv_16_104.Y VGND.t469 sg13_lv_nmos ad=0.1406p pd=1.12u as=0.1406p ps=1.12u w=0.74u l=0.13u
X861 sg13cmos5l_inv_16_26.Y sg13cmos5l_inv_16_26.A VGND.t1334 VGND.t1339 sg13_lv_nmos ad=0.1406p pd=1.12u as=0.1406p ps=1.12u w=0.74u l=0.13u
X862 sg13cmos5l_inv_16_17.Y sg13cmos5l_inv_16_17.A VGND.t84 VGND.t105 sg13_lv_nmos ad=0.1406p pd=1.12u as=0.1406p ps=1.12u w=0.74u l=0.13u
X863 VPWR.t935 sg13cmos5l_inv_16_15.A sg13cmos5l_inv_16_13.Y VPWR.t0 sg13_lv_pmos ad=0.2128p pd=1.5u as=0.2128p ps=1.5u w=1.12u l=0.13u
X864 VGND.t343 sg13cmos5l_inv_16_30.A sg13cmos5l_inv_16_30.Y VGND.t1301 sg13_lv_nmos ad=0.1406p pd=1.12u as=0.1406p ps=1.12u w=0.74u l=0.13u
X865 VPWR.t151 VGND.t3 VPWR.t149 VPWR.t4 sg13_lv_pmos ad=0.19p pd=1.38u as=0 ps=0 w=1u l=1u
X866 VPWR.t502 sg13cmos5l_inv_16_23.Y sg13cmos5l_inv_16_15.A VPWR.t0 sg13_lv_pmos ad=0.4368p pd=3.02u as=0.2128p ps=1.5u w=1.12u l=0.13u
X867 VPWR.t2117 sg13cmos5l_inv_16_46.A sg13cmos5l_inv_16_47.A VPWR.t16 sg13_lv_pmos ad=0.2128p pd=1.5u as=0.2128p ps=1.5u w=1.12u l=0.13u
X868 sg13cmos5l_inv_16_29.Y sg13cmos5l_inv_16_29.A VPWR.t707 VPWR.t177 sg13_lv_pmos ad=0.2128p pd=1.5u as=0.2128p ps=1.5u w=1.12u l=0.13u
X869 sg13cmos5l_inv_16_6.Y sg13cmos5l_inv_16_6.A VGND.t1416 VGND.t1417 sg13_lv_nmos ad=0.1406p pd=1.12u as=0.1406p ps=1.12u w=0.74u l=0.13u
X870 sg13cmos5l_inv_16_15.A sg13cmos5l_inv_16_23.Y VGND.t45 VGND.t44 sg13_lv_nmos ad=0.1406p pd=1.12u as=0.2516p ps=2.16u w=0.74u l=0.13u
X871 sg13cmos5l_inv_16_110.Y sg13cmos5l_inv_16_5.Y VGND.t637 VGND.t640 sg13_lv_nmos ad=0.1406p pd=1.12u as=0.1406p ps=1.12u w=0.74u l=0.13u
X872 VGND.t1680 sg13cmos5l_inv_16_53.A sg13cmos5l_inv_16_53.Y VGND.t380 sg13_lv_nmos ad=0.1406p pd=1.12u as=0.1406p ps=1.12u w=0.74u l=0.13u
X873 sg13cmos5l_inv_16_37.Y sg13cmos5l_inv_16_37.A VGND.t3 VGND.t2 sg13_lv_nmos ad=0.1406p pd=1.12u as=0.2516p ps=2.16u w=0.74u l=0.13u
X874 sg13cmos5l_inv_16_79.A sg13cmos5l_inv_16_81.Y VPWR.t1452 VPWR.t16 sg13_lv_pmos ad=0.2128p pd=1.5u as=0.2128p ps=1.5u w=1.12u l=0.13u
X875 sg13cmos5l_inv_16_10.Y sg13cmos5l_inv_16_9.A VPWR.t1136 VPWR.t0 sg13_lv_pmos ad=0.2128p pd=1.5u as=0.3808p ps=2.92u w=1.12u l=0.13u
X876 sg13cmos5l_inv_16_30.Y sg13cmos5l_inv_16_30.A VGND.t343 VGND.t1296 sg13_lv_nmos ad=0.1406p pd=1.12u as=0.1406p ps=1.12u w=0.74u l=0.13u
X877 sg13cmos5l_inv_16_15.Y sg13cmos5l_inv_16_15.A VPWR.t949 VPWR.t4 sg13_lv_pmos ad=0.2128p pd=1.5u as=0.2128p ps=1.5u w=1.12u l=0.13u
X878 VPWR.t1314 sg13cmos5l_inv_16_69.Y sg13cmos5l_inv_16_58.Y VPWR.t9 sg13_lv_pmos ad=0.2128p pd=1.5u as=0.2128p ps=1.5u w=1.12u l=0.13u
X879 VPWR.t1584 sg13cmos5l_inv_16_61.A sg13cmos5l_inv_16_61.Y VPWR.t9 sg13_lv_pmos ad=0.2128p pd=1.5u as=0.2128p ps=1.5u w=1.12u l=0.13u
X880 sg13cmos5l_inv_16_30.Y sg13cmos5l_inv_16_30.A VPWR.t178 VPWR.t177 sg13_lv_pmos ad=0.2128p pd=1.5u as=0.2128p ps=1.5u w=1.12u l=0.13u
X881 VGND.t1411 sg13cmos5l_inv_16_6.A sg13cmos5l_inv_16_6.Y VGND.t1410 sg13_lv_nmos ad=0.1406p pd=1.12u as=0.1406p ps=1.12u w=0.74u l=0.13u
X882 VPWR.t254 VGND.t723 VPWR.t253 VPWR.t4 sg13_lv_pmos ad=0.19p pd=1.38u as=0 ps=0 w=1u l=1u
X883 sg13cmos5l_inv_16_9.A sg13cmos5l_inv_16_8.Y VPWR.t994 VPWR.t0 sg13_lv_pmos ad=0.2128p pd=1.5u as=0.2128p ps=1.5u w=1.12u l=0.13u
X884 sg13cmos5l_inv_16_6.A sg13cmos5l_inv_16_4.Y VPWR.t751 VPWR.t4 sg13_lv_pmos ad=0.2128p pd=1.5u as=0.2128p ps=1.5u w=1.12u l=0.13u
X885 VGND.t198 sg13cmos5l_inv_16_44.A sg13cmos5l_inv_16_44.Y VGND.t207 sg13_lv_nmos ad=0.1406p pd=1.12u as=0.1406p ps=1.12u w=0.74u l=0.13u
X886 sg13cmos5l_inv_16_94.A sg13cmos5l_inv_16_88.A VGND.t898 VGND.t881 sg13_lv_nmos ad=0.1406p pd=1.12u as=0.1406p ps=1.12u w=0.74u l=0.13u
X887 VGND.t1147 sg13cmos5l_inv_16_48.A sg13cmos5l_inv_16_109.Y VGND.t881 sg13_lv_nmos ad=0.1406p pd=1.12u as=0.1406p ps=1.12u w=0.74u l=0.13u
X888 VGND.t1507 sg13cmos5l_inv_16_94.A sg13cmos5l_inv_16_76.A VGND.t881 sg13_lv_nmos ad=0.1406p pd=1.12u as=0.1406p ps=1.12u w=0.74u l=0.13u
X889 VPWR.t2316 sg13cmos5l_inv_16_47.A sg13cmos5l_inv_16_47.Y VPWR.t25 sg13_lv_pmos ad=0.2128p pd=1.5u as=0.2128p ps=1.5u w=1.12u l=0.13u
X890 VGND.t1143 VPWR.t2577 VGND.t1143 VGND.t881 sg13_lv_nmos ad=0.1428p pd=1.52u as=0 ps=0 w=0.42u l=1u
X891 sg13cmos5l_inv_8_7.Y sg13cmos5l_inv_4_4.Y VGND.t432 VGND.t632 sg13_lv_nmos ad=0.1443p pd=1.13u as=0.1406p ps=1.12u w=0.74u l=0.13u
X892 VGND.t2117 VPWR.t2466 VGND.t2117 VGND.t2129 sg13_lv_nmos ad=0.1428p pd=1.52u as=0 ps=0 w=0.42u l=1u
X893 VPWR.t1444 sg13cmos5l_inv_16_81.Y sg13cmos5l_inv_16_84.A VPWR.t9 sg13_lv_pmos ad=0.2128p pd=1.5u as=0.2128p ps=1.5u w=1.12u l=0.13u
X894 sg13cmos5l_inv_16_47.A sg13cmos5l_inv_16_46.A VPWR.t2113 VPWR.t16 sg13_lv_pmos ad=0.2128p pd=1.5u as=0.2128p ps=1.5u w=1.12u l=0.13u
X895 sg13cmos5l_inv_16_45.Y sg13cmos5l_inv_16_47.A VGND.t1715 VGND.t380 sg13_lv_nmos ad=0.1406p pd=1.12u as=0.1406p ps=1.12u w=0.74u l=0.13u
X896 VGND.t705 sg13cmos5l_inv_16_29.A sg13cmos5l_inv_16_29.Y VGND.t706 sg13_lv_nmos ad=0.1406p pd=1.12u as=0.1406p ps=1.12u w=0.74u l=0.13u
X897 VGND.t375 sg13cmos5l_inv_16_20.A sg13cmos5l_inv_16_20.Y VGND.t459 sg13_lv_nmos ad=0.1406p pd=1.12u as=0.1406p ps=1.12u w=0.74u l=0.13u
X898 sg13cmos5l_inv_16_53.Y sg13cmos5l_inv_16_53.A VGND.t1680 VGND.t380 sg13_lv_nmos ad=0.1406p pd=1.12u as=0.1406p ps=1.12u w=0.74u l=0.13u
X899 sg13cmos5l_inv_16_25.Y sg13cmos5l_inv_16_6.Y VGND.t1260 VGND.t2341 sg13_lv_nmos ad=0.1406p pd=1.12u as=0.1406p ps=1.12u w=0.74u l=0.13u
X900 VPWR.t1611 sg13cmos5l_inv_16_103.A sg13cmos5l_inv_16_103.Y VPWR.t0 sg13_lv_pmos ad=0.2128p pd=1.5u as=0.2128p ps=1.5u w=1.12u l=0.13u
X901 VGND.t1067 VPWR.t2597 VGND.t1067 VGND.t1893 sg13_lv_nmos ad=79.8f pd=0.8u as=0 ps=0 w=0.42u l=1u
X902 VPWR.t1945 sg13cmos5l_inv_16_111.A sg13cmos5l_inv_16_111.Y VPWR.t16 sg13_lv_pmos ad=0.2128p pd=1.5u as=0.2128p ps=1.5u w=1.12u l=0.13u
X903 sg13cmos5l_inv_16_77.A sg13cmos5l_inv_16_76.A VGND.t1970 VGND.t380 sg13_lv_nmos ad=0.1406p pd=1.12u as=0.1406p ps=1.12u w=0.74u l=0.13u
X904 VPWR.t315 VGND.t353 VPWR.t313 VPWR.t25 sg13_lv_pmos ad=0.19p pd=1.38u as=0 ps=0 w=1u l=1u
X905 VPWR.t178 sg13cmos5l_inv_16_30.A sg13cmos5l_inv_16_30.Y VPWR.t177 sg13_lv_pmos ad=0.2128p pd=1.5u as=0.2128p ps=1.5u w=1.12u l=0.13u
X906 VPWR.t2291 sg13cmos5l_inv_16_47.A sg13cmos5l_inv_16_45.Y VPWR.t16 sg13_lv_pmos ad=0.2128p pd=1.5u as=0.2128p ps=1.5u w=1.12u l=0.13u
X907 sg13cmos5l_inv_16_47.A sg13cmos5l_inv_16_46.A VGND.t1715 VGND.t380 sg13_lv_nmos ad=0.1406p pd=1.12u as=0.1406p ps=1.12u w=0.74u l=0.13u
X908 VPWR.t689 sg13cmos5l_and2_1_1.B a_20397_1980# VPWR.t177 sg13_lv_pmos ad=0.1918p pd=1.5u as=0.1596p ps=1.22u w=0.84u l=0.13u
X909 VPWR.t749 sg13cmos5l_inv_16_4.Y sg13cmos5l_inv_16_6.A VPWR.t4 sg13_lv_pmos ad=0.2128p pd=1.5u as=0.2128p ps=1.5u w=1.12u l=0.13u
X910 sg13cmos5l_inv_16_44.Y sg13cmos5l_inv_16_44.A VGND.t198 VGND.t204 sg13_lv_nmos ad=0.1406p pd=1.12u as=0.1406p ps=1.12u w=0.74u l=0.13u
X911 VGND.t898 sg13cmos5l_inv_16_88.A sg13cmos5l_inv_16_94.A VGND.t881 sg13_lv_nmos ad=0.1406p pd=1.12u as=0.1406p ps=1.12u w=0.74u l=0.13u
X912 sg13cmos5l_inv_16_109.Y sg13cmos5l_inv_16_48.A VGND.t1147 VGND.t881 sg13_lv_nmos ad=0.1406p pd=1.12u as=0.2516p ps=2.16u w=0.74u l=0.13u
X913 sg13cmos5l_inv_16_54.Y sg13cmos5l_inv_16_101.Y VGND.t1679 VGND.t380 sg13_lv_nmos ad=0.1406p pd=1.12u as=0.2516p ps=2.16u w=0.74u l=0.13u
X914 sg13cmos5l_inv_16_47.Y sg13cmos5l_inv_16_47.A VPWR.t2312 VPWR.t25 sg13_lv_pmos ad=0.2128p pd=1.5u as=0.2128p ps=1.5u w=1.12u l=0.13u
X915 VGND.t425 sg13cmos5l_inv_16_27.A sg13cmos5l_inv_16_27.Y VGND.t1617 sg13_lv_nmos ad=0.1406p pd=1.12u as=0.1406p ps=1.12u w=0.74u l=0.13u
X916 VPWR.t1571 sg13cmos5l_inv_16_61.A sg13cmos5l_inv_16_59.Y VPWR.t9 sg13_lv_pmos ad=0.2128p pd=1.5u as=0.2128p ps=1.5u w=1.12u l=0.13u
X917 VGND.t1715 sg13cmos5l_inv_16_47.A sg13cmos5l_inv_16_45.Y VGND.t380 sg13_lv_nmos ad=0.1406p pd=1.12u as=0.1406p ps=1.12u w=0.74u l=0.13u
X918 sg13cmos5l_inv_16_48.A sg13cmos5l_inv_8_7.Y VPWR.t1183 VPWR.t25 sg13_lv_pmos ad=0.2128p pd=1.5u as=0.2128p ps=1.5u w=1.12u l=0.13u
X919 sg13cmos5l_inv_16_77.Y sg13cmos5l_inv_16_77.A VGND.t472 VGND.t2174 sg13_lv_nmos ad=0.1406p pd=1.12u as=0.1406p ps=1.12u w=0.74u l=0.13u
X920 sg13cmos5l_inv_16_101.Y sg13cmos5l_inv_16_34.Y VPWR.t1031 VPWR.t0 sg13_lv_pmos ad=0.2128p pd=1.5u as=0.3808p ps=2.92u w=1.12u l=0.13u
X921 VPWR.t570 sg13cmos5l_inv_16_36.A sg13cmos5l_inv_16_100.Y VPWR.t0 sg13_lv_pmos ad=0.2128p pd=1.5u as=0.2128p ps=1.5u w=1.12u l=0.13u
X922 sg13cmos5l_inv_16_111.A sg13cmos5l_inv_16_109.Y VGND.t1147 VGND.t881 sg13_lv_nmos ad=0.1406p pd=1.12u as=0.1406p ps=1.12u w=0.74u l=0.13u
X923 sg13cmos5l_inv_16_68.A sg13cmos5l_inv_16_71.Y VGND.t882 VGND.t881 sg13_lv_nmos ad=0.1406p pd=1.12u as=0.1406p ps=1.12u w=0.74u l=0.13u
X924 VGND.t381 sg13cmos5l_inv_1_5.Y sg13cmos5l_inv_4_6.A VGND.t380 sg13_lv_nmos ad=0.2516p pd=2.16u as=0.1406p ps=1.12u w=0.74u l=0.13u
X925 VPWR.t352 VGND.t1792 VPWR.t350 VPWR.t16 sg13_lv_pmos ad=0.19p pd=1.38u as=0 ps=0 w=1u l=1u
X926 VPWR.t2038 sg13cmos5l_inv_16_56.Y sg13cmos5l_inv_16_71.Y VPWR.t16 sg13_lv_pmos ad=0.2128p pd=1.5u as=0.2128p ps=1.5u w=1.12u l=0.13u
X927 sg13cmos5l_inv_16_111.Y sg13cmos5l_inv_16_111.A VPWR.t1941 VPWR.t16 sg13_lv_pmos ad=0.2128p pd=1.5u as=0.2128p ps=1.5u w=1.12u l=0.13u
X928 VGND.t1970 sg13cmos5l_inv_16_76.A sg13cmos5l_inv_16_77.A VGND.t380 sg13_lv_nmos ad=0.1406p pd=1.12u as=0.1406p ps=1.12u w=0.74u l=0.13u
X929 VPWR.t2368 sg13cmos5l_inv_8_4.Y sg13cmos5l_inv_16_56.Y VPWR.t25 sg13_lv_pmos ad=0.2128p pd=1.5u as=0.2128p ps=1.5u w=1.12u l=0.13u
X930 sg13cmos5l_inv_16_30.Y sg13cmos5l_inv_16_30.A VPWR.t480 VPWR.t177 sg13_lv_pmos ad=0.2128p pd=1.5u as=0.2128p ps=1.5u w=1.12u l=0.13u
X931 sg13cmos5l_inv_16_27.Y sg13cmos5l_inv_16_27.A VGND.t425 VGND.t1612 sg13_lv_nmos ad=0.1406p pd=1.12u as=0.2516p ps=2.16u w=0.74u l=0.13u
X932 sg13cmos5l_inv_16_94.A sg13cmos5l_inv_16_88.A VGND.t898 VGND.t881 sg13_lv_nmos ad=0.1406p pd=1.12u as=0.1406p ps=1.12u w=0.74u l=0.13u
X933 sg13cmos5l_inv_16_45.Y sg13cmos5l_inv_16_47.A VPWR.t2288 VPWR.t16 sg13_lv_pmos ad=0.2128p pd=1.5u as=0.3808p ps=2.92u w=1.12u l=0.13u
X934 VGND.t635 VPWR.t2478 VGND.t635 VGND.t2101 sg13_lv_nmos ad=79.8f pd=0.8u as=0 ps=0 w=0.42u l=1u
X935 sg13cmos5l_inv_16_20.Y sg13cmos5l_inv_16_20.A VPWR.t885 VPWR.t4 sg13_lv_pmos ad=0.2128p pd=1.5u as=0.2128p ps=1.5u w=1.12u l=0.13u
X936 VGND.t2045 VPWR.t2497 VGND.t2045 VGND.t2044 sg13_lv_nmos ad=0.1428p pd=1.52u as=0 ps=0 w=0.42u l=1u
X937 VPWR.t100 VGND.t1965 VPWR.t96 VPWR.t25 sg13_lv_pmos ad=0.19p pd=1.38u as=0 ps=0 w=1u l=1u
X938 VPWR.t480 sg13cmos5l_inv_2_3.Y sg13cmos5l_inv_4_2.Y VPWR.t177 sg13_lv_pmos ad=0.2128p pd=1.5u as=0.2128p ps=1.5u w=1.12u l=0.13u
X939 VGND.t221 sg13cmos5l_inv_8_3.Y sg13cmos5l_inv_16_41.A VGND.t813 sg13_lv_nmos ad=0.1406p pd=1.12u as=0.1406p ps=1.12u w=0.74u l=0.13u
X940 VPWR.t92 VGND.t953 VPWR.t91 VPWR.t16 sg13_lv_pmos ad=0.34p pd=2.68u as=0 ps=0 w=1u l=1u
X941 VGND.t953 VPWR.t2558 VGND.t953 VGND.t380 sg13_lv_nmos ad=0.1428p pd=1.52u as=0 ps=0 w=0.42u l=1u
X942 VPWR.t388 VGND.t635 VPWR.t385 VPWR.t4 sg13_lv_pmos ad=0.19p pd=1.38u as=0 ps=0 w=1u l=1u
X943 sg13cmos5l_inv_16_87.A sg13cmos5l_inv_16_73.A VGND.t1469 VGND.t1473 sg13_lv_nmos ad=0.1406p pd=1.12u as=0.1406p ps=1.12u w=0.74u l=0.13u
X944 sg13cmos5l_inv_16_26.A sg13cmos5l_inv_16_27.Y VGND.t1243 VGND.t1269 sg13_lv_nmos ad=0.1406p pd=1.12u as=0.1406p ps=1.12u w=0.74u l=0.13u
X945 sg13cmos5l_inv_16_59.Y sg13cmos5l_inv_16_61.A VPWR.t1568 VPWR.t9 sg13_lv_pmos ad=0.2128p pd=1.5u as=0.3808p ps=2.92u w=1.12u l=0.13u
X946 sg13cmos5l_inv_16_105.A sg13cmos5l_inv_16_11.A VGND.t345 VGND.t351 sg13_lv_nmos ad=0.1406p pd=1.12u as=0.1406p ps=1.12u w=0.74u l=0.13u
X947 sg13cmos5l_inv_16_0.A sg13cmos5l_inv_8_0.Y VPWR.t2417 VPWR.t177 sg13_lv_pmos ad=0.2128p pd=1.5u as=0.2128p ps=1.5u w=1.12u l=0.13u
X948 sg13cmos5l_inv_16_111.Y sg13cmos5l_inv_16_111.A VGND.t756 VGND.t380 sg13_lv_nmos ad=0.1406p pd=1.12u as=0.1406p ps=1.12u w=0.74u l=0.13u
X949 sg13cmos5l_inv_16_108.Y sg13cmos5l_inv_16_6.Y VGND.t635 VGND.t2351 sg13_lv_nmos ad=0.1406p pd=1.12u as=0.1406p ps=1.12u w=0.74u l=0.13u
X950 sg13cmos5l_inv_16_30.A sg13cmos5l_inv_16_26.A VPWR.t1715 VPWR.t4 sg13_lv_pmos ad=0.2128p pd=1.5u as=0.2128p ps=1.5u w=1.12u l=0.13u
X951 VGND.t1147 sg13cmos5l_inv_16_109.Y sg13cmos5l_inv_16_111.A VGND.t881 sg13_lv_nmos ad=0.1406p pd=1.12u as=0.1406p ps=1.12u w=0.74u l=0.13u
X952 VPWR.t2026 sg13cmos5l_inv_16_88.A sg13cmos5l_inv_16_94.A VPWR.t9 sg13_lv_pmos ad=0.3808p pd=2.92u as=0.2128p ps=1.5u w=1.12u l=0.13u
X953 VGND.t882 sg13cmos5l_inv_16_68.A sg13cmos5l_inv_16_68.Y VGND.t881 sg13_lv_nmos ad=0.1406p pd=1.12u as=0.1406p ps=1.12u w=0.74u l=0.13u
X954 VPWR.t1169 VGND.t1663 VPWR.t70 VPWR.t16 sg13_lv_pmos ad=0.34p pd=2.68u as=0 ps=0 w=1u l=1u
X955 VPWR.t1366 sg13cmos5l_inv_4_6.Y sg13cmos5l_inv_16_96.A VPWR.t25 sg13_lv_pmos ad=0.3808p pd=2.92u as=0.2128p ps=1.5u w=1.12u l=0.13u
X956 VPWR.t178 sg13cmos5l_inv_16_30.A sg13cmos5l_inv_16_31.Y VPWR.t177 sg13_lv_pmos ad=0.2128p pd=1.5u as=0.2128p ps=1.5u w=1.12u l=0.13u
X957 VGND.t122 sg13cmos5l_inv_4_6.A sg13cmos5l_inv_4_6.Y VGND.t806 sg13_lv_nmos ad=0.1406p pd=1.12u as=0.1406p ps=1.12u w=0.74u l=0.13u
X958 sg13cmos5l_inv_16_25.Y sg13cmos5l_inv_16_6.Y VGND.t1245 VGND.t2337 sg13_lv_nmos ad=0.1406p pd=1.12u as=0.1406p ps=1.12u w=0.74u l=0.13u
X959 sg13cmos5l_inv_16_77.A sg13cmos5l_inv_16_76.A VGND.t390 VGND.t380 sg13_lv_nmos ad=0.1406p pd=1.12u as=0.1406p ps=1.12u w=0.74u l=0.13u
X960 sg13cmos5l_inv_16_51.Y sg13cmos5l_inv_16_99.A VPWR.t1189 VPWR.t25 sg13_lv_pmos ad=0.2128p pd=1.5u as=0.3808p ps=2.92u w=1.12u l=0.13u
X961 VPWR.t1607 sg13cmos5l_inv_16_103.A sg13cmos5l_inv_16_103.Y VPWR.t0 sg13_lv_pmos ad=0.2128p pd=1.5u as=0.2128p ps=1.5u w=1.12u l=0.13u
X962 VPWR.t1077 sg13cmos5l_inv_16_1.A sg13cmos5l_inv_16_2.A VPWR.t4 sg13_lv_pmos ad=0.2128p pd=1.5u as=0.2128p ps=1.5u w=1.12u l=0.13u
X963 sg13cmos5l_inv_16_2.A sg13cmos5l_inv_16_1.A VGND.t655 VGND.t669 sg13_lv_nmos ad=0.1406p pd=1.12u as=0.1406p ps=1.12u w=0.74u l=0.13u
X964 VGND.t827 sg13cmos5l_inv_16_0.A sg13cmos5l_inv_16_23.Y VGND.t832 sg13_lv_nmos ad=0.1406p pd=1.12u as=0.1406p ps=1.12u w=0.74u l=0.13u
X965 VPWR.t2415 sg13cmos5l_inv_8_0.Y sg13cmos5l_inv_16_0.A VPWR.t177 sg13_lv_pmos ad=0.2128p pd=1.5u as=0.2128p ps=1.5u w=1.12u l=0.13u
X966 VGND.t1243 sg13cmos5l_inv_16_27.Y sg13cmos5l_inv_16_26.A VGND.t1266 sg13_lv_nmos ad=0.1406p pd=1.12u as=0.1406p ps=1.12u w=0.74u l=0.13u
X967 VGND.t3 VPWR.t2494 VGND.t3 VGND.t2070 sg13_lv_nmos ad=0.1428p pd=1.52u as=0 ps=0 w=0.42u l=1u
X968 sg13cmos5l_inv_16_94.A sg13cmos5l_inv_16_88.A VPWR.t2022 VPWR.t9 sg13_lv_pmos ad=0.2128p pd=1.5u as=0.2128p ps=1.5u w=1.12u l=0.13u
X969 VPWR.t371 VGND.t217 VPWR.t370 VPWR.t0 sg13_lv_pmos ad=0.34p pd=2.68u as=0 ps=0 w=1u l=1u
X970 sg13cmos5l_inv_16_27.A sg13cmos5l_inv_8_2.A VGND.t575 VGND.t577 sg13_lv_nmos ad=0.1406p pd=1.12u as=0.1406p ps=1.12u w=0.74u l=0.13u
X971 sg13cmos5l_inv_16_31.Y sg13cmos5l_inv_16_30.A VPWR.t480 VPWR.t177 sg13_lv_pmos ad=0.2128p pd=1.5u as=0.2128p ps=1.5u w=1.12u l=0.13u
X972 sg13cmos5l_inv_16_41.A sg13cmos5l_inv_8_3.Y VPWR.t1225 VPWR.t4 sg13_lv_pmos ad=0.2128p pd=1.5u as=0.3808p ps=2.92u w=1.12u l=0.13u
X973 sg13cmos5l_inv_16_96.A sg13cmos5l_inv_4_6.Y VPWR.t1362 VPWR.t25 sg13_lv_pmos ad=0.2128p pd=1.5u as=0.2128p ps=1.5u w=1.12u l=0.13u
X974 sg13cmos5l_inv_16_1.A sg13cmos5l_inv_16_0.A VGND.t845 VGND.t846 sg13_lv_nmos ad=0.1406p pd=1.12u as=0.1406p ps=1.12u w=0.74u l=0.13u
X975 VPWR.t1855 sg13cmos5l_inv_16_73.A sg13cmos5l_inv_16_87.A VPWR.t9 sg13_lv_pmos ad=0.2128p pd=1.5u as=0.2128p ps=1.5u w=1.12u l=0.13u
X976 VGND.t1245 sg13cmos5l_inv_16_6.Y sg13cmos5l_inv_16_25.Y VGND.t2334 sg13_lv_nmos ad=0.1406p pd=1.12u as=0.1406p ps=1.12u w=0.74u l=0.13u
X977 VGND.t1718 sg13cmos5l_inv_16_48.A sg13cmos5l_inv_16_46.A VGND.t380 sg13_lv_nmos ad=0.1406p pd=1.12u as=0.1406p ps=1.12u w=0.74u l=0.13u
X978 VPWR.t159 VGND.t5 VPWR.t158 VPWR.t0 sg13_lv_pmos ad=0.34p pd=2.68u as=0 ps=0 w=1u l=1u
X979 VGND.t2136 VPWR.t178 VGND.t414 VGND.t2137 sg13_lv_nmos ad=79.8f pd=0.8u as=0 ps=0 w=0.42u l=1u
X980 sg13cmos5l_inv_16_2.A sg13cmos5l_inv_16_1.A VPWR.t1073 VPWR.t4 sg13_lv_pmos ad=0.2128p pd=1.5u as=0.2128p ps=1.5u w=1.12u l=0.13u
X981 VPWR.t2264 sg13cmos5l_inv_16_77.A sg13cmos5l_inv_16_77.Y VPWR.t25 sg13_lv_pmos ad=0.2128p pd=1.5u as=0.2128p ps=1.5u w=1.12u l=0.13u
X982 VGND.t655 sg13cmos5l_inv_16_1.A sg13cmos5l_inv_16_2.A VGND.t666 sg13_lv_nmos ad=0.1406p pd=1.12u as=0.1406p ps=1.12u w=0.74u l=0.13u
X983 VPWR.t1557 sg13cmos5l_inv_16_109.Y sg13cmos5l_inv_16_111.A VPWR.t9 sg13_lv_pmos ad=0.2128p pd=1.5u as=0.2128p ps=1.5u w=1.12u l=0.13u
X984 sg13cmos5l_inv_16_53.A sg13cmos5l_inv_16_52.Y VGND.t1164 VGND.t881 sg13_lv_nmos ad=0.1406p pd=1.12u as=0.1406p ps=1.12u w=0.74u l=0.13u
X985 sg13cmos5l_inv_8_7.Y sg13cmos5l_inv_4_4.Y VGND.t432 VGND.t628 sg13_lv_nmos ad=0.1406p pd=1.12u as=0.1406p ps=1.12u w=0.74u l=0.13u
X986 sg13cmos5l_inv_16_96.Y sg13cmos5l_inv_16_96.A VGND.t545 VGND.t943 sg13_lv_nmos ad=0.1406p pd=1.12u as=0.1406p ps=1.12u w=0.74u l=0.13u
X987 VGND.t1083 sg13cmos5l_inv_16_79.A sg13cmos5l_inv_16_91.Y VGND.t881 sg13_lv_nmos ad=0.1406p pd=1.12u as=0.1406p ps=1.12u w=0.74u l=0.13u
X988 sg13cmos5l_inv_4_5.Y sg13cmos5l_inv_2_7.Y VGND.t5 VGND.t417 sg13_lv_nmos ad=0.1406p pd=1.12u as=0.1406p ps=1.12u w=0.74u l=0.13u
X989 VGND.t1067 sg13cmos5l_inv_16_84.A sg13cmos5l_inv_16_85.Y VGND.t1080 sg13_lv_nmos ad=0.1406p pd=1.12u as=0.1406p ps=1.12u w=0.74u l=0.13u
X990 sg13cmos5l_inv_16_67.A sg13cmos5l_inv_16_109.Y VPWR.t1537 VPWR.t9 sg13_lv_pmos ad=0.2128p pd=1.5u as=0.3808p ps=2.92u w=1.12u l=0.13u
X991 VPWR.t1219 sg13cmos5l_inv_16_99.A sg13cmos5l_inv_16_99.Y VPWR.t0 sg13_lv_pmos ad=0.4368p pd=3.02u as=0.2128p ps=1.5u w=1.12u l=0.13u
X992 sg13cmos5l_inv_16_105.A sg13cmos5l_inv_16_11.A VGND.t345 VGND.t347 sg13_lv_nmos ad=0.1406p pd=1.12u as=0.1406p ps=1.12u w=0.74u l=0.13u
X993 sg13cmos5l_inv_16_73.Y sg13cmos5l_inv_16_73.A VGND.t381 VGND.t380 sg13_lv_nmos ad=0.1406p pd=1.12u as=0.1406p ps=1.12u w=0.74u l=0.13u
X994 sg13cmos5l_inv_16_104.Y sg13cmos5l_inv_16_14.A VPWR.t901 VPWR.t0 sg13_lv_pmos ad=0.2128p pd=1.5u as=0.2128p ps=1.5u w=1.12u l=0.13u
X995 sg13cmos5l_inv_16_6.Y sg13cmos5l_inv_16_6.A VPWR.t246 VPWR.t177 sg13_lv_pmos ad=0.2128p pd=1.5u as=0.2128p ps=1.5u w=1.12u l=0.13u
X996 VGND.t198 sg13cmos5l_inv_16_28.A sg13cmos5l_inv_16_29.A VGND.t207 sg13_lv_nmos ad=0.1406p pd=1.12u as=0.1406p ps=1.12u w=0.74u l=0.13u
X997 VGND.t882 sg13cmos5l_inv_16_68.A sg13cmos5l_inv_16_68.Y VGND.t881 sg13_lv_nmos ad=0.1406p pd=1.12u as=0.1406p ps=1.12u w=0.74u l=0.13u
X998 VGND.t1236 sg13cmos5l_inv_4_2.Y sg13cmos5l_inv_8_3.Y VGND.t1238 sg13_lv_nmos ad=0.1406p pd=1.12u as=0.1406p ps=1.12u w=0.74u l=0.13u
X999 VPWR.t1920 sg13cmos5l_inv_16_94.A sg13cmos5l_inv_16_76.A VPWR.t16 sg13_lv_pmos ad=0.2128p pd=1.5u as=0.2128p ps=1.5u w=1.12u l=0.13u
X1000 VPWR.t778 sg13cmos5l_inv_16_11.A sg13cmos5l_inv_16_105.A VPWR.t25 sg13_lv_pmos ad=0.2128p pd=1.5u as=0.2128p ps=1.5u w=1.12u l=0.13u
X1001 VPWR.t604 sg13cmos5l_inv_16_43.Y sg13cmos5l_inv_16_37.A VPWR.t0 sg13_lv_pmos ad=0.4368p pd=3.02u as=0.2128p ps=1.5u w=1.12u l=0.13u
X1002 sg13cmos5l_inv_16_44.Y sg13cmos5l_inv_16_44.A VGND.t198 VGND.t200 sg13_lv_nmos ad=0.1406p pd=1.12u as=0.1406p ps=1.12u w=0.74u l=0.13u
X1003 VGND.t545 sg13cmos5l_inv_16_96.A sg13cmos5l_inv_16_96.Y VGND.t940 sg13_lv_nmos ad=0.1406p pd=1.12u as=0.1406p ps=1.12u w=0.74u l=0.13u
X1004 sg13cmos5l_inv_16_91.Y sg13cmos5l_inv_16_79.A VGND.t1083 VGND.t881 sg13_lv_nmos ad=0.1406p pd=1.12u as=0.1406p ps=1.12u w=0.74u l=0.13u
X1005 sg13cmos5l_inv_16_48.A sg13cmos5l_inv_8_7.Y VPWR.t1179 VPWR.t25 sg13_lv_pmos ad=0.2128p pd=1.5u as=0.2128p ps=1.5u w=1.12u l=0.13u
X1006 sg13cmos5l_inv_16_101.Y sg13cmos5l_inv_16_34.Y VGND.t593 VGND.t603 sg13_lv_nmos ad=0.1406p pd=1.12u as=0.1406p ps=1.12u w=0.74u l=0.13u
X1007 VPWR.t1648 sg13cmos5l_inv_16_27.Y sg13cmos5l_inv_16_43.Y VPWR.t4 sg13_lv_pmos ad=0.2128p pd=1.5u as=0.2128p ps=1.5u w=1.12u l=0.13u
X1008 sg13cmos5l_inv_16_96.Y sg13cmos5l_inv_16_96.A VPWR.t1352 VPWR.t25 sg13_lv_pmos ad=0.2128p pd=1.5u as=0.2128p ps=1.5u w=1.12u l=0.13u
X1009 VPWR.t246 sg13cmos5l_inv_16_6.A sg13cmos5l_inv_16_6.Y VPWR.t177 sg13_lv_pmos ad=0.2128p pd=1.5u as=0.2128p ps=1.5u w=1.12u l=0.13u
X1010 sg13cmos5l_inv_16_29.A sg13cmos5l_inv_16_28.A VGND.t198 VGND.t204 sg13_lv_nmos ad=0.1406p pd=1.12u as=0.1406p ps=1.12u w=0.74u l=0.13u
X1011 sg13cmos5l_inv_8_3.Y sg13cmos5l_inv_4_2.Y VGND.t39 VGND.t1234 sg13_lv_nmos ad=0.1406p pd=1.12u as=0.1406p ps=1.12u w=0.74u l=0.13u
X1012 sg13cmos5l_inv_16_85.Y sg13cmos5l_inv_16_84.A VPWR.t1480 VPWR.t9 sg13_lv_pmos ad=0.2128p pd=1.5u as=0.2128p ps=1.5u w=1.12u l=0.13u
X1013 sg13cmos5l_inv_16_76.A sg13cmos5l_inv_16_94.A VPWR.t1916 VPWR.t16 sg13_lv_pmos ad=0.2128p pd=1.5u as=0.2128p ps=1.5u w=1.12u l=0.13u
X1014 VGND.t146 sg13cmos5l_inv_16_43.Y sg13cmos5l_inv_16_37.A VGND.t172 sg13_lv_nmos ad=0.1406p pd=1.12u as=0.1406p ps=1.12u w=0.74u l=0.13u
X1015 sg13cmos5l_inv_16_26.Y sg13cmos5l_inv_16_26.A VPWR.t767 VPWR.t177 sg13_lv_pmos ad=0.2128p pd=1.5u as=0.2128p ps=1.5u w=1.12u l=0.13u
X1016 sg13cmos5l_inv_16_20.Y sg13cmos5l_inv_16_20.A VPWR.t866 VPWR.t4 sg13_lv_pmos ad=0.2128p pd=1.5u as=0.3808p ps=2.92u w=1.12u l=0.13u
X1017 VPWR.t480 en[1] a_4744_908# VPWR.t177 sg13_lv_pmos ad=0.2114p pd=1.54u as=0.2856p ps=2.36u w=0.84u l=0.13u
X1018 VGND.t994 sg13cmos5l_inv_16_87.A sg13cmos5l_inv_16_93.Y VGND.t1007 sg13_lv_nmos ad=0.1406p pd=1.12u as=0.1406p ps=1.12u w=0.74u l=0.13u
X1019 VPWR.t1386 sg13cmos5l_inv_16_71.Y sg13cmos5l_inv_16_68.A VPWR.t9 sg13_lv_pmos ad=0.2128p pd=1.5u as=0.2128p ps=1.5u w=1.12u l=0.13u
X1020 VPWR.t2277 sg13cmos5l_inv_16_46.Y sg13cmos5l_inv_16_50.Y VPWR.t25 sg13_lv_pmos ad=0.2128p pd=1.5u as=0.2128p ps=1.5u w=1.12u l=0.13u
X1021 VPWR.t844 sg13cmos5l_inv_16_27.A sg13cmos5l_inv_16_27.Y VPWR.t177 sg13_lv_pmos ad=0.2128p pd=1.5u as=0.2128p ps=1.5u w=1.12u l=0.13u
X1022 sg13cmos5l_inv_16_51.Y sg13cmos5l_inv_16_99.A VGND.t773 VGND.t786 sg13_lv_nmos ad=0.1406p pd=1.12u as=0.1406p ps=1.12u w=0.74u l=0.13u
X1023 VGND.t1083 sg13cmos5l_inv_16_79.A sg13cmos5l_inv_16_91.Y VGND.t881 sg13_lv_nmos ad=0.1406p pd=1.12u as=0.1406p ps=1.12u w=0.74u l=0.13u
X1024 VPWR.t1177 sg13cmos5l_inv_8_7.Y sg13cmos5l_inv_16_48.A VPWR.t25 sg13_lv_pmos ad=0.2128p pd=1.5u as=0.2128p ps=1.5u w=1.12u l=0.13u
X1025 sg13cmos5l_inv_16_43.Y sg13cmos5l_inv_16_27.Y VPWR.t1644 VPWR.t4 sg13_lv_pmos ad=0.2128p pd=1.5u as=0.2128p ps=1.5u w=1.12u l=0.13u
X1026 sg13cmos5l_inv_16_65.Y sg13cmos5l_inv_16_67.A VPWR.t1974 VPWR.t9 sg13_lv_pmos ad=0.2128p pd=1.5u as=0.2128p ps=1.5u w=1.12u l=0.13u
X1027 VPWR.t2102 sg13cmos5l_inv_16_48.A sg13cmos5l_inv_16_46.A VPWR.t25 sg13_lv_pmos ad=0.2128p pd=1.5u as=0.2128p ps=1.5u w=1.12u l=0.13u
X1028 VPWR.t1050 sg13cmos5l_inv_4_4.Y sg13cmos5l_inv_8_7.Y VPWR.t25 sg13_lv_pmos ad=0.2128p pd=1.5u as=0.2128p ps=1.5u w=1.12u l=0.13u
X1029 VPWR.t1350 sg13cmos5l_inv_16_96.A sg13cmos5l_inv_16_96.Y VPWR.t25 sg13_lv_pmos ad=0.2128p pd=1.5u as=0.2128p ps=1.5u w=1.12u l=0.13u
X1030 VGND.t1245 sg13cmos5l_inv_16_27.Y sg13cmos5l_inv_16_43.Y VGND.t1257 sg13_lv_nmos ad=0.1406p pd=1.12u as=0.1406p ps=1.12u w=0.74u l=0.13u
X1031 sg13cmos5l_inv_16_75.Y sg13cmos5l_inv_16_75.A VGND.t122 VGND.t399 sg13_lv_nmos ad=0.1406p pd=1.12u as=0.1406p ps=1.12u w=0.74u l=0.13u
X1032 sg13cmos5l_inv_16_37.A sg13cmos5l_inv_16_43.Y VGND.t3 VGND.t169 sg13_lv_nmos ad=0.1406p pd=1.12u as=0.1406p ps=1.12u w=0.74u l=0.13u
X1033 sg13cmos5l_inv_16_103.A sg13cmos5l_inv_16_11.A VPWR.t787 VPWR.t0 sg13_lv_pmos ad=0.2128p pd=1.5u as=0.3808p ps=2.92u w=1.12u l=0.13u
X1034 VGND.t1164 sg13cmos5l_inv_16_61.A sg13cmos5l_inv_16_61.Y VGND.t881 sg13_lv_nmos ad=0.1406p pd=1.12u as=0.1406p ps=1.12u w=0.74u l=0.13u
X1035 VGND.t1680 sg13cmos5l_inv_16_101.Y sg13cmos5l_inv_16_54.Y VGND.t380 sg13_lv_nmos ad=0.1406p pd=1.12u as=0.1406p ps=1.12u w=0.74u l=0.13u
X1036 VPWR.t546 sg13cmos5l_inv_16_17.A sg13cmos5l_inv_16_17.Y VPWR.t177 sg13_lv_pmos ad=0.2128p pd=1.5u as=0.2128p ps=1.5u w=1.12u l=0.13u
X1037 VGND.t217 VPWR.t2496 VGND.t217 VGND.t2067 sg13_lv_nmos ad=0.1428p pd=1.52u as=0 ps=0 w=0.42u l=1u
X1038 VPWR.t2348 sg13cmos5l_inv_16_101.Y sg13cmos5l_inv_16_55.Y VPWR.t25 sg13_lv_pmos ad=0.2128p pd=1.5u as=0.2128p ps=1.5u w=1.12u l=0.13u
X1039 sg13cmos5l_inv_16_50.Y sg13cmos5l_inv_16_46.Y VPWR.t2273 VPWR.t25 sg13_lv_pmos ad=0.2128p pd=1.5u as=0.2128p ps=1.5u w=1.12u l=0.13u
X1040 sg13cmos5l_inv_16_2.Y sg13cmos5l_inv_16_2.A VGND.t655 VGND.t1434 sg13_lv_nmos ad=0.1406p pd=1.12u as=0.1406p ps=1.12u w=0.74u l=0.13u
X1041 sg13cmos5l_inv_8_2.A sg13cmos5l_inv_2_2.Y VPWR.t1774 VPWR.t4 sg13_lv_pmos ad=0.2128p pd=1.5u as=0.2128p ps=1.5u w=1.12u l=0.13u
X1042 VPWR.t673 sg13cmos5l_inv_16_41.A sg13cmos5l_inv_16_28.A VPWR.t4 sg13_lv_pmos ad=0.2128p pd=1.5u as=0.2128p ps=1.5u w=1.12u l=0.13u
X1043 VPWR.t774 sg13cmos5l_inv_16_11.A sg13cmos5l_inv_16_105.A VPWR.t25 sg13_lv_pmos ad=0.2128p pd=1.5u as=0.2128p ps=1.5u w=1.12u l=0.13u
X1044 sg13cmos5l_inv_16_108.Y sg13cmos5l_inv_16_6.Y VPWR.t1001 VPWR.t177 sg13_lv_pmos ad=0.2128p pd=1.5u as=0.2128p ps=1.5u w=1.12u l=0.13u
X1045 VPWR.t392 VGND.t635 VPWR.t390 VPWR.t4 sg13_lv_pmos ad=0.19p pd=1.38u as=0 ps=0 w=1u l=1u
X1046 sg13cmos5l_inv_16_8.Y sg13cmos5l_inv_16_4.Y VPWR.t735 VPWR.t4 sg13_lv_pmos ad=0.2128p pd=1.5u as=0.2128p ps=1.5u w=1.12u l=0.13u
X1047 sg13cmos5l_inv_16_105.Y sg13cmos5l_inv_16_105.A VGND.t345 VGND.t1108 sg13_lv_nmos ad=0.1406p pd=1.12u as=0.1406p ps=1.12u w=0.74u l=0.13u
X1048 VGND.t226 VPWR.t2507 VGND.t2050 VGND.t2049 sg13_lv_nmos ad=79.8f pd=0.8u as=0 ps=0 w=0.42u l=1u
X1049 VPWR.t2201 sg13cmos5l_inv_16_73.Y sg13cmos5l_inv_16_90.Y VPWR.t16 sg13_lv_pmos ad=0.2128p pd=1.5u as=0.2128p ps=1.5u w=1.12u l=0.13u
X1050 VGND.t381 sg13cmos5l_inv_16_75.A sg13cmos5l_inv_16_74.Y VGND.t380 sg13_lv_nmos ad=0.1406p pd=1.12u as=0.1406p ps=1.12u w=0.74u l=0.13u
X1051 sg13cmos5l_and2_1_4.B a_2920_3932# VGND.t2045 VGND.t2314 sg13_lv_nmos ad=0.2886p pd=2.26u as=0.14875p ps=1.16u w=0.74u l=0.13u
X1052 sg13cmos5l_inv_16_46.A sg13cmos5l_inv_16_48.A VPWR.t2098 VPWR.t25 sg13_lv_pmos ad=0.2128p pd=1.5u as=0.2128p ps=1.5u w=1.12u l=0.13u
X1053 sg13cmos5l_inv_8_7.Y sg13cmos5l_inv_4_4.Y VPWR.t1047 VPWR.t25 sg13_lv_pmos ad=0.2128p pd=1.5u as=0.3808p ps=2.92u w=1.12u l=0.13u
X1054 sg13cmos5l_inv_16_96.Y sg13cmos5l_inv_16_96.A VPWR.t1346 VPWR.t25 sg13_lv_pmos ad=0.2128p pd=1.5u as=0.2128p ps=1.5u w=1.12u l=0.13u
X1055 sg13cmos5l_inv_16_43.Y sg13cmos5l_inv_16_27.Y VGND.t1245 VGND.t1254 sg13_lv_nmos ad=0.1406p pd=1.12u as=0.1406p ps=1.12u w=0.74u l=0.13u
X1056 VGND.t370 VPWR.t2487 VGND.t370 VGND.t2083 sg13_lv_nmos ad=0.1428p pd=1.52u as=0 ps=0 w=0.42u l=1u
X1057 sg13cmos5l_inv_16_55.Y sg13cmos5l_inv_16_101.Y VPWR.t2344 VPWR.t25 sg13_lv_pmos ad=0.2128p pd=1.5u as=0.2128p ps=1.5u w=1.12u l=0.13u
X1058 VGND.t39 sg13cmos5l_inv_16_41.A sg13cmos5l_inv_16_28.A VGND.t244 sg13_lv_nmos ad=0.1406p pd=1.12u as=0.1406p ps=1.12u w=0.74u l=0.13u
X1059 VPWR.t304 VGND.t429 VPWR.t303 VPWR.t0 sg13_lv_pmos ad=0.34p pd=2.68u as=0 ps=0 w=1u l=1u
X1060 sg13cmos5l_inv_16_35.Y sg13cmos5l_inv_16_29.A VGND.t259 VGND.t268 sg13_lv_nmos ad=0.1406p pd=1.12u as=0.1406p ps=1.12u w=0.74u l=0.13u
X1061 VPWR.t1001 sg13cmos5l_inv_16_6.Y sg13cmos5l_inv_16_108.Y VPWR.t177 sg13_lv_pmos ad=0.2128p pd=1.5u as=0.2128p ps=1.5u w=1.12u l=0.13u
X1062 sg13cmos5l_inv_16_54.Y sg13cmos5l_inv_16_101.Y VPWR.t2330 VPWR.t25 sg13_lv_pmos ad=0.2128p pd=1.5u as=0.2128p ps=1.5u w=1.12u l=0.13u
X1063 VGND.t381 VPWR.t2541 VGND.t381 VGND.t380 sg13_lv_nmos ad=0.1428p pd=1.52u as=0 ps=0 w=0.42u l=1u
X1064 VGND.t1100 sg13cmos5l_inv_16_105.A sg13cmos5l_inv_16_105.Y VGND.t1105 sg13_lv_nmos ad=0.1406p pd=1.12u as=0.1406p ps=1.12u w=0.74u l=0.13u
X1065 VPWR.t1001 sg13cmos5l_inv_8_2.A sg13cmos5l_inv_16_27.A VPWR.t177 sg13_lv_pmos ad=0.2128p pd=1.5u as=0.2128p ps=1.5u w=1.12u l=0.13u
X1066 VPWR.t1629 sg13cmos5l_inv_2_5.Y sg13cmos5l_inv_4_7.Y VPWR.t9 sg13_lv_pmos ad=0.2128p pd=1.5u as=0.2128p ps=1.5u w=1.12u l=0.13u
X1067 sg13cmos5l_inv_16_53.Y sg13cmos5l_inv_16_53.A VGND.t1679 VGND.t380 sg13_lv_nmos ad=0.1406p pd=1.12u as=0.2516p ps=2.16u w=0.74u l=0.13u
X1068 VPWR.t518 sg13cmos5l_inv_16_23.Y sg13cmos5l_inv_16_14.A VPWR.t0 sg13_lv_pmos ad=0.3808p pd=2.92u as=0.2128p ps=1.5u w=1.12u l=0.13u
X1069 VPWR.t844 sg13cmos5l_inv_16_6.Y sg13cmos5l_inv_16_25.Y VPWR.t177 sg13_lv_pmos ad=0.2128p pd=1.5u as=0.2128p ps=1.5u w=1.12u l=0.13u
X1070 VPWR.t1202 sg13cmos5l_inv_16_99.A sg13cmos5l_inv_16_51.Y VPWR.t25 sg13_lv_pmos ad=0.2128p pd=1.5u as=0.2128p ps=1.5u w=1.12u l=0.13u
X1071 sg13cmos5l_inv_16_104.Y sg13cmos5l_inv_16_14.A VGND.t472 VGND.t483 sg13_lv_nmos ad=0.1406p pd=1.12u as=0.1406p ps=1.12u w=0.74u l=0.13u
X1072 sg13cmos5l_inv_16_75.A sg13cmos5l_inv_16_76.A VGND.t390 VGND.t380 sg13_lv_nmos ad=0.1406p pd=1.12u as=0.1406p ps=1.12u w=0.74u l=0.13u
X1073 VPWR.t687 sg13cmos5l_inv_16_29.A sg13cmos5l_inv_16_29.Y VPWR.t177 sg13_lv_pmos ad=0.4368p pd=3.02u as=0.2128p ps=1.5u w=1.12u l=0.13u
X1074 VGND.t45 sg13cmos5l_inv_16_23.Y sg13cmos5l_inv_16_15.A VGND.t62 sg13_lv_nmos ad=0.1406p pd=1.12u as=0.1406p ps=1.12u w=0.74u l=0.13u
X1075 VGND.t953 sg13cmos5l_inv_16_96.Y sg13cmos5l_inv_16_11.A VGND.t380 sg13_lv_nmos ad=0.1406p pd=1.12u as=0.1406p ps=1.12u w=0.74u l=0.13u
X1076 VPWR.t822 sg13cmos5l_inv_16_75.A sg13cmos5l_inv_16_75.Y VPWR.t25 sg13_lv_pmos ad=0.2128p pd=1.5u as=0.2128p ps=1.5u w=1.12u l=0.13u
X1077 sg13cmos5l_inv_16_101.Y sg13cmos5l_inv_16_34.Y VGND.t593 VGND.t599 sg13_lv_nmos ad=0.1406p pd=1.12u as=0.1406p ps=1.12u w=0.74u l=0.13u
X1078 sg13cmos5l_inv_16_105.Y sg13cmos5l_inv_16_105.A VGND.t1100 VGND.t1102 sg13_lv_nmos ad=0.1406p pd=1.12u as=0.1406p ps=1.12u w=0.74u l=0.13u
X1079 sg13cmos5l_inv_16_61.Y sg13cmos5l_inv_16_61.A VPWR.t1596 VPWR.t9 sg13_lv_pmos ad=0.2128p pd=1.5u as=0.2128p ps=1.5u w=1.12u l=0.13u
X1080 sg13cmos5l_inv_16_87.Y sg13cmos5l_inv_16_87.A VGND.t1010 VGND.t881 sg13_lv_nmos ad=0.1406p pd=1.12u as=0.1406p ps=1.12u w=0.74u l=0.13u
X1081 sg13cmos5l_inv_16_29.A sg13cmos5l_inv_16_28.A VGND.t198 VGND.t200 sg13_lv_nmos ad=0.1406p pd=1.12u as=0.1406p ps=1.12u w=0.74u l=0.13u
X1082 sg13cmos5l_inv_16_103.Y sg13cmos5l_inv_16_103.A VGND.t353 VGND.t358 sg13_lv_nmos ad=0.1406p pd=1.12u as=0.1406p ps=1.12u w=0.74u l=0.13u
X1083 sg13cmos5l_inv_16_85.Y sg13cmos5l_inv_16_84.A VPWR.t1476 VPWR.t9 sg13_lv_pmos ad=0.2128p pd=1.5u as=0.2128p ps=1.5u w=1.12u l=0.13u
X1084 sg13cmos5l_inv_16_76.A sg13cmos5l_inv_16_94.A VPWR.t1912 VPWR.t16 sg13_lv_pmos ad=0.2128p pd=1.5u as=0.2128p ps=1.5u w=1.12u l=0.13u
X1085 VGND.t390 sg13cmos5l_inv_16_76.A sg13cmos5l_inv_16_75.A VGND.t380 sg13_lv_nmos ad=0.1406p pd=1.12u as=0.1406p ps=1.12u w=0.74u l=0.13u
X1086 sg13cmos5l_inv_16_88.A sg13cmos5l_inv_4_7.Y VGND.t1201 VGND.t1224 sg13_lv_nmos ad=0.1443p pd=1.13u as=0.1406p ps=1.12u w=0.74u l=0.13u
X1087 sg13cmos5l_inv_16_34.Y sg13cmos5l_inv_16_41.A VPWR.t666 VPWR.t0 sg13_lv_pmos ad=0.2128p pd=1.5u as=0.2128p ps=1.5u w=1.12u l=0.13u
X1088 sg13cmos5l_inv_16_14.Y sg13cmos5l_inv_16_14.A VPWR.t925 VPWR.t4 sg13_lv_pmos ad=0.2128p pd=1.5u as=0.2128p ps=1.5u w=1.12u l=0.13u
X1089 VPWR.t2048 sg13cmos5l_inv_16_56.Y sg13cmos5l_inv_16_52.Y VPWR.t16 sg13_lv_pmos ad=0.2128p pd=1.5u as=0.2128p ps=1.5u w=1.12u l=0.13u
X1090 sg13cmos5l_inv_16_55.Y sg13cmos5l_inv_16_101.Y VPWR.t2340 VPWR.t25 sg13_lv_pmos ad=0.2128p pd=1.5u as=0.2128p ps=1.5u w=1.12u l=0.13u
X1091 VGND.t593 sg13cmos5l_inv_16_34.Y sg13cmos5l_inv_16_101.Y VGND.t596 sg13_lv_nmos ad=0.1406p pd=1.12u as=0.1406p ps=1.12u w=0.74u l=0.13u
X1092 VPWR.t86 VGND.t953 VPWR.t85 VPWR.t16 sg13_lv_pmos ad=0.34p pd=2.68u as=0 ps=0 w=1u l=1u
X1093 VPWR.t1098 sg13cmos5l_inv_16_1.A sg13cmos5l_inv_16_17.A VPWR.t177 sg13_lv_pmos ad=0.2128p pd=1.5u as=0.2128p ps=1.5u w=1.12u l=0.13u
X1094 VGND.t450 sg13cmos5l_inv_16_15.A sg13cmos5l_inv_16_13.Y VGND.t504 sg13_lv_nmos ad=0.1406p pd=1.12u as=0.1406p ps=1.12u w=0.74u l=0.13u
X1095 VGND.t343 sg13cmos5l_inv_16_30.A sg13cmos5l_inv_16_30.Y VGND.t1307 sg13_lv_nmos ad=0.1406p pd=1.12u as=0.1406p ps=1.12u w=0.74u l=0.13u
X1096 sg13cmos5l_inv_16_66.Y sg13cmos5l_inv_16_68.A VGND.t866 VGND.t871 sg13_lv_nmos ad=0.1406p pd=1.12u as=0.1406p ps=1.12u w=0.74u l=0.13u
X1097 VPWR.t2172 sg13cmos5l_inv_16_79.A sg13cmos5l_inv_16_79.Y VPWR.t16 sg13_lv_pmos ad=0.2128p pd=1.5u as=0.2128p ps=1.5u w=1.12u l=0.13u
X1098 sg13cmos5l_inv_16_37.A sg13cmos5l_inv_16_43.Y VGND.t3 VGND.t165 sg13_lv_nmos ad=0.1406p pd=1.12u as=0.1406p ps=1.12u w=0.74u l=0.13u
X1099 VPWR.t542 sg13cmos5l_inv_16_17.A sg13cmos5l_inv_16_17.Y VPWR.t177 sg13_lv_pmos ad=0.2128p pd=1.5u as=0.2128p ps=1.5u w=1.12u l=0.13u
X1100 VPWR.t2404 VGND.t2050 VPWR.t404 VPWR.t0 sg13_lv_pmos ad=0.19p pd=1.38u as=0 ps=0 w=1u l=1u
X1101 VGND.t1334 sg13cmos5l_inv_16_26.A sg13cmos5l_inv_16_26.Y VGND.t1340 sg13_lv_nmos ad=0.1406p pd=1.12u as=0.1406p ps=1.12u w=0.74u l=0.13u
X1102 VGND.t84 sg13cmos5l_inv_16_17.A sg13cmos5l_inv_16_17.Y VGND.t106 sg13_lv_nmos ad=0.1406p pd=1.12u as=0.1406p ps=1.12u w=0.74u l=0.13u
X1103 VGND.t1507 sg13cmos5l_inv_16_94.A sg13cmos5l_inv_16_73.A VGND.t881 sg13_lv_nmos ad=0.1406p pd=1.12u as=0.1406p ps=1.12u w=0.74u l=0.13u
X1104 sg13cmos5l_inv_16_50.Y sg13cmos5l_inv_16_46.Y VPWR.t2269 VPWR.t25 sg13_lv_pmos ad=0.2128p pd=1.5u as=0.2128p ps=1.5u w=1.12u l=0.13u
X1105 VGND.t146 sg13cmos5l_inv_16_36.A sg13cmos5l_inv_16_36.Y VGND.t153 sg13_lv_nmos ad=0.1406p pd=1.12u as=0.1406p ps=1.12u w=0.74u l=0.13u
X1106 VPWR.t1978 sg13cmos5l_inv_16_67.A sg13cmos5l_inv_16_67.Y VPWR.t16 sg13_lv_pmos ad=0.2128p pd=1.5u as=0.2128p ps=1.5u w=1.12u l=0.13u
X1107 VPWR.t664 sg13cmos5l_inv_16_41.A sg13cmos5l_inv_16_34.Y VPWR.t0 sg13_lv_pmos ad=0.2128p pd=1.5u as=0.2128p ps=1.5u w=1.12u l=0.13u
X1108 VPWR.t1149 sg13cmos5l_inv_16_9.A sg13cmos5l_inv_16_10.Y VPWR.t0 sg13_lv_pmos ad=0.2128p pd=1.5u as=0.2128p ps=1.5u w=1.12u l=0.13u
X1109 sg13cmos5l_inv_16_30.Y sg13cmos5l_inv_16_30.A VGND.t343 VGND.t1302 sg13_lv_nmos ad=0.1406p pd=1.12u as=0.1406p ps=1.12u w=0.74u l=0.13u
X1110 sg13cmos5l_inv_8_0.Y sg13cmos5l_inv_4_0.Y VPWR.t2178 VPWR.t177 sg13_lv_pmos ad=0.2128p pd=1.5u as=0.2128p ps=1.5u w=1.12u l=0.13u
X1111 VPWR.t923 sg13cmos5l_inv_16_14.A sg13cmos5l_inv_16_14.Y VPWR.t4 sg13_lv_pmos ad=0.2128p pd=1.5u as=0.2128p ps=1.5u w=1.12u l=0.13u
X1112 sg13cmos5l_inv_16_52.Y sg13cmos5l_inv_16_56.Y VPWR.t2044 VPWR.t16 sg13_lv_pmos ad=0.2128p pd=1.5u as=0.2128p ps=1.5u w=1.12u l=0.13u
X1113 sg13cmos5l_inv_16_20.A sg13cmos5l_inv_16_8.Y VGND.t353 VGND.t541 sg13_lv_nmos ad=0.1406p pd=1.12u as=0.2516p ps=2.16u w=0.74u l=0.13u
X1114 sg13cmos5l_inv_16_8.Y sg13cmos5l_inv_16_4.Y VGND.t291 VGND.t290 sg13_lv_nmos ad=0.1406p pd=1.12u as=0.2516p ps=2.16u w=0.74u l=0.13u
X1115 VGND.t1419 sg13cmos5l_inv_16_6.A sg13cmos5l_inv_16_6.Y VGND.t1418 sg13_lv_nmos ad=0.1406p pd=1.12u as=0.1406p ps=1.12u w=0.74u l=0.13u
X1116 sg13cmos5l_inv_16_93.Y sg13cmos5l_inv_16_87.A VPWR.t1404 VPWR.t9 sg13_lv_pmos ad=0.2128p pd=1.5u as=0.2128p ps=1.5u w=1.12u l=0.13u
X1117 sg13cmos5l_inv_16_17.A sg13cmos5l_inv_16_1.A VPWR.t1094 VPWR.t177 sg13_lv_pmos ad=0.2128p pd=1.5u as=0.2128p ps=1.5u w=1.12u l=0.13u
X1118 sg13cmos5l_inv_16_75.A sg13cmos5l_inv_16_76.A VPWR.t2392 VPWR.t25 sg13_lv_pmos ad=0.2128p pd=1.5u as=0.2128p ps=1.5u w=1.12u l=0.13u
X1119 VPWR.t802 sg13cmos5l_inv_16_11.A sg13cmos5l_inv_16_103.A VPWR.t0 sg13_lv_pmos ad=0.4368p pd=3.02u as=0.2128p ps=1.5u w=1.12u l=0.13u
X1120 VPWR.t1621 sg13cmos5l_inv_4_7.Y sg13cmos5l_inv_16_88.A VPWR.t9 sg13_lv_pmos ad=0.2128p pd=1.5u as=0.2128p ps=1.5u w=1.12u l=0.13u
X1121 sg13cmos5l_inv_16_13.Y sg13cmos5l_inv_16_15.A VGND.t450 VGND.t501 sg13_lv_nmos ad=0.1406p pd=1.12u as=0.2516p ps=2.16u w=0.74u l=0.13u
X1122 sg13cmos5l_inv_16_52.Y sg13cmos5l_inv_16_56.Y VGND.t1663 VGND.t380 sg13_lv_nmos ad=0.1406p pd=1.12u as=0.1406p ps=1.12u w=0.74u l=0.13u
X1123 sg13cmos5l_inv_16_17.Y sg13cmos5l_inv_16_17.A VPWR.t538 VPWR.t177 sg13_lv_pmos ad=0.2128p pd=1.5u as=0.2128p ps=1.5u w=1.12u l=0.13u
X1124 VPWR.t767 sg13cmos5l_inv_16_27.Y sg13cmos5l_inv_16_26.A VPWR.t177 sg13_lv_pmos ad=0.2128p pd=1.5u as=0.2128p ps=1.5u w=1.12u l=0.13u
X1125 sg13cmos5l_inv_16_85.Y sg13cmos5l_inv_16_84.A VPWR.t1472 VPWR.t9 sg13_lv_pmos ad=0.2128p pd=1.5u as=0.2128p ps=1.5u w=1.12u l=0.13u
X1126 sg13cmos5l_inv_16_73.A sg13cmos5l_inv_16_94.A VGND.t1010 VGND.t881 sg13_lv_nmos ad=0.1406p pd=1.12u as=0.2516p ps=2.16u w=0.74u l=0.13u
X1127 sg13cmos5l_inv_16_9.Y sg13cmos5l_inv_16_9.A VPWR.t1163 VPWR.t4 sg13_lv_pmos ad=0.2128p pd=1.5u as=0.2128p ps=1.5u w=1.12u l=0.13u
X1128 sg13cmos5l_inv_16_36.Y sg13cmos5l_inv_16_36.A VGND.t146 VGND.t150 sg13_lv_nmos ad=0.1406p pd=1.12u as=0.1406p ps=1.12u w=0.74u l=0.13u
X1129 VPWR.t1418 sg13cmos5l_inv_16_87.A sg13cmos5l_inv_16_87.Y VPWR.t9 sg13_lv_pmos ad=0.2128p pd=1.5u as=0.2128p ps=1.5u w=1.12u l=0.13u
X1130 VPWR.t339 VGND.t390 VPWR.t338 VPWR.t16 sg13_lv_pmos ad=0.34p pd=2.68u as=0 ps=0 w=1u l=1u
X1131 VPWR.t1062 sg13cmos5l_inv_16_5.Y sg13cmos5l_inv_16_110.Y VPWR.t4 sg13_lv_pmos ad=0.2128p pd=1.5u as=0.2128p ps=1.5u w=1.12u l=0.13u
X1132 VGND.t215 sg13cmos5l_inv_16_41.A sg13cmos5l_inv_16_28.A VGND.t239 sg13_lv_nmos ad=0.1406p pd=1.12u as=0.1406p ps=1.12u w=0.74u l=0.13u
X1133 sg13cmos5l_inv_16_37.Y sg13cmos5l_inv_16_37.A VGND.t3 VGND.t32 sg13_lv_nmos ad=0.1406p pd=1.12u as=0.1406p ps=1.12u w=0.74u l=0.13u
X1134 sg13cmos5l_inv_16_10.Y sg13cmos5l_inv_16_9.A VPWR.t1145 VPWR.t0 sg13_lv_pmos ad=0.2128p pd=1.5u as=0.2128p ps=1.5u w=1.12u l=0.13u
X1135 sg13cmos5l_inv_16_68.Y sg13cmos5l_inv_16_68.A VPWR.t1294 VPWR.t16 sg13_lv_pmos ad=0.2128p pd=1.5u as=0.2128p ps=1.5u w=1.12u l=0.13u
X1136 VPWR.t197 VGND.t1 VPWR.t196 VPWR.t25 sg13_lv_pmos ad=0.34p pd=2.68u as=0 ps=0 w=1u l=1u
X1137 sg13cmos5l_inv_4_0.Y sg13cmos5l_inv_4_0.A VGND.t588 VGND.t1576 sg13_lv_nmos ad=0.1406p pd=1.12u as=0.1406p ps=1.12u w=0.74u l=0.13u
X1138 VGND.t310 sg13cmos5l_inv_8_1.Y sg13cmos5l_inv_16_4.Y VGND.t1452 sg13_lv_nmos ad=0.1406p pd=1.12u as=0.1406p ps=1.12u w=0.74u l=0.13u
X1139 VPWR.t1402 sg13cmos5l_inv_16_87.A sg13cmos5l_inv_16_93.Y VPWR.t9 sg13_lv_pmos ad=0.2128p pd=1.5u as=0.2128p ps=1.5u w=1.12u l=0.13u
X1140 VGND.t146 sg13cmos5l_inv_16_43.Y sg13cmos5l_inv_16_36.A VGND.t190 sg13_lv_nmos ad=0.1406p pd=1.12u as=0.1406p ps=1.12u w=0.74u l=0.13u
X1141 sg13cmos5l_inv_16_103.A sg13cmos5l_inv_16_11.A VPWR.t798 VPWR.t0 sg13_lv_pmos ad=0.2128p pd=1.5u as=0.2128p ps=1.5u w=1.12u l=0.13u
X1142 VPWR.t1092 sg13cmos5l_inv_16_1.A sg13cmos5l_inv_16_17.A VPWR.t177 sg13_lv_pmos ad=0.2128p pd=1.5u as=0.2128p ps=1.5u w=1.12u l=0.13u
X1143 VPWR.t844 sg13cmos5l_inv_16_6.Y sg13cmos5l_inv_16_25.Y VPWR.t177 sg13_lv_pmos ad=0.2128p pd=1.5u as=0.2128p ps=1.5u w=1.12u l=0.13u
X1144 VGND.t1132 sg13cmos5l_inv_16_109.Y sg13cmos5l_inv_16_67.A VGND.t881 sg13_lv_nmos ad=0.1406p pd=1.12u as=0.1406p ps=1.12u w=0.74u l=0.13u
X1145 VGND.t291 sg13cmos5l_inv_16_8.Y sg13cmos5l_inv_16_9.A VGND.t563 sg13_lv_nmos ad=0.1406p pd=1.12u as=0.1406p ps=1.12u w=0.74u l=0.13u
X1146 sg13cmos5l_inv_16_53.Y sg13cmos5l_inv_16_53.A VPWR.t2066 VPWR.t16 sg13_lv_pmos ad=0.2128p pd=1.5u as=0.2128p ps=1.5u w=1.12u l=0.13u
X1147 sg13cmos5l_inv_16_13.Y sg13cmos5l_inv_16_15.A VPWR.t943 VPWR.t0 sg13_lv_pmos ad=0.2128p pd=1.5u as=0.2128p ps=1.5u w=1.12u l=0.13u
X1148 VGND.t1663 sg13cmos5l_inv_16_56.Y sg13cmos5l_inv_16_52.Y VGND.t380 sg13_lv_nmos ad=0.1406p pd=1.12u as=0.1406p ps=1.12u w=0.74u l=0.13u
X1149 VGND.t635 VPWR.t2477 VGND.t635 VGND.t2102 sg13_lv_nmos ad=0.1428p pd=1.52u as=0 ps=0 w=0.42u l=1u
X1150 sg13cmos5l_inv_16_44.A sg13cmos5l_inv_16_28.A VGND.t259 VGND.t268 sg13_lv_nmos ad=0.1406p pd=1.12u as=0.1406p ps=1.12u w=0.74u l=0.13u
X1151 sg13cmos5l_inv_16_99.A sg13cmos5l_inv_16_34.Y VGND.t593 VGND.t603 sg13_lv_nmos ad=0.1406p pd=1.12u as=0.1406p ps=1.12u w=0.74u l=0.13u
X1152 VGND.t375 sg13cmos5l_inv_16_20.A sg13cmos5l_inv_16_22.Y VGND.t442 sg13_lv_nmos ad=0.1406p pd=1.12u as=0.1406p ps=1.12u w=0.74u l=0.13u
X1153 sg13cmos5l_inv_16_26.A sg13cmos5l_inv_16_27.Y VPWR.t767 VPWR.t177 sg13_lv_pmos ad=0.2128p pd=1.5u as=0.2128p ps=1.5u w=1.12u l=0.13u
X1154 VPWR.t1161 sg13cmos5l_inv_16_9.A sg13cmos5l_inv_16_9.Y VPWR.t4 sg13_lv_pmos ad=0.2128p pd=1.5u as=0.2128p ps=1.5u w=1.12u l=0.13u
X1155 sg13cmos5l_inv_16_66.Y sg13cmos5l_inv_16_68.A VGND.t866 VGND.t867 sg13_lv_nmos ad=0.1406p pd=1.12u as=0.1406p ps=1.12u w=0.74u l=0.13u
X1156 sg13cmos5l_inv_16_47.A sg13cmos5l_inv_16_46.A VPWR.t2125 VPWR.t16 sg13_lv_pmos ad=0.2128p pd=1.5u as=0.2128p ps=1.5u w=1.12u l=0.13u
X1157 VGND.t45 VPWR.t2484 VGND.t45 VGND.t2089 sg13_lv_nmos ad=0.1428p pd=1.52u as=0 ps=0 w=0.42u l=1u
X1158 sg13cmos5l_inv_16_87.Y sg13cmos5l_inv_16_87.A VPWR.t1415 VPWR.t9 sg13_lv_pmos ad=0.2128p pd=1.5u as=0.4368p ps=3.02u w=1.12u l=0.13u
X1159 VGND.t1010 sg13cmos5l_inv_16_73.Y sg13cmos5l_inv_16_95.Y VGND.t881 sg13_lv_nmos ad=0.1406p pd=1.12u as=0.1406p ps=1.12u w=0.74u l=0.13u
X1160 VGND.t259 sg13cmos5l_inv_16_29.A sg13cmos5l_inv_16_35.Y VGND.t261 sg13_lv_nmos ad=0.1406p pd=1.12u as=0.1406p ps=1.12u w=0.74u l=0.13u
X1161 sg13cmos5l_inv_16_110.Y sg13cmos5l_inv_16_5.Y VPWR.t1058 VPWR.t4 sg13_lv_pmos ad=0.2128p pd=1.5u as=0.2128p ps=1.5u w=1.12u l=0.13u
X1162 VGND.t45 sg13cmos5l_inv_16_23.Y sg13cmos5l_inv_16_15.A VGND.t58 sg13_lv_nmos ad=0.1406p pd=1.12u as=0.1406p ps=1.12u w=0.74u l=0.13u
X1163 VGND.t882 sg13cmos5l_inv_16_71.Y sg13cmos5l_inv_16_68.A VGND.t881 sg13_lv_nmos ad=0.2516p pd=2.16u as=0.1406p ps=1.12u w=0.74u l=0.13u
X1164 VGND.t637 sg13cmos5l_inv_16_5.Y sg13cmos5l_inv_16_110.Y VGND.t649 sg13_lv_nmos ad=0.1406p pd=1.12u as=0.1406p ps=1.12u w=0.74u l=0.13u
X1165 VGND.t953 sg13cmos5l_inv_16_96.Y sg13cmos5l_inv_16_11.A VGND.t380 sg13_lv_nmos ad=0.1406p pd=1.12u as=0.1406p ps=1.12u w=0.74u l=0.13u
X1166 sg13cmos5l_inv_16_27.Y sg13cmos5l_inv_16_27.A VGND.t425 VGND.t1618 sg13_lv_nmos ad=0.1406p pd=1.12u as=0.1406p ps=1.12u w=0.74u l=0.13u
X1167 VPWR.t2301 sg13cmos5l_inv_16_47.A sg13cmos5l_inv_16_45.Y VPWR.t16 sg13_lv_pmos ad=0.2128p pd=1.5u as=0.2128p ps=1.5u w=1.12u l=0.13u
X1168 VPWR.t2324 sg13cmos5l_inv_16_101.Y sg13cmos5l_inv_16_54.Y VPWR.t25 sg13_lv_pmos ad=0.2128p pd=1.5u as=0.2128p ps=1.5u w=1.12u l=0.13u
X1169 sg13cmos5l_inv_16_14.A sg13cmos5l_inv_16_23.Y VPWR.t510 VPWR.t0 sg13_lv_pmos ad=0.2128p pd=1.5u as=0.2128p ps=1.5u w=1.12u l=0.13u
X1170 VPWR.t1258 sg13cmos5l_inv_16_0.A sg13cmos5l_inv_16_1.A VPWR.t177 sg13_lv_pmos ad=0.2128p pd=1.5u as=0.2128p ps=1.5u w=1.12u l=0.13u
X1171 sg13cmos5l_inv_16_4.Y sg13cmos5l_inv_8_1.Y VGND.t310 VGND.t1449 sg13_lv_nmos ad=0.1406p pd=1.12u as=0.2516p ps=2.16u w=0.74u l=0.13u
X1172 VPWR.t129 VGND.t845 VPWR.t128 VPWR.t4 sg13_lv_pmos ad=0.34p pd=2.68u as=0 ps=0 w=1u l=1u
X1173 sg13cmos5l_inv_16_58.Y sg13cmos5l_inv_16_69.Y VPWR.t1322 VPWR.t9 sg13_lv_pmos ad=0.2128p pd=1.5u as=0.2128p ps=1.5u w=1.12u l=0.13u
X1174 sg13cmos5l_inv_16_25.Y sg13cmos5l_inv_16_6.Y VPWR.t844 VPWR.t177 sg13_lv_pmos ad=0.2128p pd=1.5u as=0.2128p ps=1.5u w=1.12u l=0.13u
X1175 VPWR.t398 VGND.t635 VPWR.t397 VPWR.t4 sg13_lv_pmos ad=0.34p pd=2.68u as=0 ps=0 w=1u l=1u
X1176 VPWR.t631 sg13cmos5l_inv_16_44.A sg13cmos5l_inv_16_44.Y VPWR.t4 sg13_lv_pmos ad=0.2128p pd=1.5u as=0.2128p ps=1.5u w=1.12u l=0.13u
X1177 sg13cmos5l_inv_16_73.A sg13cmos5l_inv_16_94.A VPWR.t1894 VPWR.t9 sg13_lv_pmos ad=0.2128p pd=1.5u as=0.2128p ps=1.5u w=1.12u l=0.13u
X1178 VGND.t472 sg13cmos5l_inv_16_14.A sg13cmos5l_inv_16_104.Y VGND.t476 sg13_lv_nmos ad=0.1406p pd=1.12u as=0.1406p ps=1.12u w=0.74u l=0.13u
X1179 sg13cmos5l_inv_16_9.A sg13cmos5l_inv_16_8.Y VGND.t291 VGND.t560 sg13_lv_nmos ad=0.1406p pd=1.12u as=0.1406p ps=1.12u w=0.74u l=0.13u
X1180 VPWR.t471 sg13cmos5l_inv_16_37.A sg13cmos5l_inv_16_37.Y VPWR.t4 sg13_lv_pmos ad=0.2128p pd=1.5u as=0.2128p ps=1.5u w=1.12u l=0.13u
X1181 VPWR.t1756 sg13cmos5l_inv_16_52.Y sg13cmos5l_inv_16_53.A VPWR.t16 sg13_lv_pmos ad=0.2128p pd=1.5u as=0.2128p ps=1.5u w=1.12u l=0.13u
X1182 VPWR.t2064 sg13cmos5l_inv_16_53.A sg13cmos5l_inv_16_53.Y VPWR.t16 sg13_lv_pmos ad=0.2128p pd=1.5u as=0.2128p ps=1.5u w=1.12u l=0.13u
X1183 sg13cmos5l_inv_16_22.Y sg13cmos5l_inv_16_20.A VGND.t375 VGND.t439 sg13_lv_nmos ad=0.1406p pd=1.12u as=0.1406p ps=1.12u w=0.74u l=0.13u
X1184 VGND.t425 sg13cmos5l_inv_16_27.A sg13cmos5l_inv_16_27.Y VGND.t1613 sg13_lv_nmos ad=0.1406p pd=1.12u as=0.1406p ps=1.12u w=0.74u l=0.13u
X1185 VPWR.t767 sg13cmos5l_inv_16_27.Y sg13cmos5l_inv_16_26.A VPWR.t177 sg13_lv_pmos ad=0.2128p pd=1.5u as=0.2128p ps=1.5u w=1.12u l=0.13u
X1186 VPWR.t2123 sg13cmos5l_inv_16_46.A sg13cmos5l_inv_16_47.A VPWR.t16 sg13_lv_pmos ad=0.2128p pd=1.5u as=0.2128p ps=1.5u w=1.12u l=0.13u
X1187 sg13cmos5l_inv_16_68.A sg13cmos5l_inv_16_71.Y VGND.t882 VGND.t881 sg13_lv_nmos ad=0.1406p pd=1.12u as=0.1406p ps=1.12u w=0.74u l=0.13u
X1188 sg13cmos5l_inv_16_110.Y sg13cmos5l_inv_16_5.Y VGND.t637 VGND.t646 sg13_lv_nmos ad=0.1406p pd=1.12u as=0.1406p ps=1.12u w=0.74u l=0.13u
X1189 sg13cmos5l_inv_16_15.A sg13cmos5l_inv_16_23.Y VGND.t45 VGND.t55 sg13_lv_nmos ad=0.1406p pd=1.12u as=0.1406p ps=1.12u w=0.74u l=0.13u
X1190 sg13cmos5l_inv_16_29.A sg13cmos5l_inv_16_28.A VPWR.t707 VPWR.t177 sg13_lv_pmos ad=0.2128p pd=1.5u as=0.2128p ps=1.5u w=1.12u l=0.13u
X1191 VGND.t1680 sg13cmos5l_inv_16_53.A sg13cmos5l_inv_16_53.Y VGND.t380 sg13_lv_nmos ad=0.1406p pd=1.12u as=0.1406p ps=1.12u w=0.74u l=0.13u
X1192 sg13cmos5l_inv_16_11.A sg13cmos5l_inv_16_96.Y VGND.t1792 VGND.t380 sg13_lv_nmos ad=0.1406p pd=1.12u as=0.1406p ps=1.12u w=0.74u l=0.13u
X1193 sg13cmos5l_inv_16_68.Y sg13cmos5l_inv_16_68.A VPWR.t1291 VPWR.t16 sg13_lv_pmos ad=0.2128p pd=1.5u as=0.3808p ps=2.92u w=1.12u l=0.13u
X1194 sg13cmos5l_inv_16_45.Y sg13cmos5l_inv_16_47.A VPWR.t2297 VPWR.t16 sg13_lv_pmos ad=0.2128p pd=1.5u as=0.2128p ps=1.5u w=1.12u l=0.13u
X1195 VGND.t122 a_23648_4915# sg13cmos5l_and2_1_7.X VGND.t121 sg13_lv_nmos ad=0.1331p pd=1.12u as=0.2516p ps=2.16u w=0.74u l=0.13u
X1196 sg13cmos5l_inv_16_20.Y sg13cmos5l_inv_16_20.A VPWR.t895 VPWR.t4 sg13_lv_pmos ad=0.2128p pd=1.5u as=0.2128p ps=1.5u w=1.12u l=0.13u
X1197 sg13cmos5l_inv_16_44.Y sg13cmos5l_inv_16_44.A VPWR.t627 VPWR.t4 sg13_lv_pmos ad=0.2128p pd=1.5u as=0.2128p ps=1.5u w=1.12u l=0.13u
X1198 VPWR.t321 VGND.t353 VPWR.t319 VPWR.t0 sg13_lv_pmos ad=0.19p pd=1.38u as=0 ps=0 w=1u l=1u
X1199 sg13cmos5l_inv_16_26.Y sg13cmos5l_inv_16_26.A VGND.t1334 VGND.t1341 sg13_lv_nmos ad=0.1406p pd=1.12u as=0.1406p ps=1.12u w=0.74u l=0.13u
X1200 VGND.t198 sg13cmos5l_inv_16_44.A sg13cmos5l_inv_16_44.Y VGND.t213 sg13_lv_nmos ad=0.2516p pd=2.16u as=0.1406p ps=1.12u w=0.74u l=0.13u
X1201 sg13cmos5l_inv_16_80.Y sg13cmos5l_inv_16_105.A VGND.t345 VGND.t1108 sg13_lv_nmos ad=0.1406p pd=1.12u as=0.1406p ps=1.12u w=0.74u l=0.13u
X1202 VGND.t1147 sg13cmos5l_inv_16_48.A sg13cmos5l_inv_16_109.Y VGND.t881 sg13_lv_nmos ad=0.1406p pd=1.12u as=0.1406p ps=1.12u w=0.74u l=0.13u
X1203 VPWR.t847 sg13cmos5l_and2_1_7.X sg13cmos5l_inv_1_5.Y VPWR.t25 sg13_lv_pmos ad=0.3808p pd=2.92u as=0.3808p ps=2.92u w=1.12u l=0.13u
X1204 VPWR.t2148 sg13cmos5l_inv_16_79.A sg13cmos5l_inv_16_91.Y VPWR.t16 sg13_lv_pmos ad=0.2128p pd=1.5u as=0.2128p ps=1.5u w=1.12u l=0.13u
X1205 sg13cmos5l_inv_16_77.A sg13cmos5l_inv_16_76.A VPWR.t2377 VPWR.t16 sg13_lv_pmos ad=0.2128p pd=1.5u as=0.2128p ps=1.5u w=1.12u l=0.13u
X1206 VGND.t1970 VPWR.t2539 VGND.t1970 VGND.t380 sg13_lv_nmos ad=0.1428p pd=1.52u as=0 ps=0 w=0.42u l=1u
X1207 sg13cmos5l_inv_16_108.Y sg13cmos5l_inv_16_6.Y VGND.t2361 VGND.t2362 sg13_lv_nmos ad=0.1406p pd=1.12u as=0.1406p ps=1.12u w=0.74u l=0.13u
X1208 VPWR.t660 sg13cmos5l_inv_16_41.A sg13cmos5l_inv_16_34.Y VPWR.t0 sg13_lv_pmos ad=0.2128p pd=1.5u as=0.2128p ps=1.5u w=1.12u l=0.13u
X1209 VGND.t1083 VPWR.t2575 VGND.t1083 VGND.t881 sg13_lv_nmos ad=0.1428p pd=1.52u as=0 ps=0 w=0.42u l=1u
X1210 VPWR.t1040 sg13cmos5l_inv_16_34.Y sg13cmos5l_inv_16_101.Y VPWR.t0 sg13_lv_pmos ad=0.2128p pd=1.5u as=0.2128p ps=1.5u w=1.12u l=0.13u
X1211 VGND.t1083 sg13cmos5l_inv_16_109.Y sg13cmos5l_inv_16_111.A VGND.t881 sg13_lv_nmos ad=0.1406p pd=1.12u as=0.1406p ps=1.12u w=0.74u l=0.13u
X1212 VPWR.t707 sg13cmos5l_inv_16_28.A sg13cmos5l_inv_16_29.A VPWR.t177 sg13_lv_pmos ad=0.2128p pd=1.5u as=0.2128p ps=1.5u w=1.12u l=0.13u
X1213 VGND.t450 sg13cmos5l_inv_16_15.A sg13cmos5l_inv_16_15.Y VGND.t504 sg13_lv_nmos ad=0.1406p pd=1.12u as=0.1406p ps=1.12u w=0.74u l=0.13u
X1214 VPWR.t1617 sg13cmos5l_inv_16_103.A sg13cmos5l_inv_16_103.Y VPWR.t0 sg13_lv_pmos ad=0.4368p pd=3.02u as=0.2128p ps=1.5u w=1.12u l=0.13u
X1215 sg13cmos5l_inv_16_75.A sg13cmos5l_inv_16_76.A VPWR.t2388 VPWR.t25 sg13_lv_pmos ad=0.2128p pd=1.5u as=0.2128p ps=1.5u w=1.12u l=0.13u
X1216 VPWR.t1951 sg13cmos5l_inv_16_111.A sg13cmos5l_inv_16_111.Y VPWR.t16 sg13_lv_pmos ad=0.2128p pd=1.5u as=0.2128p ps=1.5u w=1.12u l=0.13u
X1217 sg13cmos5l_inv_16_77.A sg13cmos5l_inv_16_76.A VGND.t1970 VGND.t380 sg13_lv_nmos ad=0.1406p pd=1.12u as=0.1406p ps=1.12u w=0.74u l=0.13u
X1218 VPWR.t178 sg13cmos5l_inv_16_30.A sg13cmos5l_inv_16_30.Y VPWR.t177 sg13_lv_pmos ad=0.4368p pd=3.02u as=0.2128p ps=1.5u w=1.12u l=0.13u
X1219 VGND.t575 sg13cmos5l_inv_8_2.A sg13cmos5l_inv_16_27.A VGND.t578 sg13_lv_nmos ad=0.1406p pd=1.12u as=0.1406p ps=1.12u w=0.74u l=0.13u
X1220 VGND.t1026 sg13cmos5l_inv_16_84.A sg13cmos5l_inv_16_84.Y VGND.t881 sg13_lv_nmos ad=0.1406p pd=1.12u as=0.1406p ps=1.12u w=0.74u l=0.13u
X1221 sg13cmos5l_inv_16_109.Y sg13cmos5l_inv_16_48.A VGND.t1147 VGND.t881 sg13_lv_nmos ad=0.1406p pd=1.12u as=0.1406p ps=1.12u w=0.74u l=0.13u
X1222 VGND.t1100 sg13cmos5l_inv_16_105.A sg13cmos5l_inv_16_80.Y VGND.t1105 sg13_lv_nmos ad=0.1406p pd=1.12u as=0.1406p ps=1.12u w=0.74u l=0.13u
X1223 VPWR.t467 sg13cmos5l_inv_16_37.A sg13cmos5l_inv_16_37.Y VPWR.t4 sg13_lv_pmos ad=0.2128p pd=1.5u as=0.2128p ps=1.5u w=1.12u l=0.13u
X1224 VGND.t1469 sg13cmos5l_inv_16_73.A sg13cmos5l_inv_16_87.A VGND.t1482 sg13_lv_nmos ad=0.1406p pd=1.12u as=0.1406p ps=1.12u w=0.74u l=0.13u
X1225 sg13cmos5l_inv_16_91.Y sg13cmos5l_inv_16_79.A VPWR.t2144 VPWR.t16 sg13_lv_pmos ad=0.2128p pd=1.5u as=0.2128p ps=1.5u w=1.12u l=0.13u
X1226 VGND.t5 sg13cmos5l_inv_16_37.A sg13cmos5l_inv_16_102.Y VGND.t10 sg13_lv_nmos ad=0.1406p pd=1.12u as=0.1406p ps=1.12u w=0.74u l=0.13u
X1227 VGND.t675 a_25484_834# sg13cmos5l_buf_1_1.X VGND.t1630 sg13_lv_nmos ad=0.14875p pd=1.16u as=0.2886p ps=2.26u w=0.74u l=0.13u
X1228 sg13cmos5l_inv_16_67.Y sg13cmos5l_inv_16_67.A VGND.t1132 VGND.t881 sg13_lv_nmos ad=0.1406p pd=1.12u as=0.1406p ps=1.12u w=0.74u l=0.13u
X1229 sg13cmos5l_inv_16_111.A sg13cmos5l_inv_16_109.Y VGND.t1147 VGND.t881 sg13_lv_nmos ad=0.1406p pd=1.12u as=0.1406p ps=1.12u w=0.74u l=0.13u
X1230 sg13cmos5l_inv_16_68.Y sg13cmos5l_inv_16_68.A VGND.t882 VGND.t881 sg13_lv_nmos ad=0.1406p pd=1.12u as=0.1406p ps=1.12u w=0.74u l=0.13u
X1231 a_25484_834# en[6] VGND.t675 VGND.t1696 sg13_lv_nmos ad=0.187p pd=1.78u as=0.14875p ps=1.16u w=0.55u l=0.13u
X1232 VGND.t1381 sg13cmos5l_inv_16_6.Y sg13cmos5l_inv_16_25.Y VGND.t2344 sg13_lv_nmos ad=0.1406p pd=1.12u as=0.1406p ps=1.12u w=0.74u l=0.13u
X1233 sg13cmos5l_inv_16_15.Y sg13cmos5l_inv_16_15.A VGND.t450 VGND.t501 sg13_lv_nmos ad=0.1406p pd=1.12u as=0.2516p ps=2.16u w=0.74u l=0.13u
X1234 sg13cmos5l_inv_16_41.A sg13cmos5l_inv_8_3.Y VPWR.t1236 VPWR.t4 sg13_lv_pmos ad=0.2128p pd=1.5u as=0.2128p ps=1.5u w=1.12u l=0.13u
X1235 VGND.t1715 sg13cmos5l_inv_16_46.Y sg13cmos5l_inv_16_50.Y VGND.t380 sg13_lv_nmos ad=0.1406p pd=1.12u as=0.1406p ps=1.12u w=0.74u l=0.13u
X1236 VGND.t756 VPWR.t2549 VGND.t1779 VGND.t380 sg13_lv_nmos ad=79.8f pd=0.8u as=0 ps=0 w=0.42u l=1u
X1237 VGND.t2136 VPWR.t178 VGND.t2135 VGND.t2134 sg13_lv_nmos ad=0.1428p pd=1.52u as=0 ps=0 w=0.42u l=1u
X1238 VGND.t1132 sg13cmos5l_inv_16_109.Y sg13cmos5l_inv_16_67.A VGND.t881 sg13_lv_nmos ad=0.1406p pd=1.12u as=0.1406p ps=1.12u w=0.74u l=0.13u
X1239 sg13cmos5l_inv_16_111.Y sg13cmos5l_inv_16_111.A VPWR.t1947 VPWR.t16 sg13_lv_pmos ad=0.2128p pd=1.5u as=0.2128p ps=1.5u w=1.12u l=0.13u
X1240 VGND.t1243 VPWR.t2480 VGND.t1243 VGND.t2096 sg13_lv_nmos ad=0.1428p pd=1.52u as=0 ps=0 w=0.42u l=1u
X1241 sg13cmos5l_inv_16_36.Y sg13cmos5l_inv_16_36.A VPWR.t573 VPWR.t4 sg13_lv_pmos ad=0.2128p pd=1.5u as=0.3808p ps=2.92u w=1.12u l=0.13u
X1242 sg13cmos5l_inv_16_53.A sg13cmos5l_inv_16_52.Y VGND.t1164 VGND.t881 sg13_lv_nmos ad=0.1406p pd=1.12u as=0.1406p ps=1.12u w=0.74u l=0.13u
X1243 VGND.t1970 sg13cmos5l_inv_16_76.A sg13cmos5l_inv_16_77.A VGND.t380 sg13_lv_nmos ad=0.1406p pd=1.12u as=0.1406p ps=1.12u w=0.74u l=0.13u
X1244 VPWR.t1246 sg13cmos5l_inv_16_0.A sg13cmos5l_inv_16_23.Y VPWR.t4 sg13_lv_pmos ad=0.2128p pd=1.5u as=0.2128p ps=1.5u w=1.12u l=0.13u
X1245 sg13cmos5l_inv_16_2.A sg13cmos5l_inv_16_1.A VPWR.t1085 VPWR.t4 sg13_lv_pmos ad=0.2128p pd=1.5u as=0.2128p ps=1.5u w=1.12u l=0.13u
X1246 VGND.t953 sg13cmos5l_inv_16_96.Y sg13cmos5l_inv_16_81.Y VGND.t380 sg13_lv_nmos ad=0.1406p pd=1.12u as=0.1406p ps=1.12u w=0.74u l=0.13u
X1247 sg13cmos5l_inv_16_99.A sg13cmos5l_inv_16_34.Y VGND.t593 VGND.t599 sg13_lv_nmos ad=0.1406p pd=1.12u as=0.1406p ps=1.12u w=0.74u l=0.13u
X1248 sg13cmos5l_inv_16_80.Y sg13cmos5l_inv_16_105.A VGND.t1100 VGND.t1102 sg13_lv_nmos ad=0.1406p pd=1.12u as=0.1406p ps=1.12u w=0.74u l=0.13u
X1249 VPWR.t1820 sg13cmos5l_inv_16_2.A sg13cmos5l_inv_16_2.Y VPWR.t177 sg13_lv_pmos ad=0.2128p pd=1.5u as=0.2128p ps=1.5u w=1.12u l=0.13u
X1250 sg13cmos5l_inv_16_23.Y sg13cmos5l_inv_16_0.A VGND.t827 VGND.t841 sg13_lv_nmos ad=0.1406p pd=1.12u as=0.1406p ps=1.12u w=0.74u l=0.13u
X1251 sg13cmos5l_inv_16_67.A sg13cmos5l_inv_16_109.Y VPWR.t1546 VPWR.t9 sg13_lv_pmos ad=0.2128p pd=1.5u as=0.2128p ps=1.5u w=1.12u l=0.13u
X1252 sg13cmos5l_inv_16_105.A sg13cmos5l_inv_16_11.A VGND.t353 VGND.t358 sg13_lv_nmos ad=0.1406p pd=1.12u as=0.1406p ps=1.12u w=0.74u l=0.13u
X1253 VPWR.t343 VGND.t390 VPWR.t342 VPWR.t16 sg13_lv_pmos ad=0.34p pd=2.68u as=0 ps=0 w=1u l=1u
X1254 VGND.t96 sg13cmos5l_inv_16_17.A sg13cmos5l_inv_16_19.Y VGND.t95 sg13_lv_nmos ad=0.1406p pd=1.12u as=0.1406p ps=1.12u w=0.74u l=0.13u
X1255 VGND.t882 sg13cmos5l_inv_16_68.A sg13cmos5l_inv_16_68.Y VGND.t881 sg13_lv_nmos ad=0.1406p pd=1.12u as=0.1406p ps=1.12u w=0.74u l=0.13u
X1256 VPWR.t1234 sg13cmos5l_inv_8_3.Y sg13cmos5l_inv_16_41.A VPWR.t4 sg13_lv_pmos ad=0.2128p pd=1.5u as=0.2128p ps=1.5u w=1.12u l=0.13u
X1257 sg13cmos5l_inv_16_50.Y sg13cmos5l_inv_16_46.Y VGND.t1715 VGND.t380 sg13_lv_nmos ad=0.1406p pd=1.12u as=0.1406p ps=1.12u w=0.74u l=0.13u
X1258 VPWR.t1512 sg13cmos5l_inv_16_105.A sg13cmos5l_inv_16_80.Y VPWR.t25 sg13_lv_pmos ad=0.2128p pd=1.5u as=0.2128p ps=1.5u w=1.12u l=0.13u
X1259 VGND.t827 sg13cmos5l_inv_16_0.A sg13cmos5l_inv_16_1.A VGND.t855 sg13_lv_nmos ad=0.1406p pd=1.12u as=0.1406p ps=1.12u w=0.74u l=0.13u
X1260 sg13cmos5l_and2_1_1.X a_20397_1980# VGND.t255 VGND.t254 sg13_lv_nmos ad=0.2516p pd=2.16u as=0.1331p ps=1.12u w=0.74u l=0.13u
X1261 sg13cmos5l_inv_16_87.A sg13cmos5l_inv_16_73.A VPWR.t1863 VPWR.t9 sg13_lv_pmos ad=0.2128p pd=1.5u as=0.2128p ps=1.5u w=1.12u l=0.13u
X1262 sg13cmos5l_inv_16_67.A sg13cmos5l_inv_16_109.Y VGND.t1132 VGND.t881 sg13_lv_nmos ad=0.1406p pd=1.12u as=0.1406p ps=1.12u w=0.74u l=0.13u
X1263 VPWR.t1083 sg13cmos5l_inv_16_1.A sg13cmos5l_inv_16_2.A VPWR.t4 sg13_lv_pmos ad=0.2128p pd=1.5u as=0.2128p ps=1.5u w=1.12u l=0.13u
X1264 VGND.t1164 sg13cmos5l_inv_16_52.Y sg13cmos5l_inv_16_53.A VGND.t881 sg13_lv_nmos ad=0.1406p pd=1.12u as=0.1406p ps=1.12u w=0.74u l=0.13u
X1265 sg13cmos5l_inv_16_46.Y sg13cmos5l_inv_16_46.A VPWR.t2111 VPWR.t25 sg13_lv_pmos ad=0.2128p pd=1.5u as=0.4368p ps=3.02u w=1.12u l=0.13u
X1266 VGND.t545 sg13cmos5l_inv_16_96.A sg13cmos5l_inv_16_96.Y VGND.t952 sg13_lv_nmos ad=0.2516p pd=2.16u as=0.1406p ps=1.12u w=0.74u l=0.13u
X1267 VGND.t827 sg13cmos5l_inv_16_0.A sg13cmos5l_inv_16_23.Y VGND.t838 sg13_lv_nmos ad=0.1406p pd=1.12u as=0.1406p ps=1.12u w=0.74u l=0.13u
X1268 VGND.t259 sg13cmos5l_inv_16_28.A sg13cmos5l_inv_16_44.A VGND.t261 sg13_lv_nmos ad=0.1406p pd=1.12u as=0.1406p ps=1.12u w=0.74u l=0.13u
X1269 sg13cmos5l_inv_16_111.A sg13cmos5l_inv_16_109.Y VPWR.t1536 VPWR.t9 sg13_lv_pmos ad=0.2128p pd=1.5u as=0.2128p ps=1.5u w=1.12u l=0.13u
X1270 VGND.t593 sg13cmos5l_inv_16_34.Y sg13cmos5l_inv_16_99.A VGND.t596 sg13_lv_nmos ad=0.1406p pd=1.12u as=0.1406p ps=1.12u w=0.74u l=0.13u
X1271 VPWR.t614 sg13cmos5l_inv_16_43.Y sg13cmos5l_inv_16_36.A VPWR.t0 sg13_lv_pmos ad=0.2128p pd=1.5u as=0.2128p ps=1.5u w=1.12u l=0.13u
X1272 VPWR.t394 VGND.t635 VPWR.t393 VPWR.t4 sg13_lv_pmos ad=0.34p pd=2.68u as=0 ps=0 w=1u l=1u
X1273 VGND.t1553 VPWR.t2600 VGND.t1553 VGND.t1887 sg13_lv_nmos ad=0.1428p pd=1.52u as=0 ps=0 w=0.42u l=1u
X1274 sg13cmos5l_inv_16_105.Y sg13cmos5l_inv_16_105.A VPWR.t1522 VPWR.t0 sg13_lv_pmos ad=0.2128p pd=1.5u as=0.2128p ps=1.5u w=1.12u l=0.13u
X1275 VPWR.t2421 sg13cmos5l_inv_8_0.Y sg13cmos5l_inv_16_0.A VPWR.t177 sg13_lv_pmos ad=0.3808p pd=2.92u as=0.2128p ps=1.5u w=1.12u l=0.13u
X1276 sg13cmos5l_inv_16_68.A sg13cmos5l_inv_16_71.Y VGND.t882 VGND.t881 sg13_lv_nmos ad=0.1406p pd=1.12u as=0.1406p ps=1.12u w=0.74u l=0.13u
X1277 sg13cmos5l_inv_4_0.Y sg13cmos5l_inv_4_0.A VPWR.t1957 VPWR.t177 sg13_lv_pmos ad=0.2128p pd=1.5u as=0.2128p ps=1.5u w=1.12u l=0.13u
X1278 VGND.t255 sg13cmos5l_inv_8_1.Y sg13cmos5l_inv_16_4.Y VGND.t1465 sg13_lv_nmos ad=0.2516p pd=2.16u as=0.1406p ps=1.12u w=0.74u l=0.13u
X1279 VGND.t1541 sg13cmos5l_inv_16_111.A sg13cmos5l_inv_16_98.Y VGND.t1546 sg13_lv_nmos ad=0.1406p pd=1.12u as=0.1406p ps=1.12u w=0.74u l=0.13u
X1280 sg13cmos5l_inv_16_68.Y sg13cmos5l_inv_16_68.A VGND.t882 VGND.t881 sg13_lv_nmos ad=0.1406p pd=1.12u as=0.1406p ps=1.12u w=0.74u l=0.13u
X1281 sg13cmos5l_inv_16_62.Y sg13cmos5l_inv_16_69.Y VGND.t922 VGND.t881 sg13_lv_nmos ad=0.1406p pd=1.12u as=0.1406p ps=1.12u w=0.74u l=0.13u
X1282 VGND.t381 sg13cmos5l_inv_16_73.A sg13cmos5l_inv_16_73.Y VGND.t380 sg13_lv_nmos ad=0.1406p pd=1.12u as=0.1406p ps=1.12u w=0.74u l=0.13u
X1283 VGND.t5 sg13cmos5l_inv_16_37.A sg13cmos5l_inv_16_102.Y VGND.t6 sg13_lv_nmos ad=0.1406p pd=1.12u as=0.1406p ps=1.12u w=0.74u l=0.13u
X1284 VPWR.t911 sg13cmos5l_inv_16_14.A sg13cmos5l_inv_16_104.Y VPWR.t0 sg13_lv_pmos ad=0.2128p pd=1.5u as=0.2128p ps=1.5u w=1.12u l=0.13u
X1285 VPWR.t246 sg13cmos5l_inv_16_6.A sg13cmos5l_inv_16_6.Y VPWR.t177 sg13_lv_pmos ad=0.4368p pd=3.02u as=0.2128p ps=1.5u w=1.12u l=0.13u
X1286 VPWR.t1637 sg13cmos5l_inv_4_2.Y sg13cmos5l_inv_8_3.Y VPWR.t4 sg13_lv_pmos ad=0.2128p pd=1.5u as=0.2128p ps=1.5u w=1.12u l=0.13u
X1287 sg13cmos5l_inv_16_41.A sg13cmos5l_inv_8_3.Y VPWR.t1230 VPWR.t4 sg13_lv_pmos ad=0.2128p pd=1.5u as=0.2128p ps=1.5u w=1.12u l=0.13u
X1288 sg13cmos5l_inv_16_80.Y sg13cmos5l_inv_16_105.A VPWR.t1508 VPWR.t25 sg13_lv_pmos ad=0.2128p pd=1.5u as=0.2128p ps=1.5u w=1.12u l=0.13u
X1289 sg13cmos5l_inv_16_40.Y sg13cmos5l_inv_16_26.Y VGND.t326 VGND.t330 sg13_lv_nmos ad=0.1406p pd=1.12u as=0.1406p ps=1.12u w=0.74u l=0.13u
X1290 sg13cmos5l_inv_16_44.Y sg13cmos5l_inv_16_44.A VPWR.t623 VPWR.t4 sg13_lv_pmos ad=0.2128p pd=1.5u as=0.2128p ps=1.5u w=1.12u l=0.13u
X1291 sg13cmos5l_inv_16_20.Y sg13cmos5l_inv_16_20.A VPWR.t891 VPWR.t4 sg13_lv_pmos ad=0.2128p pd=1.5u as=0.2128p ps=1.5u w=1.12u l=0.13u
X1292 VPWR.t1861 sg13cmos5l_inv_16_73.A sg13cmos5l_inv_16_87.A VPWR.t9 sg13_lv_pmos ad=0.2128p pd=1.5u as=0.2128p ps=1.5u w=1.12u l=0.13u
X1293 VPWR.t1187 sg13cmos5l_inv_8_7.Y sg13cmos5l_inv_16_48.A VPWR.t25 sg13_lv_pmos ad=0.3808p pd=2.92u as=0.2128p ps=1.5u w=1.12u l=0.13u
X1294 sg13cmos5l_inv_16_96.Y sg13cmos5l_inv_16_96.A VGND.t545 VGND.t949 sg13_lv_nmos ad=0.1406p pd=1.12u as=0.1406p ps=1.12u w=0.74u l=0.13u
X1295 a_7051_3492# sg13cmos5l_buf_1_5.X a_6957_3492# VGND.t80 sg13_lv_nmos ad=0.1216p pd=1.02u as=0.2176p ps=1.96u w=0.64u l=0.13u
X1296 VPWR.t1563 sg13cmos5l_inv_16_109.Y sg13cmos5l_inv_16_111.A VPWR.t9 sg13_lv_pmos ad=0.2128p pd=1.5u as=0.2128p ps=1.5u w=1.12u l=0.13u
X1297 VGND.t1026 sg13cmos5l_inv_16_79.A sg13cmos5l_inv_16_91.Y VGND.t881 sg13_lv_nmos ad=0.2516p pd=2.16u as=0.1406p ps=1.12u w=0.74u l=0.13u
X1298 VPWR.t1520 sg13cmos5l_inv_16_105.A sg13cmos5l_inv_16_105.Y VPWR.t0 sg13_lv_pmos ad=0.2128p pd=1.5u as=0.2128p ps=1.5u w=1.12u l=0.13u
X1299 sg13cmos5l_inv_16_67.A sg13cmos5l_inv_16_109.Y VPWR.t1542 VPWR.t9 sg13_lv_pmos ad=0.2128p pd=1.5u as=0.2128p ps=1.5u w=1.12u l=0.13u
X1300 sg13cmos5l_inv_16_98.Y sg13cmos5l_inv_16_111.A VGND.t1541 VGND.t1543 sg13_lv_nmos ad=0.1406p pd=1.12u as=0.1406p ps=1.12u w=0.74u l=0.13u
X1301 VGND.t1 VPWR.t2538 VGND.t1 VGND.t1996 sg13_lv_nmos ad=0.1428p pd=1.52u as=0 ps=0 w=0.42u l=1u
X1302 VGND.t198 sg13cmos5l_inv_16_28.A sg13cmos5l_inv_16_29.A VGND.t213 sg13_lv_nmos ad=0.2516p pd=2.16u as=0.1406p ps=1.12u w=0.74u l=0.13u
X1303 VGND.t922 sg13cmos5l_inv_16_69.Y sg13cmos5l_inv_16_62.Y VGND.t881 sg13_lv_nmos ad=0.1406p pd=1.12u as=0.1406p ps=1.12u w=0.74u l=0.13u
X1304 VPWR.t1022 sg13cmos5l_inv_16_34.Y sg13cmos5l_inv_16_99.A VPWR.t25 sg13_lv_pmos ad=0.2128p pd=1.5u as=0.2128p ps=1.5u w=1.12u l=0.13u
X1305 VPWR.t1613 sg13cmos5l_inv_16_103.A sg13cmos5l_inv_16_103.Y VPWR.t0 sg13_lv_pmos ad=0.2128p pd=1.5u as=0.2128p ps=1.5u w=1.12u l=0.13u
X1306 sg13cmos5l_inv_16_104.Y sg13cmos5l_inv_16_14.A VPWR.t907 VPWR.t0 sg13_lv_pmos ad=0.2128p pd=1.5u as=0.2128p ps=1.5u w=1.12u l=0.13u
X1307 sg13cmos5l_inv_16_6.Y sg13cmos5l_inv_16_6.A VPWR.t246 VPWR.t177 sg13_lv_pmos ad=0.2128p pd=1.5u as=0.2128p ps=1.5u w=1.12u l=0.13u
X1308 sg13cmos5l_inv_8_3.Y sg13cmos5l_inv_4_2.Y VPWR.t1633 VPWR.t4 sg13_lv_pmos ad=0.2128p pd=1.5u as=0.2128p ps=1.5u w=1.12u l=0.13u
X1309 sg13cmos5l_inv_16_75.Y sg13cmos5l_inv_16_75.A VGND.t122 VGND.t411 sg13_lv_nmos ad=0.1406p pd=1.12u as=0.1406p ps=1.12u w=0.74u l=0.13u
X1310 VGND.t2045 osc[2] a_2920_3932# VGND.t2197 sg13_lv_nmos ad=0.14875p pd=1.16u as=0.187p ps=1.78u w=0.55u l=0.13u
X1311 VGND.t326 sg13cmos5l_inv_16_26.Y sg13cmos5l_inv_16_40.Y VGND.t327 sg13_lv_nmos ad=0.1406p pd=1.12u as=0.1406p ps=1.12u w=0.74u l=0.13u
X1312 VGND.t635 VPWR.t2479 VGND.t635 VGND.t2098 sg13_lv_nmos ad=0.1428p pd=1.52u as=0 ps=0 w=0.42u l=1u
X1313 sg13cmos5l_inv_16_56.Y sg13cmos5l_inv_8_4.Y VGND.t1944 VGND.t380 sg13_lv_nmos ad=0.1406p pd=1.12u as=0.1406p ps=1.12u w=0.74u l=0.13u
X1314 VGND.t1779 sg13cmos5l_inv_16_79.A sg13cmos5l_inv_16_79.Y VGND.t380 sg13_lv_nmos ad=0.1406p pd=1.12u as=0.1406p ps=1.12u w=0.74u l=0.13u
X1315 VPWR.t784 sg13cmos5l_inv_16_11.A sg13cmos5l_inv_16_105.A VPWR.t25 sg13_lv_pmos ad=0.2128p pd=1.5u as=0.2128p ps=1.5u w=1.12u l=0.13u
X1316 VPWR.t220 VGND.t122 VPWR.t218 VPWR.t0 sg13_lv_pmos ad=0.19p pd=1.38u as=0 ps=0 w=1u l=1u
X1317 VPWR.t383 VGND.t432 VPWR.t381 VPWR.t0 sg13_lv_pmos ad=0.19p pd=1.38u as=0 ps=0 w=1u l=1u
X1318 sg13cmos5l_inv_16_91.Y sg13cmos5l_inv_16_79.A VGND.t1026 VGND.t881 sg13_lv_nmos ad=0.1406p pd=1.12u as=0.1406p ps=1.12u w=0.74u l=0.13u
X1319 sg13cmos5l_inv_16_20.A sg13cmos5l_inv_16_8.Y VPWR.t970 VPWR.t0 sg13_lv_pmos ad=0.2128p pd=1.5u as=0.2128p ps=1.5u w=1.12u l=0.13u
X1320 VGND.t588 sg13cmos5l_inv_4_0.Y sg13cmos5l_inv_8_0.Y VGND.t1804 sg13_lv_nmos ad=0.2516p pd=2.16u as=0.1443p ps=1.13u w=0.74u l=0.13u
X1321 sg13cmos5l_inv_16_101.Y sg13cmos5l_inv_16_34.Y VPWR.t1032 VPWR.t0 sg13_lv_pmos ad=0.2128p pd=1.5u as=0.2128p ps=1.5u w=1.12u l=0.13u
X1322 VPWR.t1540 sg13cmos5l_inv_16_109.Y sg13cmos5l_inv_16_67.A VPWR.t9 sg13_lv_pmos ad=0.2128p pd=1.5u as=0.2128p ps=1.5u w=1.12u l=0.13u
X1323 sg13cmos5l_inv_16_46.A sg13cmos5l_inv_16_48.A VPWR.t2108 VPWR.t25 sg13_lv_pmos ad=0.2128p pd=1.5u as=0.2128p ps=1.5u w=1.12u l=0.13u
X1324 VPWR.t1654 sg13cmos5l_inv_16_27.Y sg13cmos5l_inv_16_43.Y VPWR.t4 sg13_lv_pmos ad=0.2128p pd=1.5u as=0.2128p ps=1.5u w=1.12u l=0.13u
X1325 VGND.t450 VPWR.t2485 VGND.t450 VGND.t2087 sg13_lv_nmos ad=0.1428p pd=1.52u as=0 ps=0 w=0.42u l=1u
X1326 sg13cmos5l_inv_16_61.A sg13cmos5l_inv_16_71.Y VPWR.t1368 VPWR.t9 sg13_lv_pmos ad=0.2128p pd=1.5u as=0.3808p ps=2.92u w=1.12u l=0.13u
X1327 sg13cmos5l_inv_16_99.A sg13cmos5l_inv_16_34.Y VPWR.t1018 VPWR.t25 sg13_lv_pmos ad=0.2128p pd=1.5u as=0.2128p ps=1.5u w=1.12u l=0.13u
X1328 VPWR.t246 sg13cmos5l_inv_16_6.A sg13cmos5l_inv_16_6.Y VPWR.t177 sg13_lv_pmos ad=0.2128p pd=1.5u as=0.2128p ps=1.5u w=1.12u l=0.13u
X1329 VGND.t122 sg13cmos5l_inv_16_75.A sg13cmos5l_inv_16_75.Y VGND.t408 sg13_lv_nmos ad=0.1406p pd=1.12u as=0.1406p ps=1.12u w=0.74u l=0.13u
X1330 VPWR.t796 sg13cmos5l_inv_16_11.A sg13cmos5l_inv_16_103.A VPWR.t0 sg13_lv_pmos ad=0.2128p pd=1.5u as=0.2128p ps=1.5u w=1.12u l=0.13u
X1331 sg13cmos5l_inv_16_109.Y sg13cmos5l_inv_16_48.A VPWR.t2090 VPWR.t16 sg13_lv_pmos ad=0.2128p pd=1.5u as=0.2128p ps=1.5u w=1.12u l=0.13u
X1332 sg13cmos5l_inv_16_20.Y sg13cmos5l_inv_16_20.A VPWR.t887 VPWR.t4 sg13_lv_pmos ad=0.2128p pd=1.5u as=0.2128p ps=1.5u w=1.12u l=0.13u
X1333 VPWR.t1392 sg13cmos5l_inv_16_71.Y sg13cmos5l_inv_16_68.A VPWR.t9 sg13_lv_pmos ad=0.2128p pd=1.5u as=0.2128p ps=1.5u w=1.12u l=0.13u
X1334 VGND.t953 sg13cmos5l_inv_16_96.Y sg13cmos5l_inv_16_81.Y VGND.t380 sg13_lv_nmos ad=0.1406p pd=1.12u as=0.1406p ps=1.12u w=0.74u l=0.13u
X1335 VGND.t1143 VPWR.t2588 VGND.t1143 VGND.t881 sg13_lv_nmos ad=79.8f pd=0.8u as=0 ps=0 w=0.42u l=1u
X1336 VGND.t655 sg13cmos5l_inv_16_2.A sg13cmos5l_inv_16_2.Y VGND.t1443 sg13_lv_nmos ad=0.1406p pd=1.12u as=0.1406p ps=1.12u w=0.74u l=0.13u
X1337 VPWR.t1336 sg13cmos5l_inv_16_69.Y sg13cmos5l_inv_16_62.Y VPWR.t9 sg13_lv_pmos ad=0.2128p pd=1.5u as=0.2128p ps=1.5u w=1.12u l=0.13u
X1338 VGND.t1029 VPWR.t2583 VGND.t1029 VGND.t881 sg13_lv_nmos ad=0.1428p pd=1.52u as=0 ps=0 w=0.42u l=1u
X1339 VGND.t637 sg13cmos5l_inv_16_6.A sg13cmos5l_inv_16_5.Y VGND.t1391 sg13_lv_nmos ad=0.1406p pd=1.12u as=0.1406p ps=1.12u w=0.74u l=0.13u
X1340 VGND.t86 sg13cmos5l_inv_16_17.A sg13cmos5l_inv_16_19.Y VGND.t91 sg13_lv_nmos ad=0.1406p pd=1.12u as=0.1406p ps=1.12u w=0.74u l=0.13u
X1341 sg13cmos5l_inv_16_43.Y sg13cmos5l_inv_16_27.Y VPWR.t1650 VPWR.t4 sg13_lv_pmos ad=0.2128p pd=1.5u as=0.2128p ps=1.5u w=1.12u l=0.13u
X1342 sg13cmos5l_inv_16_74.Y sg13cmos5l_inv_16_75.A VGND.t390 VGND.t380 sg13_lv_nmos ad=0.1406p pd=1.12u as=0.1406p ps=1.12u w=0.74u l=0.13u
X1343 VGND.t1779 VPWR.t2548 VGND.t1779 VGND.t380 sg13_lv_nmos ad=79.8f pd=0.8u as=0 ps=0 w=0.42u l=1u
X1344 VPWR.t1356 sg13cmos5l_inv_16_96.A sg13cmos5l_inv_16_96.Y VPWR.t25 sg13_lv_pmos ad=0.2128p pd=1.5u as=0.2128p ps=1.5u w=1.12u l=0.13u
X1345 VGND.t3 VPWR.t2505 VGND.t3 VGND.t2052 sg13_lv_nmos ad=0.1428p pd=1.52u as=0 ps=0 w=0.42u l=1u
X1346 VGND.t1164 sg13cmos5l_inv_16_52.Y sg13cmos5l_inv_16_53.A VGND.t881 sg13_lv_nmos ad=0.1406p pd=1.12u as=0.1406p ps=1.12u w=0.74u l=0.13u
X1347 sg13cmos5l_inv_16_75.Y sg13cmos5l_inv_16_75.A VGND.t122 VGND.t405 sg13_lv_nmos ad=0.1406p pd=1.12u as=0.1406p ps=1.12u w=0.74u l=0.13u
X1348 sg13cmos5l_inv_16_103.A sg13cmos5l_inv_16_11.A VPWR.t792 VPWR.t0 sg13_lv_pmos ad=0.2128p pd=1.5u as=0.2128p ps=1.5u w=1.12u l=0.13u
X1349 VPWR.t2060 sg13cmos5l_inv_16_53.A sg13cmos5l_inv_16_53.Y VPWR.t16 sg13_lv_pmos ad=0.2128p pd=1.5u as=0.2128p ps=1.5u w=1.12u l=0.13u
X1350 sg13cmos5l_inv_16_68.A sg13cmos5l_inv_16_71.Y VPWR.t1388 VPWR.t9 sg13_lv_pmos ad=0.2128p pd=1.5u as=0.2128p ps=1.5u w=1.12u l=0.13u
X1351 sg13cmos5l_inv_16_81.Y sg13cmos5l_inv_16_96.Y VGND.t1792 VGND.t380 sg13_lv_nmos ad=0.1406p pd=1.12u as=0.1406p ps=1.12u w=0.74u l=0.13u
X1352 sg13cmos5l_inv_4_6.A sg13cmos5l_inv_1_5.Y VPWR.t1309 VPWR.t25 sg13_lv_pmos ad=0.2128p pd=1.5u as=0.3808p ps=2.92u w=1.12u l=0.13u
X1353 VGND.t827 sg13cmos5l_inv_16_0.A sg13cmos5l_inv_16_23.Y VGND.t834 sg13_lv_nmos ad=0.1406p pd=1.12u as=0.1406p ps=1.12u w=0.74u l=0.13u
X1354 VPWR.t679 sg13cmos5l_inv_16_41.A sg13cmos5l_inv_16_28.A VPWR.t4 sg13_lv_pmos ad=0.2128p pd=1.5u as=0.2128p ps=1.5u w=1.12u l=0.13u
X1355 VPWR.t859 VGND.t1132 VPWR.t858 VPWR.t9 sg13_lv_pmos ad=0.34p pd=2.68u as=0 ps=0 w=1u l=1u
X1356 sg13cmos5l_inv_16_2.Y sg13cmos5l_inv_16_2.A VGND.t655 VGND.t1440 sg13_lv_nmos ad=0.1406p pd=1.12u as=0.1406p ps=1.12u w=0.74u l=0.13u
X1357 sg13cmos5l_inv_16_62.Y sg13cmos5l_inv_16_69.Y VPWR.t1332 VPWR.t9 sg13_lv_pmos ad=0.2128p pd=1.5u as=0.2128p ps=1.5u w=1.12u l=0.13u
X1358 VGND.t922 sg13cmos5l_inv_16_52.Y sg13cmos5l_inv_16_69.Y VGND.t881 sg13_lv_nmos ad=0.1406p pd=1.12u as=0.1406p ps=1.12u w=0.74u l=0.13u
X1359 VPWR.t188 VGND.t1718 VPWR.t185 VPWR.t16 sg13_lv_pmos ad=0.19p pd=1.38u as=0 ps=0 w=1u l=1u
X1360 VPWR.t610 sg13cmos5l_inv_16_43.Y sg13cmos5l_inv_16_36.A VPWR.t0 sg13_lv_pmos ad=0.2128p pd=1.5u as=0.2128p ps=1.5u w=1.12u l=0.13u
X1361 sg13cmos5l_inv_16_71.Y sg13cmos5l_inv_16_56.Y VPWR.t2027 VPWR.t16 sg13_lv_pmos ad=0.2128p pd=1.5u as=0.4368p ps=3.02u w=1.12u l=0.13u
X1362 sg13cmos5l_inv_16_105.Y sg13cmos5l_inv_16_105.A VGND.t345 VGND.t1114 sg13_lv_nmos ad=0.1406p pd=1.12u as=0.1406p ps=1.12u w=0.74u l=0.13u
X1363 sg13cmos5l_inv_16_4.Y sg13cmos5l_inv_8_1.Y VPWR.t329 VPWR.t177 sg13_lv_pmos ad=0.2128p pd=1.5u as=0.2128p ps=1.5u w=1.12u l=0.13u
X1364 sg13cmos5l_inv_16_5.Y sg13cmos5l_inv_16_6.A VGND.t637 VGND.t1388 sg13_lv_nmos ad=0.1406p pd=1.12u as=0.1406p ps=1.12u w=0.74u l=0.13u
X1365 VPWR.t147 VGND.t3 VPWR.t146 VPWR.t0 sg13_lv_pmos ad=0.34p pd=2.68u as=0 ps=0 w=1u l=1u
X1366 sg13cmos5l_inv_16_19.Y sg13cmos5l_inv_16_17.A VGND.t86 VGND.t88 sg13_lv_nmos ad=0.1406p pd=1.12u as=0.1406p ps=1.12u w=0.74u l=0.13u
X1367 VPWR.t868 sg13cmos5l_inv_16_20.A sg13cmos5l_inv_16_22.Y VPWR.t0 sg13_lv_pmos ad=0.2128p pd=1.5u as=0.2128p ps=1.5u w=1.12u l=0.13u
X1368 sg13cmos5l_inv_16_1.A sg13cmos5l_inv_16_0.A VGND.t845 VGND.t848 sg13_lv_nmos ad=0.1406p pd=1.12u as=0.1406p ps=1.12u w=0.74u l=0.13u
X1369 VPWR.t1857 sg13cmos5l_inv_16_73.A sg13cmos5l_inv_16_87.A VPWR.t9 sg13_lv_pmos ad=0.2128p pd=1.5u as=0.2128p ps=1.5u w=1.12u l=0.13u
X1370 VPWR.t1001 sg13cmos5l_inv_8_2.A sg13cmos5l_inv_16_27.A VPWR.t177 sg13_lv_pmos ad=0.3808p pd=2.92u as=0.2184p ps=1.51u w=1.12u l=0.13u
X1371 VPWR.t1559 sg13cmos5l_inv_16_109.Y sg13cmos5l_inv_16_111.A VPWR.t9 sg13_lv_pmos ad=0.2128p pd=1.5u as=0.2128p ps=1.5u w=1.12u l=0.13u
X1372 sg13cmos5l_inv_16_55.Y sg13cmos5l_inv_16_101.Y VPWR.t2350 VPWR.t25 sg13_lv_pmos ad=0.2128p pd=1.5u as=0.2128p ps=1.5u w=1.12u l=0.13u
X1373 sg13cmos5l_inv_16_30.Y sg13cmos5l_inv_16_30.A VGND.t343 VGND.t1308 sg13_lv_nmos ad=0.1406p pd=1.12u as=0.1406p ps=1.12u w=0.74u l=0.13u
X1374 VGND.t756 sg13cmos5l_inv_8_7.Y sg13cmos5l_inv_16_48.A VGND.t380 sg13_lv_nmos ad=0.1406p pd=1.12u as=0.1406p ps=1.12u w=0.74u l=0.13u
X1375 a_16941_916# sg13cmos5l_buf_1_3.X VPWR.t246 VPWR.t177 sg13_lv_pmos ad=0.1596p pd=1.22u as=0.2856p ps=2.36u w=0.84u l=0.13u
X1376 VGND.t655 sg13cmos5l_inv_16_2.A sg13cmos5l_inv_16_2.Y VGND.t1437 sg13_lv_nmos ad=0.1406p pd=1.12u as=0.1406p ps=1.12u w=0.74u l=0.13u
X1377 sg13cmos5l_inv_16_69.Y sg13cmos5l_inv_16_52.Y VGND.t922 VGND.t881 sg13_lv_nmos ad=0.1406p pd=1.12u as=0.1406p ps=1.12u w=0.74u l=0.13u
X1378 sg13cmos5l_inv_16_75.Y sg13cmos5l_inv_16_75.A VPWR.t830 VPWR.t25 sg13_lv_pmos ad=0.2128p pd=1.5u as=0.2128p ps=1.5u w=1.12u l=0.13u
X1379 VGND.t345 sg13cmos5l_inv_16_105.A sg13cmos5l_inv_16_105.Y VGND.t1111 sg13_lv_nmos ad=0.1406p pd=1.12u as=0.1406p ps=1.12u w=0.74u l=0.13u
X1380 sg13cmos5l_inv_16_17.Y sg13cmos5l_inv_16_17.A VGND.t84 VGND.t107 sg13_lv_nmos ad=0.1406p pd=1.12u as=0.1406p ps=1.12u w=0.74u l=0.13u
X1381 VPWR.t707 sg13cmos5l_inv_16_28.A sg13cmos5l_inv_16_29.A VPWR.t177 sg13_lv_pmos ad=0.2128p pd=1.5u as=0.2128p ps=1.5u w=1.12u l=0.13u
X1382 VGND.t1010 sg13cmos5l_inv_16_87.A sg13cmos5l_inv_16_87.Y VGND.t881 sg13_lv_nmos ad=0.1406p pd=1.12u as=0.1406p ps=1.12u w=0.74u l=0.13u
X1383 sg13cmos5l_inv_16_73.Y sg13cmos5l_inv_16_73.A VGND.t381 VGND.t380 sg13_lv_nmos ad=0.1406p pd=1.12u as=0.1406p ps=1.12u w=0.74u l=0.13u
X1384 sg13cmos5l_inv_16_104.Y sg13cmos5l_inv_16_14.A VPWR.t903 VPWR.t0 sg13_lv_pmos ad=0.2128p pd=1.5u as=0.2128p ps=1.5u w=1.12u l=0.13u
X1385 VGND.t343 sg13cmos5l_inv_16_30.A sg13cmos5l_inv_16_30.Y VGND.t1303 sg13_lv_nmos ad=0.1406p pd=1.12u as=0.1406p ps=1.12u w=0.74u l=0.13u
X1386 VPWR.t313 VGND.t353 VPWR.t312 VPWR.t25 sg13_lv_pmos ad=0.34p pd=2.68u as=0 ps=0 w=1u l=1u
X1387 sg13cmos5l_inv_16_15.A sg13cmos5l_inv_16_23.Y VPWR.t487 VPWR.t0 sg13_lv_pmos ad=0.2128p pd=1.5u as=0.3808p ps=2.92u w=1.12u l=0.13u
X1388 sg13cmos5l_inv_16_6.Y sg13cmos5l_inv_16_6.A VGND.t1419 VGND.t1420 sg13_lv_nmos ad=0.1406p pd=1.12u as=0.1406p ps=1.12u w=0.74u l=0.13u
X1389 sg13cmos5l_inv_16_8.Y sg13cmos5l_inv_16_4.Y VGND.t291 VGND.t301 sg13_lv_nmos ad=0.1406p pd=1.12u as=0.1406p ps=1.12u w=0.74u l=0.13u
X1390 sg13cmos5l_inv_16_52.Y sg13cmos5l_inv_16_56.Y VPWR.t2056 VPWR.t16 sg13_lv_pmos ad=0.2128p pd=1.5u as=0.2128p ps=1.5u w=1.12u l=0.13u
X1391 VPWR.t253 VGND.t196 VPWR.t260 VPWR.t4 sg13_lv_pmos ad=0.34p pd=2.68u as=0 ps=0 w=1u l=1u
X1392 sg13cmos5l_inv_16_101.Y sg13cmos5l_inv_16_34.Y VGND.t593 VGND.t605 sg13_lv_nmos ad=0.1406p pd=1.12u as=0.1406p ps=1.12u w=0.74u l=0.13u
X1393 VPWR.t178 sg13cmos5l_inv_16_26.Y sg13cmos5l_inv_16_40.Y VPWR.t177 sg13_lv_pmos ad=0.2128p pd=1.5u as=0.2128p ps=1.5u w=1.12u l=0.13u
X1394 sg13cmos5l_inv_16_87.Y sg13cmos5l_inv_16_87.A VGND.t1010 VGND.t881 sg13_lv_nmos ad=0.1406p pd=1.12u as=0.1406p ps=1.12u w=0.74u l=0.13u
X1395 VPWR.t350 VGND.t1792 VPWR.t349 VPWR.t16 sg13_lv_pmos ad=0.34p pd=2.68u as=0 ps=0 w=1u l=1u
X1396 VGND.t1580 sg13cmos5l_inv_16_67.A sg13cmos5l_inv_16_65.Y VGND.t1589 sg13_lv_nmos ad=0.1406p pd=1.12u as=0.1406p ps=1.12u w=0.74u l=0.13u
X1397 sg13cmos5l_inv_16_13.Y sg13cmos5l_inv_16_15.A VGND.t45 VGND.t513 sg13_lv_nmos ad=0.1406p pd=1.12u as=0.1406p ps=1.12u w=0.74u l=0.13u
X1398 VGND.t866 sg13cmos5l_inv_16_68.A sg13cmos5l_inv_16_66.Y VGND.t880 sg13_lv_nmos ad=0.2516p pd=2.16u as=0.1406p ps=1.12u w=0.74u l=0.13u
X1399 sg13cmos5l_inv_16_85.Y sg13cmos5l_inv_16_84.A VPWR.t1482 VPWR.t9 sg13_lv_pmos ad=0.2128p pd=1.5u as=0.2128p ps=1.5u w=1.12u l=0.13u
X1400 sg13cmos5l_inv_16_109.Y sg13cmos5l_inv_16_48.A VPWR.t2086 VPWR.t16 sg13_lv_pmos ad=0.2128p pd=1.5u as=0.2128p ps=1.5u w=1.12u l=0.13u
X1401 VGND.t1663 sg13cmos5l_inv_8_4.Y sg13cmos5l_inv_16_56.Y VGND.t380 sg13_lv_nmos ad=0.1406p pd=1.12u as=0.1406p ps=1.12u w=0.74u l=0.13u
X1402 VGND.t588 sg13cmos5l_inv_4_0.A sg13cmos5l_inv_4_0.Y VGND.t1577 sg13_lv_nmos ad=0.2516p pd=2.16u as=0.1406p ps=1.12u w=0.74u l=0.13u
X1403 sg13cmos5l_inv_16_36.Y sg13cmos5l_inv_16_36.A VGND.t146 VGND.t160 sg13_lv_nmos ad=0.1406p pd=1.12u as=0.1406p ps=1.12u w=0.74u l=0.13u
X1404 VPWR.t246 sg13cmos5l_inv_16_6.Y sg13cmos5l_inv_16_108.Y VPWR.t177 sg13_lv_pmos ad=0.2128p pd=1.5u as=0.2128p ps=1.5u w=1.12u l=0.13u
X1405 VGND.t39 sg13cmos5l_inv_16_41.A sg13cmos5l_inv_16_28.A VGND.t250 sg13_lv_nmos ad=0.2516p pd=2.16u as=0.1406p ps=1.12u w=0.74u l=0.13u
X1406 sg13cmos5l_inv_16_73.A sg13cmos5l_inv_16_94.A VGND.t1507 VGND.t881 sg13_lv_nmos ad=0.1406p pd=1.12u as=0.1406p ps=1.12u w=0.74u l=0.13u
X1407 VPWR.t310 VGND.t427 VPWR.t311 VPWR.t16 sg13_lv_pmos ad=0.19p pd=1.38u as=0 ps=0 w=1u l=1u
X1408 VPWR.t558 sg13cmos5l_inv_16_36.A sg13cmos5l_inv_16_100.Y VPWR.t0 sg13_lv_pmos ad=0.2128p pd=1.5u as=0.2128p ps=1.5u w=1.12u l=0.13u
X1409 VPWR.t687 osc[0] a_2920_1632# VPWR.t177 sg13_lv_pmos ad=0.2114p pd=1.54u as=0.2856p ps=2.36u w=0.84u l=0.13u
X1410 VPWR.t2054 sg13cmos5l_inv_16_56.Y sg13cmos5l_inv_16_52.Y VPWR.t16 sg13_lv_pmos ad=0.2128p pd=1.5u as=0.2128p ps=1.5u w=1.12u l=0.13u
X1411 VGND.t723 sg13cmos5l_inv_16_9.A sg13cmos5l_inv_16_10.Y VGND.t728 sg13_lv_nmos ad=0.1406p pd=1.12u as=0.1406p ps=1.12u w=0.74u l=0.13u
X1412 VGND.t545 sg13cmos5l_inv_16_8.Y sg13cmos5l_inv_16_20.A VGND.t551 sg13_lv_nmos ad=0.1406p pd=1.12u as=0.1406p ps=1.12u w=0.74u l=0.13u
X1413 VPWR.t844 sg13cmos5l_inv_16_6.Y sg13cmos5l_inv_16_25.Y VPWR.t177 sg13_lv_pmos ad=0.4368p pd=3.02u as=0.2128p ps=1.5u w=1.12u l=0.13u
X1414 VGND.t1 osc[3] a_2920_4656# VGND.t0 sg13_lv_nmos ad=0.14875p pd=1.16u as=0.187p ps=1.78u w=0.55u l=0.13u
X1415 VPWR.t1414 sg13cmos5l_inv_16_87.A sg13cmos5l_inv_16_93.Y VPWR.t9 sg13_lv_pmos ad=0.4368p pd=3.02u as=0.2128p ps=1.5u w=1.12u l=0.13u
X1416 VGND.t1010 sg13cmos5l_inv_16_87.A sg13cmos5l_inv_16_87.Y VGND.t881 sg13_lv_nmos ad=0.1406p pd=1.12u as=0.1406p ps=1.12u w=0.74u l=0.13u
X1417 VPWR.t2402 sg13cmos5l_inv_16_76.A sg13cmos5l_inv_16_75.A VPWR.t25 sg13_lv_pmos ad=0.4368p pd=3.02u as=0.2128p ps=1.5u w=1.12u l=0.13u
X1418 VGND.t45 sg13cmos5l_inv_16_15.A sg13cmos5l_inv_16_13.Y VGND.t510 sg13_lv_nmos ad=0.1406p pd=1.12u as=0.1406p ps=1.12u w=0.74u l=0.13u
X1419 VGND.t425 sg13cmos5l_inv_16_27.A sg13cmos5l_inv_16_27.Y VGND.t1619 sg13_lv_nmos ad=0.1406p pd=1.12u as=0.1406p ps=1.12u w=0.74u l=0.13u
X1420 sg13cmos5l_inv_16_66.Y sg13cmos5l_inv_16_68.A VGND.t866 VGND.t877 sg13_lv_nmos ad=0.1406p pd=1.12u as=0.1406p ps=1.12u w=0.74u l=0.13u
X1421 VPWR.t2084 sg13cmos5l_inv_16_48.A sg13cmos5l_inv_16_109.Y VPWR.t16 sg13_lv_pmos ad=0.2128p pd=1.5u as=0.2128p ps=1.5u w=1.12u l=0.13u
X1422 VPWR.t548 sg13cmos5l_inv_16_17.A sg13cmos5l_inv_16_17.Y VPWR.t177 sg13_lv_pmos ad=0.2128p pd=1.5u as=0.2128p ps=1.5u w=1.12u l=0.13u
X1423 VGND.t310 sg13cmos5l_inv_2_1.Y sg13cmos5l_inv_8_1.A VGND.t420 sg13_lv_nmos ad=0.1406p pd=1.12u as=0.1406p ps=1.12u w=0.74u l=0.13u
X1424 VGND.t326 sg13cmos5l_inv_16_26.A sg13cmos5l_inv_16_30.A VGND.t1316 sg13_lv_nmos ad=0.1406p pd=1.12u as=0.1406p ps=1.12u w=0.74u l=0.13u
X1425 VGND.t1507 sg13cmos5l_inv_16_94.A sg13cmos5l_inv_16_73.A VGND.t881 sg13_lv_nmos ad=0.1406p pd=1.12u as=0.1406p ps=1.12u w=0.74u l=0.13u
X1426 VPWR.t675 sg13cmos5l_inv_16_41.A sg13cmos5l_inv_16_28.A VPWR.t4 sg13_lv_pmos ad=0.2128p pd=1.5u as=0.2128p ps=1.5u w=1.12u l=0.13u
X1427 sg13cmos5l_inv_16_62.Y sg13cmos5l_inv_16_69.Y VPWR.t1328 VPWR.t9 sg13_lv_pmos ad=0.2128p pd=1.5u as=0.2128p ps=1.5u w=1.12u l=0.13u
X1428 VGND.t1147 VPWR.t2587 VGND.t1147 VGND.t881 sg13_lv_nmos ad=79.8f pd=0.8u as=0 ps=0 w=0.42u l=1u
X1429 sg13cmos5l_inv_16_87.Y sg13cmos5l_inv_16_87.A VPWR.t1426 VPWR.t9 sg13_lv_pmos ad=0.2128p pd=1.5u as=0.2128p ps=1.5u w=1.12u l=0.13u
X1430 VPWR.t1984 sg13cmos5l_inv_16_67.A sg13cmos5l_inv_16_67.Y VPWR.t16 sg13_lv_pmos ad=0.2128p pd=1.5u as=0.2128p ps=1.5u w=1.12u l=0.13u
X1431 VGND.t427 sg13cmos5l_inv_16_101.Y sg13cmos5l_inv_16_55.Y VGND.t380 sg13_lv_nmos ad=0.1406p pd=1.12u as=0.1406p ps=1.12u w=0.74u l=0.13u
X1432 sg13cmos5l_inv_16_102.Y sg13cmos5l_inv_16_37.A VPWR.t452 VPWR.t0 sg13_lv_pmos ad=0.2128p pd=1.5u as=0.2128p ps=1.5u w=1.12u l=0.13u
X1433 VPWR.t929 sg13cmos5l_inv_16_14.A sg13cmos5l_inv_16_14.Y VPWR.t4 sg13_lv_pmos ad=0.4368p pd=3.02u as=0.2128p ps=1.5u w=1.12u l=0.13u
X1434 VPWR.t1625 sg13cmos5l_inv_4_7.Y sg13cmos5l_inv_16_88.A VPWR.t9 sg13_lv_pmos ad=0.3808p pd=2.92u as=0.2184p ps=1.51u w=1.12u l=0.13u
X1435 sg13cmos5l_inv_2_5.Y sg13cmos5l_inv_2_5.A VPWR.t1307 VPWR.t16 sg13_lv_pmos ad=0.2128p pd=1.5u as=0.3864p ps=2.93u w=1.12u l=0.13u
X1436 sg13cmos5l_inv_16_52.Y sg13cmos5l_inv_16_56.Y VPWR.t2050 VPWR.t16 sg13_lv_pmos ad=0.2128p pd=1.5u as=0.2128p ps=1.5u w=1.12u l=0.13u
X1437 sg13cmos5l_inv_8_4.Y sg13cmos5l_inv_4_5.Y VGND.t5 VGND.t1062 sg13_lv_nmos ad=0.1406p pd=1.12u as=0.1406p ps=1.12u w=0.74u l=0.13u
X1438 VPWR.t246 sg13cmos5l_inv_16_6.A sg13cmos5l_inv_16_5.Y VPWR.t177 sg13_lv_pmos ad=0.2128p pd=1.5u as=0.2128p ps=1.5u w=1.12u l=0.13u
X1439 sg13cmos5l_inv_16_25.Y sg13cmos5l_inv_16_6.Y VPWR.t844 VPWR.t177 sg13_lv_pmos ad=0.2128p pd=1.5u as=0.2128p ps=1.5u w=1.12u l=0.13u
X1440 VPWR.t1270 sg13cmos5l_inv_16_0.A sg13cmos5l_inv_16_1.A VPWR.t177 sg13_lv_pmos ad=0.2128p pd=1.5u as=0.2128p ps=1.5u w=1.12u l=0.13u
X1441 sg13cmos5l_inv_16_4.Y sg13cmos5l_inv_8_1.Y VGND.t423 VGND.t1462 sg13_lv_nmos ad=0.1406p pd=1.12u as=0.1406p ps=1.12u w=0.74u l=0.13u
X1442 VGND.t50 sg13cmos5l_inv_16_23.Y sg13cmos5l_inv_16_14.A VGND.t68 sg13_lv_nmos ad=0.1406p pd=1.12u as=0.1406p ps=1.12u w=0.74u l=0.13u
X1443 sg13cmos5l_inv_16_93.Y sg13cmos5l_inv_16_87.A VPWR.t1410 VPWR.t9 sg13_lv_pmos ad=0.2128p pd=1.5u as=0.2128p ps=1.5u w=1.12u l=0.13u
X1444 VGND.t381 sg13cmos5l_inv_16_75.A sg13cmos5l_inv_16_74.Y VGND.t380 sg13_lv_nmos ad=0.1406p pd=1.12u as=0.1406p ps=1.12u w=0.74u l=0.13u
X1445 sg13cmos5l_inv_16_17.A sg13cmos5l_inv_16_1.A VPWR.t1100 VPWR.t177 sg13_lv_pmos ad=0.2128p pd=1.5u as=0.2128p ps=1.5u w=1.12u l=0.13u
X1446 VPWR.t1766 sg13cmos5l_inv_16_52.Y sg13cmos5l_inv_16_53.A VPWR.t16 sg13_lv_pmos ad=0.2128p pd=1.5u as=0.2128p ps=1.5u w=1.12u l=0.13u
X1447 VPWR.t213 VGND.t122 VPWR.t211 VPWR.t0 sg13_lv_pmos ad=0.19p pd=1.38u as=0 ps=0 w=1u l=1u
X1448 VPWR.t27 VGND.t1779 VPWR.t26 VPWR.t25 sg13_lv_pmos ad=0.19p pd=1.38u as=0 ps=0 w=1u l=1u
X1449 sg13cmos5l_inv_16_30.A sg13cmos5l_inv_16_26.A VGND.t326 VGND.t1313 sg13_lv_nmos ad=0.1406p pd=1.12u as=0.2516p ps=2.16u w=0.74u l=0.13u
X1450 VGND.t591 en[0] a_2920_908# VGND.t2195 sg13_lv_nmos ad=0.14875p pd=1.16u as=0.187p ps=1.78u w=0.55u l=0.13u
X1451 VGND.t1334 sg13cmos5l_inv_16_26.A sg13cmos5l_inv_16_26.Y VGND.t1342 sg13_lv_nmos ad=0.1406p pd=1.12u as=0.1406p ps=1.12u w=0.74u l=0.13u
X1452 VGND.t84 sg13cmos5l_inv_16_17.A sg13cmos5l_inv_16_17.Y VGND.t108 sg13_lv_nmos ad=0.1406p pd=1.12u as=0.1406p ps=1.12u w=0.74u l=0.13u
X1453 VPWR.t1068 sg13cmos5l_inv_16_5.Y sg13cmos5l_inv_16_110.Y VPWR.t4 sg13_lv_pmos ad=0.2128p pd=1.5u as=0.2128p ps=1.5u w=1.12u l=0.13u
X1454 VGND.t994 VPWR.t2595 VGND.t994 VGND.t1895 sg13_lv_nmos ad=0.1428p pd=1.52u as=0 ps=0 w=0.42u l=1u
X1455 VPWR.t1424 sg13cmos5l_inv_16_87.A sg13cmos5l_inv_16_87.Y VPWR.t9 sg13_lv_pmos ad=0.2128p pd=1.5u as=0.2128p ps=1.5u w=1.12u l=0.13u
X1456 sg13cmos5l_inv_16_67.Y sg13cmos5l_inv_16_67.A VPWR.t1980 VPWR.t16 sg13_lv_pmos ad=0.2128p pd=1.5u as=0.2128p ps=1.5u w=1.12u l=0.13u
X1457 sg13cmos5l_inv_16_35.Y sg13cmos5l_inv_16_29.A VGND.t259 VGND.t270 sg13_lv_nmos ad=0.1406p pd=1.12u as=0.1406p ps=1.12u w=0.74u l=0.13u
X1458 sg13cmos5l_inv_16_5.Y sg13cmos5l_inv_16_6.A VPWR.t246 VPWR.t177 sg13_lv_pmos ad=0.2128p pd=1.5u as=0.2128p ps=1.5u w=1.12u l=0.13u
X1459 sg13cmos5l_inv_16_68.Y sg13cmos5l_inv_16_68.A VPWR.t1300 VPWR.t16 sg13_lv_pmos ad=0.2128p pd=1.5u as=0.2128p ps=1.5u w=1.12u l=0.13u
X1460 sg13cmos5l_inv_16_19.Y sg13cmos5l_inv_16_17.A VPWR.t529 VPWR.t177 sg13_lv_pmos ad=0.2128p pd=1.5u as=0.2128p ps=1.5u w=1.12u l=0.13u
X1461 sg13cmos5l_inv_16_54.Y sg13cmos5l_inv_16_101.Y VPWR.t2332 VPWR.t25 sg13_lv_pmos ad=0.2128p pd=1.5u as=0.2128p ps=1.5u w=1.12u l=0.13u
X1462 VGND.t723 sg13cmos5l_inv_16_9.A sg13cmos5l_inv_16_10.Y VGND.t724 sg13_lv_nmos ad=0.1406p pd=1.12u as=0.1406p ps=1.12u w=0.74u l=0.13u
X1463 VPWR.t1001 sg13cmos5l_inv_8_2.A sg13cmos5l_inv_16_27.A VPWR.t177 sg13_lv_pmos ad=0.2128p pd=1.5u as=0.2128p ps=1.5u w=1.12u l=0.13u
X1464 sg13cmos5l_inv_16_1.A sg13cmos5l_inv_16_0.A VPWR.t1266 VPWR.t177 sg13_lv_pmos ad=0.2128p pd=1.5u as=0.2128p ps=1.5u w=1.12u l=0.13u
X1465 VGND.t1419 sg13cmos5l_inv_16_6.A sg13cmos5l_inv_16_6.Y VGND.t1421 sg13_lv_nmos ad=0.2516p pd=2.16u as=0.1406p ps=1.12u w=0.74u l=0.13u
X1466 VGND.t1459 sg13cmos5l_inv_8_1.Y sg13cmos5l_inv_16_4.Y VGND.t1458 sg13_lv_nmos ad=0.1406p pd=1.12u as=0.1406p ps=1.12u w=0.74u l=0.13u
X1467 sg13cmos5l_inv_16_14.A sg13cmos5l_inv_16_23.Y VGND.t66 VGND.t65 sg13_lv_nmos ad=0.1406p pd=1.12u as=0.2516p ps=2.16u w=0.74u l=0.13u
X1468 VGND.t922 sg13cmos5l_inv_16_69.Y sg13cmos5l_inv_16_62.Y VGND.t881 sg13_lv_nmos ad=0.1406p pd=1.12u as=0.1406p ps=1.12u w=0.74u l=0.13u
X1469 sg13cmos5l_inv_16_53.A sg13cmos5l_inv_16_52.Y VPWR.t1762 VPWR.t16 sg13_lv_pmos ad=0.2128p pd=1.5u as=0.2128p ps=1.5u w=1.12u l=0.13u
X1470 VPWR.t1904 sg13cmos5l_inv_16_94.A sg13cmos5l_inv_16_73.A VPWR.t9 sg13_lv_pmos ad=0.2128p pd=1.5u as=0.2128p ps=1.5u w=1.12u l=0.13u
X1471 VGND.t291 sg13cmos5l_inv_16_8.Y sg13cmos5l_inv_16_9.A VGND.t569 sg13_lv_nmos ad=0.1406p pd=1.12u as=0.1406p ps=1.12u w=0.74u l=0.13u
X1472 sg13cmos5l_inv_16_17.Y sg13cmos5l_inv_16_17.A VGND.t84 VGND.t83 sg13_lv_nmos ad=0.1406p pd=1.12u as=0.2516p ps=2.16u w=0.74u l=0.13u
X1473 sg13cmos5l_inv_16_53.Y sg13cmos5l_inv_16_53.A VPWR.t2072 VPWR.t16 sg13_lv_pmos ad=0.2128p pd=1.5u as=0.2128p ps=1.5u w=1.12u l=0.13u
X1474 VGND.t1067 sg13cmos5l_inv_16_84.A sg13cmos5l_inv_16_85.Y VGND.t1068 sg13_lv_nmos ad=0.1406p pd=1.12u as=0.1406p ps=1.12u w=0.74u l=0.13u
X1475 VPWR.t857 VGND.t1143 VPWR.t854 VPWR.t16 sg13_lv_pmos ad=0.19p pd=1.38u as=0 ps=0 w=1u l=1u
X1476 VPWR.t520 osc[1] a_2920_2420# VPWR.t4 sg13_lv_pmos ad=0.2114p pd=1.54u as=0.2856p ps=2.36u w=0.84u l=0.13u
X1477 sg13cmos5l_inv_16_69.Y sg13cmos5l_inv_16_52.Y VPWR.t1748 VPWR.t16 sg13_lv_pmos ad=0.2128p pd=1.5u as=0.2128p ps=1.5u w=1.12u l=0.13u
X1478 VGND.t450 sg13cmos5l_inv_16_20.A sg13cmos5l_inv_16_22.Y VGND.t449 sg13_lv_nmos ad=0.1406p pd=1.12u as=0.1406p ps=1.12u w=0.74u l=0.13u
X1479 sg13cmos5l_inv_16_8.Y sg13cmos5l_inv_16_4.Y VGND.t291 VGND.t297 sg13_lv_nmos ad=0.1406p pd=1.12u as=0.1406p ps=1.12u w=0.74u l=0.13u
X1480 sg13cmos5l_inv_16_74.Y sg13cmos5l_inv_16_75.A VPWR.t804 VPWR.t25 sg13_lv_pmos ad=0.2128p pd=1.5u as=0.2128p ps=1.5u w=1.12u l=0.13u
X1481 sg13cmos5l_inv_16_34.Y sg13cmos5l_inv_16_41.A VGND.t217 VGND.t216 sg13_lv_nmos ad=0.1406p pd=1.12u as=0.2516p ps=2.16u w=0.74u l=0.13u
X1482 sg13cmos5l_inv_16_110.Y sg13cmos5l_inv_16_5.Y VPWR.t1064 VPWR.t4 sg13_lv_pmos ad=0.2128p pd=1.5u as=0.2128p ps=1.5u w=1.12u l=0.13u
X1483 VGND.t1010 sg13cmos5l_inv_16_73.Y sg13cmos5l_inv_16_95.Y VGND.t881 sg13_lv_nmos ad=0.1406p pd=1.12u as=0.1406p ps=1.12u w=0.74u l=0.13u
X1484 sg13cmos5l_inv_16_4.Y sg13cmos5l_inv_8_1.Y VPWR.t1849 VPWR.t177 sg13_lv_pmos ad=0.2128p pd=1.5u as=0.2128p ps=1.5u w=1.12u l=0.13u
X1485 sg13cmos5l_inv_16_102.Y sg13cmos5l_inv_16_37.A VPWR.t449 VPWR.t0 sg13_lv_pmos ad=0.2128p pd=1.5u as=0.3808p ps=2.92u w=1.12u l=0.13u
X1486 VPWR.t824 sg13cmos5l_inv_16_75.A sg13cmos5l_inv_16_75.Y VPWR.t25 sg13_lv_pmos ad=0.2128p pd=1.5u as=0.2128p ps=1.5u w=1.12u l=0.13u
X1487 VPWR.t1264 sg13cmos5l_inv_16_0.A sg13cmos5l_inv_16_1.A VPWR.t177 sg13_lv_pmos ad=0.2128p pd=1.5u as=0.2128p ps=1.5u w=1.12u l=0.13u
X1488 sg13cmos5l_inv_16_4.Y sg13cmos5l_inv_8_1.Y VGND.t310 VGND.t1455 sg13_lv_nmos ad=0.1406p pd=1.12u as=0.1406p ps=1.12u w=0.74u l=0.13u
X1489 VPWR.t116 VGND.t1100 VPWR.t114 VPWR.t25 sg13_lv_pmos ad=0.19p pd=1.38u as=0 ps=0 w=1u l=1u
X1490 VPWR.t637 sg13cmos5l_inv_16_44.A sg13cmos5l_inv_16_44.Y VPWR.t4 sg13_lv_pmos ad=0.4368p pd=3.02u as=0.2128p ps=1.5u w=1.12u l=0.13u
X1491 VGND.t1580 sg13cmos5l_inv_16_67.A sg13cmos5l_inv_16_65.Y VGND.t1585 sg13_lv_nmos ad=0.1406p pd=1.12u as=0.1406p ps=1.12u w=0.74u l=0.13u
X1492 sg13cmos5l_inv_16_73.A sg13cmos5l_inv_16_94.A VPWR.t1900 VPWR.t9 sg13_lv_pmos ad=0.2128p pd=1.5u as=0.2128p ps=1.5u w=1.12u l=0.13u
X1493 VPWR.t2070 sg13cmos5l_inv_16_53.A sg13cmos5l_inv_16_53.Y VPWR.t16 sg13_lv_pmos ad=0.2128p pd=1.5u as=0.2128p ps=1.5u w=1.12u l=0.13u
X1494 VPWR.t477 sg13cmos5l_inv_16_37.A sg13cmos5l_inv_16_37.Y VPWR.t4 sg13_lv_pmos ad=0.2128p pd=1.5u as=0.2128p ps=1.5u w=1.12u l=0.13u
X1495 VPWR.t2248 sg13cmos5l_inv_16_96.Y sg13cmos5l_inv_16_11.A VPWR.t25 sg13_lv_pmos ad=0.2128p pd=1.5u as=0.2128p ps=1.5u w=1.12u l=0.13u
X1496 VPWR.t1468 sg13cmos5l_inv_4_5.Y sg13cmos5l_inv_8_4.Y VPWR.t25 sg13_lv_pmos ad=0.2128p pd=1.5u as=0.2128p ps=1.5u w=1.12u l=0.13u
X1497 VPWR.t2387 sg13cmos5l_inv_16_76.A sg13cmos5l_inv_16_77.A VPWR.t16 sg13_lv_pmos ad=0.3808p pd=2.92u as=0.2128p ps=1.5u w=1.12u l=0.13u
X1498 sg13cmos5l_inv_16_46.Y sg13cmos5l_inv_16_46.A VGND.t20 VGND.t1753 sg13_lv_nmos ad=0.1406p pd=1.12u as=0.1406p ps=1.12u w=0.74u l=0.13u
X1499 sg13cmos5l_inv_16_91.Y sg13cmos5l_inv_16_79.A VPWR.t2156 VPWR.t16 sg13_lv_pmos ad=0.2128p pd=1.5u as=0.2128p ps=1.5u w=1.12u l=0.13u
X1500 VPWR.t282 VGND.t308 VPWR.t245 VPWR.t4 sg13_lv_pmos ad=0.19p pd=1.38u as=0 ps=0 w=1u l=1u
X1501 sg13cmos5l_inv_16_95.Y sg13cmos5l_inv_16_73.Y VGND.t1010 VGND.t881 sg13_lv_nmos ad=0.1406p pd=1.12u as=0.1406p ps=1.12u w=0.74u l=0.13u
X1502 VGND.t1792 VPWR.t2544 VGND.t1792 VGND.t380 sg13_lv_nmos ad=0.1428p pd=1.52u as=0 ps=0 w=0.42u l=1u
X1503 VGND.t1245 sg13cmos5l_inv_16_27.Y sg13cmos5l_inv_16_26.A VGND.t1276 sg13_lv_nmos ad=0.2516p pd=2.16u as=0.1406p ps=1.12u w=0.74u l=0.13u
X1504 VGND.t963 sg13cmos5l_inv_16_56.Y sg13cmos5l_inv_16_71.Y VGND.t881 sg13_lv_nmos ad=0.1406p pd=1.12u as=0.1406p ps=1.12u w=0.74u l=0.13u
X1505 VGND.t1970 VPWR.t2554 VGND.t1970 VGND.t380 sg13_lv_nmos ad=0.1428p pd=1.52u as=0 ps=0 w=0.42u l=1u
X1506 sg13cmos5l_inv_16_29.A sg13cmos5l_inv_16_28.A VPWR.t707 VPWR.t177 sg13_lv_pmos ad=0.2128p pd=1.5u as=0.2128p ps=1.5u w=1.12u l=0.13u
X1507 sg13cmos5l_inv_16_15.Y sg13cmos5l_inv_16_15.A VGND.t45 VGND.t513 sg13_lv_nmos ad=0.1406p pd=1.12u as=0.1406p ps=1.12u w=0.74u l=0.13u
X1508 sg13cmos5l_inv_16_36.Y sg13cmos5l_inv_16_36.A VPWR.t582 VPWR.t4 sg13_lv_pmos ad=0.2128p pd=1.5u as=0.2128p ps=1.5u w=1.12u l=0.13u
X1509 VGND.t1143 sg13cmos5l_inv_16_109.Y sg13cmos5l_inv_16_67.A VGND.t881 sg13_lv_nmos ad=0.2516p pd=2.16u as=0.1406p ps=1.12u w=0.74u l=0.13u
X1510 sg13cmos5l_inv_16_40.Y sg13cmos5l_inv_16_26.Y VPWR.t178 VPWR.t177 sg13_lv_pmos ad=0.2128p pd=1.5u as=0.3808p ps=2.92u w=1.12u l=0.13u
X1511 sg13cmos5l_inv_16_65.Y sg13cmos5l_inv_16_67.A VGND.t1580 VGND.t1582 sg13_lv_nmos ad=0.1406p pd=1.12u as=0.1406p ps=1.12u w=0.74u l=0.13u
X1512 sg13cmos5l_inv_16_84.Y sg13cmos5l_inv_16_84.A VGND.t1026 VGND.t881 sg13_lv_nmos ad=0.1406p pd=1.12u as=0.1406p ps=1.12u w=0.74u l=0.13u
X1513 VGND.t1029 VPWR.t2574 VGND.t1029 VGND.t881 sg13_lv_nmos ad=0.1428p pd=1.52u as=0 ps=0 w=0.42u l=1u
X1514 VPWR.t1171 VGND.t1663 VPWR.t1170 VPWR.t25 sg13_lv_pmos ad=0.34p pd=2.68u as=0 ps=0 w=1u l=1u
X1515 VPWR.t844 sg13cmos5l_inv_16_27.A sg13cmos5l_inv_16_27.Y VPWR.t177 sg13_lv_pmos ad=0.2128p pd=1.5u as=0.2128p ps=1.5u w=1.12u l=0.13u
X1516 sg13cmos5l_inv_16_53.A sg13cmos5l_inv_16_52.Y VPWR.t1758 VPWR.t16 sg13_lv_pmos ad=0.2128p pd=1.5u as=0.2128p ps=1.5u w=1.12u l=0.13u
X1517 sg13cmos5l_inv_16_90.Y sg13cmos5l_inv_16_73.Y VPWR.t2190 VPWR.t16 sg13_lv_pmos ad=0.2128p pd=1.5u as=0.3808p ps=2.92u w=1.12u l=0.13u
X1518 sg13cmos5l_inv_16_11.A sg13cmos5l_inv_16_96.Y VPWR.t2244 VPWR.t25 sg13_lv_pmos ad=0.2128p pd=1.5u as=0.2128p ps=1.5u w=1.12u l=0.13u
X1519 sg13cmos5l_inv_16_80.Y sg13cmos5l_inv_16_105.A VGND.t345 VGND.t1114 sg13_lv_nmos ad=0.1406p pd=1.12u as=0.1406p ps=1.12u w=0.74u l=0.13u
X1520 VGND.t723 sg13cmos5l_inv_16_9.A sg13cmos5l_inv_16_9.Y VGND.t728 sg13_lv_nmos ad=0.1406p pd=1.12u as=0.1406p ps=1.12u w=0.74u l=0.13u
X1521 sg13cmos5l_inv_16_77.A sg13cmos5l_inv_16_76.A VPWR.t2383 VPWR.t16 sg13_lv_pmos ad=0.2128p pd=1.5u as=0.2128p ps=1.5u w=1.12u l=0.13u
X1522 sg13cmos5l_inv_16_100.Y sg13cmos5l_inv_16_36.A VGND.t134 VGND.t135 sg13_lv_nmos ad=0.1406p pd=1.12u as=0.1406p ps=1.12u w=0.74u l=0.13u
X1523 VPWR.t1046 sg13cmos5l_inv_16_34.Y sg13cmos5l_inv_16_101.Y VPWR.t0 sg13_lv_pmos ad=0.4368p pd=3.02u as=0.2128p ps=1.5u w=1.12u l=0.13u
X1524 sg13cmos5l_inv_16_102.Y sg13cmos5l_inv_16_37.A VGND.t20 VGND.t21 sg13_lv_nmos ad=0.1406p pd=1.12u as=0.1406p ps=1.12u w=0.74u l=0.13u
X1525 VGND.t226 VPWR.t2507 VGND.t226 VGND.t2048 sg13_lv_nmos ad=0.1428p pd=1.52u as=0 ps=0 w=0.42u l=1u
X1526 sg13cmos5l_inv_16_71.Y sg13cmos5l_inv_16_56.Y VGND.t963 VGND.t881 sg13_lv_nmos ad=0.1406p pd=1.12u as=0.1406p ps=1.12u w=0.74u l=0.13u
X1527 VPWR.t598 sg13cmos5l_inv_16_43.Y sg13cmos5l_inv_16_37.A VPWR.t0 sg13_lv_pmos ad=0.2128p pd=1.5u as=0.2128p ps=1.5u w=1.12u l=0.13u
X1528 sg13cmos5l_inv_16_8.Y sg13cmos5l_inv_16_4.Y VGND.t291 VGND.t293 sg13_lv_nmos ad=0.1406p pd=1.12u as=0.1406p ps=1.12u w=0.74u l=0.13u
X1529 sg13cmos5l_inv_16_67.A sg13cmos5l_inv_16_109.Y VGND.t1143 VGND.t881 sg13_lv_nmos ad=0.1406p pd=1.12u as=0.1406p ps=1.12u w=0.74u l=0.13u
X1530 VPWR.t707 sg13cmos5l_inv_16_28.A sg13cmos5l_inv_16_29.A VPWR.t177 sg13_lv_pmos ad=0.2128p pd=1.5u as=0.2128p ps=1.5u w=1.12u l=0.13u
X1531 VGND.t45 sg13cmos5l_inv_16_15.A sg13cmos5l_inv_16_15.Y VGND.t510 sg13_lv_nmos ad=0.1406p pd=1.12u as=0.1406p ps=1.12u w=0.74u l=0.13u
X1532 sg13cmos5l_inv_16_58.Y sg13cmos5l_inv_16_69.Y VGND.t905 VGND.t912 sg13_lv_nmos ad=0.1406p pd=1.12u as=0.1406p ps=1.12u w=0.74u l=0.13u
X1533 sg13cmos5l_inv_16_46.Y sg13cmos5l_inv_16_46.A VPWR.t2136 VPWR.t25 sg13_lv_pmos ad=0.2128p pd=1.5u as=0.2128p ps=1.5u w=1.12u l=0.13u
X1534 VGND.t963 sg13cmos5l_inv_16_71.Y sg13cmos5l_inv_16_61.A VGND.t881 sg13_lv_nmos ad=0.1406p pd=1.12u as=0.1406p ps=1.12u w=0.74u l=0.13u
X1535 sg13cmos5l_inv_16_75.A sg13cmos5l_inv_16_76.A VPWR.t2394 VPWR.t25 sg13_lv_pmos ad=0.2128p pd=1.5u as=0.2128p ps=1.5u w=1.12u l=0.13u
X1536 VGND.t353 VPWR.t2532 VGND.t353 VGND.t2007 sg13_lv_nmos ad=0.1428p pd=1.52u as=0 ps=0 w=0.42u l=1u
X1537 VPWR.t1623 sg13cmos5l_inv_4_7.Y sg13cmos5l_inv_16_88.A VPWR.t9 sg13_lv_pmos ad=0.2128p pd=1.5u as=0.2128p ps=1.5u w=1.12u l=0.13u
X1538 sg13cmos5l_inv_16_23.Y sg13cmos5l_inv_16_0.A VPWR.t1254 VPWR.t4 sg13_lv_pmos ad=0.2128p pd=1.5u as=0.2128p ps=1.5u w=1.12u l=0.13u
X1539 VGND.t345 sg13cmos5l_inv_16_105.A sg13cmos5l_inv_16_80.Y VGND.t1111 sg13_lv_nmos ad=0.1406p pd=1.12u as=0.1406p ps=1.12u w=0.74u l=0.13u
X1540 VPWR.t117 VGND.t432 VPWR.t384 VPWR.t0 sg13_lv_pmos ad=0.34p pd=2.68u as=0 ps=0 w=1u l=1u
X1541 sg13cmos5l_inv_16_46.Y sg13cmos5l_inv_16_46.A VGND.t20 VGND.t1749 sg13_lv_nmos ad=0.1406p pd=1.12u as=0.1406p ps=1.12u w=0.74u l=0.13u
X1542 VPWR.t141 VGND.t3 VPWR.t140 VPWR.t0 sg13_lv_pmos ad=0.34p pd=2.68u as=0 ps=0 w=1u l=1u
X1543 sg13cmos5l_inv_16_31.Y sg13cmos5l_inv_16_30.A VGND.t1236 VGND.t1283 sg13_lv_nmos ad=0.1406p pd=1.12u as=0.1406p ps=1.12u w=0.74u l=0.13u
X1544 sg13cmos5l_inv_16_69.Y sg13cmos5l_inv_16_52.Y VGND.t921 VGND.t881 sg13_lv_nmos ad=0.1406p pd=1.12u as=0.2516p ps=2.16u w=0.74u l=0.13u
X1545 VGND.t15 sg13cmos5l_inv_16_37.A sg13cmos5l_inv_16_102.Y VGND.t17 sg13_lv_nmos ad=0.1406p pd=1.12u as=0.1406p ps=1.12u w=0.74u l=0.13u
X1546 sg13cmos5l_inv_16_5.Y sg13cmos5l_inv_16_6.A VPWR.t246 VPWR.t177 sg13_lv_pmos ad=0.2128p pd=1.5u as=0.2128p ps=1.5u w=1.12u l=0.13u
X1547 VPWR.t1280 sg13cmos5l_inv_16_68.A sg13cmos5l_inv_16_66.Y VPWR.t9 sg13_lv_pmos ad=0.2128p pd=1.5u as=0.2128p ps=1.5u w=1.12u l=0.13u
X1548 sg13cmos5l_inv_16_37.A sg13cmos5l_inv_16_43.Y VPWR.t594 VPWR.t0 sg13_lv_pmos ad=0.2128p pd=1.5u as=0.2128p ps=1.5u w=1.12u l=0.13u
X1549 VGND.t905 sg13cmos5l_inv_16_69.Y sg13cmos5l_inv_16_58.Y VGND.t909 sg13_lv_nmos ad=0.1406p pd=1.12u as=0.1406p ps=1.12u w=0.74u l=0.13u
X1550 VPWR.t2134 sg13cmos5l_inv_16_46.A sg13cmos5l_inv_16_46.Y VPWR.t25 sg13_lv_pmos ad=0.2128p pd=1.5u as=0.2128p ps=1.5u w=1.12u l=0.13u
X1551 sg13cmos5l_inv_16_36.Y sg13cmos5l_inv_16_36.A VPWR.t578 VPWR.t4 sg13_lv_pmos ad=0.2128p pd=1.5u as=0.2128p ps=1.5u w=1.12u l=0.13u
X1552 sg13cmos5l_inv_16_61.A sg13cmos5l_inv_16_71.Y VGND.t963 VGND.t881 sg13_lv_nmos ad=0.1406p pd=1.12u as=0.1406p ps=1.12u w=0.74u l=0.13u
X1553 sg13cmos5l_inv_16_73.Y sg13cmos5l_inv_16_73.A VPWR.t1881 VPWR.t16 sg13_lv_pmos ad=0.2128p pd=1.5u as=0.2128p ps=1.5u w=1.12u l=0.13u
X1554 VPWR.t215 VGND.t122 VPWR.t216 VPWR.t0 sg13_lv_pmos ad=0.19p pd=1.38u as=0 ps=0 w=1u l=1u
X1555 VPWR.t1252 sg13cmos5l_inv_16_0.A sg13cmos5l_inv_16_23.Y VPWR.t4 sg13_lv_pmos ad=0.2128p pd=1.5u as=0.2128p ps=1.5u w=1.12u l=0.13u
X1556 sg13cmos5l_inv_16_84.Y sg13cmos5l_inv_16_84.A VGND.t1026 VGND.t881 sg13_lv_nmos ad=0.1406p pd=1.12u as=0.1406p ps=1.12u w=0.74u l=0.13u
X1557 VPWR.t31 VGND.t1779 VPWR.t29 VPWR.t25 sg13_lv_pmos ad=0.19p pd=1.38u as=0 ps=0 w=1u l=1u
X1558 VPWR.t1826 sg13cmos5l_inv_16_2.A sg13cmos5l_inv_16_2.Y VPWR.t177 sg13_lv_pmos ad=0.2128p pd=1.5u as=0.2128p ps=1.5u w=1.12u l=0.13u
X1559 sg13cmos5l_inv_16_44.A sg13cmos5l_inv_16_28.A VGND.t259 VGND.t270 sg13_lv_nmos ad=0.1406p pd=1.12u as=0.1406p ps=1.12u w=0.74u l=0.13u
X1560 sg13cmos5l_inv_16_99.A sg13cmos5l_inv_16_34.Y VGND.t593 VGND.t605 sg13_lv_nmos ad=0.1406p pd=1.12u as=0.1406p ps=1.12u w=0.74u l=0.13u
X1561 sg13cmos5l_inv_16_59.Y sg13cmos5l_inv_16_61.A VGND.t1166 VGND.t1174 sg13_lv_nmos ad=0.1406p pd=1.12u as=0.1406p ps=1.12u w=0.74u l=0.13u
X1562 VGND.t45 sg13cmos5l_inv_16_14.A sg13cmos5l_inv_16_14.Y VGND.t486 sg13_lv_nmos ad=0.1406p pd=1.12u as=0.1406p ps=1.12u w=0.74u l=0.13u
X1563 VPWR.t1532 sg13cmos5l_inv_16_105.A sg13cmos5l_inv_16_105.Y VPWR.t0 sg13_lv_pmos ad=0.2128p pd=1.5u as=0.2128p ps=1.5u w=1.12u l=0.13u
X1564 VGND.t723 sg13cmos5l_inv_16_9.A sg13cmos5l_inv_16_9.Y VGND.t724 sg13_lv_nmos ad=0.1406p pd=1.12u as=0.1406p ps=1.12u w=0.74u l=0.13u
X1565 VPWR.t1496 sg13cmos5l_inv_16_84.A sg13cmos5l_inv_16_84.Y VPWR.t9 sg13_lv_pmos ad=0.2128p pd=1.5u as=0.2128p ps=1.5u w=1.12u l=0.13u
X1566 sg13cmos5l_inv_16_102.Y sg13cmos5l_inv_16_37.A VGND.t5 VGND.t13 sg13_lv_nmos ad=0.1406p pd=1.12u as=0.1406p ps=1.12u w=0.74u l=0.13u
X1567 VPWR.t523 sg13cmos5l_inv_16_17.A sg13cmos5l_inv_16_19.Y VPWR.t177 sg13_lv_pmos ad=0.2128p pd=1.5u as=0.2128p ps=1.5u w=1.12u l=0.13u
X1568 VGND.t1067 VPWR.t2596 VGND.t1067 VGND.t1894 sg13_lv_nmos ad=0.1428p pd=1.52u as=0 ps=0 w=0.42u l=1u
X1569 VPWR.t1518 sg13cmos5l_inv_16_105.A sg13cmos5l_inv_16_80.Y VPWR.t25 sg13_lv_pmos ad=0.4368p pd=3.02u as=0.2128p ps=1.5u w=1.12u l=0.13u
X1570 VPWR.t1240 sg13cmos5l_inv_8_3.Y sg13cmos5l_inv_16_41.A VPWR.t4 sg13_lv_pmos ad=0.4368p pd=3.02u as=0.2128p ps=1.5u w=1.12u l=0.13u
X1571 VGND.t1779 VPWR.t2547 VGND.t1779 VGND.t380 sg13_lv_nmos ad=0.1428p pd=1.52u as=0 ps=0 w=0.42u l=1u
X1572 VPWR.t576 sg13cmos5l_inv_16_36.A sg13cmos5l_inv_16_36.Y VPWR.t4 sg13_lv_pmos ad=0.2128p pd=1.5u as=0.2128p ps=1.5u w=1.12u l=0.13u
X1573 sg13cmos5l_inv_16_73.A sg13cmos5l_inv_16_94.A VPWR.t1896 VPWR.t9 sg13_lv_pmos ad=0.2128p pd=1.5u as=0.2128p ps=1.5u w=1.12u l=0.13u
X1574 sg13cmos5l_inv_16_35.Y sg13cmos5l_inv_16_29.A VPWR.t1112 VPWR.t0 sg13_lv_pmos ad=0.2128p pd=1.5u as=0.2128p ps=1.5u w=1.12u l=0.13u
X1575 VPWR.t473 sg13cmos5l_inv_16_37.A sg13cmos5l_inv_16_37.Y VPWR.t4 sg13_lv_pmos ad=0.2128p pd=1.5u as=0.2128p ps=1.5u w=1.12u l=0.13u
X1576 VPWR.t767 sg13cmos5l_inv_16_26.A sg13cmos5l_inv_16_26.Y VPWR.t177 sg13_lv_pmos ad=0.3808p pd=2.92u as=0.2128p ps=1.5u w=1.12u l=0.13u
X1577 VPWR.t1464 sg13cmos5l_inv_4_5.Y sg13cmos5l_inv_8_4.Y VPWR.t25 sg13_lv_pmos ad=0.2128p pd=1.5u as=0.2128p ps=1.5u w=1.12u l=0.13u
X1578 sg13cmos5l_inv_16_2.Y sg13cmos5l_inv_16_2.A VPWR.t1822 VPWR.t177 sg13_lv_pmos ad=0.2128p pd=1.5u as=0.2128p ps=1.5u w=1.12u l=0.13u
X1579 sg13cmos5l_inv_16_61.Y sg13cmos5l_inv_16_61.A VPWR.t1567 VPWR.t9 sg13_lv_pmos ad=0.2128p pd=1.5u as=0.3808p ps=2.92u w=1.12u l=0.13u
X1580 VPWR.t1742 sg13cmos5l_inv_16_52.Y sg13cmos5l_inv_16_69.Y VPWR.t16 sg13_lv_pmos ad=0.2128p pd=1.5u as=0.2128p ps=1.5u w=1.12u l=0.13u
X1581 VPWR.t2189 sg13cmos5l_inv_16_73.Y sg13cmos5l_inv_16_95.Y VPWR.t16 sg13_lv_pmos ad=0.2128p pd=1.5u as=0.2128p ps=1.5u w=1.12u l=0.13u
X1582 VGND.t1166 sg13cmos5l_inv_16_61.A sg13cmos5l_inv_16_59.Y VGND.t1171 sg13_lv_nmos ad=0.1406p pd=1.12u as=0.1406p ps=1.12u w=0.74u l=0.13u
X1583 VPWR.t1550 sg13cmos5l_inv_16_109.Y sg13cmos5l_inv_16_67.A VPWR.t9 sg13_lv_pmos ad=0.2128p pd=1.5u as=0.2128p ps=1.5u w=1.12u l=0.13u
X1584 VPWR.t190 VGND.t1718 VPWR.t189 VPWR.t16 sg13_lv_pmos ad=0.34p pd=2.68u as=0 ps=0 w=1u l=1u
X1585 sg13cmos5l_inv_16_105.Y sg13cmos5l_inv_16_105.A VPWR.t1528 VPWR.t0 sg13_lv_pmos ad=0.2128p pd=1.5u as=0.2128p ps=1.5u w=1.12u l=0.13u
X1586 sg13cmos5l_inv_16_61.A sg13cmos5l_inv_16_71.Y VPWR.t1377 VPWR.t9 sg13_lv_pmos ad=0.2128p pd=1.5u as=0.2128p ps=1.5u w=1.12u l=0.13u
X1587 VGND.t1553 sg13cmos5l_inv_16_111.A sg13cmos5l_inv_16_98.Y VGND.t1552 sg13_lv_nmos ad=0.1406p pd=1.12u as=0.1406p ps=1.12u w=0.74u l=0.13u
X1588 VPWR.t699 sg13cmos5l_inv_16_28.A sg13cmos5l_inv_16_44.A VPWR.t4 sg13_lv_pmos ad=0.2128p pd=1.5u as=0.2128p ps=1.5u w=1.12u l=0.13u
X1589 sg13cmos5l_inv_16_62.Y sg13cmos5l_inv_16_69.Y VGND.t922 VGND.t881 sg13_lv_nmos ad=0.1406p pd=1.12u as=0.1406p ps=1.12u w=0.74u l=0.13u
X1590 sg13cmos5l_inv_16_80.Y sg13cmos5l_inv_16_105.A VPWR.t1514 VPWR.t25 sg13_lv_pmos ad=0.2128p pd=1.5u as=0.2128p ps=1.5u w=1.12u l=0.13u
X1591 VPWR.t1276 sg13cmos5l_inv_16_68.A sg13cmos5l_inv_16_66.Y VPWR.t9 sg13_lv_pmos ad=0.2128p pd=1.5u as=0.2128p ps=1.5u w=1.12u l=0.13u
X1592 sg13cmos5l_inv_16_40.Y sg13cmos5l_inv_16_26.Y VGND.t326 VGND.t336 sg13_lv_nmos ad=0.1406p pd=1.12u as=0.1406p ps=1.12u w=0.74u l=0.13u
X1593 VPWR.t500 sg13cmos5l_inv_16_23.Y sg13cmos5l_inv_16_15.A VPWR.t0 sg13_lv_pmos ad=0.2128p pd=1.5u as=0.2128p ps=1.5u w=1.12u l=0.13u
X1594 sg13cmos5l_inv_16_79.Y sg13cmos5l_inv_16_79.A VGND.t1779 VGND.t380 sg13_lv_nmos ad=0.1406p pd=1.12u as=0.1406p ps=1.12u w=0.74u l=0.13u
X1595 VPWR.t2130 sg13cmos5l_inv_16_46.A sg13cmos5l_inv_16_46.Y VPWR.t25 sg13_lv_pmos ad=0.2128p pd=1.5u as=0.2128p ps=1.5u w=1.12u l=0.13u
X1596 VPWR.t404 VGND.t226 VPWR.t403 VPWR.t0 sg13_lv_pmos ad=0.34p pd=2.68u as=0 ps=0 w=1u l=1u
X1597 sg13cmos5l_inv_16_84.A sg13cmos5l_inv_16_81.Y VGND.t1029 VGND.t881 sg13_lv_nmos ad=0.1406p pd=1.12u as=0.1406p ps=1.12u w=0.74u l=0.13u
X1598 VGND.t1143 sg13cmos5l_inv_16_67.A sg13cmos5l_inv_16_67.Y VGND.t881 sg13_lv_nmos ad=0.1406p pd=1.12u as=0.1406p ps=1.12u w=0.74u l=0.13u
X1599 sg13cmos5l_inv_16_90.Y sg13cmos5l_inv_16_73.Y VGND.t1029 VGND.t881 sg13_lv_nmos ad=0.1406p pd=1.12u as=0.1406p ps=1.12u w=0.74u l=0.13u
X1600 sg13cmos5l_inv_16_95.Y sg13cmos5l_inv_16_73.Y VPWR.t2213 VPWR.t16 sg13_lv_pmos ad=0.2128p pd=1.5u as=0.2128p ps=1.5u w=1.12u l=0.13u
X1601 VGND.t308 sg13cmos5l_inv_16_6.A sg13cmos5l_inv_16_5.Y VGND.t1402 sg13_lv_nmos ad=0.2516p pd=2.16u as=0.1406p ps=1.12u w=0.74u l=0.13u
X1602 sg13cmos5l_inv_16_59.Y sg13cmos5l_inv_16_61.A VGND.t1166 VGND.t1168 sg13_lv_nmos ad=0.1406p pd=1.12u as=0.1406p ps=1.12u w=0.74u l=0.13u
X1603 VPWR.t20 VGND.t882 VPWR.t19 VPWR.t16 sg13_lv_pmos ad=0.34p pd=2.68u as=0 ps=0 w=1u l=1u
X1604 sg13cmos5l_inv_16_81.Y sg13cmos5l_inv_16_96.Y VPWR.t2227 VPWR.t16 sg13_lv_pmos ad=0.2128p pd=1.5u as=0.2128p ps=1.5u w=1.12u l=0.13u
X1605 VPWR.t155 VGND.t5 VPWR.t154 VPWR.t25 sg13_lv_pmos ad=0.19p pd=1.38u as=0 ps=0 w=1u l=1u
X1606 VPWR.t1042 sg13cmos5l_inv_16_34.Y sg13cmos5l_inv_16_101.Y VPWR.t0 sg13_lv_pmos ad=0.2128p pd=1.5u as=0.2128p ps=1.5u w=1.12u l=0.13u
X1607 VPWR.t1375 sg13cmos5l_inv_16_71.Y sg13cmos5l_inv_16_61.A VPWR.t9 sg13_lv_pmos ad=0.2128p pd=1.5u as=0.2128p ps=1.5u w=1.12u l=0.13u
X1608 VGND.t432 sg13cmos5l_inv_2_6.Y sg13cmos5l_inv_4_4.Y VGND.t537 sg13_lv_nmos ad=0.1406p pd=1.12u as=0.1406p ps=1.12u w=0.74u l=0.13u
X1609 sg13cmos5l_inv_16_98.Y sg13cmos5l_inv_16_111.A VGND.t1541 VGND.t1549 sg13_lv_nmos ad=0.1406p pd=1.12u as=0.1406p ps=1.12u w=0.74u l=0.13u
X1610 VGND.t922 sg13cmos5l_inv_16_69.Y sg13cmos5l_inv_16_62.Y VGND.t881 sg13_lv_nmos ad=0.1406p pd=1.12u as=0.1406p ps=1.12u w=0.74u l=0.13u
X1611 VPWR.t1492 sg13cmos5l_inv_16_84.A sg13cmos5l_inv_16_84.Y VPWR.t9 sg13_lv_pmos ad=0.2128p pd=1.5u as=0.2128p ps=1.5u w=1.12u l=0.13u
X1612 sg13cmos5l_inv_16_44.A sg13cmos5l_inv_16_28.A VPWR.t695 VPWR.t4 sg13_lv_pmos ad=0.2128p pd=1.5u as=0.2128p ps=1.5u w=1.12u l=0.13u
X1613 VPWR.t1028 sg13cmos5l_inv_16_34.Y sg13cmos5l_inv_16_99.A VPWR.t25 sg13_lv_pmos ad=0.2128p pd=1.5u as=0.2128p ps=1.5u w=1.12u l=0.13u
X1614 VGND.t472 sg13cmos5l_inv_16_77.A sg13cmos5l_inv_16_77.Y VGND.t2173 sg13_lv_nmos ad=0.1406p pd=1.12u as=0.1406p ps=1.12u w=0.74u l=0.13u
X1615 VGND.t827 sg13cmos5l_inv_8_0.Y sg13cmos5l_inv_16_0.A VGND.t2316 sg13_lv_nmos ad=0.1406p pd=1.12u as=0.1406p ps=1.12u w=0.74u l=0.13u
X1616 VGND.t1779 sg13cmos5l_inv_16_79.A sg13cmos5l_inv_16_79.Y VGND.t380 sg13_lv_nmos ad=0.1406p pd=1.12u as=0.1406p ps=1.12u w=0.74u l=0.13u
X1617 VGND.t1029 sg13cmos5l_inv_16_81.Y sg13cmos5l_inv_16_84.A VGND.t881 sg13_lv_nmos ad=0.1406p pd=1.12u as=0.1406p ps=1.12u w=0.74u l=0.13u
X1618 VGND.t1029 sg13cmos5l_inv_16_73.Y sg13cmos5l_inv_16_90.Y VGND.t881 sg13_lv_nmos ad=0.1406p pd=1.12u as=0.1406p ps=1.12u w=0.74u l=0.13u
X1619 sg13cmos5l_inv_16_71.Y sg13cmos5l_inv_16_56.Y VPWR.t2036 VPWR.t16 sg13_lv_pmos ad=0.2128p pd=1.5u as=0.2128p ps=1.5u w=1.12u l=0.13u
X1620 sg13cmos5l_inv_16_20.A sg13cmos5l_inv_16_8.Y VPWR.t976 VPWR.t0 sg13_lv_pmos ad=0.2128p pd=1.5u as=0.2128p ps=1.5u w=1.12u l=0.13u
X1621 VPWR.t933 sg13cmos5l_inv_16_15.A sg13cmos5l_inv_16_13.Y VPWR.t0 sg13_lv_pmos ad=0.2128p pd=1.5u as=0.2128p ps=1.5u w=1.12u l=0.13u
X1622 VPWR.t2225 sg13cmos5l_inv_16_96.Y sg13cmos5l_inv_16_81.Y VPWR.t16 sg13_lv_pmos ad=0.2128p pd=1.5u as=0.2128p ps=1.5u w=1.12u l=0.13u
X1623 sg13cmos5l_inv_16_37.A sg13cmos5l_inv_16_43.Y VPWR.t590 VPWR.t0 sg13_lv_pmos ad=0.2128p pd=1.5u as=0.2128p ps=1.5u w=1.12u l=0.13u
X1624 VGND.t1310 sg13cmos5l_inv_16_30.A sg13cmos5l_inv_16_30.Y VGND.t1309 sg13_lv_nmos ad=0.2516p pd=2.16u as=0.1406p ps=1.12u w=0.74u l=0.13u
X1625 VGND.t1100 VPWR.t2533 VGND.t1100 VGND.t2006 sg13_lv_nmos ad=79.8f pd=0.8u as=0 ps=0 w=0.42u l=1u
X1626 VPWR.t1248 sg13cmos5l_inv_16_0.A sg13cmos5l_inv_16_23.Y VPWR.t4 sg13_lv_pmos ad=0.2128p pd=1.5u as=0.2128p ps=1.5u w=1.12u l=0.13u
X1627 sg13cmos5l_inv_16_73.Y sg13cmos5l_inv_16_73.A VPWR.t1877 VPWR.t16 sg13_lv_pmos ad=0.2128p pd=1.5u as=0.2128p ps=1.5u w=1.12u l=0.13u
X1628 VPWR.t169 VGND.t20 VPWR.t168 VPWR.t25 sg13_lv_pmos ad=0.34p pd=2.68u as=0 ps=0 w=1u l=1u
X1629 sg13cmos5l_inv_16_30.Y sg13cmos5l_inv_16_30.A VGND.t343 VGND.t1304 sg13_lv_nmos ad=0.1406p pd=1.12u as=0.1406p ps=1.12u w=0.74u l=0.13u
X1630 VGND.t773 sg13cmos5l_inv_16_99.A sg13cmos5l_inv_16_99.Y VGND.t781 sg13_lv_nmos ad=0.1406p pd=1.12u as=0.1406p ps=1.12u w=0.74u l=0.13u
X1631 sg13cmos5l_inv_16_15.Y sg13cmos5l_inv_16_15.A VPWR.t947 VPWR.t4 sg13_lv_pmos ad=0.2128p pd=1.5u as=0.2128p ps=1.5u w=1.12u l=0.13u
X1632 sg13cmos5l_inv_16_90.Y sg13cmos5l_inv_16_73.Y VGND.t1029 VGND.t881 sg13_lv_nmos ad=0.1406p pd=1.12u as=0.1406p ps=1.12u w=0.74u l=0.13u
X1633 VPWR.t1342 sg13cmos5l_inv_16_69.Y sg13cmos5l_inv_16_62.Y VPWR.t9 sg13_lv_pmos ad=0.4368p pd=3.02u as=0.2128p ps=1.5u w=1.12u l=0.13u
X1634 VPWR.t974 sg13cmos5l_inv_16_8.Y sg13cmos5l_inv_16_20.A VPWR.t0 sg13_lv_pmos ad=0.2128p pd=1.5u as=0.2128p ps=1.5u w=1.12u l=0.13u
X1635 sg13cmos5l_inv_16_13.Y sg13cmos5l_inv_16_15.A VPWR.t930 VPWR.t0 sg13_lv_pmos ad=0.2128p pd=1.5u as=0.3808p ps=2.92u w=1.12u l=0.13u
X1636 VGND.t96 sg13cmos5l_inv_16_17.A sg13cmos5l_inv_16_19.Y VGND.t98 sg13_lv_nmos ad=0.1406p pd=1.12u as=0.1406p ps=1.12u w=0.74u l=0.13u
X1637 VPWR.t1371 sg13cmos5l_inv_16_71.Y sg13cmos5l_inv_16_61.A VPWR.t9 sg13_lv_pmos ad=0.2128p pd=1.5u as=0.2128p ps=1.5u w=1.12u l=0.13u
X1638 VPWR.t1442 sg13cmos5l_inv_16_81.Y sg13cmos5l_inv_16_84.A VPWR.t9 sg13_lv_pmos ad=0.2128p pd=1.5u as=0.2128p ps=1.5u w=1.12u l=0.13u
X1639 VGND.t375 sg13cmos5l_inv_16_20.A sg13cmos5l_inv_16_20.Y VGND.t457 sg13_lv_nmos ad=0.1406p pd=1.12u as=0.1406p ps=1.12u w=0.74u l=0.13u
X1640 VPWR.t1875 sg13cmos5l_inv_16_73.A sg13cmos5l_inv_16_73.Y VPWR.t16 sg13_lv_pmos ad=0.2128p pd=1.5u as=0.2128p ps=1.5u w=1.12u l=0.13u
X1641 sg13cmos5l_inv_16_37.A sg13cmos5l_inv_16_43.Y VGND.t146 VGND.t175 sg13_lv_nmos ad=0.1406p pd=1.12u as=0.1406p ps=1.12u w=0.74u l=0.13u
X1642 VGND.t1539 a_28556_834# sg13cmos5l_buf_1_0.X VGND.t2178 sg13_lv_nmos ad=0.14875p pd=1.16u as=0.2886p ps=2.26u w=0.74u l=0.13u
X1643 a_28556_834# en[7] VGND.t1539 VGND.t1538 sg13_lv_nmos ad=0.187p pd=1.78u as=0.14875p ps=1.16u w=0.55u l=0.13u
X1644 VPWR.t1448 sg13cmos5l_inv_16_81.Y sg13cmos5l_inv_16_79.A VPWR.t16 sg13_lv_pmos ad=0.2128p pd=1.5u as=0.2128p ps=1.5u w=1.12u l=0.13u
X1645 VGND.t5 sg13cmos5l_inv_16_47.A sg13cmos5l_inv_16_47.Y VGND.t2217 sg13_lv_nmos ad=0.1406p pd=1.12u as=0.1406p ps=1.12u w=0.74u l=0.13u
X1646 sg13cmos5l_inv_4_4.Y sg13cmos5l_inv_2_6.Y VPWR.t965 VPWR.t25 sg13_lv_pmos ad=0.2128p pd=1.5u as=0.2128p ps=1.5u w=1.12u l=0.13u
X1647 sg13cmos5l_inv_16_99.Y sg13cmos5l_inv_16_99.A VGND.t773 VGND.t778 sg13_lv_nmos ad=0.1406p pd=1.12u as=0.1406p ps=1.12u w=0.74u l=0.13u
X1648 sg13cmos5l_inv_16_2.Y sg13cmos5l_inv_16_2.A VGND.t655 VGND.t1446 sg13_lv_nmos ad=0.1406p pd=1.12u as=0.1406p ps=1.12u w=0.74u l=0.13u
X1649 VGND.t922 sg13cmos5l_inv_16_52.Y sg13cmos5l_inv_16_69.Y VGND.t881 sg13_lv_nmos ad=0.1406p pd=1.12u as=0.1406p ps=1.12u w=0.74u l=0.13u
X1650 sg13cmos5l_inv_16_50.Y sg13cmos5l_inv_16_46.Y VPWR.t2279 VPWR.t25 sg13_lv_pmos ad=0.2128p pd=1.5u as=0.2128p ps=1.5u w=1.12u l=0.13u
X1651 sg13cmos5l_inv_16_48.A sg13cmos5l_inv_8_7.Y VGND.t756 VGND.t380 sg13_lv_nmos ad=0.1406p pd=1.12u as=0.1406p ps=1.12u w=0.74u l=0.13u
X1652 VPWR.t616 sg13cmos5l_inv_16_43.Y sg13cmos5l_inv_16_36.A VPWR.t0 sg13_lv_pmos ad=0.2128p pd=1.5u as=0.2128p ps=1.5u w=1.12u l=0.13u
X1653 VGND.t882 VPWR.t2590 VGND.t882 VGND.t881 sg13_lv_nmos ad=79.8f pd=0.8u as=0 ps=0 w=0.42u l=1u
X1654 VPWR.t990 sg13cmos5l_inv_16_8.Y sg13cmos5l_inv_16_9.A VPWR.t0 sg13_lv_pmos ad=0.2128p pd=1.5u as=0.2128p ps=1.5u w=1.12u l=0.13u
X1655 sg13cmos5l_inv_16_76.A sg13cmos5l_inv_16_94.A VGND.t1507 VGND.t881 sg13_lv_nmos ad=0.1406p pd=1.12u as=0.1406p ps=1.12u w=0.74u l=0.13u
X1656 VPWR.t1224 sg13cmos5l_buf_1_1.X a_23648_4915# VPWR.t0 sg13_lv_pmos ad=0.2856p pd=2.36u as=0.1596p ps=1.22u w=0.84u l=0.13u
X1657 sg13cmos5l_inv_16_4.Y sg13cmos5l_inv_8_1.Y VPWR.t1843 VPWR.t177 sg13_lv_pmos ad=0.2128p pd=1.5u as=0.2128p ps=1.5u w=1.12u l=0.13u
X1658 VPWR.t641 VGND.t1083 VPWR.t639 VPWR.t9 sg13_lv_pmos ad=0.19p pd=1.38u as=0 ps=0 w=1u l=1u
X1659 VGND.t1553 VPWR.t2598 VGND.t1580 VGND.t1891 sg13_lv_nmos ad=0.1428p pd=1.52u as=0 ps=0 w=0.42u l=1u
X1660 VGND.t381 sg13cmos5l_inv_16_73.A sg13cmos5l_inv_16_73.Y VGND.t380 sg13_lv_nmos ad=0.1406p pd=1.12u as=0.1406p ps=1.12u w=0.74u l=0.13u
X1661 sg13cmos5l_inv_16_84.A sg13cmos5l_inv_16_81.Y VPWR.t1438 VPWR.t9 sg13_lv_pmos ad=0.2128p pd=1.5u as=0.2128p ps=1.5u w=1.12u l=0.13u
X1662 VGND.t1944 sg13cmos5l_inv_8_4.Y sg13cmos5l_inv_16_56.Y VGND.t380 sg13_lv_nmos ad=0.1406p pd=1.12u as=0.1406p ps=1.12u w=0.74u l=0.13u
X1663 VGND.t144 VPWR.t2523 VGND.t144 VGND.t2022 sg13_lv_nmos ad=0.1428p pd=1.52u as=0 ps=0 w=0.42u l=1u
X1664 VPWR.t319 VGND.t353 VPWR.t318 VPWR.t0 sg13_lv_pmos ad=0.34p pd=2.68u as=0 ps=0 w=1u l=1u
X1665 VPWR.t874 sg13cmos5l_inv_16_20.A sg13cmos5l_inv_16_22.Y VPWR.t0 sg13_lv_pmos ad=0.2128p pd=1.5u as=0.2128p ps=1.5u w=1.12u l=0.13u
X1666 VPWR.t215 VGND.t122 VPWR.t214 VPWR.t0 sg13_lv_pmos ad=0.34p pd=2.68u as=0 ps=0 w=1u l=1u
X1667 VPWR.t1106 sg13cmos5l_inv_16_29.A sg13cmos5l_inv_16_35.Y VPWR.t0 sg13_lv_pmos ad=0.2128p pd=1.5u as=0.2128p ps=1.5u w=1.12u l=0.13u
X1668 VPWR.t496 sg13cmos5l_inv_16_23.Y sg13cmos5l_inv_16_15.A VPWR.t0 sg13_lv_pmos ad=0.2128p pd=1.5u as=0.2128p ps=1.5u w=1.12u l=0.13u
X1669 sg13cmos5l_inv_16_20.Y sg13cmos5l_inv_16_20.A VGND.t375 VGND.t454 sg13_lv_nmos ad=0.1406p pd=1.12u as=0.1406p ps=1.12u w=0.74u l=0.13u
X1670 sg13cmos5l_inv_16_17.A sg13cmos5l_inv_16_1.A VGND.t675 VGND.t676 sg13_lv_nmos ad=0.1406p pd=1.12u as=0.1406p ps=1.12u w=0.74u l=0.13u
X1671 sg13cmos5l_inv_16_95.Y sg13cmos5l_inv_16_73.Y VPWR.t2209 VPWR.t16 sg13_lv_pmos ad=0.2128p pd=1.5u as=0.2128p ps=1.5u w=1.12u l=0.13u
X1672 sg13cmos5l_inv_16_47.Y sg13cmos5l_inv_16_47.A VGND.t5 VGND.t2198 sg13_lv_nmos ad=0.1406p pd=1.12u as=0.2516p ps=2.16u w=0.74u l=0.13u
X1673 sg13cmos5l_inv_16_27.Y sg13cmos5l_inv_16_27.A VGND.t425 VGND.t1620 sg13_lv_nmos ad=0.1406p pd=1.12u as=0.1406p ps=1.12u w=0.74u l=0.13u
X1674 VGND.t756 sg13cmos5l_inv_8_7.Y sg13cmos5l_inv_16_48.A VGND.t380 sg13_lv_nmos ad=0.1406p pd=1.12u as=0.1406p ps=1.12u w=0.74u l=0.13u
X1675 VGND.t226 sg13cmos5l_inv_16_41.A sg13cmos5l_inv_16_34.Y VGND.t232 sg13_lv_nmos ad=0.1406p pd=1.12u as=0.1406p ps=1.12u w=0.74u l=0.13u
X1676 VGND.t1715 sg13cmos5l_inv_16_46.A sg13cmos5l_inv_16_47.A VGND.t380 sg13_lv_nmos ad=0.1406p pd=1.12u as=0.1406p ps=1.12u w=0.74u l=0.13u
X1677 sg13cmos5l_inv_16_9.A sg13cmos5l_inv_16_8.Y VPWR.t986 VPWR.t0 sg13_lv_pmos ad=0.2128p pd=1.5u as=0.2128p ps=1.5u w=1.12u l=0.13u
X1678 VPWR.t124 VGND.t1954 VPWR.t123 VPWR.t16 sg13_lv_pmos ad=0.34p pd=2.68u as=0 ps=0 w=1u l=1u
X1679 VGND.t2132 VPWR.t272 VGND.t534 VGND.t2133 sg13_lv_nmos ad=79.8f pd=0.8u as=0 ps=0 w=0.42u l=1u
X1680 VPWR.t1841 sg13cmos5l_inv_8_1.Y sg13cmos5l_inv_16_4.Y VPWR.t177 sg13_lv_pmos ad=0.2128p pd=1.5u as=0.2128p ps=1.5u w=1.12u l=0.13u
X1681 VPWR.t74 VGND.t1944 VPWR.t72 VPWR.t16 sg13_lv_pmos ad=0.19p pd=1.38u as=0 ps=0 w=1u l=1u
X1682 VGND.t1718 sg13cmos5l_inv_16_48.A sg13cmos5l_inv_16_46.A VGND.t380 sg13_lv_nmos ad=0.1406p pd=1.12u as=0.1406p ps=1.12u w=0.74u l=0.13u
X1683 VGND.t953 sg13cmos5l_inv_4_6.Y sg13cmos5l_inv_16_96.A VGND.t380 sg13_lv_nmos ad=0.1406p pd=1.12u as=0.1406p ps=1.12u w=0.74u l=0.13u
X1684 sg13cmos5l_inv_16_44.A sg13cmos5l_inv_16_28.A VPWR.t691 VPWR.t4 sg13_lv_pmos ad=0.2128p pd=1.5u as=0.2128p ps=1.5u w=1.12u l=0.13u
X1685 VPWR.t2094 sg13cmos5l_inv_16_48.A sg13cmos5l_inv_16_109.Y VPWR.t16 sg13_lv_pmos ad=0.3808p pd=2.92u as=0.2128p ps=1.5u w=1.12u l=0.13u
X1686 sg13cmos5l_inv_16_22.Y sg13cmos5l_inv_16_20.A VPWR.t870 VPWR.t0 sg13_lv_pmos ad=0.2128p pd=1.5u as=0.2128p ps=1.5u w=1.12u l=0.13u
X1687 VGND.t472 sg13cmos5l_inv_16_77.A sg13cmos5l_inv_16_77.Y VGND.t2169 sg13_lv_nmos ad=0.1406p pd=1.12u as=0.1406p ps=1.12u w=0.74u l=0.13u
X1688 VPWR.t369 VGND.t217 VPWR.t3 VPWR.t0 sg13_lv_pmos ad=0.19p pd=1.38u as=0 ps=0 w=1u l=1u
X1689 sg13cmos5l_inv_16_15.A sg13cmos5l_inv_16_23.Y VPWR.t492 VPWR.t0 sg13_lv_pmos ad=0.2128p pd=1.5u as=0.2128p ps=1.5u w=1.12u l=0.13u
X1690 VGND.t111 sg13cmos5l_inv_16_17.A sg13cmos5l_inv_16_17.Y VGND.t115 sg13_lv_nmos ad=0.1406p pd=1.12u as=0.1406p ps=1.12u w=0.74u l=0.13u
X1691 VPWR.t685 sg13cmos5l_inv_16_41.A sg13cmos5l_inv_16_28.A VPWR.t4 sg13_lv_pmos ad=0.4368p pd=3.02u as=0.2128p ps=1.5u w=1.12u l=0.13u
X1692 sg13cmos5l_inv_16_26.A sg13cmos5l_inv_16_27.Y VPWR.t844 VPWR.t177 sg13_lv_pmos ad=0.2128p pd=1.5u as=0.2128p ps=1.5u w=1.12u l=0.13u
X1693 VGND.t963 VPWR.t2580 VGND.t963 VGND.t881 sg13_lv_nmos ad=0.1428p pd=1.52u as=0 ps=0 w=0.42u l=1u
X1694 sg13cmos5l_inv_16_71.Y sg13cmos5l_inv_16_56.Y VPWR.t2032 VPWR.t16 sg13_lv_pmos ad=0.2128p pd=1.5u as=0.2128p ps=1.5u w=1.12u l=0.13u
X1695 sg13cmos5l_inv_16_10.Y sg13cmos5l_inv_16_9.A VGND.t738 VGND.t739 sg13_lv_nmos ad=0.1406p pd=1.12u as=0.1406p ps=1.12u w=0.74u l=0.13u
X1696 VGND.t82 osc[0] a_2920_1632# VGND.t1698 sg13_lv_nmos ad=0.14875p pd=1.16u as=0.187p ps=1.78u w=0.55u l=0.13u
X1697 VGND.t898 sg13cmos5l_inv_16_88.A sg13cmos5l_inv_16_94.A VGND.t881 sg13_lv_nmos ad=0.1406p pd=1.12u as=0.1406p ps=1.12u w=0.74u l=0.13u
X1698 sg13cmos5l_inv_16_47.A sg13cmos5l_inv_16_46.A VGND.t1715 VGND.t380 sg13_lv_nmos ad=0.1406p pd=1.12u as=0.1406p ps=1.12u w=0.74u l=0.13u
X1699 sg13cmos5l_inv_16_6.A sg13cmos5l_inv_16_4.Y VGND.t310 VGND.t321 sg13_lv_nmos ad=0.1406p pd=1.12u as=0.1406p ps=1.12u w=0.74u l=0.13u
X1700 sg13cmos5l_inv_16_17.Y sg13cmos5l_inv_16_17.A VGND.t84 VGND.t109 sg13_lv_nmos ad=0.1406p pd=1.12u as=0.1406p ps=1.12u w=0.74u l=0.13u
X1701 sg13cmos5l_inv_16_87.Y sg13cmos5l_inv_16_87.A VGND.t1010 VGND.t881 sg13_lv_nmos ad=0.1406p pd=1.12u as=0.1406p ps=1.12u w=0.74u l=0.13u
X1702 VGND.t756 VPWR.t2549 VGND.t756 VGND.t380 sg13_lv_nmos ad=0.1428p pd=1.52u as=0 ps=0 w=0.42u l=1u
X1703 sg13cmos5l_inv_16_96.A sg13cmos5l_inv_4_6.Y VGND.t953 VGND.t380 sg13_lv_nmos ad=0.1406p pd=1.12u as=0.1406p ps=1.12u w=0.74u l=0.13u
X1704 VPWR.t767 sg13cmos5l_inv_16_26.Y sg13cmos5l_inv_16_40.Y VPWR.t177 sg13_lv_pmos ad=0.2128p pd=1.5u as=0.2128p ps=1.5u w=1.12u l=0.13u
X1705 VGND.t905 sg13cmos5l_inv_16_69.Y sg13cmos5l_inv_16_58.Y VGND.t904 sg13_lv_nmos ad=0.1406p pd=1.12u as=0.1406p ps=1.12u w=0.74u l=0.13u
X1706 VGND.t1083 VPWR.t2585 VGND.t1083 VGND.t881 sg13_lv_nmos ad=79.8f pd=0.8u as=0 ps=0 w=0.42u l=1u
X1707 VPWR.t64 VGND.t1029 VPWR.t63 VPWR.t16 sg13_lv_pmos ad=0.34p pd=2.68u as=0 ps=0 w=1u l=1u
X1708 sg13cmos5l_inv_16_47.Y sg13cmos5l_inv_16_47.A VPWR.t2306 VPWR.t25 sg13_lv_pmos ad=0.2128p pd=1.5u as=0.2128p ps=1.5u w=1.12u l=0.13u
X1709 VPWR.t841 sg13cmos5l_inv_2_1.Y sg13cmos5l_inv_8_1.A VPWR.t4 sg13_lv_pmos ad=0.2128p pd=1.5u as=0.2128p ps=1.5u w=1.12u l=0.13u
X1710 VPWR.t1711 sg13cmos5l_inv_16_26.A sg13cmos5l_inv_16_30.A VPWR.t4 sg13_lv_pmos ad=0.2128p pd=1.5u as=0.2128p ps=1.5u w=1.12u l=0.13u
X1711 VGND.t756 sg13cmos5l_inv_16_111.A sg13cmos5l_inv_16_111.Y VGND.t380 sg13_lv_nmos ad=0.1406p pd=1.12u as=0.1406p ps=1.12u w=0.74u l=0.13u
X1712 sg13cmos5l_inv_16_77.Y sg13cmos5l_inv_16_77.A VGND.t472 VGND.t2166 sg13_lv_nmos ad=0.1406p pd=1.12u as=0.1406p ps=1.12u w=0.74u l=0.13u
X1713 sg13cmos5l_inv_16_67.Y sg13cmos5l_inv_16_67.A VPWR.t1990 VPWR.t16 sg13_lv_pmos ad=0.2128p pd=1.5u as=0.2128p ps=1.5u w=1.12u l=0.13u
X1714 VGND.t1944 sg13cmos5l_inv_16_47.A sg13cmos5l_inv_16_45.Y VGND.t380 sg13_lv_nmos ad=0.1406p pd=1.12u as=0.1406p ps=1.12u w=0.74u l=0.13u
X1715 VPWR.t1925 sg13cmos5l_inv_16_111.A sg13cmos5l_inv_16_98.Y VPWR.t9 sg13_lv_pmos ad=0.2128p pd=1.5u as=0.2128p ps=1.5u w=1.12u l=0.13u
X1716 VPWR.t2236 sg13cmos5l_inv_16_96.Y sg13cmos5l_inv_16_11.A VPWR.t25 sg13_lv_pmos ad=0.2128p pd=1.5u as=0.2128p ps=1.5u w=1.12u l=0.13u
X1717 VPWR.t564 sg13cmos5l_inv_16_36.A sg13cmos5l_inv_16_100.Y VPWR.t0 sg13_lv_pmos ad=0.2128p pd=1.5u as=0.2128p ps=1.5u w=1.12u l=0.13u
X1718 VPWR.t767 sg13cmos5l_inv_16_27.Y sg13cmos5l_inv_16_26.A VPWR.t177 sg13_lv_pmos ad=0.2128p pd=1.5u as=0.2128p ps=1.5u w=1.12u l=0.13u
X1719 VGND.t723 sg13cmos5l_inv_16_9.A sg13cmos5l_inv_16_10.Y VGND.t735 sg13_lv_nmos ad=0.1406p pd=1.12u as=0.1406p ps=1.12u w=0.74u l=0.13u
X1720 VGND.t1245 sg13cmos5l_inv_16_6.Y sg13cmos5l_inv_16_25.Y VGND.t2332 sg13_lv_nmos ad=0.1406p pd=1.12u as=0.1406p ps=1.12u w=0.74u l=0.13u
X1721 VPWR.t2030 sg13cmos5l_inv_16_56.Y sg13cmos5l_inv_16_71.Y VPWR.t16 sg13_lv_pmos ad=0.2128p pd=1.5u as=0.2128p ps=1.5u w=1.12u l=0.13u
X1722 sg13cmos5l_inv_16_103.Y sg13cmos5l_inv_16_103.A VPWR.t1602 VPWR.t0 sg13_lv_pmos ad=0.2128p pd=1.5u as=0.3808p ps=2.92u w=1.12u l=0.13u
X1723 VPWR.t2362 sg13cmos5l_inv_8_4.Y sg13cmos5l_inv_16_56.Y VPWR.t25 sg13_lv_pmos ad=0.2128p pd=1.5u as=0.2128p ps=1.5u w=1.12u l=0.13u
X1724 VGND.t655 sg13cmos5l_inv_16_1.A sg13cmos5l_inv_16_2.A VGND.t664 sg13_lv_nmos ad=0.1406p pd=1.12u as=0.1406p ps=1.12u w=0.74u l=0.13u
X1725 sg13cmos5l_inv_16_30.Y sg13cmos5l_inv_16_30.A VPWR.t480 VPWR.t177 sg13_lv_pmos ad=0.2128p pd=1.5u as=0.3808p ps=2.92u w=1.12u l=0.13u
X1726 sg13cmos5l_inv_16_14.A sg13cmos5l_inv_16_23.Y VGND.t52 VGND.t76 sg13_lv_nmos ad=0.1406p pd=1.12u as=0.1406p ps=1.12u w=0.74u l=0.13u
X1727 VGND.t217 VPWR.t2508 VGND.t217 VGND.t2047 sg13_lv_nmos ad=0.1428p pd=1.52u as=0 ps=0 w=0.42u l=1u
X1728 sg13cmos5l_inv_16_0.A sg13cmos5l_inv_8_0.Y VPWR.t2409 VPWR.t177 sg13_lv_pmos ad=0.2128p pd=1.5u as=0.2128p ps=1.5u w=1.12u l=0.13u
X1729 VGND.t45 sg13cmos5l_inv_16_15.A sg13cmos5l_inv_16_13.Y VGND.t516 sg13_lv_nmos ad=0.2516p pd=2.16u as=0.1406p ps=1.12u w=0.74u l=0.13u
X1730 VPWR.t2304 sg13cmos5l_inv_16_47.A sg13cmos5l_inv_16_47.Y VPWR.t25 sg13_lv_pmos ad=0.2128p pd=1.5u as=0.2128p ps=1.5u w=1.12u l=0.13u
X1731 sg13cmos5l_inv_16_30.A sg13cmos5l_inv_16_26.A VPWR.t1708 VPWR.t4 sg13_lv_pmos ad=0.2128p pd=1.5u as=0.3808p ps=2.92u w=1.12u l=0.13u
X1732 sg13cmos5l_inv_16_111.Y sg13cmos5l_inv_16_111.A VGND.t756 VGND.t380 sg13_lv_nmos ad=0.1406p pd=1.12u as=0.1406p ps=1.12u w=0.74u l=0.13u
X1733 VGND.t326 sg13cmos5l_inv_16_26.A sg13cmos5l_inv_16_30.A VGND.t1322 sg13_lv_nmos ad=0.1406p pd=1.12u as=0.1406p ps=1.12u w=0.74u l=0.13u
X1734 sg13cmos5l_inv_16_45.Y sg13cmos5l_inv_16_47.A VGND.t1944 VGND.t380 sg13_lv_nmos ad=0.1406p pd=1.12u as=0.2516p ps=2.16u w=0.74u l=0.13u
X1735 sg13cmos5l_inv_16_100.Y sg13cmos5l_inv_16_36.A VPWR.t560 VPWR.t0 sg13_lv_pmos ad=0.2128p pd=1.5u as=0.2128p ps=1.5u w=1.12u l=0.13u
X1736 VPWR.t480 sg13cmos5l_inv_16_30.A sg13cmos5l_inv_16_31.Y VPWR.t177 sg13_lv_pmos ad=0.2128p pd=1.5u as=0.2128p ps=1.5u w=1.12u l=0.13u
X1737 VGND.t1507 sg13cmos5l_inv_16_94.A sg13cmos5l_inv_16_73.A VGND.t881 sg13_lv_nmos ad=0.2516p pd=2.16u as=0.1406p ps=1.12u w=0.74u l=0.13u
X1738 sg13cmos5l_inv_16_74.Y sg13cmos5l_inv_16_75.A VPWR.t816 VPWR.t25 sg13_lv_pmos ad=0.2128p pd=1.5u as=0.2128p ps=1.5u w=1.12u l=0.13u
X1739 sg13cmos5l_inv_16_102.Y sg13cmos5l_inv_16_37.A VPWR.t458 VPWR.t0 sg13_lv_pmos ad=0.2128p pd=1.5u as=0.2128p ps=1.5u w=1.12u l=0.13u
X1740 VGND.t1026 sg13cmos5l_inv_16_81.Y sg13cmos5l_inv_16_79.A VGND.t881 sg13_lv_nmos ad=0.1406p pd=1.12u as=0.1406p ps=1.12u w=0.74u l=0.13u
X1741 sg13cmos5l_inv_16_56.Y sg13cmos5l_inv_8_4.Y VPWR.t2358 VPWR.t25 sg13_lv_pmos ad=0.2128p pd=1.5u as=0.2128p ps=1.5u w=1.12u l=0.13u
X1742 sg13cmos5l_inv_16_77.Y sg13cmos5l_inv_16_77.A VPWR.t2258 VPWR.t25 sg13_lv_pmos ad=0.2128p pd=1.5u as=0.2128p ps=1.5u w=1.12u l=0.13u
X1743 sg13cmos5l_inv_16_2.A sg13cmos5l_inv_16_1.A VGND.t655 VGND.t661 sg13_lv_nmos ad=0.1406p pd=1.12u as=0.1406p ps=1.12u w=0.74u l=0.13u
X1744 VGND.t52 sg13cmos5l_inv_16_23.Y sg13cmos5l_inv_16_14.A VGND.t73 sg13_lv_nmos ad=0.1406p pd=1.12u as=0.1406p ps=1.12u w=0.74u l=0.13u
X1745 VGND.t1580 sg13cmos5l_inv_16_67.A sg13cmos5l_inv_16_65.Y VGND.t1595 sg13_lv_nmos ad=0.2516p pd=2.16u as=0.1406p ps=1.12u w=0.74u l=0.13u
X1746 VPWR.t480 sg13cmos5l_and2_1_3.B a_5133_916# VPWR.t177 sg13_lv_pmos ad=0.1918p pd=1.5u as=0.1596p ps=1.22u w=0.84u l=0.13u
X1747 sg13cmos5l_inv_16_85.Y sg13cmos5l_inv_16_84.A VGND.t1067 VGND.t1075 sg13_lv_nmos ad=0.1406p pd=1.12u as=0.1406p ps=1.12u w=0.74u l=0.13u
X1748 sg13cmos5l_inv_16_84.A sg13cmos5l_inv_16_81.Y VPWR.t1434 VPWR.t9 sg13_lv_pmos ad=0.2128p pd=1.5u as=0.2128p ps=1.5u w=1.12u l=0.13u
X1749 sg13cmos5l_inv_16_99.Y sg13cmos5l_inv_16_99.A VPWR.t1213 VPWR.t0 sg13_lv_pmos ad=0.2128p pd=1.5u as=0.2128p ps=1.5u w=1.12u l=0.13u
X1750 VGND.t1715 sg13cmos5l_inv_16_46.Y sg13cmos5l_inv_16_50.Y VGND.t380 sg13_lv_nmos ad=0.1406p pd=1.12u as=0.1406p ps=1.12u w=0.74u l=0.13u
X1751 sg13cmos5l_inv_16_30.A sg13cmos5l_inv_16_26.A VGND.t326 VGND.t1319 sg13_lv_nmos ad=0.1406p pd=1.12u as=0.1406p ps=1.12u w=0.74u l=0.13u
X1752 sg13cmos5l_inv_16_31.Y sg13cmos5l_inv_16_30.A VPWR.t480 VPWR.t177 sg13_lv_pmos ad=0.2128p pd=1.5u as=0.3808p ps=2.92u w=1.12u l=0.13u
X1753 sg13cmos5l_inv_16_14.Y sg13cmos5l_inv_16_14.A VGND.t52 VGND.t499 sg13_lv_nmos ad=0.1406p pd=1.12u as=0.1406p ps=1.12u w=0.74u l=0.13u
X1754 VPWR.t814 sg13cmos5l_inv_16_75.A sg13cmos5l_inv_16_74.Y VPWR.t25 sg13_lv_pmos ad=0.2128p pd=1.5u as=0.2128p ps=1.5u w=1.12u l=0.13u
X1755 VPWR.t1430 sg13cmos5l_inv_16_87.A sg13cmos5l_inv_16_87.Y VPWR.t9 sg13_lv_pmos ad=0.3808p pd=2.92u as=0.2128p ps=1.5u w=1.12u l=0.13u
X1756 sg13cmos5l_inv_16_19.Y sg13cmos5l_inv_16_17.A VPWR.t535 VPWR.t177 sg13_lv_pmos ad=0.2128p pd=1.5u as=0.2128p ps=1.5u w=1.12u l=0.13u
X1757 VGND.t655 sg13cmos5l_inv_16_1.A sg13cmos5l_inv_16_2.A VGND.t658 sg13_lv_nmos ad=0.1406p pd=1.12u as=0.1406p ps=1.12u w=0.74u l=0.13u
X1758 VPWR.t2256 sg13cmos5l_inv_16_77.A sg13cmos5l_inv_16_77.Y VPWR.t25 sg13_lv_pmos ad=0.2128p pd=1.5u as=0.2128p ps=1.5u w=1.12u l=0.13u
X1759 sg13cmos5l_inv_16_65.Y sg13cmos5l_inv_16_67.A VGND.t1580 VGND.t1592 sg13_lv_nmos ad=0.1406p pd=1.12u as=0.1406p ps=1.12u w=0.74u l=0.13u
X1760 VGND.t1718 sg13cmos5l_inv_16_48.A sg13cmos5l_inv_16_46.A VGND.t380 sg13_lv_nmos ad=0.1406p pd=1.12u as=0.1406p ps=1.12u w=0.74u l=0.13u
X1761 sg13cmos5l_inv_16_53.A sg13cmos5l_inv_16_52.Y VPWR.t1768 VPWR.t16 sg13_lv_pmos ad=0.2128p pd=1.5u as=0.2128p ps=1.5u w=1.12u l=0.13u
X1762 VGND.t1083 sg13cmos5l_inv_16_79.A sg13cmos5l_inv_16_91.Y VGND.t881 sg13_lv_nmos ad=0.1406p pd=1.12u as=0.1406p ps=1.12u w=0.74u l=0.13u
X1763 VPWR.t1175 sg13cmos5l_inv_8_7.Y sg13cmos5l_inv_16_48.A VPWR.t25 sg13_lv_pmos ad=0.2128p pd=1.5u as=0.2128p ps=1.5u w=1.12u l=0.13u
X1764 VPWR.t298 VGND.t1680 VPWR.t297 VPWR.t16 sg13_lv_pmos ad=0.34p pd=2.68u as=0 ps=0 w=1u l=1u
X1765 VPWR.t94 VGND.t953 VPWR.t93 VPWR.t25 sg13_lv_pmos ad=0.34p pd=2.68u as=0 ps=0 w=1u l=1u
X1766 VPWR.t33 VGND.t1779 VPWR.t32 VPWR.t25 sg13_lv_pmos ad=0.34p pd=2.68u as=0 ps=0 w=1u l=1u
X1767 VPWR.t218 VGND.t122 VPWR.t217 VPWR.t0 sg13_lv_pmos ad=0.34p pd=2.68u as=0 ps=0 w=1u l=1u
X1768 sg13cmos5l_inv_16_50.Y sg13cmos5l_inv_16_46.Y VGND.t1715 VGND.t380 sg13_lv_nmos ad=0.1406p pd=1.12u as=0.1406p ps=1.12u w=0.74u l=0.13u
X1769 VGND.t144 sg13cmos5l_inv_16_46.A sg13cmos5l_inv_16_46.Y VGND.t1762 sg13_lv_nmos ad=0.2516p pd=2.16u as=0.1406p ps=1.12u w=0.74u l=0.13u
X1770 sg13cmos5l_inv_16_0.A sg13cmos5l_inv_8_0.Y VPWR.t2406 VPWR.t177 sg13_lv_pmos ad=0.2128p pd=1.5u as=0.4368p ps=3.02u w=1.12u l=0.13u
X1771 sg13cmos5l_inv_16_74.Y sg13cmos5l_inv_16_75.A VPWR.t810 VPWR.t25 sg13_lv_pmos ad=0.2128p pd=1.5u as=0.2128p ps=1.5u w=1.12u l=0.13u
X1772 sg13cmos5l_inv_16_8.Y sg13cmos5l_inv_16_4.Y VGND.t291 VGND.t303 sg13_lv_nmos ad=0.1406p pd=1.12u as=0.1406p ps=1.12u w=0.74u l=0.13u
X1773 sg13cmos5l_inv_16_20.A sg13cmos5l_inv_16_8.Y VGND.t545 VGND.t554 sg13_lv_nmos ad=0.1406p pd=1.12u as=0.1406p ps=1.12u w=0.74u l=0.13u
X1774 sg13cmos5l_inv_16_34.Y sg13cmos5l_inv_16_41.A VGND.t221 VGND.t224 sg13_lv_nmos ad=0.1406p pd=1.12u as=0.1406p ps=1.12u w=0.74u l=0.13u
X1775 sg13cmos5l_inv_4_7.Y sg13cmos5l_inv_2_5.Y VGND.t1201 VGND.t1230 sg13_lv_nmos ad=0.1406p pd=1.12u as=0.1406p ps=1.12u w=0.74u l=0.13u
X1776 VPWR.t862 VGND.t1132 VPWR.t20 VPWR.t16 sg13_lv_pmos ad=0.19p pd=1.38u as=0 ps=0 w=1u l=1u
X1777 sg13cmos5l_inv_16_81.Y sg13cmos5l_inv_16_96.Y VPWR.t2221 VPWR.t16 sg13_lv_pmos ad=0.2128p pd=1.5u as=0.2128p ps=1.5u w=1.12u l=0.13u
X1778 sg13cmos5l_inv_16_6.A sg13cmos5l_inv_16_4.Y VGND.t310 VGND.t317 sg13_lv_nmos ad=0.1406p pd=1.12u as=0.1406p ps=1.12u w=0.74u l=0.13u
X1779 sg13cmos5l_inv_16_93.Y sg13cmos5l_inv_16_87.A VGND.t994 VGND.t1002 sg13_lv_nmos ad=0.1406p pd=1.12u as=0.1406p ps=1.12u w=0.74u l=0.13u
X1780 VGND.t773 sg13cmos5l_inv_16_99.A sg13cmos5l_inv_16_51.Y VGND.t781 sg13_lv_nmos ad=0.1406p pd=1.12u as=0.1406p ps=1.12u w=0.74u l=0.13u
X1781 VPWR.t178 sg13cmos5l_inv_16_26.Y sg13cmos5l_inv_16_40.Y VPWR.t177 sg13_lv_pmos ad=0.2128p pd=1.5u as=0.2128p ps=1.5u w=1.12u l=0.13u
X1782 sg13cmos5l_inv_16_46.A sg13cmos5l_inv_16_48.A VGND.t1715 VGND.t380 sg13_lv_nmos ad=0.1406p pd=1.12u as=0.1406p ps=1.12u w=0.74u l=0.13u
X1783 VPWR.t772 sg13cmos5l_inv_16_11.A sg13cmos5l_inv_16_105.A VPWR.t25 sg13_lv_pmos ad=0.2128p pd=1.5u as=0.2128p ps=1.5u w=1.12u l=0.13u
X1784 sg13cmos5l_inv_16_48.A sg13cmos5l_inv_8_7.Y VPWR.t1172 VPWR.t25 sg13_lv_pmos ad=0.2128p pd=1.5u as=0.4368p ps=3.02u w=1.12u l=0.13u
X1785 sg13cmos5l_inv_16_85.Y sg13cmos5l_inv_16_84.A VGND.t1067 VGND.t1071 sg13_lv_nmos ad=0.1406p pd=1.12u as=0.1406p ps=1.12u w=0.74u l=0.13u
X1786 VPWR.t647 VGND.t1083 VPWR.t646 VPWR.t9 sg13_lv_pmos ad=0.34p pd=2.68u as=0 ps=0 w=1u l=1u
X1787 VGND.t1143 VPWR.t2588 VGND.t1143 VGND.t881 sg13_lv_nmos ad=0.1428p pd=1.52u as=0 ps=0 w=0.42u l=1u
X1788 sg13cmos5l_inv_16_9.Y sg13cmos5l_inv_16_9.A VGND.t738 VGND.t739 sg13_lv_nmos ad=0.1406p pd=1.12u as=0.1406p ps=1.12u w=0.74u l=0.13u
X1789 sg13cmos5l_inv_2_5.A sg13cmos5l_and2_1_6.X VGND.t1201 VGND.t1504 sg13_lv_nmos ad=0.2516p pd=2.16u as=0.2516p ps=2.16u w=0.74u l=0.13u
X1790 sg13cmos5l_inv_16_55.Y sg13cmos5l_inv_16_101.Y VGND.t1663 VGND.t380 sg13_lv_nmos ad=0.1406p pd=1.12u as=0.1406p ps=1.12u w=0.74u l=0.13u
X1791 VGND.t1715 sg13cmos5l_inv_16_46.Y sg13cmos5l_inv_16_50.Y VGND.t380 sg13_lv_nmos ad=0.1406p pd=1.12u as=0.1406p ps=1.12u w=0.74u l=0.13u
X1792 sg13cmos5l_inv_16_46.Y sg13cmos5l_inv_16_46.A VGND.t139 VGND.t1759 sg13_lv_nmos ad=0.1406p pd=1.12u as=0.1406p ps=1.12u w=0.74u l=0.13u
X1793 sg13cmos5l_inv_16_5.Y sg13cmos5l_inv_16_6.A VPWR.t329 VPWR.t177 sg13_lv_pmos ad=0.2128p pd=1.5u as=0.2128p ps=1.5u w=1.12u l=0.13u
X1794 VGND.t1026 sg13cmos5l_inv_16_81.Y sg13cmos5l_inv_16_84.A VGND.t881 sg13_lv_nmos ad=0.1406p pd=1.12u as=0.1406p ps=1.12u w=0.74u l=0.13u
X1795 VGND.t723 sg13cmos5l_inv_16_9.A sg13cmos5l_inv_16_10.Y VGND.t730 sg13_lv_nmos ad=0.1406p pd=1.12u as=0.1406p ps=1.12u w=0.74u l=0.13u
X1796 VGND.t963 sg13cmos5l_inv_16_56.Y sg13cmos5l_inv_16_71.Y VGND.t881 sg13_lv_nmos ad=0.1406p pd=1.12u as=0.1406p ps=1.12u w=0.74u l=0.13u
X1797 sg13cmos5l_inv_16_54.Y sg13cmos5l_inv_16_101.Y VGND.t1680 VGND.t380 sg13_lv_nmos ad=0.1406p pd=1.12u as=0.1406p ps=1.12u w=0.74u l=0.13u
X1798 sg13cmos5l_inv_16_61.Y sg13cmos5l_inv_16_61.A VGND.t1164 VGND.t881 sg13_lv_nmos ad=0.1406p pd=1.12u as=0.1406p ps=1.12u w=0.74u l=0.13u
X1799 VGND.t310 sg13cmos5l_inv_16_4.Y sg13cmos5l_inv_16_6.A VGND.t314 sg13_lv_nmos ad=0.1406p pd=1.12u as=0.1406p ps=1.12u w=0.74u l=0.13u
X1800 sg13cmos5l_inv_16_51.Y sg13cmos5l_inv_16_99.A VGND.t773 VGND.t778 sg13_lv_nmos ad=0.1406p pd=1.12u as=0.1406p ps=1.12u w=0.74u l=0.13u
X1801 sg13cmos5l_inv_16_26.Y sg13cmos5l_inv_16_26.A VPWR.t767 VPWR.t177 sg13_lv_pmos ad=0.2128p pd=1.5u as=0.2128p ps=1.5u w=1.12u l=0.13u
X1802 sg13cmos5l_inv_16_84.Y sg13cmos5l_inv_16_84.A VGND.t1026 VGND.t881 sg13_lv_nmos ad=0.1406p pd=1.12u as=0.1406p ps=1.12u w=0.74u l=0.13u
X1803 VPWR.t381 VGND.t432 VPWR.t380 VPWR.t0 sg13_lv_pmos ad=0.34p pd=2.68u as=0 ps=0 w=1u l=1u
X1804 VPWR.t844 sg13cmos5l_inv_16_27.A sg13cmos5l_inv_16_27.Y VPWR.t177 sg13_lv_pmos ad=0.2128p pd=1.5u as=0.2128p ps=1.5u w=1.12u l=0.13u
X1805 sg13cmos5l_inv_8_1.Y sg13cmos5l_inv_8_1.A VPWR.t1814 VPWR.t177 sg13_lv_pmos ad=0.2128p pd=1.5u as=0.2128p ps=1.5u w=1.12u l=0.13u
X1806 VPWR.t731 sg13cmos5l_inv_16_4.Y sg13cmos5l_inv_16_8.Y VPWR.t4 sg13_lv_pmos ad=0.2128p pd=1.5u as=0.2128p ps=1.5u w=1.12u l=0.13u
X1807 VPWR.t329 VGND.t2146 VPWR.t329 VPWR.t177 sg13_lv_pmos ad=0.19p pd=1.38u as=0 ps=0 w=1u l=1u
X1808 sg13cmos5l_inv_16_0.A sg13cmos5l_inv_8_0.Y VGND.t2123 VGND.t2329 sg13_lv_nmos ad=0.1406p pd=1.12u as=0.1406p ps=1.12u w=0.74u l=0.13u
X1809 sg13cmos5l_inv_16_90.Y sg13cmos5l_inv_16_73.Y VPWR.t2195 VPWR.t16 sg13_lv_pmos ad=0.2128p pd=1.5u as=0.2128p ps=1.5u w=1.12u l=0.13u
X1810 VGND.t723 sg13cmos5l_inv_16_9.A sg13cmos5l_inv_16_9.Y VGND.t735 sg13_lv_nmos ad=0.1406p pd=1.12u as=0.1406p ps=1.12u w=0.74u l=0.13u
X1811 sg13cmos5l_inv_16_99.Y sg13cmos5l_inv_16_99.A VGND.t773 VGND.t772 sg13_lv_nmos ad=0.1406p pd=1.12u as=0.2516p ps=2.16u w=0.74u l=0.13u
X1812 VGND.t326 sg13cmos5l_inv_16_30.A sg13cmos5l_inv_16_31.Y VGND.t1292 sg13_lv_nmos ad=0.1406p pd=1.12u as=0.1406p ps=1.12u w=0.74u l=0.13u
X1813 VGND.t1245 sg13cmos5l_inv_16_27.Y sg13cmos5l_inv_16_43.Y VGND.t1249 sg13_lv_nmos ad=0.1406p pd=1.12u as=0.1406p ps=1.12u w=0.74u l=0.13u
X1814 VGND.t1026 sg13cmos5l_inv_16_81.Y sg13cmos5l_inv_16_79.A VGND.t881 sg13_lv_nmos ad=0.1406p pd=1.12u as=0.1406p ps=1.12u w=0.74u l=0.13u
X1815 sg13cmos5l_inv_16_65.Y sg13cmos5l_inv_16_67.A VPWR.t1968 VPWR.t9 sg13_lv_pmos ad=0.2128p pd=1.5u as=0.2128p ps=1.5u w=1.12u l=0.13u
X1816 sg13cmos5l_inv_16_66.Y sg13cmos5l_inv_16_68.A VPWR.t1288 VPWR.t9 sg13_lv_pmos ad=0.2128p pd=1.5u as=0.2128p ps=1.5u w=1.12u l=0.13u
X1817 VGND.t1680 sg13cmos5l_inv_16_101.Y sg13cmos5l_inv_16_54.Y VGND.t380 sg13_lv_nmos ad=0.1406p pd=1.12u as=0.1406p ps=1.12u w=0.74u l=0.13u
X1818 sg13cmos5l_inv_16_56.Y sg13cmos5l_inv_8_4.Y VPWR.t2355 VPWR.t25 sg13_lv_pmos ad=0.2128p pd=1.5u as=0.3808p ps=2.92u w=1.12u l=0.13u
X1819 VGND.t96 VPWR.t2472 VGND.t96 VGND.t2114 sg13_lv_nmos ad=79.8f pd=0.8u as=0 ps=0 w=0.42u l=1u
X1820 VPWR.t586 sg13cmos5l_inv_16_36.A sg13cmos5l_inv_16_36.Y VPWR.t4 sg13_lv_pmos ad=0.2128p pd=1.5u as=0.2128p ps=1.5u w=1.12u l=0.13u
X1821 VGND.t1164 sg13cmos5l_inv_16_61.A sg13cmos5l_inv_16_61.Y VGND.t881 sg13_lv_nmos ad=0.1406p pd=1.12u as=0.1406p ps=1.12u w=0.74u l=0.13u
X1822 VGND.t45 sg13cmos5l_inv_16_15.A sg13cmos5l_inv_16_15.Y VGND.t516 sg13_lv_nmos ad=0.2516p pd=2.16u as=0.1406p ps=1.12u w=0.74u l=0.13u
X1823 sg13cmos5l_inv_16_58.Y sg13cmos5l_inv_16_69.Y VGND.t916 VGND.t919 sg13_lv_nmos ad=0.1406p pd=1.12u as=0.1406p ps=1.12u w=0.74u l=0.13u
X1824 VGND.t963 sg13cmos5l_inv_16_71.Y sg13cmos5l_inv_16_61.A VGND.t881 sg13_lv_nmos ad=0.2516p pd=2.16u as=0.1406p ps=1.12u w=0.74u l=0.13u
X1825 sg13cmos5l_inv_16_27.Y sg13cmos5l_inv_16_27.A VPWR.t844 VPWR.t177 sg13_lv_pmos ad=0.2128p pd=1.5u as=0.2128p ps=1.5u w=1.12u l=0.13u
X1826 sg13cmos5l_inv_16_108.Y sg13cmos5l_inv_16_6.Y VPWR.t1001 VPWR.t177 sg13_lv_pmos ad=0.2128p pd=1.5u as=0.2128p ps=1.5u w=1.12u l=0.13u
X1827 VGND.t635 sg13cmos5l_inv_2_2.Y sg13cmos5l_inv_8_2.A VGND.t1383 sg13_lv_nmos ad=0.2516p pd=2.16u as=0.1406p ps=1.12u w=0.74u l=0.13u
X1828 sg13cmos5l_inv_16_94.A sg13cmos5l_inv_16_88.A VPWR.t2011 VPWR.t9 sg13_lv_pmos ad=0.2128p pd=1.5u as=0.4368p ps=3.02u w=1.12u l=0.13u
X1829 VPWR.t2193 sg13cmos5l_inv_16_73.Y sg13cmos5l_inv_16_90.Y VPWR.t16 sg13_lv_pmos ad=0.2128p pd=1.5u as=0.2128p ps=1.5u w=1.12u l=0.13u
X1830 sg13cmos5l_inv_16_31.Y sg13cmos5l_inv_16_30.A VGND.t326 VGND.t1289 sg13_lv_nmos ad=0.1406p pd=1.12u as=0.1406p ps=1.12u w=0.74u l=0.13u
X1831 sg13cmos5l_inv_16_79.A sg13cmos5l_inv_16_81.Y VGND.t1026 VGND.t881 sg13_lv_nmos ad=0.1406p pd=1.12u as=0.1406p ps=1.12u w=0.74u l=0.13u
X1832 sg13cmos5l_inv_16_51.Y sg13cmos5l_inv_16_99.A VPWR.t1196 VPWR.t25 sg13_lv_pmos ad=0.2128p pd=1.5u as=0.2128p ps=1.5u w=1.12u l=0.13u
X1833 VPWR.t1286 sg13cmos5l_inv_16_68.A sg13cmos5l_inv_16_66.Y VPWR.t9 sg13_lv_pmos ad=0.2128p pd=1.5u as=0.2128p ps=1.5u w=1.12u l=0.13u
X1834 VPWR.t89 VGND.t953 VPWR.t90 VPWR.t16 sg13_lv_pmos ad=0.19p pd=1.38u as=0 ps=0 w=1u l=1u
X1835 sg13cmos5l_inv_16_29.Y sg13cmos5l_inv_16_29.A VPWR.t707 VPWR.t177 sg13_lv_pmos ad=0.2128p pd=1.5u as=0.2128p ps=1.5u w=1.12u l=0.13u
X1836 VGND.t916 sg13cmos5l_inv_16_69.Y sg13cmos5l_inv_16_58.Y VGND.t915 sg13_lv_nmos ad=0.1406p pd=1.12u as=0.1406p ps=1.12u w=0.74u l=0.13u
X1837 VPWR.t2140 sg13cmos5l_inv_16_46.A sg13cmos5l_inv_16_46.Y VPWR.t25 sg13_lv_pmos ad=0.2128p pd=1.5u as=0.2128p ps=1.5u w=1.12u l=0.13u
X1838 sg13cmos5l_inv_16_61.A sg13cmos5l_inv_16_71.Y VGND.t963 VGND.t881 sg13_lv_nmos ad=0.1406p pd=1.12u as=0.1406p ps=1.12u w=0.74u l=0.13u
X1839 sg13cmos5l_inv_16_55.Y sg13cmos5l_inv_16_101.Y VPWR.t2338 VPWR.t25 sg13_lv_pmos ad=0.2128p pd=1.5u as=0.2128p ps=1.5u w=1.12u l=0.13u
X1840 sg13cmos5l_inv_16_84.A sg13cmos5l_inv_16_81.Y VPWR.t1432 VPWR.t9 sg13_lv_pmos ad=0.2128p pd=1.5u as=0.2128p ps=1.5u w=1.12u l=0.13u
X1841 VPWR.t1207 sg13cmos5l_inv_16_99.A sg13cmos5l_inv_16_99.Y VPWR.t0 sg13_lv_pmos ad=0.2128p pd=1.5u as=0.2128p ps=1.5u w=1.12u l=0.13u
X1842 VPWR.t727 sg13cmos5l_inv_16_4.Y sg13cmos5l_inv_16_8.Y VPWR.t4 sg13_lv_pmos ad=0.2128p pd=1.5u as=0.2128p ps=1.5u w=1.12u l=0.13u
X1843 VPWR.t1592 sg13cmos5l_inv_16_61.A sg13cmos5l_inv_16_61.Y VPWR.t9 sg13_lv_pmos ad=0.2128p pd=1.5u as=0.2128p ps=1.5u w=1.12u l=0.13u
X1844 sg13cmos5l_inv_16_69.Y sg13cmos5l_inv_16_52.Y VPWR.t1750 VPWR.t16 sg13_lv_pmos ad=0.2128p pd=1.5u as=0.2128p ps=1.5u w=1.12u l=0.13u
X1845 sg13cmos5l_inv_16_59.Y sg13cmos5l_inv_16_61.A VGND.t1178 VGND.t1181 sg13_lv_nmos ad=0.1406p pd=1.12u as=0.1406p ps=1.12u w=0.74u l=0.13u
X1846 VGND.t353 sg13cmos5l_inv_16_103.A sg13cmos5l_inv_16_103.Y VGND.t352 sg13_lv_nmos ad=0.1406p pd=1.12u as=0.1406p ps=1.12u w=0.74u l=0.13u
X1847 VGND.t66 sg13cmos5l_inv_16_14.A sg13cmos5l_inv_16_14.Y VGND.t492 sg13_lv_nmos ad=0.1406p pd=1.12u as=0.1406p ps=1.12u w=0.74u l=0.13u
X1848 VPWR.t1908 sg13cmos5l_inv_16_94.A sg13cmos5l_inv_16_76.A VPWR.t16 sg13_lv_pmos ad=0.2128p pd=1.5u as=0.2128p ps=1.5u w=1.12u l=0.13u
X1849 VPWR.t2170 sg13cmos5l_inv_16_79.A sg13cmos5l_inv_16_79.Y VPWR.t16 sg13_lv_pmos ad=0.2128p pd=1.5u as=0.2128p ps=1.5u w=1.12u l=0.13u
X1850 VPWR.t1194 sg13cmos5l_inv_16_99.A sg13cmos5l_inv_16_51.Y VPWR.t25 sg13_lv_pmos ad=0.2128p pd=1.5u as=0.2128p ps=1.5u w=1.12u l=0.13u
X1851 VPWR.t1502 sg13cmos5l_inv_16_84.A sg13cmos5l_inv_16_84.Y VPWR.t9 sg13_lv_pmos ad=0.4368p pd=3.02u as=0.2128p ps=1.5u w=1.12u l=0.13u
X1852 sg13cmos5l_inv_16_66.Y sg13cmos5l_inv_16_68.A VPWR.t1282 VPWR.t9 sg13_lv_pmos ad=0.2128p pd=1.5u as=0.2128p ps=1.5u w=1.12u l=0.13u
X1853 VGND.t1243 VPWR.t2480 VGND.t1243 VGND.t2097 sg13_lv_nmos ad=79.8f pd=0.8u as=0 ps=0 w=0.42u l=1u
X1854 sg13cmos5l_inv_16_75.A sg13cmos5l_inv_16_76.A VGND.t390 VGND.t380 sg13_lv_nmos ad=0.1406p pd=1.12u as=0.1406p ps=1.12u w=0.74u l=0.13u
X1855 VGND.t1201 sg13cmos5l_inv_4_7.Y sg13cmos5l_inv_16_88.A VGND.t1219 sg13_lv_nmos ad=0.1406p pd=1.12u as=0.1406p ps=1.12u w=0.74u l=0.13u
X1856 VPWR.t310 VGND.t427 VPWR.t309 VPWR.t16 sg13_lv_pmos ad=0.34p pd=2.68u as=0 ps=0 w=1u l=1u
X1857 VGND.t139 sg13cmos5l_inv_16_36.A sg13cmos5l_inv_16_100.Y VGND.t138 sg13_lv_nmos ad=0.1406p pd=1.12u as=0.1406p ps=1.12u w=0.74u l=0.13u
X1858 VGND.t1178 sg13cmos5l_inv_16_61.A sg13cmos5l_inv_16_59.Y VGND.t1177 sg13_lv_nmos ad=0.1406p pd=1.12u as=0.1406p ps=1.12u w=0.74u l=0.13u
X1859 VGND.t343 sg13cmos5l_inv_16_30.A sg13cmos5l_inv_16_30.Y VGND.t1305 sg13_lv_nmos ad=0.1406p pd=1.12u as=0.1406p ps=1.12u w=0.74u l=0.13u
X1860 sg13cmos5l_inv_16_79.Y sg13cmos5l_inv_16_79.A VPWR.t2166 VPWR.t16 sg13_lv_pmos ad=0.2128p pd=1.5u as=0.2128p ps=1.5u w=1.12u l=0.13u
X1861 VPWR.t157 VGND.t5 VPWR.t156 VPWR.t0 sg13_lv_pmos ad=0.19p pd=1.38u as=0 ps=0 w=1u l=1u
X1862 VPWR.t643 VGND.t1083 VPWR.t642 VPWR.t9 sg13_lv_pmos ad=0.34p pd=2.68u as=0 ps=0 w=1u l=1u
X1863 sg13cmos5l_inv_16_17.Y sg13cmos5l_inv_16_17.A VPWR.t521 VPWR.t177 sg13_lv_pmos ad=0.2128p pd=1.5u as=0.3808p ps=2.92u w=1.12u l=0.13u
X1864 VGND.t994 sg13cmos5l_inv_16_87.A sg13cmos5l_inv_16_93.Y VGND.t995 sg13_lv_nmos ad=0.1406p pd=1.12u as=0.1406p ps=1.12u w=0.74u l=0.13u
X1865 VGND.t20 VPWR.t2524 VGND.t20 VGND.t2020 sg13_lv_nmos ad=0.1428p pd=1.52u as=0 ps=0 w=0.42u l=1u
X1866 VPWR.t705 sg13cmos5l_inv_16_28.A sg13cmos5l_inv_16_44.A VPWR.t4 sg13_lv_pmos ad=0.4368p pd=3.02u as=0.2128p ps=1.5u w=1.12u l=0.13u
X1867 VGND.t390 sg13cmos5l_inv_16_76.A sg13cmos5l_inv_16_75.A VGND.t380 sg13_lv_nmos ad=0.1406p pd=1.12u as=0.1406p ps=1.12u w=0.74u l=0.13u
X1868 sg13cmos5l_inv_16_103.A sg13cmos5l_inv_16_11.A VGND.t370 VGND.t373 sg13_lv_nmos ad=0.1406p pd=1.12u as=0.1406p ps=1.12u w=0.74u l=0.13u
X1869 sg13cmos5l_inv_16_14.Y sg13cmos5l_inv_16_14.A VPWR.t917 VPWR.t4 sg13_lv_pmos ad=0.2128p pd=1.5u as=0.2128p ps=1.5u w=1.12u l=0.13u
X1870 VGND.t723 sg13cmos5l_inv_16_9.A sg13cmos5l_inv_16_9.Y VGND.t730 sg13_lv_nmos ad=0.1406p pd=1.12u as=0.1406p ps=1.12u w=0.74u l=0.13u
X1871 VGND.t1147 VPWR.t2587 VGND.t1143 VGND.t881 sg13_lv_nmos ad=0.1428p pd=1.52u as=0 ps=0 w=0.42u l=1u
X1872 VPWR.t984 sg13cmos5l_inv_16_8.Y sg13cmos5l_inv_16_20.A VPWR.t0 sg13_lv_pmos ad=0.3808p pd=2.92u as=0.2128p ps=1.5u w=1.12u l=0.13u
X1873 VPWR.t1090 sg13cmos5l_inv_16_1.A sg13cmos5l_inv_16_17.A VPWR.t177 sg13_lv_pmos ad=0.2128p pd=1.5u as=0.2128p ps=1.5u w=1.12u l=0.13u
X1874 VGND.t215 sg13cmos5l_inv_1_2.Y sg13cmos5l_inv_2_3.Y VGND.t584 sg13_lv_nmos ad=0.2516p pd=2.16u as=0.1406p ps=1.12u w=0.74u l=0.13u
X1875 VGND.t1245 sg13cmos5l_inv_16_27.Y sg13cmos5l_inv_16_43.Y VGND.t1244 sg13_lv_nmos ad=0.1406p pd=1.12u as=0.1406p ps=1.12u w=0.74u l=0.13u
X1876 VPWR.t133 VGND.t963 VPWR.t132 VPWR.t16 sg13_lv_pmos ad=0.34p pd=2.68u as=0 ps=0 w=1u l=1u
X1877 sg13cmos5l_inv_16_81.Y sg13cmos5l_inv_16_96.Y VPWR.t2233 VPWR.t16 sg13_lv_pmos ad=0.2128p pd=1.5u as=0.2128p ps=1.5u w=1.12u l=0.13u
X1878 sg13cmos5l_inv_16_13.Y sg13cmos5l_inv_16_15.A VPWR.t941 VPWR.t0 sg13_lv_pmos ad=0.2128p pd=1.5u as=0.2128p ps=1.5u w=1.12u l=0.13u
X1879 VPWR.t1381 sg13cmos5l_inv_16_71.Y sg13cmos5l_inv_16_61.A VPWR.t9 sg13_lv_pmos ad=0.2128p pd=1.5u as=0.2128p ps=1.5u w=1.12u l=0.13u
X1880 VGND.t1663 sg13cmos5l_inv_16_56.Y sg13cmos5l_inv_16_52.Y VGND.t380 sg13_lv_nmos ad=0.1406p pd=1.12u as=0.1406p ps=1.12u w=0.74u l=0.13u
X1881 VGND.t345 sg13cmos5l_inv_16_103.A sg13cmos5l_inv_16_103.Y VGND.t348 sg13_lv_nmos ad=0.1406p pd=1.12u as=0.1406p ps=1.12u w=0.74u l=0.13u
X1882 sg13cmos5l_inv_2_5.A sg13cmos5l_and2_1_6.X VPWR.t1889 VPWR.t9 sg13_lv_pmos ad=0.3808p pd=2.92u as=0.3808p ps=2.92u w=1.12u l=0.13u
X1883 VGND.t1164 sg13cmos5l_inv_16_61.A sg13cmos5l_inv_16_61.Y VGND.t881 sg13_lv_nmos ad=0.1406p pd=1.12u as=0.1406p ps=1.12u w=0.74u l=0.13u
X1884 VPWR.t76 VGND.t1944 VPWR.t75 VPWR.t16 sg13_lv_pmos ad=0.34p pd=2.68u as=0 ps=0 w=1u l=1u
X1885 VGND.t226 sg13cmos5l_inv_8_3.Y sg13cmos5l_inv_16_41.A VGND.t821 sg13_lv_nmos ad=0.1406p pd=1.12u as=0.1406p ps=1.12u w=0.74u l=0.13u
X1886 sg13cmos5l_inv_16_87.A sg13cmos5l_inv_16_73.A VGND.t1469 VGND.t1481 sg13_lv_nmos ad=0.1406p pd=1.12u as=0.1406p ps=1.12u w=0.74u l=0.13u
X1887 VGND.t429 VPWR.t2515 VGND.t429 VGND.t2034 sg13_lv_nmos ad=0.1428p pd=1.52u as=0 ps=0 w=0.42u l=1u
X1888 VGND.t370 sg13cmos5l_inv_16_11.A sg13cmos5l_inv_16_103.A VGND.t369 sg13_lv_nmos ad=0.1406p pd=1.12u as=0.1406p ps=1.12u w=0.74u l=0.13u
X1889 VPWR.t1001 a_14636_834# sg13cmos5l_buf_1_4.X VPWR.t177 sg13_lv_pmos ad=0.2114p pd=1.54u as=0.42p ps=2.99u w=1.12u l=0.13u
X1890 VGND.t2117 VPWR.t2466 VGND.t2117 VGND.t2130 sg13_lv_nmos ad=79.8f pd=0.8u as=0 ps=0 w=0.42u l=1u
X1891 sg13cmos5l_inv_16_28.A sg13cmos5l_inv_16_41.A VGND.t215 VGND.t214 sg13_lv_nmos ad=0.1406p pd=1.12u as=0.2516p ps=2.16u w=0.74u l=0.13u
X1892 VGND.t3 sg13cmos5l_inv_16_37.A sg13cmos5l_inv_16_37.Y VGND.t27 sg13_lv_nmos ad=0.1406p pd=1.12u as=0.1406p ps=1.12u w=0.74u l=0.13u
X1893 VGND.t1201 sg13cmos5l_buf_1_12.X a_26539_9540# VGND.t1200 sg13_lv_nmos ad=0.1331p pd=1.12u as=0.1216p ps=1.02u w=0.64u l=0.13u
X1894 VGND.t20 sg13cmos5l_inv_16_47.A sg13cmos5l_inv_16_47.Y VGND.t2227 sg13_lv_nmos ad=0.1406p pd=1.12u as=0.1406p ps=1.12u w=0.74u l=0.13u
X1895 VPWR.t1141 sg13cmos5l_inv_16_9.A sg13cmos5l_inv_16_10.Y VPWR.t0 sg13_lv_pmos ad=0.2128p pd=1.5u as=0.2128p ps=1.5u w=1.12u l=0.13u
X1896 sg13cmos5l_inv_16_108.Y sg13cmos5l_inv_16_6.Y VGND.t635 VGND.t2359 sg13_lv_nmos ad=0.1406p pd=1.12u as=0.1406p ps=1.12u w=0.74u l=0.13u
X1897 VGND.t2154 VPWR.t2464 VGND.t2156 VGND.t2155 sg13_lv_nmos ad=79.8f pd=0.8u as=0 ps=0 w=0.42u l=1u
X1898 VGND.t827 sg13cmos5l_inv_8_0.Y sg13cmos5l_inv_16_0.A VGND.t2322 sg13_lv_nmos ad=0.1406p pd=1.12u as=0.1406p ps=1.12u w=0.74u l=0.13u
X1899 sg13cmos5l_inv_16_98.Y sg13cmos5l_inv_16_111.A VPWR.t1937 VPWR.t9 sg13_lv_pmos ad=0.2128p pd=1.5u as=0.2128p ps=1.5u w=1.12u l=0.13u
X1900 VGND.t1029 sg13cmos5l_inv_16_81.Y sg13cmos5l_inv_16_84.A VGND.t881 sg13_lv_nmos ad=0.1406p pd=1.12u as=0.1406p ps=1.12u w=0.74u l=0.13u
X1901 VPWR.t1460 sg13cmos5l_inv_16_81.Y sg13cmos5l_inv_16_79.A VPWR.t16 sg13_lv_pmos ad=0.2128p pd=1.5u as=0.2128p ps=1.5u w=1.12u l=0.13u
X1902 VGND.t1507 VPWR.t2572 VGND.t1507 VGND.t881 sg13_lv_nmos ad=79.8f pd=0.8u as=0 ps=0 w=0.42u l=1u
X1903 VGND.t1792 sg13cmos5l_inv_16_79.A sg13cmos5l_inv_16_79.Y VGND.t380 sg13_lv_nmos ad=0.1406p pd=1.12u as=0.1406p ps=1.12u w=0.74u l=0.13u
X1904 VPWR.t957 sg13cmos5l_inv_16_15.A sg13cmos5l_inv_16_15.Y VPWR.t4 sg13_lv_pmos ad=0.2128p pd=1.5u as=0.2128p ps=1.5u w=1.12u l=0.13u
X1905 VGND.t1820 sg13cmos5l_inv_16_73.Y sg13cmos5l_inv_16_90.Y VGND.t881 sg13_lv_nmos ad=0.1406p pd=1.12u as=0.1406p ps=1.12u w=0.74u l=0.13u
X1906 sg13cmos5l_inv_16_36.A sg13cmos5l_inv_16_43.Y VGND.t146 VGND.t185 sg13_lv_nmos ad=0.1406p pd=1.12u as=0.1406p ps=1.12u w=0.74u l=0.13u
X1907 VGND.t675 sg13cmos5l_inv_16_1.A sg13cmos5l_inv_16_17.A VGND.t677 sg13_lv_nmos ad=0.1406p pd=1.12u as=0.1406p ps=1.12u w=0.74u l=0.13u
X1908 sg13cmos5l_inv_16_17.A sg13cmos5l_inv_16_1.A VPWR.t1071 VPWR.t177 sg13_lv_pmos ad=0.2128p pd=1.5u as=0.3808p ps=2.92u w=1.12u l=0.13u
X1909 sg13cmos5l_inv_16_25.Y sg13cmos5l_inv_16_6.Y VPWR.t844 VPWR.t177 sg13_lv_pmos ad=0.2128p pd=1.5u as=0.3808p ps=2.92u w=1.12u l=0.13u
X1910 sg13cmos5l_inv_16_31.Y sg13cmos5l_inv_16_30.A VGND.t1236 VGND.t1285 sg13_lv_nmos ad=0.1406p pd=1.12u as=0.1406p ps=1.12u w=0.74u l=0.13u
X1911 VPWR.t278 VGND.t291 VPWR.t277 VPWR.t4 sg13_lv_pmos ad=0.34p pd=2.68u as=0 ps=0 w=1u l=1u
X1912 VPWR.t939 sg13cmos5l_inv_16_15.A sg13cmos5l_inv_16_13.Y VPWR.t0 sg13_lv_pmos ad=0.2128p pd=1.5u as=0.2128p ps=1.5u w=1.12u l=0.13u
X1913 sg13cmos5l_inv_16_52.Y sg13cmos5l_inv_16_56.Y VGND.t1663 VGND.t380 sg13_lv_nmos ad=0.1406p pd=1.12u as=0.1406p ps=1.12u w=0.74u l=0.13u
X1914 VGND.t425 sg13cmos5l_inv_16_27.A sg13cmos5l_inv_16_27.Y VGND.t1621 sg13_lv_nmos ad=0.1406p pd=1.12u as=0.1406p ps=1.12u w=0.74u l=0.13u
X1915 sg13cmos5l_inv_16_22.Y sg13cmos5l_inv_16_20.A VGND.t375 VGND.t437 sg13_lv_nmos ad=0.1406p pd=1.12u as=0.1406p ps=1.12u w=0.74u l=0.13u
X1916 VPWR.t233 VGND.t2142 VPWR.t233 VPWR.t177 sg13_lv_pmos ad=0.19p pd=1.38u as=0 ps=0 w=1u l=1u
X1917 VGND.t101 VPWR.t2471 VGND.t2117 VGND.t2116 sg13_lv_nmos ad=79.8f pd=0.8u as=0 ps=0 w=0.42u l=1u
X1918 sg13cmos5l_inv_16_20.Y sg13cmos5l_inv_16_20.A VGND.t375 VGND.t464 sg13_lv_nmos ad=0.1406p pd=1.12u as=0.1406p ps=1.12u w=0.74u l=0.13u
X1919 sg13cmos5l_inv_16_9.Y sg13cmos5l_inv_16_9.A VPWR.t1155 VPWR.t4 sg13_lv_pmos ad=0.2128p pd=1.5u as=0.2128p ps=1.5u w=1.12u l=0.13u
X1920 VPWR.t165 VGND.t96 VPWR.t164 VPWR.t4 sg13_lv_pmos ad=0.19p pd=1.38u as=0 ps=0 w=1u l=1u
X1921 VPWR.t329 VGND.t1419 VPWR.t329 VPWR.t177 sg13_lv_pmos ad=0.34p pd=2.68u as=0 ps=0 w=1u l=1u
X1922 sg13cmos5l_inv_16_17.A sg13cmos5l_inv_16_1.A VGND.t653 VGND.t652 sg13_lv_nmos ad=0.1406p pd=1.12u as=0.2516p ps=2.16u w=0.74u l=0.13u
X1923 sg13cmos5l_inv_16_110.Y sg13cmos5l_inv_16_5.Y VGND.t637 VGND.t644 sg13_lv_nmos ad=0.1406p pd=1.12u as=0.1406p ps=1.12u w=0.74u l=0.13u
X1924 sg13cmos5l_inv_16_15.A sg13cmos5l_inv_16_23.Y VGND.t45 VGND.t53 sg13_lv_nmos ad=0.1406p pd=1.12u as=0.1406p ps=1.12u w=0.74u l=0.13u
X1925 sg13cmos5l_inv_16_73.Y sg13cmos5l_inv_16_73.A VPWR.t1883 VPWR.t16 sg13_lv_pmos ad=0.2128p pd=1.5u as=0.2128p ps=1.5u w=1.12u l=0.13u
X1926 sg13cmos5l_inv_16_47.Y sg13cmos5l_inv_16_47.A VGND.t15 VGND.t2224 sg13_lv_nmos ad=0.1406p pd=1.12u as=0.1406p ps=1.12u w=0.74u l=0.13u
X1927 VPWR.t855 VGND.t1143 VPWR.t854 VPWR.t16 sg13_lv_pmos ad=0.34p pd=2.68u as=0 ps=0 w=1u l=1u
X1928 VPWR.t1812 sg13cmos5l_inv_8_1.A sg13cmos5l_inv_8_1.Y VPWR.t177 sg13_lv_pmos ad=0.2128p pd=1.5u as=0.2128p ps=1.5u w=1.12u l=0.13u
X1929 sg13cmos5l_inv_16_79.A sg13cmos5l_inv_16_81.Y VPWR.t1456 VPWR.t16 sg13_lv_pmos ad=0.2128p pd=1.5u as=0.2128p ps=1.5u w=1.12u l=0.13u
X1930 VGND.t773 sg13cmos5l_inv_16_99.A sg13cmos5l_inv_16_99.Y VGND.t787 sg13_lv_nmos ad=0.1406p pd=1.12u as=0.1406p ps=1.12u w=0.74u l=0.13u
X1931 VPWR.t506 sg13cmos5l_inv_16_23.Y sg13cmos5l_inv_16_14.A VPWR.t0 sg13_lv_pmos ad=0.2128p pd=1.5u as=0.2128p ps=1.5u w=1.12u l=0.13u
X1932 sg13cmos5l_inv_16_15.Y sg13cmos5l_inv_16_15.A VPWR.t953 VPWR.t4 sg13_lv_pmos ad=0.2128p pd=1.5u as=0.2128p ps=1.5u w=1.12u l=0.13u
X1933 VPWR.t1318 sg13cmos5l_inv_16_69.Y sg13cmos5l_inv_16_58.Y VPWR.t9 sg13_lv_pmos ad=0.2128p pd=1.5u as=0.2128p ps=1.5u w=1.12u l=0.13u
X1934 VGND.t2132 VPWR.t272 VGND.t125 VGND.t2131 sg13_lv_nmos ad=0.1428p pd=1.52u as=0 ps=0 w=0.42u l=1u
X1935 sg13cmos5l_inv_16_17.Y sg13cmos5l_inv_16_17.A VGND.t111 VGND.t116 sg13_lv_nmos ad=0.1406p pd=1.12u as=0.1406p ps=1.12u w=0.74u l=0.13u
X1936 sg13cmos5l_inv_16_104.Y sg13cmos5l_inv_16_14.A VGND.t122 VGND.t470 sg13_lv_nmos ad=0.1406p pd=1.12u as=0.1406p ps=1.12u w=0.74u l=0.13u
X1937 VPWR.t232 VGND.t1423 VPWR.t231 VPWR.t177 sg13_lv_pmos ad=0.34p pd=2.68u as=0 ps=0 w=1u l=1u
X1938 VPWR.t1498 sg13cmos5l_inv_16_84.A sg13cmos5l_inv_16_84.Y VPWR.t9 sg13_lv_pmos ad=0.2128p pd=1.5u as=0.2128p ps=1.5u w=1.12u l=0.13u
X1939 VGND.t898 sg13cmos5l_inv_16_94.A sg13cmos5l_inv_16_76.A VGND.t881 sg13_lv_nmos ad=0.1406p pd=1.12u as=0.1406p ps=1.12u w=0.74u l=0.13u
X1940 VPWR.t211 VGND.t122 VPWR.t210 VPWR.t0 sg13_lv_pmos ad=0.34p pd=2.68u as=0 ps=0 w=1u l=1u
X1941 VPWR.t98 VGND.t1965 VPWR.t92 VPWR.t16 sg13_lv_pmos ad=0.19p pd=1.38u as=0 ps=0 w=1u l=1u
X1942 sg13cmos5l_inv_2_7.Y sg13cmos5l_inv_1_3.Y VPWR.t1599 VPWR.t0 sg13_lv_pmos ad=0.2128p pd=1.5u as=0.3864p ps=2.93u w=1.12u l=0.13u
X1943 VPWR.t707 sg13cmos5l_inv_16_29.A sg13cmos5l_inv_16_29.Y VPWR.t177 sg13_lv_pmos ad=0.2128p pd=1.5u as=0.2128p ps=1.5u w=1.12u l=0.13u
X1944 sg13cmos5l_inv_16_47.A sg13cmos5l_inv_16_46.A VPWR.t2117 VPWR.t16 sg13_lv_pmos ad=0.2128p pd=1.5u as=0.2128p ps=1.5u w=1.12u l=0.13u
X1945 sg13cmos5l_and2_1_3.B a_2920_2420# VGND.t82 VGND.t81 sg13_lv_nmos ad=0.2886p pd=2.26u as=0.14875p ps=1.16u w=0.74u l=0.13u
X1946 VGND.t45 sg13cmos5l_inv_16_23.Y sg13cmos5l_inv_16_15.A VGND.t46 sg13_lv_nmos ad=0.1406p pd=1.12u as=0.1406p ps=1.12u w=0.74u l=0.13u
X1947 sg13cmos5l_inv_16_35.Y sg13cmos5l_inv_16_29.A VPWR.t1114 VPWR.t0 sg13_lv_pmos ad=0.2128p pd=1.5u as=0.2128p ps=1.5u w=1.12u l=0.13u
X1948 VGND.t111 sg13cmos5l_inv_16_17.A sg13cmos5l_inv_16_17.Y VGND.t110 sg13_lv_nmos ad=0.1406p pd=1.12u as=0.1406p ps=1.12u w=0.74u l=0.13u
X1949 VGND.t637 sg13cmos5l_inv_16_5.Y sg13cmos5l_inv_16_110.Y VGND.t641 sg13_lv_nmos ad=0.1406p pd=1.12u as=0.1406p ps=1.12u w=0.74u l=0.13u
X1950 VGND.t3 sg13cmos5l_inv_16_37.A sg13cmos5l_inv_16_37.Y VGND.t23 sg13_lv_nmos ad=0.1406p pd=1.12u as=0.1406p ps=1.12u w=0.74u l=0.13u
X1951 sg13cmos5l_inv_16_53.Y sg13cmos5l_inv_16_53.A VGND.t1680 VGND.t380 sg13_lv_nmos ad=0.1406p pd=1.12u as=0.1406p ps=1.12u w=0.74u l=0.13u
X1952 VPWR.t1137 sg13cmos5l_inv_16_9.A sg13cmos5l_inv_16_10.Y VPWR.t0 sg13_lv_pmos ad=0.2128p pd=1.5u as=0.2128p ps=1.5u w=1.12u l=0.13u
X1953 sg13cmos5l_inv_16_61.Y sg13cmos5l_inv_16_61.A VPWR.t1584 VPWR.t9 sg13_lv_pmos ad=0.2128p pd=1.5u as=0.2128p ps=1.5u w=1.12u l=0.13u
X1954 VGND.t1029 VPWR.t2583 VGND.t1029 VGND.t881 sg13_lv_nmos ad=79.8f pd=0.8u as=0 ps=0 w=0.42u l=1u
X1955 sg13cmos5l_inv_16_14.A sg13cmos5l_inv_16_23.Y VPWR.t503 VPWR.t0 sg13_lv_pmos ad=0.2128p pd=1.5u as=0.4368p ps=3.02u w=1.12u l=0.13u
X1956 sg13cmos5l_inv_16_30.Y sg13cmos5l_inv_16_30.A VGND.t343 VGND.t1306 sg13_lv_nmos ad=0.1406p pd=1.12u as=0.1406p ps=1.12u w=0.74u l=0.13u
X1957 VPWR.t951 sg13cmos5l_inv_16_15.A sg13cmos5l_inv_16_15.Y VPWR.t4 sg13_lv_pmos ad=0.2128p pd=1.5u as=0.2128p ps=1.5u w=1.12u l=0.13u
X1958 sg13cmos5l_inv_16_58.Y sg13cmos5l_inv_16_69.Y VPWR.t1314 VPWR.t9 sg13_lv_pmos ad=0.2128p pd=1.5u as=0.2128p ps=1.5u w=1.12u l=0.13u
X1959 VGND.t898 sg13cmos5l_inv_16_88.A sg13cmos5l_inv_16_94.A VGND.t881 sg13_lv_nmos ad=0.2516p pd=2.16u as=0.1406p ps=1.12u w=0.74u l=0.13u
X1960 sg13cmos5l_inv_16_47.A sg13cmos5l_inv_16_46.A VGND.t1718 VGND.t380 sg13_lv_nmos ad=0.1406p pd=1.12u as=0.1406p ps=1.12u w=0.74u l=0.13u
X1961 sg13cmos5l_inv_16_79.Y sg13cmos5l_inv_16_79.A VPWR.t2162 VPWR.t16 sg13_lv_pmos ad=0.2128p pd=1.5u as=0.2128p ps=1.5u w=1.12u l=0.13u
X1962 sg13cmos5l_inv_16_36.A sg13cmos5l_inv_16_43.Y VGND.t146 VGND.t181 sg13_lv_nmos ad=0.1406p pd=1.12u as=0.1406p ps=1.12u w=0.74u l=0.13u
X1963 VPWR.t996 sg13cmos5l_inv_16_8.Y sg13cmos5l_inv_16_9.A VPWR.t0 sg13_lv_pmos ad=0.2128p pd=1.5u as=0.2128p ps=1.5u w=1.12u l=0.13u
X1964 sg13cmos5l_inv_16_44.Y sg13cmos5l_inv_16_44.A VGND.t198 VGND.t208 sg13_lv_nmos ad=0.1406p pd=1.12u as=0.1406p ps=1.12u w=0.74u l=0.13u
X1965 sg13cmos5l_inv_16_76.A sg13cmos5l_inv_16_94.A VGND.t1507 VGND.t881 sg13_lv_nmos ad=0.1406p pd=1.12u as=0.1406p ps=1.12u w=0.74u l=0.13u
X1966 sg13cmos5l_inv_16_47.Y sg13cmos5l_inv_16_47.A VPWR.t2316 VPWR.t25 sg13_lv_pmos ad=0.2128p pd=1.5u as=0.2128p ps=1.5u w=1.12u l=0.13u
X1967 sg13cmos5l_inv_16_91.Y sg13cmos5l_inv_16_79.A VPWR.t2143 VPWR.t16 sg13_lv_pmos ad=0.2128p pd=1.5u as=0.3808p ps=2.92u w=1.12u l=0.13u
X1968 VPWR.t2115 sg13cmos5l_inv_16_46.A sg13cmos5l_inv_16_47.A VPWR.t16 sg13_lv_pmos ad=0.2128p pd=1.5u as=0.2128p ps=1.5u w=1.12u l=0.13u
X1969 sg13cmos5l_inv_16_51.Y sg13cmos5l_inv_16_99.A VGND.t773 VGND.t772 sg13_lv_nmos ad=0.1406p pd=1.12u as=0.2516p ps=2.16u w=0.74u l=0.13u
X1970 VPWR.t880 sg13cmos5l_inv_16_20.A sg13cmos5l_inv_16_22.Y VPWR.t0 sg13_lv_pmos ad=0.2128p pd=1.5u as=0.2128p ps=1.5u w=1.12u l=0.13u
X1971 VGND.t1715 sg13cmos5l_inv_16_47.A sg13cmos5l_inv_16_45.Y VGND.t380 sg13_lv_nmos ad=0.1406p pd=1.12u as=0.1406p ps=1.12u w=0.74u l=0.13u
X1972 sg13cmos5l_inv_16_34.Y sg13cmos5l_inv_16_41.A VPWR.t655 VPWR.t0 sg13_lv_pmos ad=0.2128p pd=1.5u as=0.3808p ps=2.92u w=1.12u l=0.13u
X1973 VGND.t353 VPWR.t2531 VGND.t353 VGND.t2009 sg13_lv_nmos ad=0.1428p pd=1.52u as=0 ps=0 w=0.42u l=1u
X1974 VPWR.t437 VGND.t1243 VPWR.t434 VPWR.t4 sg13_lv_pmos ad=0.19p pd=1.38u as=0 ps=0 w=1u l=1u
X1975 sg13cmos5l_inv_16_20.Y sg13cmos5l_inv_16_20.A VGND.t375 VGND.t460 sg13_lv_nmos ad=0.1406p pd=1.12u as=0.1406p ps=1.12u w=0.74u l=0.13u
X1976 sg13cmos5l_inv_16_9.Y sg13cmos5l_inv_16_9.A VPWR.t1150 VPWR.t4 sg13_lv_pmos ad=0.2128p pd=1.5u as=0.3808p ps=2.92u w=1.12u l=0.13u
X1977 VPWR.t373 VGND.t217 VPWR.t8 VPWR.t4 sg13_lv_pmos ad=0.19p pd=1.38u as=0 ps=0 w=1u l=1u
X1978 VGND.t1680 sg13cmos5l_inv_16_53.A sg13cmos5l_inv_16_53.Y VGND.t380 sg13_lv_nmos ad=0.1406p pd=1.12u as=0.1406p ps=1.12u w=0.74u l=0.13u
X1979 sg13cmos5l_inv_16_103.Y sg13cmos5l_inv_16_103.A VPWR.t1611 VPWR.t0 sg13_lv_pmos ad=0.2128p pd=1.5u as=0.2128p ps=1.5u w=1.12u l=0.13u
X1980 sg13cmos5l_inv_4_0.Y sg13cmos5l_inv_4_0.A VPWR.t1956 VPWR.t177 sg13_lv_pmos ad=0.2128p pd=1.5u as=0.3808p ps=2.92u w=1.12u l=0.13u
X1981 sg13cmos5l_inv_2_1.Y sg13cmos5l_inv_1_0.Y VGND.t310 VGND.t1466 sg13_lv_nmos ad=0.1406p pd=1.12u as=0.2516p ps=2.16u w=0.74u l=0.13u
X1982 sg13cmos5l_inv_16_111.Y sg13cmos5l_inv_16_111.A VPWR.t1945 VPWR.t16 sg13_lv_pmos ad=0.2128p pd=1.5u as=0.2128p ps=1.5u w=1.12u l=0.13u
X1983 VGND.t1718 sg13cmos5l_inv_16_46.A sg13cmos5l_inv_16_47.A VGND.t380 sg13_lv_nmos ad=0.1406p pd=1.12u as=0.1406p ps=1.12u w=0.74u l=0.13u
X1984 sg13cmos5l_inv_16_30.Y sg13cmos5l_inv_16_30.A VPWR.t178 VPWR.t177 sg13_lv_pmos ad=0.2128p pd=1.5u as=0.2128p ps=1.5u w=1.12u l=0.13u
X1985 sg13cmos5l_inv_16_6.A sg13cmos5l_inv_16_4.Y VPWR.t749 VPWR.t4 sg13_lv_pmos ad=0.2128p pd=1.5u as=0.2128p ps=1.5u w=1.12u l=0.13u
X1986 VPWR.t57 VGND.t1067 VPWR.t56 VPWR.t9 sg13_lv_pmos ad=0.34p pd=2.68u as=0 ps=0 w=1u l=1u
X1987 sg13cmos5l_inv_16_94.A sg13cmos5l_inv_16_88.A VGND.t898 VGND.t881 sg13_lv_nmos ad=0.1406p pd=1.12u as=0.1406p ps=1.12u w=0.74u l=0.13u
X1988 sg13cmos5l_inv_16_45.Y sg13cmos5l_inv_16_47.A VPWR.t2291 VPWR.t16 sg13_lv_pmos ad=0.2128p pd=1.5u as=0.2128p ps=1.5u w=1.12u l=0.13u
X1989 sg13cmos5l_and2_1_1.X a_20397_1980# VPWR.t689 VPWR.t177 sg13_lv_pmos ad=0.3808p pd=2.92u as=0.1918p ps=1.5u w=1.12u l=0.13u
X1990 VGND.t1147 sg13cmos5l_inv_16_48.A sg13cmos5l_inv_16_109.Y VGND.t881 sg13_lv_nmos ad=0.1406p pd=1.12u as=0.1406p ps=1.12u w=0.74u l=0.13u
X1991 VGND.t1507 sg13cmos5l_inv_16_94.A sg13cmos5l_inv_16_76.A VGND.t881 sg13_lv_nmos ad=0.1406p pd=1.12u as=0.1406p ps=1.12u w=0.74u l=0.13u
X1992 VGND.t1680 sg13cmos5l_inv_16_101.Y sg13cmos5l_inv_16_54.Y VGND.t380 sg13_lv_nmos ad=0.1406p pd=1.12u as=0.1406p ps=1.12u w=0.74u l=0.13u
X1993 VGND.t226 sg13cmos5l_inv_8_3.Y sg13cmos5l_inv_16_41.A VGND.t817 sg13_lv_nmos ad=0.1406p pd=1.12u as=0.1406p ps=1.12u w=0.74u l=0.13u
X1994 VPWR.t2314 sg13cmos5l_inv_16_47.A sg13cmos5l_inv_16_47.Y VPWR.t25 sg13_lv_pmos ad=0.2128p pd=1.5u as=0.2128p ps=1.5u w=1.12u l=0.13u
X1995 sg13cmos5l_inv_16_87.A sg13cmos5l_inv_16_73.A VGND.t1469 VGND.t1477 sg13_lv_nmos ad=0.1406p pd=1.12u as=0.1406p ps=1.12u w=0.74u l=0.13u
X1996 a_14636_834# en[3] VPWR.t1001 VPWR.t177 sg13_lv_pmos ad=0.2856p pd=2.36u as=0.2114p ps=1.54u w=0.84u l=0.13u
X1997 sg13cmos5l_inv_16_59.Y sg13cmos5l_inv_16_61.A VPWR.t1571 VPWR.t9 sg13_lv_pmos ad=0.2128p pd=1.5u as=0.2128p ps=1.5u w=1.12u l=0.13u
X1998 sg13cmos5l_inv_16_45.Y sg13cmos5l_inv_16_47.A VGND.t1715 VGND.t380 sg13_lv_nmos ad=0.1406p pd=1.12u as=0.1406p ps=1.12u w=0.74u l=0.13u
X1999 VGND.t291 sg13cmos5l_inv_16_11.A sg13cmos5l_inv_16_103.A VGND.t365 sg13_lv_nmos ad=0.1406p pd=1.12u as=0.1406p ps=1.12u w=0.74u l=0.13u
X2000 sg13cmos5l_inv_16_108.Y sg13cmos5l_inv_16_6.Y VGND.t635 VGND.t2355 sg13_lv_nmos ad=0.1406p pd=1.12u as=0.1406p ps=1.12u w=0.74u l=0.13u
X2001 VGND.t1147 sg13cmos5l_inv_16_109.Y sg13cmos5l_inv_16_111.A VGND.t881 sg13_lv_nmos ad=0.1406p pd=1.12u as=0.1406p ps=1.12u w=0.74u l=0.13u
X2002 VGND.t472 sg13cmos5l_inv_16_77.A sg13cmos5l_inv_16_77.Y VGND.t2175 sg13_lv_nmos ad=0.1406p pd=1.12u as=0.1406p ps=1.12u w=0.74u l=0.13u
X2003 sg13cmos5l_inv_16_100.Y sg13cmos5l_inv_16_36.A VPWR.t570 VPWR.t0 sg13_lv_pmos ad=0.2128p pd=1.5u as=0.2128p ps=1.5u w=1.12u l=0.13u
X2004 sg13cmos5l_inv_16_17.A sg13cmos5l_inv_16_1.A VGND.t675 VGND.t678 sg13_lv_nmos ad=0.1406p pd=1.12u as=0.1406p ps=1.12u w=0.74u l=0.13u
X2005 sg13cmos5l_inv_16_98.Y sg13cmos5l_inv_16_111.A VPWR.t1933 VPWR.t9 sg13_lv_pmos ad=0.2128p pd=1.5u as=0.2128p ps=1.5u w=1.12u l=0.13u
X2006 sg13cmos5l_inv_16_67.A sg13cmos5l_inv_16_109.Y VGND.t1132 VGND.t881 sg13_lv_nmos ad=0.1406p pd=1.12u as=0.2516p ps=2.16u w=0.74u l=0.13u
X2007 VPWR.t1943 sg13cmos5l_inv_16_111.A sg13cmos5l_inv_16_111.Y VPWR.t16 sg13_lv_pmos ad=0.2128p pd=1.5u as=0.2128p ps=1.5u w=1.12u l=0.13u
X2008 sg13cmos5l_inv_16_77.A sg13cmos5l_inv_16_76.A VGND.t1970 VGND.t380 sg13_lv_nmos ad=0.1406p pd=1.12u as=0.1406p ps=1.12u w=0.74u l=0.13u
X2009 sg13cmos5l_inv_16_56.Y sg13cmos5l_inv_8_4.Y VPWR.t2368 VPWR.t25 sg13_lv_pmos ad=0.2128p pd=1.5u as=0.2128p ps=1.5u w=1.12u l=0.13u
X2010 VPWR.t865 sg13cmos5l_inv_1_7.Y sg13cmos5l_inv_2_6.Y VPWR.t0 sg13_lv_pmos ad=0.3864p pd=2.93u as=0.2128p ps=1.5u w=1.12u l=0.13u
X2011 VPWR.t1081 sg13cmos5l_inv_16_1.A sg13cmos5l_inv_16_2.A VPWR.t4 sg13_lv_pmos ad=0.2128p pd=1.5u as=0.2128p ps=1.5u w=1.12u l=0.13u
X2012 sg13cmos5l_inv_16_71.Y sg13cmos5l_inv_16_56.Y VPWR.t2038 VPWR.t16 sg13_lv_pmos ad=0.2128p pd=1.5u as=0.2128p ps=1.5u w=1.12u l=0.13u
X2013 sg13cmos5l_inv_16_41.A sg13cmos5l_inv_8_3.Y VGND.t221 VGND.t814 sg13_lv_nmos ad=0.1406p pd=1.12u as=0.1406p ps=1.12u w=0.74u l=0.13u
X2014 VGND.t672 sg13cmos5l_inv_16_1.A sg13cmos5l_inv_16_17.A VGND.t671 sg13_lv_nmos ad=0.1406p pd=1.12u as=0.1406p ps=1.12u w=0.74u l=0.13u
X2015 VGND.t1243 sg13cmos5l_inv_16_27.Y sg13cmos5l_inv_16_26.A VGND.t1270 sg13_lv_nmos ad=0.1406p pd=1.12u as=0.1406p ps=1.12u w=0.74u l=0.13u
X2016 VPWR.t1569 sg13cmos5l_inv_16_61.A sg13cmos5l_inv_16_59.Y VPWR.t9 sg13_lv_pmos ad=0.2128p pd=1.5u as=0.2128p ps=1.5u w=1.12u l=0.13u
X2017 VGND.t1469 sg13cmos5l_inv_16_73.A sg13cmos5l_inv_16_87.A VGND.t1474 sg13_lv_nmos ad=0.1406p pd=1.12u as=0.1406p ps=1.12u w=0.74u l=0.13u
X2018 VGND.t353 sg13cmos5l_inv_16_11.A sg13cmos5l_inv_16_105.A VGND.t352 sg13_lv_nmos ad=0.1406p pd=1.12u as=0.1406p ps=1.12u w=0.74u l=0.13u
X2019 VPWR.t2419 sg13cmos5l_inv_8_0.Y sg13cmos5l_inv_16_0.A VPWR.t177 sg13_lv_pmos ad=0.2128p pd=1.5u as=0.2128p ps=1.5u w=1.12u l=0.13u
X2020 a_6957_3492# sg13cmos5l_buf_1_5.X VPWR.t519 VPWR.t4 sg13_lv_pmos ad=0.1596p pd=1.22u as=0.2856p ps=2.36u w=0.84u l=0.13u
X2021 VGND.t756 sg13cmos5l_inv_16_111.A sg13cmos5l_inv_16_111.Y VGND.t380 sg13_lv_nmos ad=0.1406p pd=1.12u as=0.1406p ps=1.12u w=0.74u l=0.13u
X2022 VGND.t635 sg13cmos5l_inv_16_6.Y sg13cmos5l_inv_16_108.Y VGND.t2352 sg13_lv_nmos ad=0.1406p pd=1.12u as=0.1406p ps=1.12u w=0.74u l=0.13u
X2023 VPWR.t1717 sg13cmos5l_inv_16_26.A sg13cmos5l_inv_16_30.A VPWR.t4 sg13_lv_pmos ad=0.2128p pd=1.5u as=0.2128p ps=1.5u w=1.12u l=0.13u
X2024 sg13cmos5l_inv_16_68.Y sg13cmos5l_inv_16_68.A VGND.t882 VGND.t881 sg13_lv_nmos ad=0.1406p pd=1.12u as=0.1406p ps=1.12u w=0.74u l=0.13u
X2025 VGND.t756 sg13cmos5l_inv_8_7.Y sg13cmos5l_inv_16_48.A VGND.t380 sg13_lv_nmos ad=0.1406p pd=1.12u as=0.1406p ps=1.12u w=0.74u l=0.13u
X2026 VGND.t326 VPWR.t2481 VGND.t326 VGND.t2095 sg13_lv_nmos ad=79.8f pd=0.8u as=0 ps=0 w=0.42u l=1u
X2027 sg13cmos5l_inv_16_31.Y sg13cmos5l_inv_16_30.A VPWR.t178 VPWR.t177 sg13_lv_pmos ad=0.2128p pd=1.5u as=0.2128p ps=1.5u w=1.12u l=0.13u
X2028 VGND.t1245 sg13cmos5l_inv_16_6.Y sg13cmos5l_inv_16_25.Y VGND.t2338 sg13_lv_nmos ad=0.1406p pd=1.12u as=0.1406p ps=1.12u w=0.74u l=0.13u
X2029 sg13cmos5l_inv_16_2.A sg13cmos5l_inv_16_1.A VPWR.t1077 VPWR.t4 sg13_lv_pmos ad=0.2128p pd=1.5u as=0.2128p ps=1.5u w=1.12u l=0.13u
X2030 VGND.t916 VPWR.t2606 VGND.t1873 VGND.t1872 sg13_lv_nmos ad=79.8f pd=0.8u as=0 ps=0 w=0.42u l=1u
X2031 VGND.t1718 sg13cmos5l_inv_16_48.A sg13cmos5l_inv_16_46.A VGND.t380 sg13_lv_nmos ad=0.2516p pd=2.16u as=0.1406p ps=1.12u w=0.74u l=0.13u
X2032 VPWR.t1190 sg13cmos5l_inv_16_99.A sg13cmos5l_inv_16_51.Y VPWR.t25 sg13_lv_pmos ad=0.2128p pd=1.5u as=0.2128p ps=1.5u w=1.12u l=0.13u
X2033 VGND.t655 sg13cmos5l_inv_16_1.A sg13cmos5l_inv_16_2.A VGND.t670 sg13_lv_nmos ad=0.2516p pd=2.16u as=0.1406p ps=1.12u w=0.74u l=0.13u
X2034 sg13cmos5l_inv_16_96.Y sg13cmos5l_inv_16_96.A VGND.t545 VGND.t947 sg13_lv_nmos ad=0.1406p pd=1.12u as=0.1406p ps=1.12u w=0.74u l=0.13u
X2035 sg13cmos5l_inv_16_23.Y sg13cmos5l_inv_16_0.A VGND.t827 VGND.t833 sg13_lv_nmos ad=0.1406p pd=1.12u as=0.1406p ps=1.12u w=0.74u l=0.13u
X2036 sg13cmos5l_inv_16_26.A sg13cmos5l_inv_16_27.Y VGND.t1243 VGND.t1267 sg13_lv_nmos ad=0.1406p pd=1.12u as=0.1406p ps=1.12u w=0.74u l=0.13u
X2037 VGND.t2117 VPWR.t2470 VGND.t1432 VGND.t2119 sg13_lv_nmos ad=79.8f pd=0.8u as=0 ps=0 w=0.42u l=1u
X2038 VPWR.t2310 sg13cmos5l_inv_16_47.A sg13cmos5l_inv_16_47.Y VPWR.t25 sg13_lv_pmos ad=0.2128p pd=1.5u as=0.2128p ps=1.5u w=1.12u l=0.13u
X2039 sg13cmos5l_inv_16_0.A sg13cmos5l_inv_8_0.Y VPWR.t2415 VPWR.t177 sg13_lv_pmos ad=0.2128p pd=1.5u as=0.2128p ps=1.5u w=1.12u l=0.13u
X2040 VPWR.t442 VGND.t2117 VPWR.t176 VPWR.t4 sg13_lv_pmos ad=0.19p pd=1.38u as=0 ps=0 w=1u l=1u
X2041 VGND.t882 sg13cmos5l_inv_16_71.Y sg13cmos5l_inv_16_68.A VGND.t881 sg13_lv_nmos ad=0.1406p pd=1.12u as=0.1406p ps=1.12u w=0.74u l=0.13u
X2042 sg13cmos5l_inv_16_111.Y sg13cmos5l_inv_16_111.A VGND.t756 VGND.t380 sg13_lv_nmos ad=0.1406p pd=1.12u as=0.1406p ps=1.12u w=0.74u l=0.13u
X2043 VPWR.t329 VGND.t2148 VPWR.t329 VPWR.t177 sg13_lv_pmos ad=0.34p pd=2.68u as=0 ps=0 w=1u l=1u
X2044 VGND.t637 sg13cmos5l_inv_16_5.Y sg13cmos5l_inv_16_110.Y VGND.t636 sg13_lv_nmos ad=0.1406p pd=1.12u as=0.1406p ps=1.12u w=0.74u l=0.13u
X2045 sg13cmos5l_inv_16_30.A sg13cmos5l_inv_16_26.A VPWR.t1713 VPWR.t4 sg13_lv_pmos ad=0.2128p pd=1.5u as=0.2128p ps=1.5u w=1.12u l=0.13u
X2046 VPWR.t2024 sg13cmos5l_inv_16_88.A sg13cmos5l_inv_16_94.A VPWR.t9 sg13_lv_pmos ad=0.2128p pd=1.5u as=0.2128p ps=1.5u w=1.12u l=0.13u
X2047 VPWR.t480 sg13cmos5l_inv_16_30.A sg13cmos5l_inv_16_31.Y VPWR.t177 sg13_lv_pmos ad=0.2128p pd=1.5u as=0.2128p ps=1.5u w=1.12u l=0.13u
X2048 VPWR.t1226 sg13cmos5l_inv_8_3.Y sg13cmos5l_inv_16_41.A VPWR.t4 sg13_lv_pmos ad=0.2128p pd=1.5u as=0.2128p ps=1.5u w=1.12u l=0.13u
X2049 sg13cmos5l_inv_16_87.A sg13cmos5l_inv_16_73.A VPWR.t1855 VPWR.t9 sg13_lv_pmos ad=0.2128p pd=1.5u as=0.2128p ps=1.5u w=1.12u l=0.13u
X2050 sg13cmos5l_inv_16_25.Y sg13cmos5l_inv_16_6.Y VGND.t1245 VGND.t2335 sg13_lv_nmos ad=0.1406p pd=1.12u as=0.1406p ps=1.12u w=0.74u l=0.13u
X2051 VPWR.t1075 sg13cmos5l_inv_16_1.A sg13cmos5l_inv_16_2.A VPWR.t4 sg13_lv_pmos ad=0.2128p pd=1.5u as=0.2128p ps=1.5u w=1.12u l=0.13u
X2052 sg13cmos5l_inv_16_46.A sg13cmos5l_inv_16_48.A VGND.t1718 VGND.t380 sg13_lv_nmos ad=0.1406p pd=1.12u as=0.1406p ps=1.12u w=0.74u l=0.13u
X2053 VGND.t1970 VPWR.t2540 VGND.t1970 VGND.t380 sg13_lv_nmos ad=0.1428p pd=1.52u as=0 ps=0 w=0.42u l=1u
X2054 sg13cmos5l_inv_16_2.A sg13cmos5l_inv_16_1.A VGND.t655 VGND.t667 sg13_lv_nmos ad=0.1406p pd=1.12u as=0.1406p ps=1.12u w=0.74u l=0.13u
X2055 VGND.t1164 sg13cmos5l_inv_16_52.Y sg13cmos5l_inv_16_53.A VGND.t881 sg13_lv_nmos ad=0.1406p pd=1.12u as=0.1406p ps=1.12u w=0.74u l=0.13u
X2056 VGND.t545 sg13cmos5l_inv_16_96.A sg13cmos5l_inv_16_96.Y VGND.t944 sg13_lv_nmos ad=0.1406p pd=1.12u as=0.1406p ps=1.12u w=0.74u l=0.13u
X2057 sg13cmos5l_inv_16_77.Y sg13cmos5l_inv_16_77.A VPWR.t2264 VPWR.t25 sg13_lv_pmos ad=0.2128p pd=1.5u as=0.2128p ps=1.5u w=1.12u l=0.13u
X2058 sg13cmos5l_inv_16_111.A sg13cmos5l_inv_16_109.Y VPWR.t1557 VPWR.t9 sg13_lv_pmos ad=0.2128p pd=1.5u as=0.2128p ps=1.5u w=1.12u l=0.13u
X2059 VGND.t432 sg13cmos5l_inv_4_4.Y sg13cmos5l_inv_8_7.Y VGND.t629 sg13_lv_nmos ad=0.1406p pd=1.12u as=0.1406p ps=1.12u w=0.74u l=0.13u
X2060 sg13cmos5l_inv_16_85.Y sg13cmos5l_inv_16_84.A VGND.t1067 VGND.t1081 sg13_lv_nmos ad=0.1406p pd=1.12u as=0.1406p ps=1.12u w=0.74u l=0.13u
X2061 sg13cmos5l_inv_16_91.Y sg13cmos5l_inv_16_79.A VGND.t1083 VGND.t881 sg13_lv_nmos ad=0.1406p pd=1.12u as=0.1406p ps=1.12u w=0.74u l=0.13u
X2062 VPWR.t1538 sg13cmos5l_inv_16_109.Y sg13cmos5l_inv_16_67.A VPWR.t9 sg13_lv_pmos ad=0.2128p pd=1.5u as=0.2128p ps=1.5u w=1.12u l=0.13u
X2063 VGND.t345 sg13cmos5l_inv_16_11.A sg13cmos5l_inv_16_105.A VGND.t348 sg13_lv_nmos ad=0.1406p pd=1.12u as=0.1406p ps=1.12u w=0.74u l=0.13u
X2064 VPWR.t379 VGND.t432 VPWR.t378 VPWR.t0 sg13_lv_pmos ad=0.34p pd=2.68u as=0 ps=0 w=1u l=1u
X2065 sg13cmos5l_inv_16_103.Y sg13cmos5l_inv_16_103.A VPWR.t1607 VPWR.t0 sg13_lv_pmos ad=0.2128p pd=1.5u as=0.2128p ps=1.5u w=1.12u l=0.13u
X2066 sg13cmos5l_inv_16_29.A sg13cmos5l_inv_16_28.A VGND.t198 VGND.t208 sg13_lv_nmos ad=0.1406p pd=1.12u as=0.1406p ps=1.12u w=0.74u l=0.13u
X2067 VPWR.t246 sg13cmos5l_inv_16_6.A sg13cmos5l_inv_16_6.Y VPWR.t177 sg13_lv_pmos ad=0.2128p pd=1.5u as=0.2128p ps=1.5u w=1.12u l=0.13u
X2068 VGND.t1820 VPWR.t2582 VGND.t1820 VGND.t881 sg13_lv_nmos ad=79.8f pd=0.8u as=0 ps=0 w=0.42u l=1u
X2069 sg13cmos5l_inv_16_68.Y sg13cmos5l_inv_16_68.A VGND.t882 VGND.t881 sg13_lv_nmos ad=0.1406p pd=1.12u as=0.1406p ps=1.12u w=0.74u l=0.13u
X2070 sg13cmos5l_inv_16_76.A sg13cmos5l_inv_16_94.A VPWR.t1920 VPWR.t16 sg13_lv_pmos ad=0.2128p pd=1.5u as=0.2128p ps=1.5u w=1.12u l=0.13u
X2071 VGND.t226 sg13cmos5l_inv_16_41.A sg13cmos5l_inv_16_34.Y VGND.t234 sg13_lv_nmos ad=0.2516p pd=2.16u as=0.1406p ps=1.12u w=0.74u l=0.13u
X2072 sg13cmos5l_inv_16_6.A sg13cmos5l_inv_16_4.Y VPWR.t745 VPWR.t4 sg13_lv_pmos ad=0.2128p pd=1.5u as=0.2128p ps=1.5u w=1.12u l=0.13u
X2073 VPWR.t84 VGND.t1944 VPWR.t83 VPWR.t25 sg13_lv_pmos ad=0.34p pd=2.68u as=0 ps=0 w=1u l=1u
X2074 sg13cmos5l_inv_16_26.Y sg13cmos5l_inv_16_26.A VPWR.t767 VPWR.t177 sg13_lv_pmos ad=0.2128p pd=1.5u as=0.2128p ps=1.5u w=1.12u l=0.13u
X2075 VGND.t198 sg13cmos5l_inv_16_44.A sg13cmos5l_inv_16_44.Y VGND.t201 sg13_lv_nmos ad=0.1406p pd=1.12u as=0.1406p ps=1.12u w=0.74u l=0.13u
X2076 sg13cmos5l_inv_16_105.A sg13cmos5l_inv_16_11.A VPWR.t778 VPWR.t25 sg13_lv_pmos ad=0.2128p pd=1.5u as=0.2128p ps=1.5u w=1.12u l=0.13u
X2077 sg13cmos5l_inv_8_7.Y sg13cmos5l_inv_4_4.Y VGND.t432 VGND.t626 sg13_lv_nmos ad=0.1406p pd=1.12u as=0.2516p ps=2.16u w=0.74u l=0.13u
X2078 sg13cmos5l_inv_16_96.Y sg13cmos5l_inv_16_96.A VGND.t545 VGND.t941 sg13_lv_nmos ad=0.1406p pd=1.12u as=0.1406p ps=1.12u w=0.74u l=0.13u
X2079 VGND.t1083 sg13cmos5l_inv_16_79.A sg13cmos5l_inv_16_91.Y VGND.t881 sg13_lv_nmos ad=0.1406p pd=1.12u as=0.1406p ps=1.12u w=0.74u l=0.13u
X2080 VPWR.t1181 sg13cmos5l_inv_8_7.Y sg13cmos5l_inv_16_48.A VPWR.t25 sg13_lv_pmos ad=0.2128p pd=1.5u as=0.2128p ps=1.5u w=1.12u l=0.13u
X2081 VGND.t20 VPWR.t2524 VGND.t20 VGND.t2021 sg13_lv_nmos ad=79.8f pd=0.8u as=0 ps=0 w=0.42u l=1u
X2082 sg13cmos5l_and2_1_2.X a_3597_916# VPWR.t272 VPWR.t177 sg13_lv_pmos ad=0.3808p pd=2.92u as=0.1918p ps=1.5u w=1.12u l=0.13u
X2083 VPWR.t377 VGND.t217 VPWR.t375 VPWR.t4 sg13_lv_pmos ad=0.19p pd=1.38u as=0 ps=0 w=1u l=1u
X2084 VGND.t1663 sg13cmos5l_inv_16_101.Y sg13cmos5l_inv_16_55.Y VGND.t380 sg13_lv_nmos ad=0.2516p pd=2.16u as=0.1406p ps=1.12u w=0.74u l=0.13u
X2085 VGND.t2045 VPWR.t2509 VGND.t2045 VGND.t2044 sg13_lv_nmos ad=0.1428p pd=1.52u as=0 ps=0 w=0.42u l=1u
X2086 sg13cmos5l_inv_16_6.Y sg13cmos5l_inv_16_6.A VPWR.t246 VPWR.t177 sg13_lv_pmos ad=0.2128p pd=1.5u as=0.2128p ps=1.5u w=1.12u l=0.13u
X2087 sg13cmos5l_inv_16_56.Y sg13cmos5l_inv_8_4.Y VPWR.t2364 VPWR.t25 sg13_lv_pmos ad=0.2128p pd=1.5u as=0.2128p ps=1.5u w=1.12u l=0.13u
X2088 VPWR.t167 VGND.t1882 VPWR.t229 VPWR.t9 sg13_lv_pmos ad=0.19p pd=1.38u as=0 ps=0 w=1u l=1u
X2089 VPWR.t480 sg13cmos5l_inv_16_30.A sg13cmos5l_inv_16_30.Y VPWR.t177 sg13_lv_pmos ad=0.2128p pd=1.5u as=0.2128p ps=1.5u w=1.12u l=0.13u
X2090 VPWR.t743 sg13cmos5l_inv_16_4.Y sg13cmos5l_inv_16_6.A VPWR.t4 sg13_lv_pmos ad=0.2128p pd=1.5u as=0.2128p ps=1.5u w=1.12u l=0.13u
X2091 VGND.t1236 sg13cmos5l_inv_4_2.Y sg13cmos5l_inv_8_3.Y VGND.t1235 sg13_lv_nmos ad=0.1406p pd=1.12u as=0.1406p ps=1.12u w=0.74u l=0.13u
X2092 VPWR.t271 VGND.t1553 VPWR.t270 VPWR.t9 sg13_lv_pmos ad=0.34p pd=2.68u as=0 ps=0 w=1u l=1u
X2093 sg13cmos5l_and2_1_3.X a_5133_916# VGND.t343 VGND.t342 sg13_lv_nmos ad=0.2516p pd=2.16u as=0.1331p ps=1.12u w=0.74u l=0.13u
X2094 VPWR.t767 sg13cmos5l_inv_16_26.A sg13cmos5l_inv_16_26.Y VPWR.t177 sg13_lv_pmos ad=0.2128p pd=1.5u as=0.2128p ps=1.5u w=1.12u l=0.13u
X2095 VPWR.t883 sg13cmos5l_inv_16_20.A sg13cmos5l_inv_16_20.Y VPWR.t4 sg13_lv_pmos ad=0.2128p pd=1.5u as=0.2128p ps=1.5u w=1.12u l=0.13u
X2096 sg13cmos5l_inv_16_93.Y sg13cmos5l_inv_16_87.A VGND.t994 VGND.t1008 sg13_lv_nmos ad=0.1406p pd=1.12u as=0.1406p ps=1.12u w=0.74u l=0.13u
X2097 sg13cmos5l_inv_16_68.A sg13cmos5l_inv_16_71.Y VPWR.t1386 VPWR.t9 sg13_lv_pmos ad=0.2128p pd=1.5u as=0.2128p ps=1.5u w=1.12u l=0.13u
X2098 sg13cmos5l_inv_16_27.Y sg13cmos5l_inv_16_27.A VPWR.t844 VPWR.t177 sg13_lv_pmos ad=0.2128p pd=1.5u as=0.2128p ps=1.5u w=1.12u l=0.13u
X2099 VGND.t773 sg13cmos5l_inv_16_99.A sg13cmos5l_inv_16_51.Y VGND.t787 sg13_lv_nmos ad=0.1406p pd=1.12u as=0.1406p ps=1.12u w=0.74u l=0.13u
X2100 sg13cmos5l_buf_1_12.X a_3592_9192# VPWR.t1673 VPWR.t9 sg13_lv_pmos ad=0.42p pd=2.99u as=0.2114p ps=1.54u w=1.12u l=0.13u
X2101 sg13cmos5l_inv_16_48.A sg13cmos5l_inv_8_7.Y VPWR.t1177 VPWR.t25 sg13_lv_pmos ad=0.2128p pd=1.5u as=0.2128p ps=1.5u w=1.12u l=0.13u
X2102 sg13cmos5l_inv_16_5.Y sg13cmos5l_inv_16_6.A VGND.t637 VGND.t1386 sg13_lv_nmos ad=0.1406p pd=1.12u as=0.2516p ps=2.16u w=0.74u l=0.13u
X2103 sg13cmos5l_inv_2_3.Y sg13cmos5l_inv_1_2.Y VPWR.t272 VPWR.t177 sg13_lv_pmos ad=0.2128p pd=1.5u as=0.3808p ps=2.92u w=1.12u l=0.13u
X2104 VPWR.t337 VGND.t375 VPWR.t331 VPWR.t4 sg13_lv_pmos ad=0.19p pd=1.38u as=0 ps=0 w=1u l=1u
X2105 VPWR.t2205 sg13cmos5l_inv_16_73.Y sg13cmos5l_inv_16_90.Y VPWR.t16 sg13_lv_pmos ad=0.4368p pd=3.02u as=0.2128p ps=1.5u w=1.12u l=0.13u
X2106 sg13cmos5l_inv_16_19.Y sg13cmos5l_inv_16_17.A VGND.t86 VGND.t85 sg13_lv_nmos ad=0.1406p pd=1.12u as=0.2516p ps=2.16u w=0.74u l=0.13u
X2107 VPWR.t1646 sg13cmos5l_inv_16_27.Y sg13cmos5l_inv_16_43.Y VPWR.t4 sg13_lv_pmos ad=0.2128p pd=1.5u as=0.2128p ps=1.5u w=1.12u l=0.13u
X2108 sg13cmos5l_inv_16_46.A sg13cmos5l_inv_16_48.A VPWR.t2102 VPWR.t25 sg13_lv_pmos ad=0.2128p pd=1.5u as=0.2128p ps=1.5u w=1.12u l=0.13u
X2109 sg13cmos5l_inv_16_96.Y sg13cmos5l_inv_16_96.A VPWR.t1350 VPWR.t25 sg13_lv_pmos ad=0.2128p pd=1.5u as=0.2128p ps=1.5u w=1.12u l=0.13u
X2110 sg13cmos5l_inv_16_43.Y sg13cmos5l_inv_16_27.Y VGND.t1245 VGND.t1258 sg13_lv_nmos ad=0.1406p pd=1.12u as=0.1406p ps=1.12u w=0.74u l=0.13u
X2111 VGND.t1083 VPWR.t2586 VGND.t1083 VGND.t881 sg13_lv_nmos ad=0.1428p pd=1.52u as=0 ps=0 w=0.42u l=1u
X2112 sg13cmos5l_inv_8_7.Y sg13cmos5l_inv_4_4.Y VPWR.t1050 VPWR.t25 sg13_lv_pmos ad=0.2128p pd=1.5u as=0.2128p ps=1.5u w=1.12u l=0.13u
X2113 VGND.t122 sg13cmos5l_inv_16_75.A sg13cmos5l_inv_16_75.Y VGND.t400 sg13_lv_nmos ad=0.1406p pd=1.12u as=0.1406p ps=1.12u w=0.74u l=0.13u
X2114 sg13cmos5l_inv_16_103.Y sg13cmos5l_inv_16_103.A VPWR.t1603 VPWR.t0 sg13_lv_pmos ad=0.2128p pd=1.5u as=0.2128p ps=1.5u w=1.12u l=0.13u
X2115 sg13cmos5l_inv_16_61.Y sg13cmos5l_inv_16_61.A VGND.t1164 VGND.t881 sg13_lv_nmos ad=0.1406p pd=1.12u as=0.1406p ps=1.12u w=0.74u l=0.13u
X2116 sg13cmos5l_inv_16_54.Y sg13cmos5l_inv_16_101.Y VGND.t1680 VGND.t380 sg13_lv_nmos ad=0.1406p pd=1.12u as=0.1406p ps=1.12u w=0.74u l=0.13u
X2117 sg13cmos5l_inv_16_55.Y sg13cmos5l_inv_16_101.Y VPWR.t2348 VPWR.t25 sg13_lv_pmos ad=0.2128p pd=1.5u as=0.2128p ps=1.5u w=1.12u l=0.13u
X2118 sg13cmos5l_inv_16_23.Y sg13cmos5l_inv_16_0.A VGND.t827 VGND.t829 sg13_lv_nmos ad=0.1406p pd=1.12u as=0.1406p ps=1.12u w=0.74u l=0.13u
X2119 VPWR.t1776 sg13cmos5l_inv_2_2.Y sg13cmos5l_inv_8_2.A VPWR.t4 sg13_lv_pmos ad=0.3808p pd=2.92u as=0.2128p ps=1.5u w=1.12u l=0.13u
X2120 sg13cmos5l_inv_16_105.A sg13cmos5l_inv_16_11.A VPWR.t774 VPWR.t25 sg13_lv_pmos ad=0.2128p pd=1.5u as=0.2128p ps=1.5u w=1.12u l=0.13u
X2121 VGND.t655 sg13cmos5l_inv_16_2.A sg13cmos5l_inv_16_2.Y VGND.t1435 sg13_lv_nmos ad=0.1406p pd=1.12u as=0.1406p ps=1.12u w=0.74u l=0.13u
X2122 VPWR.t1001 sg13cmos5l_inv_16_6.Y sg13cmos5l_inv_16_108.Y VPWR.t177 sg13_lv_pmos ad=0.2128p pd=1.5u as=0.2128p ps=1.5u w=1.12u l=0.13u
X2123 sg13cmos5l_inv_16_26.A sg13cmos5l_inv_16_27.Y VGND.t1243 VGND.t1263 sg13_lv_nmos ad=0.1406p pd=1.12u as=0.1406p ps=1.12u w=0.74u l=0.13u
X2124 VPWR.t737 sg13cmos5l_inv_16_4.Y sg13cmos5l_inv_16_8.Y VPWR.t4 sg13_lv_pmos ad=0.4368p pd=3.02u as=0.2128p ps=1.5u w=1.12u l=0.13u
X2125 VGND.t3 VPWR.t2504 VGND.t3 VGND.t2054 sg13_lv_nmos ad=0.1428p pd=1.52u as=0 ps=0 w=0.42u l=1u
X2126 sg13cmos5l_inv_16_0.A sg13cmos5l_inv_8_0.Y VPWR.t2411 VPWR.t177 sg13_lv_pmos ad=0.2128p pd=1.5u as=0.2128p ps=1.5u w=1.12u l=0.13u
X2127 VGND.t345 sg13cmos5l_inv_16_105.A sg13cmos5l_inv_16_105.Y VGND.t1109 sg13_lv_nmos ad=0.1406p pd=1.12u as=0.1406p ps=1.12u w=0.74u l=0.13u
X2128 VPWR.t2020 sg13cmos5l_inv_16_88.A sg13cmos5l_inv_16_94.A VPWR.t9 sg13_lv_pmos ad=0.2128p pd=1.5u as=0.2128p ps=1.5u w=1.12u l=0.13u
X2129 sg13cmos5l_inv_16_90.Y sg13cmos5l_inv_16_73.Y VPWR.t2201 VPWR.t16 sg13_lv_pmos ad=0.2128p pd=1.5u as=0.2128p ps=1.5u w=1.12u l=0.13u
X2130 sg13cmos5l_inv_16_58.Y sg13cmos5l_inv_16_69.Y VPWR.t1311 VPWR.t9 sg13_lv_pmos ad=0.2128p pd=1.5u as=0.3808p ps=2.92u w=1.12u l=0.13u
X2131 VGND.t882 VPWR.t2590 VGND.t882 VGND.t881 sg13_lv_nmos ad=0.1428p pd=1.52u as=0 ps=0 w=0.42u l=1u
X2132 VPWR.t1048 sg13cmos5l_inv_4_4.Y sg13cmos5l_inv_8_7.Y VPWR.t25 sg13_lv_pmos ad=0.2128p pd=1.5u as=0.2128p ps=1.5u w=1.12u l=0.13u
X2133 VGND.t1680 sg13cmos5l_inv_16_101.Y sg13cmos5l_inv_16_54.Y VGND.t380 sg13_lv_nmos ad=0.1406p pd=1.12u as=0.1406p ps=1.12u w=0.74u l=0.13u
X2134 sg13cmos5l_inv_16_111.A sg13cmos5l_inv_16_109.Y VPWR.t1553 VPWR.t9 sg13_lv_pmos ad=0.2128p pd=1.5u as=0.2128p ps=1.5u w=1.12u l=0.13u
X2135 VPWR.t2346 sg13cmos5l_inv_16_101.Y sg13cmos5l_inv_16_55.Y VPWR.t25 sg13_lv_pmos ad=0.2128p pd=1.5u as=0.2128p ps=1.5u w=1.12u l=0.13u
X2136 VPWR.t767 sg13cmos5l_inv_16_26.A sg13cmos5l_inv_16_26.Y VPWR.t177 sg13_lv_pmos ad=0.2128p pd=1.5u as=0.2128p ps=1.5u w=1.12u l=0.13u
X2137 sg13cmos5l_inv_16_2.Y sg13cmos5l_inv_16_2.A VGND.t1432 VGND.t1431 sg13_lv_nmos ad=0.1406p pd=1.12u as=0.2516p ps=2.16u w=0.74u l=0.13u
X2138 sg13cmos5l_inv_16_68.A sg13cmos5l_inv_16_71.Y VPWR.t1367 VPWR.t9 sg13_lv_pmos ad=0.2128p pd=1.5u as=0.4368p ps=3.02u w=1.12u l=0.13u
X2139 VGND.t635 VPWR.t2477 VGND.t635 VGND.t2103 sg13_lv_nmos ad=79.8f pd=0.8u as=0 ps=0 w=0.42u l=1u
X2140 VGND.t429 sg13cmos5l_and2_1_7.X sg13cmos5l_inv_1_5.Y VGND.t428 sg13_lv_nmos ad=0.2516p pd=2.16u as=0.2516p ps=2.16u w=0.74u l=0.13u
X2141 sg13cmos5l_inv_4_6.Y sg13cmos5l_inv_4_6.A VPWR.t1221 VPWR.t25 sg13_lv_pmos ad=0.2128p pd=1.5u as=0.2128p ps=1.5u w=1.12u l=0.13u
X2142 sg13cmos5l_inv_16_99.Y sg13cmos5l_inv_16_99.A VPWR.t1215 VPWR.t0 sg13_lv_pmos ad=0.2128p pd=1.5u as=0.2128p ps=1.5u w=1.12u l=0.13u
X2143 sg13cmos5l_inv_16_105.Y sg13cmos5l_inv_16_105.A VGND.t1100 VGND.t1106 sg13_lv_nmos ad=0.1406p pd=1.12u as=0.1406p ps=1.12u w=0.74u l=0.13u
X2144 sg13cmos5l_inv_16_94.A sg13cmos5l_inv_16_88.A VPWR.t2016 VPWR.t9 sg13_lv_pmos ad=0.2128p pd=1.5u as=0.2128p ps=1.5u w=1.12u l=0.13u
X2145 VPWR.t649 VGND.t1147 VPWR.t2429 VPWR.t16 sg13_lv_pmos ad=0.34p pd=2.68u as=0 ps=0 w=1u l=1u
X2146 VGND.t1680 sg13cmos5l_inv_16_53.A sg13cmos5l_inv_16_53.Y VGND.t380 sg13_lv_nmos ad=0.1406p pd=1.12u as=0.1406p ps=1.12u w=0.74u l=0.13u
X2147 VPWR.t899 sg13cmos5l_inv_16_14.A sg13cmos5l_inv_16_104.Y VPWR.t0 sg13_lv_pmos ad=0.2128p pd=1.5u as=0.2128p ps=1.5u w=1.12u l=0.13u
X2148 sg13cmos5l_inv_16_51.Y sg13cmos5l_inv_16_99.A VPWR.t1202 VPWR.t25 sg13_lv_pmos ad=0.2128p pd=1.5u as=0.2128p ps=1.5u w=1.12u l=0.13u
X2149 sg13cmos5l_inv_16_37.A sg13cmos5l_inv_16_43.Y VPWR.t600 VPWR.t0 sg13_lv_pmos ad=0.2128p pd=1.5u as=0.2128p ps=1.5u w=1.12u l=0.13u
X2150 VGND.t1970 sg13cmos5l_inv_16_76.A sg13cmos5l_inv_16_75.A VGND.t380 sg13_lv_nmos ad=0.1406p pd=1.12u as=0.1406p ps=1.12u w=0.74u l=0.13u
X2151 VPWR.t3 VGND.t2045 VPWR.t2 VPWR.t0 sg13_lv_pmos ad=0.34p pd=2.68u as=0 ps=0 w=1u l=1u
X2152 VGND.t1718 VPWR.t2550 VGND.t1718 VGND.t380 sg13_lv_nmos ad=79.8f pd=0.8u as=0 ps=0 w=0.42u l=1u
X2153 VGND.t593 sg13cmos5l_inv_16_34.Y sg13cmos5l_inv_16_101.Y VGND.t600 sg13_lv_nmos ad=0.1406p pd=1.12u as=0.1406p ps=1.12u w=0.74u l=0.13u
X2154 VGND.t1010 sg13cmos5l_inv_16_87.A sg13cmos5l_inv_16_87.Y VGND.t881 sg13_lv_nmos ad=0.1406p pd=1.12u as=0.1406p ps=1.12u w=0.74u l=0.13u
X2155 VGND.t198 sg13cmos5l_inv_16_28.A sg13cmos5l_inv_16_29.A VGND.t201 sg13_lv_nmos ad=0.1406p pd=1.12u as=0.1406p ps=1.12u w=0.74u l=0.13u
X2156 VPWR.t1598 sg13cmos5l_inv_16_61.A sg13cmos5l_inv_16_61.Y VPWR.t9 sg13_lv_pmos ad=0.4368p pd=3.02u as=0.2128p ps=1.5u w=1.12u l=0.13u
X2157 VGND.t353 sg13cmos5l_inv_16_103.A sg13cmos5l_inv_16_103.Y VGND.t359 sg13_lv_nmos ad=0.1406p pd=1.12u as=0.1406p ps=1.12u w=0.74u l=0.13u
X2158 sg13cmos5l_inv_16_6.Y sg13cmos5l_inv_16_6.A VPWR.t246 VPWR.t177 sg13_lv_pmos ad=0.2128p pd=1.5u as=0.3808p ps=2.92u w=1.12u l=0.13u
X2159 VPWR.t1914 sg13cmos5l_inv_16_94.A sg13cmos5l_inv_16_76.A VPWR.t16 sg13_lv_pmos ad=0.2128p pd=1.5u as=0.2128p ps=1.5u w=1.12u l=0.13u
X2160 VPWR.t1200 sg13cmos5l_inv_16_99.A sg13cmos5l_inv_16_51.Y VPWR.t25 sg13_lv_pmos ad=0.2128p pd=1.5u as=0.2128p ps=1.5u w=1.12u l=0.13u
X2161 VPWR.t839 sg13cmos5l_inv_2_7.Y sg13cmos5l_inv_4_5.Y VPWR.t25 sg13_lv_pmos ad=0.3808p pd=2.92u as=0.2128p ps=1.5u w=1.12u l=0.13u
X2162 sg13cmos5l_buf_1_12.X a_3592_9192# VGND.t916 VGND.t1277 sg13_lv_nmos ad=0.2886p pd=2.26u as=0.14875p ps=1.16u w=0.74u l=0.13u
X2163 VPWR.t1478 sg13cmos5l_inv_16_84.A sg13cmos5l_inv_16_85.Y VPWR.t9 sg13_lv_pmos ad=0.2128p pd=1.5u as=0.2128p ps=1.5u w=1.12u l=0.13u
X2164 VGND.t1820 VPWR.t2581 VGND.t1820 VGND.t881 sg13_lv_nmos ad=79.8f pd=0.8u as=0 ps=0 w=0.42u l=1u
X2165 VPWR.t2082 sg13cmos5l_inv_16_48.A sg13cmos5l_inv_16_109.Y VPWR.t16 sg13_lv_pmos ad=0.2128p pd=1.5u as=0.2128p ps=1.5u w=1.12u l=0.13u
X2166 sg13cmos5l_inv_16_28.A sg13cmos5l_inv_16_41.A VGND.t39 VGND.t245 sg13_lv_nmos ad=0.1406p pd=1.12u as=0.1406p ps=1.12u w=0.74u l=0.13u
X2167 sg13cmos5l_inv_16_75.A sg13cmos5l_inv_16_76.A VGND.t390 VGND.t380 sg13_lv_nmos ad=0.1406p pd=1.12u as=0.1406p ps=1.12u w=0.74u l=0.13u
X2168 VPWR.t927 sg13cmos5l_inv_16_14.A sg13cmos5l_inv_16_14.Y VPWR.t4 sg13_lv_pmos ad=0.2128p pd=1.5u as=0.2128p ps=1.5u w=1.12u l=0.13u
X2169 sg13cmos5l_inv_16_52.Y sg13cmos5l_inv_16_56.Y VPWR.t2048 VPWR.t16 sg13_lv_pmos ad=0.2128p pd=1.5u as=0.2128p ps=1.5u w=1.12u l=0.13u
X2170 VPWR.t668 sg13cmos5l_inv_16_41.A sg13cmos5l_inv_16_34.Y VPWR.t0 sg13_lv_pmos ad=0.2128p pd=1.5u as=0.2128p ps=1.5u w=1.12u l=0.13u
X2171 sg13cmos5l_inv_16_25.Y sg13cmos5l_inv_16_6.Y VPWR.t844 VPWR.t177 sg13_lv_pmos ad=0.2128p pd=1.5u as=0.2128p ps=1.5u w=1.12u l=0.13u
X2172 sg13cmos5l_inv_16_101.Y sg13cmos5l_inv_16_34.Y VGND.t593 VGND.t597 sg13_lv_nmos ad=0.1406p pd=1.12u as=0.1406p ps=1.12u w=0.74u l=0.13u
X2173 VPWR.t1642 sg13cmos5l_inv_16_27.Y sg13cmos5l_inv_16_43.Y VPWR.t4 sg13_lv_pmos ad=0.2128p pd=1.5u as=0.2128p ps=1.5u w=1.12u l=0.13u
X2174 VPWR.t1972 sg13cmos5l_inv_16_67.A sg13cmos5l_inv_16_65.Y VPWR.t9 sg13_lv_pmos ad=0.2128p pd=1.5u as=0.2128p ps=1.5u w=1.12u l=0.13u
X2175 sg13cmos5l_inv_16_93.Y sg13cmos5l_inv_16_87.A VPWR.t1408 VPWR.t9 sg13_lv_pmos ad=0.2128p pd=1.5u as=0.2128p ps=1.5u w=1.12u l=0.13u
X2176 sg13cmos5l_inv_16_87.Y sg13cmos5l_inv_16_87.A VGND.t1010 VGND.t881 sg13_lv_nmos ad=0.1406p pd=1.12u as=0.2516p ps=2.16u w=0.74u l=0.13u
X2177 sg13cmos5l_inv_16_17.A sg13cmos5l_inv_16_1.A VPWR.t1098 VPWR.t177 sg13_lv_pmos ad=0.2128p pd=1.5u as=0.2128p ps=1.5u w=1.12u l=0.13u
X2178 sg13cmos5l_inv_4_5.Y sg13cmos5l_inv_2_7.Y VPWR.t836 VPWR.t25 sg13_lv_pmos ad=0.2128p pd=1.5u as=0.3808p ps=2.92u w=1.12u l=0.13u
X2179 VGND.t3 sg13cmos5l_inv_16_43.Y sg13cmos5l_inv_16_37.A VGND.t166 sg13_lv_nmos ad=0.1406p pd=1.12u as=0.1406p ps=1.12u w=0.74u l=0.13u
X2180 VPWR.t445 VGND.t2117 VPWR.t348 VPWR.t177 sg13_lv_pmos ad=0.34p pd=2.68u as=0 ps=0 w=1u l=1u
X2181 VGND.t866 sg13cmos5l_inv_16_68.A sg13cmos5l_inv_16_66.Y VGND.t872 sg13_lv_nmos ad=0.1406p pd=1.12u as=0.1406p ps=1.12u w=0.74u l=0.13u
X2182 VPWR.t11 VGND.t1885 VPWR.t10 VPWR.t9 sg13_lv_pmos ad=0.19p pd=1.38u as=0 ps=0 w=1u l=1u
X2183 sg13cmos5l_inv_16_109.Y sg13cmos5l_inv_16_48.A VPWR.t2079 VPWR.t16 sg13_lv_pmos ad=0.2128p pd=1.5u as=0.4368p ps=3.02u w=1.12u l=0.13u
X2184 sg13cmos5l_inv_16_52.Y sg13cmos5l_inv_16_56.Y VGND.t1663 VGND.t380 sg13_lv_nmos ad=0.1406p pd=1.12u as=0.1406p ps=1.12u w=0.74u l=0.13u
X2185 sg13cmos5l_inv_16_17.Y sg13cmos5l_inv_16_17.A VPWR.t542 VPWR.t177 sg13_lv_pmos ad=0.2128p pd=1.5u as=0.2128p ps=1.5u w=1.12u l=0.13u
X2186 VGND.t111 sg13cmos5l_inv_16_17.A sg13cmos5l_inv_16_17.Y VGND.t117 sg13_lv_nmos ad=0.1406p pd=1.12u as=0.1406p ps=1.12u w=0.74u l=0.13u
X2187 sg13cmos5l_inv_16_28.A sg13cmos5l_inv_16_41.A VPWR.t654 VPWR.t4 sg13_lv_pmos ad=0.2128p pd=1.5u as=0.3808p ps=2.92u w=1.12u l=0.13u
X2188 sg13cmos5l_inv_16_15.A sg13cmos5l_inv_16_23.Y VGND.t45 VGND.t63 sg13_lv_nmos ad=0.1406p pd=1.12u as=0.1406p ps=1.12u w=0.74u l=0.13u
X2189 sg13cmos5l_inv_16_73.A sg13cmos5l_inv_16_94.A VGND.t1507 VGND.t881 sg13_lv_nmos ad=0.1406p pd=1.12u as=0.1406p ps=1.12u w=0.74u l=0.13u
X2190 VPWR.t2271 sg13cmos5l_inv_16_46.Y sg13cmos5l_inv_16_50.Y VPWR.t25 sg13_lv_pmos ad=0.2128p pd=1.5u as=0.2128p ps=1.5u w=1.12u l=0.13u
X2191 sg13cmos5l_inv_16_36.Y sg13cmos5l_inv_16_36.A VGND.t146 VGND.t154 sg13_lv_nmos ad=0.1406p pd=1.12u as=0.1406p ps=1.12u w=0.74u l=0.13u
X2192 VGND.t1178 VPWR.t2605 VGND.t1178 VGND.t1875 sg13_lv_nmos ad=79.8f pd=0.8u as=0 ps=0 w=0.42u l=1u
X2193 sg13cmos5l_and2_1_0.X a_16941_916# VPWR.t329 VPWR.t177 sg13_lv_pmos ad=0.3808p pd=2.92u as=0.1918p ps=1.5u w=1.12u l=0.13u
X2194 VPWR.t2180 sg13cmos5l_inv_4_0.Y sg13cmos5l_inv_8_0.Y VPWR.t177 sg13_lv_pmos ad=0.2128p pd=1.5u as=0.2128p ps=1.5u w=1.12u l=0.13u
X2195 sg13cmos5l_inv_16_14.Y sg13cmos5l_inv_16_14.A VPWR.t923 VPWR.t4 sg13_lv_pmos ad=0.2128p pd=1.5u as=0.2128p ps=1.5u w=1.12u l=0.13u
X2196 VPWR.t733 sg13cmos5l_inv_16_4.Y sg13cmos5l_inv_16_8.Y VPWR.t4 sg13_lv_pmos ad=0.2128p pd=1.5u as=0.2128p ps=1.5u w=1.12u l=0.13u
X2197 sg13cmos5l_inv_16_37.Y sg13cmos5l_inv_16_37.A VGND.t3 VGND.t36 sg13_lv_nmos ad=0.1406p pd=1.12u as=0.1406p ps=1.12u w=0.74u l=0.13u
X2198 VPWR.t2046 sg13cmos5l_inv_16_56.Y sg13cmos5l_inv_16_52.Y VPWR.t16 sg13_lv_pmos ad=0.2128p pd=1.5u as=0.2128p ps=1.5u w=1.12u l=0.13u
X2199 sg13cmos5l_inv_16_10.Y sg13cmos5l_inv_16_9.A VPWR.t1149 VPWR.t0 sg13_lv_pmos ad=0.2128p pd=1.5u as=0.2128p ps=1.5u w=1.12u l=0.13u
X2200 VGND.t82 osc[1] a_2920_2420# VGND.t1698 sg13_lv_nmos ad=0.14875p pd=1.16u as=0.187p ps=1.78u w=0.55u l=0.13u
X2201 VPWR.t294 VGND.t45 VPWR.t291 VPWR.t4 sg13_lv_pmos ad=0.19p pd=1.38u as=0 ps=0 w=1u l=1u
X2202 VPWR.t1406 sg13cmos5l_inv_16_87.A sg13cmos5l_inv_16_93.Y VPWR.t9 sg13_lv_pmos ad=0.2128p pd=1.5u as=0.2128p ps=1.5u w=1.12u l=0.13u
X2203 sg13cmos5l_inv_16_74.Y sg13cmos5l_inv_16_75.A VGND.t381 VGND.t380 sg13_lv_nmos ad=0.1406p pd=1.12u as=0.2516p ps=2.16u w=0.74u l=0.13u
X2204 VGND.t162 sg13cmos5l_inv_16_43.Y sg13cmos5l_inv_16_36.A VGND.t194 sg13_lv_nmos ad=0.2516p pd=2.16u as=0.1406p ps=1.12u w=0.74u l=0.13u
X2205 VPWR.t1096 sg13cmos5l_inv_16_1.A sg13cmos5l_inv_16_17.A VPWR.t177 sg13_lv_pmos ad=0.2128p pd=1.5u as=0.2128p ps=1.5u w=1.12u l=0.13u
X2206 sg13cmos5l_inv_16_17.Y sg13cmos5l_inv_16_17.A VGND.t111 VGND.t112 sg13_lv_nmos ad=0.1406p pd=1.12u as=0.1406p ps=1.12u w=0.74u l=0.13u
X2207 VPWR.t1344 sg13cmos5l_inv_16_96.A sg13cmos5l_inv_16_96.Y VPWR.t25 sg13_lv_pmos ad=0.2128p pd=1.5u as=0.2128p ps=1.5u w=1.12u l=0.13u
X2208 sg13cmos5l_inv_16_88.A sg13cmos5l_inv_4_7.Y VPWR.t1621 VPWR.t9 sg13_lv_pmos ad=0.2128p pd=1.5u as=0.2128p ps=1.5u w=1.12u l=0.13u
X2209 sg13cmos5l_inv_16_37.A sg13cmos5l_inv_16_43.Y VGND.t3 VGND.t163 sg13_lv_nmos ad=0.1406p pd=1.12u as=0.2516p ps=2.16u w=0.74u l=0.13u
X2210 VGND.t1663 sg13cmos5l_inv_16_56.Y sg13cmos5l_inv_16_52.Y VGND.t380 sg13_lv_nmos ad=0.1406p pd=1.12u as=0.1406p ps=1.12u w=0.74u l=0.13u
X2211 VPWR.t68 VGND.t866 VPWR.t67 VPWR.t9 sg13_lv_pmos ad=0.34p pd=2.68u as=0 ps=0 w=1u l=1u
X2212 VPWR.t1474 sg13cmos5l_inv_16_84.A sg13cmos5l_inv_16_85.Y VPWR.t9 sg13_lv_pmos ad=0.2128p pd=1.5u as=0.2128p ps=1.5u w=1.12u l=0.13u
X2213 VGND.t447 sg13cmos5l_inv_16_20.A sg13cmos5l_inv_16_22.Y VGND.t446 sg13_lv_nmos ad=0.1406p pd=1.12u as=0.1406p ps=1.12u w=0.74u l=0.13u
X2214 VPWR.t540 sg13cmos5l_inv_16_17.A sg13cmos5l_inv_16_17.Y VPWR.t177 sg13_lv_pmos ad=0.2128p pd=1.5u as=0.2128p ps=1.5u w=1.12u l=0.13u
X2215 sg13cmos5l_inv_16_26.A sg13cmos5l_inv_16_27.Y VPWR.t767 VPWR.t177 sg13_lv_pmos ad=0.2128p pd=1.5u as=0.2128p ps=1.5u w=1.12u l=0.13u
X2216 VPWR.t1165 sg13cmos5l_inv_16_9.A sg13cmos5l_inv_16_9.Y VPWR.t4 sg13_lv_pmos ad=0.2128p pd=1.5u as=0.2128p ps=1.5u w=1.12u l=0.13u
X2217 VPWR.t2342 sg13cmos5l_inv_16_101.Y sg13cmos5l_inv_16_55.Y VPWR.t25 sg13_lv_pmos ad=0.2128p pd=1.5u as=0.2128p ps=1.5u w=1.12u l=0.13u
X2218 sg13cmos5l_inv_16_50.Y sg13cmos5l_inv_16_46.Y VPWR.t2268 VPWR.t25 sg13_lv_pmos ad=0.2128p pd=1.5u as=0.3808p ps=2.92u w=1.12u l=0.13u
X2219 VGND.t259 sg13cmos5l_inv_16_29.A sg13cmos5l_inv_16_35.Y VGND.t265 sg13_lv_nmos ad=0.1406p pd=1.12u as=0.1406p ps=1.12u w=0.74u l=0.13u
X2220 sg13cmos5l_inv_4_2.Y sg13cmos5l_inv_2_3.Y VGND.t39 VGND.t41 sg13_lv_nmos ad=0.1406p pd=1.12u as=0.1406p ps=1.12u w=0.74u l=0.13u
X2221 sg13cmos5l_inv_16_110.Y sg13cmos5l_inv_16_5.Y VPWR.t1062 VPWR.t4 sg13_lv_pmos ad=0.2128p pd=1.5u as=0.2128p ps=1.5u w=1.12u l=0.13u
X2222 sg13cmos5l_inv_16_28.A sg13cmos5l_inv_16_41.A VGND.t215 VGND.t240 sg13_lv_nmos ad=0.1406p pd=1.12u as=0.1406p ps=1.12u w=0.74u l=0.13u
X2223 sg13cmos5l_inv_16_108.Y sg13cmos5l_inv_16_6.Y VPWR.t1001 VPWR.t177 sg13_lv_pmos ad=0.2128p pd=1.5u as=0.2128p ps=1.5u w=1.12u l=0.13u
X2224 VGND.t3 sg13cmos5l_inv_16_37.A sg13cmos5l_inv_16_37.Y VGND.t33 sg13_lv_nmos ad=0.1406p pd=1.12u as=0.1406p ps=1.12u w=0.74u l=0.13u
X2225 VPWR.t1296 sg13cmos5l_inv_16_68.A sg13cmos5l_inv_16_68.Y VPWR.t16 sg13_lv_pmos ad=0.2128p pd=1.5u as=0.2128p ps=1.5u w=1.12u l=0.13u
X2226 VPWR.t1147 sg13cmos5l_inv_16_9.A sg13cmos5l_inv_16_10.Y VPWR.t0 sg13_lv_pmos ad=0.2128p pd=1.5u as=0.2128p ps=1.5u w=1.12u l=0.13u
X2227 VPWR.t2328 sg13cmos5l_inv_16_101.Y sg13cmos5l_inv_16_54.Y VPWR.t25 sg13_lv_pmos ad=0.2128p pd=1.5u as=0.2128p ps=1.5u w=1.12u l=0.13u
X2228 sg13cmos5l_inv_16_27.A sg13cmos5l_inv_8_2.A VPWR.t1001 VPWR.t177 sg13_lv_pmos ad=0.2128p pd=1.5u as=0.3808p ps=2.92u w=1.12u l=0.13u
X2229 VGND.t450 VPWR.t2486 VGND.t450 VGND.t2086 sg13_lv_nmos ad=79.8f pd=0.8u as=0 ps=0 w=0.42u l=1u
X2230 sg13cmos5l_inv_16_93.Y sg13cmos5l_inv_16_87.A VPWR.t1402 VPWR.t9 sg13_lv_pmos ad=0.2128p pd=1.5u as=0.2128p ps=1.5u w=1.12u l=0.13u
X2231 sg13cmos5l_inv_16_36.A sg13cmos5l_inv_16_43.Y VGND.t146 VGND.t191 sg13_lv_nmos ad=0.1406p pd=1.12u as=0.1406p ps=1.12u w=0.74u l=0.13u
X2232 sg13cmos5l_inv_16_14.A sg13cmos5l_inv_16_23.Y VPWR.t514 VPWR.t0 sg13_lv_pmos ad=0.2128p pd=1.5u as=0.2128p ps=1.5u w=1.12u l=0.13u
X2233 a_5227_916# sg13cmos5l_and2_1_3.A a_5133_916# VGND.t43 sg13_lv_nmos ad=0.1216p pd=1.02u as=0.2176p ps=1.96u w=0.64u l=0.13u
X2234 sg13cmos5l_inv_16_25.Y sg13cmos5l_inv_16_6.Y VPWR.t844 VPWR.t177 sg13_lv_pmos ad=0.2128p pd=1.5u as=0.2128p ps=1.5u w=1.12u l=0.13u
X2235 VGND.t472 sg13cmos5l_inv_16_14.A sg13cmos5l_inv_16_104.Y VGND.t480 sg13_lv_nmos ad=0.1406p pd=1.12u as=0.1406p ps=1.12u w=0.74u l=0.13u
X2236 VPWR.t2068 sg13cmos5l_inv_16_53.A sg13cmos5l_inv_16_53.Y VPWR.t16 sg13_lv_pmos ad=0.2128p pd=1.5u as=0.2128p ps=1.5u w=1.12u l=0.13u
X2237 VPWR.t945 sg13cmos5l_inv_16_15.A sg13cmos5l_inv_16_13.Y VPWR.t0 sg13_lv_pmos ad=0.4368p pd=3.02u as=0.2128p ps=1.5u w=1.12u l=0.13u
X2238 sg13cmos5l_inv_16_9.A sg13cmos5l_inv_16_8.Y VGND.t291 VGND.t564 sg13_lv_nmos ad=0.1406p pd=1.12u as=0.1406p ps=1.12u w=0.74u l=0.13u
X2239 sg13cmos5l_inv_16_52.Y sg13cmos5l_inv_16_56.Y VGND.t1663 VGND.t380 sg13_lv_nmos ad=0.1406p pd=1.12u as=0.1406p ps=1.12u w=0.74u l=0.13u
X2240 VGND.t866 sg13cmos5l_inv_16_68.A sg13cmos5l_inv_16_66.Y VGND.t868 sg13_lv_nmos ad=0.1406p pd=1.12u as=0.1406p ps=1.12u w=0.74u l=0.13u
X2241 VPWR.t2127 sg13cmos5l_inv_16_46.A sg13cmos5l_inv_16_47.A VPWR.t16 sg13_lv_pmos ad=0.4368p pd=3.02u as=0.2128p ps=1.5u w=1.12u l=0.13u
X2242 VGND.t1718 VPWR.t2564 VGND.t1718 VGND.t380 sg13_lv_nmos ad=0.1428p pd=1.52u as=0 ps=0 w=0.42u l=1u
X2243 sg13cmos5l_inv_16_22.Y sg13cmos5l_inv_16_20.A VGND.t375 VGND.t443 sg13_lv_nmos ad=0.1406p pd=1.12u as=0.1406p ps=1.12u w=0.74u l=0.13u
X2244 sg13cmos5l_inv_16_29.Y sg13cmos5l_inv_16_29.A VPWR.t707 VPWR.t177 sg13_lv_pmos ad=0.2128p pd=1.5u as=0.2128p ps=1.5u w=1.12u l=0.13u
X2245 VPWR.t767 sg13cmos5l_inv_16_27.Y sg13cmos5l_inv_16_26.A VPWR.t177 sg13_lv_pmos ad=0.2128p pd=1.5u as=0.2128p ps=1.5u w=1.12u l=0.13u
X2246 sg13cmos5l_inv_16_9.Y sg13cmos5l_inv_16_9.A VPWR.t1161 VPWR.t4 sg13_lv_pmos ad=0.2128p pd=1.5u as=0.2128p ps=1.5u w=1.12u l=0.13u
X2247 sg13cmos5l_inv_16_95.Y sg13cmos5l_inv_16_73.Y VGND.t1010 VGND.t881 sg13_lv_nmos ad=0.1406p pd=1.12u as=0.1406p ps=1.12u w=0.74u l=0.13u
X2248 sg13cmos5l_inv_16_35.Y sg13cmos5l_inv_16_29.A VGND.t259 VGND.t262 sg13_lv_nmos ad=0.1406p pd=1.12u as=0.1406p ps=1.12u w=0.74u l=0.13u
X2249 VPWR.t1060 sg13cmos5l_inv_16_5.Y sg13cmos5l_inv_16_110.Y VPWR.t4 sg13_lv_pmos ad=0.2128p pd=1.5u as=0.2128p ps=1.5u w=1.12u l=0.13u
X2250 sg13cmos5l_inv_16_37.Y sg13cmos5l_inv_16_37.A VGND.t3 VGND.t30 sg13_lv_nmos ad=0.1406p pd=1.12u as=0.1406p ps=1.12u w=0.74u l=0.13u
X2251 sg13cmos5l_inv_16_15.A sg13cmos5l_inv_16_23.Y VGND.t45 VGND.t59 sg13_lv_nmos ad=0.1406p pd=1.12u as=0.1406p ps=1.12u w=0.74u l=0.13u
X2252 VGND.t1 VPWR.t2537 VGND.t1 VGND.t1998 sg13_lv_nmos ad=0.1428p pd=1.52u as=0 ps=0 w=0.42u l=1u
X2253 sg13cmos5l_inv_16_110.Y sg13cmos5l_inv_16_5.Y VGND.t637 VGND.t650 sg13_lv_nmos ad=0.1406p pd=1.12u as=0.1406p ps=1.12u w=0.74u l=0.13u
X2254 sg13cmos5l_inv_16_11.A sg13cmos5l_inv_16_96.Y VGND.t953 VGND.t380 sg13_lv_nmos ad=0.1406p pd=1.12u as=0.1406p ps=1.12u w=0.74u l=0.13u
X2255 sg13cmos5l_inv_16_75.Y sg13cmos5l_inv_16_75.A VPWR.t819 VPWR.t25 sg13_lv_pmos ad=0.2128p pd=1.5u as=0.3808p ps=2.92u w=1.12u l=0.13u
X2256 sg13cmos5l_inv_16_54.Y sg13cmos5l_inv_16_101.Y VPWR.t2324 VPWR.t25 sg13_lv_pmos ad=0.2128p pd=1.5u as=0.2128p ps=1.5u w=1.12u l=0.13u
X2257 VPWR.t512 sg13cmos5l_inv_16_23.Y sg13cmos5l_inv_16_14.A VPWR.t0 sg13_lv_pmos ad=0.2128p pd=1.5u as=0.2128p ps=1.5u w=1.12u l=0.13u
X2258 sg13cmos5l_inv_16_1.A sg13cmos5l_inv_16_0.A VPWR.t1258 VPWR.t177 sg13_lv_pmos ad=0.2128p pd=1.5u as=0.2128p ps=1.5u w=1.12u l=0.13u
X2259 VGND.t310 sg13cmos5l_inv_8_1.Y sg13cmos5l_inv_16_4.Y VGND.t1450 sg13_lv_nmos ad=0.1406p pd=1.12u as=0.1406p ps=1.12u w=0.74u l=0.13u
X2260 VPWR.t1594 sg13cmos5l_inv_16_61.A sg13cmos5l_inv_16_61.Y VPWR.t9 sg13_lv_pmos ad=0.2128p pd=1.5u as=0.2128p ps=1.5u w=1.12u l=0.13u
X2261 sg13cmos5l_inv_16_45.Y sg13cmos5l_inv_16_47.A VPWR.t2301 VPWR.t16 sg13_lv_pmos ad=0.2128p pd=1.5u as=0.2128p ps=1.5u w=1.12u l=0.13u
X2262 VPWR.t844 sg13cmos5l_inv_16_6.Y sg13cmos5l_inv_16_25.Y VPWR.t177 sg13_lv_pmos ad=0.2128p pd=1.5u as=0.2128p ps=1.5u w=1.12u l=0.13u
X2263 sg13cmos5l_inv_16_44.Y sg13cmos5l_inv_16_44.A VPWR.t631 VPWR.t4 sg13_lv_pmos ad=0.2128p pd=1.5u as=0.2128p ps=1.5u w=1.12u l=0.13u
X2264 sg13cmos5l_inv_16_15.Y sg13cmos5l_inv_16_15.A VPWR.t959 VPWR.t4 sg13_lv_pmos ad=0.2128p pd=1.5u as=0.2128p ps=1.5u w=1.12u l=0.13u
X2265 VPWR.t1324 sg13cmos5l_inv_16_69.Y sg13cmos5l_inv_16_58.Y VPWR.t9 sg13_lv_pmos ad=0.2128p pd=1.5u as=0.2128p ps=1.5u w=1.12u l=0.13u
X2266 sg13cmos5l_inv_16_65.Y sg13cmos5l_inv_16_67.A VGND.t1580 VGND.t1579 sg13_lv_nmos ad=0.1406p pd=1.12u as=0.2516p ps=2.16u w=0.74u l=0.13u
X2267 VPWR.t651 VGND.t1083 VPWR.t650 VPWR.t16 sg13_lv_pmos ad=0.34p pd=2.68u as=0 ps=0 w=1u l=1u
X2268 sg13cmos5l_inv_16_104.Y sg13cmos5l_inv_16_14.A VGND.t472 VGND.t477 sg13_lv_nmos ad=0.1406p pd=1.12u as=0.1406p ps=1.12u w=0.74u l=0.13u
X2269 VGND.t291 sg13cmos5l_inv_16_8.Y sg13cmos5l_inv_16_9.A VGND.t561 sg13_lv_nmos ad=0.1406p pd=1.12u as=0.1406p ps=1.12u w=0.74u l=0.13u
X2270 sg13cmos5l_inv_16_53.Y sg13cmos5l_inv_16_53.A VPWR.t2064 VPWR.t16 sg13_lv_pmos ad=0.2128p pd=1.5u as=0.2128p ps=1.5u w=1.12u l=0.13u
X2271 VGND.t675 sg13cmos5l_inv_16_1.A sg13cmos5l_inv_16_17.A VGND.t679 sg13_lv_nmos ad=0.1406p pd=1.12u as=0.1406p ps=1.12u w=0.74u l=0.13u
X2272 sg13cmos5l_inv_16_53.A sg13cmos5l_inv_16_52.Y VPWR.t1756 VPWR.t16 sg13_lv_pmos ad=0.2128p pd=1.5u as=0.2128p ps=1.5u w=1.12u l=0.13u
X2273 VPWR.t2152 sg13cmos5l_inv_16_79.A sg13cmos5l_inv_16_91.Y VPWR.t16 sg13_lv_pmos ad=0.2128p pd=1.5u as=0.2128p ps=1.5u w=1.12u l=0.13u
X2274 sg13cmos5l_inv_16_47.A sg13cmos5l_inv_16_46.A VPWR.t2123 VPWR.t16 sg13_lv_pmos ad=0.2128p pd=1.5u as=0.2128p ps=1.5u w=1.12u l=0.13u
X2275 VPWR.t104 VGND.t1970 VPWR.t103 VPWR.t25 sg13_lv_pmos ad=0.34p pd=2.68u as=0 ps=0 w=1u l=1u
X2276 VGND.t375 sg13cmos5l_inv_16_20.A sg13cmos5l_inv_16_22.Y VGND.t440 sg13_lv_nmos ad=0.1406p pd=1.12u as=0.1406p ps=1.12u w=0.74u l=0.13u
X2277 VGND.t45 sg13cmos5l_inv_16_23.Y sg13cmos5l_inv_16_15.A VGND.t56 sg13_lv_nmos ad=0.1406p pd=1.12u as=0.1406p ps=1.12u w=0.74u l=0.13u
X2278 sg13cmos5l_inv_16_67.A sg13cmos5l_inv_16_109.Y VGND.t1132 VGND.t881 sg13_lv_nmos ad=0.1406p pd=1.12u as=0.1406p ps=1.12u w=0.74u l=0.13u
X2279 sg13cmos5l_inv_16_53.Y sg13cmos5l_inv_16_53.A VGND.t1680 VGND.t380 sg13_lv_nmos ad=0.1406p pd=1.12u as=0.1406p ps=1.12u w=0.74u l=0.13u
X2280 VGND.t1792 sg13cmos5l_inv_16_96.Y sg13cmos5l_inv_16_11.A VGND.t380 sg13_lv_nmos ad=0.1406p pd=1.12u as=0.1406p ps=1.12u w=0.74u l=0.13u
X2281 sg13cmos5l_inv_16_17.A sg13cmos5l_inv_16_1.A VGND.t672 VGND.t673 sg13_lv_nmos ad=0.1406p pd=1.12u as=0.1406p ps=1.12u w=0.74u l=0.13u
X2282 VPWR.t707 sg13cmos5l_inv_16_28.A sg13cmos5l_inv_16_29.A VPWR.t177 sg13_lv_pmos ad=0.2128p pd=1.5u as=0.2128p ps=1.5u w=1.12u l=0.13u
X2283 VPWR.t1292 sg13cmos5l_inv_16_68.A sg13cmos5l_inv_16_68.Y VPWR.t16 sg13_lv_pmos ad=0.2128p pd=1.5u as=0.2128p ps=1.5u w=1.12u l=0.13u
X2284 a_23785_5004# sg13cmos5l_and2_1_7.B VGND.t122 VGND.t1378 sg13_lv_nmos ad=0.1216p pd=1.02u as=0.1331p ps=1.12u w=0.64u l=0.13u
X2285 VPWR.t1955 sg13cmos5l_inv_16_111.A sg13cmos5l_inv_16_111.Y VPWR.t16 sg13_lv_pmos ad=0.4368p pd=3.02u as=0.2128p ps=1.5u w=1.12u l=0.13u
X2286 VGND.t472 sg13cmos5l_inv_16_14.A sg13cmos5l_inv_16_104.Y VGND.t474 sg13_lv_nmos ad=0.1406p pd=1.12u as=0.1406p ps=1.12u w=0.74u l=0.13u
X2287 sg13cmos5l_inv_16_109.Y sg13cmos5l_inv_16_48.A VGND.t1147 VGND.t881 sg13_lv_nmos ad=0.1406p pd=1.12u as=0.1406p ps=1.12u w=0.74u l=0.13u
X2288 VGND.t345 sg13cmos5l_inv_16_105.A sg13cmos5l_inv_16_80.Y VGND.t1109 sg13_lv_nmos ad=0.1406p pd=1.12u as=0.1406p ps=1.12u w=0.74u l=0.13u
X2289 sg13cmos5l_inv_16_91.Y sg13cmos5l_inv_16_79.A VPWR.t2148 VPWR.t16 sg13_lv_pmos ad=0.2128p pd=1.5u as=0.2128p ps=1.5u w=1.12u l=0.13u
X2290 VPWR.t2379 sg13cmos5l_inv_16_76.A sg13cmos5l_inv_16_77.A VPWR.t16 sg13_lv_pmos ad=0.2128p pd=1.5u as=0.2128p ps=1.5u w=1.12u l=0.13u
X2291 sg13cmos5l_and2_1_0.X a_16941_916# VGND.t1419 VGND.t1503 sg13_lv_nmos ad=0.2516p pd=2.16u as=0.1331p ps=1.12u w=0.74u l=0.13u
X2292 VGND.t637 sg13cmos5l_inv_16_6.Y sg13cmos5l_inv_16_108.Y VGND.t2363 sg13_lv_nmos ad=0.2516p pd=2.16u as=0.1406p ps=1.12u w=0.74u l=0.13u
X2293 VPWR.t1581 sg13cmos5l_inv_16_61.A sg13cmos5l_inv_16_59.Y VPWR.t9 sg13_lv_pmos ad=0.2128p pd=1.5u as=0.2128p ps=1.5u w=1.12u l=0.13u
X2294 sg13cmos5l_inv_16_46.Y sg13cmos5l_inv_16_46.A VGND.t20 VGND.t1731 sg13_lv_nmos ad=0.1406p pd=1.12u as=0.2516p ps=2.16u w=0.74u l=0.13u
X2295 sg13cmos5l_inv_16_14.Y sg13cmos5l_inv_16_14.A VPWR.t919 VPWR.t4 sg13_lv_pmos ad=0.2128p pd=1.5u as=0.2128p ps=1.5u w=1.12u l=0.13u
X2296 sg13cmos5l_inv_16_101.Y sg13cmos5l_inv_16_34.Y VPWR.t1040 VPWR.t0 sg13_lv_pmos ad=0.2128p pd=1.5u as=0.2128p ps=1.5u w=1.12u l=0.13u
X2297 sg13cmos5l_inv_16_34.Y sg13cmos5l_inv_16_41.A VPWR.t660 VPWR.t0 sg13_lv_pmos ad=0.2128p pd=1.5u as=0.2128p ps=1.5u w=1.12u l=0.13u
X2298 VPWR.t396 VGND.t635 VPWR.t394 VPWR.t4 sg13_lv_pmos ad=0.19p pd=1.38u as=0 ps=0 w=1u l=1u
X2299 sg13cmos5l_inv_16_111.A sg13cmos5l_inv_16_109.Y VGND.t1083 VGND.t881 sg13_lv_nmos ad=0.1406p pd=1.12u as=0.1406p ps=1.12u w=0.74u l=0.13u
X2300 VGND.t1680 sg13cmos5l_inv_16_53.A sg13cmos5l_inv_16_53.Y VGND.t380 sg13_lv_nmos ad=0.1406p pd=1.12u as=0.1406p ps=1.12u w=0.74u l=0.13u
X2301 sg13cmos5l_inv_16_29.A sg13cmos5l_inv_16_28.A VPWR.t707 VPWR.t177 sg13_lv_pmos ad=0.2128p pd=1.5u as=0.2128p ps=1.5u w=1.12u l=0.13u
X2302 VGND.t1820 VPWR.t2581 VGND.t1820 VGND.t881 sg13_lv_nmos ad=0.1428p pd=1.52u as=0 ps=0 w=0.42u l=1u
X2303 sg13cmos5l_inv_16_111.Y sg13cmos5l_inv_16_111.A VPWR.t1951 VPWR.t16 sg13_lv_pmos ad=0.2128p pd=1.5u as=0.2128p ps=1.5u w=1.12u l=0.13u
X2304 VGND.t1970 sg13cmos5l_inv_16_76.A sg13cmos5l_inv_16_77.A VGND.t380 sg13_lv_nmos ad=0.2516p pd=2.16u as=0.1406p ps=1.12u w=0.74u l=0.13u
X2305 VPWR.t2390 sg13cmos5l_inv_16_76.A sg13cmos5l_inv_16_75.A VPWR.t25 sg13_lv_pmos ad=0.2128p pd=1.5u as=0.2128p ps=1.5u w=1.12u l=0.13u
X2306 VPWR.t163 VGND.t5 VPWR.t162 VPWR.t0 sg13_lv_pmos ad=0.34p pd=2.68u as=0 ps=0 w=1u l=1u
X2307 sg13cmos5l_inv_16_88.A sg13cmos5l_inv_4_7.Y VPWR.t1618 VPWR.t9 sg13_lv_pmos ad=0.2128p pd=1.5u as=0.3808p ps=2.92u w=1.12u l=0.13u
X2308 VGND.t3 VPWR.t2506 VGND.t3 VGND.t2051 sg13_lv_nmos ad=0.1428p pd=1.52u as=0 ps=0 w=0.42u l=1u
X2309 VGND.t96 VPWR.t2472 VGND.t86 VGND.t2113 sg13_lv_nmos ad=0.1428p pd=1.52u as=0 ps=0 w=0.42u l=1u
X2310 VGND.t425 sg13cmos5l_inv_16_27.A sg13cmos5l_inv_16_27.Y VGND.t1623 sg13_lv_nmos ad=0.1406p pd=1.12u as=0.1406p ps=1.12u w=0.74u l=0.13u
X2311 VGND.t1147 sg13cmos5l_inv_16_48.A sg13cmos5l_inv_16_109.Y VGND.t881 sg13_lv_nmos ad=0.1406p pd=1.12u as=0.1406p ps=1.12u w=0.74u l=0.13u
X2312 sg13cmos5l_inv_16_80.Y sg13cmos5l_inv_16_105.A VGND.t1100 VGND.t1106 sg13_lv_nmos ad=0.1406p pd=1.12u as=0.1406p ps=1.12u w=0.74u l=0.13u
X2313 VGND.t226 sg13cmos5l_inv_8_3.Y sg13cmos5l_inv_16_41.A VGND.t823 sg13_lv_nmos ad=0.1406p pd=1.12u as=0.1406p ps=1.12u w=0.74u l=0.13u
X2314 sg13cmos5l_inv_16_87.A sg13cmos5l_inv_16_73.A VGND.t1469 VGND.t1483 sg13_lv_nmos ad=0.1406p pd=1.12u as=0.1406p ps=1.12u w=0.74u l=0.13u
X2315 VPWR.t2146 sg13cmos5l_inv_16_79.A sg13cmos5l_inv_16_91.Y VPWR.t16 sg13_lv_pmos ad=0.2128p pd=1.5u as=0.2128p ps=1.5u w=1.12u l=0.13u
X2316 VGND.t1779 VPWR.t2546 VGND.t1779 VGND.t380 sg13_lv_nmos ad=79.8f pd=0.8u as=0 ps=0 w=0.42u l=1u
X2317 sg13cmos5l_inv_16_59.Y sg13cmos5l_inv_16_61.A VPWR.t1577 VPWR.t9 sg13_lv_pmos ad=0.2128p pd=1.5u as=0.2128p ps=1.5u w=1.12u l=0.13u
X2318 VGND.t1132 sg13cmos5l_inv_16_67.A sg13cmos5l_inv_16_67.Y VGND.t881 sg13_lv_nmos ad=0.1406p pd=1.12u as=0.1406p ps=1.12u w=0.74u l=0.13u
X2319 sg13cmos5l_inv_16_102.Y sg13cmos5l_inv_16_37.A VGND.t5 VGND.t11 sg13_lv_nmos ad=0.1406p pd=1.12u as=0.1406p ps=1.12u w=0.74u l=0.13u
X2320 VPWR.t1143 sg13cmos5l_inv_16_9.A sg13cmos5l_inv_16_10.Y VPWR.t0 sg13_lv_pmos ad=0.2128p pd=1.5u as=0.2128p ps=1.5u w=1.12u l=0.13u
X2321 VGND.t1147 sg13cmos5l_inv_16_109.Y sg13cmos5l_inv_16_111.A VGND.t881 sg13_lv_nmos ad=0.1406p pd=1.12u as=0.1406p ps=1.12u w=0.74u l=0.13u
X2322 VGND.t882 sg13cmos5l_inv_16_68.A sg13cmos5l_inv_16_68.Y VGND.t881 sg13_lv_nmos ad=0.2516p pd=2.16u as=0.1406p ps=1.12u w=0.74u l=0.13u
X2323 sg13cmos5l_inv_16_50.Y sg13cmos5l_inv_16_46.Y VGND.t1715 VGND.t380 sg13_lv_nmos ad=0.1406p pd=1.12u as=0.1406p ps=1.12u w=0.74u l=0.13u
X2324 sg13cmos5l_inv_16_25.Y sg13cmos5l_inv_16_6.Y VGND.t1381 VGND.t2345 sg13_lv_nmos ad=0.1406p pd=1.12u as=0.1406p ps=1.12u w=0.74u l=0.13u
X2325 sg13cmos5l_inv_16_75.A sg13cmos5l_inv_16_76.A VPWR.t2371 VPWR.t25 sg13_lv_pmos ad=0.2128p pd=1.5u as=0.3808p ps=2.92u w=1.12u l=0.13u
X2326 VPWR.t844 sg13cmos5l_inv_2_2.A sg13cmos5l_inv_2_2.Y VPWR.t177 sg13_lv_pmos ad=0.3864p pd=2.93u as=0.2128p ps=1.5u w=1.12u l=0.13u
X2327 VPWR.t574 sg13cmos5l_inv_16_36.A sg13cmos5l_inv_16_36.Y VPWR.t4 sg13_lv_pmos ad=0.2128p pd=1.5u as=0.2128p ps=1.5u w=1.12u l=0.13u
X2328 sg13cmos5l_inv_16_67.A sg13cmos5l_inv_16_109.Y VGND.t1132 VGND.t881 sg13_lv_nmos ad=0.1406p pd=1.12u as=0.1406p ps=1.12u w=0.74u l=0.13u
X2329 VPWR.t1949 sg13cmos5l_inv_16_111.A sg13cmos5l_inv_16_111.Y VPWR.t16 sg13_lv_pmos ad=0.2128p pd=1.5u as=0.2128p ps=1.5u w=1.12u l=0.13u
X2330 sg13cmos5l_inv_16_77.A sg13cmos5l_inv_16_76.A VGND.t1970 VGND.t380 sg13_lv_nmos ad=0.1406p pd=1.12u as=0.1406p ps=1.12u w=0.74u l=0.13u
X2331 VPWR.t1087 sg13cmos5l_inv_16_1.A sg13cmos5l_inv_16_2.A VPWR.t4 sg13_lv_pmos ad=0.4368p pd=3.02u as=0.2128p ps=1.5u w=1.12u l=0.13u
X2332 sg13cmos5l_inv_16_23.Y sg13cmos5l_inv_16_0.A VPWR.t1246 VPWR.t4 sg13_lv_pmos ad=0.2128p pd=1.5u as=0.2128p ps=1.5u w=1.12u l=0.13u
X2333 VPWR.t89 VGND.t953 VPWR.t88 VPWR.t16 sg13_lv_pmos ad=0.34p pd=2.68u as=0 ps=0 w=1u l=1u
X2334 VGND.t593 sg13cmos5l_inv_16_34.Y sg13cmos5l_inv_16_99.A VGND.t600 sg13_lv_nmos ad=0.1406p pd=1.12u as=0.1406p ps=1.12u w=0.74u l=0.13u
X2335 sg13cmos5l_inv_16_2.Y sg13cmos5l_inv_16_2.A VPWR.t1820 VPWR.t177 sg13_lv_pmos ad=0.2128p pd=1.5u as=0.2128p ps=1.5u w=1.12u l=0.13u
X2336 VGND.t827 sg13cmos5l_inv_16_0.A sg13cmos5l_inv_16_23.Y VGND.t842 sg13_lv_nmos ad=0.2516p pd=2.16u as=0.1406p ps=1.12u w=0.74u l=0.13u
X2337 VGND.t259 sg13cmos5l_inv_16_28.A sg13cmos5l_inv_16_44.A VGND.t265 sg13_lv_nmos ad=0.1406p pd=1.12u as=0.1406p ps=1.12u w=0.74u l=0.13u
X2338 VPWR.t1056 sg13cmos5l_inv_16_5.Y sg13cmos5l_inv_16_110.Y VPWR.t4 sg13_lv_pmos ad=0.2128p pd=1.5u as=0.2128p ps=1.5u w=1.12u l=0.13u
X2339 VGND.t353 sg13cmos5l_inv_16_11.A sg13cmos5l_inv_16_105.A VGND.t359 sg13_lv_nmos ad=0.1406p pd=1.12u as=0.1406p ps=1.12u w=0.74u l=0.13u
X2340 sg13cmos5l_inv_16_105.Y sg13cmos5l_inv_16_105.A VPWR.t1526 VPWR.t0 sg13_lv_pmos ad=0.2128p pd=1.5u as=0.2128p ps=1.5u w=1.12u l=0.13u
X2341 sg13cmos5l_inv_16_68.Y sg13cmos5l_inv_16_68.A VGND.t882 VGND.t881 sg13_lv_nmos ad=0.1406p pd=1.12u as=0.1406p ps=1.12u w=0.74u l=0.13u
X2342 sg13cmos5l_inv_16_41.A sg13cmos5l_inv_8_3.Y VPWR.t1234 VPWR.t4 sg13_lv_pmos ad=0.2128p pd=1.5u as=0.2128p ps=1.5u w=1.12u l=0.13u
X2343 VGND.t1715 sg13cmos5l_inv_16_46.Y sg13cmos5l_inv_16_50.Y VGND.t380 sg13_lv_nmos ad=0.1406p pd=1.12u as=0.1406p ps=1.12u w=0.74u l=0.13u
X2344 sg13cmos5l_inv_16_1.A sg13cmos5l_inv_16_0.A VGND.t827 VGND.t856 sg13_lv_nmos ad=0.1406p pd=1.12u as=0.1406p ps=1.12u w=0.74u l=0.13u
X2345 VGND.t450 VPWR.t2485 VGND.t450 VGND.t2088 sg13_lv_nmos ad=79.8f pd=0.8u as=0 ps=0 w=0.42u l=1u
X2346 VPWR.t1865 sg13cmos5l_inv_16_73.A sg13cmos5l_inv_16_87.A VPWR.t9 sg13_lv_pmos ad=0.2128p pd=1.5u as=0.2128p ps=1.5u w=1.12u l=0.13u
X2347 VGND.t1132 sg13cmos5l_inv_16_109.Y sg13cmos5l_inv_16_67.A VGND.t881 sg13_lv_nmos ad=0.1406p pd=1.12u as=0.1406p ps=1.12u w=0.74u l=0.13u
X2348 VPWR.t1892 sg13cmos5l_inv_16_94.A sg13cmos5l_inv_16_73.A VPWR.t9 sg13_lv_pmos ad=0.2128p pd=1.5u as=0.2128p ps=1.5u w=1.12u l=0.13u
X2349 sg13cmos5l_inv_16_2.A sg13cmos5l_inv_16_1.A VPWR.t1083 VPWR.t4 sg13_lv_pmos ad=0.2128p pd=1.5u as=0.2128p ps=1.5u w=1.12u l=0.13u
X2350 sg13cmos5l_inv_16_37.Y sg13cmos5l_inv_16_37.A VPWR.t467 VPWR.t4 sg13_lv_pmos ad=0.2128p pd=1.5u as=0.2128p ps=1.5u w=1.12u l=0.13u
X2351 sg13cmos5l_inv_16_53.Y sg13cmos5l_inv_16_53.A VPWR.t2060 VPWR.t16 sg13_lv_pmos ad=0.2128p pd=1.5u as=0.2128p ps=1.5u w=1.12u l=0.13u
X2352 VPWR.t2128 sg13cmos5l_inv_16_46.A sg13cmos5l_inv_16_46.Y VPWR.t25 sg13_lv_pmos ad=0.2128p pd=1.5u as=0.2128p ps=1.5u w=1.12u l=0.13u
X2353 VPWR.t272 VGND.t534 VPWR.t272 VPWR.t177 sg13_lv_pmos ad=0.19p pd=1.38u as=0 ps=0 w=1u l=1u
X2354 sg13cmos5l_inv_16_61.A sg13cmos5l_inv_16_71.Y VGND.t963 VGND.t881 sg13_lv_nmos ad=0.1406p pd=1.12u as=0.2516p ps=2.16u w=0.74u l=0.13u
X2355 sg13cmos5l_inv_16_99.A sg13cmos5l_inv_16_34.Y VGND.t593 VGND.t597 sg13_lv_nmos ad=0.1406p pd=1.12u as=0.1406p ps=1.12u w=0.74u l=0.13u
X2356 VGND.t2158 VPWR.t2463 VGND.t2158 VGND.t2159 sg13_lv_nmos ad=79.8f pd=0.8u as=0 ps=0 w=0.42u l=1u
X2357 sg13cmos5l_inv_16_44.A sg13cmos5l_inv_16_28.A VGND.t259 VGND.t262 sg13_lv_nmos ad=0.1406p pd=1.12u as=0.1406p ps=1.12u w=0.74u l=0.13u
X2358 VPWR.t1566 sg13cmos5l_inv_16_109.Y sg13cmos5l_inv_16_111.A VPWR.t9 sg13_lv_pmos ad=0.3808p pd=2.92u as=0.2128p ps=1.5u w=1.12u l=0.13u
X2359 VPWR.t5 VGND.t259 VPWR.t366 VPWR.t4 sg13_lv_pmos ad=0.34p pd=2.68u as=0 ps=0 w=1u l=1u
X2360 sg13cmos5l_and2_1_7.B a_2920_9192# VPWR.t1960 VPWR.t9 sg13_lv_pmos ad=0.42p pd=2.99u as=0.2114p ps=1.54u w=1.12u l=0.13u
X2361 VGND.t882 sg13cmos5l_inv_16_71.Y sg13cmos5l_inv_16_68.A VGND.t881 sg13_lv_nmos ad=0.1406p pd=1.12u as=0.1406p ps=1.12u w=0.74u l=0.13u
X2362 VPWR.t1524 sg13cmos5l_inv_16_105.A sg13cmos5l_inv_16_105.Y VPWR.t0 sg13_lv_pmos ad=0.2128p pd=1.5u as=0.2128p ps=1.5u w=1.12u l=0.13u
X2363 VPWR.t1959 sg13cmos5l_inv_4_0.A sg13cmos5l_inv_4_0.Y VPWR.t177 sg13_lv_pmos ad=0.3808p pd=2.92u as=0.2128p ps=1.5u w=1.12u l=0.13u
X2364 sg13cmos5l_inv_16_98.Y sg13cmos5l_inv_16_111.A VGND.t1541 VGND.t1547 sg13_lv_nmos ad=0.1406p pd=1.12u as=0.1406p ps=1.12u w=0.74u l=0.13u
X2365 VGND.t922 sg13cmos5l_inv_16_69.Y sg13cmos5l_inv_16_62.Y VGND.t881 sg13_lv_nmos ad=0.1406p pd=1.12u as=0.1406p ps=1.12u w=0.74u l=0.13u
X2366 sg13cmos5l_inv_16_73.Y sg13cmos5l_inv_16_73.A VGND.t381 VGND.t380 sg13_lv_nmos ad=0.1406p pd=1.12u as=0.1406p ps=1.12u w=0.74u l=0.13u
X2367 sg13cmos5l_inv_16_102.Y sg13cmos5l_inv_16_37.A VGND.t5 VGND.t7 sg13_lv_nmos ad=0.1406p pd=1.12u as=0.1406p ps=1.12u w=0.74u l=0.13u
X2368 sg13cmos5l_inv_16_104.Y sg13cmos5l_inv_16_14.A VPWR.t911 VPWR.t0 sg13_lv_pmos ad=0.2128p pd=1.5u as=0.2128p ps=1.5u w=1.12u l=0.13u
X2369 VPWR.t2295 sg13cmos5l_inv_16_47.A sg13cmos5l_inv_16_45.Y VPWR.t16 sg13_lv_pmos ad=0.2128p pd=1.5u as=0.2128p ps=1.5u w=1.12u l=0.13u
X2370 VPWR.t1510 sg13cmos5l_inv_16_105.A sg13cmos5l_inv_16_80.Y VPWR.t25 sg13_lv_pmos ad=0.2128p pd=1.5u as=0.2128p ps=1.5u w=1.12u l=0.13u
X2371 VGND.t326 sg13cmos5l_inv_16_26.Y sg13cmos5l_inv_16_40.Y VGND.t331 sg13_lv_nmos ad=0.1406p pd=1.12u as=0.1406p ps=1.12u w=0.74u l=0.13u
X2372 VPWR.t893 sg13cmos5l_inv_16_20.A sg13cmos5l_inv_16_20.Y VPWR.t4 sg13_lv_pmos ad=0.2128p pd=1.5u as=0.2128p ps=1.5u w=1.12u l=0.13u
X2373 VPWR.t625 sg13cmos5l_inv_16_44.A sg13cmos5l_inv_16_44.Y VPWR.t4 sg13_lv_pmos ad=0.2128p pd=1.5u as=0.2128p ps=1.5u w=1.12u l=0.13u
X2374 VGND.t1820 VPWR.t2573 VGND.t1820 VGND.t881 sg13_lv_nmos ad=0.1428p pd=1.52u as=0 ps=0 w=0.42u l=1u
X2375 VGND.t3 VPWR.t2505 VGND.t3 VGND.t2053 sg13_lv_nmos ad=79.8f pd=0.8u as=0 ps=0 w=0.42u l=1u
X2376 sg13cmos5l_inv_16_44.Y sg13cmos5l_inv_16_44.A VGND.t198 VGND.t210 sg13_lv_nmos ad=0.1406p pd=1.12u as=0.1406p ps=1.12u w=0.74u l=0.13u
X2377 VGND.t545 sg13cmos5l_inv_16_96.A sg13cmos5l_inv_16_96.Y VGND.t950 sg13_lv_nmos ad=0.1406p pd=1.12u as=0.1406p ps=1.12u w=0.74u l=0.13u
X2378 VGND.t3 sg13cmos5l_and2_1_4.B a_7051_3492# VGND.t251 sg13_lv_nmos ad=0.1331p pd=1.12u as=0.1216p ps=1.02u w=0.64u l=0.13u
X2379 VPWR.t2375 sg13cmos5l_inv_16_76.A sg13cmos5l_inv_16_77.A VPWR.t16 sg13_lv_pmos ad=0.2128p pd=1.5u as=0.2128p ps=1.5u w=1.12u l=0.13u
X2380 sg13cmos5l_inv_16_101.Y sg13cmos5l_inv_16_34.Y VPWR.t1036 VPWR.t0 sg13_lv_pmos ad=0.2128p pd=1.5u as=0.2128p ps=1.5u w=1.12u l=0.13u
X2381 VPWR.t1544 sg13cmos5l_inv_16_109.Y sg13cmos5l_inv_16_67.A VPWR.t9 sg13_lv_pmos ad=0.2128p pd=1.5u as=0.2128p ps=1.5u w=1.12u l=0.13u
X2382 sg13cmos5l_inv_16_68.A sg13cmos5l_inv_16_71.Y VGND.t882 VGND.t881 sg13_lv_nmos ad=0.1406p pd=1.12u as=0.1406p ps=1.12u w=0.74u l=0.13u
X2383 VGND.t898 sg13cmos5l_inv_2_5.A sg13cmos5l_inv_2_5.Y VGND.t881 sg13_lv_nmos ad=0.2516p pd=2.16u as=0.1406p ps=1.12u w=0.74u l=0.13u
X2384 sg13cmos5l_inv_16_105.Y sg13cmos5l_inv_16_105.A VPWR.t1520 VPWR.t0 sg13_lv_pmos ad=0.2128p pd=1.5u as=0.2128p ps=1.5u w=1.12u l=0.13u
X2385 VGND.t1541 sg13cmos5l_inv_16_111.A sg13cmos5l_inv_16_98.Y VGND.t1544 sg13_lv_nmos ad=0.1406p pd=1.12u as=0.1406p ps=1.12u w=0.74u l=0.13u
X2386 VGND.t545 VPWR.t2516 VGND.t545 VGND.t2032 sg13_lv_nmos ad=0.1428p pd=1.52u as=0 ps=0 w=0.42u l=1u
X2387 sg13cmos5l_inv_16_29.A sg13cmos5l_inv_16_28.A VPWR.t707 VPWR.t177 sg13_lv_pmos ad=0.2128p pd=1.5u as=0.2128p ps=1.5u w=1.12u l=0.13u
X2388 sg13cmos5l_inv_16_62.Y sg13cmos5l_inv_16_69.Y VGND.t922 VGND.t881 sg13_lv_nmos ad=0.1406p pd=1.12u as=0.1406p ps=1.12u w=0.74u l=0.13u
X2389 sg13cmos5l_inv_16_84.Y sg13cmos5l_inv_16_84.A VPWR.t1487 VPWR.t9 sg13_lv_pmos ad=0.2128p pd=1.5u as=0.3808p ps=2.92u w=1.12u l=0.13u
X2390 sg13cmos5l_inv_16_103.Y sg13cmos5l_inv_16_103.A VPWR.t1613 VPWR.t0 sg13_lv_pmos ad=0.2128p pd=1.5u as=0.2128p ps=1.5u w=1.12u l=0.13u
X2391 VPWR.t687 en[0] a_2920_908# VPWR.t177 sg13_lv_pmos ad=0.2114p pd=1.54u as=0.2856p ps=2.36u w=0.84u l=0.13u
X2392 VPWR.t246 sg13cmos5l_inv_16_6.A sg13cmos5l_inv_16_6.Y VPWR.t177 sg13_lv_pmos ad=0.2128p pd=1.5u as=0.2128p ps=1.5u w=1.12u l=0.13u
X2393 VPWR.t1635 sg13cmos5l_inv_4_2.Y sg13cmos5l_inv_8_3.Y VPWR.t4 sg13_lv_pmos ad=0.2128p pd=1.5u as=0.2128p ps=1.5u w=1.12u l=0.13u
X2394 VPWR.t194 VGND.t1718 VPWR.t195 VPWR.t25 sg13_lv_pmos ad=0.19p pd=1.38u as=0 ps=0 w=1u l=1u
X2395 sg13cmos5l_inv_16_99.A sg13cmos5l_inv_16_34.Y VPWR.t1022 VPWR.t25 sg13_lv_pmos ad=0.2128p pd=1.5u as=0.2128p ps=1.5u w=1.12u l=0.13u
X2396 sg13cmos5l_inv_16_40.Y sg13cmos5l_inv_16_26.Y VGND.t326 VGND.t328 sg13_lv_nmos ad=0.1406p pd=1.12u as=0.1406p ps=1.12u w=0.74u l=0.13u
X2397 a_13664_4097# sg13cmos5l_buf_1_15.X VPWR.t621 VPWR.t0 sg13_lv_pmos ad=0.1596p pd=1.22u as=0.1918p ps=1.5u w=0.84u l=0.13u
X2398 VGND.t1944 sg13cmos5l_inv_8_4.Y sg13cmos5l_inv_16_56.Y VGND.t380 sg13_lv_nmos ad=0.1406p pd=1.12u as=0.1406p ps=1.12u w=0.74u l=0.13u
X2399 sg13cmos5l_inv_16_105.A sg13cmos5l_inv_16_11.A VPWR.t784 VPWR.t25 sg13_lv_pmos ad=0.2128p pd=1.5u as=0.2128p ps=1.5u w=1.12u l=0.13u
X2400 VPWR.t1396 sg13cmos5l_inv_16_71.Y sg13cmos5l_inv_16_68.A VPWR.t9 sg13_lv_pmos ad=0.2128p pd=1.5u as=0.2128p ps=1.5u w=1.12u l=0.13u
X2401 sg13cmos5l_inv_16_37.Y sg13cmos5l_inv_16_37.A VPWR.t448 VPWR.t4 sg13_lv_pmos ad=0.2128p pd=1.5u as=0.3808p ps=2.92u w=1.12u l=0.13u
X2402 sg13cmos5l_inv_16_77.A sg13cmos5l_inv_16_76.A VPWR.t2372 VPWR.t16 sg13_lv_pmos ad=0.2128p pd=1.5u as=0.4368p ps=3.02u w=1.12u l=0.13u
X2403 VGND.t1026 sg13cmos5l_inv_16_79.A sg13cmos5l_inv_16_91.Y VGND.t881 sg13_lv_nmos ad=0.1406p pd=1.12u as=0.1406p ps=1.12u w=0.74u l=0.13u
X2404 VGND.t326 sg13cmos5l_inv_4_2.Y sg13cmos5l_inv_8_3.Y VGND.t1240 sg13_lv_nmos ad=0.2516p pd=2.16u as=0.1443p ps=1.13u w=0.74u l=0.13u
X2405 VPWR.t1034 sg13cmos5l_inv_16_34.Y sg13cmos5l_inv_16_101.Y VPWR.t0 sg13_lv_pmos ad=0.2128p pd=1.5u as=0.2128p ps=1.5u w=1.12u l=0.13u
X2406 sg13cmos5l_inv_16_67.A sg13cmos5l_inv_16_109.Y VPWR.t1540 VPWR.t9 sg13_lv_pmos ad=0.2128p pd=1.5u as=0.2128p ps=1.5u w=1.12u l=0.13u
X2407 VGND.t1147 sg13cmos5l_inv_16_109.Y sg13cmos5l_inv_16_111.A VGND.t881 sg13_lv_nmos ad=0.1406p pd=1.12u as=0.1406p ps=1.12u w=0.74u l=0.13u
X2408 VGND.t1132 sg13cmos5l_inv_16_67.A sg13cmos5l_inv_16_67.Y VGND.t881 sg13_lv_nmos ad=0.1406p pd=1.12u as=0.1406p ps=1.12u w=0.74u l=0.13u
X2409 VGND.t637 sg13cmos5l_inv_16_6.A sg13cmos5l_inv_16_5.Y VGND.t1395 sg13_lv_nmos ad=0.1406p pd=1.12u as=0.1406p ps=1.12u w=0.74u l=0.13u
X2410 a_3597_916# sg13cmos5l_buf_1_8.X VPWR.t272 VPWR.t177 sg13_lv_pmos ad=0.1596p pd=1.22u as=0.2856p ps=2.36u w=0.84u l=0.13u
X2411 sg13cmos5l_inv_16_43.Y sg13cmos5l_inv_16_27.Y VPWR.t1654 VPWR.t4 sg13_lv_pmos ad=0.2128p pd=1.5u as=0.2128p ps=1.5u w=1.12u l=0.13u
X2412 VPWR.t1369 sg13cmos5l_inv_16_71.Y sg13cmos5l_inv_16_61.A VPWR.t9 sg13_lv_pmos ad=0.2128p pd=1.5u as=0.2128p ps=1.5u w=1.12u l=0.13u
X2413 VPWR.t1020 sg13cmos5l_inv_16_34.Y sg13cmos5l_inv_16_99.A VPWR.t25 sg13_lv_pmos ad=0.2128p pd=1.5u as=0.2128p ps=1.5u w=1.12u l=0.13u
X2414 sg13cmos5l_inv_16_75.Y sg13cmos5l_inv_16_75.A VGND.t122 VGND.t409 sg13_lv_nmos ad=0.1406p pd=1.12u as=0.1406p ps=1.12u w=0.74u l=0.13u
X2415 sg13cmos5l_inv_16_103.A sg13cmos5l_inv_16_11.A VPWR.t796 VPWR.t0 sg13_lv_pmos ad=0.2128p pd=1.5u as=0.2128p ps=1.5u w=1.12u l=0.13u
X2416 sg13cmos5l_inv_16_23.Y sg13cmos5l_inv_16_0.A VPWR.t1242 VPWR.t4 sg13_lv_pmos ad=0.2128p pd=1.5u as=0.2128p ps=1.5u w=1.12u l=0.13u
X2417 VPWR.t889 sg13cmos5l_inv_16_20.A sg13cmos5l_inv_16_20.Y VPWR.t4 sg13_lv_pmos ad=0.2128p pd=1.5u as=0.2128p ps=1.5u w=1.12u l=0.13u
X2418 sg13cmos5l_inv_16_68.A sg13cmos5l_inv_16_71.Y VPWR.t1392 VPWR.t9 sg13_lv_pmos ad=0.2128p pd=1.5u as=0.2128p ps=1.5u w=1.12u l=0.13u
X2419 sg13cmos5l_inv_16_81.Y sg13cmos5l_inv_16_96.Y VGND.t953 VGND.t380 sg13_lv_nmos ad=0.1406p pd=1.12u as=0.1406p ps=1.12u w=0.74u l=0.13u
X2420 VPWR.t233 VGND.t2139 VPWR.t233 VPWR.t177 sg13_lv_pmos ad=0.34p pd=2.68u as=0 ps=0 w=1u l=1u
X2421 sg13cmos5l_inv_16_2.Y sg13cmos5l_inv_16_2.A VGND.t655 VGND.t1444 sg13_lv_nmos ad=0.1406p pd=1.12u as=0.1406p ps=1.12u w=0.74u l=0.13u
X2422 VPWR.t122 VGND.t1879 VPWR.t68 VPWR.t9 sg13_lv_pmos ad=0.19p pd=1.38u as=0 ps=0 w=1u l=1u
X2423 sg13cmos5l_inv_16_62.Y sg13cmos5l_inv_16_69.Y VPWR.t1336 VPWR.t9 sg13_lv_pmos ad=0.2128p pd=1.5u as=0.2128p ps=1.5u w=1.12u l=0.13u
X2424 VGND.t1792 VPWR.t2545 VGND.t1792 VGND.t380 sg13_lv_nmos ad=79.8f pd=0.8u as=0 ps=0 w=0.42u l=1u
X2425 sg13cmos5l_inv_16_20.A sg13cmos5l_inv_16_8.Y VPWR.t969 VPWR.t0 sg13_lv_pmos ad=0.2128p pd=1.5u as=0.4368p ps=3.02u w=1.12u l=0.13u
X2426 sg13cmos5l_inv_16_35.Y sg13cmos5l_inv_16_29.A VGND.t257 VGND.t256 sg13_lv_nmos ad=0.1406p pd=1.12u as=0.2516p ps=2.16u w=0.74u l=0.13u
X2427 sg13cmos5l_inv_16_67.Y sg13cmos5l_inv_16_67.A VGND.t1132 VGND.t881 sg13_lv_nmos ad=0.1406p pd=1.12u as=0.1406p ps=1.12u w=0.74u l=0.13u
X2428 sg13cmos5l_inv_16_19.Y sg13cmos5l_inv_16_17.A VGND.t86 VGND.t92 sg13_lv_nmos ad=0.1406p pd=1.12u as=0.1406p ps=1.12u w=0.74u l=0.13u
X2429 sg13cmos5l_inv_16_5.Y sg13cmos5l_inv_16_6.A VGND.t637 VGND.t1392 sg13_lv_nmos ad=0.1406p pd=1.12u as=0.1406p ps=1.12u w=0.74u l=0.13u
X2430 sg13cmos5l_inv_16_54.Y sg13cmos5l_inv_16_101.Y VPWR.t2321 VPWR.t25 sg13_lv_pmos ad=0.2128p pd=1.5u as=0.3808p ps=2.92u w=1.12u l=0.13u
X2431 VGND.t390 sg13cmos5l_inv_16_75.A sg13cmos5l_inv_16_74.Y VGND.t380 sg13_lv_nmos ad=0.1406p pd=1.12u as=0.1406p ps=1.12u w=0.74u l=0.13u
X2432 sg13cmos5l_inv_16_96.Y sg13cmos5l_inv_16_96.A VPWR.t1356 VPWR.t25 sg13_lv_pmos ad=0.2128p pd=1.5u as=0.2128p ps=1.5u w=1.12u l=0.13u
X2433 sg13cmos5l_inv_16_1.A sg13cmos5l_inv_16_0.A VGND.t827 VGND.t852 sg13_lv_nmos ad=0.1406p pd=1.12u as=0.1406p ps=1.12u w=0.74u l=0.13u
X2434 VPWR.t794 sg13cmos5l_inv_16_11.A sg13cmos5l_inv_16_103.A VPWR.t0 sg13_lv_pmos ad=0.2128p pd=1.5u as=0.2128p ps=1.5u w=1.12u l=0.13u
X2435 sg13cmos5l_and2_1_7.B a_2920_9192# VGND.t916 VGND.t1578 sg13_lv_nmos ad=0.2886p pd=2.26u as=0.14875p ps=1.16u w=0.74u l=0.13u
X2436 sg13cmos5l_inv_16_53.A sg13cmos5l_inv_16_52.Y VGND.t1164 VGND.t881 sg13_lv_nmos ad=0.1406p pd=1.12u as=0.1406p ps=1.12u w=0.74u l=0.13u
X2437 sg13cmos5l_inv_16_73.Y sg13cmos5l_inv_16_73.A VPWR.t1870 VPWR.t16 sg13_lv_pmos ad=0.2128p pd=1.5u as=0.3808p ps=2.92u w=1.12u l=0.13u
X2438 VPWR.t1390 sg13cmos5l_inv_16_71.Y sg13cmos5l_inv_16_68.A VPWR.t9 sg13_lv_pmos ad=0.2128p pd=1.5u as=0.2128p ps=1.5u w=1.12u l=0.13u
X2439 VGND.t1792 sg13cmos5l_inv_16_96.Y sg13cmos5l_inv_16_81.Y VGND.t380 sg13_lv_nmos ad=0.1406p pd=1.12u as=0.1406p ps=1.12u w=0.74u l=0.13u
X2440 sg13cmos5l_inv_16_23.Y sg13cmos5l_inv_16_0.A VGND.t827 VGND.t835 sg13_lv_nmos ad=0.1406p pd=1.12u as=0.1406p ps=1.12u w=0.74u l=0.13u
X2441 VPWR.t1310 sg13cmos5l_inv_1_5.Y sg13cmos5l_inv_4_6.A VPWR.t25 sg13_lv_pmos ad=0.3864p pd=2.93u as=0.2128p ps=1.5u w=1.12u l=0.13u
X2442 VPWR.t178 a_8204_834# sg13cmos5l_buf_1_5.X VPWR.t177 sg13_lv_pmos ad=0.2114p pd=1.54u as=0.42p ps=2.99u w=1.12u l=0.13u
X2443 VGND.t655 sg13cmos5l_inv_16_2.A sg13cmos5l_inv_16_2.Y VGND.t1441 sg13_lv_nmos ad=0.1406p pd=1.12u as=0.1406p ps=1.12u w=0.74u l=0.13u
X2444 VGND.t864 VPWR.t2604 VGND.t1178 VGND.t1876 sg13_lv_nmos ad=0.1428p pd=1.52u as=0 ps=0 w=0.42u l=1u
X2445 sg13cmos5l_inv_16_69.Y sg13cmos5l_inv_16_52.Y VGND.t922 VGND.t881 sg13_lv_nmos ad=0.1406p pd=1.12u as=0.1406p ps=1.12u w=0.74u l=0.13u
X2446 sg13cmos5l_inv_16_36.A sg13cmos5l_inv_16_43.Y VPWR.t610 VPWR.t0 sg13_lv_pmos ad=0.2128p pd=1.5u as=0.2128p ps=1.5u w=1.12u l=0.13u
X2447 VGND.t345 sg13cmos5l_inv_16_105.A sg13cmos5l_inv_16_105.Y VGND.t1115 sg13_lv_nmos ad=0.2516p pd=2.16u as=0.1406p ps=1.12u w=0.74u l=0.13u
X2448 VPWR.t1839 sg13cmos5l_inv_8_1.Y sg13cmos5l_inv_16_4.Y VPWR.t177 sg13_lv_pmos ad=0.2128p pd=1.5u as=0.2128p ps=1.5u w=1.12u l=0.13u
X2449 VGND.t637 sg13cmos5l_inv_16_6.A sg13cmos5l_inv_16_5.Y VGND.t1389 sg13_lv_nmos ad=0.1406p pd=1.12u as=0.1406p ps=1.12u w=0.74u l=0.13u
X2450 sg13cmos5l_inv_16_73.Y sg13cmos5l_inv_16_73.A VGND.t381 VGND.t380 sg13_lv_nmos ad=0.1406p pd=1.12u as=0.1406p ps=1.12u w=0.74u l=0.13u
X2451 VPWR.t145 VGND.t3 VPWR.t143 VPWR.t0 sg13_lv_pmos ad=0.19p pd=1.38u as=0 ps=0 w=1u l=1u
X2452 VGND.t86 sg13cmos5l_inv_16_17.A sg13cmos5l_inv_16_19.Y VGND.t89 sg13_lv_nmos ad=0.1406p pd=1.12u as=0.1406p ps=1.12u w=0.74u l=0.13u
X2453 sg13cmos5l_inv_16_11.A sg13cmos5l_inv_16_96.Y VGND.t1792 VGND.t380 sg13_lv_nmos ad=0.1406p pd=1.12u as=0.1406p ps=1.12u w=0.74u l=0.13u
X2454 VPWR.t1506 sg13cmos5l_inv_16_105.A sg13cmos5l_inv_16_80.Y VPWR.t25 sg13_lv_pmos ad=0.2128p pd=1.5u as=0.2128p ps=1.5u w=1.12u l=0.13u
X2455 sg13cmos5l_inv_16_22.Y sg13cmos5l_inv_16_20.A VPWR.t868 VPWR.t0 sg13_lv_pmos ad=0.2128p pd=1.5u as=0.2128p ps=1.5u w=1.12u l=0.13u
X2456 VGND.t827 sg13cmos5l_inv_16_0.A sg13cmos5l_inv_16_1.A VGND.t849 sg13_lv_nmos ad=0.1406p pd=1.12u as=0.1406p ps=1.12u w=0.74u l=0.13u
X2457 VPWR.t1228 sg13cmos5l_inv_8_3.Y sg13cmos5l_inv_16_41.A VPWR.t4 sg13_lv_pmos ad=0.2128p pd=1.5u as=0.2128p ps=1.5u w=1.12u l=0.13u
X2458 sg13cmos5l_inv_16_87.A sg13cmos5l_inv_16_73.A VPWR.t1857 VPWR.t9 sg13_lv_pmos ad=0.2128p pd=1.5u as=0.2128p ps=1.5u w=1.12u l=0.13u
X2459 sg13cmos5l_inv_16_15.A sg13cmos5l_inv_16_23.Y VPWR.t490 VPWR.t0 sg13_lv_pmos ad=0.2128p pd=1.5u as=0.2128p ps=1.5u w=1.12u l=0.13u
X2460 VPWR.t165 VGND.t86 VPWR.t440 VPWR.t4 sg13_lv_pmos ad=0.34p pd=2.68u as=0 ps=0 w=1u l=1u
X2461 sg13cmos5l_inv_16_111.A sg13cmos5l_inv_16_109.Y VPWR.t1559 VPWR.t9 sg13_lv_pmos ad=0.2128p pd=1.5u as=0.2128p ps=1.5u w=1.12u l=0.13u
X2462 VPWR.t2206 sg13cmos5l_inv_16_73.Y sg13cmos5l_inv_16_95.Y VPWR.t16 sg13_lv_pmos ad=0.2128p pd=1.5u as=0.2128p ps=1.5u w=1.12u l=0.13u
X2463 VGND.t922 sg13cmos5l_inv_16_52.Y sg13cmos5l_inv_16_69.Y VGND.t881 sg13_lv_nmos ad=0.1406p pd=1.12u as=0.1406p ps=1.12u w=0.74u l=0.13u
X2464 sg13cmos5l_inv_16_48.A sg13cmos5l_inv_8_7.Y VGND.t756 VGND.t380 sg13_lv_nmos ad=0.1406p pd=1.12u as=0.1406p ps=1.12u w=0.74u l=0.13u
X2465 VGND.t162 VPWR.t2492 VGND.t162 VGND.t2056 sg13_lv_nmos ad=79.8f pd=0.8u as=0 ps=0 w=0.42u l=1u
X2466 VPWR.t8 VGND.t2045 VPWR.t7 VPWR.t4 sg13_lv_pmos ad=0.34p pd=2.68u as=0 ps=0 w=1u l=1u
X2467 sg13cmos5l_inv_16_17.Y sg13cmos5l_inv_16_17.A VGND.t111 VGND.t118 sg13_lv_nmos ad=0.1406p pd=1.12u as=0.1406p ps=1.12u w=0.74u l=0.13u
X2468 VPWR.t832 sg13cmos5l_inv_16_75.A sg13cmos5l_inv_16_75.Y VPWR.t25 sg13_lv_pmos ad=0.2128p pd=1.5u as=0.2128p ps=1.5u w=1.12u l=0.13u
X2469 sg13cmos5l_inv_16_105.Y sg13cmos5l_inv_16_105.A VGND.t345 VGND.t1112 sg13_lv_nmos ad=0.1406p pd=1.12u as=0.1406p ps=1.12u w=0.74u l=0.13u
X2470 sg13cmos5l_inv_16_4.Y sg13cmos5l_inv_8_1.Y VPWR.t329 VPWR.t177 sg13_lv_pmos ad=0.2128p pd=1.5u as=0.3808p ps=2.92u w=1.12u l=0.13u
X2471 VPWR.t267 VGND.t1553 VPWR.t266 VPWR.t9 sg13_lv_pmos ad=0.34p pd=2.68u as=0 ps=0 w=1u l=1u
X2472 sg13cmos5l_inv_16_87.Y sg13cmos5l_inv_16_87.A VGND.t1010 VGND.t881 sg13_lv_nmos ad=0.1406p pd=1.12u as=0.1406p ps=1.12u w=0.74u l=0.13u
X2473 VGND.t381 sg13cmos5l_inv_16_73.A sg13cmos5l_inv_16_73.Y VGND.t380 sg13_lv_nmos ad=0.1406p pd=1.12u as=0.1406p ps=1.12u w=0.74u l=0.13u
X2474 sg13cmos5l_inv_16_29.A sg13cmos5l_inv_16_28.A VGND.t198 VGND.t210 sg13_lv_nmos ad=0.1406p pd=1.12u as=0.1406p ps=1.12u w=0.74u l=0.13u
X2475 sg13cmos5l_inv_16_62.Y sg13cmos5l_inv_16_69.Y VGND.t922 VGND.t881 sg13_lv_nmos ad=0.1406p pd=1.12u as=0.1406p ps=1.12u w=0.74u l=0.13u
X2476 sg13cmos5l_inv_16_80.Y sg13cmos5l_inv_16_105.A VPWR.t1503 VPWR.t25 sg13_lv_pmos ad=0.2128p pd=1.5u as=0.3808p ps=2.92u w=1.12u l=0.13u
X2477 VPWR.t905 sg13cmos5l_inv_16_14.A sg13cmos5l_inv_16_104.Y VPWR.t0 sg13_lv_pmos ad=0.2128p pd=1.5u as=0.2128p ps=1.5u w=1.12u l=0.13u
X2478 sg13cmos5l_inv_16_28.A sg13cmos5l_inv_16_41.A VPWR.t679 VPWR.t4 sg13_lv_pmos ad=0.2128p pd=1.5u as=0.2128p ps=1.5u w=1.12u l=0.13u
X2479 VGND.t1944 sg13cmos5l_inv_8_4.Y sg13cmos5l_inv_16_56.Y VGND.t380 sg13_lv_nmos ad=0.1406p pd=1.12u as=0.1406p ps=1.12u w=0.74u l=0.13u
X2480 VPWR.t488 sg13cmos5l_inv_16_23.Y sg13cmos5l_inv_16_15.A VPWR.t0 sg13_lv_pmos ad=0.2128p pd=1.5u as=0.2128p ps=1.5u w=1.12u l=0.13u
X2481 VGND.t111 sg13cmos5l_inv_16_17.A sg13cmos5l_inv_16_17.Y VGND.t113 sg13_lv_nmos ad=0.1406p pd=1.12u as=0.1406p ps=1.12u w=0.74u l=0.13u
X2482 sg13cmos5l_inv_8_1.Y sg13cmos5l_inv_8_1.A VGND.t84 VGND.t1427 sg13_lv_nmos ad=0.1406p pd=1.12u as=0.1406p ps=1.12u w=0.74u l=0.13u
X2483 VGND.t472 VPWR.t2510 VGND.t2012 VGND.t2043 sg13_lv_nmos ad=79.8f pd=0.8u as=0 ps=0 w=0.42u l=1u
X2484 VGND.t994 VPWR.t2595 VGND.t994 VGND.t1896 sg13_lv_nmos ad=79.8f pd=0.8u as=0 ps=0 w=0.42u l=1u
X2485 VPWR.t2058 sg13cmos5l_inv_16_56.Y sg13cmos5l_inv_16_52.Y VPWR.t16 sg13_lv_pmos ad=0.4368p pd=3.02u as=0.2128p ps=1.5u w=1.12u l=0.13u
X2486 sg13cmos5l_inv_16_36.A sg13cmos5l_inv_16_43.Y VPWR.t606 VPWR.t0 sg13_lv_pmos ad=0.2128p pd=1.5u as=0.2128p ps=1.5u w=1.12u l=0.13u
X2487 VPWR.t2106 sg13cmos5l_inv_16_48.A sg13cmos5l_inv_16_46.A VPWR.t25 sg13_lv_pmos ad=0.2128p pd=1.5u as=0.2128p ps=1.5u w=1.12u l=0.13u
X2488 VGND.t593 sg13cmos5l_inv_16_34.Y sg13cmos5l_inv_16_101.Y VGND.t606 sg13_lv_nmos ad=0.1406p pd=1.12u as=0.1406p ps=1.12u w=0.74u l=0.13u
X2489 VGND.t1010 sg13cmos5l_inv_16_87.A sg13cmos5l_inv_16_87.Y VGND.t881 sg13_lv_nmos ad=0.1406p pd=1.12u as=0.1406p ps=1.12u w=0.74u l=0.13u
X2490 VPWR.t1016 sg13cmos5l_inv_16_34.Y sg13cmos5l_inv_16_99.A VPWR.t25 sg13_lv_pmos ad=0.2128p pd=1.5u as=0.2128p ps=1.5u w=1.12u l=0.13u
X2491 VGND.t45 sg13cmos5l_inv_16_15.A sg13cmos5l_inv_16_13.Y VGND.t514 sg13_lv_nmos ad=0.1406p pd=1.12u as=0.1406p ps=1.12u w=0.74u l=0.13u
X2492 VPWR.t1484 sg13cmos5l_inv_16_84.A sg13cmos5l_inv_16_85.Y VPWR.t9 sg13_lv_pmos ad=0.2128p pd=1.5u as=0.2128p ps=1.5u w=1.12u l=0.13u
X2493 VPWR.t149 VGND.t3 VPWR.t148 VPWR.t4 sg13_lv_pmos ad=0.34p pd=2.68u as=0 ps=0 w=1u l=1u
X2494 VPWR.t2088 sg13cmos5l_inv_16_48.A sg13cmos5l_inv_16_109.Y VPWR.t16 sg13_lv_pmos ad=0.2128p pd=1.5u as=0.2128p ps=1.5u w=1.12u l=0.13u
X2495 sg13cmos5l_inv_16_56.Y sg13cmos5l_inv_8_4.Y VGND.t1663 VGND.t380 sg13_lv_nmos ad=0.1406p pd=1.12u as=0.1406p ps=1.12u w=0.74u l=0.13u
X2496 VGND.t343 sg13cmos5l_and2_1_3.B a_5227_916# VGND.t1377 sg13_lv_nmos ad=0.1331p pd=1.12u as=0.1216p ps=1.02u w=0.64u l=0.13u
X2497 VPWR.t537 sg13cmos5l_inv_16_17.A sg13cmos5l_inv_16_17.Y VPWR.t177 sg13_lv_pmos ad=0.4368p pd=3.02u as=0.2128p ps=1.5u w=1.12u l=0.13u
X2498 sg13cmos5l_inv_16_108.Y sg13cmos5l_inv_16_6.Y VPWR.t246 VPWR.t177 sg13_lv_pmos ad=0.2128p pd=1.5u as=0.2128p ps=1.5u w=1.12u l=0.13u
X2499 VPWR.t435 VGND.t1243 VPWR.t434 VPWR.t4 sg13_lv_pmos ad=0.34p pd=2.68u as=0 ps=0 w=1u l=1u
X2500 VGND.t922 VPWR.t2592 VGND.t1241 VGND.t881 sg13_lv_nmos ad=79.8f pd=0.8u as=0 ps=0 w=0.42u l=1u
X2501 VGND.t1507 sg13cmos5l_inv_16_94.A sg13cmos5l_inv_16_73.A VGND.t881 sg13_lv_nmos ad=0.1406p pd=1.12u as=0.1406p ps=1.12u w=0.74u l=0.13u
X2502 VGND.t2140 VPWR.t233 VGND.t2142 VGND.t2141 sg13_lv_nmos ad=79.8f pd=0.8u as=0 ps=0 w=0.42u l=1u
X2503 VPWR.t851 VGND.t1143 VPWR.t849 VPWR.t9 sg13_lv_pmos ad=0.19p pd=1.38u as=0 ps=0 w=1u l=1u
X2504 sg13cmos5l_inv_16_10.Y sg13cmos5l_inv_16_9.A VGND.t723 VGND.t729 sg13_lv_nmos ad=0.1406p pd=1.12u as=0.1406p ps=1.12u w=0.74u l=0.13u
X2505 sg13cmos5l_inv_16_52.Y sg13cmos5l_inv_16_56.Y VPWR.t2054 VPWR.t16 sg13_lv_pmos ad=0.2128p pd=1.5u as=0.2128p ps=1.5u w=1.12u l=0.13u
X2506 sg13cmos5l_inv_16_29.Y sg13cmos5l_inv_16_29.A VGND.t705 VGND.t707 sg13_lv_nmos ad=0.1406p pd=1.12u as=0.1406p ps=1.12u w=0.74u l=0.13u
X2507 sg13cmos5l_inv_16_20.A sg13cmos5l_inv_16_8.Y VGND.t545 VGND.t552 sg13_lv_nmos ad=0.1406p pd=1.12u as=0.1406p ps=1.12u w=0.74u l=0.13u
X2508 VPWR.t59 VGND.t1029 VPWR.t58 VPWR.t9 sg13_lv_pmos ad=0.34p pd=2.68u as=0 ps=0 w=1u l=1u
X2509 VGND.t390 sg13cmos5l_inv_16_75.A sg13cmos5l_inv_16_74.Y VGND.t380 sg13_lv_nmos ad=0.1406p pd=1.12u as=0.1406p ps=1.12u w=0.74u l=0.13u
X2510 VGND.t916 VPWR.t2606 VGND.t916 VGND.t1871 sg13_lv_nmos ad=0.1428p pd=1.52u as=0 ps=0 w=0.42u l=1u
X2511 sg13cmos5l_inv_16_13.Y sg13cmos5l_inv_16_15.A VGND.t45 VGND.t511 sg13_lv_nmos ad=0.1406p pd=1.12u as=0.1406p ps=1.12u w=0.74u l=0.13u
X2512 VPWR.t2184 sg13cmos5l_inv_4_0.Y sg13cmos5l_inv_8_0.Y VPWR.t177 sg13_lv_pmos ad=0.3808p pd=2.92u as=0.2184p ps=1.51u w=1.12u l=0.13u
X2513 VGND.t866 sg13cmos5l_inv_16_68.A sg13cmos5l_inv_16_66.Y VGND.t878 sg13_lv_nmos ad=0.1406p pd=1.12u as=0.1406p ps=1.12u w=0.74u l=0.13u
X2514 sg13cmos5l_inv_16_109.Y sg13cmos5l_inv_16_48.A VPWR.t2084 VPWR.t16 sg13_lv_pmos ad=0.2128p pd=1.5u as=0.2128p ps=1.5u w=1.12u l=0.13u
X2515 VGND.t122 sg13cmos5l_inv_16_75.A sg13cmos5l_inv_16_75.Y VGND.t402 sg13_lv_nmos ad=0.1406p pd=1.12u as=0.1406p ps=1.12u w=0.74u l=0.13u
X2516 VPWR.t790 sg13cmos5l_inv_16_11.A sg13cmos5l_inv_16_103.A VPWR.t0 sg13_lv_pmos ad=0.2128p pd=1.5u as=0.2128p ps=1.5u w=1.12u l=0.13u
X2517 sg13cmos5l_inv_16_17.Y sg13cmos5l_inv_16_17.A VPWR.t548 VPWR.t177 sg13_lv_pmos ad=0.2128p pd=1.5u as=0.2128p ps=1.5u w=1.12u l=0.13u
X2518 sg13cmos5l_inv_16_30.A sg13cmos5l_inv_16_26.A VGND.t326 VGND.t1317 sg13_lv_nmos ad=0.1406p pd=1.12u as=0.1406p ps=1.12u w=0.74u l=0.13u
X2519 VGND.t39 sg13cmos5l_inv_16_41.A sg13cmos5l_inv_16_28.A VGND.t248 sg13_lv_nmos ad=0.1406p pd=1.12u as=0.1406p ps=1.12u w=0.74u l=0.13u
X2520 a_8204_834# en[2] VPWR.t178 VPWR.t177 sg13_lv_pmos ad=0.2856p pd=2.36u as=0.2114p ps=1.54u w=0.84u l=0.13u
X2521 sg13cmos5l_inv_16_28.A sg13cmos5l_inv_16_41.A VPWR.t675 VPWR.t4 sg13_lv_pmos ad=0.2128p pd=1.5u as=0.2128p ps=1.5u w=1.12u l=0.13u
X2522 sg13cmos5l_inv_16_44.A sg13cmos5l_inv_16_28.A VGND.t257 VGND.t256 sg13_lv_nmos ad=0.1406p pd=1.12u as=0.2516p ps=2.16u w=0.74u l=0.13u
X2523 sg13cmos5l_inv_16_73.A sg13cmos5l_inv_16_94.A VGND.t1507 VGND.t881 sg13_lv_nmos ad=0.1406p pd=1.12u as=0.1406p ps=1.12u w=0.74u l=0.13u
X2524 VPWR.t454 sg13cmos5l_inv_16_37.A sg13cmos5l_inv_16_102.Y VPWR.t0 sg13_lv_pmos ad=0.2128p pd=1.5u as=0.2128p ps=1.5u w=1.12u l=0.13u
X2525 sg13cmos5l_inv_16_17.A sg13cmos5l_inv_16_1.A VGND.t675 VGND.t680 sg13_lv_nmos ad=0.1406p pd=1.12u as=0.1406p ps=1.12u w=0.74u l=0.13u
X2526 VPWR.t1330 sg13cmos5l_inv_16_69.Y sg13cmos5l_inv_16_62.Y VPWR.t9 sg13_lv_pmos ad=0.2128p pd=1.5u as=0.2128p ps=1.5u w=1.12u l=0.13u
X2527 VPWR.t1428 sg13cmos5l_inv_16_87.A sg13cmos5l_inv_16_87.Y VPWR.t9 sg13_lv_pmos ad=0.2128p pd=1.5u as=0.2128p ps=1.5u w=1.12u l=0.13u
X2528 sg13cmos5l_inv_16_67.Y sg13cmos5l_inv_16_67.A VPWR.t1984 VPWR.t16 sg13_lv_pmos ad=0.2128p pd=1.5u as=0.2128p ps=1.5u w=1.12u l=0.13u
X2529 VPWR.t39 VGND.t1779 VPWR.t36 VPWR.t25 sg13_lv_pmos ad=0.19p pd=1.38u as=0 ps=0 w=1u l=1u
X2530 VGND.t5 sg13cmos5l_inv_4_5.Y sg13cmos5l_inv_8_4.Y VGND.t1063 sg13_lv_nmos ad=0.1406p pd=1.12u as=0.1406p ps=1.12u w=0.74u l=0.13u
X2531 sg13cmos5l_inv_16_68.Y sg13cmos5l_inv_16_68.A VPWR.t1304 VPWR.t16 sg13_lv_pmos ad=0.2128p pd=1.5u as=0.2128p ps=1.5u w=1.12u l=0.13u
X2532 VPWR.t844 sg13cmos5l_inv_16_6.Y sg13cmos5l_inv_16_25.Y VPWR.t177 sg13_lv_pmos ad=0.2128p pd=1.5u as=0.2128p ps=1.5u w=1.12u l=0.13u
X2533 VGND.t423 sg13cmos5l_inv_8_1.Y sg13cmos5l_inv_16_4.Y VGND.t1463 sg13_lv_nmos ad=0.1406p pd=1.12u as=0.1406p ps=1.12u w=0.74u l=0.13u
X2534 sg13cmos5l_inv_16_14.A sg13cmos5l_inv_16_23.Y VGND.t50 VGND.t69 sg13_lv_nmos ad=0.1406p pd=1.12u as=0.1406p ps=1.12u w=0.74u l=0.13u
X2535 sg13cmos5l_inv_16_65.Y sg13cmos5l_inv_16_67.A VGND.t1580 VGND.t1590 sg13_lv_nmos ad=0.1406p pd=1.12u as=0.1406p ps=1.12u w=0.74u l=0.13u
X2536 VPWR.t1412 sg13cmos5l_inv_16_87.A sg13cmos5l_inv_16_93.Y VPWR.t9 sg13_lv_pmos ad=0.2128p pd=1.5u as=0.2128p ps=1.5u w=1.12u l=0.13u
X2537 sg13cmos5l_inv_16_74.Y sg13cmos5l_inv_16_75.A VGND.t381 VGND.t380 sg13_lv_nmos ad=0.1406p pd=1.12u as=0.1406p ps=1.12u w=0.74u l=0.13u
X2538 VPWR.t1102 sg13cmos5l_inv_16_1.A sg13cmos5l_inv_16_17.A VPWR.t177 sg13_lv_pmos ad=0.4368p pd=3.02u as=0.2128p ps=1.5u w=1.12u l=0.13u
X2539 VGND.t1067 VPWR.t2597 VGND.t1067 VGND.t1892 sg13_lv_nmos ad=0.1428p pd=1.52u as=0 ps=0 w=0.42u l=1u
X2540 sg13cmos5l_inv_16_53.A sg13cmos5l_inv_16_52.Y VPWR.t1766 VPWR.t16 sg13_lv_pmos ad=0.2128p pd=1.5u as=0.2128p ps=1.5u w=1.12u l=0.13u
X2541 VGND.t291 sg13cmos5l_inv_16_8.Y sg13cmos5l_inv_16_9.A VGND.t573 sg13_lv_nmos ad=0.2516p pd=2.16u as=0.1406p ps=1.12u w=0.74u l=0.13u
X2542 VGND.t575 sg13cmos5l_inv_8_2.A sg13cmos5l_inv_16_27.A VGND.t582 sg13_lv_nmos ad=0.2516p pd=2.16u as=0.1443p ps=1.13u w=0.74u l=0.13u
X2543 sg13cmos5l_inv_4_0.A sg13cmos5l_inv_2_0.A VPWR.t1011 VPWR.t177 sg13_lv_pmos ad=0.2128p pd=1.5u as=0.3808p ps=2.92u w=1.12u l=0.13u
X2544 VGND.t675 sg13cmos5l_inv_16_1.A sg13cmos5l_inv_16_17.A VGND.t674 sg13_lv_nmos ad=0.1406p pd=1.12u as=0.1406p ps=1.12u w=0.74u l=0.13u
X2545 VGND.t326 sg13cmos5l_inv_16_26.A sg13cmos5l_inv_16_30.A VGND.t1314 sg13_lv_nmos ad=0.1406p pd=1.12u as=0.1406p ps=1.12u w=0.74u l=0.13u
X2546 VGND.t326 VPWR.t2481 VGND.t326 VGND.t2094 sg13_lv_nmos ad=0.1428p pd=1.52u as=0 ps=0 w=0.42u l=1u
X2547 sg13cmos5l_inv_16_87.Y sg13cmos5l_inv_16_87.A VPWR.t1424 VPWR.t9 sg13_lv_pmos ad=0.2128p pd=1.5u as=0.2128p ps=1.5u w=1.12u l=0.13u
X2548 VGND.t1010 sg13cmos5l_inv_16_73.Y sg13cmos5l_inv_16_95.Y VGND.t881 sg13_lv_nmos ad=0.1406p pd=1.12u as=0.1406p ps=1.12u w=0.74u l=0.13u
X2549 VGND.t259 sg13cmos5l_inv_16_29.A sg13cmos5l_inv_16_35.Y VGND.t271 sg13_lv_nmos ad=0.1406p pd=1.12u as=0.1406p ps=1.12u w=0.74u l=0.13u
X2550 VGND.t111 sg13cmos5l_inv_16_17.A sg13cmos5l_inv_16_17.Y VGND.t119 sg13_lv_nmos ad=0.2516p pd=2.16u as=0.1406p ps=1.12u w=0.74u l=0.13u
X2551 sg13cmos5l_inv_16_110.Y sg13cmos5l_inv_16_5.Y VPWR.t1068 VPWR.t4 sg13_lv_pmos ad=0.2128p pd=1.5u as=0.2128p ps=1.5u w=1.12u l=0.13u
X2552 VPWR.t531 sg13cmos5l_inv_16_17.A sg13cmos5l_inv_16_19.Y VPWR.t177 sg13_lv_pmos ad=0.2128p pd=1.5u as=0.2128p ps=1.5u w=1.12u l=0.13u
X2553 VGND.t827 VPWR.t2468 VGND.t2123 VGND.t2122 sg13_lv_nmos ad=79.8f pd=0.8u as=0 ps=0 w=0.42u l=1u
X2554 VPWR.t1302 sg13cmos5l_inv_16_68.A sg13cmos5l_inv_16_68.Y VPWR.t16 sg13_lv_pmos ad=0.2128p pd=1.5u as=0.2128p ps=1.5u w=1.12u l=0.13u
X2555 VPWR.t1470 sg13cmos5l_inv_4_5.Y sg13cmos5l_inv_8_4.Y VPWR.t25 sg13_lv_pmos ad=0.3808p pd=2.92u as=0.2184p ps=1.51u w=1.12u l=0.13u
X2556 VPWR.t828 sg13cmos5l_inv_16_75.A sg13cmos5l_inv_16_75.Y VPWR.t25 sg13_lv_pmos ad=0.2128p pd=1.5u as=0.2128p ps=1.5u w=1.12u l=0.13u
X2557 sg13cmos5l_inv_16_27.A sg13cmos5l_inv_8_2.A VPWR.t1001 VPWR.t177 sg13_lv_pmos ad=0.2184p pd=1.51u as=0.2128p ps=1.5u w=1.12u l=0.13u
X2558 VPWR.t2334 sg13cmos5l_inv_16_101.Y sg13cmos5l_inv_16_54.Y VPWR.t25 sg13_lv_pmos ad=0.2128p pd=1.5u as=0.2128p ps=1.5u w=1.12u l=0.13u
X2559 sg13cmos5l_inv_16_77.Y sg13cmos5l_inv_16_77.A VPWR.t2251 VPWR.t25 sg13_lv_pmos ad=0.2128p pd=1.5u as=0.3808p ps=2.92u w=1.12u l=0.13u
X2560 VPWR.t1268 sg13cmos5l_inv_16_0.A sg13cmos5l_inv_16_1.A VPWR.t177 sg13_lv_pmos ad=0.2128p pd=1.5u as=0.2128p ps=1.5u w=1.12u l=0.13u
X2561 sg13cmos5l_inv_16_4.Y sg13cmos5l_inv_8_1.Y VGND.t1459 VGND.t1460 sg13_lv_nmos ad=0.1406p pd=1.12u as=0.1406p ps=1.12u w=0.74u l=0.13u
X2562 VGND.t50 sg13cmos5l_inv_16_23.Y sg13cmos5l_inv_16_14.A VGND.t67 sg13_lv_nmos ad=0.1406p pd=1.12u as=0.1406p ps=1.12u w=0.74u l=0.13u
X2563 sg13cmos5l_inv_16_46.A sg13cmos5l_inv_16_48.A VGND.t1715 VGND.t380 sg13_lv_nmos ad=0.1406p pd=1.12u as=0.2516p ps=2.16u w=0.74u l=0.13u
X2564 VGND.t1820 VPWR.t2582 VGND.t1029 VGND.t881 sg13_lv_nmos ad=0.1428p pd=1.52u as=0 ps=0 w=0.42u l=1u
X2565 sg13cmos5l_inv_16_73.A sg13cmos5l_inv_16_94.A VPWR.t1904 VPWR.t9 sg13_lv_pmos ad=0.2128p pd=1.5u as=0.2128p ps=1.5u w=1.12u l=0.13u
X2566 VPWR.t1764 sg13cmos5l_inv_16_52.Y sg13cmos5l_inv_16_53.A VPWR.t16 sg13_lv_pmos ad=0.2128p pd=1.5u as=0.2128p ps=1.5u w=1.12u l=0.13u
X2567 sg13cmos5l_inv_16_9.A sg13cmos5l_inv_16_8.Y VGND.t291 VGND.t570 sg13_lv_nmos ad=0.1406p pd=1.12u as=0.1406p ps=1.12u w=0.74u l=0.13u
X2568 VPWR.t2074 sg13cmos5l_inv_16_53.A sg13cmos5l_inv_16_53.Y VPWR.t16 sg13_lv_pmos ad=0.4368p pd=3.02u as=0.2128p ps=1.5u w=1.12u l=0.13u
X2569 VGND.t390 VPWR.t2556 VGND.t390 VGND.t380 sg13_lv_nmos ad=79.8f pd=0.8u as=0 ps=0 w=0.42u l=1u
X2570 sg13cmos5l_inv_16_17.Y sg13cmos5l_inv_16_17.A VGND.t111 VGND.t114 sg13_lv_nmos ad=0.1406p pd=1.12u as=0.1406p ps=1.12u w=0.74u l=0.13u
X2571 VGND.t635 VPWR.t2478 VGND.t635 VGND.t2100 sg13_lv_nmos ad=0.1428p pd=1.52u as=0 ps=0 w=0.42u l=1u
X2572 VGND.t1779 VPWR.t2547 VGND.t1779 VGND.t380 sg13_lv_nmos ad=79.8f pd=0.8u as=0 ps=0 w=0.42u l=1u
X2573 sg13cmos5l_inv_16_46.Y sg13cmos5l_inv_16_46.A VGND.t134 VGND.t1757 sg13_lv_nmos ad=0.1406p pd=1.12u as=0.1406p ps=1.12u w=0.74u l=0.13u
X2574 sg13cmos5l_inv_16_22.Y sg13cmos5l_inv_16_20.A VGND.t450 VGND.t451 sg13_lv_nmos ad=0.1406p pd=1.12u as=0.1406p ps=1.12u w=0.74u l=0.13u
X2575 VPWR.t386 VGND.t635 VPWR.t385 VPWR.t4 sg13_lv_pmos ad=0.34p pd=2.68u as=0 ps=0 w=1u l=1u
X2576 VPWR.t806 sg13cmos5l_inv_16_75.A sg13cmos5l_inv_16_74.Y VPWR.t25 sg13_lv_pmos ad=0.2128p pd=1.5u as=0.2128p ps=1.5u w=1.12u l=0.13u
X2577 VPWR.t118 VGND.t1100 VPWR.t117 VPWR.t0 sg13_lv_pmos ad=0.19p pd=1.38u as=0 ps=0 w=1u l=1u
X2578 VGND.t291 sg13cmos5l_inv_16_4.Y sg13cmos5l_inv_16_8.Y VGND.t298 sg13_lv_nmos ad=0.1406p pd=1.12u as=0.1406p ps=1.12u w=0.74u l=0.13u
X2579 sg13cmos5l_inv_16_95.Y sg13cmos5l_inv_16_73.Y VGND.t1010 VGND.t881 sg13_lv_nmos ad=0.1406p pd=1.12u as=0.1406p ps=1.12u w=0.74u l=0.13u
X2580 VGND.t217 sg13cmos5l_inv_16_41.A sg13cmos5l_inv_16_34.Y VGND.t218 sg13_lv_nmos ad=0.1406p pd=1.12u as=0.1406p ps=1.12u w=0.74u l=0.13u
X2581 sg13cmos5l_inv_16_27.Y sg13cmos5l_inv_16_27.A VGND.t425 VGND.t1624 sg13_lv_nmos ad=0.1406p pd=1.12u as=0.1406p ps=1.12u w=0.74u l=0.13u
X2582 VPWR.t1851 sg13cmos5l_inv_8_1.Y sg13cmos5l_inv_16_4.Y VPWR.t177 sg13_lv_pmos ad=0.4368p pd=3.02u as=0.2128p ps=1.5u w=1.12u l=0.13u
X2583 sg13cmos5l_inv_16_68.Y sg13cmos5l_inv_16_68.A VPWR.t1298 VPWR.t16 sg13_lv_pmos ad=0.2128p pd=1.5u as=0.2128p ps=1.5u w=1.12u l=0.13u
X2584 VPWR.t143 VGND.t3 VPWR.t142 VPWR.t0 sg13_lv_pmos ad=0.34p pd=2.68u as=0 ps=0 w=1u l=1u
X2585 VGND.t310 sg13cmos5l_inv_16_4.Y sg13cmos5l_inv_16_6.A VGND.t312 sg13_lv_nmos ad=0.1406p pd=1.12u as=0.1406p ps=1.12u w=0.74u l=0.13u
X2586 VGND.t196 VPWR.t2491 VGND.t196 VGND.t2077 sg13_lv_nmos ad=79.8f pd=0.8u as=0 ps=0 w=0.42u l=1u
X2587 VPWR.t375 VGND.t217 VPWR.t374 VPWR.t4 sg13_lv_pmos ad=0.34p pd=2.68u as=0 ps=0 w=1u l=1u
X2588 sg13cmos5l_inv_16_11.A sg13cmos5l_inv_16_96.Y VGND.t953 VGND.t380 sg13_lv_nmos ad=0.1406p pd=1.12u as=0.1406p ps=1.12u w=0.74u l=0.13u
X2589 sg13cmos5l_inv_16_75.Y sg13cmos5l_inv_16_75.A VPWR.t824 VPWR.t25 sg13_lv_pmos ad=0.2128p pd=1.5u as=0.2128p ps=1.5u w=1.12u l=0.13u
X2590 VPWR.t450 sg13cmos5l_inv_16_37.A sg13cmos5l_inv_16_102.Y VPWR.t0 sg13_lv_pmos ad=0.2128p pd=1.5u as=0.2128p ps=1.5u w=1.12u l=0.13u
X2591 sg13cmos5l_inv_16_40.Y sg13cmos5l_inv_16_26.Y VPWR.t178 VPWR.t177 sg13_lv_pmos ad=0.2128p pd=1.5u as=0.2128p ps=1.5u w=1.12u l=0.13u
X2592 sg13cmos5l_inv_16_65.Y sg13cmos5l_inv_16_67.A VGND.t1580 VGND.t1586 sg13_lv_nmos ad=0.1406p pd=1.12u as=0.1406p ps=1.12u w=0.74u l=0.13u
X2593 VPWR.t167 VGND.t1580 VPWR.t166 VPWR.t9 sg13_lv_pmos ad=0.34p pd=2.68u as=0 ps=0 w=1u l=1u
X2594 VGND.t291 sg13cmos5l_inv_16_8.Y sg13cmos5l_inv_16_9.A VGND.t567 sg13_lv_nmos ad=0.1406p pd=1.12u as=0.1406p ps=1.12u w=0.74u l=0.13u
X2595 VGND.t146 sg13cmos5l_inv_16_36.A sg13cmos5l_inv_16_36.Y VGND.t157 sg13_lv_nmos ad=0.1406p pd=1.12u as=0.1406p ps=1.12u w=0.74u l=0.13u
X2596 VGND.t134 sg13cmos5l_inv_16_46.A sg13cmos5l_inv_16_46.Y VGND.t1754 sg13_lv_nmos ad=0.1406p pd=1.12u as=0.1406p ps=1.12u w=0.74u l=0.13u
X2597 VPWR.t2158 sg13cmos5l_inv_16_79.A sg13cmos5l_inv_16_91.Y VPWR.t16 sg13_lv_pmos ad=0.4368p pd=3.02u as=0.2128p ps=1.5u w=1.12u l=0.13u
X2598 VGND.t1010 sg13cmos5l_inv_16_73.Y sg13cmos5l_inv_16_95.Y VGND.t881 sg13_lv_nmos ad=0.1406p pd=1.12u as=0.1406p ps=1.12u w=0.74u l=0.13u
X2599 VGND.t1944 VPWR.t2566 VGND.t1944 VGND.t380 sg13_lv_nmos ad=0.1428p pd=1.52u as=0 ps=0 w=0.42u l=1u
X2600 VPWR.t670 sg13cmos5l_inv_16_41.A sg13cmos5l_inv_16_34.Y VPWR.t0 sg13_lv_pmos ad=0.4368p pd=3.02u as=0.2128p ps=1.5u w=1.12u l=0.13u
X2601 sg13cmos5l_inv_16_10.Y sg13cmos5l_inv_16_9.A VGND.t723 VGND.t725 sg13_lv_nmos ad=0.1406p pd=1.12u as=0.1406p ps=1.12u w=0.74u l=0.13u
X2602 VPWR.t331 VGND.t370 VPWR.t330 VPWR.t4 sg13_lv_pmos ad=0.34p pd=2.68u as=0 ps=0 w=1u l=1u
X2603 sg13cmos5l_inv_16_71.Y sg13cmos5l_inv_16_56.Y VGND.t963 VGND.t881 sg13_lv_nmos ad=0.1406p pd=1.12u as=0.1406p ps=1.12u w=0.74u l=0.13u
X2604 sg13cmos5l_inv_16_20.A sg13cmos5l_inv_16_8.Y VGND.t545 VGND.t548 sg13_lv_nmos ad=0.1406p pd=1.12u as=0.1406p ps=1.12u w=0.74u l=0.13u
X2605 VPWR.t687 sg13cmos5l_inv_16_28.A sg13cmos5l_inv_16_29.A VPWR.t177 sg13_lv_pmos ad=0.4368p pd=3.02u as=0.2128p ps=1.5u w=1.12u l=0.13u
X2606 sg13cmos5l_inv_16_6.A sg13cmos5l_inv_16_4.Y VGND.t308 VGND.t307 sg13_lv_nmos ad=0.1406p pd=1.12u as=0.2516p ps=2.16u w=0.74u l=0.13u
X2607 VGND.t45 sg13cmos5l_inv_16_15.A sg13cmos5l_inv_16_15.Y VGND.t514 sg13_lv_nmos ad=0.1406p pd=1.12u as=0.1406p ps=1.12u w=0.74u l=0.13u
X2608 VGND.t146 VPWR.t2493 VGND.t146 VGND.t2072 sg13_lv_nmos ad=0.1428p pd=1.52u as=0 ps=0 w=0.42u l=1u
X2609 sg13cmos5l_inv_16_75.A sg13cmos5l_inv_16_76.A VPWR.t2398 VPWR.t25 sg13_lv_pmos ad=0.2128p pd=1.5u as=0.2128p ps=1.5u w=1.12u l=0.13u
X2610 VPWR.t178 sg13cmos5l_inv_16_26.Y sg13cmos5l_inv_16_40.Y VPWR.t177 sg13_lv_pmos ad=0.2128p pd=1.5u as=0.2128p ps=1.5u w=1.12u l=0.13u
X2611 VGND.t1026 sg13cmos5l_inv_16_84.A sg13cmos5l_inv_16_84.Y VGND.t881 sg13_lv_nmos ad=0.1406p pd=1.12u as=0.1406p ps=1.12u w=0.74u l=0.13u
X2612 sg13cmos5l_inv_16_13.Y sg13cmos5l_inv_16_15.A VGND.t450 VGND.t507 sg13_lv_nmos ad=0.1406p pd=1.12u as=0.1406p ps=1.12u w=0.74u l=0.13u
X2613 VGND.t1580 sg13cmos5l_inv_16_67.A sg13cmos5l_inv_16_65.Y VGND.t1583 sg13_lv_nmos ad=0.1406p pd=1.12u as=0.1406p ps=1.12u w=0.74u l=0.13u
X2614 VGND.t866 sg13cmos5l_inv_16_68.A sg13cmos5l_inv_16_66.Y VGND.t874 sg13_lv_nmos ad=0.1406p pd=1.12u as=0.1406p ps=1.12u w=0.74u l=0.13u
X2615 VGND.t345 sg13cmos5l_inv_16_105.A sg13cmos5l_inv_16_80.Y VGND.t1115 sg13_lv_nmos ad=0.2516p pd=2.16u as=0.1406p ps=1.12u w=0.74u l=0.13u
X2616 VPWR.t2246 sg13cmos5l_inv_16_96.Y sg13cmos5l_inv_16_11.A VPWR.t25 sg13_lv_pmos ad=0.2128p pd=1.5u as=0.2128p ps=1.5u w=1.12u l=0.13u
X2617 sg13cmos5l_inv_16_9.Y sg13cmos5l_inv_16_9.A VGND.t723 VGND.t729 sg13_lv_nmos ad=0.1406p pd=1.12u as=0.1406p ps=1.12u w=0.74u l=0.13u
X2618 sg13cmos5l_inv_16_73.A sg13cmos5l_inv_16_94.A VGND.t1507 VGND.t881 sg13_lv_nmos ad=0.1406p pd=1.12u as=0.1406p ps=1.12u w=0.74u l=0.13u
X2619 sg13cmos5l_inv_16_91.Y sg13cmos5l_inv_16_79.A VPWR.t2154 VPWR.t16 sg13_lv_pmos ad=0.2128p pd=1.5u as=0.2128p ps=1.5u w=1.12u l=0.13u
X2620 sg13cmos5l_inv_16_81.Y sg13cmos5l_inv_16_96.Y VGND.t1792 VGND.t380 sg13_lv_nmos ad=0.1406p pd=1.12u as=0.1406p ps=1.12u w=0.74u l=0.13u
X2621 sg13cmos5l_inv_16_79.A sg13cmos5l_inv_16_81.Y VGND.t1026 VGND.t881 sg13_lv_nmos ad=0.1406p pd=1.12u as=0.1406p ps=1.12u w=0.74u l=0.13u
X2622 sg13cmos5l_inv_16_55.Y sg13cmos5l_inv_16_101.Y VGND.t427 VGND.t380 sg13_lv_nmos ad=0.1406p pd=1.12u as=0.2516p ps=2.16u w=0.74u l=0.13u
X2623 VGND.t20 sg13cmos5l_inv_16_37.A sg13cmos5l_inv_16_102.Y VGND.t22 sg13_lv_nmos ad=0.2516p pd=2.16u as=0.1406p ps=1.12u w=0.74u l=0.13u
X2624 VGND.t134 sg13cmos5l_inv_16_36.A sg13cmos5l_inv_16_100.Y VGND.t136 sg13_lv_nmos ad=0.1406p pd=1.12u as=0.1406p ps=1.12u w=0.74u l=0.13u
X2625 a_17035_916# sg13cmos5l_buf_1_3.X a_16941_916# VGND.t1505 sg13_lv_nmos ad=0.1216p pd=1.02u as=0.2176p ps=1.96u w=0.64u l=0.13u
X2626 VPWR.t2182 sg13cmos5l_inv_4_0.Y sg13cmos5l_inv_8_0.Y VPWR.t177 sg13_lv_pmos ad=0.2128p pd=1.5u as=0.2128p ps=1.5u w=1.12u l=0.13u
X2627 VPWR.t2428 VGND.t1147 VPWR.t853 VPWR.t9 sg13_lv_pmos ad=0.19p pd=1.38u as=0 ps=0 w=1u l=1u
X2628 VGND.t5 sg13cmos5l_inv_4_5.Y sg13cmos5l_inv_8_4.Y VGND.t1059 sg13_lv_nmos ad=0.1406p pd=1.12u as=0.1406p ps=1.12u w=0.74u l=0.13u
X2629 VGND.t291 sg13cmos5l_inv_16_4.Y sg13cmos5l_inv_16_8.Y VGND.t294 sg13_lv_nmos ad=0.1406p pd=1.12u as=0.1406p ps=1.12u w=0.74u l=0.13u
X2630 sg13cmos5l_inv_16_61.Y sg13cmos5l_inv_16_61.A VGND.t1164 VGND.t881 sg13_lv_nmos ad=0.1406p pd=1.12u as=0.2516p ps=2.16u w=0.74u l=0.13u
X2631 VGND.t963 sg13cmos5l_inv_16_56.Y sg13cmos5l_inv_16_71.Y VGND.t881 sg13_lv_nmos ad=0.1406p pd=1.12u as=0.1406p ps=1.12u w=0.74u l=0.13u
X2632 VGND.t545 sg13cmos5l_inv_16_8.Y sg13cmos5l_inv_16_20.A VGND.t544 sg13_lv_nmos ad=0.1406p pd=1.12u as=0.1406p ps=1.12u w=0.74u l=0.13u
X2633 sg13cmos5l_inv_16_15.Y sg13cmos5l_inv_16_15.A VGND.t45 VGND.t511 sg13_lv_nmos ad=0.1406p pd=1.12u as=0.1406p ps=1.12u w=0.74u l=0.13u
X2634 VPWR.t406 VGND.t226 VPWR.t405 VPWR.t4 sg13_lv_pmos ad=0.34p pd=2.68u as=0 ps=0 w=1u l=1u
X2635 VGND.t1143 sg13cmos5l_inv_16_109.Y sg13cmos5l_inv_16_67.A VGND.t881 sg13_lv_nmos ad=0.1406p pd=1.12u as=0.1406p ps=1.12u w=0.74u l=0.13u
X2636 VGND.t905 sg13cmos5l_inv_16_69.Y sg13cmos5l_inv_16_58.Y VGND.t913 sg13_lv_nmos ad=0.1406p pd=1.12u as=0.1406p ps=1.12u w=0.74u l=0.13u
X2637 VPWR.t2396 sg13cmos5l_inv_16_76.A sg13cmos5l_inv_16_75.A VPWR.t25 sg13_lv_pmos ad=0.2128p pd=1.5u as=0.2128p ps=1.5u w=1.12u l=0.13u
X2638 sg13cmos5l_inv_16_61.A sg13cmos5l_inv_16_71.Y VGND.t963 VGND.t881 sg13_lv_nmos ad=0.1406p pd=1.12u as=0.1406p ps=1.12u w=0.74u l=0.13u
X2639 VGND.t450 VPWR.t2500 VGND.t450 VGND.t2061 sg13_lv_nmos ad=79.8f pd=0.8u as=0 ps=0 w=0.42u l=1u
X2640 sg13cmos5l_inv_16_88.A sg13cmos5l_inv_4_7.Y VPWR.t1623 VPWR.t9 sg13_lv_pmos ad=0.2184p pd=1.51u as=0.2128p ps=1.5u w=1.12u l=0.13u
X2641 VPWR.t1256 sg13cmos5l_inv_16_0.A sg13cmos5l_inv_16_23.Y VPWR.t4 sg13_lv_pmos ad=0.4368p pd=3.02u as=0.2128p ps=1.5u w=1.12u l=0.13u
X2642 sg13cmos5l_inv_16_80.Y sg13cmos5l_inv_16_105.A VGND.t345 VGND.t1112 sg13_lv_nmos ad=0.1406p pd=1.12u as=0.1406p ps=1.12u w=0.74u l=0.13u
X2643 VPWR.t1830 sg13cmos5l_inv_16_2.A sg13cmos5l_inv_16_2.Y VPWR.t177 sg13_lv_pmos ad=0.2128p pd=1.5u as=0.2128p ps=1.5u w=1.12u l=0.13u
X2644 VGND.t1236 sg13cmos5l_inv_16_30.A sg13cmos5l_inv_16_31.Y VGND.t1284 sg13_lv_nmos ad=0.1406p pd=1.12u as=0.1406p ps=1.12u w=0.74u l=0.13u
X2645 sg13cmos5l_inv_16_87.Y sg13cmos5l_inv_16_87.A VPWR.t1420 VPWR.t9 sg13_lv_pmos ad=0.2128p pd=1.5u as=0.2128p ps=1.5u w=1.12u l=0.13u
X2646 VGND.t922 sg13cmos5l_inv_16_52.Y sg13cmos5l_inv_16_69.Y VGND.t881 sg13_lv_nmos ad=0.1406p pd=1.12u as=0.1406p ps=1.12u w=0.74u l=0.13u
X2647 VGND.t20 sg13cmos5l_inv_16_46.A sg13cmos5l_inv_16_46.Y VGND.t1750 sg13_lv_nmos ad=0.1406p pd=1.12u as=0.1406p ps=1.12u w=0.74u l=0.13u
X2648 sg13cmos5l_inv_16_102.Y sg13cmos5l_inv_16_37.A VGND.t15 VGND.t18 sg13_lv_nmos ad=0.1406p pd=1.12u as=0.1406p ps=1.12u w=0.74u l=0.13u
X2649 VPWR.t246 sg13cmos5l_inv_16_6.A sg13cmos5l_inv_16_5.Y VPWR.t177 sg13_lv_pmos ad=0.2128p pd=1.5u as=0.2128p ps=1.5u w=1.12u l=0.13u
X2650 VPWR.t356 VGND.t1792 VPWR.t354 VPWR.t25 sg13_lv_pmos ad=0.19p pd=1.38u as=0 ps=0 w=1u l=1u
X2651 VPWR.t527 sg13cmos5l_inv_16_17.A sg13cmos5l_inv_16_19.Y VPWR.t177 sg13_lv_pmos ad=0.2128p pd=1.5u as=0.2128p ps=1.5u w=1.12u l=0.13u
X2652 sg13cmos5l_inv_16_66.Y sg13cmos5l_inv_16_68.A VPWR.t1280 VPWR.t9 sg13_lv_pmos ad=0.2128p pd=1.5u as=0.2128p ps=1.5u w=1.12u l=0.13u
X2653 sg13cmos5l_inv_16_58.Y sg13cmos5l_inv_16_69.Y VGND.t905 VGND.t910 sg13_lv_nmos ad=0.1406p pd=1.12u as=0.1406p ps=1.12u w=0.74u l=0.13u
X2654 VPWR.t246 VGND.t637 VPWR.t246 VPWR.t177 sg13_lv_pmos ad=0.34p pd=2.68u as=0 ps=0 w=1u l=1u
X2655 VPWR.t276 VGND.t1469 VPWR.t274 VPWR.t9 sg13_lv_pmos ad=0.19p pd=1.38u as=0 ps=0 w=1u l=1u
X2656 VPWR.t1760 sg13cmos5l_inv_16_52.Y sg13cmos5l_inv_16_53.A VPWR.t16 sg13_lv_pmos ad=0.2128p pd=1.5u as=0.2128p ps=1.5u w=1.12u l=0.13u
X2657 sg13cmos5l_inv_16_46.Y sg13cmos5l_inv_16_46.A VPWR.t2134 VPWR.t25 sg13_lv_pmos ad=0.2128p pd=1.5u as=0.2128p ps=1.5u w=1.12u l=0.13u
X2658 VPWR.t580 sg13cmos5l_inv_16_36.A sg13cmos5l_inv_16_36.Y VPWR.t4 sg13_lv_pmos ad=0.2128p pd=1.5u as=0.2128p ps=1.5u w=1.12u l=0.13u
X2659 VGND.t963 sg13cmos5l_inv_16_71.Y sg13cmos5l_inv_16_61.A VGND.t881 sg13_lv_nmos ad=0.1406p pd=1.12u as=0.1406p ps=1.12u w=0.74u l=0.13u
X2660 a_26445_9540# sg13cmos5l_buf_1_0.X VPWR.t1777 VPWR.t9 sg13_lv_pmos ad=0.1596p pd=1.22u as=0.2856p ps=2.36u w=0.84u l=0.13u
X2661 sg13cmos5l_inv_16_8.Y sg13cmos5l_inv_16_4.Y VPWR.t722 VPWR.t4 sg13_lv_pmos ad=0.2128p pd=1.5u as=0.3808p ps=2.92u w=1.12u l=0.13u
X2662 VGND.t259 sg13cmos5l_inv_16_28.A sg13cmos5l_inv_16_44.A VGND.t271 sg13_lv_nmos ad=0.1406p pd=1.12u as=0.1406p ps=1.12u w=0.74u l=0.13u
X2663 VGND.t1026 sg13cmos5l_inv_16_84.A sg13cmos5l_inv_16_84.Y VGND.t881 sg13_lv_nmos ad=0.1406p pd=1.12u as=0.1406p ps=1.12u w=0.74u l=0.13u
X2664 VGND.t593 sg13cmos5l_inv_16_34.Y sg13cmos5l_inv_16_99.A VGND.t606 sg13_lv_nmos ad=0.1406p pd=1.12u as=0.1406p ps=1.12u w=0.74u l=0.13u
X2665 sg13cmos5l_inv_16_2.Y sg13cmos5l_inv_16_2.A VPWR.t1826 VPWR.t177 sg13_lv_pmos ad=0.2128p pd=1.5u as=0.2128p ps=1.5u w=1.12u l=0.13u
X2666 VGND.t1166 sg13cmos5l_inv_16_61.A sg13cmos5l_inv_16_59.Y VGND.t1175 sg13_lv_nmos ad=0.1406p pd=1.12u as=0.1406p ps=1.12u w=0.74u l=0.13u
X2667 VPWR.t1746 sg13cmos5l_inv_16_52.Y sg13cmos5l_inv_16_69.Y VPWR.t16 sg13_lv_pmos ad=0.2128p pd=1.5u as=0.2128p ps=1.5u w=1.12u l=0.13u
X2668 sg13cmos5l_and2_1_0.B a_2920_6168# VPWR.t846 VPWR.t25 sg13_lv_pmos ad=0.42p pd=2.99u as=0.2114p ps=1.54u w=1.12u l=0.13u
X2669 sg13cmos5l_inv_16_14.Y sg13cmos5l_inv_16_14.A VGND.t45 VGND.t487 sg13_lv_nmos ad=0.1406p pd=1.12u as=0.1406p ps=1.12u w=0.74u l=0.13u
X2670 sg13cmos5l_inv_16_105.Y sg13cmos5l_inv_16_105.A VPWR.t1532 VPWR.t0 sg13_lv_pmos ad=0.2128p pd=1.5u as=0.2128p ps=1.5u w=1.12u l=0.13u
X2671 sg13cmos5l_inv_16_84.Y sg13cmos5l_inv_16_84.A VPWR.t1496 VPWR.t9 sg13_lv_pmos ad=0.2128p pd=1.5u as=0.2128p ps=1.5u w=1.12u l=0.13u
X2672 sg13cmos5l_inv_16_5.Y sg13cmos5l_inv_16_6.A VPWR.t246 VPWR.t177 sg13_lv_pmos ad=0.2128p pd=1.5u as=0.2128p ps=1.5u w=1.12u l=0.13u
X2673 VGND.t1553 sg13cmos5l_inv_16_111.A sg13cmos5l_inv_16_98.Y VGND.t1557 sg13_lv_nmos ad=0.2516p pd=2.16u as=0.1406p ps=1.12u w=0.74u l=0.13u
X2674 VGND.t1718 VPWR.t2550 VGND.t1718 VGND.t380 sg13_lv_nmos ad=0.1428p pd=1.52u as=0 ps=0 w=0.42u l=1u
X2675 sg13cmos5l_inv_16_19.Y sg13cmos5l_inv_16_17.A VPWR.t523 VPWR.t177 sg13_lv_pmos ad=0.2128p pd=1.5u as=0.2128p ps=1.5u w=1.12u l=0.13u
X2676 VPWR.t284 VGND.t326 VPWR.t283 VPWR.t4 sg13_lv_pmos ad=0.34p pd=2.68u as=0 ps=0 w=1u l=1u
X2677 sg13cmos5l_inv_16_1.A sg13cmos5l_inv_16_0.A VPWR.t1260 VPWR.t177 sg13_lv_pmos ad=0.2128p pd=1.5u as=0.2128p ps=1.5u w=1.12u l=0.13u
X2678 sg13cmos5l_inv_16_40.Y sg13cmos5l_inv_16_26.Y VGND.t326 VGND.t340 sg13_lv_nmos ad=0.1406p pd=1.12u as=0.1406p ps=1.12u w=0.74u l=0.13u
X2679 VPWR.t288 VGND.t2123 VPWR.t287 VPWR.t4 sg13_lv_pmos ad=0.19p pd=1.38u as=0 ps=0 w=1u l=1u
X2680 sg13cmos5l_inv_16_44.Y sg13cmos5l_inv_16_44.A VPWR.t633 VPWR.t4 sg13_lv_pmos ad=0.2128p pd=1.5u as=0.2128p ps=1.5u w=1.12u l=0.13u
X2681 VPWR.t1898 sg13cmos5l_inv_16_94.A sg13cmos5l_inv_16_73.A VPWR.t9 sg13_lv_pmos ad=0.2128p pd=1.5u as=0.2128p ps=1.5u w=1.12u l=0.13u
X2682 VGND.t1147 sg13cmos5l_inv_16_48.A sg13cmos5l_inv_16_109.Y VGND.t881 sg13_lv_nmos ad=0.1406p pd=1.12u as=0.1406p ps=1.12u w=0.74u l=0.13u
X2683 sg13cmos5l_inv_16_36.Y sg13cmos5l_inv_16_36.A VPWR.t576 VPWR.t4 sg13_lv_pmos ad=0.2128p pd=1.5u as=0.2128p ps=1.5u w=1.12u l=0.13u
X2684 sg13cmos5l_inv_16_37.Y sg13cmos5l_inv_16_37.A VPWR.t473 VPWR.t4 sg13_lv_pmos ad=0.2128p pd=1.5u as=0.2128p ps=1.5u w=1.12u l=0.13u
X2685 sg13cmos5l_inv_8_4.Y sg13cmos5l_inv_4_5.Y VPWR.t1464 VPWR.t25 sg13_lv_pmos ad=0.2128p pd=1.5u as=0.2128p ps=1.5u w=1.12u l=0.13u
X2686 VPWR.t1824 sg13cmos5l_inv_16_2.A sg13cmos5l_inv_16_2.Y VPWR.t177 sg13_lv_pmos ad=0.2128p pd=1.5u as=0.2128p ps=1.5u w=1.12u l=0.13u
X2687 sg13cmos5l_inv_16_59.Y sg13cmos5l_inv_16_61.A VGND.t1166 VGND.t1172 sg13_lv_nmos ad=0.1406p pd=1.12u as=0.1406p ps=1.12u w=0.74u l=0.13u
X2688 sg13cmos5l_inv_16_67.A sg13cmos5l_inv_16_109.Y VPWR.t1550 VPWR.t9 sg13_lv_pmos ad=0.2128p pd=1.5u as=0.2128p ps=1.5u w=1.12u l=0.13u
X2689 sg13cmos5l_inv_16_69.Y sg13cmos5l_inv_16_52.Y VPWR.t1742 VPWR.t16 sg13_lv_pmos ad=0.2128p pd=1.5u as=0.2128p ps=1.5u w=1.12u l=0.13u
X2690 VGND.t1143 sg13cmos5l_inv_16_67.A sg13cmos5l_inv_16_67.Y VGND.t881 sg13_lv_nmos ad=0.2516p pd=2.16u as=0.1406p ps=1.12u w=0.74u l=0.13u
X2691 VPWR.t390 VGND.t635 VPWR.t389 VPWR.t4 sg13_lv_pmos ad=0.34p pd=2.68u as=0 ps=0 w=1u l=1u
X2692 sg13cmos5l_inv_16_81.Y sg13cmos5l_inv_16_96.Y VPWR.t2231 VPWR.t16 sg13_lv_pmos ad=0.2128p pd=1.5u as=0.2128p ps=1.5u w=1.12u l=0.13u
X2693 VPWR.t1530 sg13cmos5l_inv_16_105.A sg13cmos5l_inv_16_105.Y VPWR.t0 sg13_lv_pmos ad=0.2128p pd=1.5u as=0.2128p ps=1.5u w=1.12u l=0.13u
X2694 sg13cmos5l_inv_16_26.A sg13cmos5l_inv_16_27.Y VGND.t1243 VGND.t1273 sg13_lv_nmos ad=0.1406p pd=1.12u as=0.1406p ps=1.12u w=0.74u l=0.13u
X2695 VPWR.t1379 sg13cmos5l_inv_16_71.Y sg13cmos5l_inv_16_61.A VPWR.t9 sg13_lv_pmos ad=0.2128p pd=1.5u as=0.2128p ps=1.5u w=1.12u l=0.13u
X2696 VGND.t345 sg13cmos5l_inv_16_103.A sg13cmos5l_inv_16_103.Y VGND.t346 sg13_lv_nmos ad=0.1406p pd=1.12u as=0.1406p ps=1.12u w=0.74u l=0.13u
X2697 sg13cmos5l_inv_16_98.Y sg13cmos5l_inv_16_111.A VGND.t1553 VGND.t1554 sg13_lv_nmos ad=0.1406p pd=1.12u as=0.1406p ps=1.12u w=0.74u l=0.13u
X2698 sg13cmos5l_inv_16_44.A sg13cmos5l_inv_16_28.A VPWR.t699 VPWR.t4 sg13_lv_pmos ad=0.2128p pd=1.5u as=0.2128p ps=1.5u w=1.12u l=0.13u
X2699 VGND.t922 sg13cmos5l_inv_16_69.Y sg13cmos5l_inv_16_62.Y VGND.t881 sg13_lv_nmos ad=0.2516p pd=2.16u as=0.1406p ps=1.12u w=0.74u l=0.13u
X2700 sg13cmos5l_inv_16_66.Y sg13cmos5l_inv_16_68.A VPWR.t1276 VPWR.t9 sg13_lv_pmos ad=0.2128p pd=1.5u as=0.2128p ps=1.5u w=1.12u l=0.13u
X2701 VGND.t326 sg13cmos5l_inv_16_26.Y sg13cmos5l_inv_16_40.Y VGND.t337 sg13_lv_nmos ad=0.1406p pd=1.12u as=0.1406p ps=1.12u w=0.74u l=0.13u
X2702 VPWR.t10 VGND.t1882 VPWR.t230 VPWR.t9 sg13_lv_pmos ad=0.34p pd=2.68u as=0 ps=0 w=1u l=1u
X2703 sg13cmos5l_inv_16_46.Y sg13cmos5l_inv_16_46.A VPWR.t2130 VPWR.t25 sg13_lv_pmos ad=0.2128p pd=1.5u as=0.2128p ps=1.5u w=1.12u l=0.13u
X2704 VGND.t963 sg13cmos5l_inv_16_71.Y sg13cmos5l_inv_16_61.A VGND.t881 sg13_lv_nmos ad=0.1406p pd=1.12u as=0.1406p ps=1.12u w=0.74u l=0.13u
X2705 VGND.t1029 sg13cmos5l_inv_16_81.Y sg13cmos5l_inv_16_84.A VGND.t881 sg13_lv_nmos ad=0.1406p pd=1.12u as=0.1406p ps=1.12u w=0.74u l=0.13u
X2706 VGND.t1779 sg13cmos5l_inv_16_79.A sg13cmos5l_inv_16_79.Y VGND.t380 sg13_lv_nmos ad=0.1406p pd=1.12u as=0.1406p ps=1.12u w=0.74u l=0.13u
X2707 VPWR.t2242 sg13cmos5l_inv_16_96.Y sg13cmos5l_inv_16_11.A VPWR.t25 sg13_lv_pmos ad=0.2128p pd=1.5u as=0.2128p ps=1.5u w=1.12u l=0.13u
X2708 VGND.t1419 sg13cmos5l_and2_1_0.B a_17035_916# VGND.t2264 sg13_lv_nmos ad=0.1331p pd=1.12u as=0.1216p ps=1.02u w=0.64u l=0.13u
X2709 VPWR.t290 VGND.t2123 VPWR.t289 VPWR.t4 sg13_lv_pmos ad=0.34p pd=2.68u as=0 ps=0 w=1u l=1u
X2710 sg13cmos5l_inv_16_9.Y sg13cmos5l_inv_16_9.A VGND.t723 VGND.t725 sg13_lv_nmos ad=0.1406p pd=1.12u as=0.1406p ps=1.12u w=0.74u l=0.13u
X2711 VPWR.t2381 sg13cmos5l_inv_16_76.A sg13cmos5l_inv_16_77.A VPWR.t16 sg13_lv_pmos ad=0.2128p pd=1.5u as=0.2128p ps=1.5u w=1.12u l=0.13u
X2712 VPWR.t1639 sg13cmos5l_inv_4_2.Y sg13cmos5l_inv_8_3.Y VPWR.t4 sg13_lv_pmos ad=0.3808p pd=2.92u as=0.2184p ps=1.51u w=1.12u l=0.13u
X2713 sg13cmos5l_inv_16_67.Y sg13cmos5l_inv_16_67.A VGND.t1143 VGND.t881 sg13_lv_nmos ad=0.1406p pd=1.12u as=0.1406p ps=1.12u w=0.74u l=0.13u
X2714 VGND.t20 sg13cmos5l_inv_16_36.A sg13cmos5l_inv_16_100.Y VGND.t131 sg13_lv_nmos ad=0.1406p pd=1.12u as=0.1406p ps=1.12u w=0.74u l=0.13u
X2715 VPWR.t2229 sg13cmos5l_inv_16_96.Y sg13cmos5l_inv_16_81.Y VPWR.t16 sg13_lv_pmos ad=0.2128p pd=1.5u as=0.2128p ps=1.5u w=1.12u l=0.13u
X2716 sg13cmos5l_inv_16_101.Y sg13cmos5l_inv_16_34.Y VPWR.t1042 VPWR.t0 sg13_lv_pmos ad=0.2128p pd=1.5u as=0.2128p ps=1.5u w=1.12u l=0.13u
X2717 sg13cmos5l_inv_16_61.A sg13cmos5l_inv_16_71.Y VPWR.t1375 VPWR.t9 sg13_lv_pmos ad=0.2128p pd=1.5u as=0.2128p ps=1.5u w=1.12u l=0.13u
X2718 VGND.t963 sg13cmos5l_inv_16_56.Y sg13cmos5l_inv_16_71.Y VGND.t881 sg13_lv_nmos ad=0.1406p pd=1.12u as=0.1406p ps=1.12u w=0.74u l=0.13u
X2719 sg13cmos5l_inv_4_4.Y sg13cmos5l_inv_2_6.Y VGND.t432 VGND.t538 sg13_lv_nmos ad=0.1406p pd=1.12u as=0.1406p ps=1.12u w=0.74u l=0.13u
X2720 VGND.t1541 sg13cmos5l_inv_16_111.A sg13cmos5l_inv_16_98.Y VGND.t1550 sg13_lv_nmos ad=0.1406p pd=1.12u as=0.1406p ps=1.12u w=0.74u l=0.13u
X2721 VPWR.t292 VGND.t45 VPWR.t291 VPWR.t4 sg13_lv_pmos ad=0.34p pd=2.68u as=0 ps=0 w=1u l=1u
X2722 sg13cmos5l_inv_16_15.Y sg13cmos5l_inv_16_15.A VGND.t450 VGND.t507 sg13_lv_nmos ad=0.1406p pd=1.12u as=0.1406p ps=1.12u w=0.74u l=0.13u
X2723 sg13cmos5l_inv_16_99.A sg13cmos5l_inv_16_34.Y VPWR.t1028 VPWR.t25 sg13_lv_pmos ad=0.2128p pd=1.5u as=0.2128p ps=1.5u w=1.12u l=0.13u
X2724 sg13cmos5l_inv_16_40.Y sg13cmos5l_inv_16_26.Y VGND.t326 VGND.t334 sg13_lv_nmos ad=0.1406p pd=1.12u as=0.1406p ps=1.12u w=0.74u l=0.13u
X2725 sg13cmos5l_inv_16_79.Y sg13cmos5l_inv_16_79.A VGND.t1779 VGND.t380 sg13_lv_nmos ad=0.1406p pd=1.12u as=0.1406p ps=1.12u w=0.74u l=0.13u
X2726 sg13cmos5l_inv_16_0.A sg13cmos5l_inv_8_0.Y VGND.t827 VGND.t2317 sg13_lv_nmos ad=0.1406p pd=1.12u as=0.1406p ps=1.12u w=0.74u l=0.13u
X2727 sg13cmos5l_inv_16_84.A sg13cmos5l_inv_16_81.Y VGND.t1029 VGND.t881 sg13_lv_nmos ad=0.1406p pd=1.12u as=0.1406p ps=1.12u w=0.74u l=0.13u
X2728 sg13cmos5l_inv_16_11.A sg13cmos5l_inv_16_96.Y VPWR.t2238 VPWR.t25 sg13_lv_pmos ad=0.2128p pd=1.5u as=0.2128p ps=1.5u w=1.12u l=0.13u
X2729 sg13cmos5l_inv_16_90.Y sg13cmos5l_inv_16_73.Y VGND.t1029 VGND.t881 sg13_lv_nmos ad=0.1406p pd=1.12u as=0.1406p ps=1.12u w=0.74u l=0.13u
X2730 sg13cmos5l_inv_16_100.Y sg13cmos5l_inv_16_36.A VGND.t20 VGND.t128 sg13_lv_nmos ad=0.1406p pd=1.12u as=0.1406p ps=1.12u w=0.74u l=0.13u
X2731 VPWR.t978 sg13cmos5l_inv_16_8.Y sg13cmos5l_inv_16_20.A VPWR.t0 sg13_lv_pmos ad=0.2128p pd=1.5u as=0.2128p ps=1.5u w=1.12u l=0.13u
X2732 VGND.t39 sg13cmos5l_inv_16_30.A sg13cmos5l_inv_16_31.Y VGND.t1280 sg13_lv_nmos ad=0.1406p pd=1.12u as=0.1406p ps=1.12u w=0.74u l=0.13u
X2733 sg13cmos5l_inv_16_81.Y sg13cmos5l_inv_16_96.Y VPWR.t2225 VPWR.t16 sg13_lv_pmos ad=0.2128p pd=1.5u as=0.2128p ps=1.5u w=1.12u l=0.13u
X2734 VPWR.t592 sg13cmos5l_inv_16_43.Y sg13cmos5l_inv_16_37.A VPWR.t0 sg13_lv_pmos ad=0.2128p pd=1.5u as=0.2128p ps=1.5u w=1.12u l=0.13u
X2735 VGND.t101 sg13cmos5l_inv_16_17.A sg13cmos5l_inv_16_19.Y VGND.t103 sg13_lv_nmos ad=0.2516p pd=2.16u as=0.1406p ps=1.12u w=0.74u l=0.13u
X2736 VGND.t450 VPWR.t2486 VGND.t450 VGND.t2085 sg13_lv_nmos ad=0.1428p pd=1.52u as=0 ps=0 w=0.42u l=1u
X2737 sg13cmos5l_inv_16_15.A sg13cmos5l_inv_16_23.Y VPWR.t500 VPWR.t0 sg13_lv_pmos ad=0.2128p pd=1.5u as=0.2128p ps=1.5u w=1.12u l=0.13u
X2738 sg13cmos5l_inv_16_58.Y sg13cmos5l_inv_16_69.Y VGND.t905 VGND.t906 sg13_lv_nmos ad=0.1406p pd=1.12u as=0.1406p ps=1.12u w=0.74u l=0.13u
X2739 VGND.t1164 sg13cmos5l_inv_16_52.Y sg13cmos5l_inv_16_53.A VGND.t881 sg13_lv_nmos ad=0.2516p pd=2.16u as=0.1406p ps=1.12u w=0.74u l=0.13u
X2740 VPWR.t1879 sg13cmos5l_inv_16_73.A sg13cmos5l_inv_16_73.Y VPWR.t16 sg13_lv_pmos ad=0.2128p pd=1.5u as=0.2128p ps=1.5u w=1.12u l=0.13u
X2741 sg13cmos5l_inv_16_23.Y sg13cmos5l_inv_16_0.A VPWR.t1248 VPWR.t4 sg13_lv_pmos ad=0.2128p pd=1.5u as=0.2128p ps=1.5u w=1.12u l=0.13u
X2742 sg13cmos5l_inv_16_81.Y sg13cmos5l_inv_16_96.Y VGND.t953 VGND.t380 sg13_lv_nmos ad=0.1406p pd=1.12u as=0.1406p ps=1.12u w=0.74u l=0.13u
X2743 sg13cmos5l_inv_16_99.Y sg13cmos5l_inv_16_99.A VGND.t773 VGND.t782 sg13_lv_nmos ad=0.1406p pd=1.12u as=0.1406p ps=1.12u w=0.74u l=0.13u
X2744 sg13cmos5l_inv_16_79.A sg13cmos5l_inv_16_81.Y VGND.t1029 VGND.t881 sg13_lv_nmos ad=0.1406p pd=1.12u as=0.1406p ps=1.12u w=0.74u l=0.13u
X2745 VPWR.t949 sg13cmos5l_inv_16_15.A sg13cmos5l_inv_16_15.Y VPWR.t4 sg13_lv_pmos ad=0.2128p pd=1.5u as=0.2128p ps=1.5u w=1.12u l=0.13u
X2746 VPWR.t620 sg13cmos5l_inv_16_43.Y sg13cmos5l_inv_16_36.A VPWR.t0 sg13_lv_pmos ad=0.3808p pd=2.92u as=0.2128p ps=1.5u w=1.12u l=0.13u
X2747 sg13cmos5l_inv_16_36.A sg13cmos5l_inv_16_43.Y VGND.t146 VGND.t179 sg13_lv_nmos ad=0.1406p pd=1.12u as=0.2516p ps=2.16u w=0.74u l=0.13u
X2748 sg13cmos5l_inv_16_84.Y sg13cmos5l_inv_16_84.A VPWR.t1492 VPWR.t9 sg13_lv_pmos ad=0.2128p pd=1.5u as=0.2128p ps=1.5u w=1.12u l=0.13u
X2749 sg13cmos5l_inv_16_37.A sg13cmos5l_inv_16_43.Y VPWR.t589 VPWR.t0 sg13_lv_pmos ad=0.2128p pd=1.5u as=0.3808p ps=2.92u w=1.12u l=0.13u
X2750 VGND.t84 sg13cmos5l_inv_8_1.A sg13cmos5l_inv_8_1.Y VGND.t1428 sg13_lv_nmos ad=0.1406p pd=1.12u as=0.1406p ps=1.12u w=0.74u l=0.13u
X2751 sg13cmos5l_inv_16_4.Y sg13cmos5l_inv_8_1.Y VPWR.t1847 VPWR.t177 sg13_lv_pmos ad=0.2128p pd=1.5u as=0.2128p ps=1.5u w=1.12u l=0.13u
X2752 sg13cmos5l_inv_16_5.Y sg13cmos5l_inv_16_6.A VGND.t1398 VGND.t1399 sg13_lv_nmos ad=0.1406p pd=1.12u as=0.1406p ps=1.12u w=0.74u l=0.13u
X2753 sg13cmos5l_inv_16_19.Y sg13cmos5l_inv_16_17.A VGND.t96 VGND.t99 sg13_lv_nmos ad=0.1406p pd=1.12u as=0.1406p ps=1.12u w=0.74u l=0.13u
X2754 VGND.t1944 sg13cmos5l_inv_8_4.Y sg13cmos5l_inv_16_56.Y VGND.t380 sg13_lv_nmos ad=0.2516p pd=2.16u as=0.1406p ps=1.12u w=0.74u l=0.13u
X2755 VPWR.t878 sg13cmos5l_inv_16_20.A sg13cmos5l_inv_16_22.Y VPWR.t0 sg13_lv_pmos ad=0.2128p pd=1.5u as=0.2128p ps=1.5u w=1.12u l=0.13u
X2756 sg13cmos5l_inv_16_1.A sg13cmos5l_inv_16_0.A VGND.t827 VGND.t858 sg13_lv_nmos ad=0.1406p pd=1.12u as=0.1406p ps=1.12u w=0.74u l=0.13u
X2757 VPWR.t1867 sg13cmos5l_inv_16_73.A sg13cmos5l_inv_16_87.A VPWR.t9 sg13_lv_pmos ad=0.2128p pd=1.5u as=0.2128p ps=1.5u w=1.12u l=0.13u
X2758 sg13cmos5l_inv_16_84.A sg13cmos5l_inv_16_81.Y VPWR.t1442 VPWR.t9 sg13_lv_pmos ad=0.2128p pd=1.5u as=0.2128p ps=1.5u w=1.12u l=0.13u
X2759 VPWR.t1110 sg13cmos5l_inv_16_29.A sg13cmos5l_inv_16_35.Y VPWR.t0 sg13_lv_pmos ad=0.2128p pd=1.5u as=0.2128p ps=1.5u w=1.12u l=0.13u
X2760 VGND.t146 sg13cmos5l_inv_16_43.Y sg13cmos5l_inv_16_37.A VGND.t176 sg13_lv_nmos ad=0.1406p pd=1.12u as=0.1406p ps=1.12u w=0.74u l=0.13u
X2761 sg13cmos5l_inv_16_73.Y sg13cmos5l_inv_16_73.A VPWR.t1875 VPWR.t16 sg13_lv_pmos ad=0.2128p pd=1.5u as=0.2128p ps=1.5u w=1.12u l=0.13u
X2762 VPWR.t967 sg13cmos5l_inv_2_6.Y sg13cmos5l_inv_4_4.Y VPWR.t25 sg13_lv_pmos ad=0.3808p pd=2.92u as=0.2128p ps=1.5u w=1.12u l=0.13u
X2763 VGND.t773 sg13cmos5l_inv_16_99.A sg13cmos5l_inv_16_99.Y VGND.t779 sg13_lv_nmos ad=0.1406p pd=1.12u as=0.1406p ps=1.12u w=0.74u l=0.13u
X2764 VPWR.t2281 sg13cmos5l_inv_16_46.Y sg13cmos5l_inv_16_50.Y VPWR.t25 sg13_lv_pmos ad=0.2128p pd=1.5u as=0.2128p ps=1.5u w=1.12u l=0.13u
X2765 VGND.t756 sg13cmos5l_inv_8_7.Y sg13cmos5l_inv_16_48.A VGND.t380 sg13_lv_nmos ad=0.1406p pd=1.12u as=0.1406p ps=1.12u w=0.74u l=0.13u
X2766 sg13cmos5l_inv_16_47.Y sg13cmos5l_inv_16_47.A VGND.t5 VGND.t2218 sg13_lv_nmos ad=0.1406p pd=1.12u as=0.1406p ps=1.12u w=0.74u l=0.13u
X2767 VGND.t655 sg13cmos5l_inv_16_2.A sg13cmos5l_inv_16_2.Y VGND.t1447 sg13_lv_nmos ad=0.2516p pd=2.16u as=0.1406p ps=1.12u w=0.74u l=0.13u
X2768 sg13cmos5l_inv_16_15.Y sg13cmos5l_inv_16_15.A VPWR.t946 VPWR.t4 sg13_lv_pmos ad=0.2128p pd=1.5u as=0.3808p ps=2.92u w=1.12u l=0.13u
X2769 sg13cmos5l_inv_16_69.Y sg13cmos5l_inv_16_52.Y VGND.t922 VGND.t881 sg13_lv_nmos ad=0.1406p pd=1.12u as=0.1406p ps=1.12u w=0.74u l=0.13u
X2770 sg13cmos5l_inv_16_36.A sg13cmos5l_inv_16_43.Y VPWR.t616 VPWR.t0 sg13_lv_pmos ad=0.2128p pd=1.5u as=0.2128p ps=1.5u w=1.12u l=0.13u
X2771 sg13cmos5l_inv_16_9.A sg13cmos5l_inv_16_8.Y VPWR.t990 VPWR.t0 sg13_lv_pmos ad=0.2128p pd=1.5u as=0.2128p ps=1.5u w=1.12u l=0.13u
X2772 VGND.t1507 sg13cmos5l_inv_16_94.A sg13cmos5l_inv_16_76.A VGND.t881 sg13_lv_nmos ad=0.1406p pd=1.12u as=0.1406p ps=1.12u w=0.74u l=0.13u
X2773 VPWR.t1845 sg13cmos5l_inv_8_1.Y sg13cmos5l_inv_16_4.Y VPWR.t177 sg13_lv_pmos ad=0.2128p pd=1.5u as=0.2128p ps=1.5u w=1.12u l=0.13u
X2774 sg13cmos5l_inv_16_73.Y sg13cmos5l_inv_16_73.A VGND.t381 VGND.t380 sg13_lv_nmos ad=0.1406p pd=1.12u as=0.1406p ps=1.12u w=0.74u l=0.13u
X2775 sg13cmos5l_inv_16_56.Y sg13cmos5l_inv_8_4.Y VGND.t1944 VGND.t380 sg13_lv_nmos ad=0.1406p pd=1.12u as=0.1406p ps=1.12u w=0.74u l=0.13u
X2776 sg13cmos5l_inv_16_22.Y sg13cmos5l_inv_16_20.A VPWR.t874 VPWR.t0 sg13_lv_pmos ad=0.2128p pd=1.5u as=0.2128p ps=1.5u w=1.12u l=0.13u
X2777 VGND.t705 sg13cmos5l_inv_16_29.A sg13cmos5l_inv_16_29.Y VGND.t708 sg13_lv_nmos ad=0.1406p pd=1.12u as=0.1406p ps=1.12u w=0.74u l=0.13u
X2778 sg13cmos5l_inv_16_35.Y sg13cmos5l_inv_16_29.A VPWR.t1106 VPWR.t0 sg13_lv_pmos ad=0.2128p pd=1.5u as=0.2128p ps=1.5u w=1.12u l=0.13u
X2779 sg13cmos5l_inv_16_15.A sg13cmos5l_inv_16_23.Y VPWR.t496 VPWR.t0 sg13_lv_pmos ad=0.2128p pd=1.5u as=0.2128p ps=1.5u w=1.12u l=0.13u
X2780 VGND.t375 sg13cmos5l_inv_16_20.A sg13cmos5l_inv_16_20.Y VGND.t455 sg13_lv_nmos ad=0.1406p pd=1.12u as=0.1406p ps=1.12u w=0.74u l=0.13u
X2781 sg13cmos5l_inv_16_37.A sg13cmos5l_inv_16_43.Y VGND.t146 VGND.t173 sg13_lv_nmos ad=0.1406p pd=1.12u as=0.1406p ps=1.12u w=0.74u l=0.13u
X2782 sg13cmos5l_inv_16_17.A sg13cmos5l_inv_16_1.A VGND.t675 VGND.t686 sg13_lv_nmos ad=0.1406p pd=1.12u as=0.1406p ps=1.12u w=0.74u l=0.13u
X2783 VPWR.t2211 sg13cmos5l_inv_16_73.Y sg13cmos5l_inv_16_95.Y VPWR.t16 sg13_lv_pmos ad=0.2128p pd=1.5u as=0.2128p ps=1.5u w=1.12u l=0.13u
X2784 VPWR.t209 VGND.t122 VPWR.t208 VPWR.t25 sg13_lv_pmos ad=0.34p pd=2.68u as=0 ps=0 w=1u l=1u
X2785 sg13cmos5l_inv_16_50.Y sg13cmos5l_inv_16_46.Y VPWR.t2277 VPWR.t25 sg13_lv_pmos ad=0.2128p pd=1.5u as=0.2128p ps=1.5u w=1.12u l=0.13u
X2786 VGND.t5 sg13cmos5l_inv_16_47.A sg13cmos5l_inv_16_47.Y VGND.t2215 sg13_lv_nmos ad=0.1406p pd=1.12u as=0.1406p ps=1.12u w=0.74u l=0.13u
X2787 VGND.t922 sg13cmos5l_inv_16_52.Y sg13cmos5l_inv_16_69.Y VGND.t881 sg13_lv_nmos ad=0.1406p pd=1.12u as=0.1406p ps=1.12u w=0.74u l=0.13u
X2788 sg13cmos5l_inv_16_47.A sg13cmos5l_inv_16_46.A VGND.t1715 VGND.t380 sg13_lv_nmos ad=0.1406p pd=1.12u as=0.1406p ps=1.12u w=0.74u l=0.13u
X2789 VPWR.t988 sg13cmos5l_inv_16_8.Y sg13cmos5l_inv_16_9.A VPWR.t0 sg13_lv_pmos ad=0.2128p pd=1.5u as=0.2128p ps=1.5u w=1.12u l=0.13u
X2790 sg13cmos5l_inv_16_61.A sg13cmos5l_inv_16_71.Y VPWR.t1371 VPWR.t9 sg13_lv_pmos ad=0.2128p pd=1.5u as=0.2128p ps=1.5u w=1.12u l=0.13u
X2791 sg13cmos5l_inv_16_76.A sg13cmos5l_inv_16_94.A VGND.t1507 VGND.t881 sg13_lv_nmos ad=0.1406p pd=1.12u as=0.2516p ps=2.16u w=0.74u l=0.13u
X2792 sg13cmos5l_inv_16_96.A sg13cmos5l_inv_4_6.Y VGND.t953 VGND.t380 sg13_lv_nmos ad=0.1406p pd=1.12u as=0.1406p ps=1.12u w=0.74u l=0.13u
X2793 VPWR.t554 a_23648_4915# sg13cmos5l_and2_1_7.X VPWR.t0 sg13_lv_pmos ad=0.1918p pd=1.5u as=0.3808p ps=2.92u w=1.12u l=0.13u
X2794 VGND.t675 sg13cmos5l_inv_16_1.A sg13cmos5l_inv_16_17.A VGND.t681 sg13_lv_nmos ad=0.1406p pd=1.12u as=0.1406p ps=1.12u w=0.74u l=0.13u
X2795 sg13cmos5l_inv_16_4.Y sg13cmos5l_inv_8_1.Y VPWR.t1841 VPWR.t177 sg13_lv_pmos ad=0.2128p pd=1.5u as=0.2128p ps=1.5u w=1.12u l=0.13u
X2796 sg13cmos5l_inv_16_41.A sg13cmos5l_inv_8_3.Y VGND.t221 VGND.t812 sg13_lv_nmos ad=0.1406p pd=1.12u as=0.1406p ps=1.12u w=0.74u l=0.13u
X2797 sg13cmos5l_inv_16_84.Y sg13cmos5l_inv_16_84.A VPWR.t1488 VPWR.t9 sg13_lv_pmos ad=0.2128p pd=1.5u as=0.2128p ps=1.5u w=1.12u l=0.13u
X2798 VPWR.t693 sg13cmos5l_inv_16_28.A sg13cmos5l_inv_16_44.A VPWR.t4 sg13_lv_pmos ad=0.2128p pd=1.5u as=0.2128p ps=1.5u w=1.12u l=0.13u
X2799 VPWR.t872 sg13cmos5l_inv_16_20.A sg13cmos5l_inv_16_22.Y VPWR.t0 sg13_lv_pmos ad=0.2128p pd=1.5u as=0.2128p ps=1.5u w=1.12u l=0.13u
X2800 VGND.t146 VPWR.t2493 VGND.t146 VGND.t2073 sg13_lv_nmos ad=79.8f pd=0.8u as=0 ps=0 w=0.42u l=1u
X2801 sg13cmos5l_inv_16_77.Y sg13cmos5l_inv_16_77.A VGND.t472 VGND.t2170 sg13_lv_nmos ad=0.1406p pd=1.12u as=0.1406p ps=1.12u w=0.74u l=0.13u
X2802 VPWR.t494 sg13cmos5l_inv_16_23.Y sg13cmos5l_inv_16_15.A VPWR.t0 sg13_lv_pmos ad=0.2128p pd=1.5u as=0.2128p ps=1.5u w=1.12u l=0.13u
X2803 VGND.t635 sg13cmos5l_inv_16_6.Y sg13cmos5l_inv_16_108.Y VGND.t2350 sg13_lv_nmos ad=0.1406p pd=1.12u as=0.1406p ps=1.12u w=0.74u l=0.13u
X2804 VPWR.t1929 sg13cmos5l_inv_16_111.A sg13cmos5l_inv_16_98.Y VPWR.t9 sg13_lv_pmos ad=0.2128p pd=1.5u as=0.2128p ps=1.5u w=1.12u l=0.13u
X2805 sg13cmos5l_inv_16_79.Y sg13cmos5l_inv_16_79.A VGND.t1779 VGND.t380 sg13_lv_nmos ad=0.1406p pd=1.12u as=0.1406p ps=1.12u w=0.74u l=0.13u
X2806 VGND.t1779 VPWR.t2546 VGND.t1779 VGND.t380 sg13_lv_nmos ad=0.1428p pd=1.52u as=0 ps=0 w=0.42u l=1u
X2807 VPWR.t226 VGND.t144 VPWR.t224 VPWR.t25 sg13_lv_pmos ad=0.19p pd=1.38u as=0 ps=0 w=1u l=1u
X2808 sg13cmos5l_inv_16_84.A sg13cmos5l_inv_16_81.Y VGND.t1029 VGND.t881 sg13_lv_nmos ad=0.1406p pd=1.12u as=0.1406p ps=1.12u w=0.74u l=0.13u
X2809 sg13cmos5l_inv_16_95.Y sg13cmos5l_inv_16_73.Y VPWR.t2188 VPWR.t16 sg13_lv_pmos ad=0.2128p pd=1.5u as=0.2128p ps=1.5u w=1.12u l=0.13u
X2810 VPWR.t844 sg13cmos5l_inv_16_27.Y sg13cmos5l_inv_16_26.A VPWR.t177 sg13_lv_pmos ad=0.4368p pd=3.02u as=0.2128p ps=1.5u w=1.12u l=0.13u
X2811 VGND.t1083 VPWR.t2584 VGND.t1083 VGND.t881 sg13_lv_nmos ad=0.1428p pd=1.52u as=0 ps=0 w=0.42u l=1u
X2812 VPWR.t2034 sg13cmos5l_inv_16_56.Y sg13cmos5l_inv_16_71.Y VPWR.t16 sg13_lv_pmos ad=0.2128p pd=1.5u as=0.2128p ps=1.5u w=1.12u l=0.13u
X2813 VGND.t291 sg13cmos5l_inv_16_9.A sg13cmos5l_inv_16_10.Y VGND.t740 sg13_lv_nmos ad=0.2516p pd=2.16u as=0.1406p ps=1.12u w=0.74u l=0.13u
X2814 VGND.t1715 sg13cmos5l_inv_16_46.A sg13cmos5l_inv_16_47.A VGND.t380 sg13_lv_nmos ad=0.1406p pd=1.12u as=0.1406p ps=1.12u w=0.74u l=0.13u
X2815 VGND.t953 sg13cmos5l_inv_4_6.Y sg13cmos5l_inv_16_96.A VGND.t380 sg13_lv_nmos ad=0.1406p pd=1.12u as=0.1406p ps=1.12u w=0.74u l=0.13u
X2816 sg13cmos5l_inv_16_87.A sg13cmos5l_inv_16_73.A VGND.t1469 VGND.t1468 sg13_lv_nmos ad=0.1406p pd=1.12u as=0.2516p ps=2.16u w=0.74u l=0.13u
X2817 VGND.t1010 sg13cmos5l_inv_16_87.A sg13cmos5l_inv_16_87.Y VGND.t881 sg13_lv_nmos ad=0.2516p pd=2.16u as=0.1406p ps=1.12u w=0.74u l=0.13u
X2818 VPWR.t2308 sg13cmos5l_inv_16_47.A sg13cmos5l_inv_16_47.Y VPWR.t25 sg13_lv_pmos ad=0.2128p pd=1.5u as=0.2128p ps=1.5u w=1.12u l=0.13u
X2819 sg13cmos5l_inv_16_111.Y sg13cmos5l_inv_16_111.A VGND.t756 VGND.t380 sg13_lv_nmos ad=0.1406p pd=1.12u as=0.1406p ps=1.12u w=0.74u l=0.13u
X2820 VGND.t472 sg13cmos5l_inv_16_77.A sg13cmos5l_inv_16_77.Y VGND.t2167 sg13_lv_nmos ad=0.1406p pd=1.12u as=0.1406p ps=1.12u w=0.74u l=0.13u
X2821 sg13cmos5l_inv_16_108.Y sg13cmos5l_inv_16_6.Y VGND.t635 VGND.t2347 sg13_lv_nmos ad=0.1406p pd=1.12u as=0.2516p ps=2.16u w=0.74u l=0.13u
X2822 sg13cmos5l_inv_16_30.A sg13cmos5l_inv_16_26.A VPWR.t1711 VPWR.t4 sg13_lv_pmos ad=0.2128p pd=1.5u as=0.2128p ps=1.5u w=1.12u l=0.13u
X2823 VPWR.t683 sg13cmos5l_inv_16_41.A sg13cmos5l_inv_16_28.A VPWR.t4 sg13_lv_pmos ad=0.2128p pd=1.5u as=0.2128p ps=1.5u w=1.12u l=0.13u
X2824 sg13cmos5l_inv_16_45.Y sg13cmos5l_inv_16_47.A VGND.t1944 VGND.t380 sg13_lv_nmos ad=0.1406p pd=1.12u as=0.1406p ps=1.12u w=0.74u l=0.13u
X2825 VGND.t198 sg13cmos5l_inv_16_26.A sg13cmos5l_inv_16_30.A VGND.t1326 sg13_lv_nmos ad=0.1406p pd=1.12u as=0.1406p ps=1.12u w=0.74u l=0.13u
X2826 sg13cmos5l_inv_16_98.Y sg13cmos5l_inv_16_111.A VPWR.t1925 VPWR.t9 sg13_lv_pmos ad=0.2128p pd=1.5u as=0.2128p ps=1.5u w=1.12u l=0.13u
X2827 sg13cmos5l_inv_16_100.Y sg13cmos5l_inv_16_36.A VPWR.t564 VPWR.t0 sg13_lv_pmos ad=0.2128p pd=1.5u as=0.2128p ps=1.5u w=1.12u l=0.13u
X2828 VPWR.t256 VGND.t723 VPWR.t255 VPWR.t4 sg13_lv_pmos ad=0.34p pd=2.68u as=0 ps=0 w=1u l=1u
X2829 VGND.t1029 sg13cmos5l_inv_16_73.Y sg13cmos5l_inv_16_90.Y VGND.t881 sg13_lv_nmos ad=0.1406p pd=1.12u as=0.1406p ps=1.12u w=0.74u l=0.13u
X2830 sg13cmos5l_inv_16_102.Y sg13cmos5l_inv_16_37.A VPWR.t462 VPWR.t0 sg13_lv_pmos ad=0.2128p pd=1.5u as=0.2128p ps=1.5u w=1.12u l=0.13u
X2831 VPWR.t1818 sg13cmos5l_inv_8_1.A sg13cmos5l_inv_8_1.Y VPWR.t177 sg13_lv_pmos ad=0.3808p pd=2.92u as=0.2184p ps=1.51u w=1.12u l=0.13u
X2832 sg13cmos5l_inv_16_62.Y sg13cmos5l_inv_16_69.Y VPWR.t1338 VPWR.t9 sg13_lv_pmos ad=0.2128p pd=1.5u as=0.2128p ps=1.5u w=1.12u l=0.13u
X2833 sg13cmos5l_inv_16_71.Y sg13cmos5l_inv_16_56.Y VPWR.t2030 VPWR.t16 sg13_lv_pmos ad=0.2128p pd=1.5u as=0.2128p ps=1.5u w=1.12u l=0.13u
X2834 sg13cmos5l_inv_16_56.Y sg13cmos5l_inv_8_4.Y VPWR.t2362 VPWR.t25 sg13_lv_pmos ad=0.2128p pd=1.5u as=0.2128p ps=1.5u w=1.12u l=0.13u
X2835 sg13cmos5l_inv_16_46.A sg13cmos5l_inv_16_48.A VGND.t1718 VGND.t380 sg13_lv_nmos ad=0.1406p pd=1.12u as=0.1406p ps=1.12u w=0.74u l=0.13u
X2836 VPWR.t480 sg13cmos5l_inv_16_30.A sg13cmos5l_inv_16_30.Y VPWR.t177 sg13_lv_pmos ad=0.2128p pd=1.5u as=0.2128p ps=1.5u w=1.12u l=0.13u
X2837 VGND.t425 sg13cmos5l_inv_16_27.A sg13cmos5l_inv_16_27.Y VGND.t1625 sg13_lv_nmos ad=0.1406p pd=1.12u as=0.1406p ps=1.12u w=0.74u l=0.13u
X2838 VGND.t52 sg13cmos5l_inv_16_23.Y sg13cmos5l_inv_16_14.A VGND.t77 sg13_lv_nmos ad=0.1406p pd=1.12u as=0.1406p ps=1.12u w=0.74u l=0.13u
X2839 VGND.t390 sg13cmos5l_inv_16_75.A sg13cmos5l_inv_16_74.Y VGND.t380 sg13_lv_nmos ad=0.2516p pd=2.16u as=0.1406p ps=1.12u w=0.74u l=0.13u
X2840 sg13cmos5l_inv_16_47.Y sg13cmos5l_inv_16_47.A VPWR.t2304 VPWR.t25 sg13_lv_pmos ad=0.2128p pd=1.5u as=0.2128p ps=1.5u w=1.12u l=0.13u
X2841 VGND.t756 sg13cmos5l_inv_16_111.A sg13cmos5l_inv_16_111.Y VGND.t380 sg13_lv_nmos ad=0.1406p pd=1.12u as=0.1406p ps=1.12u w=0.74u l=0.13u
X2842 VPWR.t1709 sg13cmos5l_inv_16_26.A sg13cmos5l_inv_16_30.A VPWR.t4 sg13_lv_pmos ad=0.2128p pd=1.5u as=0.2128p ps=1.5u w=1.12u l=0.13u
X2843 VGND.t345 sg13cmos5l_inv_16_11.A sg13cmos5l_inv_16_105.A VGND.t346 sg13_lv_nmos ad=0.1406p pd=1.12u as=0.1406p ps=1.12u w=0.74u l=0.13u
X2844 sg13cmos5l_inv_16_30.A sg13cmos5l_inv_16_26.A VGND.t326 VGND.t1323 sg13_lv_nmos ad=0.1406p pd=1.12u as=0.1406p ps=1.12u w=0.74u l=0.13u
X2845 sg13cmos5l_inv_16_31.Y sg13cmos5l_inv_16_30.A VPWR.t480 VPWR.t177 sg13_lv_pmos ad=0.2128p pd=1.5u as=0.2128p ps=1.5u w=1.12u l=0.13u
X2846 sg13cmos5l_inv_16_69.Y sg13cmos5l_inv_16_52.Y VPWR.t1739 VPWR.t16 sg13_lv_pmos ad=0.2128p pd=1.5u as=0.3808p ps=2.92u w=1.12u l=0.13u
X2847 VPWR.t460 sg13cmos5l_inv_16_37.A sg13cmos5l_inv_16_102.Y VPWR.t0 sg13_lv_pmos ad=0.2128p pd=1.5u as=0.2128p ps=1.5u w=1.12u l=0.13u
X2848 VGND.t655 sg13cmos5l_inv_16_1.A sg13cmos5l_inv_16_2.A VGND.t662 sg13_lv_nmos ad=0.1406p pd=1.12u as=0.1406p ps=1.12u w=0.74u l=0.13u
X2849 VPWR.t15 VGND.t882 VPWR.t13 VPWR.t9 sg13_lv_pmos ad=0.19p pd=1.38u as=0 ps=0 w=1u l=1u
X2850 VPWR.t2260 sg13cmos5l_inv_16_77.A sg13cmos5l_inv_16_77.Y VPWR.t25 sg13_lv_pmos ad=0.2128p pd=1.5u as=0.2128p ps=1.5u w=1.12u l=0.13u
X2851 sg13cmos5l_inv_16_14.A sg13cmos5l_inv_16_23.Y VGND.t52 VGND.t74 sg13_lv_nmos ad=0.1406p pd=1.12u as=0.1406p ps=1.12u w=0.74u l=0.13u
X2852 VGND.t1067 sg13cmos5l_inv_16_84.A sg13cmos5l_inv_16_85.Y VGND.t1076 sg13_lv_nmos ad=0.1406p pd=1.12u as=0.1406p ps=1.12u w=0.74u l=0.13u
X2853 VPWR.t1436 sg13cmos5l_inv_16_81.Y sg13cmos5l_inv_16_84.A VPWR.t9 sg13_lv_pmos ad=0.2128p pd=1.5u as=0.2128p ps=1.5u w=1.12u l=0.13u
X2854 VGND.t326 sg13cmos5l_inv_16_26.A sg13cmos5l_inv_16_30.A VGND.t1320 sg13_lv_nmos ad=0.1406p pd=1.12u as=0.1406p ps=1.12u w=0.74u l=0.13u
X2855 VPWR.t425 VGND.t450 VPWR.t424 VPWR.t4 sg13_lv_pmos ad=0.34p pd=2.68u as=0 ps=0 w=1u l=1u
X2856 sg13cmos5l_inv_16_50.Y sg13cmos5l_inv_16_46.Y VGND.t1715 VGND.t380 sg13_lv_nmos ad=0.1406p pd=1.12u as=0.1406p ps=1.12u w=0.74u l=0.13u
X2857 sg13cmos5l_inv_16_74.Y sg13cmos5l_inv_16_75.A VPWR.t814 VPWR.t25 sg13_lv_pmos ad=0.2128p pd=1.5u as=0.2128p ps=1.5u w=1.12u l=0.13u
X2858 sg13cmos5l_inv_16_34.Y sg13cmos5l_inv_16_41.A VGND.t226 VGND.t229 sg13_lv_nmos ad=0.1406p pd=1.12u as=0.1406p ps=1.12u w=0.74u l=0.13u
X2859 sg13cmos5l_inv_16_48.A sg13cmos5l_inv_8_7.Y VGND.t756 VGND.t380 sg13_lv_nmos ad=0.1406p pd=1.12u as=0.1406p ps=1.12u w=0.74u l=0.13u
X2860 sg13cmos5l_inv_16_102.Y sg13cmos5l_inv_16_37.A VPWR.t456 VPWR.t0 sg13_lv_pmos ad=0.2128p pd=1.5u as=0.2128p ps=1.5u w=1.12u l=0.13u
X2861 VPWR.t741 sg13cmos5l_inv_16_4.Y sg13cmos5l_inv_16_6.A VPWR.t4 sg13_lv_pmos ad=0.2128p pd=1.5u as=0.2128p ps=1.5u w=1.12u l=0.13u
X2862 VPWR.t358 VGND.t1792 VPWR.t357 VPWR.t25 sg13_lv_pmos ad=0.34p pd=2.68u as=0 ps=0 w=1u l=1u
X2863 VPWR.t834 sg13cmos5l_inv_16_75.A sg13cmos5l_inv_16_75.Y VPWR.t25 sg13_lv_pmos ad=0.4368p pd=3.02u as=0.2128p ps=1.5u w=1.12u l=0.13u
X2864 VGND.t1580 sg13cmos5l_inv_16_67.A sg13cmos5l_inv_16_65.Y VGND.t1593 sg13_lv_nmos ad=0.1406p pd=1.12u as=0.1406p ps=1.12u w=0.74u l=0.13u
X2865 sg13cmos5l_inv_16_46.A sg13cmos5l_inv_16_48.A VGND.t1718 VGND.t380 sg13_lv_nmos ad=0.1406p pd=1.12u as=0.1406p ps=1.12u w=0.74u l=0.13u
X2866 VPWR.t194 VGND.t1718 VPWR.t193 VPWR.t25 sg13_lv_pmos ad=0.34p pd=2.68u as=0 ps=0 w=1u l=1u
X2867 sg13cmos5l_inv_16_77.Y sg13cmos5l_inv_16_77.A VPWR.t2256 VPWR.t25 sg13_lv_pmos ad=0.2128p pd=1.5u as=0.2128p ps=1.5u w=1.12u l=0.13u
X2868 sg13cmos5l_inv_1_3.Y sg13cmos5l_and2_1_4.X VGND.t3 VGND.t721 sg13_lv_nmos ad=0.2516p pd=2.16u as=0.2516p ps=2.16u w=0.74u l=0.13u
X2869 sg13cmos5l_inv_16_55.Y sg13cmos5l_inv_16_101.Y VGND.t1663 VGND.t380 sg13_lv_nmos ad=0.1406p pd=1.12u as=0.1406p ps=1.12u w=0.74u l=0.13u
X2870 VGND.t1715 sg13cmos5l_inv_16_46.Y sg13cmos5l_inv_16_50.Y VGND.t380 sg13_lv_nmos ad=0.1406p pd=1.12u as=0.1406p ps=1.12u w=0.74u l=0.13u
X2871 VGND.t291 sg13cmos5l_inv_16_4.Y sg13cmos5l_inv_16_8.Y VGND.t304 sg13_lv_nmos ad=0.1406p pd=1.12u as=0.1406p ps=1.12u w=0.74u l=0.13u
X2872 VGND.t545 sg13cmos5l_inv_16_8.Y sg13cmos5l_inv_16_20.A VGND.t555 sg13_lv_nmos ad=0.1406p pd=1.12u as=0.1406p ps=1.12u w=0.74u l=0.13u
X2873 VGND.t226 sg13cmos5l_inv_16_41.A sg13cmos5l_inv_16_34.Y VGND.t225 sg13_lv_nmos ad=0.1406p pd=1.12u as=0.1406p ps=1.12u w=0.74u l=0.13u
X2874 sg13cmos5l_inv_16_95.Y sg13cmos5l_inv_16_73.Y VGND.t1010 VGND.t881 sg13_lv_nmos ad=0.1406p pd=1.12u as=0.1406p ps=1.12u w=0.74u l=0.13u
X2875 VGND.t862 a_14636_834# sg13cmos5l_buf_1_4.X VGND.t861 sg13_lv_nmos ad=0.14875p pd=1.16u as=0.2886p ps=2.26u w=0.74u l=0.13u
X2876 sg13cmos5l_inv_16_6.A sg13cmos5l_inv_16_4.Y VPWR.t738 VPWR.t4 sg13_lv_pmos ad=0.2128p pd=1.5u as=0.3808p ps=2.92u w=1.12u l=0.13u
X2877 VGND.t1201 sg13cmos5l_inv_2_5.Y sg13cmos5l_inv_4_7.Y VGND.t1231 sg13_lv_nmos ad=0.2516p pd=2.16u as=0.1406p ps=1.12u w=0.74u l=0.13u
X2878 sg13cmos5l_inv_16_94.A sg13cmos5l_inv_16_88.A VGND.t1507 VGND.t881 sg13_lv_nmos ad=0.1406p pd=1.12u as=0.2516p ps=2.16u w=0.74u l=0.13u
X2879 VGND.t310 sg13cmos5l_inv_16_4.Y sg13cmos5l_inv_16_6.A VGND.t318 sg13_lv_nmos ad=0.1406p pd=1.12u as=0.1406p ps=1.12u w=0.74u l=0.13u
X2880 VGND.t994 sg13cmos5l_inv_16_87.A sg13cmos5l_inv_16_93.Y VGND.t1003 sg13_lv_nmos ad=0.1406p pd=1.12u as=0.1406p ps=1.12u w=0.74u l=0.13u
X2881 VPWR.t2223 sg13cmos5l_inv_16_96.Y sg13cmos5l_inv_16_81.Y VPWR.t16 sg13_lv_pmos ad=0.2128p pd=1.5u as=0.2128p ps=1.5u w=1.12u l=0.13u
X2882 a_14636_834# en[3] VGND.t862 VGND.t1697 sg13_lv_nmos ad=0.187p pd=1.78u as=0.14875p ps=1.16u w=0.55u l=0.13u
X2883 sg13cmos5l_inv_16_40.Y sg13cmos5l_inv_16_26.Y VPWR.t178 VPWR.t177 sg13_lv_pmos ad=0.2128p pd=1.5u as=0.2128p ps=1.5u w=1.12u l=0.13u
X2884 VGND.t1718 sg13cmos5l_inv_16_48.A sg13cmos5l_inv_16_46.A VGND.t380 sg13_lv_nmos ad=0.1406p pd=1.12u as=0.1406p ps=1.12u w=0.74u l=0.13u
X2885 sg13cmos5l_inv_16_51.Y sg13cmos5l_inv_16_99.A VGND.t773 VGND.t782 sg13_lv_nmos ad=0.1406p pd=1.12u as=0.1406p ps=1.12u w=0.74u l=0.13u
X2886 VGND.t375 sg13cmos5l_inv_16_11.A sg13cmos5l_inv_16_103.A VGND.t377 sg13_lv_nmos ad=0.1406p pd=1.12u as=0.1406p ps=1.12u w=0.74u l=0.13u
X2887 VPWR.t1173 sg13cmos5l_inv_8_7.Y sg13cmos5l_inv_16_48.A VPWR.t25 sg13_lv_pmos ad=0.2128p pd=1.5u as=0.2128p ps=1.5u w=1.12u l=0.13u
X2888 VGND.t1067 sg13cmos5l_inv_16_84.A sg13cmos5l_inv_16_85.Y VGND.t1072 sg13_lv_nmos ad=0.1406p pd=1.12u as=0.1406p ps=1.12u w=0.74u l=0.13u
X2889 VPWR.t1988 sg13cmos5l_inv_16_67.A sg13cmos5l_inv_16_67.Y VPWR.t16 sg13_lv_pmos ad=0.2128p pd=1.5u as=0.2128p ps=1.5u w=1.12u l=0.13u
X2890 sg13cmos5l_inv_16_90.Y sg13cmos5l_inv_16_73.Y VPWR.t2199 VPWR.t16 sg13_lv_pmos ad=0.2128p pd=1.5u as=0.2128p ps=1.5u w=1.12u l=0.13u
X2891 VGND.t1663 sg13cmos5l_inv_16_101.Y sg13cmos5l_inv_16_55.Y VGND.t380 sg13_lv_nmos ad=0.1406p pd=1.12u as=0.1406p ps=1.12u w=0.74u l=0.13u
X2892 VGND.t139 sg13cmos5l_inv_16_46.A sg13cmos5l_inv_16_46.Y VGND.t1760 sg13_lv_nmos ad=0.1406p pd=1.12u as=0.1406p ps=1.12u w=0.74u l=0.13u
X2893 VPWR.t329 sg13cmos5l_inv_16_6.A sg13cmos5l_inv_16_5.Y VPWR.t177 sg13_lv_pmos ad=0.4368p pd=3.02u as=0.2128p ps=1.5u w=1.12u l=0.13u
X2894 VGND.t291 sg13cmos5l_inv_16_9.A sg13cmos5l_inv_16_9.Y VGND.t740 sg13_lv_nmos ad=0.2516p pd=2.16u as=0.1406p ps=1.12u w=0.74u l=0.13u
X2895 VGND.t1792 VPWR.t2545 VGND.t1792 VGND.t380 sg13_lv_nmos ad=0.1428p pd=1.52u as=0 ps=0 w=0.42u l=1u
X2896 sg13cmos5l_inv_16_84.A sg13cmos5l_inv_16_81.Y VGND.t1026 VGND.t881 sg13_lv_nmos ad=0.1406p pd=1.12u as=0.1406p ps=1.12u w=0.74u l=0.13u
X2897 sg13cmos5l_inv_16_34.Y sg13cmos5l_inv_16_41.A VGND.t221 VGND.t222 sg13_lv_nmos ad=0.1406p pd=1.12u as=0.1406p ps=1.12u w=0.74u l=0.13u
X2898 sg13cmos5l_inv_16_10.Y sg13cmos5l_inv_16_9.A VGND.t723 VGND.t731 sg13_lv_nmos ad=0.1406p pd=1.12u as=0.1406p ps=1.12u w=0.74u l=0.13u
X2899 sg13cmos5l_inv_16_71.Y sg13cmos5l_inv_16_56.Y VGND.t963 VGND.t881 sg13_lv_nmos ad=0.1406p pd=1.12u as=0.1406p ps=1.12u w=0.74u l=0.13u
X2900 sg13cmos5l_inv_4_7.Y sg13cmos5l_inv_2_5.Y VGND.t1201 VGND.t1228 sg13_lv_nmos ad=0.1406p pd=1.12u as=0.2516p ps=2.16u w=0.74u l=0.13u
X2901 VGND.t1164 sg13cmos5l_inv_16_61.A sg13cmos5l_inv_16_61.Y VGND.t881 sg13_lv_nmos ad=0.1406p pd=1.12u as=0.1406p ps=1.12u w=0.74u l=0.13u
X2902 sg13cmos5l_inv_16_81.Y sg13cmos5l_inv_16_96.Y VPWR.t2220 VPWR.t16 sg13_lv_pmos ad=0.2128p pd=1.5u as=0.3808p ps=2.92u w=1.12u l=0.13u
X2903 VGND.t1680 sg13cmos5l_inv_16_101.Y sg13cmos5l_inv_16_54.Y VGND.t380 sg13_lv_nmos ad=0.1406p pd=1.12u as=0.1406p ps=1.12u w=0.74u l=0.13u
X2904 sg13cmos5l_inv_16_6.A sg13cmos5l_inv_16_4.Y VGND.t310 VGND.t315 sg13_lv_nmos ad=0.1406p pd=1.12u as=0.1406p ps=1.12u w=0.74u l=0.13u
X2905 VPWR.t767 sg13cmos5l_inv_16_26.A sg13cmos5l_inv_16_26.Y VPWR.t177 sg13_lv_pmos ad=0.2128p pd=1.5u as=0.2128p ps=1.5u w=1.12u l=0.13u
X2906 VGND.t773 sg13cmos5l_inv_16_99.A sg13cmos5l_inv_16_51.Y VGND.t779 sg13_lv_nmos ad=0.1406p pd=1.12u as=0.1406p ps=1.12u w=0.74u l=0.13u
X2907 VGND.t5 sg13cmos5l_inv_1_3.Y sg13cmos5l_inv_2_7.Y VGND.t1199 sg13_lv_nmos ad=0.2516p pd=2.16u as=0.1406p ps=1.12u w=0.74u l=0.13u
X2908 VPWR.t1816 sg13cmos5l_inv_8_1.A sg13cmos5l_inv_8_1.Y VPWR.t177 sg13_lv_pmos ad=0.2128p pd=1.5u as=0.2128p ps=1.5u w=1.12u l=0.13u
X2909 sg13cmos5l_inv_16_8.Y sg13cmos5l_inv_16_4.Y VPWR.t731 VPWR.t4 sg13_lv_pmos ad=0.2128p pd=1.5u as=0.2128p ps=1.5u w=1.12u l=0.13u
X2910 VGND.t1026 sg13cmos5l_inv_16_84.A sg13cmos5l_inv_16_84.Y VGND.t881 sg13_lv_nmos ad=0.2516p pd=2.16u as=0.1406p ps=1.12u w=0.74u l=0.13u
X2911 sg13cmos5l_inv_16_27.Y sg13cmos5l_inv_16_27.A VPWR.t844 VPWR.t177 sg13_lv_pmos ad=0.2128p pd=1.5u as=0.2128p ps=1.5u w=1.12u l=0.13u
X2912 VPWR.t2407 sg13cmos5l_inv_8_0.Y sg13cmos5l_inv_16_0.A VPWR.t177 sg13_lv_pmos ad=0.2128p pd=1.5u as=0.2128p ps=1.5u w=1.12u l=0.13u
X2913 VPWR.t2197 sg13cmos5l_inv_16_73.Y sg13cmos5l_inv_16_90.Y VPWR.t16 sg13_lv_pmos ad=0.2128p pd=1.5u as=0.2128p ps=1.5u w=1.12u l=0.13u
X2914 sg13cmos5l_inv_16_94.A sg13cmos5l_inv_16_88.A VPWR.t2014 VPWR.t9 sg13_lv_pmos ad=0.2128p pd=1.5u as=0.2128p ps=1.5u w=1.12u l=0.13u
X2915 VGND.t773 sg13cmos5l_inv_16_99.A sg13cmos5l_inv_16_99.Y VGND.t775 sg13_lv_nmos ad=0.1406p pd=1.12u as=0.1406p ps=1.12u w=0.74u l=0.13u
X2916 sg13cmos5l_inv_16_79.A sg13cmos5l_inv_16_81.Y VGND.t1026 VGND.t881 sg13_lv_nmos ad=0.1406p pd=1.12u as=0.1406p ps=1.12u w=0.74u l=0.13u
X2917 sg13cmos5l_inv_16_31.Y sg13cmos5l_inv_16_30.A VGND.t326 VGND.t1293 sg13_lv_nmos ad=0.1406p pd=1.12u as=0.1406p ps=1.12u w=0.74u l=0.13u
X2918 VPWR.t1970 sg13cmos5l_inv_16_67.A sg13cmos5l_inv_16_65.Y VPWR.t9 sg13_lv_pmos ad=0.2128p pd=1.5u as=0.2128p ps=1.5u w=1.12u l=0.13u
X2919 VPWR.t1290 sg13cmos5l_inv_16_68.A sg13cmos5l_inv_16_66.Y VPWR.t9 sg13_lv_pmos ad=0.4368p pd=3.02u as=0.2128p ps=1.5u w=1.12u l=0.13u
X2920 sg13cmos5l_inv_2_6.Y sg13cmos5l_inv_1_7.Y VGND.t432 VGND.t431 sg13_lv_nmos ad=0.1406p pd=1.12u as=0.2516p ps=2.16u w=0.74u l=0.13u
X2921 sg13cmos5l_inv_16_54.Y sg13cmos5l_inv_16_101.Y VGND.t1680 VGND.t380 sg13_lv_nmos ad=0.1406p pd=1.12u as=0.1406p ps=1.12u w=0.74u l=0.13u
X2922 VPWR.t2356 sg13cmos5l_inv_8_4.Y sg13cmos5l_inv_16_56.Y VPWR.t25 sg13_lv_pmos ad=0.2128p pd=1.5u as=0.2128p ps=1.5u w=1.12u l=0.13u
X2923 sg13cmos5l_inv_16_36.Y sg13cmos5l_inv_16_36.A VPWR.t586 VPWR.t4 sg13_lv_pmos ad=0.2128p pd=1.5u as=0.2128p ps=1.5u w=1.12u l=0.13u
X2924 VGND.t916 sg13cmos5l_inv_16_69.Y sg13cmos5l_inv_16_58.Y VGND.t920 sg13_lv_nmos ad=0.2516p pd=2.16u as=0.1406p ps=1.12u w=0.74u l=0.13u
X2925 sg13cmos5l_inv_16_26.Y sg13cmos5l_inv_16_26.A VPWR.t767 VPWR.t177 sg13_lv_pmos ad=0.2128p pd=1.5u as=0.4368p ps=3.02u w=1.12u l=0.13u
X2926 VGND.t432 VPWR.t2522 VGND.t432 VGND.t2023 sg13_lv_nmos ad=0.1428p pd=1.52u as=0 ps=0 w=0.42u l=1u
X2927 sg13cmos5l_inv_16_35.Y sg13cmos5l_inv_16_29.A VPWR.t1103 VPWR.t0 sg13_lv_pmos ad=0.2128p pd=1.5u as=0.3808p ps=2.92u w=1.12u l=0.13u
X2928 VPWR.t1211 sg13cmos5l_inv_16_99.A sg13cmos5l_inv_16_99.Y VPWR.t0 sg13_lv_pmos ad=0.2128p pd=1.5u as=0.2128p ps=1.5u w=1.12u l=0.13u
X2929 VPWR.t2012 sg13cmos5l_inv_16_88.A sg13cmos5l_inv_16_94.A VPWR.t9 sg13_lv_pmos ad=0.2128p pd=1.5u as=0.2128p ps=1.5u w=1.12u l=0.13u
X2930 sg13cmos5l_inv_16_90.Y sg13cmos5l_inv_16_73.Y VPWR.t2193 VPWR.t16 sg13_lv_pmos ad=0.2128p pd=1.5u as=0.2128p ps=1.5u w=1.12u l=0.13u
X2931 VGND.t144 VPWR.t2534 VGND.t144 VGND.t2004 sg13_lv_nmos ad=79.8f pd=0.8u as=0 ps=0 w=0.42u l=1u
X2932 VGND.t50 sg13cmos5l_inv_16_14.A sg13cmos5l_inv_16_14.Y VGND.t496 sg13_lv_nmos ad=0.1406p pd=1.12u as=0.1406p ps=1.12u w=0.74u l=0.13u
X2933 VGND.t1026 sg13cmos5l_inv_16_81.Y sg13cmos5l_inv_16_79.A VGND.t881 sg13_lv_nmos ad=0.1406p pd=1.12u as=0.1406p ps=1.12u w=0.74u l=0.13u
X2934 VPWR.t1198 sg13cmos5l_inv_16_99.A sg13cmos5l_inv_16_51.Y VPWR.t25 sg13_lv_pmos ad=0.2128p pd=1.5u as=0.2128p ps=1.5u w=1.12u l=0.13u
X2935 VGND.t162 VPWR.t2492 VGND.t162 VGND.t2055 sg13_lv_nmos ad=0.1428p pd=1.52u as=0 ps=0 w=0.42u l=1u
X2936 VPWR.t533 sg13cmos5l_inv_16_17.A sg13cmos5l_inv_16_19.Y VPWR.t177 sg13_lv_pmos ad=0.2128p pd=1.5u as=0.2128p ps=1.5u w=1.12u l=0.13u
X2937 VPWR.t272 sg13cmos5l_and2_1_2.X sg13cmos5l_inv_1_2.Y VPWR.t177 sg13_lv_pmos ad=0.3808p pd=2.92u as=0.3808p ps=2.92u w=1.12u l=0.13u
X2938 sg13cmos5l_inv_16_66.Y sg13cmos5l_inv_16_68.A VPWR.t1286 VPWR.t9 sg13_lv_pmos ad=0.2128p pd=1.5u as=0.2128p ps=1.5u w=1.12u l=0.13u
X2939 VGND.t2140 VPWR.t233 VGND.t2139 VGND.t2138 sg13_lv_nmos ad=0.1428p pd=1.52u as=0 ps=0 w=0.42u l=1u
X2940 sg13cmos5l_inv_16_2.A sg13cmos5l_inv_16_1.A VGND.t655 VGND.t654 sg13_lv_nmos ad=0.1406p pd=1.12u as=0.2516p ps=2.16u w=0.74u l=0.13u
X2941 sg13cmos5l_inv_16_77.Y sg13cmos5l_inv_16_77.A VPWR.t2252 VPWR.t25 sg13_lv_pmos ad=0.2128p pd=1.5u as=0.2128p ps=1.5u w=1.12u l=0.13u
X2942 sg13cmos5l_inv_16_46.Y sg13cmos5l_inv_16_46.A VPWR.t2140 VPWR.t25 sg13_lv_pmos ad=0.2128p pd=1.5u as=0.2128p ps=1.5u w=1.12u l=0.13u
X2943 VGND.t963 sg13cmos5l_inv_16_71.Y sg13cmos5l_inv_16_61.A VGND.t881 sg13_lv_nmos ad=0.1406p pd=1.12u as=0.1406p ps=1.12u w=0.74u l=0.13u
X2944 VPWR.t2340 sg13cmos5l_inv_16_101.Y sg13cmos5l_inv_16_55.Y VPWR.t25 sg13_lv_pmos ad=0.2128p pd=1.5u as=0.2128p ps=1.5u w=1.12u l=0.13u
X2945 sg13cmos5l_inv_16_99.Y sg13cmos5l_inv_16_99.A VPWR.t1207 VPWR.t0 sg13_lv_pmos ad=0.2128p pd=1.5u as=0.2128p ps=1.5u w=1.12u l=0.13u
X2946 VGND.t144 sg13cmos5l_inv_16_36.A sg13cmos5l_inv_16_100.Y VGND.t143 sg13_lv_nmos ad=0.2516p pd=2.16u as=0.1406p ps=1.12u w=0.74u l=0.13u
X2947 sg13cmos5l_inv_16_2.Y sg13cmos5l_inv_16_2.A VPWR.t1832 VPWR.t177 sg13_lv_pmos ad=0.2128p pd=1.5u as=0.2128p ps=1.5u w=1.12u l=0.13u
X2948 VPWR.t1752 sg13cmos5l_inv_16_52.Y sg13cmos5l_inv_16_69.Y VPWR.t16 sg13_lv_pmos ad=0.2128p pd=1.5u as=0.2128p ps=1.5u w=1.12u l=0.13u
X2949 VGND.t1178 sg13cmos5l_inv_16_61.A sg13cmos5l_inv_16_59.Y VGND.t1182 sg13_lv_nmos ad=0.2516p pd=2.16u as=0.1406p ps=1.12u w=0.74u l=0.13u
X2950 sg13cmos5l_inv_16_61.Y sg13cmos5l_inv_16_61.A VPWR.t1592 VPWR.t9 sg13_lv_pmos ad=0.2128p pd=1.5u as=0.2128p ps=1.5u w=1.12u l=0.13u
X2951 VPWR.t808 sg13cmos5l_inv_16_75.A sg13cmos5l_inv_16_74.Y VPWR.t25 sg13_lv_pmos ad=0.2128p pd=1.5u as=0.2128p ps=1.5u w=1.12u l=0.13u
X2952 sg13cmos5l_inv_16_103.Y sg13cmos5l_inv_16_103.A VGND.t353 VGND.t354 sg13_lv_nmos ad=0.1406p pd=1.12u as=0.1406p ps=1.12u w=0.74u l=0.13u
X2953 sg13cmos5l_inv_16_14.Y sg13cmos5l_inv_16_14.A VGND.t66 VGND.t493 sg13_lv_nmos ad=0.1406p pd=1.12u as=0.1406p ps=1.12u w=0.74u l=0.13u
X2954 sg13cmos5l_inv_16_76.A sg13cmos5l_inv_16_94.A VPWR.t1908 VPWR.t16 sg13_lv_pmos ad=0.2128p pd=1.5u as=0.2128p ps=1.5u w=1.12u l=0.13u
X2955 sg13cmos5l_inv_16_51.Y sg13cmos5l_inv_16_99.A VPWR.t1194 VPWR.t25 sg13_lv_pmos ad=0.2128p pd=1.5u as=0.2128p ps=1.5u w=1.12u l=0.13u
X2956 VGND.t994 sg13cmos5l_inv_16_87.A sg13cmos5l_inv_16_93.Y VGND.t999 sg13_lv_nmos ad=0.1406p pd=1.12u as=0.1406p ps=1.12u w=0.74u l=0.13u
X2957 VGND.t390 sg13cmos5l_inv_16_76.A sg13cmos5l_inv_16_75.A VGND.t380 sg13_lv_nmos ad=0.1406p pd=1.12u as=0.1406p ps=1.12u w=0.74u l=0.13u
X2958 VGND.t1899 VPWR.t2593 VGND.t1899 VGND.t1580 sg13_lv_nmos ad=0.1428p pd=1.52u as=0 ps=0 w=0.42u l=1u
X2959 VGND.t1779 VPWR.t2548 VGND.t1779 VGND.t380 sg13_lv_nmos ad=0.1428p pd=1.52u as=0 ps=0 w=0.42u l=1u
X2960 VPWR.t252 VGND.t723 VPWR.t251 VPWR.t0 sg13_lv_pmos ad=0.34p pd=2.68u as=0 ps=0 w=1u l=1u
X2961 sg13cmos5l_inv_16_88.A sg13cmos5l_inv_4_7.Y VGND.t1201 VGND.t1220 sg13_lv_nmos ad=0.1406p pd=1.12u as=0.1406p ps=1.12u w=0.74u l=0.13u
X2962 sg13cmos5l_inv_16_100.Y sg13cmos5l_inv_16_36.A VGND.t139 VGND.t140 sg13_lv_nmos ad=0.1406p pd=1.12u as=0.1406p ps=1.12u w=0.74u l=0.13u
X2963 a_13801_3940# sg13cmos5l_buf_1_15.X VGND.t196 VGND.t253 sg13_lv_nmos ad=0.1216p pd=1.02u as=0.1331p ps=1.12u w=0.64u l=0.13u
X2964 VPWR.t323 VGND.t353 VPWR.t322 VPWR.t0 sg13_lv_pmos ad=0.34p pd=2.68u as=0 ps=0 w=1u l=1u
X2965 sg13cmos5l_inv_16_59.Y sg13cmos5l_inv_16_61.A VGND.t1178 VGND.t1179 sg13_lv_nmos ad=0.1406p pd=1.12u as=0.1406p ps=1.12u w=0.74u l=0.13u
X2966 VPWR.t849 VGND.t1143 VPWR.t848 VPWR.t9 sg13_lv_pmos ad=0.34p pd=2.68u as=0 ps=0 w=1u l=1u
X2967 VGND.t45 sg13cmos5l_inv_16_14.A sg13cmos5l_inv_16_14.Y VGND.t490 sg13_lv_nmos ad=0.1406p pd=1.12u as=0.1406p ps=1.12u w=0.74u l=0.13u
X2968 VPWR.t1472 sg13cmos5l_inv_16_84.A sg13cmos5l_inv_16_85.Y VPWR.t9 sg13_lv_pmos ad=0.2128p pd=1.5u as=0.2128p ps=1.5u w=1.12u l=0.13u
X2969 sg13cmos5l_inv_16_93.Y sg13cmos5l_inv_16_87.A VGND.t994 VGND.t996 sg13_lv_nmos ad=0.1406p pd=1.12u as=0.1406p ps=1.12u w=0.74u l=0.13u
X2970 VGND.t1132 VPWR.t2589 VGND.t1132 VGND.t881 sg13_lv_nmos ad=79.8f pd=0.8u as=0 ps=0 w=0.42u l=1u
X2971 sg13cmos5l_inv_4_2.Y sg13cmos5l_inv_2_3.Y VGND.t39 VGND.t38 sg13_lv_nmos ad=0.1406p pd=1.12u as=0.2516p ps=2.16u w=0.74u l=0.13u
X2972 VGND.t1026 sg13cmos5l_inv_16_84.A sg13cmos5l_inv_16_84.Y VGND.t881 sg13_lv_nmos ad=0.1406p pd=1.12u as=0.1406p ps=1.12u w=0.74u l=0.13u
X2973 sg13cmos5l_inv_8_1.Y sg13cmos5l_inv_8_1.A VGND.t84 VGND.t1429 sg13_lv_nmos ad=0.1443p pd=1.13u as=0.1406p ps=1.12u w=0.74u l=0.13u
X2974 sg13cmos5l_inv_16_8.Y sg13cmos5l_inv_16_4.Y VPWR.t727 VPWR.t4 sg13_lv_pmos ad=0.2128p pd=1.5u as=0.2128p ps=1.5u w=1.12u l=0.13u
X2975 VGND.t472 VPWR.t2510 VGND.t472 VGND.t2042 sg13_lv_nmos ad=0.1428p pd=1.52u as=0 ps=0 w=0.42u l=1u
X2976 VGND.t2123 sg13cmos5l_inv_8_0.Y sg13cmos5l_inv_16_0.A VGND.t2326 sg13_lv_nmos ad=0.1406p pd=1.12u as=0.1406p ps=1.12u w=0.74u l=0.13u
X2977 VGND.t1718 VPWR.t2563 VGND.t1718 VGND.t380 sg13_lv_nmos ad=79.8f pd=0.8u as=0 ps=0 w=0.42u l=1u
X2978 sg13cmos5l_inv_16_36.A sg13cmos5l_inv_16_43.Y VGND.t146 VGND.t189 sg13_lv_nmos ad=0.1406p pd=1.12u as=0.1406p ps=1.12u w=0.74u l=0.13u
X2979 sg13cmos5l_inv_16_9.Y sg13cmos5l_inv_16_9.A VGND.t723 VGND.t731 sg13_lv_nmos ad=0.1406p pd=1.12u as=0.1406p ps=1.12u w=0.74u l=0.13u
X2980 sg13cmos5l_inv_16_43.Y sg13cmos5l_inv_16_27.Y VGND.t1245 VGND.t1246 sg13_lv_nmos ad=0.1406p pd=1.12u as=0.1406p ps=1.12u w=0.74u l=0.13u
X2981 VPWR.t37 VGND.t1779 VPWR.t36 VPWR.t25 sg13_lv_pmos ad=0.34p pd=2.68u as=0 ps=0 w=1u l=1u
X2982 VPWR.t943 sg13cmos5l_inv_16_15.A sg13cmos5l_inv_16_13.Y VPWR.t0 sg13_lv_pmos ad=0.2128p pd=1.5u as=0.2128p ps=1.5u w=1.12u l=0.13u
X2983 VPWR.t1966 sg13cmos5l_inv_16_67.A sg13cmos5l_inv_16_65.Y VPWR.t9 sg13_lv_pmos ad=0.2128p pd=1.5u as=0.2128p ps=1.5u w=1.12u l=0.13u
X2984 VPWR.t2235 sg13cmos5l_inv_16_96.Y sg13cmos5l_inv_16_81.Y VPWR.t16 sg13_lv_pmos ad=0.4368p pd=3.02u as=0.2128p ps=1.5u w=1.12u l=0.13u
X2985 sg13cmos5l_inv_16_61.Y sg13cmos5l_inv_16_61.A VGND.t1164 VGND.t881 sg13_lv_nmos ad=0.1406p pd=1.12u as=0.1406p ps=1.12u w=0.74u l=0.13u
X2986 sg13cmos5l_inv_16_52.Y sg13cmos5l_inv_16_56.Y VGND.t1663 VGND.t380 sg13_lv_nmos ad=0.1406p pd=1.12u as=0.1406p ps=1.12u w=0.74u l=0.13u
X2987 sg13cmos5l_inv_16_54.Y sg13cmos5l_inv_16_101.Y VGND.t1680 VGND.t380 sg13_lv_nmos ad=0.1406p pd=1.12u as=0.1406p ps=1.12u w=0.74u l=0.13u
X2988 sg13cmos5l_inv_16_103.Y sg13cmos5l_inv_16_103.A VGND.t345 VGND.t349 sg13_lv_nmos ad=0.1406p pd=1.12u as=0.1406p ps=1.12u w=0.74u l=0.13u
X2989 sg13cmos5l_inv_8_2.A sg13cmos5l_inv_2_2.Y VGND.t1260 VGND.t1379 sg13_lv_nmos ad=0.1406p pd=1.12u as=0.2516p ps=2.16u w=0.74u l=0.13u
X2990 VGND.t215 sg13cmos5l_inv_16_41.A sg13cmos5l_inv_16_28.A VGND.t235 sg13_lv_nmos ad=0.1406p pd=1.12u as=0.1406p ps=1.12u w=0.74u l=0.13u
X2991 sg13cmos5l_inv_16_37.Y sg13cmos5l_inv_16_37.A VGND.t3 VGND.t28 sg13_lv_nmos ad=0.1406p pd=1.12u as=0.1406p ps=1.12u w=0.74u l=0.13u
X2992 sg13cmos5l_inv_16_10.Y sg13cmos5l_inv_16_9.A VPWR.t1141 VPWR.t0 sg13_lv_pmos ad=0.2128p pd=1.5u as=0.2128p ps=1.5u w=1.12u l=0.13u
X2993 sg13cmos5l_and2_1_6.X a_26445_9540# VGND.t1201 VGND.t1311 sg13_lv_nmos ad=0.2516p pd=2.16u as=0.1331p ps=1.12u w=0.74u l=0.13u
X2994 sg13cmos5l_inv_16_47.Y sg13cmos5l_inv_16_47.A VGND.t20 VGND.t2228 sg13_lv_nmos ad=0.1406p pd=1.12u as=0.1406p ps=1.12u w=0.74u l=0.13u
X2995 sg13cmos5l_inv_16_0.A sg13cmos5l_inv_8_0.Y VGND.t827 VGND.t2323 sg13_lv_nmos ad=0.1406p pd=1.12u as=0.1406p ps=1.12u w=0.74u l=0.13u
X2996 sg13cmos5l_inv_16_29.Y sg13cmos5l_inv_16_29.A VGND.t705 VGND.t709 sg13_lv_nmos ad=0.1406p pd=1.12u as=0.1406p ps=1.12u w=0.74u l=0.13u
X2997 sg13cmos5l_inv_16_90.Y sg13cmos5l_inv_16_73.Y VGND.t1820 VGND.t881 sg13_lv_nmos ad=0.1406p pd=1.12u as=0.1406p ps=1.12u w=0.74u l=0.13u
X2998 VGND.t146 sg13cmos5l_inv_16_43.Y sg13cmos5l_inv_16_36.A VGND.t186 sg13_lv_nmos ad=0.1406p pd=1.12u as=0.1406p ps=1.12u w=0.74u l=0.13u
X2999 VPWR.t844 sg13cmos5l_inv_16_6.Y sg13cmos5l_inv_16_25.Y VPWR.t177 sg13_lv_pmos ad=0.2128p pd=1.5u as=0.2128p ps=1.5u w=1.12u l=0.13u
X3000 sg13cmos5l_inv_16_15.Y sg13cmos5l_inv_16_15.A VPWR.t957 VPWR.t4 sg13_lv_pmos ad=0.2128p pd=1.5u as=0.2128p ps=1.5u w=1.12u l=0.13u
X3001 VGND.t675 sg13cmos5l_inv_16_1.A sg13cmos5l_inv_16_17.A VGND.t687 sg13_lv_nmos ad=0.2516p pd=2.16u as=0.1406p ps=1.12u w=0.74u l=0.13u
X3002 VGND.t326 sg13cmos5l_inv_16_30.A sg13cmos5l_inv_16_31.Y VGND.t1286 sg13_lv_nmos ad=0.1406p pd=1.12u as=0.1406p ps=1.12u w=0.74u l=0.13u
X3003 sg13cmos5l_inv_16_13.Y sg13cmos5l_inv_16_15.A VPWR.t939 VPWR.t0 sg13_lv_pmos ad=0.2128p pd=1.5u as=0.2128p ps=1.5u w=1.12u l=0.13u
X3004 sg13cmos5l_inv_16_65.Y sg13cmos5l_inv_16_67.A VPWR.t1962 VPWR.t9 sg13_lv_pmos ad=0.2128p pd=1.5u as=0.2128p ps=1.5u w=1.12u l=0.13u
X3005 VGND.t1663 sg13cmos5l_inv_16_56.Y sg13cmos5l_inv_16_52.Y VGND.t380 sg13_lv_nmos ad=0.1406p pd=1.12u as=0.1406p ps=1.12u w=0.74u l=0.13u
X3006 VPWR.t707 sg13cmos5l_inv_16_29.A sg13cmos5l_inv_16_29.Y VPWR.t177 sg13_lv_pmos ad=0.2128p pd=1.5u as=0.2128p ps=1.5u w=1.12u l=0.13u
X3007 VGND.t447 sg13cmos5l_inv_16_20.A sg13cmos5l_inv_16_20.Y VGND.t465 sg13_lv_nmos ad=0.1406p pd=1.12u as=0.1406p ps=1.12u w=0.74u l=0.13u
X3008 VPWR.t1157 sg13cmos5l_inv_16_9.A sg13cmos5l_inv_16_9.Y VPWR.t4 sg13_lv_pmos ad=0.2128p pd=1.5u as=0.2128p ps=1.5u w=1.12u l=0.13u
X3009 VGND.t45 sg13cmos5l_inv_16_23.Y sg13cmos5l_inv_16_15.A VGND.t54 sg13_lv_nmos ad=0.1406p pd=1.12u as=0.1406p ps=1.12u w=0.74u l=0.13u
X3010 VGND.t390 VPWR.t2556 VGND.t390 VGND.t380 sg13_lv_nmos ad=0.1428p pd=1.52u as=0 ps=0 w=0.42u l=1u
X3011 sg13cmos5l_inv_16_17.A sg13cmos5l_inv_16_1.A VGND.t675 VGND.t682 sg13_lv_nmos ad=0.1406p pd=1.12u as=0.1406p ps=1.12u w=0.74u l=0.13u
X3012 VGND.t637 sg13cmos5l_inv_16_5.Y sg13cmos5l_inv_16_110.Y VGND.t645 sg13_lv_nmos ad=0.1406p pd=1.12u as=0.1406p ps=1.12u w=0.74u l=0.13u
X3013 VPWR.t1885 sg13cmos5l_inv_16_73.A sg13cmos5l_inv_16_73.Y VPWR.t16 sg13_lv_pmos ad=0.4368p pd=3.02u as=0.2128p ps=1.5u w=1.12u l=0.13u
X3014 VGND.t20 sg13cmos5l_inv_16_47.A sg13cmos5l_inv_16_47.Y VGND.t2225 sg13_lv_nmos ad=0.1406p pd=1.12u as=0.1406p ps=1.12u w=0.74u l=0.13u
X3015 VGND.t827 sg13cmos5l_inv_8_0.Y sg13cmos5l_inv_16_0.A VGND.t2320 sg13_lv_nmos ad=0.1406p pd=1.12u as=0.1406p ps=1.12u w=0.74u l=0.13u
X3016 sg13cmos5l_inv_16_8.Y sg13cmos5l_inv_16_4.Y VPWR.t723 VPWR.t4 sg13_lv_pmos ad=0.2128p pd=1.5u as=0.2128p ps=1.5u w=1.12u l=0.13u
X3017 VPWR.t1458 sg13cmos5l_inv_16_81.Y sg13cmos5l_inv_16_79.A VPWR.t16 sg13_lv_pmos ad=0.2128p pd=1.5u as=0.2128p ps=1.5u w=1.12u l=0.13u
X3018 sg13cmos5l_inv_16_99.Y sg13cmos5l_inv_16_99.A VGND.t773 VGND.t788 sg13_lv_nmos ad=0.1406p pd=1.12u as=0.1406p ps=1.12u w=0.74u l=0.13u
X3019 sg13cmos5l_inv_16_14.A sg13cmos5l_inv_16_23.Y VPWR.t506 VPWR.t0 sg13_lv_pmos ad=0.2128p pd=1.5u as=0.2128p ps=1.5u w=1.12u l=0.13u
X3020 sg13cmos5l_inv_8_1.Y sg13cmos5l_inv_8_1.A VPWR.t1812 VPWR.t177 sg13_lv_pmos ad=0.2128p pd=1.5u as=0.2128p ps=1.5u w=1.12u l=0.13u
X3021 VPWR.t955 sg13cmos5l_inv_16_15.A sg13cmos5l_inv_16_15.Y VPWR.t4 sg13_lv_pmos ad=0.2128p pd=1.5u as=0.2128p ps=1.5u w=1.12u l=0.13u
X3022 sg13cmos5l_inv_16_58.Y sg13cmos5l_inv_16_69.Y VPWR.t1318 VPWR.t9 sg13_lv_pmos ad=0.2128p pd=1.5u as=0.2128p ps=1.5u w=1.12u l=0.13u
X3023 sg13cmos5l_inv_16_61.Y sg13cmos5l_inv_16_61.A VPWR.t1588 VPWR.t9 sg13_lv_pmos ad=0.2128p pd=1.5u as=0.2128p ps=1.5u w=1.12u l=0.13u
X3024 sg13cmos5l_inv_16_51.Y sg13cmos5l_inv_16_99.A VPWR.t1190 VPWR.t25 sg13_lv_pmos ad=0.2128p pd=1.5u as=0.2128p ps=1.5u w=1.12u l=0.13u
X3025 VGND.t472 sg13cmos5l_inv_16_14.A sg13cmos5l_inv_16_104.Y VGND.t471 sg13_lv_nmos ad=0.1406p pd=1.12u as=0.1406p ps=1.12u w=0.74u l=0.13u
X3026 VPWR.t1000 sg13cmos5l_inv_16_8.Y sg13cmos5l_inv_16_9.A VPWR.t0 sg13_lv_pmos ad=0.4368p pd=3.02u as=0.2128p ps=1.5u w=1.12u l=0.13u
X3027 sg13cmos5l_inv_16_84.Y sg13cmos5l_inv_16_84.A VPWR.t1498 VPWR.t9 sg13_lv_pmos ad=0.2128p pd=1.5u as=0.2128p ps=1.5u w=1.12u l=0.13u
X3028 VGND.t196 VPWR.t2491 VGND.t162 VGND.t2076 sg13_lv_nmos ad=0.1428p pd=1.52u as=0 ps=0 w=0.42u l=1u
X3029 sg13cmos5l_inv_16_76.A sg13cmos5l_inv_16_94.A VGND.t898 VGND.t881 sg13_lv_nmos ad=0.1406p pd=1.12u as=0.1406p ps=1.12u w=0.74u l=0.13u
X3030 sg13cmos5l_inv_16_29.Y sg13cmos5l_inv_16_29.A VPWR.t707 VPWR.t177 sg13_lv_pmos ad=0.2128p pd=1.5u as=0.2128p ps=1.5u w=1.12u l=0.13u
X3031 sg13cmos5l_and2_1_1.B a_2920_7680# VPWR.t1640 VPWR.t16 sg13_lv_pmos ad=0.42p pd=2.99u as=0.2114p ps=1.54u w=1.12u l=0.13u
X3032 VPWR.t2119 sg13cmos5l_inv_16_46.A sg13cmos5l_inv_16_47.A VPWR.t16 sg13_lv_pmos ad=0.2128p pd=1.5u as=0.2128p ps=1.5u w=1.12u l=0.13u
X3033 sg13cmos5l_inv_16_22.Y sg13cmos5l_inv_16_20.A VGND.t375 VGND.t435 sg13_lv_nmos ad=0.1406p pd=1.12u as=0.2516p ps=2.16u w=0.74u l=0.13u
X3034 VGND.t1334 sg13cmos5l_inv_16_26.A sg13cmos5l_inv_16_26.Y VGND.t1333 sg13_lv_nmos ad=0.1406p pd=1.12u as=0.1406p ps=1.12u w=0.74u l=0.13u
X3035 VGND.t215 sg13cmos5l_and2_1_2.X sg13cmos5l_inv_1_2.Y VGND.t1448 sg13_lv_nmos ad=0.2516p pd=2.16u as=0.2516p ps=2.16u w=0.74u l=0.13u
X3036 VPWR.t1116 sg13cmos5l_inv_16_29.A sg13cmos5l_inv_16_35.Y VPWR.t0 sg13_lv_pmos ad=0.2128p pd=1.5u as=0.2128p ps=1.5u w=1.12u l=0.13u
X3037 sg13cmos5l_inv_16_15.A sg13cmos5l_inv_16_23.Y VGND.t45 VGND.t47 sg13_lv_nmos ad=0.1406p pd=1.12u as=0.1406p ps=1.12u w=0.74u l=0.13u
X3038 VGND.t1680 sg13cmos5l_inv_16_53.A sg13cmos5l_inv_16_53.Y VGND.t380 sg13_lv_nmos ad=0.1406p pd=1.12u as=0.1406p ps=1.12u w=0.74u l=0.13u
X3039 sg13cmos5l_inv_16_37.Y sg13cmos5l_inv_16_37.A VGND.t3 VGND.t24 sg13_lv_nmos ad=0.1406p pd=1.12u as=0.1406p ps=1.12u w=0.74u l=0.13u
X3040 VGND.t773 sg13cmos5l_inv_16_99.A sg13cmos5l_inv_16_99.Y VGND.t785 sg13_lv_nmos ad=0.1406p pd=1.12u as=0.1406p ps=1.12u w=0.74u l=0.13u
X3041 VPWR.t504 sg13cmos5l_inv_16_23.Y sg13cmos5l_inv_16_14.A VPWR.t0 sg13_lv_pmos ad=0.2128p pd=1.5u as=0.2128p ps=1.5u w=1.12u l=0.13u
X3042 VPWR.t1316 sg13cmos5l_inv_16_69.Y sg13cmos5l_inv_16_58.Y VPWR.t9 sg13_lv_pmos ad=0.2128p pd=1.5u as=0.2128p ps=1.5u w=1.12u l=0.13u
X3043 VPWR.t1586 sg13cmos5l_inv_16_61.A sg13cmos5l_inv_16_61.Y VPWR.t9 sg13_lv_pmos ad=0.2128p pd=1.5u as=0.2128p ps=1.5u w=1.12u l=0.13u
X3044 VGND.t1718 sg13cmos5l_inv_16_46.A sg13cmos5l_inv_16_47.A VGND.t380 sg13_lv_nmos ad=0.2516p pd=2.16u as=0.1406p ps=1.12u w=0.74u l=0.13u
X3045 sg13cmos5l_inv_16_104.Y sg13cmos5l_inv_16_14.A VGND.t122 VGND.t468 sg13_lv_nmos ad=0.1406p pd=1.12u as=0.2516p ps=2.16u w=0.74u l=0.13u
X3046 sg13cmos5l_inv_16_9.A sg13cmos5l_inv_16_8.Y VPWR.t996 VPWR.t0 sg13_lv_pmos ad=0.2128p pd=1.5u as=0.2128p ps=1.5u w=1.12u l=0.13u
X3047 sg13cmos5l_inv_16_26.Y sg13cmos5l_inv_16_26.A VGND.t414 VGND.t1312 sg13_lv_nmos ad=0.1406p pd=1.12u as=0.2516p ps=2.16u w=0.74u l=0.13u
X3048 VGND.t1507 sg13cmos5l_inv_16_94.A sg13cmos5l_inv_16_76.A VGND.t881 sg13_lv_nmos ad=0.1406p pd=1.12u as=0.1406p ps=1.12u w=0.74u l=0.13u
X3049 VPWR.t2164 sg13cmos5l_inv_16_79.A sg13cmos5l_inv_16_79.Y VPWR.t16 sg13_lv_pmos ad=0.2128p pd=1.5u as=0.2128p ps=1.5u w=1.12u l=0.13u
X3050 VGND.t146 sg13cmos5l_inv_16_43.Y sg13cmos5l_inv_16_36.A VGND.t182 sg13_lv_nmos ad=0.1406p pd=1.12u as=0.1406p ps=1.12u w=0.74u l=0.13u
X3051 VPWR.t2318 sg13cmos5l_inv_16_47.A sg13cmos5l_inv_16_47.Y VPWR.t25 sg13_lv_pmos ad=0.4368p pd=3.02u as=0.2128p ps=1.5u w=1.12u l=0.13u
X3052 VPWR.t1923 a_28556_834# sg13cmos5l_buf_1_0.X VPWR.t177 sg13_lv_pmos ad=0.2114p pd=1.54u as=0.42p ps=2.99u w=1.12u l=0.13u
X3053 sg13cmos5l_inv_16_44.A sg13cmos5l_inv_16_28.A VPWR.t701 VPWR.t4 sg13_lv_pmos ad=0.2128p pd=1.5u as=0.2128p ps=1.5u w=1.12u l=0.13u
X3054 VPWR.t2144 sg13cmos5l_inv_16_79.A sg13cmos5l_inv_16_91.Y VPWR.t16 sg13_lv_pmos ad=0.2128p pd=1.5u as=0.2128p ps=1.5u w=1.12u l=0.13u
X3055 sg13cmos5l_inv_16_59.Y sg13cmos5l_inv_16_61.A VPWR.t1575 VPWR.t9 sg13_lv_pmos ad=0.2128p pd=1.5u as=0.2128p ps=1.5u w=1.12u l=0.13u
X3056 sg13cmos5l_inv_16_45.Y sg13cmos5l_inv_16_47.A VGND.t1715 VGND.t380 sg13_lv_nmos ad=0.1406p pd=1.12u as=0.1406p ps=1.12u w=0.74u l=0.13u
X3057 VPWR.t26 VGND.t756 VPWR.t363 VPWR.t25 sg13_lv_pmos ad=0.34p pd=2.68u as=0 ps=0 w=1u l=1u
X3058 VGND.t773 sg13cmos5l_inv_16_99.A sg13cmos5l_inv_16_51.Y VGND.t775 sg13_lv_nmos ad=0.1406p pd=1.12u as=0.1406p ps=1.12u w=0.74u l=0.13u
X3059 sg13cmos5l_inv_16_22.Y sg13cmos5l_inv_16_20.A VPWR.t880 VPWR.t0 sg13_lv_pmos ad=0.2128p pd=1.5u as=0.2128p ps=1.5u w=1.12u l=0.13u
X3060 VPWR.t915 sg13cmos5l_inv_16_14.A sg13cmos5l_inv_16_14.Y VPWR.t4 sg13_lv_pmos ad=0.2128p pd=1.5u as=0.2128p ps=1.5u w=1.12u l=0.13u
X3061 VPWR.t656 sg13cmos5l_inv_16_41.A sg13cmos5l_inv_16_34.Y VPWR.t0 sg13_lv_pmos ad=0.2128p pd=1.5u as=0.2128p ps=1.5u w=1.12u l=0.13u
X3062 sg13cmos5l_inv_16_27.Y sg13cmos5l_inv_16_27.A VGND.t425 VGND.t1626 sg13_lv_nmos ad=0.1406p pd=1.12u as=0.1406p ps=1.12u w=0.74u l=0.13u
X3063 VGND.t375 sg13cmos5l_inv_16_20.A sg13cmos5l_inv_16_20.Y VGND.t461 sg13_lv_nmos ad=0.1406p pd=1.12u as=0.1406p ps=1.12u w=0.74u l=0.13u
X3064 VPWR.t1153 sg13cmos5l_inv_16_9.A sg13cmos5l_inv_16_9.Y VPWR.t4 sg13_lv_pmos ad=0.2128p pd=1.5u as=0.2128p ps=1.5u w=1.12u l=0.13u
X3065 sg13cmos5l_inv_16_53.Y sg13cmos5l_inv_16_53.A VGND.t1680 VGND.t380 sg13_lv_nmos ad=0.1406p pd=1.12u as=0.1406p ps=1.12u w=0.74u l=0.13u
X3066 sg13cmos5l_inv_16_20.A sg13cmos5l_inv_16_8.Y VPWR.t980 VPWR.t0 sg13_lv_pmos ad=0.2128p pd=1.5u as=0.2128p ps=1.5u w=1.12u l=0.13u
X3067 VGND.t310 sg13cmos5l_inv_1_0.Y sg13cmos5l_inv_2_1.Y VGND.t1467 sg13_lv_nmos ad=0.2516p pd=2.16u as=0.1406p ps=1.12u w=0.74u l=0.13u
X3068 VGND.t15 sg13cmos5l_inv_16_47.A sg13cmos5l_inv_16_47.Y VGND.t2221 sg13_lv_nmos ad=0.1406p pd=1.12u as=0.1406p ps=1.12u w=0.74u l=0.13u
X3069 VPWR.t1947 sg13cmos5l_inv_16_111.A sg13cmos5l_inv_16_111.Y VPWR.t16 sg13_lv_pmos ad=0.2128p pd=1.5u as=0.2128p ps=1.5u w=1.12u l=0.13u
X3070 VPWR.t178 sg13cmos5l_inv_16_30.A sg13cmos5l_inv_16_30.Y VPWR.t177 sg13_lv_pmos ad=0.2128p pd=1.5u as=0.2128p ps=1.5u w=1.12u l=0.13u
X3071 VPWR.t853 VGND.t1143 VPWR.t852 VPWR.t9 sg13_lv_pmos ad=0.34p pd=2.68u as=0 ps=0 w=1u l=1u
X3072 VGND.t898 sg13cmos5l_inv_16_88.A sg13cmos5l_inv_16_94.A VGND.t881 sg13_lv_nmos ad=0.1406p pd=1.12u as=0.1406p ps=1.12u w=0.74u l=0.13u
X3073 VPWR.t2293 sg13cmos5l_inv_16_47.A sg13cmos5l_inv_16_45.Y VPWR.t16 sg13_lv_pmos ad=0.2128p pd=1.5u as=0.2128p ps=1.5u w=1.12u l=0.13u
X3074 sg13cmos5l_inv_16_47.A sg13cmos5l_inv_16_46.A VGND.t1718 VGND.t380 sg13_lv_nmos ad=0.1406p pd=1.12u as=0.1406p ps=1.12u w=0.74u l=0.13u
X3075 sg13cmos5l_inv_16_79.Y sg13cmos5l_inv_16_79.A VPWR.t2160 VPWR.t16 sg13_lv_pmos ad=0.2128p pd=1.5u as=0.2128p ps=1.5u w=1.12u l=0.13u
X3076 VPWR.t994 sg13cmos5l_inv_16_8.Y sg13cmos5l_inv_16_9.A VPWR.t0 sg13_lv_pmos ad=0.2128p pd=1.5u as=0.2128p ps=1.5u w=1.12u l=0.13u
X3077 sg13cmos5l_inv_16_41.A sg13cmos5l_inv_8_3.Y VGND.t226 VGND.t818 sg13_lv_nmos ad=0.1406p pd=1.12u as=0.1406p ps=1.12u w=0.74u l=0.13u
X3078 sg13cmos5l_inv_16_109.Y sg13cmos5l_inv_16_48.A VGND.t1147 VGND.t881 sg13_lv_nmos ad=0.1406p pd=1.12u as=0.1406p ps=1.12u w=0.74u l=0.13u
X3079 VGND.t1507 VPWR.t2571 VGND.t1507 VGND.t881 sg13_lv_nmos ad=0.1428p pd=1.52u as=0 ps=0 w=0.42u l=1u
X3080 sg13cmos5l_inv_16_47.Y sg13cmos5l_inv_16_47.A VPWR.t2314 VPWR.t25 sg13_lv_pmos ad=0.2128p pd=1.5u as=0.2128p ps=1.5u w=1.12u l=0.13u
X3081 VGND.t1469 sg13cmos5l_inv_16_73.A sg13cmos5l_inv_16_87.A VGND.t1478 sg13_lv_nmos ad=0.1406p pd=1.12u as=0.1406p ps=1.12u w=0.74u l=0.13u
X3082 VPWR.t1573 sg13cmos5l_inv_16_61.A sg13cmos5l_inv_16_59.Y VPWR.t9 sg13_lv_pmos ad=0.2128p pd=1.5u as=0.2128p ps=1.5u w=1.12u l=0.13u
X3083 sg13cmos5l_inv_16_103.A sg13cmos5l_inv_16_11.A VGND.t291 VGND.t366 sg13_lv_nmos ad=0.1406p pd=1.12u as=0.1406p ps=1.12u w=0.74u l=0.13u
X3084 VGND.t756 sg13cmos5l_inv_16_111.A sg13cmos5l_inv_16_111.Y VGND.t380 sg13_lv_nmos ad=0.2516p pd=2.16u as=0.1406p ps=1.12u w=0.74u l=0.13u
X3085 sg13cmos5l_inv_16_77.Y sg13cmos5l_inv_16_77.A VGND.t472 VGND.t2176 sg13_lv_nmos ad=0.1406p pd=1.12u as=0.1406p ps=1.12u w=0.74u l=0.13u
X3086 sg13cmos5l_inv_16_10.Y sg13cmos5l_inv_16_9.A VPWR.t1137 VPWR.t0 sg13_lv_pmos ad=0.2128p pd=1.5u as=0.2128p ps=1.5u w=1.12u l=0.13u
X3087 VGND.t635 sg13cmos5l_inv_16_6.Y sg13cmos5l_inv_16_108.Y VGND.t2356 sg13_lv_nmos ad=0.1406p pd=1.12u as=0.1406p ps=1.12u w=0.74u l=0.13u
X3088 VPWR.t1721 sg13cmos5l_inv_16_26.A sg13cmos5l_inv_16_30.A VPWR.t4 sg13_lv_pmos ad=0.2128p pd=1.5u as=0.2128p ps=1.5u w=1.12u l=0.13u
X3089 sg13cmos5l_inv_16_111.A sg13cmos5l_inv_16_109.Y VGND.t1147 VGND.t881 sg13_lv_nmos ad=0.1406p pd=1.12u as=0.1406p ps=1.12u w=0.74u l=0.13u
X3090 VPWR.t1935 sg13cmos5l_inv_16_111.A sg13cmos5l_inv_16_98.Y VPWR.t9 sg13_lv_pmos ad=0.2128p pd=1.5u as=0.2128p ps=1.5u w=1.12u l=0.13u
X3091 VGND.t1954 VPWR.t2562 VGND.t756 VGND.t380 sg13_lv_nmos ad=79.8f pd=0.8u as=0 ps=0 w=0.42u l=1u
X3092 VGND.t1132 sg13cmos5l_inv_16_109.Y sg13cmos5l_inv_16_67.A VGND.t881 sg13_lv_nmos ad=0.1406p pd=1.12u as=0.1406p ps=1.12u w=0.74u l=0.13u
X3093 VPWR.t2040 sg13cmos5l_inv_16_56.Y sg13cmos5l_inv_16_71.Y VPWR.t16 sg13_lv_pmos ad=0.2128p pd=1.5u as=0.2128p ps=1.5u w=1.12u l=0.13u
X3094 sg13cmos5l_inv_16_111.Y sg13cmos5l_inv_16_111.A VPWR.t1943 VPWR.t16 sg13_lv_pmos ad=0.2128p pd=1.5u as=0.2128p ps=1.5u w=1.12u l=0.13u
X3095 VGND.t1970 sg13cmos5l_inv_16_76.A sg13cmos5l_inv_16_77.A VGND.t380 sg13_lv_nmos ad=0.1406p pd=1.12u as=0.1406p ps=1.12u w=0.74u l=0.13u
X3096 sg13cmos5l_inv_16_13.Y sg13cmos5l_inv_16_15.A VPWR.t935 VPWR.t0 sg13_lv_pmos ad=0.2128p pd=1.5u as=0.2128p ps=1.5u w=1.12u l=0.13u
X3097 VPWR.t269 VGND.t1553 VPWR.t267 VPWR.t9 sg13_lv_pmos ad=0.19p pd=1.38u as=0 ps=0 w=1u l=1u
X3098 VPWR.t354 VGND.t1792 VPWR.t353 VPWR.t25 sg13_lv_pmos ad=0.34p pd=2.68u as=0 ps=0 w=1u l=1u
X3099 VGND.t226 sg13cmos5l_inv_8_3.Y sg13cmos5l_inv_16_41.A VGND.t815 sg13_lv_nmos ad=0.1406p pd=1.12u as=0.1406p ps=1.12u w=0.74u l=0.13u
X3100 VPWR.t114 VGND.t1100 VPWR.t113 VPWR.t25 sg13_lv_pmos ad=0.34p pd=2.68u as=0 ps=0 w=1u l=1u
X3101 VPWR.t419 VGND.t450 VPWR.t418 VPWR.t0 sg13_lv_pmos ad=0.34p pd=2.68u as=0 ps=0 w=1u l=1u
X3102 VGND.t675 sg13cmos5l_inv_16_1.A sg13cmos5l_inv_16_17.A VGND.t683 sg13_lv_nmos ad=0.1406p pd=1.12u as=0.1406p ps=1.12u w=0.74u l=0.13u
X3103 sg13cmos5l_inv_16_87.A sg13cmos5l_inv_16_73.A VGND.t1469 VGND.t1475 sg13_lv_nmos ad=0.1406p pd=1.12u as=0.1406p ps=1.12u w=0.74u l=0.13u
X3104 sg13cmos5l_inv_16_0.A sg13cmos5l_inv_8_0.Y VPWR.t2419 VPWR.t177 sg13_lv_pmos ad=0.2128p pd=1.5u as=0.2128p ps=1.5u w=1.12u l=0.13u
X3105 VPWR.t686 sg13cmos5l_and2_1_4.B a_6957_3492# VPWR.t4 sg13_lv_pmos ad=0.1918p pd=1.5u as=0.1596p ps=1.22u w=0.84u l=0.13u
X3106 sg13cmos5l_inv_16_59.Y sg13cmos5l_inv_16_61.A VPWR.t1569 VPWR.t9 sg13_lv_pmos ad=0.2128p pd=1.5u as=0.2128p ps=1.5u w=1.12u l=0.13u
X3107 sg13cmos5l_inv_16_105.A sg13cmos5l_inv_16_11.A VGND.t353 VGND.t354 sg13_lv_nmos ad=0.1406p pd=1.12u as=0.1406p ps=1.12u w=0.74u l=0.13u
X3108 VGND.t291 sg13cmos5l_inv_16_11.A sg13cmos5l_inv_16_103.A VGND.t363 sg13_lv_nmos ad=0.1406p pd=1.12u as=0.1406p ps=1.12u w=0.74u l=0.13u
X3109 sg13cmos5l_inv_16_30.A sg13cmos5l_inv_16_26.A VPWR.t1717 VPWR.t4 sg13_lv_pmos ad=0.2128p pd=1.5u as=0.2128p ps=1.5u w=1.12u l=0.13u
X3110 sg13cmos5l_inv_16_111.Y sg13cmos5l_inv_16_111.A VGND.t756 VGND.t380 sg13_lv_nmos ad=0.1406p pd=1.12u as=0.1406p ps=1.12u w=0.74u l=0.13u
X3111 sg13cmos5l_inv_16_108.Y sg13cmos5l_inv_16_6.Y VGND.t635 VGND.t2353 sg13_lv_nmos ad=0.1406p pd=1.12u as=0.1406p ps=1.12u w=0.74u l=0.13u
X3112 VGND.t882 sg13cmos5l_inv_16_68.A sg13cmos5l_inv_16_68.Y VGND.t881 sg13_lv_nmos ad=0.1406p pd=1.12u as=0.1406p ps=1.12u w=0.74u l=0.13u
X3113 sg13cmos5l_inv_16_48.A sg13cmos5l_inv_8_7.Y VGND.t756 VGND.t380 sg13_lv_nmos ad=0.1406p pd=1.12u as=0.1406p ps=1.12u w=0.74u l=0.13u
X3114 sg13cmos5l_inv_16_99.Y sg13cmos5l_inv_16_99.A VPWR.t1188 VPWR.t0 sg13_lv_pmos ad=0.2128p pd=1.5u as=0.3808p ps=2.92u w=1.12u l=0.13u
X3115 VPWR.t178 sg13cmos5l_inv_16_30.A sg13cmos5l_inv_16_31.Y VPWR.t177 sg13_lv_pmos ad=0.2128p pd=1.5u as=0.2128p ps=1.5u w=1.12u l=0.13u
X3116 sg13cmos5l_inv_16_98.Y sg13cmos5l_inv_16_111.A VPWR.t1931 VPWR.t9 sg13_lv_pmos ad=0.2128p pd=1.5u as=0.2128p ps=1.5u w=1.12u l=0.13u
X3117 VPWR.t1454 sg13cmos5l_inv_16_81.Y sg13cmos5l_inv_16_79.A VPWR.t16 sg13_lv_pmos ad=0.2128p pd=1.5u as=0.2128p ps=1.5u w=1.12u l=0.13u
X3118 sg13cmos5l_inv_16_25.Y sg13cmos5l_inv_16_6.Y VGND.t1245 VGND.t2339 sg13_lv_nmos ad=0.1406p pd=1.12u as=0.1406p ps=1.12u w=0.74u l=0.13u
X3119 VPWR.t1079 sg13cmos5l_inv_16_1.A sg13cmos5l_inv_16_2.A VPWR.t4 sg13_lv_pmos ad=0.2128p pd=1.5u as=0.2128p ps=1.5u w=1.12u l=0.13u
X3120 sg13cmos5l_inv_16_84.A sg13cmos5l_inv_16_81.Y VPWR.t1444 VPWR.t9 sg13_lv_pmos ad=0.2128p pd=1.5u as=0.2128p ps=1.5u w=1.12u l=0.13u
X3121 sg13cmos5l_inv_16_68.A sg13cmos5l_inv_16_71.Y VGND.t882 VGND.t881 sg13_lv_nmos ad=0.1406p pd=1.12u as=0.1406p ps=1.12u w=0.74u l=0.13u
X3122 sg13cmos5l_inv_16_110.Y sg13cmos5l_inv_16_5.Y VGND.t637 VGND.t638 sg13_lv_nmos ad=0.1406p pd=1.12u as=0.1406p ps=1.12u w=0.74u l=0.13u
X3123 VPWR.t1715 sg13cmos5l_inv_16_26.A sg13cmos5l_inv_16_30.A VPWR.t4 sg13_lv_pmos ad=0.2128p pd=1.5u as=0.2128p ps=1.5u w=1.12u l=0.13u
X3124 VGND.t756 sg13cmos5l_inv_16_111.A sg13cmos5l_inv_16_111.Y VGND.t380 sg13_lv_nmos ad=0.1406p pd=1.12u as=0.1406p ps=1.12u w=0.74u l=0.13u
X3125 sg13cmos5l_inv_16_31.Y sg13cmos5l_inv_16_30.A VPWR.t480 VPWR.t177 sg13_lv_pmos ad=0.2128p pd=1.5u as=0.2128p ps=1.5u w=1.12u l=0.13u
X3126 sg13cmos5l_inv_16_79.A sg13cmos5l_inv_16_81.Y VPWR.t1450 VPWR.t16 sg13_lv_pmos ad=0.2128p pd=1.5u as=0.2128p ps=1.5u w=1.12u l=0.13u
X3127 VPWR.t61 VGND.t1029 VPWR.t59 VPWR.t9 sg13_lv_pmos ad=0.19p pd=1.38u as=0 ps=0 w=1u l=1u
X3128 VGND.t1718 sg13cmos5l_inv_16_48.A sg13cmos5l_inv_16_46.A VGND.t380 sg13_lv_nmos ad=0.1406p pd=1.12u as=0.1406p ps=1.12u w=0.74u l=0.13u
X3129 sg13cmos5l_and2_1_4.B a_2920_3932# VPWR.t2286 VPWR.t0 sg13_lv_pmos ad=0.42p pd=2.99u as=0.2114p ps=1.54u w=1.12u l=0.13u
X3130 VGND.t198 sg13cmos5l_inv_16_44.A sg13cmos5l_inv_16_44.Y VGND.t205 sg13_lv_nmos ad=0.1406p pd=1.12u as=0.1406p ps=1.12u w=0.74u l=0.13u
X3131 sg13cmos5l_inv_16_96.Y sg13cmos5l_inv_16_96.A VGND.t545 VGND.t945 sg13_lv_nmos ad=0.1406p pd=1.12u as=0.1406p ps=1.12u w=0.74u l=0.13u
X3132 VPWR.t2266 sg13cmos5l_inv_16_77.A sg13cmos5l_inv_16_77.Y VPWR.t25 sg13_lv_pmos ad=0.4368p pd=3.02u as=0.2128p ps=1.5u w=1.12u l=0.13u
X3133 a_28556_834# en[7] VPWR.t1923 VPWR.t177 sg13_lv_pmos ad=0.2856p pd=2.36u as=0.2114p ps=1.54u w=0.84u l=0.13u
X3134 VGND.t655 sg13cmos5l_inv_16_1.A sg13cmos5l_inv_16_2.A VGND.t668 sg13_lv_nmos ad=0.1406p pd=1.12u as=0.1406p ps=1.12u w=0.74u l=0.13u
X3135 VGND.t196 VPWR.t2490 VGND.t196 VGND.t2078 sg13_lv_nmos ad=0.1428p pd=1.52u as=0 ps=0 w=0.42u l=1u
X3136 sg13cmos5l_inv_8_7.Y sg13cmos5l_inv_4_4.Y VGND.t432 VGND.t630 sg13_lv_nmos ad=0.1406p pd=1.12u as=0.1406p ps=1.12u w=0.74u l=0.13u
X3137 VGND.t1026 sg13cmos5l_inv_16_79.A sg13cmos5l_inv_16_91.Y VGND.t881 sg13_lv_nmos ad=0.1406p pd=1.12u as=0.1406p ps=1.12u w=0.74u l=0.13u
X3138 sg13cmos5l_inv_16_47.A sg13cmos5l_inv_16_46.A VPWR.t2112 VPWR.t16 sg13_lv_pmos ad=0.2128p pd=1.5u as=0.3808p ps=2.92u w=1.12u l=0.13u
X3139 VGND.t1628 sg13cmos5l_inv_16_27.A sg13cmos5l_inv_16_27.Y VGND.t1627 sg13_lv_nmos ad=0.2516p pd=2.16u as=0.1406p ps=1.12u w=0.74u l=0.13u
X3140 VGND.t1067 sg13cmos5l_inv_16_84.A sg13cmos5l_inv_16_85.Y VGND.t1082 sg13_lv_nmos ad=0.2516p pd=2.16u as=0.1406p ps=1.12u w=0.74u l=0.13u
X3141 sg13cmos5l_inv_16_53.Y sg13cmos5l_inv_16_53.A VGND.t1680 VGND.t380 sg13_lv_nmos ad=0.1406p pd=1.12u as=0.1406p ps=1.12u w=0.74u l=0.13u
X3142 sg13cmos5l_inv_16_105.A sg13cmos5l_inv_16_11.A VGND.t345 VGND.t349 sg13_lv_nmos ad=0.1406p pd=1.12u as=0.1406p ps=1.12u w=0.74u l=0.13u
X3143 VGND.t5 VPWR.t2525 VGND.t5 VGND.t2019 sg13_lv_nmos ad=0.1428p pd=1.52u as=0 ps=0 w=0.42u l=1u
X3144 VPWR.t1609 sg13cmos5l_inv_16_103.A sg13cmos5l_inv_16_103.Y VPWR.t0 sg13_lv_pmos ad=0.2128p pd=1.5u as=0.2128p ps=1.5u w=1.12u l=0.13u
X3145 VGND.t882 sg13cmos5l_inv_16_68.A sg13cmos5l_inv_16_68.Y VGND.t881 sg13_lv_nmos ad=0.1406p pd=1.12u as=0.1406p ps=1.12u w=0.74u l=0.13u
X3146 VPWR.t480 sg13cmos5l_inv_16_30.A sg13cmos5l_inv_16_30.Y VPWR.t177 sg13_lv_pmos ad=0.2128p pd=1.5u as=0.2128p ps=1.5u w=1.12u l=0.13u
X3147 VPWR.t2289 sg13cmos5l_inv_16_47.A sg13cmos5l_inv_16_45.Y VPWR.t16 sg13_lv_pmos ad=0.2128p pd=1.5u as=0.2128p ps=1.5u w=1.12u l=0.13u
X3148 VPWR.t767 sg13cmos5l_inv_16_26.A sg13cmos5l_inv_16_26.Y VPWR.t177 sg13_lv_pmos ad=0.2128p pd=1.5u as=0.2128p ps=1.5u w=1.12u l=0.13u
X3149 sg13cmos5l_inv_16_27.Y sg13cmos5l_inv_16_27.A VGND.t425 VGND.t1622 sg13_lv_nmos ad=0.1406p pd=1.12u as=0.1406p ps=1.12u w=0.74u l=0.13u
X3150 VPWR.t747 sg13cmos5l_inv_16_4.Y sg13cmos5l_inv_16_6.A VPWR.t4 sg13_lv_pmos ad=0.2128p pd=1.5u as=0.2128p ps=1.5u w=1.12u l=0.13u
X3151 sg13cmos5l_inv_16_44.Y sg13cmos5l_inv_16_44.A VGND.t198 VGND.t202 sg13_lv_nmos ad=0.1406p pd=1.12u as=0.1406p ps=1.12u w=0.74u l=0.13u
X3152 VPWR.t887 sg13cmos5l_inv_16_20.A sg13cmos5l_inv_16_20.Y VPWR.t4 sg13_lv_pmos ad=0.2128p pd=1.5u as=0.2128p ps=1.5u w=1.12u l=0.13u
X3153 VGND.t898 sg13cmos5l_inv_16_88.A sg13cmos5l_inv_16_94.A VGND.t881 sg13_lv_nmos ad=0.1406p pd=1.12u as=0.1406p ps=1.12u w=0.74u l=0.13u
X3154 VPWR.t780 sg13cmos5l_inv_16_11.A sg13cmos5l_inv_16_105.A VPWR.t25 sg13_lv_pmos ad=0.2128p pd=1.5u as=0.2128p ps=1.5u w=1.12u l=0.13u
X3155 sg13cmos5l_inv_16_47.Y sg13cmos5l_inv_16_47.A VPWR.t2310 VPWR.t25 sg13_lv_pmos ad=0.2128p pd=1.5u as=0.2128p ps=1.5u w=1.12u l=0.13u
X3156 VGND.t52 VPWR.t2482 VGND.t52 VGND.t2093 sg13_lv_nmos ad=79.8f pd=0.8u as=0 ps=0 w=0.42u l=1u
X3157 VGND.t432 sg13cmos5l_inv_4_4.Y sg13cmos5l_inv_8_7.Y VGND.t627 sg13_lv_nmos ad=0.1406p pd=1.12u as=0.1406p ps=1.12u w=0.74u l=0.13u
X3158 VGND.t353 VPWR.t2518 VGND.t353 VGND.t2008 sg13_lv_nmos ad=79.8f pd=0.8u as=0 ps=0 w=0.42u l=1u
X3159 sg13cmos5l_inv_16_91.Y sg13cmos5l_inv_16_79.A VGND.t1083 VGND.t881 sg13_lv_nmos ad=0.1406p pd=1.12u as=0.1406p ps=1.12u w=0.74u l=0.13u
X3160 sg13cmos5l_inv_16_48.A sg13cmos5l_inv_8_7.Y VPWR.t1181 VPWR.t25 sg13_lv_pmos ad=0.2128p pd=1.5u as=0.2128p ps=1.5u w=1.12u l=0.13u
X3161 VGND.t1944 sg13cmos5l_inv_16_47.A sg13cmos5l_inv_16_45.Y VGND.t380 sg13_lv_nmos ad=0.1406p pd=1.12u as=0.1406p ps=1.12u w=0.74u l=0.13u
X3162 VPWR.t29 VGND.t1779 VPWR.t28 VPWR.t25 sg13_lv_pmos ad=0.34p pd=2.68u as=0 ps=0 w=1u l=1u
X3163 VPWR.t568 sg13cmos5l_inv_16_36.A sg13cmos5l_inv_16_100.Y VPWR.t0 sg13_lv_pmos ad=0.2128p pd=1.5u as=0.2128p ps=1.5u w=1.12u l=0.13u
X3164 sg13cmos5l_inv_16_111.A sg13cmos5l_inv_16_109.Y VGND.t1147 VGND.t881 sg13_lv_nmos ad=0.1406p pd=1.12u as=0.1406p ps=1.12u w=0.74u l=0.13u
X3165 sg13cmos5l_inv_16_67.Y sg13cmos5l_inv_16_67.A VGND.t1132 VGND.t881 sg13_lv_nmos ad=0.1406p pd=1.12u as=0.2516p ps=2.16u w=0.74u l=0.13u
X3166 sg13cmos5l_inv_16_68.A sg13cmos5l_inv_16_71.Y VGND.t882 VGND.t881 sg13_lv_nmos ad=0.1406p pd=1.12u as=0.2516p ps=2.16u w=0.74u l=0.13u
X3167 sg13cmos5l_inv_16_99.A sg13cmos5l_inv_16_34.Y VPWR.t1015 VPWR.t25 sg13_lv_pmos ad=0.2128p pd=1.5u as=0.3808p ps=2.92u w=1.12u l=0.13u
X3168 sg13cmos5l_inv_4_6.Y sg13cmos5l_inv_4_6.A VGND.t122 VGND.t807 sg13_lv_nmos ad=0.1406p pd=1.12u as=0.1406p ps=1.12u w=0.74u l=0.13u
X3169 sg13cmos5l_inv_16_111.Y sg13cmos5l_inv_16_111.A VPWR.t1940 VPWR.t16 sg13_lv_pmos ad=0.2128p pd=1.5u as=0.3808p ps=2.92u w=1.12u l=0.13u
X3170 VGND.t390 sg13cmos5l_inv_16_76.A sg13cmos5l_inv_16_77.A VGND.t380 sg13_lv_nmos ad=0.1406p pd=1.12u as=0.1406p ps=1.12u w=0.74u l=0.13u
X3171 VPWR.t2366 sg13cmos5l_inv_8_4.Y sg13cmos5l_inv_16_56.Y VPWR.t25 sg13_lv_pmos ad=0.2128p pd=1.5u as=0.2128p ps=1.5u w=1.12u l=0.13u
X3172 sg13cmos5l_inv_16_30.Y sg13cmos5l_inv_16_30.A VPWR.t480 VPWR.t177 sg13_lv_pmos ad=0.2128p pd=1.5u as=0.2128p ps=1.5u w=1.12u l=0.13u
X3173 sg13cmos5l_inv_8_3.Y sg13cmos5l_inv_4_2.Y VGND.t1236 VGND.t1237 sg13_lv_nmos ad=0.1406p pd=1.12u as=0.1406p ps=1.12u w=0.74u l=0.13u
X3174 sg13cmos5l_inv_16_26.Y sg13cmos5l_inv_16_26.A VPWR.t767 VPWR.t177 sg13_lv_pmos ad=0.2128p pd=1.5u as=0.2128p ps=1.5u w=1.12u l=0.13u
X3175 sg13cmos5l_inv_16_6.A sg13cmos5l_inv_16_4.Y VPWR.t743 VPWR.t4 sg13_lv_pmos ad=0.2128p pd=1.5u as=0.2128p ps=1.5u w=1.12u l=0.13u
X3176 sg13cmos5l_inv_16_20.Y sg13cmos5l_inv_16_20.A VPWR.t883 VPWR.t4 sg13_lv_pmos ad=0.2128p pd=1.5u as=0.2128p ps=1.5u w=1.12u l=0.13u
X3177 VPWR.t1388 sg13cmos5l_inv_16_71.Y sg13cmos5l_inv_16_68.A VPWR.t9 sg13_lv_pmos ad=0.2128p pd=1.5u as=0.2128p ps=1.5u w=1.12u l=0.13u
X3178 sg13cmos5l_inv_16_94.A sg13cmos5l_inv_16_88.A VGND.t898 VGND.t881 sg13_lv_nmos ad=0.1406p pd=1.12u as=0.1406p ps=1.12u w=0.74u l=0.13u
X3179 VGND.t310 sg13cmos5l_inv_16_4.Y sg13cmos5l_inv_16_6.A VGND.t324 sg13_lv_nmos ad=0.2516p pd=2.16u as=0.1406p ps=1.12u w=0.74u l=0.13u
X3180 VGND.t1680 VPWR.t2569 VGND.t427 VGND.t380 sg13_lv_nmos ad=79.8f pd=0.8u as=0 ps=0 w=0.42u l=1u
X3181 sg13cmos5l_inv_16_51.Y sg13cmos5l_inv_16_99.A VGND.t773 VGND.t788 sg13_lv_nmos ad=0.1406p pd=1.12u as=0.1406p ps=1.12u w=0.74u l=0.13u
X3182 VPWR.t1179 sg13cmos5l_inv_8_7.Y sg13cmos5l_inv_16_48.A VPWR.t25 sg13_lv_pmos ad=0.2128p pd=1.5u as=0.2128p ps=1.5u w=1.12u l=0.13u
X3183 VGND.t637 sg13cmos5l_inv_16_6.A sg13cmos5l_inv_16_5.Y VGND.t1387 sg13_lv_nmos ad=0.1406p pd=1.12u as=0.1406p ps=1.12u w=0.74u l=0.13u
X3184 VPWR.t272 sg13cmos5l_inv_1_2.Y sg13cmos5l_inv_2_3.Y VPWR.t177 sg13_lv_pmos ad=0.3864p pd=2.93u as=0.2128p ps=1.5u w=1.12u l=0.13u
X3185 VGND.t1663 sg13cmos5l_inv_16_101.Y sg13cmos5l_inv_16_55.Y VGND.t380 sg13_lv_nmos ad=0.1406p pd=1.12u as=0.1406p ps=1.12u w=0.74u l=0.13u
X3186 VPWR.t1364 sg13cmos5l_inv_4_6.Y sg13cmos5l_inv_16_96.A VPWR.t25 sg13_lv_pmos ad=0.2128p pd=1.5u as=0.2128p ps=1.5u w=1.12u l=0.13u
X3187 VGND.t845 sg13cmos5l_inv_16_0.A sg13cmos5l_inv_16_1.A VGND.t847 sg13_lv_nmos ad=0.1406p pd=1.12u as=0.1406p ps=1.12u w=0.74u l=0.13u
X3188 VPWR.t2104 sg13cmos5l_inv_16_48.A sg13cmos5l_inv_16_46.A VPWR.t25 sg13_lv_pmos ad=0.2128p pd=1.5u as=0.2128p ps=1.5u w=1.12u l=0.13u
X3189 VPWR.t1052 sg13cmos5l_inv_4_4.Y sg13cmos5l_inv_8_7.Y VPWR.t25 sg13_lv_pmos ad=0.2128p pd=1.5u as=0.2128p ps=1.5u w=1.12u l=0.13u
X3190 VPWR.t1352 sg13cmos5l_inv_16_96.A sg13cmos5l_inv_16_96.Y VPWR.t25 sg13_lv_pmos ad=0.2128p pd=1.5u as=0.2128p ps=1.5u w=1.12u l=0.13u
X3191 VGND.t1260 sg13cmos5l_inv_16_27.Y sg13cmos5l_inv_16_43.Y VGND.t1259 sg13_lv_nmos ad=0.2516p pd=2.16u as=0.1406p ps=1.12u w=0.74u l=0.13u
X3192 sg13cmos5l_inv_16_77.A sg13cmos5l_inv_16_76.A VGND.t390 VGND.t380 sg13_lv_nmos ad=0.1406p pd=1.12u as=0.2516p ps=2.16u w=0.74u l=0.13u
X3193 VPWR.t172 VGND.t20 VPWR.t171 VPWR.t0 sg13_lv_pmos ad=0.34p pd=2.68u as=0 ps=0 w=1u l=1u
X3194 VPWR.t1605 sg13cmos5l_inv_16_103.A sg13cmos5l_inv_16_103.Y VPWR.t0 sg13_lv_pmos ad=0.2128p pd=1.5u as=0.2128p ps=1.5u w=1.12u l=0.13u
X3195 VGND.t1680 sg13cmos5l_inv_16_101.Y sg13cmos5l_inv_16_54.Y VGND.t380 sg13_lv_nmos ad=0.2516p pd=2.16u as=0.1406p ps=1.12u w=0.74u l=0.13u
X3196 VGND.t291 VPWR.t2488 VGND.t291 VGND.t2082 sg13_lv_nmos ad=79.8f pd=0.8u as=0 ps=0 w=0.42u l=1u
X3197 VGND.t963 sg13cmos5l_inv_16_61.A sg13cmos5l_inv_16_61.Y VGND.t881 sg13_lv_nmos ad=0.2516p pd=2.16u as=0.1406p ps=1.12u w=0.74u l=0.13u
X3198 VGND.t827 sg13cmos5l_inv_16_0.A sg13cmos5l_inv_16_23.Y VGND.t830 sg13_lv_nmos ad=0.1406p pd=1.12u as=0.1406p ps=1.12u w=0.74u l=0.13u
X3199 VGND.t773 sg13cmos5l_inv_16_99.A sg13cmos5l_inv_16_51.Y VGND.t785 sg13_lv_nmos ad=0.1406p pd=1.12u as=0.1406p ps=1.12u w=0.74u l=0.13u
X3200 VGND.t5 sg13cmos5l_inv_2_7.Y sg13cmos5l_inv_4_5.Y VGND.t418 sg13_lv_nmos ad=0.2516p pd=2.16u as=0.1406p ps=1.12u w=0.74u l=0.13u
X3201 VPWR.t776 sg13cmos5l_inv_16_11.A sg13cmos5l_inv_16_105.A VPWR.t25 sg13_lv_pmos ad=0.2128p pd=1.5u as=0.2128p ps=1.5u w=1.12u l=0.13u
X3202 VGND.t2144 VPWR.t329 VGND.t2146 VGND.t2145 sg13_lv_nmos ad=79.8f pd=0.8u as=0 ps=0 w=0.42u l=1u
X3203 sg13cmos5l_inv_16_29.Y sg13cmos5l_inv_16_29.A VPWR.t706 VPWR.t177 sg13_lv_pmos ad=0.2128p pd=1.5u as=0.3808p ps=2.92u w=1.12u l=0.13u
X3204 sg13cmos5l_inv_16_108.Y sg13cmos5l_inv_16_6.Y VPWR.t1001 VPWR.t177 sg13_lv_pmos ad=0.2128p pd=1.5u as=0.2128p ps=1.5u w=1.12u l=0.13u
X3205 VGND.t1243 sg13cmos5l_inv_16_27.Y sg13cmos5l_inv_16_26.A VGND.t1264 sg13_lv_nmos ad=0.1406p pd=1.12u as=0.1406p ps=1.12u w=0.74u l=0.13u
X3206 VPWR.t302 VGND.t429 VPWR.t180 VPWR.t0 sg13_lv_pmos ad=0.19p pd=1.38u as=0 ps=0 w=1u l=1u
X3207 VPWR.t2413 sg13cmos5l_inv_8_0.Y sg13cmos5l_inv_16_0.A VPWR.t177 sg13_lv_pmos ad=0.2128p pd=1.5u as=0.2128p ps=1.5u w=1.12u l=0.13u
X3208 sg13cmos5l_inv_16_94.A sg13cmos5l_inv_16_88.A VPWR.t2020 VPWR.t9 sg13_lv_pmos ad=0.2128p pd=1.5u as=0.2128p ps=1.5u w=1.12u l=0.13u
X3209 VPWR.t2203 sg13cmos5l_inv_16_73.Y sg13cmos5l_inv_16_90.Y VPWR.t16 sg13_lv_pmos ad=0.2128p pd=1.5u as=0.2128p ps=1.5u w=1.12u l=0.13u
X3210 sg13cmos5l_inv_16_96.A sg13cmos5l_inv_4_6.Y VPWR.t1360 VPWR.t25 sg13_lv_pmos ad=0.2128p pd=1.5u as=0.2128p ps=1.5u w=1.12u l=0.13u
X3211 sg13cmos5l_inv_16_1.A sg13cmos5l_inv_16_0.A VGND.t655 VGND.t843 sg13_lv_nmos ad=0.1406p pd=1.12u as=0.2516p ps=2.16u w=0.74u l=0.13u
X3212 sg13cmos5l_inv_16_31.Y sg13cmos5l_inv_16_30.A VPWR.t480 VPWR.t177 sg13_lv_pmos ad=0.2128p pd=1.5u as=0.2128p ps=1.5u w=1.12u l=0.13u
X3213 VPWR.t1312 sg13cmos5l_inv_16_69.Y sg13cmos5l_inv_16_58.Y VPWR.t9 sg13_lv_pmos ad=0.2128p pd=1.5u as=0.2128p ps=1.5u w=1.12u l=0.13u
X3214 VGND.t845 VPWR.t2469 VGND.t845 VGND.t2120 sg13_lv_nmos ad=0.1428p pd=1.52u as=0 ps=0 w=0.42u l=1u
X3215 VPWR.t445 VGND.t2117 VPWR.t446 VPWR.t177 sg13_lv_pmos ad=0.19p pd=1.38u as=0 ps=0 w=1u l=1u
X3216 sg13cmos5l_inv_16_2.A sg13cmos5l_inv_16_1.A VPWR.t1072 VPWR.t4 sg13_lv_pmos ad=0.2128p pd=1.5u as=0.3808p ps=2.92u w=1.12u l=0.13u
X3217 VGND.t635 VPWR.t2476 VGND.t635 VGND.t2104 sg13_lv_nmos ad=0.1428p pd=1.52u as=0 ps=0 w=0.42u l=1u
X3218 sg13cmos5l_inv_16_53.A sg13cmos5l_inv_16_52.Y VGND.t1164 VGND.t881 sg13_lv_nmos ad=0.1406p pd=1.12u as=0.2516p ps=2.16u w=0.74u l=0.13u
X3219 sg13cmos5l_inv_16_23.Y sg13cmos5l_inv_16_0.A VGND.t827 VGND.t826 sg13_lv_nmos ad=0.1406p pd=1.12u as=0.2516p ps=2.16u w=0.74u l=0.13u
X3220 VPWR.t1555 sg13cmos5l_inv_16_109.Y sg13cmos5l_inv_16_111.A VPWR.t9 sg13_lv_pmos ad=0.2128p pd=1.5u as=0.2128p ps=1.5u w=1.12u l=0.13u
X3221 sg13cmos5l_inv_4_5.Y sg13cmos5l_inv_2_7.Y VGND.t5 VGND.t415 sg13_lv_nmos ad=0.1406p pd=1.12u as=0.2516p ps=2.16u w=0.74u l=0.13u
X3222 sg13cmos5l_inv_16_26.Y sg13cmos5l_inv_16_26.A VPWR.t767 VPWR.t177 sg13_lv_pmos ad=0.2128p pd=1.5u as=0.2128p ps=1.5u w=1.12u l=0.13u
X3223 VGND.t1067 sg13cmos5l_inv_16_84.A sg13cmos5l_inv_16_85.Y VGND.t1078 sg13_lv_nmos ad=0.1406p pd=1.12u as=0.1406p ps=1.12u w=0.74u l=0.13u
X3224 VPWR.t1384 sg13cmos5l_inv_16_71.Y sg13cmos5l_inv_16_68.A VPWR.t9 sg13_lv_pmos ad=0.2128p pd=1.5u as=0.2128p ps=1.5u w=1.12u l=0.13u
X3225 sg13cmos5l_inv_16_26.A sg13cmos5l_inv_16_27.Y VGND.t1243 VGND.t1261 sg13_lv_nmos ad=0.1406p pd=1.12u as=0.2516p ps=2.16u w=0.74u l=0.13u
X3226 VPWR.t1223 sg13cmos5l_inv_4_6.A sg13cmos5l_inv_4_6.Y VPWR.t25 sg13_lv_pmos ad=0.3808p pd=2.92u as=0.2128p ps=1.5u w=1.12u l=0.13u
X3227 sg13cmos5l_inv_16_36.A sg13cmos5l_inv_16_43.Y VPWR.t605 VPWR.t0 sg13_lv_pmos ad=0.2128p pd=1.5u as=0.4368p ps=3.02u w=1.12u l=0.13u
X3228 VGND.t1419 a_17516_834# sg13cmos5l_buf_1_3.X VGND.t1502 sg13_lv_nmos ad=0.14875p pd=1.16u as=0.2886p ps=2.26u w=0.74u l=0.13u
X3229 VPWR.t1217 sg13cmos5l_inv_16_99.A sg13cmos5l_inv_16_99.Y VPWR.t0 sg13_lv_pmos ad=0.2128p pd=1.5u as=0.2128p ps=1.5u w=1.12u l=0.13u
X3230 VGND.t345 sg13cmos5l_inv_16_105.A sg13cmos5l_inv_16_105.Y VGND.t1107 sg13_lv_nmos ad=0.1406p pd=1.12u as=0.1406p ps=1.12u w=0.74u l=0.13u
X3231 a_17516_834# en[4] VGND.t1419 VGND.t2231 sg13_lv_nmos ad=0.187p pd=1.78u as=0.14875p ps=1.16u w=0.55u l=0.13u
X3232 VGND.t2050 VPWR.t2495 VGND.t226 VGND.t2069 sg13_lv_nmos ad=0.1428p pd=1.52u as=0 ps=0 w=0.42u l=1u
X3233 VPWR.t2018 sg13cmos5l_inv_16_88.A sg13cmos5l_inv_16_94.A VPWR.t9 sg13_lv_pmos ad=0.2128p pd=1.5u as=0.2128p ps=1.5u w=1.12u l=0.13u
X3234 sg13cmos5l_inv_16_73.Y sg13cmos5l_inv_16_73.A VGND.t381 VGND.t380 sg13_lv_nmos ad=0.1406p pd=1.12u as=0.2516p ps=2.16u w=0.74u l=0.13u
X3235 VPWR.t203 VGND.t1 VPWR.t202 VPWR.t0 sg13_lv_pmos ad=0.34p pd=2.68u as=0 ps=0 w=1u l=1u
X3236 sg13cmos5l_inv_16_104.Y sg13cmos5l_inv_16_14.A VPWR.t899 VPWR.t0 sg13_lv_pmos ad=0.2128p pd=1.5u as=0.2128p ps=1.5u w=1.12u l=0.13u
X3237 VGND.t198 sg13cmos5l_inv_16_28.A sg13cmos5l_inv_16_29.A VGND.t205 sg13_lv_nmos ad=0.1406p pd=1.12u as=0.1406p ps=1.12u w=0.74u l=0.13u
X3238 VPWR.t1918 sg13cmos5l_inv_16_94.A sg13cmos5l_inv_16_76.A VPWR.t16 sg13_lv_pmos ad=0.2128p pd=1.5u as=0.2128p ps=1.5u w=1.12u l=0.13u
X3239 VPWR.t1204 sg13cmos5l_inv_16_99.A sg13cmos5l_inv_16_51.Y VPWR.t25 sg13_lv_pmos ad=0.4368p pd=3.02u as=0.2128p ps=1.5u w=1.12u l=0.13u
X3240 VPWR.t602 sg13cmos5l_inv_16_43.Y sg13cmos5l_inv_16_37.A VPWR.t0 sg13_lv_pmos ad=0.2128p pd=1.5u as=0.2128p ps=1.5u w=1.12u l=0.13u
X3241 VPWR.t178 VGND.t414 VPWR.t178 VPWR.t177 sg13_lv_pmos ad=0.19p pd=1.38u as=0 ps=0 w=1u l=1u
X3242 VPWR.t41 VGND.t1820 VPWR.t40 VPWR.t9 sg13_lv_pmos ad=0.19p pd=1.38u as=0 ps=0 w=1u l=1u
X3243 sg13cmos5l_inv_16_111.A sg13cmos5l_inv_16_109.Y VPWR.t1535 VPWR.t9 sg13_lv_pmos ad=0.2128p pd=1.5u as=0.4368p ps=3.02u w=1.12u l=0.13u
X3244 sg13cmos5l_inv_16_75.A sg13cmos5l_inv_16_76.A VGND.t1970 VGND.t380 sg13_lv_nmos ad=0.1406p pd=1.12u as=0.1406p ps=1.12u w=0.74u l=0.13u
X3245 VGND.t1100 VPWR.t2533 VGND.t1100 VGND.t2005 sg13_lv_nmos ad=0.1428p pd=1.52u as=0 ps=0 w=0.42u l=1u
X3246 VGND.t545 sg13cmos5l_inv_16_96.A sg13cmos5l_inv_16_96.Y VGND.t938 sg13_lv_nmos ad=0.1406p pd=1.12u as=0.1406p ps=1.12u w=0.74u l=0.13u
X3247 sg13cmos5l_inv_16_91.Y sg13cmos5l_inv_16_79.A VGND.t1083 VGND.t881 sg13_lv_nmos ad=0.1406p pd=1.12u as=0.1406p ps=1.12u w=0.74u l=0.13u
X3248 VPWR.t1960 osc[6] a_2920_9192# VPWR.t9 sg13_lv_pmos ad=0.2114p pd=1.54u as=0.2856p ps=2.36u w=0.84u l=0.13u
X3249 sg13cmos5l_inv_4_6.Y sg13cmos5l_inv_4_6.A VPWR.t1220 VPWR.t25 sg13_lv_pmos ad=0.2128p pd=1.5u as=0.3808p ps=2.92u w=1.12u l=0.13u
X3250 sg13cmos5l_inv_16_101.Y sg13cmos5l_inv_16_34.Y VGND.t593 VGND.t601 sg13_lv_nmos ad=0.1406p pd=1.12u as=0.1406p ps=1.12u w=0.74u l=0.13u
X3251 VPWR.t224 VGND.t144 VPWR.t223 VPWR.t25 sg13_lv_pmos ad=0.34p pd=2.68u as=0 ps=0 w=1u l=1u
X3252 VPWR.t1976 sg13cmos5l_inv_16_67.A sg13cmos5l_inv_16_65.Y VPWR.t9 sg13_lv_pmos ad=0.4368p pd=3.02u as=0.2128p ps=1.5u w=1.12u l=0.13u
X3253 VPWR.t246 sg13cmos5l_inv_16_6.A sg13cmos5l_inv_16_6.Y VPWR.t177 sg13_lv_pmos ad=0.2128p pd=1.5u as=0.2128p ps=1.5u w=1.12u l=0.13u
X3254 sg13cmos5l_inv_16_29.A sg13cmos5l_inv_16_28.A VGND.t198 VGND.t202 sg13_lv_nmos ad=0.1406p pd=1.12u as=0.1406p ps=1.12u w=0.74u l=0.13u
X3255 sg13cmos5l_inv_16_103.Y sg13cmos5l_inv_16_103.A VGND.t353 VGND.t360 sg13_lv_nmos ad=0.1406p pd=1.12u as=0.1406p ps=1.12u w=0.74u l=0.13u
X3256 sg13cmos5l_inv_8_3.Y sg13cmos5l_inv_4_2.Y VGND.t39 VGND.t1232 sg13_lv_nmos ad=0.1406p pd=1.12u as=0.2516p ps=2.16u w=0.74u l=0.13u
X3257 sg13cmos5l_inv_16_85.Y sg13cmos5l_inv_16_84.A VPWR.t1478 VPWR.t9 sg13_lv_pmos ad=0.2128p pd=1.5u as=0.2128p ps=1.5u w=1.12u l=0.13u
X3258 sg13cmos5l_inv_16_76.A sg13cmos5l_inv_16_94.A VPWR.t1914 VPWR.t16 sg13_lv_pmos ad=0.2128p pd=1.5u as=0.2128p ps=1.5u w=1.12u l=0.13u
X3259 VGND.t3 sg13cmos5l_inv_16_43.Y sg13cmos5l_inv_16_37.A VGND.t170 sg13_lv_nmos ad=0.1406p pd=1.12u as=0.1406p ps=1.12u w=0.74u l=0.13u
X3260 VGND.t705 sg13cmos5l_inv_16_29.A sg13cmos5l_inv_16_29.Y VGND.t710 sg13_lv_nmos ad=0.1406p pd=1.12u as=0.1406p ps=1.12u w=0.74u l=0.13u
X3261 sg13cmos5l_inv_16_37.A sg13cmos5l_inv_16_43.Y VPWR.t598 VPWR.t0 sg13_lv_pmos ad=0.2128p pd=1.5u as=0.2128p ps=1.5u w=1.12u l=0.13u
X3262 sg13cmos5l_inv_16_17.Y sg13cmos5l_inv_16_17.A VPWR.t546 VPWR.t177 sg13_lv_pmos ad=0.2128p pd=1.5u as=0.2128p ps=1.5u w=1.12u l=0.13u
X3263 VGND.t39 sg13cmos5l_inv_16_41.A sg13cmos5l_inv_16_28.A VGND.t246 sg13_lv_nmos ad=0.1406p pd=1.12u as=0.1406p ps=1.12u w=0.74u l=0.13u
X3264 VGND.t994 sg13cmos5l_inv_16_87.A sg13cmos5l_inv_16_93.Y VGND.t1005 sg13_lv_nmos ad=0.1406p pd=1.12u as=0.1406p ps=1.12u w=0.74u l=0.13u
X3265 VPWR.t844 sg13cmos5l_inv_16_27.A sg13cmos5l_inv_16_27.Y VPWR.t177 sg13_lv_pmos ad=0.2128p pd=1.5u as=0.2128p ps=1.5u w=1.12u l=0.13u
X3266 VPWR.t2275 sg13cmos5l_inv_16_46.Y sg13cmos5l_inv_16_50.Y VPWR.t25 sg13_lv_pmos ad=0.2128p pd=1.5u as=0.2128p ps=1.5u w=1.12u l=0.13u
X3267 VGND.t390 sg13cmos5l_inv_16_76.A sg13cmos5l_inv_16_75.A VGND.t380 sg13_lv_nmos ad=0.1406p pd=1.12u as=0.1406p ps=1.12u w=0.74u l=0.13u
X3268 VGND.t122 VPWR.t2512 VGND.t122 VGND.t2040 sg13_lv_nmos ad=79.8f pd=0.8u as=0 ps=0 w=0.42u l=1u
X3269 sg13cmos5l_inv_16_14.Y sg13cmos5l_inv_16_14.A VPWR.t927 VPWR.t4 sg13_lv_pmos ad=0.2128p pd=1.5u as=0.2128p ps=1.5u w=1.12u l=0.13u
X3270 VGND.t593 sg13cmos5l_inv_16_34.Y sg13cmos5l_inv_16_101.Y VGND.t598 sg13_lv_nmos ad=0.1406p pd=1.12u as=0.1406p ps=1.12u w=0.74u l=0.13u
X3271 sg13cmos5l_inv_2_1.Y sg13cmos5l_inv_1_0.Y VPWR.t329 VPWR.t177 sg13_lv_pmos ad=0.2128p pd=1.5u as=0.3808p ps=2.92u w=1.12u l=0.13u
X3272 sg13cmos5l_inv_16_74.Y sg13cmos5l_inv_16_75.A VGND.t381 VGND.t380 sg13_lv_nmos ad=0.1406p pd=1.12u as=0.1406p ps=1.12u w=0.74u l=0.13u
X3273 VPWR.t1100 sg13cmos5l_inv_16_1.A sg13cmos5l_inv_16_17.A VPWR.t177 sg13_lv_pmos ad=0.2128p pd=1.5u as=0.2128p ps=1.5u w=1.12u l=0.13u
X3274 sg13cmos5l_inv_16_43.Y sg13cmos5l_inv_16_27.Y VPWR.t1642 VPWR.t4 sg13_lv_pmos ad=0.2128p pd=1.5u as=0.2128p ps=1.5u w=1.12u l=0.13u
X3275 sg13cmos5l_inv_16_65.Y sg13cmos5l_inv_16_67.A VPWR.t1972 VPWR.t9 sg13_lv_pmos ad=0.2128p pd=1.5u as=0.2128p ps=1.5u w=1.12u l=0.13u
X3276 VPWR.t2100 sg13cmos5l_inv_16_48.A sg13cmos5l_inv_16_46.A VPWR.t25 sg13_lv_pmos ad=0.2128p pd=1.5u as=0.2128p ps=1.5u w=1.12u l=0.13u
X3277 VPWR.t1348 sg13cmos5l_inv_16_96.A sg13cmos5l_inv_16_96.Y VPWR.t25 sg13_lv_pmos ad=0.2128p pd=1.5u as=0.2128p ps=1.5u w=1.12u l=0.13u
X3278 VGND.t414 a_8204_834# sg13cmos5l_buf_1_5.X VGND.t535 sg13_lv_nmos ad=0.14875p pd=1.16u as=0.2886p ps=2.26u w=0.74u l=0.13u
X3279 VGND.t1245 sg13cmos5l_inv_16_27.Y sg13cmos5l_inv_16_43.Y VGND.t1255 sg13_lv_nmos ad=0.1406p pd=1.12u as=0.1406p ps=1.12u w=0.74u l=0.13u
X3280 VPWR.t837 sg13cmos5l_inv_2_7.Y sg13cmos5l_inv_4_5.Y VPWR.t25 sg13_lv_pmos ad=0.2128p pd=1.5u as=0.2128p ps=1.5u w=1.12u l=0.13u
X3281 sg13cmos5l_inv_16_75.Y sg13cmos5l_inv_16_75.A VGND.t122 VGND.t397 sg13_lv_nmos ad=0.1406p pd=1.12u as=0.2516p ps=2.16u w=0.74u l=0.13u
X3282 a_8204_834# en[2] VGND.t414 VGND.t413 sg13_lv_nmos ad=0.187p pd=1.78u as=0.14875p ps=1.16u w=0.55u l=0.13u
X3283 VPWR.t2080 sg13cmos5l_inv_16_48.A sg13cmos5l_inv_16_109.Y VPWR.t16 sg13_lv_pmos ad=0.2128p pd=1.5u as=0.2128p ps=1.5u w=1.12u l=0.13u
X3284 VPWR.t1912 sg13cmos5l_inv_16_94.A sg13cmos5l_inv_16_76.A VPWR.t16 sg13_lv_pmos ad=0.2128p pd=1.5u as=0.2128p ps=1.5u w=1.12u l=0.13u
X3285 sg13cmos5l_inv_16_37.A sg13cmos5l_inv_16_43.Y VGND.t3 VGND.t167 sg13_lv_nmos ad=0.1406p pd=1.12u as=0.1406p ps=1.12u w=0.74u l=0.13u
X3286 VGND.t1164 sg13cmos5l_inv_16_61.A sg13cmos5l_inv_16_61.Y VGND.t881 sg13_lv_nmos ad=0.1406p pd=1.12u as=0.1406p ps=1.12u w=0.74u l=0.13u
X3287 VPWR.t639 VGND.t1083 VPWR.t638 VPWR.t9 sg13_lv_pmos ad=0.34p pd=2.68u as=0 ps=0 w=1u l=1u
X3288 VGND.t1663 sg13cmos5l_inv_16_56.Y sg13cmos5l_inv_16_52.Y VGND.t380 sg13_lv_nmos ad=0.2516p pd=2.16u as=0.1406p ps=1.12u w=0.74u l=0.13u
X3289 VPWR.t544 sg13cmos5l_inv_16_17.A sg13cmos5l_inv_16_17.Y VPWR.t177 sg13_lv_pmos ad=0.2128p pd=1.5u as=0.2128p ps=1.5u w=1.12u l=0.13u
X3290 sg13cmos5l_inv_16_50.Y sg13cmos5l_inv_16_46.Y VPWR.t2271 VPWR.t25 sg13_lv_pmos ad=0.2128p pd=1.5u as=0.2128p ps=1.5u w=1.12u l=0.13u
X3291 sg13cmos5l_inv_8_2.A sg13cmos5l_inv_2_2.Y VPWR.t1773 VPWR.t4 sg13_lv_pmos ad=0.2128p pd=1.5u as=0.3808p ps=2.92u w=1.12u l=0.13u
X3292 VPWR.t671 sg13cmos5l_inv_16_41.A sg13cmos5l_inv_16_28.A VPWR.t4 sg13_lv_pmos ad=0.2128p pd=1.5u as=0.2128p ps=1.5u w=1.12u l=0.13u
X3293 VGND.t146 sg13cmos5l_inv_16_36.A sg13cmos5l_inv_16_36.Y VGND.t155 sg13_lv_nmos ad=0.1406p pd=1.12u as=0.1406p ps=1.12u w=0.74u l=0.13u
X3294 VPWR.t328 VGND.t1507 VPWR.t327 VPWR.t16 sg13_lv_pmos ad=0.34p pd=2.68u as=0 ps=0 w=1u l=1u
X3295 VGND.t427 VPWR.t2568 VGND.t427 VGND.t380 sg13_lv_nmos ad=79.8f pd=0.8u as=0 ps=0 w=0.42u l=1u
X3296 sg13cmos5l_inv_8_0.Y sg13cmos5l_inv_4_0.Y VPWR.t2180 VPWR.t177 sg13_lv_pmos ad=0.2128p pd=1.5u as=0.2128p ps=1.5u w=1.12u l=0.13u
X3297 sg13cmos5l_inv_16_108.Y sg13cmos5l_inv_16_6.Y VPWR.t1001 VPWR.t177 sg13_lv_pmos ad=0.2128p pd=1.5u as=0.2128p ps=1.5u w=1.12u l=0.13u
X3298 sg13cmos5l_inv_16_8.Y sg13cmos5l_inv_16_4.Y VPWR.t733 VPWR.t4 sg13_lv_pmos ad=0.2128p pd=1.5u as=0.2128p ps=1.5u w=1.12u l=0.13u
X3299 VGND.t3 sg13cmos5l_inv_16_37.A sg13cmos5l_inv_16_37.Y VGND.t37 sg13_lv_nmos ad=0.2516p pd=2.16u as=0.1406p ps=1.12u w=0.74u l=0.13u
X3300 VPWR.t1152 sg13cmos5l_inv_16_9.A sg13cmos5l_inv_16_10.Y VPWR.t0 sg13_lv_pmos ad=0.4368p pd=3.02u as=0.2128p ps=1.5u w=1.12u l=0.13u
X3301 VPWR.t248 VGND.t1432 VPWR.t247 VPWR.t4 sg13_lv_pmos ad=0.19p pd=1.38u as=0 ps=0 w=1u l=1u
X3302 sg13cmos5l_inv_4_7.Y sg13cmos5l_inv_2_5.Y VPWR.t1629 VPWR.t9 sg13_lv_pmos ad=0.2128p pd=1.5u as=0.2128p ps=1.5u w=1.12u l=0.13u
X3303 sg13cmos5l_inv_16_26.Y sg13cmos5l_inv_16_26.A VGND.t1334 VGND.t1335 sg13_lv_nmos ad=0.1406p pd=1.12u as=0.1406p ps=1.12u w=0.74u l=0.13u
X3304 sg13cmos5l_inv_16_93.Y sg13cmos5l_inv_16_87.A VPWR.t1406 VPWR.t9 sg13_lv_pmos ad=0.2128p pd=1.5u as=0.2128p ps=1.5u w=1.12u l=0.13u
X3305 VGND.t381 sg13cmos5l_inv_16_75.A sg13cmos5l_inv_16_74.Y VGND.t380 sg13_lv_nmos ad=0.1406p pd=1.12u as=0.1406p ps=1.12u w=0.74u l=0.13u
X3306 sg13cmos5l_inv_16_17.A sg13cmos5l_inv_16_1.A VPWR.t1096 VPWR.t177 sg13_lv_pmos ad=0.2128p pd=1.5u as=0.2128p ps=1.5u w=1.12u l=0.13u
X3307 VGND.t1779 VPWR.t2561 VGND.t1779 VGND.t380 sg13_lv_nmos ad=79.8f pd=0.8u as=0 ps=0 w=0.42u l=1u
X3308 sg13cmos5l_inv_16_46.A sg13cmos5l_inv_16_48.A VPWR.t2096 VPWR.t25 sg13_lv_pmos ad=0.2128p pd=1.5u as=0.2128p ps=1.5u w=1.12u l=0.13u
X3309 sg13cmos5l_inv_16_96.Y sg13cmos5l_inv_16_96.A VPWR.t1344 VPWR.t25 sg13_lv_pmos ad=0.2128p pd=1.5u as=0.2128p ps=1.5u w=1.12u l=0.13u
X3310 sg13cmos5l_inv_16_43.Y sg13cmos5l_inv_16_27.Y VGND.t1245 VGND.t1252 sg13_lv_nmos ad=0.1406p pd=1.12u as=0.1406p ps=1.12u w=0.74u l=0.13u
X3311 VGND.t3 sg13cmos5l_inv_16_43.Y sg13cmos5l_inv_16_37.A VGND.t164 sg13_lv_nmos ad=0.1406p pd=1.12u as=0.1406p ps=1.12u w=0.74u l=0.13u
X3312 VPWR.t13 VGND.t882 VPWR.t12 VPWR.t9 sg13_lv_pmos ad=0.34p pd=2.68u as=0 ps=0 w=1u l=1u
X3313 sg13cmos5l_inv_16_52.Y sg13cmos5l_inv_16_56.Y VGND.t1663 VGND.t380 sg13_lv_nmos ad=0.1406p pd=1.12u as=0.1406p ps=1.12u w=0.74u l=0.13u
X3314 sg13cmos5l_inv_16_22.Y sg13cmos5l_inv_16_20.A VGND.t447 VGND.t448 sg13_lv_nmos ad=0.1406p pd=1.12u as=0.1406p ps=1.12u w=0.74u l=0.13u
X3315 sg13cmos5l_inv_16_17.Y sg13cmos5l_inv_16_17.A VPWR.t540 VPWR.t177 sg13_lv_pmos ad=0.2128p pd=1.5u as=0.2128p ps=1.5u w=1.12u l=0.13u
X3316 VPWR.t333 VGND.t2158 VPWR.t332 VPWR.t177 sg13_lv_pmos ad=0.34p pd=2.68u as=0 ps=0 w=1u l=1u
X3317 VPWR.t767 sg13cmos5l_inv_16_27.Y sg13cmos5l_inv_16_26.A VPWR.t177 sg13_lv_pmos ad=0.2128p pd=1.5u as=0.2128p ps=1.5u w=1.12u l=0.13u
X3318 sg13cmos5l_inv_16_9.Y sg13cmos5l_inv_16_9.A VPWR.t1165 VPWR.t4 sg13_lv_pmos ad=0.2128p pd=1.5u as=0.2128p ps=1.5u w=1.12u l=0.13u
X3319 sg13cmos5l_inv_16_85.Y sg13cmos5l_inv_16_84.A VPWR.t1474 VPWR.t9 sg13_lv_pmos ad=0.2128p pd=1.5u as=0.2128p ps=1.5u w=1.12u l=0.13u
X3320 sg13cmos5l_inv_16_55.Y sg13cmos5l_inv_16_101.Y VPWR.t2342 VPWR.t25 sg13_lv_pmos ad=0.2128p pd=1.5u as=0.2128p ps=1.5u w=1.12u l=0.13u
X3321 VPWR.t2269 sg13cmos5l_inv_16_46.Y sg13cmos5l_inv_16_50.Y VPWR.t25 sg13_lv_pmos ad=0.2128p pd=1.5u as=0.2128p ps=1.5u w=1.12u l=0.13u
X3322 VGND.t414 sg13cmos5l_inv_16_26.A sg13cmos5l_inv_16_26.Y VGND.t1329 sg13_lv_nmos ad=0.1406p pd=1.12u as=0.1406p ps=1.12u w=0.74u l=0.13u
X3323 VGND.t39 sg13cmos5l_inv_2_3.Y sg13cmos5l_inv_4_2.Y VGND.t42 sg13_lv_nmos ad=0.2516p pd=2.16u as=0.1406p ps=1.12u w=0.74u l=0.13u
X3324 sg13cmos5l_inv_16_35.Y sg13cmos5l_inv_16_29.A VGND.t259 VGND.t266 sg13_lv_nmos ad=0.1406p pd=1.12u as=0.1406p ps=1.12u w=0.74u l=0.13u
X3325 VPWR.t1001 sg13cmos5l_inv_16_6.Y sg13cmos5l_inv_16_108.Y VPWR.t177 sg13_lv_pmos ad=0.2128p pd=1.5u as=0.2128p ps=1.5u w=1.12u l=0.13u
X3326 VPWR.t1064 sg13cmos5l_inv_16_5.Y sg13cmos5l_inv_16_110.Y VPWR.t4 sg13_lv_pmos ad=0.2128p pd=1.5u as=0.2128p ps=1.5u w=1.12u l=0.13u
X3327 VGND.t242 sg13cmos5l_inv_16_41.A sg13cmos5l_inv_16_28.A VGND.t241 sg13_lv_nmos ad=0.1406p pd=1.12u as=0.1406p ps=1.12u w=0.74u l=0.13u
X3328 sg13cmos5l_inv_16_37.Y sg13cmos5l_inv_16_37.A VGND.t3 VGND.t34 sg13_lv_nmos ad=0.1406p pd=1.12u as=0.1406p ps=1.12u w=0.74u l=0.13u
X3329 sg13cmos5l_inv_16_68.Y sg13cmos5l_inv_16_68.A VPWR.t1296 VPWR.t16 sg13_lv_pmos ad=0.2128p pd=1.5u as=0.2128p ps=1.5u w=1.12u l=0.13u
X3330 sg13cmos5l_inv_16_11.A sg13cmos5l_inv_16_96.Y VGND.t953 VGND.t380 sg13_lv_nmos ad=0.1406p pd=1.12u as=0.1406p ps=1.12u w=0.74u l=0.13u
X3331 sg13cmos5l_inv_16_75.Y sg13cmos5l_inv_16_75.A VPWR.t822 VPWR.t25 sg13_lv_pmos ad=0.2128p pd=1.5u as=0.2128p ps=1.5u w=1.12u l=0.13u
X3332 VGND.t1100 sg13cmos5l_inv_16_105.A sg13cmos5l_inv_16_105.Y VGND.t1103 sg13_lv_nmos ad=0.1406p pd=1.12u as=0.1406p ps=1.12u w=0.74u l=0.13u
X3333 VPWR.t1001 sg13cmos5l_inv_8_2.A sg13cmos5l_inv_16_27.A VPWR.t177 sg13_lv_pmos ad=0.2128p pd=1.5u as=0.2128p ps=1.5u w=1.12u l=0.13u
X3334 sg13cmos5l_inv_16_54.Y sg13cmos5l_inv_16_101.Y VPWR.t2328 VPWR.t25 sg13_lv_pmos ad=0.2128p pd=1.5u as=0.2128p ps=1.5u w=1.12u l=0.13u
X3335 VPWR.t516 sg13cmos5l_inv_16_23.Y sg13cmos5l_inv_16_14.A VPWR.t0 sg13_lv_pmos ad=0.2128p pd=1.5u as=0.2128p ps=1.5u w=1.12u l=0.13u
X3336 VGND.t146 sg13cmos5l_inv_16_43.Y sg13cmos5l_inv_16_36.A VGND.t192 sg13_lv_nmos ad=0.1406p pd=1.12u as=0.1406p ps=1.12u w=0.74u l=0.13u
X3337 sg13cmos5l_and2_1_3.A a_4744_908# VGND.t534 VGND.t533 sg13_lv_nmos ad=0.2886p pd=2.26u as=0.14875p ps=1.16u w=0.74u l=0.13u
X3338 VPWR.t844 sg13cmos5l_inv_16_6.Y sg13cmos5l_inv_16_25.Y VPWR.t177 sg13_lv_pmos ad=0.2128p pd=1.5u as=0.2128p ps=1.5u w=1.12u l=0.13u
X3339 VGND.t1944 VPWR.t2565 VGND.t1944 VGND.t380 sg13_lv_nmos ad=79.8f pd=0.8u as=0 ps=0 w=0.42u l=1u
X3340 sg13cmos5l_inv_16_104.Y sg13cmos5l_inv_16_14.A VGND.t472 VGND.t481 sg13_lv_nmos ad=0.1406p pd=1.12u as=0.1406p ps=1.12u w=0.74u l=0.13u
X3341 VGND.t291 sg13cmos5l_inv_16_8.Y sg13cmos5l_inv_16_9.A VGND.t565 sg13_lv_nmos ad=0.1406p pd=1.12u as=0.1406p ps=1.12u w=0.74u l=0.13u
X3342 VGND.t916 osc[6] a_2920_9192# VGND.t1796 sg13_lv_nmos ad=0.14875p pd=1.16u as=0.187p ps=1.78u w=0.55u l=0.13u
X3343 sg13cmos5l_inv_16_53.Y sg13cmos5l_inv_16_53.A VPWR.t2068 VPWR.t16 sg13_lv_pmos ad=0.2128p pd=1.5u as=0.2128p ps=1.5u w=1.12u l=0.13u
X3344 sg13cmos5l_buf_1_15.X a_2920_4656# VPWR.t1 VPWR.t0 sg13_lv_pmos ad=0.42p pd=2.99u as=0.2114p ps=1.54u w=1.12u l=0.13u
X3345 sg13cmos5l_inv_16_44.Y sg13cmos5l_inv_16_44.A VGND.t198 VGND.t197 sg13_lv_nmos ad=0.1406p pd=1.12u as=0.2516p ps=2.16u w=0.74u l=0.13u
X3346 VPWR.t120 VGND.t1100 VPWR.t119 VPWR.t0 sg13_lv_pmos ad=0.34p pd=2.68u as=0 ps=0 w=1u l=1u
X3347 VGND.t375 sg13cmos5l_inv_16_20.A sg13cmos5l_inv_16_22.Y VGND.t444 sg13_lv_nmos ad=0.1406p pd=1.12u as=0.1406p ps=1.12u w=0.74u l=0.13u
X3348 VPWR.t707 sg13cmos5l_inv_16_29.A sg13cmos5l_inv_16_29.Y VPWR.t177 sg13_lv_pmos ad=0.2128p pd=1.5u as=0.2128p ps=1.5u w=1.12u l=0.13u
X3349 sg13cmos5l_inv_16_26.A sg13cmos5l_inv_16_27.Y VPWR.t767 VPWR.t177 sg13_lv_pmos ad=0.2128p pd=1.5u as=0.2128p ps=1.5u w=1.12u l=0.13u
X3350 VPWR.t1163 sg13cmos5l_inv_16_9.A sg13cmos5l_inv_16_9.Y VPWR.t4 sg13_lv_pmos ad=0.2128p pd=1.5u as=0.2128p ps=1.5u w=1.12u l=0.13u
X3351 VGND.t196 VPWR.t2502 VGND.t196 VGND.t2057 sg13_lv_nmos ad=0.1428p pd=1.52u as=0 ps=0 w=0.42u l=1u
X3352 sg13cmos5l_inv_16_28.A sg13cmos5l_inv_16_41.A VGND.t215 VGND.t238 sg13_lv_nmos ad=0.1406p pd=1.12u as=0.1406p ps=1.12u w=0.74u l=0.13u
X3353 VGND.t1010 sg13cmos5l_inv_16_73.Y sg13cmos5l_inv_16_95.Y VGND.t881 sg13_lv_nmos ad=0.1406p pd=1.12u as=0.1406p ps=1.12u w=0.74u l=0.13u
X3354 VGND.t259 sg13cmos5l_inv_16_29.A sg13cmos5l_inv_16_35.Y VGND.t263 sg13_lv_nmos ad=0.1406p pd=1.12u as=0.1406p ps=1.12u w=0.74u l=0.13u
X3355 VGND.t637 sg13cmos5l_inv_16_5.Y sg13cmos5l_inv_16_110.Y VGND.t651 sg13_lv_nmos ad=0.2516p pd=2.16u as=0.1406p ps=1.12u w=0.74u l=0.13u
X3356 VGND.t45 sg13cmos5l_inv_16_23.Y sg13cmos5l_inv_16_15.A VGND.t60 sg13_lv_nmos ad=0.1406p pd=1.12u as=0.1406p ps=1.12u w=0.74u l=0.13u
X3357 sg13cmos5l_and2_1_1.B a_2920_7680# VGND.t1241 VGND.t881 sg13_lv_nmos ad=0.2886p pd=2.26u as=0.14875p ps=1.16u w=0.74u l=0.13u
X3358 VPWR.t2326 sg13cmos5l_inv_16_101.Y sg13cmos5l_inv_16_54.Y VPWR.t25 sg13_lv_pmos ad=0.2128p pd=1.5u as=0.2128p ps=1.5u w=1.12u l=0.13u
X3359 VGND.t953 sg13cmos5l_inv_16_96.Y sg13cmos5l_inv_16_11.A VGND.t380 sg13_lv_nmos ad=0.1406p pd=1.12u as=0.1406p ps=1.12u w=0.74u l=0.13u
X3360 VPWR.t820 sg13cmos5l_inv_16_75.A sg13cmos5l_inv_16_75.Y VPWR.t25 sg13_lv_pmos ad=0.2128p pd=1.5u as=0.2128p ps=1.5u w=1.12u l=0.13u
X3361 sg13cmos5l_inv_16_105.Y sg13cmos5l_inv_16_105.A VGND.t1100 VGND.t1099 sg13_lv_nmos ad=0.1406p pd=1.12u as=0.2516p ps=2.16u w=0.74u l=0.13u
X3362 VGND.t2149 VPWR.t329 VGND.t2151 VGND.t2150 sg13_lv_nmos ad=79.8f pd=0.8u as=0 ps=0 w=0.42u l=1u
X3363 VGND.t2111 VPWR.t2473 VGND.t86 VGND.t2112 sg13_lv_nmos ad=79.8f pd=0.8u as=0 ps=0 w=0.42u l=1u
X3364 VPWR.t2303 sg13cmos5l_inv_16_47.A sg13cmos5l_inv_16_45.Y VPWR.t16 sg13_lv_pmos ad=0.4368p pd=3.02u as=0.2128p ps=1.5u w=1.12u l=0.13u
X3365 sg13cmos5l_inv_16_14.A sg13cmos5l_inv_16_23.Y VPWR.t512 VPWR.t0 sg13_lv_pmos ad=0.2128p pd=1.5u as=0.2128p ps=1.5u w=1.12u l=0.13u
X3366 sg13cmos5l_inv_16_25.Y sg13cmos5l_inv_16_6.Y VPWR.t844 VPWR.t177 sg13_lv_pmos ad=0.2128p pd=1.5u as=0.2128p ps=1.5u w=1.12u l=0.13u
X3367 VPWR.t961 sg13cmos5l_inv_16_15.A sg13cmos5l_inv_16_15.Y VPWR.t4 sg13_lv_pmos ad=0.4368p pd=3.02u as=0.2128p ps=1.5u w=1.12u l=0.13u
X3368 sg13cmos5l_inv_16_58.Y sg13cmos5l_inv_16_69.Y VPWR.t1324 VPWR.t9 sg13_lv_pmos ad=0.2128p pd=1.5u as=0.2128p ps=1.5u w=1.12u l=0.13u
X3369 sg13cmos5l_inv_16_61.Y sg13cmos5l_inv_16_61.A VPWR.t1594 VPWR.t9 sg13_lv_pmos ad=0.2128p pd=1.5u as=0.2128p ps=1.5u w=1.12u l=0.13u
X3370 VGND.t1944 VPWR.t2552 VGND.t1944 VGND.t380 sg13_lv_nmos ad=0.1428p pd=1.52u as=0 ps=0 w=0.42u l=1u
X3371 VGND.t1580 sg13cmos5l_inv_16_67.A sg13cmos5l_inv_16_65.Y VGND.t1581 sg13_lv_nmos ad=0.1406p pd=1.12u as=0.1406p ps=1.12u w=0.74u l=0.13u
X3372 sg13cmos5l_inv_16_79.Y sg13cmos5l_inv_16_79.A VPWR.t2172 VPWR.t16 sg13_lv_pmos ad=0.2128p pd=1.5u as=0.2128p ps=1.5u w=1.12u l=0.13u
X3373 VGND.t472 sg13cmos5l_inv_16_14.A sg13cmos5l_inv_16_104.Y VGND.t478 sg13_lv_nmos ad=0.1406p pd=1.12u as=0.1406p ps=1.12u w=0.74u l=0.13u
X3374 sg13cmos5l_inv_16_9.A sg13cmos5l_inv_16_8.Y VGND.t291 VGND.t562 sg13_lv_nmos ad=0.1406p pd=1.12u as=0.1406p ps=1.12u w=0.74u l=0.13u
X3375 VPWR.t1758 sg13cmos5l_inv_16_52.Y sg13cmos5l_inv_16_53.A VPWR.t16 sg13_lv_pmos ad=0.2128p pd=1.5u as=0.2128p ps=1.5u w=1.12u l=0.13u
X3376 VPWR.t45 VGND.t1820 VPWR.t43 VPWR.t9 sg13_lv_pmos ad=0.19p pd=1.38u as=0 ps=0 w=1u l=1u
X3377 sg13cmos5l_inv_16_91.Y sg13cmos5l_inv_16_79.A VPWR.t2152 VPWR.t16 sg13_lv_pmos ad=0.2128p pd=1.5u as=0.2128p ps=1.5u w=1.12u l=0.13u
X3378 VGND.t390 sg13cmos5l_inv_16_76.A sg13cmos5l_inv_16_75.A VGND.t380 sg13_lv_nmos ad=0.1406p pd=1.12u as=0.1406p ps=1.12u w=0.74u l=0.13u
X3379 VPWR.t2125 sg13cmos5l_inv_16_46.A sg13cmos5l_inv_16_47.A VPWR.t16 sg13_lv_pmos ad=0.2128p pd=1.5u as=0.2128p ps=1.5u w=1.12u l=0.13u
X3380 sg13cmos5l_inv_16_34.Y sg13cmos5l_inv_16_41.A VPWR.t664 VPWR.t0 sg13_lv_pmos ad=0.2128p pd=1.5u as=0.2128p ps=1.5u w=1.12u l=0.13u
X3381 sg13cmos5l_inv_16_15.A sg13cmos5l_inv_16_23.Y VGND.t45 VGND.t57 sg13_lv_nmos ad=0.1406p pd=1.12u as=0.1406p ps=1.12u w=0.74u l=0.13u
X3382 sg13cmos5l_inv_16_95.Y sg13cmos5l_inv_16_73.Y VGND.t1010 VGND.t881 sg13_lv_nmos ad=0.1406p pd=1.12u as=0.2516p ps=2.16u w=0.74u l=0.13u
X3383 VGND.t291 sg13cmos5l_inv_16_4.Y sg13cmos5l_inv_16_8.Y VGND.t292 sg13_lv_nmos ad=0.1406p pd=1.12u as=0.1406p ps=1.12u w=0.74u l=0.13u
X3384 sg13cmos5l_inv_16_11.A sg13cmos5l_inv_16_96.Y VGND.t1792 VGND.t380 sg13_lv_nmos ad=0.1406p pd=1.12u as=0.1406p ps=1.12u w=0.74u l=0.13u
X3385 VGND.t353 sg13cmos5l_inv_16_8.Y sg13cmos5l_inv_16_20.A VGND.t542 sg13_lv_nmos ad=0.1406p pd=1.12u as=0.1406p ps=1.12u w=0.74u l=0.13u
X3386 sg13cmos5l_inv_16_17.A sg13cmos5l_inv_16_1.A VGND.t675 VGND.t684 sg13_lv_nmos ad=0.1406p pd=1.12u as=0.1406p ps=1.12u w=0.74u l=0.13u
X3387 sg13cmos5l_inv_16_29.A sg13cmos5l_inv_16_28.A VPWR.t707 VPWR.t177 sg13_lv_pmos ad=0.2128p pd=1.5u as=0.2128p ps=1.5u w=1.12u l=0.13u
X3388 VGND.t1680 sg13cmos5l_inv_16_53.A sg13cmos5l_inv_16_53.Y VGND.t380 sg13_lv_nmos ad=0.2516p pd=2.16u as=0.1406p ps=1.12u w=0.74u l=0.13u
X3389 VGND.t593 sg13cmos5l_inv_16_34.Y sg13cmos5l_inv_16_101.Y VGND.t594 sg13_lv_nmos ad=0.1406p pd=1.12u as=0.1406p ps=1.12u w=0.74u l=0.13u
X3390 sg13cmos5l_inv_16_68.Y sg13cmos5l_inv_16_68.A VPWR.t1292 VPWR.t16 sg13_lv_pmos ad=0.2128p pd=1.5u as=0.2128p ps=1.5u w=1.12u l=0.13u
X3391 VPWR.t1322 sg13cmos5l_inv_16_69.Y sg13cmos5l_inv_16_58.Y VPWR.t9 sg13_lv_pmos ad=0.2128p pd=1.5u as=0.2128p ps=1.5u w=1.12u l=0.13u
X3392 VGND.t450 sg13cmos5l_inv_16_15.A sg13cmos5l_inv_16_13.Y VGND.t502 sg13_lv_nmos ad=0.1406p pd=1.12u as=0.1406p ps=1.12u w=0.74u l=0.13u
X3393 sg13cmos5l_inv_16_66.Y sg13cmos5l_inv_16_68.A VGND.t866 VGND.t869 sg13_lv_nmos ad=0.1406p pd=1.12u as=0.1406p ps=1.12u w=0.74u l=0.13u
X3394 VGND.t635 VPWR.t233 VGND.t635 VGND.t2127 sg13_lv_nmos ad=79.8f pd=0.8u as=0 ps=0 w=0.42u l=1u
X3395 VGND.t1147 sg13cmos5l_inv_16_48.A sg13cmos5l_inv_16_109.Y VGND.t881 sg13_lv_nmos ad=0.1406p pd=1.12u as=0.1406p ps=1.12u w=0.74u l=0.13u
X3396 VGND.t898 sg13cmos5l_inv_16_94.A sg13cmos5l_inv_16_76.A VGND.t881 sg13_lv_nmos ad=0.2516p pd=2.16u as=0.1406p ps=1.12u w=0.74u l=0.13u
X3397 VGND.t1507 sg13cmos5l_inv_16_94.A sg13cmos5l_inv_16_73.A VGND.t881 sg13_lv_nmos ad=0.1406p pd=1.12u as=0.1406p ps=1.12u w=0.74u l=0.13u
X3398 VPWR.t2150 sg13cmos5l_inv_16_79.A sg13cmos5l_inv_16_91.Y VPWR.t16 sg13_lv_pmos ad=0.2128p pd=1.5u as=0.2128p ps=1.5u w=1.12u l=0.13u
X3399 VGND.t146 sg13cmos5l_inv_16_36.A sg13cmos5l_inv_16_36.Y VGND.t151 sg13_lv_nmos ad=0.1406p pd=1.12u as=0.1406p ps=1.12u w=0.74u l=0.13u
X3400 sg13cmos5l_inv_16_59.Y sg13cmos5l_inv_16_61.A VPWR.t1581 VPWR.t9 sg13_lv_pmos ad=0.2128p pd=1.5u as=0.2128p ps=1.5u w=1.12u l=0.13u
X3401 VGND.t20 sg13cmos5l_inv_16_46.A sg13cmos5l_inv_16_46.Y VGND.t1748 sg13_lv_nmos ad=0.1406p pd=1.12u as=0.1406p ps=1.12u w=0.74u l=0.13u
X3402 VPWR.t662 sg13cmos5l_inv_16_41.A sg13cmos5l_inv_16_34.Y VPWR.t0 sg13_lv_pmos ad=0.2128p pd=1.5u as=0.2128p ps=1.5u w=1.12u l=0.13u
X3403 sg13cmos5l_inv_8_0.Y sg13cmos5l_inv_4_0.Y VPWR.t2177 VPWR.t177 sg13_lv_pmos ad=0.2128p pd=1.5u as=0.3808p ps=2.92u w=1.12u l=0.13u
X3404 VPWR.t921 sg13cmos5l_inv_16_14.A sg13cmos5l_inv_16_14.Y VPWR.t4 sg13_lv_pmos ad=0.2128p pd=1.5u as=0.2128p ps=1.5u w=1.12u l=0.13u
X3405 sg13cmos5l_inv_16_52.Y sg13cmos5l_inv_16_56.Y VPWR.t2043 VPWR.t16 sg13_lv_pmos ad=0.2128p pd=1.5u as=0.3808p ps=2.92u w=1.12u l=0.13u
X3406 VGND.t1083 sg13cmos5l_inv_16_109.Y sg13cmos5l_inv_16_111.A VGND.t881 sg13_lv_nmos ad=0.2516p pd=2.16u as=0.1406p ps=1.12u w=0.74u l=0.13u
X3407 VPWR.t265 VGND.t1553 VPWR.t263 VPWR.t9 sg13_lv_pmos ad=0.19p pd=1.38u as=0 ps=0 w=1u l=1u
X3408 VPWR.t1953 sg13cmos5l_inv_16_111.A sg13cmos5l_inv_16_111.Y VPWR.t16 sg13_lv_pmos ad=0.2128p pd=1.5u as=0.2128p ps=1.5u w=1.12u l=0.13u
X3409 sg13cmos5l_inv_16_75.A sg13cmos5l_inv_16_76.A VPWR.t2390 VPWR.t25 sg13_lv_pmos ad=0.2128p pd=1.5u as=0.2128p ps=1.5u w=1.12u l=0.13u
X3410 VPWR.t800 sg13cmos5l_inv_16_11.A sg13cmos5l_inv_16_103.A VPWR.t0 sg13_lv_pmos ad=0.2128p pd=1.5u as=0.2128p ps=1.5u w=1.12u l=0.13u
X3411 sg13cmos5l_inv_16_17.A sg13cmos5l_inv_16_1.A VPWR.t1092 VPWR.t177 sg13_lv_pmos ad=0.2128p pd=1.5u as=0.2128p ps=1.5u w=1.12u l=0.13u
X3412 VPWR.t1619 sg13cmos5l_inv_4_7.Y sg13cmos5l_inv_16_88.A VPWR.t9 sg13_lv_pmos ad=0.2128p pd=1.5u as=0.2128p ps=1.5u w=1.12u l=0.13u
X3413 sg13cmos5l_inv_16_26.Y sg13cmos5l_inv_16_26.A VGND.t414 VGND.t1330 sg13_lv_nmos ad=0.1406p pd=1.12u as=0.1406p ps=1.12u w=0.74u l=0.13u
X3414 VPWR.t131 VGND.t1899 VPWR.t130 VPWR.t9 sg13_lv_pmos ad=0.34p pd=2.68u as=0 ps=0 w=1u l=1u
X3415 VGND.t1820 VPWR.t2573 VGND.t1820 VGND.t881 sg13_lv_nmos ad=79.8f pd=0.8u as=0 ps=0 w=0.42u l=1u
X3416 VGND.t345 sg13cmos5l_inv_16_105.A sg13cmos5l_inv_16_80.Y VGND.t1107 sg13_lv_nmos ad=0.1406p pd=1.12u as=0.1406p ps=1.12u w=0.74u l=0.13u
X3417 VPWR.t174 VGND.t20 VPWR.t172 VPWR.t0 sg13_lv_pmos ad=0.19p pd=1.38u as=0 ps=0 w=1u l=1u
X3418 sg13cmos5l_inv_16_41.A sg13cmos5l_inv_8_3.Y VGND.t226 VGND.t824 sg13_lv_nmos ad=0.1406p pd=1.12u as=0.1406p ps=1.12u w=0.74u l=0.13u
X3419 VGND.t1469 sg13cmos5l_inv_16_73.A sg13cmos5l_inv_16_87.A VGND.t1484 sg13_lv_nmos ad=0.2516p pd=2.16u as=0.1406p ps=1.12u w=0.74u l=0.13u
X3420 sg13cmos5l_inv_16_36.Y sg13cmos5l_inv_16_36.A VGND.t146 VGND.t148 sg13_lv_nmos ad=0.1406p pd=1.12u as=0.1406p ps=1.12u w=0.74u l=0.13u
X3421 VPWR.t1579 sg13cmos5l_inv_16_61.A sg13cmos5l_inv_16_59.Y VPWR.t9 sg13_lv_pmos ad=0.2128p pd=1.5u as=0.2128p ps=1.5u w=1.12u l=0.13u
X3422 VPWR.t1416 sg13cmos5l_inv_16_87.A sg13cmos5l_inv_16_87.Y VPWR.t9 sg13_lv_pmos ad=0.2128p pd=1.5u as=0.2128p ps=1.5u w=1.12u l=0.13u
X3423 VGND.t5 sg13cmos5l_inv_16_37.A sg13cmos5l_inv_16_102.Y VGND.t12 sg13_lv_nmos ad=0.1406p pd=1.12u as=0.1406p ps=1.12u w=0.74u l=0.13u
X3424 sg13cmos5l_inv_16_34.Y sg13cmos5l_inv_16_41.A VPWR.t658 VPWR.t0 sg13_lv_pmos ad=0.2128p pd=1.5u as=0.2128p ps=1.5u w=1.12u l=0.13u
X3425 sg13cmos5l_inv_16_10.Y sg13cmos5l_inv_16_9.A VPWR.t1143 VPWR.t0 sg13_lv_pmos ad=0.2128p pd=1.5u as=0.2128p ps=1.5u w=1.12u l=0.13u
X3426 sg13cmos5l_inv_16_5.Y sg13cmos5l_inv_16_6.A VPWR.t246 VPWR.t177 sg13_lv_pmos ad=0.2128p pd=1.5u as=0.3808p ps=2.92u w=1.12u l=0.13u
X3427 sg13cmos5l_inv_16_19.Y sg13cmos5l_inv_16_17.A VPWR.t522 VPWR.t177 sg13_lv_pmos ad=0.2128p pd=1.5u as=0.3808p ps=2.92u w=1.12u l=0.13u
X3428 VGND.t144 VPWR.t2534 VGND.t144 VGND.t2003 sg13_lv_nmos ad=0.1428p pd=1.52u as=0 ps=0 w=0.42u l=1u
X3429 VPWR.t66 VGND.t864 VPWR.t65 VPWR.t9 sg13_lv_pmos ad=0.19p pd=1.38u as=0 ps=0 w=1u l=1u
X3430 VPWR.t1400 sg13cmos5l_inv_16_87.A sg13cmos5l_inv_16_93.Y VPWR.t9 sg13_lv_pmos ad=0.2128p pd=1.5u as=0.2128p ps=1.5u w=1.12u l=0.13u
X3431 VGND.t1715 sg13cmos5l_inv_16_46.Y sg13cmos5l_inv_16_50.Y VGND.t380 sg13_lv_nmos ad=0.2516p pd=2.16u as=0.1406p ps=1.12u w=0.74u l=0.13u
X3432 VGND.t1132 sg13cmos5l_inv_16_109.Y sg13cmos5l_inv_16_67.A VGND.t881 sg13_lv_nmos ad=0.1406p pd=1.12u as=0.1406p ps=1.12u w=0.74u l=0.13u
X3433 VPWR.t2388 sg13cmos5l_inv_16_76.A sg13cmos5l_inv_16_75.A VPWR.t25 sg13_lv_pmos ad=0.2128p pd=1.5u as=0.2128p ps=1.5u w=1.12u l=0.13u
X3434 VPWR.t249 VGND.t196 VPWR.t257 VPWR.t0 sg13_lv_pmos ad=0.34p pd=2.68u as=0 ps=0 w=1u l=1u
X3435 sg13cmos5l_inv_16_84.Y sg13cmos5l_inv_16_84.A VGND.t1083 VGND.t881 sg13_lv_nmos ad=0.1406p pd=1.12u as=0.2516p ps=2.16u w=0.74u l=0.13u
X3436 sg13cmos5l_inv_16_44.A sg13cmos5l_inv_16_28.A VGND.t259 VGND.t266 sg13_lv_nmos ad=0.1406p pd=1.12u as=0.1406p ps=1.12u w=0.74u l=0.13u
X3437 sg13cmos5l_inv_16_99.A sg13cmos5l_inv_16_34.Y VGND.t593 VGND.t601 sg13_lv_nmos ad=0.1406p pd=1.12u as=0.1406p ps=1.12u w=0.74u l=0.13u
X3438 VPWR.t1822 sg13cmos5l_inv_16_2.A sg13cmos5l_inv_16_2.Y VPWR.t177 sg13_lv_pmos ad=0.2128p pd=1.5u as=0.2128p ps=1.5u w=1.12u l=0.13u
X3439 sg13cmos5l_inv_16_26.A sg13cmos5l_inv_16_27.Y VPWR.t767 VPWR.t177 sg13_lv_pmos ad=0.2128p pd=1.5u as=0.2128p ps=1.5u w=1.12u l=0.13u
X3440 sg13cmos5l_inv_16_66.Y sg13cmos5l_inv_16_68.A VGND.t864 VGND.t863 sg13_lv_nmos ad=0.1406p pd=1.12u as=0.2516p ps=2.16u w=0.74u l=0.13u
X3441 VGND.t450 sg13cmos5l_inv_16_20.A sg13cmos5l_inv_16_20.Y VGND.t467 sg13_lv_nmos ad=0.2516p pd=2.16u as=0.1406p ps=1.12u w=0.74u l=0.13u
X3442 VPWR.t1159 sg13cmos5l_inv_16_9.A sg13cmos5l_inv_16_9.Y VPWR.t4 sg13_lv_pmos ad=0.2128p pd=1.5u as=0.2128p ps=1.5u w=1.12u l=0.13u
X3443 VPWR.t47 VGND.t1820 VPWR.t46 VPWR.t16 sg13_lv_pmos ad=0.34p pd=2.68u as=0 ps=0 w=1u l=1u
X3444 sg13cmos5l_inv_16_105.A sg13cmos5l_inv_16_11.A VGND.t353 VGND.t360 sg13_lv_nmos ad=0.1406p pd=1.12u as=0.1406p ps=1.12u w=0.74u l=0.13u
X3445 VPWR.t1528 sg13cmos5l_inv_16_105.A sg13cmos5l_inv_16_105.Y VPWR.t0 sg13_lv_pmos ad=0.2128p pd=1.5u as=0.2128p ps=1.5u w=1.12u l=0.13u
X3446 sg13cmos5l_inv_16_110.Y sg13cmos5l_inv_16_5.Y VPWR.t1056 VPWR.t4 sg13_lv_pmos ad=0.2128p pd=1.5u as=0.2128p ps=1.5u w=1.12u l=0.13u
X3447 VGND.t882 sg13cmos5l_inv_16_71.Y sg13cmos5l_inv_16_68.A VGND.t881 sg13_lv_nmos ad=0.1406p pd=1.12u as=0.1406p ps=1.12u w=0.74u l=0.13u
X3448 VGND.t637 sg13cmos5l_inv_16_5.Y sg13cmos5l_inv_16_110.Y VGND.t647 sg13_lv_nmos ad=0.1406p pd=1.12u as=0.1406p ps=1.12u w=0.74u l=0.13u
X3449 VGND.t882 sg13cmos5l_inv_16_68.A sg13cmos5l_inv_16_68.Y VGND.t881 sg13_lv_nmos ad=0.1406p pd=1.12u as=0.1406p ps=1.12u w=0.74u l=0.13u
X3450 VPWR.t1236 sg13cmos5l_inv_8_3.Y sg13cmos5l_inv_16_41.A VPWR.t4 sg13_lv_pmos ad=0.2128p pd=1.5u as=0.2128p ps=1.5u w=1.12u l=0.13u
X3451 VPWR.t2299 sg13cmos5l_inv_16_47.A sg13cmos5l_inv_16_45.Y VPWR.t16 sg13_lv_pmos ad=0.2128p pd=1.5u as=0.2128p ps=1.5u w=1.12u l=0.13u
X3452 sg13cmos5l_buf_1_8.X a_2920_908# VPWR.t687 VPWR.t177 sg13_lv_pmos ad=0.42p pd=2.99u as=0.2114p ps=1.54u w=1.12u l=0.13u
X3453 sg13cmos5l_inv_16_29.A sg13cmos5l_inv_16_28.A VGND.t198 VGND.t197 sg13_lv_nmos ad=0.1406p pd=1.12u as=0.2516p ps=2.16u w=0.74u l=0.13u
X3454 VPWR.t629 sg13cmos5l_inv_16_44.A sg13cmos5l_inv_16_44.Y VPWR.t4 sg13_lv_pmos ad=0.2128p pd=1.5u as=0.2128p ps=1.5u w=1.12u l=0.13u
X3455 sg13cmos5l_inv_16_87.A sg13cmos5l_inv_16_73.A VPWR.t1865 VPWR.t9 sg13_lv_pmos ad=0.2128p pd=1.5u as=0.2128p ps=1.5u w=1.12u l=0.13u
X3456 sg13cmos5l_inv_16_67.A sg13cmos5l_inv_16_109.Y VGND.t1132 VGND.t881 sg13_lv_nmos ad=0.1406p pd=1.12u as=0.1406p ps=1.12u w=0.74u l=0.13u
X3457 sg13cmos5l_inv_16_73.A sg13cmos5l_inv_16_94.A VPWR.t1892 VPWR.t9 sg13_lv_pmos ad=0.2128p pd=1.5u as=0.2128p ps=1.5u w=1.12u l=0.13u
X3458 sg13cmos5l_inv_16_9.A sg13cmos5l_inv_16_8.Y VGND.t291 VGND.t558 sg13_lv_nmos ad=0.1406p pd=1.12u as=0.2516p ps=2.16u w=0.74u l=0.13u
X3459 VPWR.t1085 sg13cmos5l_inv_16_1.A sg13cmos5l_inv_16_2.A VPWR.t4 sg13_lv_pmos ad=0.2128p pd=1.5u as=0.2128p ps=1.5u w=1.12u l=0.13u
X3460 VPWR.t469 sg13cmos5l_inv_16_37.A sg13cmos5l_inv_16_37.Y VPWR.t4 sg13_lv_pmos ad=0.2128p pd=1.5u as=0.2128p ps=1.5u w=1.12u l=0.13u
X3461 VPWR.t2062 sg13cmos5l_inv_16_53.A sg13cmos5l_inv_16_53.Y VPWR.t16 sg13_lv_pmos ad=0.2128p pd=1.5u as=0.2128p ps=1.5u w=1.12u l=0.13u
X3462 VGND.t963 sg13cmos5l_inv_16_71.Y sg13cmos5l_inv_16_61.A VGND.t881 sg13_lv_nmos ad=0.1406p pd=1.12u as=0.1406p ps=1.12u w=0.74u l=0.13u
X3463 sg13cmos5l_inv_16_2.Y sg13cmos5l_inv_16_2.A VPWR.t1819 VPWR.t177 sg13_lv_pmos ad=0.2128p pd=1.5u as=0.3808p ps=2.92u w=1.12u l=0.13u
X3464 VGND.t259 sg13cmos5l_inv_16_28.A sg13cmos5l_inv_16_44.A VGND.t263 sg13_lv_nmos ad=0.1406p pd=1.12u as=0.1406p ps=1.12u w=0.74u l=0.13u
X3465 VGND.t593 sg13cmos5l_inv_16_34.Y sg13cmos5l_inv_16_99.A VGND.t598 sg13_lv_nmos ad=0.1406p pd=1.12u as=0.1406p ps=1.12u w=0.74u l=0.13u
X3466 sg13cmos5l_inv_16_67.Y sg13cmos5l_inv_16_67.A VGND.t1132 VGND.t881 sg13_lv_nmos ad=0.1406p pd=1.12u as=0.1406p ps=1.12u w=0.74u l=0.13u
X3467 VPWR.t2121 sg13cmos5l_inv_16_46.A sg13cmos5l_inv_16_47.A VPWR.t16 sg13_lv_pmos ad=0.2128p pd=1.5u as=0.2128p ps=1.5u w=1.12u l=0.13u
X3468 VGND.t723 VPWR.t2489 VGND.t723 VGND.t2080 sg13_lv_nmos ad=0.1428p pd=1.52u as=0 ps=0 w=0.42u l=1u
X3469 sg13cmos5l_inv_16_105.Y sg13cmos5l_inv_16_105.A VPWR.t1524 VPWR.t0 sg13_lv_pmos ad=0.2128p pd=1.5u as=0.2128p ps=1.5u w=1.12u l=0.13u
X3470 sg13cmos5l_inv_16_68.A sg13cmos5l_inv_16_71.Y VGND.t882 VGND.t881 sg13_lv_nmos ad=0.1406p pd=1.12u as=0.1406p ps=1.12u w=0.74u l=0.13u
X3471 VGND.t1541 sg13cmos5l_inv_16_111.A sg13cmos5l_inv_16_98.Y VGND.t1548 sg13_lv_nmos ad=0.1406p pd=1.12u as=0.1406p ps=1.12u w=0.74u l=0.13u
X3472 VGND.t5 sg13cmos5l_inv_16_37.A sg13cmos5l_inv_16_102.Y VGND.t8 sg13_lv_nmos ad=0.1406p pd=1.12u as=0.1406p ps=1.12u w=0.74u l=0.13u
X3473 sg13cmos5l_inv_16_62.Y sg13cmos5l_inv_16_69.Y VGND.t922 VGND.t881 sg13_lv_nmos ad=0.1406p pd=1.12u as=0.1406p ps=1.12u w=0.74u l=0.13u
X3474 sg13cmos5l_inv_16_45.Y sg13cmos5l_inv_16_47.A VPWR.t2295 VPWR.t16 sg13_lv_pmos ad=0.2128p pd=1.5u as=0.2128p ps=1.5u w=1.12u l=0.13u
X3475 sg13cmos5l_inv_16_20.Y sg13cmos5l_inv_16_20.A VPWR.t893 VPWR.t4 sg13_lv_pmos ad=0.2128p pd=1.5u as=0.2128p ps=1.5u w=1.12u l=0.13u
X3476 sg13cmos5l_inv_1_3.Y sg13cmos5l_and2_1_4.X VPWR.t1135 VPWR.t0 sg13_lv_pmos ad=0.3808p pd=2.92u as=0.3808p ps=2.92u w=1.12u l=0.13u
X3477 sg13cmos5l_inv_16_40.Y sg13cmos5l_inv_16_26.Y VGND.t326 VGND.t332 sg13_lv_nmos ad=0.1406p pd=1.12u as=0.1406p ps=1.12u w=0.74u l=0.13u
X3478 sg13cmos5l_inv_16_44.Y sg13cmos5l_inv_16_44.A VPWR.t625 VPWR.t4 sg13_lv_pmos ad=0.2128p pd=1.5u as=0.2128p ps=1.5u w=1.12u l=0.13u
X3479 VPWR.t439 VGND.t86 VPWR.t413 VPWR.t4 sg13_lv_pmos ad=0.19p pd=1.38u as=0 ps=0 w=1u l=1u
X3480 VGND.t198 sg13cmos5l_inv_16_44.A sg13cmos5l_inv_16_44.Y VGND.t211 sg13_lv_nmos ad=0.1406p pd=1.12u as=0.1406p ps=1.12u w=0.74u l=0.13u
X3481 VGND.t1132 VPWR.t2589 VGND.t1132 VGND.t881 sg13_lv_nmos ad=0.1428p pd=1.52u as=0 ps=0 w=0.42u l=1u
X3482 VGND.t1663 VPWR.t2553 VGND.t1663 VGND.t380 sg13_lv_nmos ad=0.1428p pd=1.52u as=0 ps=0 w=0.42u l=1u
X3483 sg13cmos5l_inv_16_96.Y sg13cmos5l_inv_16_96.A VGND.t545 VGND.t951 sg13_lv_nmos ad=0.1406p pd=1.12u as=0.1406p ps=1.12u w=0.74u l=0.13u
X3484 sg13cmos5l_and2_1_4.X a_6957_3492# VGND.t3 VGND.t1226 sg13_lv_nmos ad=0.2516p pd=2.16u as=0.1331p ps=1.12u w=0.74u l=0.13u
X3485 sg13cmos5l_inv_16_77.A sg13cmos5l_inv_16_76.A VPWR.t2375 VPWR.t16 sg13_lv_pmos ad=0.2128p pd=1.5u as=0.2128p ps=1.5u w=1.12u l=0.13u
X3486 sg13cmos5l_inv_16_100.Y sg13cmos5l_inv_16_36.A VGND.t20 VGND.t126 sg13_lv_nmos ad=0.1406p pd=1.12u as=0.2516p ps=2.16u w=0.74u l=0.13u
X3487 VGND.t882 sg13cmos5l_inv_16_71.Y sg13cmos5l_inv_16_68.A VGND.t881 sg13_lv_nmos ad=0.1406p pd=1.12u as=0.1406p ps=1.12u w=0.74u l=0.13u
X3488 VPWR.t1038 sg13cmos5l_inv_16_34.Y sg13cmos5l_inv_16_101.Y VPWR.t0 sg13_lv_pmos ad=0.2128p pd=1.5u as=0.2128p ps=1.5u w=1.12u l=0.13u
X3489 sg13cmos5l_inv_16_67.A sg13cmos5l_inv_16_109.Y VPWR.t1544 VPWR.t9 sg13_lv_pmos ad=0.2128p pd=1.5u as=0.2128p ps=1.5u w=1.12u l=0.13u
X3490 VGND.t1718 VPWR.t2563 VGND.t1718 VGND.t380 sg13_lv_nmos ad=0.1428p pd=1.52u as=0 ps=0 w=0.42u l=1u
X3491 VPWR.t707 sg13cmos5l_inv_16_28.A sg13cmos5l_inv_16_29.A VPWR.t177 sg13_lv_pmos ad=0.2128p pd=1.5u as=0.2128p ps=1.5u w=1.12u l=0.13u
X3492 sg13cmos5l_inv_16_98.Y sg13cmos5l_inv_16_111.A VGND.t1541 VGND.t1545 sg13_lv_nmos ad=0.1406p pd=1.12u as=0.1406p ps=1.12u w=0.74u l=0.13u
X3493 VPWR.t1615 sg13cmos5l_inv_16_103.A sg13cmos5l_inv_16_103.Y VPWR.t0 sg13_lv_pmos ad=0.2128p pd=1.5u as=0.2128p ps=1.5u w=1.12u l=0.13u
X3494 VGND.t450 sg13cmos5l_inv_16_15.A sg13cmos5l_inv_16_15.Y VGND.t502 sg13_lv_nmos ad=0.1406p pd=1.12u as=0.1406p ps=1.12u w=0.74u l=0.13u
X3495 VPWR.t1024 sg13cmos5l_inv_16_34.Y sg13cmos5l_inv_16_99.A VPWR.t25 sg13_lv_pmos ad=0.2128p pd=1.5u as=0.2128p ps=1.5u w=1.12u l=0.13u
X3496 sg13cmos5l_inv_16_6.Y sg13cmos5l_inv_16_6.A VPWR.t246 VPWR.t177 sg13_lv_pmos ad=0.2128p pd=1.5u as=0.2128p ps=1.5u w=1.12u l=0.13u
X3497 sg13cmos5l_inv_8_3.Y sg13cmos5l_inv_4_2.Y VPWR.t1635 VPWR.t4 sg13_lv_pmos ad=0.2128p pd=1.5u as=0.2128p ps=1.5u w=1.12u l=0.13u
X3498 VPWR.t178 sg13cmos5l_inv_16_30.A sg13cmos5l_inv_16_30.Y VPWR.t177 sg13_lv_pmos ad=0.2128p pd=1.5u as=0.2128p ps=1.5u w=1.12u l=0.13u
X3499 VGND.t326 sg13cmos5l_inv_16_26.Y sg13cmos5l_inv_16_40.Y VGND.t329 sg13_lv_nmos ad=0.1406p pd=1.12u as=0.1406p ps=1.12u w=0.74u l=0.13u
X3500 VPWR.t753 sg13cmos5l_inv_16_4.Y sg13cmos5l_inv_16_6.A VPWR.t4 sg13_lv_pmos ad=0.4368p pd=3.02u as=0.2128p ps=1.5u w=1.12u l=0.13u
X3501 VPWR.t555 sg13cmos5l_buf_1_4.X a_13664_4097# VPWR.t0 sg13_lv_pmos ad=0.2856p pd=2.36u as=0.1596p ps=1.22u w=0.84u l=0.13u
X3502 sg13cmos5l_inv_16_68.A sg13cmos5l_inv_16_71.Y VPWR.t1396 VPWR.t9 sg13_lv_pmos ad=0.2128p pd=1.5u as=0.2128p ps=1.5u w=1.12u l=0.13u
X3503 VPWR.t43 VGND.t1820 VPWR.t42 VPWR.t9 sg13_lv_pmos ad=0.34p pd=2.68u as=0 ps=0 w=1u l=1u
X3504 sg13cmos5l_inv_16_81.Y sg13cmos5l_inv_16_96.Y VGND.t953 VGND.t380 sg13_lv_nmos ad=0.1406p pd=1.12u as=0.1406p ps=1.12u w=0.74u l=0.13u
X3505 VPWR.t786 sg13cmos5l_inv_16_11.A sg13cmos5l_inv_16_105.A VPWR.t25 sg13_lv_pmos ad=0.4368p pd=3.02u as=0.2128p ps=1.5u w=1.12u l=0.13u
X3506 VGND.t1100 sg13cmos5l_inv_16_105.A sg13cmos5l_inv_16_80.Y VGND.t1103 sg13_lv_nmos ad=0.1406p pd=1.12u as=0.1406p ps=1.12u w=0.74u l=0.13u
X3507 VGND.t2154 VPWR.t2464 VGND.t111 VGND.t2153 sg13_lv_nmos ad=0.1428p pd=1.52u as=0 ps=0 w=0.42u l=1u
X3508 sg13cmos5l_inv_16_109.Y sg13cmos5l_inv_16_48.A VGND.t1147 VGND.t881 sg13_lv_nmos ad=0.1406p pd=1.12u as=0.1406p ps=1.12u w=0.74u l=0.13u
X3509 VPWR.t465 sg13cmos5l_inv_16_37.A sg13cmos5l_inv_16_37.Y VPWR.t4 sg13_lv_pmos ad=0.2128p pd=1.5u as=0.2128p ps=1.5u w=1.12u l=0.13u
X3510 VPWR.t2373 sg13cmos5l_inv_16_76.A sg13cmos5l_inv_16_77.A VPWR.t16 sg13_lv_pmos ad=0.2128p pd=1.5u as=0.2128p ps=1.5u w=1.12u l=0.13u
X3511 VGND.t1423 VPWR.t2465 VGND.t1423 VGND.t2152 sg13_lv_nmos ad=0.1428p pd=1.52u as=0 ps=0 w=0.42u l=1u
X3512 sg13cmos5l_inv_16_67.Y sg13cmos5l_inv_16_67.A VGND.t1132 VGND.t881 sg13_lv_nmos ad=0.1406p pd=1.12u as=0.1406p ps=1.12u w=0.74u l=0.13u
X3513 sg13cmos5l_inv_16_101.Y sg13cmos5l_inv_16_34.Y VPWR.t1034 VPWR.t0 sg13_lv_pmos ad=0.2128p pd=1.5u as=0.2128p ps=1.5u w=1.12u l=0.13u
X3514 sg13cmos5l_inv_16_5.Y sg13cmos5l_inv_16_6.A VGND.t637 VGND.t1396 sg13_lv_nmos ad=0.1406p pd=1.12u as=0.1406p ps=1.12u w=0.74u l=0.13u
X3515 VGND.t637 VPWR.t246 VGND.t637 VGND.t2128 sg13_lv_nmos ad=0.1428p pd=1.52u as=0 ps=0 w=0.42u l=1u
X3516 sg13cmos5l_inv_16_111.A sg13cmos5l_inv_16_109.Y VGND.t1147 VGND.t881 sg13_lv_nmos ad=0.1406p pd=1.12u as=0.1406p ps=1.12u w=0.74u l=0.13u
X3517 VPWR.t272 sg13cmos5l_and2_1_2.B a_3597_916# VPWR.t177 sg13_lv_pmos ad=0.1918p pd=1.5u as=0.1596p ps=1.22u w=0.84u l=0.13u
X3518 sg13cmos5l_inv_16_19.Y sg13cmos5l_inv_16_17.A VGND.t96 VGND.t97 sg13_lv_nmos ad=0.1406p pd=1.12u as=0.1406p ps=1.12u w=0.74u l=0.13u
X3519 VGND.t1260 sg13cmos5l_inv_16_6.Y sg13cmos5l_inv_16_25.Y VGND.t2342 sg13_lv_nmos ad=0.1406p pd=1.12u as=0.1406p ps=1.12u w=0.74u l=0.13u
X3520 VPWR.t1656 sg13cmos5l_inv_16_27.Y sg13cmos5l_inv_16_43.Y VPWR.t4 sg13_lv_pmos ad=0.4368p pd=3.02u as=0.2128p ps=1.5u w=1.12u l=0.13u
X3521 sg13cmos5l_inv_16_61.A sg13cmos5l_inv_16_71.Y VPWR.t1369 VPWR.t9 sg13_lv_pmos ad=0.2128p pd=1.5u as=0.2128p ps=1.5u w=1.12u l=0.13u
X3522 sg13cmos5l_inv_16_53.A sg13cmos5l_inv_16_52.Y VGND.t1164 VGND.t881 sg13_lv_nmos ad=0.1406p pd=1.12u as=0.1406p ps=1.12u w=0.74u l=0.13u
X3523 VGND.t1970 sg13cmos5l_inv_16_76.A sg13cmos5l_inv_16_77.A VGND.t380 sg13_lv_nmos ad=0.1406p pd=1.12u as=0.1406p ps=1.12u w=0.74u l=0.13u
X3524 VGND.t122 sg13cmos5l_inv_16_75.A sg13cmos5l_inv_16_75.Y VGND.t410 sg13_lv_nmos ad=0.1406p pd=1.12u as=0.1406p ps=1.12u w=0.74u l=0.13u
X3525 VPWR.t1244 sg13cmos5l_inv_16_0.A sg13cmos5l_inv_16_23.Y VPWR.t4 sg13_lv_pmos ad=0.2128p pd=1.5u as=0.2128p ps=1.5u w=1.12u l=0.13u
X3526 sg13cmos5l_inv_16_20.Y sg13cmos5l_inv_16_20.A VPWR.t889 VPWR.t4 sg13_lv_pmos ad=0.2128p pd=1.5u as=0.2128p ps=1.5u w=1.12u l=0.13u
X3527 VPWR.t1394 sg13cmos5l_inv_16_71.Y sg13cmos5l_inv_16_68.A VPWR.t9 sg13_lv_pmos ad=0.2128p pd=1.5u as=0.2128p ps=1.5u w=1.12u l=0.13u
X3528 VGND.t953 sg13cmos5l_inv_16_96.Y sg13cmos5l_inv_16_81.Y VGND.t380 sg13_lv_nmos ad=0.1406p pd=1.12u as=0.1406p ps=1.12u w=0.74u l=0.13u
X3529 sg13cmos5l_inv_16_80.Y sg13cmos5l_inv_16_105.A VGND.t1100 VGND.t1099 sg13_lv_nmos ad=0.1406p pd=1.12u as=0.2516p ps=2.16u w=0.74u l=0.13u
X3530 sg13cmos5l_inv_16_23.Y sg13cmos5l_inv_16_0.A VGND.t827 VGND.t839 sg13_lv_nmos ad=0.1406p pd=1.12u as=0.1406p ps=1.12u w=0.74u l=0.13u
X3531 VGND.t655 sg13cmos5l_inv_16_2.A sg13cmos5l_inv_16_2.Y VGND.t1445 sg13_lv_nmos ad=0.1406p pd=1.12u as=0.1406p ps=1.12u w=0.74u l=0.13u
X3532 sg13cmos5l_inv_16_36.A sg13cmos5l_inv_16_43.Y VPWR.t614 VPWR.t0 sg13_lv_pmos ad=0.2128p pd=1.5u as=0.2128p ps=1.5u w=1.12u l=0.13u
X3533 VGND.t1944 VPWR.t2567 VGND.t1944 VGND.t380 sg13_lv_nmos ad=79.8f pd=0.8u as=0 ps=0 w=0.42u l=1u
X3534 VGND.t259 sg13cmos5l_inv_16_29.A sg13cmos5l_inv_16_35.Y VGND.t258 sg13_lv_nmos ad=0.1406p pd=1.12u as=0.1406p ps=1.12u w=0.74u l=0.13u
X3535 VGND.t1132 sg13cmos5l_inv_16_67.A sg13cmos5l_inv_16_67.Y VGND.t881 sg13_lv_nmos ad=0.1406p pd=1.12u as=0.1406p ps=1.12u w=0.74u l=0.13u
X3536 VGND.t637 sg13cmos5l_inv_16_6.A sg13cmos5l_inv_16_5.Y VGND.t1393 sg13_lv_nmos ad=0.1406p pd=1.12u as=0.1406p ps=1.12u w=0.74u l=0.13u
X3537 VGND.t882 sg13cmos5l_inv_16_68.A sg13cmos5l_inv_16_68.Y VGND.t881 sg13_lv_nmos ad=0.1406p pd=1.12u as=0.1406p ps=1.12u w=0.74u l=0.13u
X3538 VGND.t705 sg13cmos5l_inv_16_29.A sg13cmos5l_inv_16_29.Y VGND.t716 sg13_lv_nmos ad=0.1406p pd=1.12u as=0.1406p ps=1.12u w=0.74u l=0.13u
X3539 VGND.t86 sg13cmos5l_inv_16_17.A sg13cmos5l_inv_16_19.Y VGND.t93 sg13_lv_nmos ad=0.1406p pd=1.12u as=0.1406p ps=1.12u w=0.74u l=0.13u
X3540 VPWR.t1232 sg13cmos5l_inv_8_3.Y sg13cmos5l_inv_16_41.A VPWR.t4 sg13_lv_pmos ad=0.2128p pd=1.5u as=0.2128p ps=1.5u w=1.12u l=0.13u
X3541 VPWR.t2322 sg13cmos5l_inv_16_101.Y sg13cmos5l_inv_16_54.Y VPWR.t25 sg13_lv_pmos ad=0.2128p pd=1.5u as=0.2128p ps=1.5u w=1.12u l=0.13u
X3542 VGND.t827 sg13cmos5l_inv_16_0.A sg13cmos5l_inv_16_1.A VGND.t853 sg13_lv_nmos ad=0.1406p pd=1.12u as=0.1406p ps=1.12u w=0.74u l=0.13u
X3543 sg13cmos5l_inv_16_87.A sg13cmos5l_inv_16_73.A VPWR.t1861 VPWR.t9 sg13_lv_pmos ad=0.2128p pd=1.5u as=0.2128p ps=1.5u w=1.12u l=0.13u
X3544 a_20491_1980# sg13cmos5l_buf_1_2.X a_20397_1980# VGND.t589 sg13_lv_nmos ad=0.1216p pd=1.02u as=0.2176p ps=1.96u w=0.64u l=0.13u
X3545 VGND.t1164 sg13cmos5l_inv_16_52.Y sg13cmos5l_inv_16_53.A VGND.t881 sg13_lv_nmos ad=0.1406p pd=1.12u as=0.1406p ps=1.12u w=0.74u l=0.13u
X3546 sg13cmos5l_inv_16_23.Y sg13cmos5l_inv_16_0.A VPWR.t1241 VPWR.t4 sg13_lv_pmos ad=0.2128p pd=1.5u as=0.3808p ps=2.92u w=1.12u l=0.13u
X3547 VPWR.t1871 sg13cmos5l_inv_16_73.A sg13cmos5l_inv_16_73.Y VPWR.t16 sg13_lv_pmos ad=0.2128p pd=1.5u as=0.2128p ps=1.5u w=1.12u l=0.13u
X3548 sg13cmos5l_inv_16_111.A sg13cmos5l_inv_16_109.Y VPWR.t1563 VPWR.t9 sg13_lv_pmos ad=0.2128p pd=1.5u as=0.2128p ps=1.5u w=1.12u l=0.13u
X3549 sg13cmos5l_inv_16_81.Y sg13cmos5l_inv_16_96.Y VGND.t1792 VGND.t380 sg13_lv_nmos ad=0.1406p pd=1.12u as=0.1406p ps=1.12u w=0.74u l=0.13u
X3550 VGND.t593 sg13cmos5l_inv_16_34.Y sg13cmos5l_inv_16_99.A VGND.t594 sg13_lv_nmos ad=0.1406p pd=1.12u as=0.1406p ps=1.12u w=0.74u l=0.13u
X3551 sg13cmos5l_inv_4_2.Y sg13cmos5l_inv_2_3.Y VPWR.t480 VPWR.t177 sg13_lv_pmos ad=0.2128p pd=1.5u as=0.2128p ps=1.5u w=1.12u l=0.13u
X3552 VGND.t827 sg13cmos5l_inv_16_0.A sg13cmos5l_inv_16_23.Y VGND.t836 sg13_lv_nmos ad=0.1406p pd=1.12u as=0.1406p ps=1.12u w=0.74u l=0.13u
X3553 VPWR.t612 sg13cmos5l_inv_16_43.Y sg13cmos5l_inv_16_36.A VPWR.t0 sg13_lv_pmos ad=0.2128p pd=1.5u as=0.2128p ps=1.5u w=1.12u l=0.13u
X3554 sg13cmos5l_inv_16_29.Y sg13cmos5l_inv_16_29.A VGND.t705 VGND.t711 sg13_lv_nmos ad=0.1406p pd=1.12u as=0.1406p ps=1.12u w=0.74u l=0.13u
X3555 sg13cmos5l_inv_16_2.Y sg13cmos5l_inv_16_2.A VGND.t655 VGND.t1442 sg13_lv_nmos ad=0.1406p pd=1.12u as=0.1406p ps=1.12u w=0.74u l=0.13u
X3556 VGND.t922 sg13cmos5l_inv_16_52.Y sg13cmos5l_inv_16_69.Y VGND.t881 sg13_lv_nmos ad=0.1406p pd=1.12u as=0.1406p ps=1.12u w=0.74u l=0.13u
X3557 sg13cmos5l_inv_16_19.Y sg13cmos5l_inv_16_17.A VGND.t86 VGND.t90 sg13_lv_nmos ad=0.1406p pd=1.12u as=0.1406p ps=1.12u w=0.74u l=0.13u
X3558 VGND.t381 sg13cmos5l_inv_16_73.A sg13cmos5l_inv_16_73.Y VGND.t380 sg13_lv_nmos ad=0.1406p pd=1.12u as=0.1406p ps=1.12u w=0.74u l=0.13u
X3559 VGND.t1792 sg13cmos5l_inv_16_96.Y sg13cmos5l_inv_16_11.A VGND.t380 sg13_lv_nmos ad=0.1406p pd=1.12u as=0.1406p ps=1.12u w=0.74u l=0.13u
X3560 VPWR.t909 sg13cmos5l_inv_16_14.A sg13cmos5l_inv_16_104.Y VPWR.t0 sg13_lv_pmos ad=0.2128p pd=1.5u as=0.2128p ps=1.5u w=1.12u l=0.13u
X3561 sg13cmos5l_inv_16_41.A sg13cmos5l_inv_8_3.Y VPWR.t1228 VPWR.t4 sg13_lv_pmos ad=0.2128p pd=1.5u as=0.2128p ps=1.5u w=1.12u l=0.13u
X3562 sg13cmos5l_inv_16_80.Y sg13cmos5l_inv_16_105.A VPWR.t1506 VPWR.t25 sg13_lv_pmos ad=0.2128p pd=1.5u as=0.2128p ps=1.5u w=1.12u l=0.13u
X3563 sg13cmos5l_inv_16_1.A sg13cmos5l_inv_16_0.A VGND.t827 VGND.t850 sg13_lv_nmos ad=0.1406p pd=1.12u as=0.1406p ps=1.12u w=0.74u l=0.13u
X3564 VPWR.t1859 sg13cmos5l_inv_16_73.A sg13cmos5l_inv_16_87.A VPWR.t9 sg13_lv_pmos ad=0.2128p pd=1.5u as=0.2128p ps=1.5u w=1.12u l=0.13u
X3565 VPWR.t492 sg13cmos5l_inv_16_23.Y sg13cmos5l_inv_16_15.A VPWR.t0 sg13_lv_pmos ad=0.2128p pd=1.5u as=0.2128p ps=1.5u w=1.12u l=0.13u
X3566 VPWR.t1561 sg13cmos5l_inv_16_109.Y sg13cmos5l_inv_16_111.A VPWR.t9 sg13_lv_pmos ad=0.2128p pd=1.5u as=0.2128p ps=1.5u w=1.12u l=0.13u
X3567 sg13cmos5l_inv_16_95.Y sg13cmos5l_inv_16_73.Y VPWR.t2206 VPWR.t16 sg13_lv_pmos ad=0.2128p pd=1.5u as=0.2128p ps=1.5u w=1.12u l=0.13u
X3568 VPWR.t846 osc[4] a_2920_6168# VPWR.t25 sg13_lv_pmos ad=0.2114p pd=1.54u as=0.2856p ps=2.36u w=0.84u l=0.13u
X3569 VPWR.t1185 sg13cmos5l_inv_8_7.Y sg13cmos5l_inv_16_48.A VPWR.t25 sg13_lv_pmos ad=0.2128p pd=1.5u as=0.2128p ps=1.5u w=1.12u l=0.13u
X3570 sg13cmos5l_inv_16_69.Y sg13cmos5l_inv_16_52.Y VGND.t922 VGND.t881 sg13_lv_nmos ad=0.1406p pd=1.12u as=0.1406p ps=1.12u w=0.74u l=0.13u
X3571 VPWR.t347 VGND.t381 VPWR.t346 VPWR.t25 sg13_lv_pmos ad=0.34p pd=2.68u as=0 ps=0 w=1u l=1u
X3572 VPWR.t2110 sg13cmos5l_inv_16_48.A sg13cmos5l_inv_16_46.A VPWR.t25 sg13_lv_pmos ad=0.4368p pd=3.02u as=0.2128p ps=1.5u w=1.12u l=0.13u
X3573 VPWR.t329 sg13cmos5l_inv_8_1.Y sg13cmos5l_inv_16_4.Y VPWR.t177 sg13_lv_pmos ad=0.2128p pd=1.5u as=0.2128p ps=1.5u w=1.12u l=0.13u
X3574 sg13cmos5l_inv_16_98.Y sg13cmos5l_inv_16_111.A VGND.t1541 VGND.t1540 sg13_lv_nmos ad=0.1406p pd=1.12u as=0.2516p ps=2.16u w=0.74u l=0.13u
X3575 VGND.t1507 VPWR.t2572 VGND.t1010 VGND.t881 sg13_lv_nmos ad=0.1428p pd=1.52u as=0 ps=0 w=0.42u l=1u
X3576 VGND.t953 sg13cmos5l_inv_4_6.Y sg13cmos5l_inv_16_96.A VGND.t380 sg13_lv_nmos ad=0.1406p pd=1.12u as=0.1443p ps=1.13u w=0.74u l=0.13u
X3577 VGND.t922 sg13cmos5l_inv_16_69.Y sg13cmos5l_inv_16_62.Y VGND.t881 sg13_lv_nmos ad=0.1406p pd=1.12u as=0.1406p ps=1.12u w=0.74u l=0.13u
X3578 VGND.t1010 sg13cmos5l_inv_16_87.A sg13cmos5l_inv_16_87.Y VGND.t881 sg13_lv_nmos ad=0.1406p pd=1.12u as=0.1406p ps=1.12u w=0.74u l=0.13u
X3579 sg13cmos5l_inv_16_73.Y sg13cmos5l_inv_16_73.A VGND.t381 VGND.t380 sg13_lv_nmos ad=0.1406p pd=1.12u as=0.1406p ps=1.12u w=0.74u l=0.13u
X3580 sg13cmos5l_inv_16_11.A sg13cmos5l_inv_16_96.Y VGND.t1792 VGND.t380 sg13_lv_nmos ad=0.1406p pd=1.12u as=0.2516p ps=2.16u w=0.74u l=0.13u
X3581 sg13cmos5l_inv_16_104.Y sg13cmos5l_inv_16_14.A VPWR.t905 VPWR.t0 sg13_lv_pmos ad=0.2128p pd=1.5u as=0.2128p ps=1.5u w=1.12u l=0.13u
X3582 sg13cmos5l_inv_16_6.Y sg13cmos5l_inv_16_6.A VPWR.t246 VPWR.t177 sg13_lv_pmos ad=0.2128p pd=1.5u as=0.2128p ps=1.5u w=1.12u l=0.13u
X3583 VGND.t198 sg13cmos5l_inv_16_28.A sg13cmos5l_inv_16_29.A VGND.t211 sg13_lv_nmos ad=0.1406p pd=1.12u as=0.1406p ps=1.12u w=0.74u l=0.13u
X3584 sg13cmos5l_inv_8_3.Y sg13cmos5l_inv_4_2.Y VPWR.t1632 VPWR.t4 sg13_lv_pmos ad=0.2128p pd=1.5u as=0.3808p ps=2.92u w=1.12u l=0.13u
X3585 VPWR.t1504 sg13cmos5l_inv_16_105.A sg13cmos5l_inv_16_80.Y VPWR.t25 sg13_lv_pmos ad=0.2128p pd=1.5u as=0.2128p ps=1.5u w=1.12u l=0.13u
X3586 sg13cmos5l_inv_16_22.Y sg13cmos5l_inv_16_20.A VPWR.t867 VPWR.t0 sg13_lv_pmos ad=0.2128p pd=1.5u as=0.3808p ps=2.92u w=1.12u l=0.13u
X3587 sg13cmos5l_inv_16_56.Y sg13cmos5l_inv_8_4.Y VGND.t1944 VGND.t380 sg13_lv_nmos ad=0.1406p pd=1.12u as=0.1406p ps=1.12u w=0.74u l=0.13u
X3588 VPWR.t80 VGND.t1944 VPWR.t79 VPWR.t25 sg13_lv_pmos ad=0.34p pd=2.68u as=0 ps=0 w=1u l=1u
X3589 sg13cmos5l_inv_16_15.A sg13cmos5l_inv_16_23.Y VPWR.t488 VPWR.t0 sg13_lv_pmos ad=0.2128p pd=1.5u as=0.2128p ps=1.5u w=1.12u l=0.13u
X3590 VPWR.t681 sg13cmos5l_inv_16_41.A sg13cmos5l_inv_16_28.A VPWR.t4 sg13_lv_pmos ad=0.2128p pd=1.5u as=0.2128p ps=1.5u w=1.12u l=0.13u
X3591 VPWR.t782 sg13cmos5l_inv_16_11.A sg13cmos5l_inv_16_105.A VPWR.t25 sg13_lv_pmos ad=0.2128p pd=1.5u as=0.2128p ps=1.5u w=1.12u l=0.13u
X3592 VGND.t101 VPWR.t2471 VGND.t101 VGND.t2115 sg13_lv_nmos ad=0.1428p pd=1.52u as=0 ps=0 w=0.42u l=1u
X3593 sg13cmos5l_inv_16_46.A sg13cmos5l_inv_16_48.A VPWR.t2106 VPWR.t25 sg13_lv_pmos ad=0.2128p pd=1.5u as=0.2128p ps=1.5u w=1.12u l=0.13u
X3594 sg13cmos5l_inv_16_101.Y sg13cmos5l_inv_16_34.Y VGND.t593 VGND.t607 sg13_lv_nmos ad=0.1406p pd=1.12u as=0.1406p ps=1.12u w=0.74u l=0.13u
X3595 VPWR.t608 sg13cmos5l_inv_16_43.Y sg13cmos5l_inv_16_36.A VPWR.t0 sg13_lv_pmos ad=0.2128p pd=1.5u as=0.2128p ps=1.5u w=1.12u l=0.13u
X3596 sg13cmos5l_inv_16_87.Y sg13cmos5l_inv_16_87.A VGND.t1010 VGND.t881 sg13_lv_nmos ad=0.1406p pd=1.12u as=0.1406p ps=1.12u w=0.74u l=0.13u
X3597 VPWR.t1652 sg13cmos5l_inv_16_27.Y sg13cmos5l_inv_16_43.Y VPWR.t4 sg13_lv_pmos ad=0.2128p pd=1.5u as=0.2128p ps=1.5u w=1.12u l=0.13u
X3598 sg13cmos5l_inv_16_99.A sg13cmos5l_inv_16_34.Y VPWR.t1016 VPWR.t25 sg13_lv_pmos ad=0.2128p pd=1.5u as=0.2128p ps=1.5u w=1.12u l=0.13u
X3599 VPWR.t903 sg13cmos5l_inv_16_14.A sg13cmos5l_inv_16_104.Y VPWR.t0 sg13_lv_pmos ad=0.2128p pd=1.5u as=0.2128p ps=1.5u w=1.12u l=0.13u
X3600 VGND.t5 sg13cmos5l_inv_4_5.Y sg13cmos5l_inv_8_4.Y VGND.t1065 sg13_lv_nmos ad=0.2516p pd=2.16u as=0.1443p ps=1.13u w=0.74u l=0.13u
X3601 VGND.t122 sg13cmos5l_inv_16_75.A sg13cmos5l_inv_16_75.Y VGND.t406 sg13_lv_nmos ad=0.1406p pd=1.12u as=0.1406p ps=1.12u w=0.74u l=0.13u
X3602 sg13cmos5l_inv_8_3.Y sg13cmos5l_inv_4_2.Y VGND.t1236 VGND.t1239 sg13_lv_nmos ad=0.1443p pd=1.13u as=0.1406p ps=1.12u w=0.74u l=0.13u
X3603 sg13cmos5l_inv_16_85.Y sg13cmos5l_inv_16_84.A VPWR.t1484 VPWR.t9 sg13_lv_pmos ad=0.2128p pd=1.5u as=0.2128p ps=1.5u w=1.12u l=0.13u
X3604 sg13cmos5l_inv_16_109.Y sg13cmos5l_inv_16_48.A VPWR.t2088 VPWR.t16 sg13_lv_pmos ad=0.2128p pd=1.5u as=0.2128p ps=1.5u w=1.12u l=0.13u
X3605 VGND.t1944 sg13cmos5l_inv_8_4.Y sg13cmos5l_inv_16_56.Y VGND.t380 sg13_lv_nmos ad=0.1406p pd=1.12u as=0.1406p ps=1.12u w=0.74u l=0.13u
X3606 sg13cmos5l_inv_16_77.Y sg13cmos5l_inv_16_77.A VGND.t122 VGND.t2162 sg13_lv_nmos ad=0.1406p pd=1.12u as=0.2516p ps=2.16u w=0.74u l=0.13u
X3607 VPWR.t222 VGND.t122 VPWR.t221 VPWR.t0 sg13_lv_pmos ad=0.34p pd=2.68u as=0 ps=0 w=1u l=1u
X3608 VPWR.t246 sg13cmos5l_inv_16_6.Y sg13cmos5l_inv_16_108.Y VPWR.t177 sg13_lv_pmos ad=0.3808p pd=2.92u as=0.2128p ps=1.5u w=1.12u l=0.13u
X3609 sg13cmos5l_inv_16_73.A sg13cmos5l_inv_16_94.A VGND.t1507 VGND.t881 sg13_lv_nmos ad=0.1406p pd=1.12u as=0.1406p ps=1.12u w=0.74u l=0.13u
X3610 sg13cmos5l_inv_16_96.A sg13cmos5l_inv_4_6.Y VGND.t953 VGND.t380 sg13_lv_nmos ad=0.1443p pd=1.13u as=0.2516p ps=2.16u w=0.74u l=0.13u
X3611 VPWR.t1334 sg13cmos5l_inv_16_69.Y sg13cmos5l_inv_16_62.Y VPWR.t9 sg13_lv_pmos ad=0.2128p pd=1.5u as=0.2128p ps=1.5u w=1.12u l=0.13u
X3612 VPWR.t2056 sg13cmos5l_inv_16_56.Y sg13cmos5l_inv_16_52.Y VPWR.t16 sg13_lv_pmos ad=0.2128p pd=1.5u as=0.2128p ps=1.5u w=1.12u l=0.13u
X3613 sg13cmos5l_inv_16_29.Y sg13cmos5l_inv_16_29.A VGND.t705 VGND.t717 sg13_lv_nmos ad=0.1406p pd=1.12u as=0.1406p ps=1.12u w=0.74u l=0.13u
X3614 sg13cmos5l_inv_16_43.Y sg13cmos5l_inv_16_27.Y VPWR.t1648 VPWR.t4 sg13_lv_pmos ad=0.2128p pd=1.5u as=0.2128p ps=1.5u w=1.12u l=0.13u
X3615 sg13cmos5l_inv_16_74.Y sg13cmos5l_inv_16_75.A VGND.t390 VGND.t380 sg13_lv_nmos ad=0.1406p pd=1.12u as=0.1406p ps=1.12u w=0.74u l=0.13u
X3616 VPWR.t1354 sg13cmos5l_inv_16_96.A sg13cmos5l_inv_16_96.Y VPWR.t25 sg13_lv_pmos ad=0.2128p pd=1.5u as=0.2128p ps=1.5u w=1.12u l=0.13u
X3617 sg13cmos5l_inv_16_75.Y sg13cmos5l_inv_16_75.A VGND.t122 VGND.t403 sg13_lv_nmos ad=0.1406p pd=1.12u as=0.1406p ps=1.12u w=0.74u l=0.13u
X3618 sg13cmos5l_inv_16_103.A sg13cmos5l_inv_16_11.A VPWR.t790 VPWR.t0 sg13_lv_pmos ad=0.2128p pd=1.5u as=0.2128p ps=1.5u w=1.12u l=0.13u
X3619 VPWR.t2086 sg13cmos5l_inv_16_48.A sg13cmos5l_inv_16_109.Y VPWR.t16 sg13_lv_pmos ad=0.2128p pd=1.5u as=0.2128p ps=1.5u w=1.12u l=0.13u
X3620 VGND.t705 sg13cmos5l_inv_16_29.A sg13cmos5l_inv_16_29.Y VGND.t712 sg13_lv_nmos ad=0.1406p pd=1.12u as=0.1406p ps=1.12u w=0.74u l=0.13u
X3621 VGND.t326 sg13cmos5l_inv_16_26.A sg13cmos5l_inv_16_30.A VGND.t1318 sg13_lv_nmos ad=0.1406p pd=1.12u as=0.1406p ps=1.12u w=0.74u l=0.13u
X3622 VPWR.t550 sg13cmos5l_inv_16_17.A sg13cmos5l_inv_16_17.Y VPWR.t177 sg13_lv_pmos ad=0.2128p pd=1.5u as=0.2128p ps=1.5u w=1.12u l=0.13u
X3623 sg13cmos5l_inv_16_28.A sg13cmos5l_inv_16_41.A VGND.t39 VGND.t249 sg13_lv_nmos ad=0.1406p pd=1.12u as=0.1406p ps=1.12u w=0.74u l=0.13u
X3624 VPWR.t677 sg13cmos5l_inv_16_41.A sg13cmos5l_inv_16_28.A VPWR.t4 sg13_lv_pmos ad=0.2128p pd=1.5u as=0.2128p ps=1.5u w=1.12u l=0.13u
X3625 VGND.t259 sg13cmos5l_inv_16_28.A sg13cmos5l_inv_16_44.A VGND.t258 sg13_lv_nmos ad=0.1406p pd=1.12u as=0.1406p ps=1.12u w=0.74u l=0.13u
X3626 VPWR.t2352 sg13cmos5l_inv_16_101.Y sg13cmos5l_inv_16_55.Y VPWR.t25 sg13_lv_pmos ad=0.3808p pd=2.92u as=0.2128p ps=1.5u w=1.12u l=0.13u
X3627 VPWR.t329 sg13cmos5l_and2_1_0.B a_16941_916# VPWR.t177 sg13_lv_pmos ad=0.1918p pd=1.5u as=0.1596p ps=1.22u w=0.84u l=0.13u
X3628 sg13cmos5l_inv_16_2.Y sg13cmos5l_inv_16_2.A VGND.t655 VGND.t1438 sg13_lv_nmos ad=0.1406p pd=1.12u as=0.1406p ps=1.12u w=0.74u l=0.13u
X3629 sg13cmos5l_inv_16_62.Y sg13cmos5l_inv_16_69.Y VPWR.t1330 VPWR.t9 sg13_lv_pmos ad=0.2128p pd=1.5u as=0.2128p ps=1.5u w=1.12u l=0.13u
X3630 VPWR.t1986 sg13cmos5l_inv_16_67.A sg13cmos5l_inv_16_67.Y VPWR.t16 sg13_lv_pmos ad=0.2128p pd=1.5u as=0.2128p ps=1.5u w=1.12u l=0.13u
X3631 sg13cmos5l_inv_16_102.Y sg13cmos5l_inv_16_37.A VPWR.t454 VPWR.t0 sg13_lv_pmos ad=0.2128p pd=1.5u as=0.2128p ps=1.5u w=1.12u l=0.13u
X3632 VPWR.t1306 sg13cmos5l_inv_16_68.A sg13cmos5l_inv_16_68.Y VPWR.t16 sg13_lv_pmos ad=0.4368p pd=3.02u as=0.2128p ps=1.5u w=1.12u l=0.13u
X3633 VGND.t2149 VPWR.t329 VGND.t2148 VGND.t2147 sg13_lv_nmos ad=0.1428p pd=1.52u as=0 ps=0 w=0.42u l=1u
X3634 sg13cmos5l_inv_16_25.Y sg13cmos5l_inv_16_6.Y VPWR.t844 VPWR.t177 sg13_lv_pmos ad=0.2128p pd=1.5u as=0.2128p ps=1.5u w=1.12u l=0.13u
X3635 VGND.t52 sg13cmos5l_inv_16_23.Y sg13cmos5l_inv_16_14.A VGND.t70 sg13_lv_nmos ad=0.1406p pd=1.12u as=0.1406p ps=1.12u w=0.74u l=0.13u
X3636 sg13cmos5l_inv_16_93.Y sg13cmos5l_inv_16_87.A VPWR.t1412 VPWR.t9 sg13_lv_pmos ad=0.2128p pd=1.5u as=0.2128p ps=1.5u w=1.12u l=0.13u
X3637 VGND.t381 sg13cmos5l_inv_16_75.A sg13cmos5l_inv_16_74.Y VGND.t380 sg13_lv_nmos ad=0.1406p pd=1.12u as=0.1406p ps=1.12u w=0.74u l=0.13u
X3638 VGND.t5 VPWR.t2526 VGND.t5 VGND.t2018 sg13_lv_nmos ad=79.8f pd=0.8u as=0 ps=0 w=0.42u l=1u
X3639 VGND.t675 sg13cmos5l_inv_16_1.A sg13cmos5l_inv_16_17.A VGND.t685 sg13_lv_nmos ad=0.1406p pd=1.12u as=0.1406p ps=1.12u w=0.74u l=0.13u
X3640 sg13cmos5l_inv_16_44.Y sg13cmos5l_inv_16_44.A VPWR.t622 VPWR.t4 sg13_lv_pmos ad=0.2128p pd=1.5u as=0.3808p ps=2.92u w=1.12u l=0.13u
X3641 VPWR.t788 sg13cmos5l_inv_16_11.A sg13cmos5l_inv_16_103.A VPWR.t0 sg13_lv_pmos ad=0.2128p pd=1.5u as=0.2128p ps=1.5u w=1.12u l=0.13u
X3642 VPWR.t1012 sg13cmos5l_inv_2_0.A sg13cmos5l_inv_4_0.A VPWR.t177 sg13_lv_pmos ad=0.3864p pd=2.93u as=0.2128p ps=1.5u w=1.12u l=0.13u
X3643 VGND.t162 VPWR.t2503 VGND.t162 VGND.t2056 sg13_lv_nmos ad=79.8f pd=0.8u as=0 ps=0 w=0.42u l=1u
X3644 sg13cmos5l_inv_16_30.A sg13cmos5l_inv_16_26.A VGND.t326 VGND.t1315 sg13_lv_nmos ad=0.1406p pd=1.12u as=0.1406p ps=1.12u w=0.74u l=0.13u
X3645 sg13cmos5l_inv_16_28.A sg13cmos5l_inv_16_41.A VPWR.t673 VPWR.t4 sg13_lv_pmos ad=0.2128p pd=1.5u as=0.2128p ps=1.5u w=1.12u l=0.13u
X3646 sg13cmos5l_inv_16_95.Y sg13cmos5l_inv_16_73.Y VGND.t1010 VGND.t881 sg13_lv_nmos ad=0.1406p pd=1.12u as=0.1406p ps=1.12u w=0.74u l=0.13u
X3647 VGND.t545 sg13cmos5l_inv_16_8.Y sg13cmos5l_inv_16_20.A VGND.t553 sg13_lv_nmos ad=0.1406p pd=1.12u as=0.1406p ps=1.12u w=0.74u l=0.13u
X3648 sg13cmos5l_inv_16_35.Y sg13cmos5l_inv_16_29.A VGND.t259 VGND.t272 sg13_lv_nmos ad=0.1406p pd=1.12u as=0.1406p ps=1.12u w=0.74u l=0.13u
X3649 VPWR.t1070 sg13cmos5l_inv_16_5.Y sg13cmos5l_inv_16_110.Y VPWR.t4 sg13_lv_pmos ad=0.4368p pd=3.02u as=0.2128p ps=1.5u w=1.12u l=0.13u
X3650 sg13cmos5l_inv_16_69.Y sg13cmos5l_inv_16_52.Y VGND.t922 VGND.t881 sg13_lv_nmos ad=0.1406p pd=1.12u as=0.1406p ps=1.12u w=0.74u l=0.13u
X3651 sg13cmos5l_inv_16_68.Y sg13cmos5l_inv_16_68.A VPWR.t1302 VPWR.t16 sg13_lv_pmos ad=0.2128p pd=1.5u as=0.2128p ps=1.5u w=1.12u l=0.13u
X3652 VGND.t259 VPWR.t2498 VGND.t2045 VGND.t2064 sg13_lv_nmos ad=79.8f pd=0.8u as=0 ps=0 w=0.42u l=1u
X3653 sg13cmos5l_inv_16_54.Y sg13cmos5l_inv_16_101.Y VPWR.t2334 VPWR.t25 sg13_lv_pmos ad=0.2128p pd=1.5u as=0.2128p ps=1.5u w=1.12u l=0.13u
X3654 sg13cmos5l_inv_16_75.Y sg13cmos5l_inv_16_75.A VPWR.t828 VPWR.t25 sg13_lv_pmos ad=0.2128p pd=1.5u as=0.2128p ps=1.5u w=1.12u l=0.13u
X3655 VPWR.t2252 sg13cmos5l_inv_16_77.A sg13cmos5l_inv_16_77.Y VPWR.t25 sg13_lv_pmos ad=0.2128p pd=1.5u as=0.2128p ps=1.5u w=1.12u l=0.13u
X3656 sg13cmos5l_inv_16_1.A sg13cmos5l_inv_16_0.A VPWR.t1268 VPWR.t177 sg13_lv_pmos ad=0.2128p pd=1.5u as=0.2128p ps=1.5u w=1.12u l=0.13u
X3657 VGND.t953 VPWR.t2559 VGND.t953 VGND.t380 sg13_lv_nmos ad=79.8f pd=0.8u as=0 ps=0 w=0.42u l=1u
X3658 VGND.t1715 sg13cmos5l_inv_16_48.A sg13cmos5l_inv_16_46.A VGND.t380 sg13_lv_nmos ad=0.1406p pd=1.12u as=0.1406p ps=1.12u w=0.74u l=0.13u
X3659 VGND.t1792 VPWR.t2544 VGND.t1792 VGND.t380 sg13_lv_nmos ad=79.8f pd=0.8u as=0 ps=0 w=0.42u l=1u
X3660 VGND.t423 sg13cmos5l_inv_8_1.Y sg13cmos5l_inv_16_4.Y VGND.t1461 sg13_lv_nmos ad=0.1406p pd=1.12u as=0.1406p ps=1.12u w=0.74u l=0.13u
X3661 VGND.t291 sg13cmos5l_inv_16_8.Y sg13cmos5l_inv_16_9.A VGND.t571 sg13_lv_nmos ad=0.1406p pd=1.12u as=0.1406p ps=1.12u w=0.74u l=0.13u
X3662 VPWR.t2010 a_25484_834# sg13cmos5l_buf_1_1.X VPWR.t177 sg13_lv_pmos ad=0.2114p pd=1.54u as=0.42p ps=2.99u w=1.12u l=0.13u
X3663 VGND.t162 sg13cmos5l_inv_16_36.A sg13cmos5l_inv_16_36.Y VGND.t161 sg13_lv_nmos ad=0.2516p pd=2.16u as=0.1406p ps=1.12u w=0.74u l=0.13u
X3664 VPWR.t186 VGND.t1718 VPWR.t185 VPWR.t16 sg13_lv_pmos ad=0.34p pd=2.68u as=0 ps=0 w=1u l=1u
X3665 VGND.t450 sg13cmos5l_inv_16_20.A sg13cmos5l_inv_16_22.Y VGND.t452 sg13_lv_nmos ad=0.2516p pd=2.16u as=0.1406p ps=1.12u w=0.74u l=0.13u
X3666 sg13cmos5l_inv_16_8.Y sg13cmos5l_inv_16_4.Y VGND.t291 VGND.t299 sg13_lv_nmos ad=0.1406p pd=1.12u as=0.1406p ps=1.12u w=0.74u l=0.13u
X3667 VGND.t1010 sg13cmos5l_inv_16_73.Y sg13cmos5l_inv_16_95.Y VGND.t881 sg13_lv_nmos ad=0.1406p pd=1.12u as=0.1406p ps=1.12u w=0.74u l=0.13u
X3668 VGND.t259 sg13cmos5l_inv_16_29.A sg13cmos5l_inv_16_35.Y VGND.t269 sg13_lv_nmos ad=0.1406p pd=1.12u as=0.1406p ps=1.12u w=0.74u l=0.13u
X3669 sg13cmos5l_inv_16_34.Y sg13cmos5l_inv_16_41.A VGND.t217 VGND.t219 sg13_lv_nmos ad=0.1406p pd=1.12u as=0.1406p ps=1.12u w=0.74u l=0.13u
X3670 VGND.t414 sg13cmos5l_inv_16_26.A sg13cmos5l_inv_16_26.Y VGND.t1331 sg13_lv_nmos ad=0.1406p pd=1.12u as=0.1406p ps=1.12u w=0.74u l=0.13u
X3671 VGND.t588 sg13cmos5l_inv_4_0.Y sg13cmos5l_inv_8_0.Y VGND.t1802 sg13_lv_nmos ad=0.1406p pd=1.12u as=0.1406p ps=1.12u w=0.74u l=0.13u
X3672 VGND.t953 sg13cmos5l_inv_16_96.Y sg13cmos5l_inv_16_11.A VGND.t380 sg13_lv_nmos ad=0.2516p pd=2.16u as=0.1406p ps=1.12u w=0.74u l=0.13u
X3673 VPWR.t826 sg13cmos5l_inv_16_75.A sg13cmos5l_inv_16_75.Y VPWR.t25 sg13_lv_pmos ad=0.2128p pd=1.5u as=0.2128p ps=1.5u w=1.12u l=0.13u
X3674 sg13cmos5l_inv_16_102.Y sg13cmos5l_inv_16_37.A VPWR.t450 VPWR.t0 sg13_lv_pmos ad=0.2128p pd=1.5u as=0.2128p ps=1.5u w=1.12u l=0.13u
X3675 sg13cmos5l_inv_16_6.A sg13cmos5l_inv_16_4.Y VGND.t310 VGND.t313 sg13_lv_nmos ad=0.1406p pd=1.12u as=0.1406p ps=1.12u w=0.74u l=0.13u
X3676 VPWR.t2332 sg13cmos5l_inv_16_101.Y sg13cmos5l_inv_16_54.Y VPWR.t25 sg13_lv_pmos ad=0.2128p pd=1.5u as=0.2128p ps=1.5u w=1.12u l=0.13u
X3677 sg13cmos5l_inv_16_27.A sg13cmos5l_inv_8_2.A VPWR.t1001 VPWR.t177 sg13_lv_pmos ad=0.2128p pd=1.5u as=0.2128p ps=1.5u w=1.12u l=0.13u
X3678 VPWR.t178 sg13cmos5l_inv_16_26.Y sg13cmos5l_inv_16_40.Y VPWR.t177 sg13_lv_pmos ad=0.2128p pd=1.5u as=0.2128p ps=1.5u w=1.12u l=0.13u
X3679 sg13cmos5l_inv_16_87.Y sg13cmos5l_inv_16_87.A VGND.t1010 VGND.t881 sg13_lv_nmos ad=0.1406p pd=1.12u as=0.1406p ps=1.12u w=0.74u l=0.13u
X3680 VGND.t1580 sg13cmos5l_inv_16_67.A sg13cmos5l_inv_16_65.Y VGND.t1587 sg13_lv_nmos ad=0.1406p pd=1.12u as=0.1406p ps=1.12u w=0.74u l=0.13u
X3681 VGND.t472 sg13cmos5l_inv_16_14.A sg13cmos5l_inv_16_104.Y VGND.t484 sg13_lv_nmos ad=0.2516p pd=2.16u as=0.1406p ps=1.12u w=0.74u l=0.13u
X3682 sg13cmos5l_inv_8_0.Y sg13cmos5l_inv_4_0.Y VGND.t588 VGND.t1797 sg13_lv_nmos ad=0.1406p pd=1.12u as=0.2516p ps=2.16u w=0.74u l=0.13u
X3683 sg13cmos5l_inv_8_1.A sg13cmos5l_inv_2_1.Y VGND.t310 VGND.t421 sg13_lv_nmos ad=0.1406p pd=1.12u as=0.1406p ps=1.12u w=0.74u l=0.13u
X3684 sg13cmos5l_inv_16_36.Y sg13cmos5l_inv_16_36.A VGND.t146 VGND.t158 sg13_lv_nmos ad=0.1406p pd=1.12u as=0.1406p ps=1.12u w=0.74u l=0.13u
X3685 sg13cmos5l_inv_16_85.Y sg13cmos5l_inv_16_84.A VGND.t1067 VGND.t1066 sg13_lv_nmos ad=0.1406p pd=1.12u as=0.2516p ps=2.16u w=0.74u l=0.13u
X3686 sg13cmos5l_inv_16_46.Y sg13cmos5l_inv_16_46.A VGND.t134 VGND.t1755 sg13_lv_nmos ad=0.1406p pd=1.12u as=0.1406p ps=1.12u w=0.74u l=0.13u
X3687 VGND.t2117 VPWR.t2470 VGND.t2117 VGND.t2118 sg13_lv_nmos ad=0.1428p pd=1.52u as=0 ps=0 w=0.42u l=1u
X3688 VPWR.t431 VGND.t1241 VPWR.t127 VPWR.t9 sg13_lv_pmos ad=0.19p pd=1.38u as=0 ps=0 w=1u l=1u
X3689 VPWR.t1308 sg13cmos5l_inv_2_5.A sg13cmos5l_inv_2_5.Y VPWR.t16 sg13_lv_pmos ad=0.3808p pd=2.92u as=0.2128p ps=1.5u w=1.12u l=0.13u
X3690 VPWR.t2052 sg13cmos5l_inv_16_56.Y sg13cmos5l_inv_16_52.Y VPWR.t16 sg13_lv_pmos ad=0.2128p pd=1.5u as=0.2128p ps=1.5u w=1.12u l=0.13u
X3691 VGND.t723 sg13cmos5l_inv_16_9.A sg13cmos5l_inv_16_10.Y VGND.t726 sg13_lv_nmos ad=0.1406p pd=1.12u as=0.1406p ps=1.12u w=0.74u l=0.13u
X3692 VPWR.t176 VGND.t101 VPWR.t175 VPWR.t4 sg13_lv_pmos ad=0.34p pd=2.68u as=0 ps=0 w=1u l=1u
X3693 VGND.t963 sg13cmos5l_inv_16_56.Y sg13cmos5l_inv_16_71.Y VGND.t881 sg13_lv_nmos ad=0.1406p pd=1.12u as=0.1406p ps=1.12u w=0.74u l=0.13u
X3694 VGND.t545 sg13cmos5l_inv_16_8.Y sg13cmos5l_inv_16_20.A VGND.t549 sg13_lv_nmos ad=0.1406p pd=1.12u as=0.1406p ps=1.12u w=0.74u l=0.13u
X3695 VGND.t310 sg13cmos5l_inv_16_4.Y sg13cmos5l_inv_16_6.A VGND.t309 sg13_lv_nmos ad=0.1406p pd=1.12u as=0.1406p ps=1.12u w=0.74u l=0.13u
X3696 VPWR.t286 VGND.t326 VPWR.t284 VPWR.t4 sg13_lv_pmos ad=0.19p pd=1.38u as=0 ps=0 w=1u l=1u
X3697 sg13cmos5l_inv_16_40.Y sg13cmos5l_inv_16_26.Y VPWR.t178 VPWR.t177 sg13_lv_pmos ad=0.2128p pd=1.5u as=0.2128p ps=1.5u w=1.12u l=0.13u
X3698 VGND.t1398 VPWR.t2475 VGND.t637 VGND.t2105 sg13_lv_nmos ad=0.1428p pd=1.52u as=0 ps=0 w=0.42u l=1u
X3699 VPWR.t2400 sg13cmos5l_inv_16_76.A sg13cmos5l_inv_16_75.A VPWR.t25 sg13_lv_pmos ad=0.2128p pd=1.5u as=0.2128p ps=1.5u w=1.12u l=0.13u
X3700 sg13cmos5l_inv_16_65.Y sg13cmos5l_inv_16_67.A VGND.t1580 VGND.t1584 sg13_lv_nmos ad=0.1406p pd=1.12u as=0.1406p ps=1.12u w=0.74u l=0.13u
X3701 sg13cmos5l_inv_16_84.Y sg13cmos5l_inv_16_84.A VGND.t1026 VGND.t881 sg13_lv_nmos ad=0.1406p pd=1.12u as=0.1406p ps=1.12u w=0.74u l=0.13u
X3702 VGND.t45 sg13cmos5l_inv_16_15.A sg13cmos5l_inv_16_13.Y VGND.t508 sg13_lv_nmos ad=0.1406p pd=1.12u as=0.1406p ps=1.12u w=0.74u l=0.13u
X3703 VGND.t52 VPWR.t2482 VGND.t52 VGND.t2092 sg13_lv_nmos ad=0.1428p pd=1.52u as=0 ps=0 w=0.42u l=1u
X3704 sg13cmos5l_inv_16_66.Y sg13cmos5l_inv_16_68.A VGND.t866 VGND.t875 sg13_lv_nmos ad=0.1406p pd=1.12u as=0.1406p ps=1.12u w=0.74u l=0.13u
X3705 VPWR.t108 VGND.t1970 VPWR.t107 VPWR.t25 sg13_lv_pmos ad=0.34p pd=2.68u as=0 ps=0 w=1u l=1u
X3706 VPWR.t429 VGND.t1539 VPWR.t428 VPWR.t177 sg13_lv_pmos ad=0.34p pd=2.68u as=0 ps=0 w=1u l=1u
X3707 VGND.t1507 sg13cmos5l_inv_16_94.A sg13cmos5l_inv_16_73.A VGND.t881 sg13_lv_nmos ad=0.1406p pd=1.12u as=0.1406p ps=1.12u w=0.74u l=0.13u
X3708 VPWR.t2156 sg13cmos5l_inv_16_79.A sg13cmos5l_inv_16_91.Y VPWR.t16 sg13_lv_pmos ad=0.2128p pd=1.5u as=0.2128p ps=1.5u w=1.12u l=0.13u
X3709 VGND.t1792 sg13cmos5l_inv_16_96.Y sg13cmos5l_inv_16_81.Y VGND.t380 sg13_lv_nmos ad=0.1406p pd=1.12u as=0.1406p ps=1.12u w=0.74u l=0.13u
X3710 VGND.t1026 sg13cmos5l_inv_16_81.Y sg13cmos5l_inv_16_79.A VGND.t881 sg13_lv_nmos ad=0.1406p pd=1.12u as=0.1406p ps=1.12u w=0.74u l=0.13u
X3711 VPWR.t180 VGND.t545 VPWR.t179 VPWR.t0 sg13_lv_pmos ad=0.34p pd=2.68u as=0 ps=0 w=1u l=1u
X3712 sg13cmos5l_inv_8_0.Y sg13cmos5l_inv_4_0.Y VPWR.t2182 VPWR.t177 sg13_lv_pmos ad=0.2184p pd=1.51u as=0.2128p ps=1.5u w=1.12u l=0.13u
X3713 VPWR.t1982 sg13cmos5l_inv_16_67.A sg13cmos5l_inv_16_67.Y VPWR.t16 sg13_lv_pmos ad=0.2128p pd=1.5u as=0.2128p ps=1.5u w=1.12u l=0.13u
X3714 VGND.t427 sg13cmos5l_inv_16_101.Y sg13cmos5l_inv_16_55.Y VGND.t380 sg13_lv_nmos ad=0.1406p pd=1.12u as=0.1406p ps=1.12u w=0.74u l=0.13u
X3715 sg13cmos5l_inv_8_4.Y sg13cmos5l_inv_4_5.Y VGND.t5 VGND.t1060 sg13_lv_nmos ad=0.1406p pd=1.12u as=0.1406p ps=1.12u w=0.74u l=0.13u
X3716 sg13cmos5l_inv_2_2.Y sg13cmos5l_inv_2_2.A VGND.t425 VGND.t424 sg13_lv_nmos ad=0.1406p pd=1.12u as=0.2516p ps=2.16u w=0.74u l=0.13u
X3717 VPWR.t246 sg13cmos5l_inv_16_6.A sg13cmos5l_inv_16_5.Y VPWR.t177 sg13_lv_pmos ad=0.2128p pd=1.5u as=0.2128p ps=1.5u w=1.12u l=0.13u
X3718 sg13cmos5l_inv_16_8.Y sg13cmos5l_inv_16_4.Y VGND.t291 VGND.t295 sg13_lv_nmos ad=0.1406p pd=1.12u as=0.1406p ps=1.12u w=0.74u l=0.13u
X3719 sg13cmos5l_inv_16_20.A sg13cmos5l_inv_16_8.Y VGND.t545 VGND.t546 sg13_lv_nmos ad=0.1406p pd=1.12u as=0.1406p ps=1.12u w=0.74u l=0.13u
X3720 sg13cmos5l_inv_16_67.A sg13cmos5l_inv_16_109.Y VGND.t1143 VGND.t881 sg13_lv_nmos ad=0.1406p pd=1.12u as=0.1406p ps=1.12u w=0.74u l=0.13u
X3721 sg13cmos5l_inv_16_58.Y sg13cmos5l_inv_16_69.Y VGND.t905 VGND.t914 sg13_lv_nmos ad=0.1406p pd=1.12u as=0.1406p ps=1.12u w=0.74u l=0.13u
X3722 VPWR.t237 VGND.t162 VPWR.t235 VPWR.t0 sg13_lv_pmos ad=0.19p pd=1.38u as=0 ps=0 w=1u l=1u
X3723 VGND.t963 sg13cmos5l_inv_16_71.Y sg13cmos5l_inv_16_61.A VGND.t881 sg13_lv_nmos ad=0.1406p pd=1.12u as=0.1406p ps=1.12u w=0.74u l=0.13u
X3724 sg13cmos5l_inv_16_75.A sg13cmos5l_inv_16_76.A VPWR.t2396 VPWR.t25 sg13_lv_pmos ad=0.2128p pd=1.5u as=0.2128p ps=1.5u w=1.12u l=0.13u
X3725 sg13cmos5l_inv_16_13.Y sg13cmos5l_inv_16_15.A VGND.t450 VGND.t505 sg13_lv_nmos ad=0.1406p pd=1.12u as=0.1406p ps=1.12u w=0.74u l=0.13u
X3726 sg13cmos5l_inv_16_6.Y sg13cmos5l_inv_16_6.A VGND.t862 VGND.t1403 sg13_lv_nmos ad=0.1406p pd=1.12u as=0.2516p ps=2.16u w=0.74u l=0.13u
X3727 sg13cmos5l_inv_16_2.Y sg13cmos5l_inv_16_2.A VPWR.t1830 VPWR.t177 sg13_lv_pmos ad=0.2128p pd=1.5u as=0.2128p ps=1.5u w=1.12u l=0.13u
X3728 sg13cmos5l_inv_16_81.Y sg13cmos5l_inv_16_96.Y VGND.t1792 VGND.t380 sg13_lv_nmos ad=0.1406p pd=1.12u as=0.2516p ps=2.16u w=0.74u l=0.13u
X3729 VPWR.t1422 sg13cmos5l_inv_16_87.A sg13cmos5l_inv_16_87.Y VPWR.t9 sg13_lv_pmos ad=0.2128p pd=1.5u as=0.2128p ps=1.5u w=1.12u l=0.13u
X3730 sg13cmos5l_inv_16_67.Y sg13cmos5l_inv_16_67.A VPWR.t1978 VPWR.t16 sg13_lv_pmos ad=0.2128p pd=1.5u as=0.2128p ps=1.5u w=1.12u l=0.13u
X3731 sg13cmos5l_inv_16_79.A sg13cmos5l_inv_16_81.Y VGND.t1026 VGND.t881 sg13_lv_nmos ad=0.1406p pd=1.12u as=0.2516p ps=2.16u w=0.74u l=0.13u
X3732 sg13cmos5l_inv_16_46.Y sg13cmos5l_inv_16_46.A VGND.t20 VGND.t1751 sg13_lv_nmos ad=0.1406p pd=1.12u as=0.1406p ps=1.12u w=0.74u l=0.13u
X3733 VPWR.t1066 sg13cmos5l_inv_16_5.Y sg13cmos5l_inv_16_110.Y VPWR.t4 sg13_lv_pmos ad=0.2128p pd=1.5u as=0.2128p ps=1.5u w=1.12u l=0.13u
X3734 VGND.t20 sg13cmos5l_inv_16_37.A sg13cmos5l_inv_16_102.Y VGND.t19 sg13_lv_nmos ad=0.1406p pd=1.12u as=0.1406p ps=1.12u w=0.74u l=0.13u
X3735 sg13cmos5l_inv_16_19.Y sg13cmos5l_inv_16_17.A VPWR.t527 VPWR.t177 sg13_lv_pmos ad=0.2128p pd=1.5u as=0.2128p ps=1.5u w=1.12u l=0.13u
X3736 sg13cmos5l_inv_16_5.Y sg13cmos5l_inv_16_6.A VPWR.t246 VPWR.t177 sg13_lv_pmos ad=0.2128p pd=1.5u as=0.2128p ps=1.5u w=1.12u l=0.13u
X3737 VPWR.t1282 sg13cmos5l_inv_16_68.A sg13cmos5l_inv_16_66.Y VPWR.t9 sg13_lv_pmos ad=0.2128p pd=1.5u as=0.2128p ps=1.5u w=1.12u l=0.13u
X3738 sg13cmos5l_inv_16_1.A sg13cmos5l_inv_16_0.A VPWR.t1264 VPWR.t177 sg13_lv_pmos ad=0.2128p pd=1.5u as=0.2128p ps=1.5u w=1.12u l=0.13u
X3739 VGND.t310 sg13cmos5l_inv_8_1.Y sg13cmos5l_inv_16_4.Y VGND.t1456 sg13_lv_nmos ad=0.1406p pd=1.12u as=0.1406p ps=1.12u w=0.74u l=0.13u
X3740 VPWR.t2136 sg13cmos5l_inv_16_46.A sg13cmos5l_inv_16_46.Y VPWR.t25 sg13_lv_pmos ad=0.2128p pd=1.5u as=0.2128p ps=1.5u w=1.12u l=0.13u
X3741 sg13cmos5l_inv_16_36.Y sg13cmos5l_inv_16_36.A VPWR.t580 VPWR.t4 sg13_lv_pmos ad=0.2128p pd=1.5u as=0.2128p ps=1.5u w=1.12u l=0.13u
X3742 sg13cmos5l_inv_16_61.A sg13cmos5l_inv_16_71.Y VGND.t963 VGND.t881 sg13_lv_nmos ad=0.1406p pd=1.12u as=0.1406p ps=1.12u w=0.74u l=0.13u
X3743 VPWR.t1902 sg13cmos5l_inv_16_94.A sg13cmos5l_inv_16_73.A VPWR.t9 sg13_lv_pmos ad=0.2128p pd=1.5u as=0.2128p ps=1.5u w=1.12u l=0.13u
X3744 sg13cmos5l_inv_16_53.A sg13cmos5l_inv_16_52.Y VPWR.t1760 VPWR.t16 sg13_lv_pmos ad=0.2128p pd=1.5u as=0.2128p ps=1.5u w=1.12u l=0.13u
X3745 a_25484_834# en[6] VPWR.t2010 VPWR.t177 sg13_lv_pmos ad=0.2856p pd=2.36u as=0.2114p ps=1.54u w=0.84u l=0.13u
X3746 sg13cmos5l_inv_16_37.Y sg13cmos5l_inv_16_37.A VPWR.t477 VPWR.t4 sg13_lv_pmos ad=0.2128p pd=1.5u as=0.2128p ps=1.5u w=1.12u l=0.13u
X3747 sg13cmos5l_inv_16_53.Y sg13cmos5l_inv_16_53.A VPWR.t2070 VPWR.t16 sg13_lv_pmos ad=0.2128p pd=1.5u as=0.2128p ps=1.5u w=1.12u l=0.13u
X3748 VPWR.t1601 sg13cmos5l_buf_1_12.X a_26445_9540# VPWR.t9 sg13_lv_pmos ad=0.1918p pd=1.5u as=0.1596p ps=1.22u w=0.84u l=0.13u
X3749 sg13cmos5l_inv_16_99.A sg13cmos5l_inv_16_34.Y VGND.t593 VGND.t607 sg13_lv_nmos ad=0.1406p pd=1.12u as=0.1406p ps=1.12u w=0.74u l=0.13u
X3750 sg13cmos5l_inv_8_4.Y sg13cmos5l_inv_4_5.Y VPWR.t1468 VPWR.t25 sg13_lv_pmos ad=0.2184p pd=1.51u as=0.2128p ps=1.5u w=1.12u l=0.13u
X3751 sg13cmos5l_inv_16_100.Y sg13cmos5l_inv_16_36.A VGND.t134 VGND.t137 sg13_lv_nmos ad=0.1406p pd=1.12u as=0.1406p ps=1.12u w=0.74u l=0.13u
X3752 VPWR.t1828 sg13cmos5l_inv_16_2.A sg13cmos5l_inv_16_2.Y VPWR.t177 sg13_lv_pmos ad=0.2128p pd=1.5u as=0.2128p ps=1.5u w=1.12u l=0.13u
X3753 sg13cmos5l_inv_16_44.A sg13cmos5l_inv_16_28.A VGND.t259 VGND.t272 sg13_lv_nmos ad=0.1406p pd=1.12u as=0.1406p ps=1.12u w=0.74u l=0.13u
X3754 sg13cmos5l_inv_16_69.Y sg13cmos5l_inv_16_52.Y VPWR.t1746 VPWR.t16 sg13_lv_pmos ad=0.2128p pd=1.5u as=0.2128p ps=1.5u w=1.12u l=0.13u
X3755 VGND.t953 VPWR.t2543 VGND.t953 VGND.t380 sg13_lv_nmos ad=0.1428p pd=1.52u as=0 ps=0 w=0.42u l=1u
X3756 sg13cmos5l_inv_16_74.Y sg13cmos5l_inv_16_75.A VPWR.t803 VPWR.t25 sg13_lv_pmos ad=0.2128p pd=1.5u as=0.3808p ps=2.92u w=1.12u l=0.13u
X3757 VGND.t45 sg13cmos5l_inv_16_14.A sg13cmos5l_inv_16_14.Y VGND.t488 sg13_lv_nmos ad=0.1406p pd=1.12u as=0.1406p ps=1.12u w=0.74u l=0.13u
X3758 sg13cmos5l_inv_16_87.Y sg13cmos5l_inv_16_87.A VPWR.t1418 VPWR.t9 sg13_lv_pmos ad=0.2128p pd=1.5u as=0.2128p ps=1.5u w=1.12u l=0.13u
X3759 VPWR.t1534 sg13cmos5l_inv_16_105.A sg13cmos5l_inv_16_105.Y VPWR.t0 sg13_lv_pmos ad=0.4368p pd=3.02u as=0.2128p ps=1.5u w=1.12u l=0.13u
X3760 VPWR.t246 sg13cmos5l_inv_16_6.A sg13cmos5l_inv_16_5.Y VPWR.t177 sg13_lv_pmos ad=0.2128p pd=1.5u as=0.2128p ps=1.5u w=1.12u l=0.13u
X3761 VGND.t723 VPWR.t2501 VGND.t723 VGND.t2059 sg13_lv_nmos ad=0.1428p pd=1.52u as=0 ps=0 w=0.42u l=1u
X3762 VPWR.t525 sg13cmos5l_inv_16_17.A sg13cmos5l_inv_16_19.Y VPWR.t177 sg13_lv_pmos ad=0.2128p pd=1.5u as=0.2128p ps=1.5u w=1.12u l=0.13u
X3763 sg13cmos5l_inv_16_93.Y sg13cmos5l_inv_16_87.A VGND.t994 VGND.t993 sg13_lv_nmos ad=0.1406p pd=1.12u as=0.2516p ps=2.16u w=0.74u l=0.13u
X3764 VPWR.t1262 sg13cmos5l_inv_16_0.A sg13cmos5l_inv_16_1.A VPWR.t177 sg13_lv_pmos ad=0.2128p pd=1.5u as=0.2128p ps=1.5u w=1.12u l=0.13u
X3765 VGND.t2045 VPWR.t2497 VGND.t217 VGND.t2046 sg13_lv_nmos ad=79.8f pd=0.8u as=0 ps=0 w=0.42u l=1u
X3766 sg13cmos5l_inv_16_4.Y sg13cmos5l_inv_8_1.Y VGND.t310 VGND.t1453 sg13_lv_nmos ad=0.1406p pd=1.12u as=0.1406p ps=1.12u w=0.74u l=0.13u
X3767 VGND.t953 VPWR.t2558 VGND.t953 VGND.t380 sg13_lv_nmos ad=79.8f pd=0.8u as=0 ps=0 w=0.42u l=1u
X3768 VGND.t198 sg13cmos5l_inv_16_26.Y sg13cmos5l_inv_16_40.Y VGND.t341 sg13_lv_nmos ad=0.2516p pd=2.16u as=0.1406p ps=1.12u w=0.74u l=0.13u
X3769 VPWR.t635 sg13cmos5l_inv_16_44.A sg13cmos5l_inv_16_44.Y VPWR.t4 sg13_lv_pmos ad=0.2128p pd=1.5u as=0.2128p ps=1.5u w=1.12u l=0.13u
X3770 sg13cmos5l_inv_16_73.A sg13cmos5l_inv_16_94.A VPWR.t1898 VPWR.t9 sg13_lv_pmos ad=0.2128p pd=1.5u as=0.2128p ps=1.5u w=1.12u l=0.13u
X3771 sg13cmos5l_inv_16_109.Y sg13cmos5l_inv_16_48.A VGND.t1147 VGND.t881 sg13_lv_nmos ad=0.1406p pd=1.12u as=0.1406p ps=1.12u w=0.74u l=0.13u
X3772 VPWR.t475 sg13cmos5l_inv_16_37.A sg13cmos5l_inv_16_37.Y VPWR.t4 sg13_lv_pmos ad=0.2128p pd=1.5u as=0.2128p ps=1.5u w=1.12u l=0.13u
X3773 VPWR.t1466 sg13cmos5l_inv_4_5.Y sg13cmos5l_inv_8_4.Y VPWR.t25 sg13_lv_pmos ad=0.2128p pd=1.5u as=0.2128p ps=1.5u w=1.12u l=0.13u
X3774 VGND.t259 sg13cmos5l_inv_16_28.A sg13cmos5l_inv_16_44.A VGND.t269 sg13_lv_nmos ad=0.1406p pd=1.12u as=0.1406p ps=1.12u w=0.74u l=0.13u
X3775 VPWR.t1744 sg13cmos5l_inv_16_52.Y sg13cmos5l_inv_16_69.Y VPWR.t16 sg13_lv_pmos ad=0.2128p pd=1.5u as=0.2128p ps=1.5u w=1.12u l=0.13u
X3776 VPWR.t2385 sg13cmos5l_inv_16_76.A sg13cmos5l_inv_16_77.A VPWR.t16 sg13_lv_pmos ad=0.2128p pd=1.5u as=0.2128p ps=1.5u w=1.12u l=0.13u
X3777 VGND.t1166 sg13cmos5l_inv_16_61.A sg13cmos5l_inv_16_59.Y VGND.t1173 sg13_lv_nmos ad=0.1406p pd=1.12u as=0.1406p ps=1.12u w=0.74u l=0.13u
X3778 VGND.t1245 sg13cmos5l_inv_16_27.Y sg13cmos5l_inv_16_26.A VGND.t1274 sg13_lv_nmos ad=0.1406p pd=1.12u as=0.1406p ps=1.12u w=0.74u l=0.13u
X3779 sg13cmos5l_inv_16_14.Y sg13cmos5l_inv_16_14.A VGND.t45 VGND.t485 sg13_lv_nmos ad=0.1406p pd=1.12u as=0.2516p ps=2.16u w=0.74u l=0.13u
X3780 VPWR.t2233 sg13cmos5l_inv_16_96.Y sg13cmos5l_inv_16_81.Y VPWR.t16 sg13_lv_pmos ad=0.2128p pd=1.5u as=0.2128p ps=1.5u w=1.12u l=0.13u
X3781 sg13cmos5l_inv_16_105.Y sg13cmos5l_inv_16_105.A VPWR.t1530 VPWR.t0 sg13_lv_pmos ad=0.2128p pd=1.5u as=0.2128p ps=1.5u w=1.12u l=0.13u
X3782 sg13cmos5l_inv_16_29.A sg13cmos5l_inv_16_28.A VPWR.t707 VPWR.t177 sg13_lv_pmos ad=0.2128p pd=1.5u as=0.2128p ps=1.5u w=1.12u l=0.13u
X3783 VGND.t1553 sg13cmos5l_inv_16_111.A sg13cmos5l_inv_16_98.Y VGND.t1555 sg13_lv_nmos ad=0.1406p pd=1.12u as=0.1406p ps=1.12u w=0.74u l=0.13u
X3784 VPWR.t1278 sg13cmos5l_inv_16_68.A sg13cmos5l_inv_16_66.Y VPWR.t9 sg13_lv_pmos ad=0.2128p pd=1.5u as=0.2128p ps=1.5u w=1.12u l=0.13u
X3785 sg13cmos5l_inv_16_40.Y sg13cmos5l_inv_16_26.Y VGND.t326 VGND.t338 sg13_lv_nmos ad=0.1406p pd=1.12u as=0.1406p ps=1.12u w=0.74u l=0.13u
X3786 sg13cmos5l_inv_16_84.Y sg13cmos5l_inv_16_84.A VGND.t1026 VGND.t881 sg13_lv_nmos ad=0.1406p pd=1.12u as=0.1406p ps=1.12u w=0.74u l=0.13u
X3787 VPWR.t1896 sg13cmos5l_inv_16_94.A sg13cmos5l_inv_16_73.A VPWR.t9 sg13_lv_pmos ad=0.2128p pd=1.5u as=0.2128p ps=1.5u w=1.12u l=0.13u
X3788 VPWR.t423 VGND.t450 VPWR.t421 VPWR.t4 sg13_lv_pmos ad=0.19p pd=1.38u as=0 ps=0 w=1u l=1u
X3789 sg13cmos5l_inv_16_37.Y sg13cmos5l_inv_16_37.A VPWR.t471 VPWR.t4 sg13_lv_pmos ad=0.2128p pd=1.5u as=0.2128p ps=1.5u w=1.12u l=0.13u
X3790 sg13cmos5l_inv_16_11.A sg13cmos5l_inv_16_96.Y VPWR.t2242 VPWR.t25 sg13_lv_pmos ad=0.2128p pd=1.5u as=0.2128p ps=1.5u w=1.12u l=0.13u
X3791 sg13cmos5l_inv_8_4.Y sg13cmos5l_inv_4_5.Y VPWR.t1463 VPWR.t25 sg13_lv_pmos ad=0.2128p pd=1.5u as=0.3808p ps=2.92u w=1.12u l=0.13u
X3792 sg13cmos5l_inv_16_84.A sg13cmos5l_inv_16_81.Y VGND.t1029 VGND.t881 sg13_lv_nmos ad=0.1406p pd=1.12u as=0.1406p ps=1.12u w=0.74u l=0.13u
X3793 VGND.t723 sg13cmos5l_inv_16_9.A sg13cmos5l_inv_16_9.Y VGND.t726 sg13_lv_nmos ad=0.1406p pd=1.12u as=0.1406p ps=1.12u w=0.74u l=0.13u
X3794 VGND.t3 VPWR.t2494 VGND.t3 VGND.t2071 sg13_lv_nmos ad=79.8f pd=0.8u as=0 ps=0 w=0.42u l=1u
X3795 VGND.t1143 sg13cmos5l_inv_16_67.A sg13cmos5l_inv_16_67.Y VGND.t881 sg13_lv_nmos ad=0.1406p pd=1.12u as=0.1406p ps=1.12u w=0.74u l=0.13u
X3796 sg13cmos5l_inv_16_77.A sg13cmos5l_inv_16_76.A VPWR.t2381 VPWR.t16 sg13_lv_pmos ad=0.2128p pd=1.5u as=0.2128p ps=1.5u w=1.12u l=0.13u
X3797 VGND.t390 VPWR.t2555 VGND.t390 VGND.t380 sg13_lv_nmos ad=79.8f pd=0.8u as=0 ps=0 w=0.42u l=1u
X3798 sg13cmos5l_inv_16_100.Y sg13cmos5l_inv_16_36.A VGND.t20 VGND.t132 sg13_lv_nmos ad=0.1406p pd=1.12u as=0.1406p ps=1.12u w=0.74u l=0.13u
X3799 VGND.t425 sg13cmos5l_inv_2_2.A sg13cmos5l_inv_2_2.Y VGND.t426 sg13_lv_nmos ad=0.2516p pd=2.16u as=0.1406p ps=1.12u w=0.74u l=0.13u
X3800 sg13cmos5l_inv_16_62.Y sg13cmos5l_inv_16_69.Y VPWR.t1327 VPWR.t9 sg13_lv_pmos ad=0.2128p pd=1.5u as=0.3808p ps=2.92u w=1.12u l=0.13u
X3801 VPWR.t1044 sg13cmos5l_inv_16_34.Y sg13cmos5l_inv_16_101.Y VPWR.t0 sg13_lv_pmos ad=0.2128p pd=1.5u as=0.2128p ps=1.5u w=1.12u l=0.13u
X3802 sg13cmos5l_inv_16_26.A sg13cmos5l_inv_16_27.Y VGND.t1243 VGND.t1271 sg13_lv_nmos ad=0.1406p pd=1.12u as=0.1406p ps=1.12u w=0.74u l=0.13u
X3803 sg13cmos5l_inv_16_65.Y sg13cmos5l_inv_16_67.A VPWR.t1961 VPWR.t9 sg13_lv_pmos ad=0.2128p pd=1.5u as=0.3808p ps=2.92u w=1.12u l=0.13u
X3804 sg13cmos5l_inv_16_71.Y sg13cmos5l_inv_16_56.Y VGND.t963 VGND.t881 sg13_lv_nmos ad=0.1406p pd=1.12u as=0.1406p ps=1.12u w=0.74u l=0.13u
X3805 sg13cmos5l_inv_16_81.Y sg13cmos5l_inv_16_96.Y VPWR.t2229 VPWR.t16 sg13_lv_pmos ad=0.2128p pd=1.5u as=0.2128p ps=1.5u w=1.12u l=0.13u
X3806 VGND.t432 sg13cmos5l_inv_2_6.Y sg13cmos5l_inv_4_4.Y VGND.t539 sg13_lv_nmos ad=0.2516p pd=2.16u as=0.1406p ps=1.12u w=0.74u l=0.13u
X3807 VPWR.t596 sg13cmos5l_inv_16_43.Y sg13cmos5l_inv_16_37.A VPWR.t0 sg13_lv_pmos ad=0.2128p pd=1.5u as=0.2128p ps=1.5u w=1.12u l=0.13u
X3808 VPWR.t247 VGND.t2117 VPWR.t443 VPWR.t4 sg13_lv_pmos ad=0.34p pd=2.68u as=0 ps=0 w=1u l=1u
X3809 VGND.t45 sg13cmos5l_inv_16_15.A sg13cmos5l_inv_16_15.Y VGND.t508 sg13_lv_nmos ad=0.1406p pd=1.12u as=0.1406p ps=1.12u w=0.74u l=0.13u
X3810 VGND.t1779 VPWR.t2561 VGND.t1779 VGND.t380 sg13_lv_nmos ad=0.1428p pd=1.52u as=0 ps=0 w=0.42u l=1u
X3811 VPWR.t1030 sg13cmos5l_inv_16_34.Y sg13cmos5l_inv_16_99.A VPWR.t25 sg13_lv_pmos ad=0.4368p pd=3.02u as=0.2128p ps=1.5u w=1.12u l=0.13u
X3812 VGND.t196 VPWR.t2490 VGND.t723 VGND.t2079 sg13_lv_nmos ad=79.8f pd=0.8u as=0 ps=0 w=0.42u l=1u
X3813 sg13cmos5l_inv_16_23.Y sg13cmos5l_inv_16_0.A VPWR.t1252 VPWR.t4 sg13_lv_pmos ad=0.2128p pd=1.5u as=0.2128p ps=1.5u w=1.12u l=0.13u
X3814 VGND.t827 sg13cmos5l_inv_8_0.Y sg13cmos5l_inv_16_0.A VGND.t2318 sg13_lv_nmos ad=0.1406p pd=1.12u as=0.1406p ps=1.12u w=0.74u l=0.13u
X3815 VPWR.t245 VGND.t637 VPWR.t244 VPWR.t4 sg13_lv_pmos ad=0.34p pd=2.68u as=0 ps=0 w=1u l=1u
X3816 VPWR.t2240 sg13cmos5l_inv_16_96.Y sg13cmos5l_inv_16_11.A VPWR.t25 sg13_lv_pmos ad=0.2128p pd=1.5u as=0.2128p ps=1.5u w=1.12u l=0.13u
X3817 VGND.t1029 sg13cmos5l_inv_16_73.Y sg13cmos5l_inv_16_90.Y VGND.t881 sg13_lv_nmos ad=0.1406p pd=1.12u as=0.1406p ps=1.12u w=0.74u l=0.13u
X3818 VGND.t20 sg13cmos5l_inv_16_36.A sg13cmos5l_inv_16_100.Y VGND.t129 sg13_lv_nmos ad=0.1406p pd=1.12u as=0.1406p ps=1.12u w=0.74u l=0.13u
X3819 sg13cmos5l_inv_16_31.Y sg13cmos5l_inv_16_30.A VGND.t39 VGND.t1281 sg13_lv_nmos ad=0.1406p pd=1.12u as=0.1406p ps=1.12u w=0.74u l=0.13u
X3820 VGND.t15 sg13cmos5l_inv_16_37.A sg13cmos5l_inv_16_102.Y VGND.t14 sg13_lv_nmos ad=0.1406p pd=1.12u as=0.1406p ps=1.12u w=0.74u l=0.13u
X3821 sg13cmos5l_inv_16_20.A sg13cmos5l_inv_16_8.Y VPWR.t978 VPWR.t0 sg13_lv_pmos ad=0.2128p pd=1.5u as=0.2128p ps=1.5u w=1.12u l=0.13u
X3822 sg13cmos5l_inv_16_37.A sg13cmos5l_inv_16_43.Y VPWR.t592 VPWR.t0 sg13_lv_pmos ad=0.2128p pd=1.5u as=0.2128p ps=1.5u w=1.12u l=0.13u
X3823 sg13cmos5l_inv_16_15.Y sg13cmos5l_inv_16_15.A VGND.t450 VGND.t505 sg13_lv_nmos ad=0.1406p pd=1.12u as=0.1406p ps=1.12u w=0.74u l=0.13u
X3824 VGND.t905 sg13cmos5l_inv_16_69.Y sg13cmos5l_inv_16_58.Y VGND.t907 sg13_lv_nmos ad=0.1406p pd=1.12u as=0.1406p ps=1.12u w=0.74u l=0.13u
X3825 VPWR.t2132 sg13cmos5l_inv_16_46.A sg13cmos5l_inv_16_46.Y VPWR.t25 sg13_lv_pmos ad=0.2128p pd=1.5u as=0.2128p ps=1.5u w=1.12u l=0.13u
X3826 sg13cmos5l_inv_16_61.A sg13cmos5l_inv_16_71.Y VGND.t963 VGND.t881 sg13_lv_nmos ad=0.1406p pd=1.12u as=0.1406p ps=1.12u w=0.74u l=0.13u
X3827 sg13cmos5l_inv_16_73.Y sg13cmos5l_inv_16_73.A VPWR.t1879 VPWR.t16 sg13_lv_pmos ad=0.2128p pd=1.5u as=0.2128p ps=1.5u w=1.12u l=0.13u
X3828 VPWR.t1250 sg13cmos5l_inv_16_0.A sg13cmos5l_inv_16_23.Y VPWR.t4 sg13_lv_pmos ad=0.2128p pd=1.5u as=0.2128p ps=1.5u w=1.12u l=0.13u
X3829 sg13cmos5l_inv_16_84.Y sg13cmos5l_inv_16_84.A VGND.t1026 VGND.t881 sg13_lv_nmos ad=0.1406p pd=1.12u as=0.1406p ps=1.12u w=0.74u l=0.13u
X3830 VGND.t1029 sg13cmos5l_inv_16_81.Y sg13cmos5l_inv_16_79.A VGND.t881 sg13_lv_nmos ad=0.2516p pd=2.16u as=0.1406p ps=1.12u w=0.74u l=0.13u
X3831 VGND.t953 sg13cmos5l_inv_16_96.Y sg13cmos5l_inv_16_81.Y VGND.t380 sg13_lv_nmos ad=0.2516p pd=2.16u as=0.1406p ps=1.12u w=0.74u l=0.13u
X3832 VGND.t773 sg13cmos5l_inv_16_99.A sg13cmos5l_inv_16_99.Y VGND.t783 sg13_lv_nmos ad=0.1406p pd=1.12u as=0.1406p ps=1.12u w=0.74u l=0.13u
X3833 VPWR.t2423 VGND.t1178 VPWR.t2422 VPWR.t9 sg13_lv_pmos ad=0.34p pd=2.68u as=0 ps=0 w=1u l=1u
X3834 VPWR.t1494 sg13cmos5l_inv_16_84.A sg13cmos5l_inv_16_84.Y VPWR.t9 sg13_lv_pmos ad=0.2128p pd=1.5u as=0.2128p ps=1.5u w=1.12u l=0.13u
X3835 VGND.t146 sg13cmos5l_inv_16_43.Y sg13cmos5l_inv_16_36.A VGND.t180 sg13_lv_nmos ad=0.1406p pd=1.12u as=0.1406p ps=1.12u w=0.74u l=0.13u
X3836 VGND.t534 en[1] a_4744_908# VGND.t1806 sg13_lv_nmos ad=0.14875p pd=1.16u as=0.187p ps=1.78u w=0.55u l=0.13u
X3837 VPWR.t1849 sg13cmos5l_inv_8_1.Y sg13cmos5l_inv_16_4.Y VPWR.t177 sg13_lv_pmos ad=0.2128p pd=1.5u as=0.2128p ps=1.5u w=1.12u l=0.13u
X3838 VPWR.t590 sg13cmos5l_inv_16_43.Y sg13cmos5l_inv_16_37.A VPWR.t0 sg13_lv_pmos ad=0.2128p pd=1.5u as=0.2128p ps=1.5u w=1.12u l=0.13u
X3839 VGND.t101 sg13cmos5l_inv_16_17.A sg13cmos5l_inv_16_19.Y VGND.t100 sg13_lv_nmos ad=0.1406p pd=1.12u as=0.1406p ps=1.12u w=0.74u l=0.13u
X3840 VGND.t308 sg13cmos5l_inv_16_6.A sg13cmos5l_inv_16_5.Y VGND.t1400 sg13_lv_nmos ad=0.1406p pd=1.12u as=0.1406p ps=1.12u w=0.74u l=0.13u
X3841 VGND.t2111 VPWR.t2473 VGND.t255 VGND.t2110 sg13_lv_nmos ad=0.1428p pd=1.52u as=0 ps=0 w=0.42u l=1u
X3842 VPWR.t139 VGND.t2012 VPWR.t138 VPWR.t0 sg13_lv_pmos ad=0.19p pd=1.38u as=0 ps=0 w=1u l=1u
X3843 VPWR.t1238 sg13cmos5l_inv_8_3.Y sg13cmos5l_inv_16_41.A VPWR.t4 sg13_lv_pmos ad=0.2128p pd=1.5u as=0.2128p ps=1.5u w=1.12u l=0.13u
X3844 VPWR.t1516 sg13cmos5l_inv_16_105.A sg13cmos5l_inv_16_80.Y VPWR.t25 sg13_lv_pmos ad=0.2128p pd=1.5u as=0.2128p ps=1.5u w=1.12u l=0.13u
X3845 sg13cmos5l_inv_16_22.Y sg13cmos5l_inv_16_20.A VPWR.t878 VPWR.t0 sg13_lv_pmos ad=0.2128p pd=1.5u as=0.2128p ps=1.5u w=1.12u l=0.13u
X3846 VGND.t827 sg13cmos5l_inv_16_0.A sg13cmos5l_inv_16_1.A VGND.t859 sg13_lv_nmos ad=0.2516p pd=2.16u as=0.1406p ps=1.12u w=0.74u l=0.13u
X3847 sg13cmos5l_inv_16_87.A sg13cmos5l_inv_16_73.A VPWR.t1867 VPWR.t9 sg13_lv_pmos ad=0.2128p pd=1.5u as=0.2128p ps=1.5u w=1.12u l=0.13u
X3848 sg13cmos5l_inv_16_35.Y sg13cmos5l_inv_16_29.A VPWR.t1110 VPWR.t0 sg13_lv_pmos ad=0.2128p pd=1.5u as=0.2128p ps=1.5u w=1.12u l=0.13u
X3849 VGND.t1164 sg13cmos5l_inv_16_52.Y sg13cmos5l_inv_16_53.A VGND.t881 sg13_lv_nmos ad=0.1406p pd=1.12u as=0.1406p ps=1.12u w=0.74u l=0.13u
X3850 VPWR.t1877 sg13cmos5l_inv_16_73.A sg13cmos5l_inv_16_73.Y VPWR.t16 sg13_lv_pmos ad=0.2128p pd=1.5u as=0.2128p ps=1.5u w=1.12u l=0.13u
X3851 VGND.t353 VPWR.t2517 VGND.t353 VGND.t2009 sg13_lv_nmos ad=0.1428p pd=1.52u as=0 ps=0 w=0.42u l=1u
X3852 sg13cmos5l_inv_16_37.A sg13cmos5l_inv_16_43.Y VGND.t146 VGND.t177 sg13_lv_nmos ad=0.1406p pd=1.12u as=0.1406p ps=1.12u w=0.74u l=0.13u
X3853 sg13cmos5l_inv_16_30.Y sg13cmos5l_inv_16_30.A VGND.t343 VGND.t1278 sg13_lv_nmos ad=0.1406p pd=1.12u as=0.2516p ps=2.16u w=0.74u l=0.13u
X3854 VPWR.t2215 sg13cmos5l_inv_16_73.Y sg13cmos5l_inv_16_95.Y VPWR.t16 sg13_lv_pmos ad=0.2128p pd=1.5u as=0.2128p ps=1.5u w=1.12u l=0.13u
X3855 VGND.t5 sg13cmos5l_inv_16_47.A sg13cmos5l_inv_16_47.Y VGND.t2219 sg13_lv_nmos ad=0.1406p pd=1.12u as=0.1406p ps=1.12u w=0.74u l=0.13u
X3856 sg13cmos5l_inv_16_99.Y sg13cmos5l_inv_16_99.A VGND.t773 VGND.t780 sg13_lv_nmos ad=0.1406p pd=1.12u as=0.1406p ps=1.12u w=0.74u l=0.13u
X3857 VGND.t1166 sg13cmos5l_inv_16_61.A sg13cmos5l_inv_16_59.Y VGND.t1169 sg13_lv_nmos ad=0.1406p pd=1.12u as=0.1406p ps=1.12u w=0.74u l=0.13u
X3858 VPWR.t1548 sg13cmos5l_inv_16_109.Y sg13cmos5l_inv_16_67.A VPWR.t9 sg13_lv_pmos ad=0.2128p pd=1.5u as=0.2128p ps=1.5u w=1.12u l=0.13u
X3859 VGND.t922 sg13cmos5l_inv_16_52.Y sg13cmos5l_inv_16_69.Y VGND.t881 sg13_lv_nmos ad=0.2516p pd=2.16u as=0.1406p ps=1.12u w=0.74u l=0.13u
X3860 sg13cmos5l_inv_16_50.Y sg13cmos5l_inv_16_46.Y VPWR.t2281 VPWR.t25 sg13_lv_pmos ad=0.2128p pd=1.5u as=0.2128p ps=1.5u w=1.12u l=0.13u
X3861 sg13cmos5l_inv_16_48.A sg13cmos5l_inv_8_7.Y VGND.t756 VGND.t380 sg13_lv_nmos ad=0.1406p pd=1.12u as=0.1406p ps=1.12u w=0.74u l=0.13u
X3862 VPWR.t618 sg13cmos5l_inv_16_43.Y sg13cmos5l_inv_16_36.A VPWR.t0 sg13_lv_pmos ad=0.2128p pd=1.5u as=0.2128p ps=1.5u w=1.12u l=0.13u
X3863 sg13cmos5l_inv_16_79.Y sg13cmos5l_inv_16_79.A VPWR.t2159 VPWR.t16 sg13_lv_pmos ad=0.2128p pd=1.5u as=0.3808p ps=2.92u w=1.12u l=0.13u
X3864 VPWR.t992 sg13cmos5l_inv_16_8.Y sg13cmos5l_inv_16_9.A VPWR.t0 sg13_lv_pmos ad=0.2128p pd=1.5u as=0.2128p ps=1.5u w=1.12u l=0.13u
X3865 sg13cmos5l_and2_1_3.B a_2920_2420# VPWR.t520 VPWR.t4 sg13_lv_pmos ad=0.42p pd=2.99u as=0.2114p ps=1.54u w=1.12u l=0.13u
X3866 sg13cmos5l_inv_16_76.A sg13cmos5l_inv_16_94.A VGND.t1507 VGND.t881 sg13_lv_nmos ad=0.1406p pd=1.12u as=0.1406p ps=1.12u w=0.74u l=0.13u
X3867 VPWR.t417 VGND.t450 VPWR.t415 VPWR.t0 sg13_lv_pmos ad=0.19p pd=1.38u as=0 ps=0 w=1u l=1u
X3868 sg13cmos5l_inv_16_4.Y sg13cmos5l_inv_8_1.Y VPWR.t1845 VPWR.t177 sg13_lv_pmos ad=0.2128p pd=1.5u as=0.2128p ps=1.5u w=1.12u l=0.13u
X3869 VGND.t381 sg13cmos5l_inv_16_73.A sg13cmos5l_inv_16_73.Y VGND.t380 sg13_lv_nmos ad=0.2516p pd=2.16u as=0.1406p ps=1.12u w=0.74u l=0.13u
X3870 VPWR.t697 sg13cmos5l_inv_16_28.A sg13cmos5l_inv_16_44.A VPWR.t4 sg13_lv_pmos ad=0.2128p pd=1.5u as=0.2128p ps=1.5u w=1.12u l=0.13u
X3871 sg13cmos5l_inv_16_62.Y sg13cmos5l_inv_16_69.Y VGND.t922 VGND.t881 sg13_lv_nmos ad=0.1406p pd=1.12u as=0.1406p ps=1.12u w=0.74u l=0.13u
X3872 VGND.t1944 sg13cmos5l_inv_8_4.Y sg13cmos5l_inv_16_56.Y VGND.t380 sg13_lv_nmos ad=0.1406p pd=1.12u as=0.1406p ps=1.12u w=0.74u l=0.13u
X3873 sg13cmos5l_inv_16_80.Y sg13cmos5l_inv_16_105.A VPWR.t1512 VPWR.t25 sg13_lv_pmos ad=0.2128p pd=1.5u as=0.2128p ps=1.5u w=1.12u l=0.13u
X3874 VPWR.t876 sg13cmos5l_inv_16_20.A sg13cmos5l_inv_16_22.Y VPWR.t0 sg13_lv_pmos ad=0.2128p pd=1.5u as=0.2128p ps=1.5u w=1.12u l=0.13u
X3875 VGND.t705 sg13cmos5l_inv_16_29.A sg13cmos5l_inv_16_29.Y VGND.t718 sg13_lv_nmos ad=0.1406p pd=1.12u as=0.1406p ps=1.12u w=0.74u l=0.13u
X3876 VPWR.t360 VGND.t1792 VPWR.t358 VPWR.t25 sg13_lv_pmos ad=0.19p pd=1.38u as=0 ps=0 w=1u l=1u
X3877 VPWR.t1108 sg13cmos5l_inv_16_29.A sg13cmos5l_inv_16_35.Y VPWR.t0 sg13_lv_pmos ad=0.2128p pd=1.5u as=0.2128p ps=1.5u w=1.12u l=0.13u
X3878 VPWR.t498 sg13cmos5l_inv_16_23.Y sg13cmos5l_inv_16_15.A VPWR.t0 sg13_lv_pmos ad=0.2128p pd=1.5u as=0.2128p ps=1.5u w=1.12u l=0.13u
X3879 VGND.t635 VPWR.t233 VGND.t635 VGND.t2126 sg13_lv_nmos ad=0.1428p pd=1.52u as=0 ps=0 w=0.42u l=1u
X3880 sg13cmos5l_inv_16_20.Y sg13cmos5l_inv_16_20.A VGND.t375 VGND.t456 sg13_lv_nmos ad=0.1406p pd=1.12u as=0.1406p ps=1.12u w=0.74u l=0.13u
X3881 VGND.t146 sg13cmos5l_inv_16_43.Y sg13cmos5l_inv_16_37.A VGND.t174 sg13_lv_nmos ad=0.1406p pd=1.12u as=0.1406p ps=1.12u w=0.74u l=0.13u
X3882 sg13cmos5l_inv_16_95.Y sg13cmos5l_inv_16_73.Y VPWR.t2211 VPWR.t16 sg13_lv_pmos ad=0.2128p pd=1.5u as=0.2128p ps=1.5u w=1.12u l=0.13u
X3883 VPWR.t2279 sg13cmos5l_inv_16_46.Y sg13cmos5l_inv_16_50.Y VPWR.t25 sg13_lv_pmos ad=0.2128p pd=1.5u as=0.2128p ps=1.5u w=1.12u l=0.13u
X3884 sg13cmos5l_inv_16_47.Y sg13cmos5l_inv_16_47.A VGND.t5 VGND.t2216 sg13_lv_nmos ad=0.1406p pd=1.12u as=0.1406p ps=1.12u w=0.74u l=0.13u
X3885 sg13cmos5l_inv_16_59.Y sg13cmos5l_inv_16_61.A VGND.t1166 VGND.t1165 sg13_lv_nmos ad=0.1406p pd=1.12u as=0.2516p ps=2.16u w=0.74u l=0.13u
X3886 sg13cmos5l_inv_16_29.Y sg13cmos5l_inv_16_29.A VGND.t705 VGND.t713 sg13_lv_nmos ad=0.1406p pd=1.12u as=0.1406p ps=1.12u w=0.74u l=0.13u
X3887 VGND.t1715 sg13cmos5l_inv_16_46.A sg13cmos5l_inv_16_47.A VGND.t380 sg13_lv_nmos ad=0.1406p pd=1.12u as=0.1406p ps=1.12u w=0.74u l=0.13u
X3888 VPWR.t137 VGND.t2012 VPWR.t136 VPWR.t25 sg13_lv_pmos ad=0.19p pd=1.38u as=0 ps=0 w=1u l=1u
X3889 sg13cmos5l_inv_16_9.A sg13cmos5l_inv_16_8.Y VPWR.t988 VPWR.t0 sg13_lv_pmos ad=0.2128p pd=1.5u as=0.2128p ps=1.5u w=1.12u l=0.13u
X3890 VPWR.t1373 sg13cmos5l_inv_16_71.Y sg13cmos5l_inv_16_61.A VPWR.t9 sg13_lv_pmos ad=0.2128p pd=1.5u as=0.2128p ps=1.5u w=1.12u l=0.13u
X3891 a_23648_4915# sg13cmos5l_and2_1_7.B VPWR.t554 VPWR.t0 sg13_lv_pmos ad=0.1596p pd=1.22u as=0.1918p ps=1.5u w=0.84u l=0.13u
X3892 VGND.t370 VPWR.t2487 VGND.t375 VGND.t2084 sg13_lv_nmos ad=79.8f pd=0.8u as=0 ps=0 w=0.42u l=1u
X3893 VPWR.t263 VGND.t1553 VPWR.t262 VPWR.t9 sg13_lv_pmos ad=0.34p pd=2.68u as=0 ps=0 w=1u l=1u
X3894 VGND.t953 sg13cmos5l_inv_4_6.Y sg13cmos5l_inv_16_96.A VGND.t380 sg13_lv_nmos ad=0.2516p pd=2.16u as=0.1406p ps=1.12u w=0.74u l=0.13u
X3895 sg13cmos5l_inv_16_44.A sg13cmos5l_inv_16_28.A VPWR.t693 VPWR.t4 sg13_lv_pmos ad=0.2128p pd=1.5u as=0.2128p ps=1.5u w=1.12u l=0.13u
X3896 VPWR.t1490 sg13cmos5l_inv_16_84.A sg13cmos5l_inv_16_84.Y VPWR.t9 sg13_lv_pmos ad=0.2128p pd=1.5u as=0.2128p ps=1.5u w=1.12u l=0.13u
X3897 VPWR.t1026 sg13cmos5l_inv_16_34.Y sg13cmos5l_inv_16_99.A VPWR.t25 sg13_lv_pmos ad=0.2128p pd=1.5u as=0.2128p ps=1.5u w=1.12u l=0.13u
X3898 VGND.t609 VPWR.t2527 VGND.t5 VGND.t2000 sg13_lv_nmos ad=79.8f pd=0.8u as=0 ps=0 w=0.42u l=1u
X3899 sg13cmos5l_inv_8_3.Y sg13cmos5l_inv_4_2.Y VPWR.t1637 VPWR.t4 sg13_lv_pmos ad=0.2184p pd=1.51u as=0.2128p ps=1.5u w=1.12u l=0.13u
X3900 VGND.t472 sg13cmos5l_inv_16_77.A sg13cmos5l_inv_16_77.Y VGND.t2171 sg13_lv_nmos ad=0.1406p pd=1.12u as=0.1406p ps=1.12u w=0.74u l=0.13u
X3901 sg13cmos5l_inv_16_15.A sg13cmos5l_inv_16_23.Y VPWR.t494 VPWR.t0 sg13_lv_pmos ad=0.2128p pd=1.5u as=0.2128p ps=1.5u w=1.12u l=0.13u
X3902 VGND.t1779 sg13cmos5l_inv_16_79.A sg13cmos5l_inv_16_79.Y VGND.t380 sg13_lv_nmos ad=0.1406p pd=1.12u as=0.1406p ps=1.12u w=0.74u l=0.13u
X3903 VPWR.t427 VGND.t450 VPWR.t425 VPWR.t4 sg13_lv_pmos ad=0.19p pd=1.38u as=0 ps=0 w=1u l=1u
X3904 sg13cmos5l_inv_16_98.Y sg13cmos5l_inv_16_111.A VPWR.t1929 VPWR.t9 sg13_lv_pmos ad=0.2128p pd=1.5u as=0.2128p ps=1.5u w=1.12u l=0.13u
X3905 VGND.t1029 sg13cmos5l_inv_16_81.Y sg13cmos5l_inv_16_84.A VGND.t881 sg13_lv_nmos ad=0.1406p pd=1.12u as=0.1406p ps=1.12u w=0.74u l=0.13u
X3906 VGND.t1029 sg13cmos5l_inv_16_73.Y sg13cmos5l_inv_16_90.Y VGND.t881 sg13_lv_nmos ad=0.1406p pd=1.12u as=0.1406p ps=1.12u w=0.74u l=0.13u
X3907 VPWR.t2209 sg13cmos5l_inv_16_73.Y sg13cmos5l_inv_16_95.Y VPWR.t16 sg13_lv_pmos ad=0.2128p pd=1.5u as=0.2128p ps=1.5u w=1.12u l=0.13u
X3908 VGND.t450 VPWR.t2499 VGND.t450 VGND.t2062 sg13_lv_nmos ad=0.1428p pd=1.52u as=0 ps=0 w=0.42u l=1u
X3909 sg13cmos5l_inv_16_71.Y sg13cmos5l_inv_16_56.Y VPWR.t2034 VPWR.t16 sg13_lv_pmos ad=0.2128p pd=1.5u as=0.2128p ps=1.5u w=1.12u l=0.13u
X3910 sg13cmos5l_inv_16_20.A sg13cmos5l_inv_16_8.Y VPWR.t974 VPWR.t0 sg13_lv_pmos ad=0.2128p pd=1.5u as=0.2128p ps=1.5u w=1.12u l=0.13u
X3911 VPWR.t931 sg13cmos5l_inv_16_15.A sg13cmos5l_inv_16_13.Y VPWR.t0 sg13_lv_pmos ad=0.2128p pd=1.5u as=0.2128p ps=1.5u w=1.12u l=0.13u
X3912 sg13cmos5l_inv_16_41.A sg13cmos5l_inv_8_3.Y VGND.t217 VGND.t810 sg13_lv_nmos ad=0.1406p pd=1.12u as=0.2516p ps=2.16u w=0.74u l=0.13u
X3913 sg13cmos5l_inv_16_96.A sg13cmos5l_inv_4_6.Y VGND.t953 VGND.t380 sg13_lv_nmos ad=0.1406p pd=1.12u as=0.1406p ps=1.12u w=0.74u l=0.13u
X3914 VGND.t1469 sg13cmos5l_inv_16_73.A sg13cmos5l_inv_16_87.A VGND.t1470 sg13_lv_nmos ad=0.1406p pd=1.12u as=0.1406p ps=1.12u w=0.74u l=0.13u
X3915 sg13cmos5l_inv_16_47.Y sg13cmos5l_inv_16_47.A VPWR.t2308 VPWR.t25 sg13_lv_pmos ad=0.2128p pd=1.5u as=0.2128p ps=1.5u w=1.12u l=0.13u
X3916 VGND.t122 sg13cmos5l_inv_16_75.A sg13cmos5l_inv_16_75.Y VGND.t412 sg13_lv_nmos ad=0.2516p pd=2.16u as=0.1406p ps=1.12u w=0.74u l=0.13u
X3917 VPWR.t305 VGND.t111 VPWR.t348 VPWR.t177 sg13_lv_pmos ad=0.34p pd=2.68u as=0 ps=0 w=1u l=1u
X3918 VGND.t635 sg13cmos5l_inv_16_6.Y sg13cmos5l_inv_16_108.Y VGND.t2348 sg13_lv_nmos ad=0.1406p pd=1.12u as=0.1406p ps=1.12u w=0.74u l=0.13u
X3919 VPWR.t1713 sg13cmos5l_inv_16_26.A sg13cmos5l_inv_16_30.A VPWR.t4 sg13_lv_pmos ad=0.2128p pd=1.5u as=0.2128p ps=1.5u w=1.12u l=0.13u
X3920 sg13cmos5l_inv_16_28.A sg13cmos5l_inv_16_41.A VPWR.t683 VPWR.t4 sg13_lv_pmos ad=0.2128p pd=1.5u as=0.2128p ps=1.5u w=1.12u l=0.13u
X3921 VGND.t756 sg13cmos5l_inv_16_111.A sg13cmos5l_inv_16_111.Y VGND.t380 sg13_lv_nmos ad=0.1406p pd=1.12u as=0.1406p ps=1.12u w=0.74u l=0.13u
X3922 sg13cmos5l_inv_16_77.Y sg13cmos5l_inv_16_77.A VGND.t472 VGND.t2168 sg13_lv_nmos ad=0.1406p pd=1.12u as=0.1406p ps=1.12u w=0.74u l=0.13u
X3923 sg13cmos5l_inv_16_30.A sg13cmos5l_inv_16_26.A VGND.t198 VGND.t1327 sg13_lv_nmos ad=0.1406p pd=1.12u as=0.1406p ps=1.12u w=0.74u l=0.13u
X3924 VGND.t1944 sg13cmos5l_inv_16_47.A sg13cmos5l_inv_16_45.Y VGND.t380 sg13_lv_nmos ad=0.1406p pd=1.12u as=0.1406p ps=1.12u w=0.74u l=0.13u
X3925 sg13cmos5l_inv_16_79.Y sg13cmos5l_inv_16_79.A VGND.t1779 VGND.t380 sg13_lv_nmos ad=0.1406p pd=1.12u as=0.1406p ps=1.12u w=0.74u l=0.13u
X3926 VPWR.t566 sg13cmos5l_inv_16_36.A sg13cmos5l_inv_16_100.Y VPWR.t0 sg13_lv_pmos ad=0.2128p pd=1.5u as=0.2128p ps=1.5u w=1.12u l=0.13u
X3927 VPWR.t1927 sg13cmos5l_inv_16_111.A sg13cmos5l_inv_16_98.Y VPWR.t9 sg13_lv_pmos ad=0.2128p pd=1.5u as=0.2128p ps=1.5u w=1.12u l=0.13u
X3928 sg13cmos5l_inv_16_79.A sg13cmos5l_inv_16_81.Y VPWR.t1448 VPWR.t16 sg13_lv_pmos ad=0.2128p pd=1.5u as=0.2128p ps=1.5u w=1.12u l=0.13u
X3929 sg13cmos5l_inv_16_90.Y sg13cmos5l_inv_16_73.Y VGND.t1029 VGND.t881 sg13_lv_nmos ad=0.1406p pd=1.12u as=0.1406p ps=1.12u w=0.74u l=0.13u
X3930 VPWR.t464 sg13cmos5l_inv_16_37.A sg13cmos5l_inv_16_102.Y VPWR.t0 sg13_lv_pmos ad=0.4368p pd=3.02u as=0.2128p ps=1.5u w=1.12u l=0.13u
X3931 VPWR.t1340 sg13cmos5l_inv_16_69.Y sg13cmos5l_inv_16_62.Y VPWR.t9 sg13_lv_pmos ad=0.2128p pd=1.5u as=0.2128p ps=1.5u w=1.12u l=0.13u
X3932 VPWR.t2032 sg13cmos5l_inv_16_56.Y sg13cmos5l_inv_16_71.Y VPWR.t16 sg13_lv_pmos ad=0.2128p pd=1.5u as=0.2128p ps=1.5u w=1.12u l=0.13u
X3933 VPWR.t972 sg13cmos5l_inv_16_8.Y sg13cmos5l_inv_16_20.A VPWR.t0 sg13_lv_pmos ad=0.2128p pd=1.5u as=0.2128p ps=1.5u w=1.12u l=0.13u
X3934 VPWR.t2364 sg13cmos5l_inv_8_4.Y sg13cmos5l_inv_16_56.Y VPWR.t25 sg13_lv_pmos ad=0.2128p pd=1.5u as=0.2128p ps=1.5u w=1.12u l=0.13u
X3935 sg13cmos5l_inv_16_14.A sg13cmos5l_inv_16_23.Y VGND.t52 VGND.t78 sg13_lv_nmos ad=0.1406p pd=1.12u as=0.1406p ps=1.12u w=0.74u l=0.13u
X3936 sg13cmos5l_inv_16_26.Y sg13cmos5l_inv_16_26.A VGND.t414 VGND.t1332 sg13_lv_nmos ad=0.1406p pd=1.12u as=0.1406p ps=1.12u w=0.74u l=0.13u
X3937 VGND.t2158 VPWR.t2463 VGND.t2158 VGND.t2157 sg13_lv_nmos ad=0.1428p pd=1.52u as=0 ps=0 w=0.42u l=1u
X3938 sg13cmos5l_inv_8_0.Y sg13cmos5l_inv_4_0.Y VGND.t588 VGND.t1803 sg13_lv_nmos ad=0.1443p pd=1.13u as=0.1406p ps=1.12u w=0.74u l=0.13u
X3939 VPWR.t1440 sg13cmos5l_inv_16_81.Y sg13cmos5l_inv_16_84.A VPWR.t9 sg13_lv_pmos ad=0.2128p pd=1.5u as=0.2128p ps=1.5u w=1.12u l=0.13u
X3940 VGND.t1083 VPWR.t2576 VGND.t1083 VGND.t881 sg13_lv_nmos ad=79.8f pd=0.8u as=0 ps=0 w=0.42u l=1u
X3941 sg13cmos5l_inv_16_111.Y sg13cmos5l_inv_16_111.A VGND.t756 VGND.t380 sg13_lv_nmos ad=0.1406p pd=1.12u as=0.1406p ps=1.12u w=0.74u l=0.13u
X3942 sg13cmos5l_inv_16_30.A sg13cmos5l_inv_16_26.A VPWR.t1709 VPWR.t4 sg13_lv_pmos ad=0.2128p pd=1.5u as=0.2128p ps=1.5u w=1.12u l=0.13u
X3943 VPWR.t1873 sg13cmos5l_inv_16_73.A sg13cmos5l_inv_16_73.Y VPWR.t16 sg13_lv_pmos ad=0.2128p pd=1.5u as=0.2128p ps=1.5u w=1.12u l=0.13u
X3944 VGND.t326 sg13cmos5l_inv_16_26.A sg13cmos5l_inv_16_30.A VGND.t1324 sg13_lv_nmos ad=0.1406p pd=1.12u as=0.1406p ps=1.12u w=0.74u l=0.13u
X3945 sg13cmos5l_inv_4_4.Y sg13cmos5l_inv_2_6.Y VPWR.t964 VPWR.t25 sg13_lv_pmos ad=0.2128p pd=1.5u as=0.3808p ps=2.92u w=1.12u l=0.13u
X3946 sg13cmos5l_inv_16_99.Y sg13cmos5l_inv_16_99.A VGND.t773 VGND.t776 sg13_lv_nmos ad=0.1406p pd=1.12u as=0.1406p ps=1.12u w=0.74u l=0.13u
X3947 VPWR.t480 sg13cmos5l_inv_16_30.A sg13cmos5l_inv_16_31.Y VPWR.t177 sg13_lv_pmos ad=0.2128p pd=1.5u as=0.2128p ps=1.5u w=1.12u l=0.13u
X3948 VPWR.t1740 sg13cmos5l_inv_16_52.Y sg13cmos5l_inv_16_69.Y VPWR.t16 sg13_lv_pmos ad=0.2128p pd=1.5u as=0.2128p ps=1.5u w=1.12u l=0.13u
X3949 sg13cmos5l_inv_16_48.A sg13cmos5l_inv_8_7.Y VGND.t756 VGND.t380 sg13_lv_nmos ad=0.1406p pd=1.12u as=0.1406p ps=1.12u w=0.74u l=0.13u
X3950 sg13cmos5l_inv_16_102.Y sg13cmos5l_inv_16_37.A VPWR.t460 VPWR.t0 sg13_lv_pmos ad=0.2128p pd=1.5u as=0.2128p ps=1.5u w=1.12u l=0.13u
X3951 VPWR.t35 VGND.t1779 VPWR.t33 VPWR.t25 sg13_lv_pmos ad=0.19p pd=1.38u as=0 ps=0 w=1u l=1u
X3952 VGND.t588 sg13cmos5l_inv_4_0.Y sg13cmos5l_inv_8_0.Y VGND.t1798 sg13_lv_nmos ad=0.1406p pd=1.12u as=0.1406p ps=1.12u w=0.74u l=0.13u
X3953 sg13cmos5l_inv_16_2.A sg13cmos5l_inv_16_1.A VGND.t655 VGND.t663 sg13_lv_nmos ad=0.1406p pd=1.12u as=0.1406p ps=1.12u w=0.74u l=0.13u
X3954 sg13cmos5l_inv_16_77.Y sg13cmos5l_inv_16_77.A VPWR.t2260 VPWR.t25 sg13_lv_pmos ad=0.2128p pd=1.5u as=0.2128p ps=1.5u w=1.12u l=0.13u
X3955 VGND.t52 sg13cmos5l_inv_16_23.Y sg13cmos5l_inv_16_14.A VGND.t75 sg13_lv_nmos ad=0.1406p pd=1.12u as=0.1406p ps=1.12u w=0.74u l=0.13u
X3956 sg13cmos5l_inv_16_84.A sg13cmos5l_inv_16_81.Y VPWR.t1436 VPWR.t9 sg13_lv_pmos ad=0.2128p pd=1.5u as=0.2128p ps=1.5u w=1.12u l=0.13u
X3957 VPWR.t413 VGND.t255 VPWR.t412 VPWR.t4 sg13_lv_pmos ad=0.34p pd=2.68u as=0 ps=0 w=1u l=1u
X3958 sg13cmos5l_inv_16_85.Y sg13cmos5l_inv_16_84.A VGND.t1067 VGND.t1077 sg13_lv_nmos ad=0.1406p pd=1.12u as=0.1406p ps=1.12u w=0.74u l=0.13u
X3959 sg13cmos5l_inv_16_20.Y sg13cmos5l_inv_16_20.A VGND.t375 VGND.t434 sg13_lv_nmos ad=0.1406p pd=1.12u as=0.2516p ps=2.16u w=0.74u l=0.13u
X3960 VGND.t1882 VPWR.t2602 VGND.t1882 VGND.t1883 sg13_lv_nmos ad=79.8f pd=0.8u as=0 ps=0 w=0.42u l=1u
X3961 VGND.t1715 sg13cmos5l_inv_16_46.Y sg13cmos5l_inv_16_50.Y VGND.t380 sg13_lv_nmos ad=0.1406p pd=1.12u as=0.1406p ps=1.12u w=0.74u l=0.13u
X3962 VPWR.t816 sg13cmos5l_inv_16_75.A sg13cmos5l_inv_16_74.Y VPWR.t25 sg13_lv_pmos ad=0.2128p pd=1.5u as=0.2128p ps=1.5u w=1.12u l=0.13u
X3963 VGND.t756 sg13cmos5l_inv_8_7.Y sg13cmos5l_inv_16_48.A VGND.t380 sg13_lv_nmos ad=0.1406p pd=1.12u as=0.1406p ps=1.12u w=0.74u l=0.13u
X3964 VGND.t226 sg13cmos5l_inv_16_41.A sg13cmos5l_inv_16_34.Y VGND.t230 sg13_lv_nmos ad=0.1406p pd=1.12u as=0.1406p ps=1.12u w=0.74u l=0.13u
X3965 sg13cmos5l_inv_16_30.Y sg13cmos5l_inv_16_30.A VPWR.t480 VPWR.t177 sg13_lv_pmos ad=0.2128p pd=1.5u as=0.2128p ps=1.5u w=1.12u l=0.13u
X3966 sg13cmos5l_inv_16_9.A sg13cmos5l_inv_16_8.Y VPWR.t985 VPWR.t0 sg13_lv_pmos ad=0.2128p pd=1.5u as=0.3808p ps=2.92u w=1.12u l=0.13u
X3967 sg13cmos5l_inv_16_6.A sg13cmos5l_inv_16_4.Y VPWR.t741 VPWR.t4 sg13_lv_pmos ad=0.2128p pd=1.5u as=0.2128p ps=1.5u w=1.12u l=0.13u
X3968 sg13cmos5l_inv_16_94.A sg13cmos5l_inv_16_88.A VGND.t898 VGND.t881 sg13_lv_nmos ad=0.1406p pd=1.12u as=0.1406p ps=1.12u w=0.74u l=0.13u
X3969 VGND.t310 sg13cmos5l_inv_16_4.Y sg13cmos5l_inv_16_6.A VGND.t322 sg13_lv_nmos ad=0.1406p pd=1.12u as=0.1406p ps=1.12u w=0.74u l=0.13u
X3970 sg13cmos5l_inv_16_65.Y sg13cmos5l_inv_16_67.A VGND.t1580 VGND.t1594 sg13_lv_nmos ad=0.1406p pd=1.12u as=0.1406p ps=1.12u w=0.74u l=0.13u
X3971 sg13cmos5l_inv_16_40.Y sg13cmos5l_inv_16_26.Y VPWR.t767 VPWR.t177 sg13_lv_pmos ad=0.2128p pd=1.5u as=0.2128p ps=1.5u w=1.12u l=0.13u
X3972 VPWR.t1640 osc[5] a_2920_7680# VPWR.t16 sg13_lv_pmos ad=0.2114p pd=1.54u as=0.2856p ps=2.36u w=0.84u l=0.13u
X3973 VPWR.t2092 sg13cmos5l_inv_16_48.A sg13cmos5l_inv_16_109.Y VPWR.t16 sg13_lv_pmos ad=0.2128p pd=1.5u as=0.2128p ps=1.5u w=1.12u l=0.13u
X3974 VGND.t1718 sg13cmos5l_inv_16_48.A sg13cmos5l_inv_16_46.A VGND.t380 sg13_lv_nmos ad=0.1406p pd=1.12u as=0.1406p ps=1.12u w=0.74u l=0.13u
X3975 VPWR.t1434 sg13cmos5l_inv_16_81.Y sg13cmos5l_inv_16_84.A VPWR.t9 sg13_lv_pmos ad=0.2128p pd=1.5u as=0.2128p ps=1.5u w=1.12u l=0.13u
X3976 VPWR.t341 VGND.t390 VPWR.t339 VPWR.t16 sg13_lv_pmos ad=0.19p pd=1.38u as=0 ps=0 w=1u l=1u
X3977 sg13cmos5l_inv_8_1.A sg13cmos5l_inv_2_1.Y VPWR.t841 VPWR.t4 sg13_lv_pmos ad=0.2128p pd=1.5u as=0.2128p ps=1.5u w=1.12u l=0.13u
X3978 VPWR.t1992 sg13cmos5l_inv_16_67.A sg13cmos5l_inv_16_67.Y VPWR.t16 sg13_lv_pmos ad=0.4368p pd=3.02u as=0.2128p ps=1.5u w=1.12u l=0.13u
X3979 VGND.t1663 sg13cmos5l_inv_16_101.Y sg13cmos5l_inv_16_55.Y VGND.t380 sg13_lv_nmos ad=0.1406p pd=1.12u as=0.1406p ps=1.12u w=0.74u l=0.13u
X3980 sg13cmos5l_inv_16_50.Y sg13cmos5l_inv_16_46.Y VGND.t1715 VGND.t380 sg13_lv_nmos ad=0.1406p pd=1.12u as=0.1406p ps=1.12u w=0.74u l=0.13u
X3981 sg13cmos5l_inv_16_26.A sg13cmos5l_inv_16_27.Y VPWR.t767 VPWR.t177 sg13_lv_pmos ad=0.2128p pd=1.5u as=0.2128p ps=1.5u w=1.12u l=0.13u
X3982 sg13cmos5l_inv_16_11.A sg13cmos5l_inv_16_96.Y VPWR.t2236 VPWR.t25 sg13_lv_pmos ad=0.2128p pd=1.5u as=0.2128p ps=1.5u w=1.12u l=0.13u
X3983 VPWR.t199 VGND.t1 VPWR.t197 VPWR.t25 sg13_lv_pmos ad=0.19p pd=1.38u as=0 ps=0 w=1u l=1u
X3984 sg13cmos5l_inv_16_20.A sg13cmos5l_inv_16_8.Y VGND.t545 VGND.t556 sg13_lv_nmos ad=0.1406p pd=1.12u as=0.1406p ps=1.12u w=0.74u l=0.13u
X3985 sg13cmos5l_inv_16_8.Y sg13cmos5l_inv_16_4.Y VGND.t291 VGND.t305 sg13_lv_nmos ad=0.1406p pd=1.12u as=0.1406p ps=1.12u w=0.74u l=0.13u
X3986 VGND.t1010 sg13cmos5l_inv_16_73.Y sg13cmos5l_inv_16_95.Y VGND.t881 sg13_lv_nmos ad=0.2516p pd=2.16u as=0.1406p ps=1.12u w=0.74u l=0.13u
X3987 VPWR.t1603 sg13cmos5l_inv_16_103.A sg13cmos5l_inv_16_103.Y VPWR.t0 sg13_lv_pmos ad=0.2128p pd=1.5u as=0.2128p ps=1.5u w=1.12u l=0.13u
X3988 sg13cmos5l_inv_16_34.Y sg13cmos5l_inv_16_41.A VGND.t226 VGND.t227 sg13_lv_nmos ad=0.1406p pd=1.12u as=0.1406p ps=1.12u w=0.74u l=0.13u
X3989 sg13cmos5l_inv_16_10.Y sg13cmos5l_inv_16_9.A VGND.t723 VGND.t736 sg13_lv_nmos ad=0.1406p pd=1.12u as=0.1406p ps=1.12u w=0.74u l=0.13u
X3990 VGND.t862 sg13cmos5l_inv_16_6.A sg13cmos5l_inv_16_6.Y VGND.t1404 sg13_lv_nmos ad=0.1406p pd=1.12u as=0.1406p ps=1.12u w=0.74u l=0.13u
X3991 VPWR.t739 sg13cmos5l_inv_16_4.Y sg13cmos5l_inv_16_6.A VPWR.t4 sg13_lv_pmos ad=0.2128p pd=1.5u as=0.2128p ps=1.5u w=1.12u l=0.13u
X3992 VGND.t1507 sg13cmos5l_inv_16_88.A sg13cmos5l_inv_16_94.A VGND.t881 sg13_lv_nmos ad=0.1406p pd=1.12u as=0.1406p ps=1.12u w=0.74u l=0.13u
X3993 sg13cmos5l_inv_16_47.A sg13cmos5l_inv_16_46.A VGND.t1715 VGND.t380 sg13_lv_nmos ad=0.1406p pd=1.12u as=0.2516p ps=2.16u w=0.74u l=0.13u
X3994 VGND.t1792 VPWR.t2560 VGND.t1792 VGND.t380 sg13_lv_nmos ad=79.8f pd=0.8u as=0 ps=0 w=0.42u l=1u
X3995 sg13cmos5l_inv_16_6.A sg13cmos5l_inv_16_4.Y VGND.t310 VGND.t319 sg13_lv_nmos ad=0.1406p pd=1.12u as=0.1406p ps=1.12u w=0.74u l=0.13u
X3996 sg13cmos5l_inv_16_46.A sg13cmos5l_inv_16_48.A VGND.t1718 VGND.t380 sg13_lv_nmos ad=0.1406p pd=1.12u as=0.1406p ps=1.12u w=0.74u l=0.13u
X3997 VGND.t773 sg13cmos5l_inv_16_99.A sg13cmos5l_inv_16_51.Y VGND.t783 sg13_lv_nmos ad=0.1406p pd=1.12u as=0.1406p ps=1.12u w=0.74u l=0.13u
X3998 sg13cmos5l_inv_16_103.A sg13cmos5l_inv_16_11.A VGND.t375 VGND.t378 sg13_lv_nmos ad=0.1406p pd=1.12u as=0.1406p ps=1.12u w=0.74u l=0.13u
X3999 VPWR.t178 sg13cmos5l_inv_16_26.Y sg13cmos5l_inv_16_40.Y VPWR.t177 sg13_lv_pmos ad=0.2128p pd=1.5u as=0.2128p ps=1.5u w=1.12u l=0.13u
X4000 VGND.t953 VPWR.t2557 VGND.t953 VGND.t380 sg13_lv_nmos ad=0.1428p pd=1.52u as=0 ps=0 w=0.42u l=1u
X4001 VGND.t45 VPWR.t2484 VGND.t45 VGND.t2090 sg13_lv_nmos ad=79.8f pd=0.8u as=0 ps=0 w=0.42u l=1u
X4002 sg13cmos5l_inv_16_48.A sg13cmos5l_inv_8_7.Y VPWR.t1173 VPWR.t25 sg13_lv_pmos ad=0.2128p pd=1.5u as=0.2128p ps=1.5u w=1.12u l=0.13u
X4003 VPWR.t272 VGND.t125 VPWR.t272 VPWR.t177 sg13_lv_pmos ad=0.34p pd=2.68u as=0 ps=0 w=1u l=1u
X4004 sg13cmos5l_inv_16_77.Y sg13cmos5l_inv_16_77.A VGND.t472 VGND.t2164 sg13_lv_nmos ad=0.1406p pd=1.12u as=0.1406p ps=1.12u w=0.74u l=0.13u
X4005 VGND.t1944 sg13cmos5l_inv_16_47.A sg13cmos5l_inv_16_45.Y VGND.t380 sg13_lv_nmos ad=0.1406p pd=1.12u as=0.1406p ps=1.12u w=0.74u l=0.13u
X4006 sg13cmos5l_inv_16_46.Y sg13cmos5l_inv_16_46.A VGND.t139 VGND.t1761 sg13_lv_nmos ad=0.1406p pd=1.12u as=0.1406p ps=1.12u w=0.74u l=0.13u
X4007 VGND.t144 sg13cmos5l_inv_1_7.A sg13cmos5l_inv_1_7.Y VGND.t540 sg13_lv_nmos ad=0.2516p pd=2.16u as=0.2516p ps=2.16u w=0.74u l=0.13u
X4008 VGND.t196 VPWR.t2502 VGND.t723 VGND.t2058 sg13_lv_nmos ad=79.8f pd=0.8u as=0 ps=0 w=0.42u l=1u
X4009 sg13cmos5l_inv_16_67.Y sg13cmos5l_inv_16_67.A VPWR.t1988 VPWR.t16 sg13_lv_pmos ad=0.2128p pd=1.5u as=0.2128p ps=1.5u w=1.12u l=0.13u
X4010 sg13cmos5l_inv_16_55.Y sg13cmos5l_inv_16_101.Y VGND.t1663 VGND.t380 sg13_lv_nmos ad=0.1406p pd=1.12u as=0.1406p ps=1.12u w=0.74u l=0.13u
X4011 VPWR.t562 sg13cmos5l_inv_16_36.A sg13cmos5l_inv_16_100.Y VPWR.t0 sg13_lv_pmos ad=0.2128p pd=1.5u as=0.2128p ps=1.5u w=1.12u l=0.13u
X4012 sg13cmos5l_inv_16_79.A sg13cmos5l_inv_16_81.Y VGND.t1026 VGND.t881 sg13_lv_nmos ad=0.1406p pd=1.12u as=0.1406p ps=1.12u w=0.74u l=0.13u
X4013 VGND.t1944 VPWR.t2567 VGND.t1663 VGND.t380 sg13_lv_nmos ad=0.1428p pd=1.52u as=0 ps=0 w=0.42u l=1u
X4014 VPWR.t2028 sg13cmos5l_inv_16_56.Y sg13cmos5l_inv_16_71.Y VPWR.t16 sg13_lv_pmos ad=0.2128p pd=1.5u as=0.2128p ps=1.5u w=1.12u l=0.13u
X4015 VGND.t723 sg13cmos5l_inv_16_9.A sg13cmos5l_inv_16_10.Y VGND.t732 sg13_lv_nmos ad=0.1406p pd=1.12u as=0.1406p ps=1.12u w=0.74u l=0.13u
X4016 VGND.t1201 sg13cmos5l_inv_2_5.Y sg13cmos5l_inv_4_7.Y VGND.t1229 sg13_lv_nmos ad=0.1406p pd=1.12u as=0.1406p ps=1.12u w=0.74u l=0.13u
X4017 VGND.t882 sg13cmos5l_inv_16_56.Y sg13cmos5l_inv_16_71.Y VGND.t881 sg13_lv_nmos ad=0.2516p pd=2.16u as=0.1406p ps=1.12u w=0.74u l=0.13u
X4018 sg13cmos5l_inv_16_54.Y sg13cmos5l_inv_16_101.Y VGND.t1680 VGND.t380 sg13_lv_nmos ad=0.1406p pd=1.12u as=0.1406p ps=1.12u w=0.74u l=0.13u
X4019 VPWR.t2360 sg13cmos5l_inv_8_4.Y sg13cmos5l_inv_16_56.Y VPWR.t25 sg13_lv_pmos ad=0.2128p pd=1.5u as=0.2128p ps=1.5u w=1.12u l=0.13u
X4020 VGND.t310 sg13cmos5l_inv_16_4.Y sg13cmos5l_inv_16_6.A VGND.t316 sg13_lv_nmos ad=0.1406p pd=1.12u as=0.1406p ps=1.12u w=0.74u l=0.13u
X4021 sg13cmos5l_inv_16_61.Y sg13cmos5l_inv_16_61.A VGND.t1164 VGND.t881 sg13_lv_nmos ad=0.1406p pd=1.12u as=0.1406p ps=1.12u w=0.74u l=0.13u
X4022 VPWR.t2221 sg13cmos5l_inv_16_96.Y sg13cmos5l_inv_16_81.Y VPWR.t16 sg13_lv_pmos ad=0.2128p pd=1.5u as=0.2128p ps=1.5u w=1.12u l=0.13u
X4023 VGND.t609 VPWR.t2527 VGND.t609 VGND.t1999 sg13_lv_nmos ad=0.1428p pd=1.52u as=0 ps=0 w=0.42u l=1u
X4024 sg13cmos5l_inv_16_51.Y sg13cmos5l_inv_16_99.A VGND.t773 VGND.t780 sg13_lv_nmos ad=0.1406p pd=1.12u as=0.1406p ps=1.12u w=0.74u l=0.13u
X4025 sg13cmos5l_inv_16_105.A sg13cmos5l_inv_16_11.A VPWR.t771 VPWR.t25 sg13_lv_pmos ad=0.2128p pd=1.5u as=0.3808p ps=2.92u w=1.12u l=0.13u
X4026 VGND.t375 sg13cmos5l_inv_16_11.A sg13cmos5l_inv_16_103.A VGND.t374 sg13_lv_nmos ad=0.1406p pd=1.12u as=0.1406p ps=1.12u w=0.74u l=0.13u
X4027 sg13cmos5l_inv_16_26.Y sg13cmos5l_inv_16_26.A VPWR.t767 VPWR.t177 sg13_lv_pmos ad=0.2128p pd=1.5u as=0.2128p ps=1.5u w=1.12u l=0.13u
X4028 sg13cmos5l_inv_8_1.Y sg13cmos5l_inv_8_1.A VPWR.t1816 VPWR.t177 sg13_lv_pmos ad=0.2184p pd=1.51u as=0.2128p ps=1.5u w=1.12u l=0.13u
X4029 sg13cmos5l_inv_16_40.Y sg13cmos5l_inv_16_26.Y VPWR.t178 VPWR.t177 sg13_lv_pmos ad=0.2128p pd=1.5u as=0.2128p ps=1.5u w=1.12u l=0.13u
X4030 sg13cmos5l_inv_16_0.A sg13cmos5l_inv_8_0.Y VPWR.t2407 VPWR.t177 sg13_lv_pmos ad=0.2128p pd=1.5u as=0.2128p ps=1.5u w=1.12u l=0.13u
X4031 VPWR.t844 sg13cmos5l_inv_16_27.A sg13cmos5l_inv_16_27.Y VPWR.t177 sg13_lv_pmos ad=0.2128p pd=1.5u as=0.2128p ps=1.5u w=1.12u l=0.13u
X4032 VPWR.t241 VGND.t162 VPWR.t238 VPWR.t4 sg13_lv_pmos ad=0.19p pd=1.38u as=0 ps=0 w=1u l=1u
X4033 sg13cmos5l_inv_16_111.Y sg13cmos5l_inv_16_111.A VGND.t756 VGND.t380 sg13_lv_nmos ad=0.1406p pd=1.12u as=0.2516p ps=2.16u w=0.74u l=0.13u
X4034 VPWR.t2016 sg13cmos5l_inv_16_88.A sg13cmos5l_inv_16_94.A VPWR.t9 sg13_lv_pmos ad=0.2128p pd=1.5u as=0.2128p ps=1.5u w=1.12u l=0.13u
X4035 sg13cmos5l_inv_16_90.Y sg13cmos5l_inv_16_73.Y VPWR.t2197 VPWR.t16 sg13_lv_pmos ad=0.2128p pd=1.5u as=0.2128p ps=1.5u w=1.12u l=0.13u
X4036 VPWR.t480 sg13cmos5l_inv_16_30.A sg13cmos5l_inv_16_31.Y VPWR.t177 sg13_lv_pmos ad=0.2128p pd=1.5u as=0.2128p ps=1.5u w=1.12u l=0.13u
X4037 sg13cmos5l_inv_16_100.Y sg13cmos5l_inv_16_36.A VPWR.t558 VPWR.t0 sg13_lv_pmos ad=0.2128p pd=1.5u as=0.2128p ps=1.5u w=1.12u l=0.13u
X4038 VGND.t326 sg13cmos5l_inv_16_30.A sg13cmos5l_inv_16_31.Y VGND.t1294 sg13_lv_nmos ad=0.2516p pd=2.16u as=0.1406p ps=1.12u w=0.74u l=0.13u
X4039 VGND.t1026 sg13cmos5l_inv_16_81.Y sg13cmos5l_inv_16_79.A VGND.t881 sg13_lv_nmos ad=0.1406p pd=1.12u as=0.1406p ps=1.12u w=0.74u l=0.13u
X4040 VGND.t2012 VPWR.t2529 VGND.t2012 VGND.t2013 sg13_lv_nmos ad=79.8f pd=0.8u as=0 ps=0 w=0.42u l=1u
X4041 VPWR.t537 sg13cmos5l_inv_16_17.A sg13cmos5l_inv_16_19.Y VPWR.t177 sg13_lv_pmos ad=0.4368p pd=3.02u as=0.2128p ps=1.5u w=1.12u l=0.13u
X4042 sg13cmos5l_inv_16_56.Y sg13cmos5l_inv_8_4.Y VPWR.t2356 VPWR.t25 sg13_lv_pmos ad=0.2128p pd=1.5u as=0.2128p ps=1.5u w=1.12u l=0.13u
X4043 sg13cmos5l_inv_16_2.A sg13cmos5l_inv_16_1.A VGND.t655 VGND.t659 sg13_lv_nmos ad=0.1406p pd=1.12u as=0.1406p ps=1.12u w=0.74u l=0.13u
X4044 VPWR.t767 sg13cmos5l_inv_16_26.A sg13cmos5l_inv_16_26.Y VPWR.t177 sg13_lv_pmos ad=0.2128p pd=1.5u as=0.2128p ps=1.5u w=1.12u l=0.13u
X4045 VGND.t52 sg13cmos5l_inv_16_23.Y sg13cmos5l_inv_16_14.A VGND.t51 sg13_lv_nmos ad=0.1406p pd=1.12u as=0.1406p ps=1.12u w=0.74u l=0.13u
X4046 VPWR.t1770 sg13cmos5l_inv_16_52.Y sg13cmos5l_inv_16_53.A VPWR.t16 sg13_lv_pmos ad=0.3808p pd=2.92u as=0.2128p ps=1.5u w=1.12u l=0.13u
X4047 sg13cmos5l_inv_16_85.Y sg13cmos5l_inv_16_84.A VGND.t1067 VGND.t1073 sg13_lv_nmos ad=0.1406p pd=1.12u as=0.1406p ps=1.12u w=0.74u l=0.13u
X4048 sg13cmos5l_inv_16_99.Y sg13cmos5l_inv_16_99.A VPWR.t1211 VPWR.t0 sg13_lv_pmos ad=0.2128p pd=1.5u as=0.2128p ps=1.5u w=1.12u l=0.13u
X4049 VPWR.t1104 sg13cmos5l_inv_16_29.A sg13cmos5l_inv_16_35.Y VPWR.t0 sg13_lv_pmos ad=0.2128p pd=1.5u as=0.2128p ps=1.5u w=1.12u l=0.13u
X4050 VGND.t1083 VPWR.t2575 VGND.t1083 VGND.t881 sg13_lv_nmos ad=79.8f pd=0.8u as=0 ps=0 w=0.42u l=1u
X4051 sg13cmos5l_inv_16_79.A sg13cmos5l_inv_16_81.Y VPWR.t1460 VPWR.t16 sg13_lv_pmos ad=0.2128p pd=1.5u as=0.2128p ps=1.5u w=1.12u l=0.13u
X4052 VGND.t84 a_20588_834# sg13cmos5l_buf_1_2.X VGND.t1629 sg13_lv_nmos ad=0.14875p pd=1.16u as=0.2886p ps=2.26u w=0.74u l=0.13u
X4053 sg13cmos5l_inv_16_94.A sg13cmos5l_inv_16_88.A VPWR.t2012 VPWR.t9 sg13_lv_pmos ad=0.2128p pd=1.5u as=0.2128p ps=1.5u w=1.12u l=0.13u
X4054 a_20588_834# en[5] VGND.t84 VGND.t2230 sg13_lv_nmos ad=0.187p pd=1.78u as=0.14875p ps=1.16u w=0.55u l=0.13u
X4055 VPWR.t812 sg13cmos5l_inv_16_75.A sg13cmos5l_inv_16_74.Y VPWR.t25 sg13_lv_pmos ad=0.2128p pd=1.5u as=0.2128p ps=1.5u w=1.12u l=0.13u
X4056 sg13cmos5l_inv_16_14.Y sg13cmos5l_inv_16_14.A VGND.t50 VGND.t497 sg13_lv_nmos ad=0.1406p pd=1.12u as=0.1406p ps=1.12u w=0.74u l=0.13u
X4057 sg13cmos5l_inv_16_79.A sg13cmos5l_inv_16_81.Y VGND.t1026 VGND.t881 sg13_lv_nmos ad=0.1406p pd=1.12u as=0.1406p ps=1.12u w=0.74u l=0.13u
X4058 sg13cmos5l_inv_16_55.Y sg13cmos5l_inv_16_101.Y VGND.t427 VGND.t380 sg13_lv_nmos ad=0.1406p pd=1.12u as=0.1406p ps=1.12u w=0.74u l=0.13u
X4059 sg13cmos5l_inv_16_51.Y sg13cmos5l_inv_16_99.A VPWR.t1198 VPWR.t25 sg13_lv_pmos ad=0.2128p pd=1.5u as=0.2128p ps=1.5u w=1.12u l=0.13u
X4060 sg13cmos5l_inv_16_5.Y sg13cmos5l_inv_16_6.A VPWR.t246 VPWR.t177 sg13_lv_pmos ad=0.2128p pd=1.5u as=0.2128p ps=1.5u w=1.12u l=0.13u
X4061 sg13cmos5l_inv_16_19.Y sg13cmos5l_inv_16_17.A VPWR.t533 VPWR.t177 sg13_lv_pmos ad=0.2128p pd=1.5u as=0.2128p ps=1.5u w=1.12u l=0.13u
X4062 VPWR.t1288 sg13cmos5l_inv_16_68.A sg13cmos5l_inv_16_66.Y VPWR.t9 sg13_lv_pmos ad=0.2128p pd=1.5u as=0.2128p ps=1.5u w=1.12u l=0.13u
X4063 VPWR.t2254 sg13cmos5l_inv_16_77.A sg13cmos5l_inv_16_77.Y VPWR.t25 sg13_lv_pmos ad=0.2128p pd=1.5u as=0.2128p ps=1.5u w=1.12u l=0.13u
X4064 sg13cmos5l_inv_16_1.A sg13cmos5l_inv_16_0.A VPWR.t1270 VPWR.t177 sg13_lv_pmos ad=0.2128p pd=1.5u as=0.2128p ps=1.5u w=1.12u l=0.13u
X4065 VGND.t655 sg13cmos5l_inv_16_1.A sg13cmos5l_inv_16_2.A VGND.t656 sg13_lv_nmos ad=0.1406p pd=1.12u as=0.1406p ps=1.12u w=0.74u l=0.13u
X4066 sg13cmos5l_inv_16_44.A sg13cmos5l_inv_16_28.A VPWR.t690 VPWR.t4 sg13_lv_pmos ad=0.2128p pd=1.5u as=0.3808p ps=2.92u w=1.12u l=0.13u
X4067 VGND.t1944 VPWR.t2551 VGND.t1944 VGND.t380 sg13_lv_nmos ad=0.1428p pd=1.52u as=0 ps=0 w=0.42u l=1u
X4068 VPWR.t645 VGND.t1083 VPWR.t643 VPWR.t9 sg13_lv_pmos ad=0.19p pd=1.38u as=0 ps=0 w=1u l=1u
X4069 sg13cmos5l_and2_1_0.B a_2920_6168# VGND.t427 VGND.t380 sg13_lv_nmos ad=0.2886p pd=2.26u as=0.14875p ps=1.16u w=0.74u l=0.13u
X4070 VPWR.t1209 sg13cmos5l_inv_16_99.A sg13cmos5l_inv_16_99.Y VPWR.t0 sg13_lv_pmos ad=0.2128p pd=1.5u as=0.2128p ps=1.5u w=1.12u l=0.13u
X4071 sg13cmos5l_inv_16_50.Y sg13cmos5l_inv_16_46.Y VGND.t1715 VGND.t380 sg13_lv_nmos ad=0.1406p pd=1.12u as=0.1406p ps=1.12u w=0.74u l=0.13u
X4072 VPWR.t1834 sg13cmos5l_inv_16_2.A sg13cmos5l_inv_16_2.Y VPWR.t177 sg13_lv_pmos ad=0.4368p pd=3.02u as=0.2128p ps=1.5u w=1.12u l=0.13u
X4073 VGND.t1885 VPWR.t2601 VGND.t1885 VGND.t1886 sg13_lv_nmos ad=79.8f pd=0.8u as=0 ps=0 w=0.42u l=1u
X4074 sg13cmos5l_inv_16_65.Y sg13cmos5l_inv_16_67.A VPWR.t1970 VPWR.t9 sg13_lv_pmos ad=0.2128p pd=1.5u as=0.2128p ps=1.5u w=1.12u l=0.13u
X4075 sg13cmos5l_inv_16_69.Y sg13cmos5l_inv_16_52.Y VPWR.t1752 VPWR.t16 sg13_lv_pmos ad=0.2128p pd=1.5u as=0.2128p ps=1.5u w=1.12u l=0.13u
X4076 VGND.t50 sg13cmos5l_inv_16_14.A sg13cmos5l_inv_16_14.Y VGND.t494 sg13_lv_nmos ad=0.1406p pd=1.12u as=0.1406p ps=1.12u w=0.74u l=0.13u
X4077 sg13cmos5l_inv_16_74.Y sg13cmos5l_inv_16_75.A VPWR.t808 VPWR.t25 sg13_lv_pmos ad=0.2128p pd=1.5u as=0.2128p ps=1.5u w=1.12u l=0.13u
X4078 VGND.t353 sg13cmos5l_inv_16_103.A sg13cmos5l_inv_16_103.Y VGND.t355 sg13_lv_nmos ad=0.1406p pd=1.12u as=0.1406p ps=1.12u w=0.74u l=0.13u
X4079 VPWR.t1910 sg13cmos5l_inv_16_94.A sg13cmos5l_inv_16_76.A VPWR.t16 sg13_lv_pmos ad=0.2128p pd=1.5u as=0.2128p ps=1.5u w=1.12u l=0.13u
X4080 sg13cmos5l_inv_16_93.Y sg13cmos5l_inv_16_87.A VGND.t994 VGND.t1000 sg13_lv_nmos ad=0.1406p pd=1.12u as=0.1406p ps=1.12u w=0.74u l=0.13u
X4081 VPWR.t110 VGND.t994 VPWR.t109 VPWR.t9 sg13_lv_pmos ad=0.34p pd=2.68u as=0 ps=0 w=1u l=1u
X4082 sg13cmos5l_inv_16_75.A sg13cmos5l_inv_16_76.A VGND.t390 VGND.t380 sg13_lv_nmos ad=0.1406p pd=1.12u as=0.1406p ps=1.12u w=0.74u l=0.13u
X4083 VPWR.t250 VGND.t723 VPWR.t249 VPWR.t0 sg13_lv_pmos ad=0.19p pd=1.38u as=0 ps=0 w=1u l=1u
X4084 VGND.t1201 sg13cmos5l_inv_4_7.Y sg13cmos5l_inv_16_88.A VGND.t1221 sg13_lv_nmos ad=0.1406p pd=1.12u as=0.1406p ps=1.12u w=0.74u l=0.13u
X4085 sg13cmos5l_inv_16_101.Y sg13cmos5l_inv_16_34.Y VGND.t593 VGND.t592 sg13_lv_nmos ad=0.1406p pd=1.12u as=0.2516p ps=2.16u w=0.74u l=0.13u
X4086 VGND.t139 sg13cmos5l_inv_16_36.A sg13cmos5l_inv_16_100.Y VGND.t141 sg13_lv_nmos ad=0.1406p pd=1.12u as=0.1406p ps=1.12u w=0.74u l=0.13u
X4087 a_13664_4097# sg13cmos5l_buf_1_4.X a_13801_3940# VGND.t123 sg13_lv_nmos ad=0.2176p pd=1.96u as=0.1216p ps=1.02u w=0.64u l=0.13u
X4088 sg13cmos5l_inv_16_9.Y sg13cmos5l_inv_16_9.A VGND.t723 VGND.t736 sg13_lv_nmos ad=0.1406p pd=1.12u as=0.1406p ps=1.12u w=0.74u l=0.13u
X4089 sg13cmos5l_inv_16_85.Y sg13cmos5l_inv_16_84.A VGND.t1067 VGND.t1069 sg13_lv_nmos ad=0.1406p pd=1.12u as=0.1406p ps=1.12u w=0.74u l=0.13u
X4090 VPWR.t1750 sg13cmos5l_inv_16_52.Y sg13cmos5l_inv_16_69.Y VPWR.t16 sg13_lv_pmos ad=0.2128p pd=1.5u as=0.2128p ps=1.5u w=1.12u l=0.13u
X4091 sg13cmos5l_inv_16_46.A sg13cmos5l_inv_16_48.A VPWR.t2095 VPWR.t25 sg13_lv_pmos ad=0.2128p pd=1.5u as=0.3808p ps=2.92u w=1.12u l=0.13u
X4092 sg13cmos5l_inv_16_96.Y sg13cmos5l_inv_16_96.A VPWR.t1343 VPWR.t25 sg13_lv_pmos ad=0.2128p pd=1.5u as=0.3808p ps=2.92u w=1.12u l=0.13u
X4093 sg13cmos5l_inv_16_43.Y sg13cmos5l_inv_16_27.Y VGND.t1245 VGND.t1250 sg13_lv_nmos ad=0.1406p pd=1.12u as=0.1406p ps=1.12u w=0.74u l=0.13u
X4094 VGND.t1879 VPWR.t2603 VGND.t866 VGND.t1878 sg13_lv_nmos ad=0.1428p pd=1.52u as=0 ps=0 w=0.42u l=1u
X4095 VGND.t963 sg13cmos5l_inv_16_56.Y sg13cmos5l_inv_16_71.Y VGND.t881 sg13_lv_nmos ad=0.1406p pd=1.12u as=0.1406p ps=1.12u w=0.74u l=0.13u
X4096 sg13cmos5l_inv_16_76.A sg13cmos5l_inv_16_94.A VPWR.t1907 VPWR.t16 sg13_lv_pmos ad=0.2128p pd=1.5u as=0.3808p ps=2.92u w=1.12u l=0.13u
X4097 sg13cmos5l_inv_16_61.Y sg13cmos5l_inv_16_61.A VGND.t1164 VGND.t881 sg13_lv_nmos ad=0.1406p pd=1.12u as=0.1406p ps=1.12u w=0.74u l=0.13u
X4098 VGND.t994 sg13cmos5l_inv_16_87.A sg13cmos5l_inv_16_93.Y VGND.t997 sg13_lv_nmos ad=0.1406p pd=1.12u as=0.1406p ps=1.12u w=0.74u l=0.13u
X4099 sg13cmos5l_inv_16_51.Y sg13cmos5l_inv_16_99.A VGND.t773 VGND.t776 sg13_lv_nmos ad=0.1406p pd=1.12u as=0.1406p ps=1.12u w=0.74u l=0.13u
X4100 VGND.t39 sg13cmos5l_inv_2_3.Y sg13cmos5l_inv_4_2.Y VGND.t40 sg13_lv_nmos ad=0.1406p pd=1.12u as=0.1406p ps=1.12u w=0.74u l=0.13u
X4101 sg13cmos5l_inv_16_84.Y sg13cmos5l_inv_16_84.A VGND.t1026 VGND.t881 sg13_lv_nmos ad=0.1406p pd=1.12u as=0.1406p ps=1.12u w=0.74u l=0.13u
X4102 VPWR.t1001 sg13cmos5l_inv_16_6.Y sg13cmos5l_inv_16_108.Y VPWR.t177 sg13_lv_pmos ad=0.2128p pd=1.5u as=0.2128p ps=1.5u w=1.12u l=0.13u
X4103 VPWR.t729 sg13cmos5l_inv_16_4.Y sg13cmos5l_inv_16_8.Y VPWR.t4 sg13_lv_pmos ad=0.2128p pd=1.5u as=0.2128p ps=1.5u w=1.12u l=0.13u
X4104 VPWR.t844 sg13cmos5l_inv_16_27.A sg13cmos5l_inv_16_27.Y VPWR.t177 sg13_lv_pmos ad=0.2128p pd=1.5u as=0.2128p ps=1.5u w=1.12u l=0.13u
X4105 sg13cmos5l_inv_16_0.A sg13cmos5l_inv_8_0.Y VGND.t2123 VGND.t2327 sg13_lv_nmos ad=0.1406p pd=1.12u as=0.1406p ps=1.12u w=0.74u l=0.13u
X4106 sg13cmos5l_inv_16_11.A sg13cmos5l_inv_16_96.Y VPWR.t2248 VPWR.t25 sg13_lv_pmos ad=0.2128p pd=1.5u as=0.2128p ps=1.5u w=1.12u l=0.13u
X4107 VGND.t723 sg13cmos5l_inv_16_9.A sg13cmos5l_inv_16_9.Y VGND.t732 sg13_lv_nmos ad=0.1406p pd=1.12u as=0.1406p ps=1.12u w=0.74u l=0.13u
X4108 sg13cmos5l_inv_2_0.A sg13cmos5l_and2_1_1.X VGND.t86 VGND.t1385 sg13_lv_nmos ad=0.2516p pd=2.16u as=0.2516p ps=2.16u w=0.74u l=0.13u
X4109 VGND.t326 sg13cmos5l_inv_16_30.A sg13cmos5l_inv_16_31.Y VGND.t1290 sg13_lv_nmos ad=0.1406p pd=1.12u as=0.1406p ps=1.12u w=0.74u l=0.13u
X4110 VGND.t1245 sg13cmos5l_inv_16_27.Y sg13cmos5l_inv_16_43.Y VGND.t1247 sg13_lv_nmos ad=0.1406p pd=1.12u as=0.1406p ps=1.12u w=0.74u l=0.13u
X4111 sg13cmos5l_inv_16_65.Y sg13cmos5l_inv_16_67.A VPWR.t1966 VPWR.t9 sg13_lv_pmos ad=0.2128p pd=1.5u as=0.2128p ps=1.5u w=1.12u l=0.13u
X4112 VGND.t343 sg13cmos5l_inv_16_30.A sg13cmos5l_inv_16_30.Y VGND.t1295 sg13_lv_nmos ad=0.1406p pd=1.12u as=0.1406p ps=1.12u w=0.74u l=0.13u
X4113 VPWR.t433 VGND.t1241 VPWR.t432 VPWR.t9 sg13_lv_pmos ad=0.34p pd=2.68u as=0 ps=0 w=1u l=1u
X4114 VGND.t1680 sg13cmos5l_inv_16_101.Y sg13cmos5l_inv_16_54.Y VGND.t380 sg13_lv_nmos ad=0.1406p pd=1.12u as=0.1406p ps=1.12u w=0.74u l=0.13u
X4115 VGND.t345 sg13cmos5l_inv_16_103.A sg13cmos5l_inv_16_103.Y VGND.t350 sg13_lv_nmos ad=0.1406p pd=1.12u as=0.1406p ps=1.12u w=0.74u l=0.13u
X4116 VGND.t1164 sg13cmos5l_inv_16_61.A sg13cmos5l_inv_16_61.Y VGND.t881 sg13_lv_nmos ad=0.1406p pd=1.12u as=0.1406p ps=1.12u w=0.74u l=0.13u
X4117 VPWR.t584 sg13cmos5l_inv_16_36.A sg13cmos5l_inv_16_36.Y VPWR.t4 sg13_lv_pmos ad=0.2128p pd=1.5u as=0.2128p ps=1.5u w=1.12u l=0.13u
X4118 sg13cmos5l_inv_16_58.Y sg13cmos5l_inv_16_69.Y VGND.t916 VGND.t917 sg13_lv_nmos ad=0.1406p pd=1.12u as=0.1406p ps=1.12u w=0.74u l=0.13u
X4119 VGND.t5 VPWR.t2526 VGND.t5 VGND.t2017 sg13_lv_nmos ad=0.1428p pd=1.52u as=0 ps=0 w=0.42u l=1u
X4120 sg13cmos5l_inv_16_28.A sg13cmos5l_inv_16_41.A VGND.t215 VGND.t236 sg13_lv_nmos ad=0.1406p pd=1.12u as=0.1406p ps=1.12u w=0.74u l=0.13u
X4121 sg13cmos5l_inv_16_27.Y sg13cmos5l_inv_16_27.A VPWR.t844 VPWR.t177 sg13_lv_pmos ad=0.2128p pd=1.5u as=0.2128p ps=1.5u w=1.12u l=0.13u
X4122 sg13cmos5l_inv_16_108.Y sg13cmos5l_inv_16_6.Y VPWR.t1001 VPWR.t177 sg13_lv_pmos ad=0.2128p pd=1.5u as=0.4368p ps=3.02u w=1.12u l=0.13u
X4123 VGND.t1381 sg13cmos5l_inv_2_2.Y sg13cmos5l_inv_8_2.A VGND.t1380 sg13_lv_nmos ad=0.1406p pd=1.12u as=0.1406p ps=1.12u w=0.74u l=0.13u
X4124 VGND.t3 sg13cmos5l_inv_16_37.A sg13cmos5l_inv_16_37.Y VGND.t29 sg13_lv_nmos ad=0.1406p pd=1.12u as=0.1406p ps=1.12u w=0.74u l=0.13u
X4125 VGND.t20 sg13cmos5l_inv_16_47.A sg13cmos5l_inv_16_47.Y VGND.t2229 sg13_lv_nmos ad=0.2516p pd=2.16u as=0.1406p ps=1.12u w=0.74u l=0.13u
X4126 VPWR.t259 VGND.t196 VPWR.t243 VPWR.t4 sg13_lv_pmos ad=0.19p pd=1.38u as=0 ps=0 w=1u l=1u
X4127 VGND.t1 VPWR.t2528 VGND.t1 VGND.t1998 sg13_lv_nmos ad=0.1428p pd=1.52u as=0 ps=0 w=0.42u l=1u
X4128 VGND.t162 VPWR.t2503 VGND.t162 VGND.t2055 sg13_lv_nmos ad=0.1428p pd=1.52u as=0 ps=0 w=0.42u l=1u
X4129 sg13cmos5l_inv_16_29.Y sg13cmos5l_inv_16_29.A VGND.t705 VGND.t719 sg13_lv_nmos ad=0.1406p pd=1.12u as=0.1406p ps=1.12u w=0.74u l=0.13u
X4130 VGND.t827 sg13cmos5l_inv_8_0.Y sg13cmos5l_inv_16_0.A VGND.t2324 sg13_lv_nmos ad=0.1406p pd=1.12u as=0.1406p ps=1.12u w=0.74u l=0.13u
X4131 VPWR.t2191 sg13cmos5l_inv_16_73.Y sg13cmos5l_inv_16_90.Y VPWR.t16 sg13_lv_pmos ad=0.2128p pd=1.5u as=0.2128p ps=1.5u w=1.12u l=0.13u
X4132 VPWR.t959 sg13cmos5l_inv_16_15.A sg13cmos5l_inv_16_15.Y VPWR.t4 sg13_lv_pmos ad=0.2128p pd=1.5u as=0.2128p ps=1.5u w=1.12u l=0.13u
X4133 VGND.t1 VPWR.t2538 VGND.t1 VGND.t1997 sg13_lv_nmos ad=79.8f pd=0.8u as=0 ps=0 w=0.42u l=1u
X4134 sg13cmos5l_inv_16_36.A sg13cmos5l_inv_16_43.Y VGND.t146 VGND.t187 sg13_lv_nmos ad=0.1406p pd=1.12u as=0.1406p ps=1.12u w=0.74u l=0.13u
X4135 sg13cmos5l_inv_16_43.Y sg13cmos5l_inv_16_27.Y VGND.t1243 VGND.t1242 sg13_lv_nmos ad=0.1406p pd=1.12u as=0.2516p ps=2.16u w=0.74u l=0.13u
X4136 VPWR.t317 VGND.t353 VPWR.t316 VPWR.t25 sg13_lv_pmos ad=0.34p pd=2.68u as=0 ps=0 w=1u l=1u
X4137 sg13cmos5l_inv_16_31.Y sg13cmos5l_inv_16_30.A VGND.t326 VGND.t1287 sg13_lv_nmos ad=0.1406p pd=1.12u as=0.1406p ps=1.12u w=0.74u l=0.13u
X4138 VPWR.t1964 sg13cmos5l_inv_16_67.A sg13cmos5l_inv_16_65.Y VPWR.t9 sg13_lv_pmos ad=0.2128p pd=1.5u as=0.2128p ps=1.5u w=1.12u l=0.13u
X4139 VPWR.t1284 sg13cmos5l_inv_16_68.A sg13cmos5l_inv_16_66.Y VPWR.t9 sg13_lv_pmos ad=0.2128p pd=1.5u as=0.2128p ps=1.5u w=1.12u l=0.13u
X4140 sg13cmos5l_inv_16_29.Y sg13cmos5l_inv_16_29.A VPWR.t707 VPWR.t177 sg13_lv_pmos ad=0.2128p pd=1.5u as=0.2128p ps=1.5u w=1.12u l=0.13u
X4141 VGND.t705 sg13cmos5l_inv_16_29.A sg13cmos5l_inv_16_29.Y VGND.t714 sg13_lv_nmos ad=0.1406p pd=1.12u as=0.1406p ps=1.12u w=0.74u l=0.13u
X4142 sg13cmos5l_inv_16_20.Y sg13cmos5l_inv_16_20.A VGND.t447 VGND.t466 sg13_lv_nmos ad=0.1406p pd=1.12u as=0.1406p ps=1.12u w=0.74u l=0.13u
X4143 sg13cmos5l_inv_16_9.Y sg13cmos5l_inv_16_9.A VPWR.t1157 VPWR.t4 sg13_lv_pmos ad=0.2128p pd=1.5u as=0.2128p ps=1.5u w=1.12u l=0.13u
X4144 VPWR.t2138 sg13cmos5l_inv_16_46.A sg13cmos5l_inv_16_46.Y VPWR.t25 sg13_lv_pmos ad=0.2128p pd=1.5u as=0.2128p ps=1.5u w=1.12u l=0.13u
X4145 VGND.t882 VPWR.t2579 VGND.t882 VGND.t881 sg13_lv_nmos ad=0.1428p pd=1.52u as=0 ps=0 w=0.42u l=1u
X4146 sg13cmos5l_inv_16_84.A sg13cmos5l_inv_16_81.Y VPWR.t1431 VPWR.t9 sg13_lv_pmos ad=0.2128p pd=1.5u as=0.4368p ps=3.02u w=1.12u l=0.13u
X4147 sg13cmos5l_inv_16_55.Y sg13cmos5l_inv_16_101.Y VPWR.t2337 VPWR.t25 sg13_lv_pmos ad=0.2128p pd=1.5u as=0.4368p ps=3.02u w=1.12u l=0.13u
X4148 sg13cmos5l_inv_16_47.Y sg13cmos5l_inv_16_47.A VGND.t20 VGND.t2226 sg13_lv_nmos ad=0.1406p pd=1.12u as=0.1406p ps=1.12u w=0.74u l=0.13u
X4149 VPWR.t725 sg13cmos5l_inv_16_4.Y sg13cmos5l_inv_16_8.Y VPWR.t4 sg13_lv_pmos ad=0.2128p pd=1.5u as=0.2128p ps=1.5u w=1.12u l=0.13u
X4150 VPWR.t182 VGND.t146 VPWR.t181 VPWR.t4 sg13_lv_pmos ad=0.34p pd=2.68u as=0 ps=0 w=1u l=1u
X4151 VGND.t922 VPWR.t2592 VGND.t922 VGND.t881 sg13_lv_nmos ad=0.1428p pd=1.52u as=0 ps=0 w=0.42u l=1u
X4152 VGND.t1 sg13cmos5l_inv_16_99.A sg13cmos5l_inv_16_99.Y VGND.t789 sg13_lv_nmos ad=0.2516p pd=2.16u as=0.1406p ps=1.12u w=0.74u l=0.13u
X4153 VPWR.t1814 sg13cmos5l_inv_8_1.A sg13cmos5l_inv_8_1.Y VPWR.t177 sg13_lv_pmos ad=0.2128p pd=1.5u as=0.2128p ps=1.5u w=1.12u l=0.13u
X4154 VPWR.t1590 sg13cmos5l_inv_16_61.A sg13cmos5l_inv_16_61.Y VPWR.t9 sg13_lv_pmos ad=0.2128p pd=1.5u as=0.2128p ps=1.5u w=1.12u l=0.13u
X4155 VPWR.t508 sg13cmos5l_inv_16_23.Y sg13cmos5l_inv_16_14.A VPWR.t0 sg13_lv_pmos ad=0.2128p pd=1.5u as=0.2128p ps=1.5u w=1.12u l=0.13u
X4156 sg13cmos5l_inv_16_15.Y sg13cmos5l_inv_16_15.A VPWR.t955 VPWR.t4 sg13_lv_pmos ad=0.2128p pd=1.5u as=0.2128p ps=1.5u w=1.12u l=0.13u
X4157 VPWR.t1320 sg13cmos5l_inv_16_69.Y sg13cmos5l_inv_16_58.Y VPWR.t9 sg13_lv_pmos ad=0.2128p pd=1.5u as=0.2128p ps=1.5u w=1.12u l=0.13u
X4158 VGND.t953 VPWR.t2542 VGND.t953 VGND.t380 sg13_lv_nmos ad=0.1428p pd=1.52u as=0 ps=0 w=0.42u l=1u
X4159 sg13cmos5l_inv_16_104.Y sg13cmos5l_inv_16_14.A VGND.t472 VGND.t473 sg13_lv_nmos ad=0.1406p pd=1.12u as=0.1406p ps=1.12u w=0.74u l=0.13u
X4160 VPWR.t2168 sg13cmos5l_inv_16_79.A sg13cmos5l_inv_16_79.Y VPWR.t16 sg13_lv_pmos ad=0.2128p pd=1.5u as=0.2128p ps=1.5u w=1.12u l=0.13u
X4161 VPWR.t1192 sg13cmos5l_inv_16_99.A sg13cmos5l_inv_16_51.Y VPWR.t25 sg13_lv_pmos ad=0.2128p pd=1.5u as=0.2128p ps=1.5u w=1.12u l=0.13u
X4162 VPWR.t1500 sg13cmos5l_inv_16_84.A sg13cmos5l_inv_16_84.Y VPWR.t9 sg13_lv_pmos ad=0.2128p pd=1.5u as=0.2128p ps=1.5u w=1.12u l=0.13u
X4163 VGND.t898 sg13cmos5l_inv_16_94.A sg13cmos5l_inv_16_76.A VGND.t881 sg13_lv_nmos ad=0.1406p pd=1.12u as=0.1406p ps=1.12u w=0.74u l=0.13u
X4164 VPWR.t326 VGND.t1507 VPWR.t135 VPWR.t16 sg13_lv_pmos ad=0.19p pd=1.38u as=0 ps=0 w=1u l=1u
X4165 sg13cmos5l_inv_16_47.A sg13cmos5l_inv_16_46.A VPWR.t2119 VPWR.t16 sg13_lv_pmos ad=0.2128p pd=1.5u as=0.2128p ps=1.5u w=1.12u l=0.13u
X4166 sg13cmos5l_inv_16_75.A sg13cmos5l_inv_16_76.A VGND.t390 VGND.t380 sg13_lv_nmos ad=0.1406p pd=1.12u as=0.1406p ps=1.12u w=0.74u l=0.13u
X4167 VPWR.t707 sg13cmos5l_inv_16_29.A sg13cmos5l_inv_16_29.Y VPWR.t177 sg13_lv_pmos ad=0.2128p pd=1.5u as=0.2128p ps=1.5u w=1.12u l=0.13u
X4168 sg13cmos5l_inv_16_35.Y sg13cmos5l_inv_16_29.A VPWR.t1116 VPWR.t0 sg13_lv_pmos ad=0.2128p pd=1.5u as=0.2128p ps=1.5u w=1.12u l=0.13u
X4169 VGND.t45 sg13cmos5l_inv_16_23.Y sg13cmos5l_inv_16_15.A VGND.t48 sg13_lv_nmos ad=0.1406p pd=1.12u as=0.1406p ps=1.12u w=0.74u l=0.13u
X4170 VGND.t3 sg13cmos5l_inv_16_37.A sg13cmos5l_inv_16_37.Y VGND.t25 sg13_lv_nmos ad=0.1406p pd=1.12u as=0.1406p ps=1.12u w=0.74u l=0.13u
X4171 sg13cmos5l_inv_16_53.Y sg13cmos5l_inv_16_53.A VGND.t1680 VGND.t380 sg13_lv_nmos ad=0.1406p pd=1.12u as=0.1406p ps=1.12u w=0.74u l=0.13u
X4172 sg13cmos5l_inv_16_61.Y sg13cmos5l_inv_16_61.A VPWR.t1586 VPWR.t9 sg13_lv_pmos ad=0.2128p pd=1.5u as=0.2128p ps=1.5u w=1.12u l=0.13u
X4173 sg13cmos5l_inv_16_58.Y sg13cmos5l_inv_16_69.Y VPWR.t1316 VPWR.t9 sg13_lv_pmos ad=0.2128p pd=1.5u as=0.2128p ps=1.5u w=1.12u l=0.13u
X4174 VGND.t953 VPWR.t2559 VGND.t953 VGND.t380 sg13_lv_nmos ad=0.1428p pd=1.52u as=0 ps=0 w=0.42u l=1u
X4175 sg13cmos5l_inv_16_79.Y sg13cmos5l_inv_16_79.A VPWR.t2164 VPWR.t16 sg13_lv_pmos ad=0.2128p pd=1.5u as=0.2128p ps=1.5u w=1.12u l=0.13u
X4176 sg13cmos5l_inv_16_36.A sg13cmos5l_inv_16_43.Y VGND.t146 VGND.t183 sg13_lv_nmos ad=0.1406p pd=1.12u as=0.1406p ps=1.12u w=0.74u l=0.13u
X4177 VPWR.t998 sg13cmos5l_inv_16_8.Y sg13cmos5l_inv_16_9.A VPWR.t0 sg13_lv_pmos ad=0.2128p pd=1.5u as=0.2128p ps=1.5u w=1.12u l=0.13u
X4178 sg13cmos5l_inv_16_61.A sg13cmos5l_inv_16_71.Y VPWR.t1381 VPWR.t9 sg13_lv_pmos ad=0.2128p pd=1.5u as=0.2128p ps=1.5u w=1.12u l=0.13u
X4179 sg13cmos5l_inv_16_76.A sg13cmos5l_inv_16_94.A VGND.t1507 VGND.t881 sg13_lv_nmos ad=0.1406p pd=1.12u as=0.1406p ps=1.12u w=0.74u l=0.13u
X4180 sg13cmos5l_inv_16_41.A sg13cmos5l_inv_8_3.Y VGND.t226 VGND.t822 sg13_lv_nmos ad=0.1406p pd=1.12u as=0.1406p ps=1.12u w=0.74u l=0.13u
X4181 VPWR.t703 sg13cmos5l_inv_16_28.A sg13cmos5l_inv_16_44.A VPWR.t4 sg13_lv_pmos ad=0.2128p pd=1.5u as=0.2128p ps=1.5u w=1.12u l=0.13u
X4182 VPWR.t859 VGND.t1132 VPWR.t860 VPWR.t9 sg13_lv_pmos ad=0.19p pd=1.38u as=0 ps=0 w=1u l=1u
X4183 VPWR.t882 sg13cmos5l_inv_16_20.A sg13cmos5l_inv_16_22.Y VPWR.t0 sg13_lv_pmos ad=0.4368p pd=3.02u as=0.2128p ps=1.5u w=1.12u l=0.13u
X4184 sg13cmos5l_inv_16_36.Y sg13cmos5l_inv_16_36.A VGND.t146 VGND.t145 sg13_lv_nmos ad=0.1406p pd=1.12u as=0.2516p ps=2.16u w=0.74u l=0.13u
X4185 VPWR.t1577 sg13cmos5l_inv_16_61.A sg13cmos5l_inv_16_59.Y VPWR.t9 sg13_lv_pmos ad=0.2128p pd=1.5u as=0.2128p ps=1.5u w=1.12u l=0.13u
X4186 VGND.t1715 sg13cmos5l_inv_16_47.A sg13cmos5l_inv_16_45.Y VGND.t380 sg13_lv_nmos ad=0.2516p pd=2.16u as=0.1406p ps=1.12u w=0.74u l=0.13u
X4187 VPWR.t1114 sg13cmos5l_inv_16_29.A sg13cmos5l_inv_16_35.Y VPWR.t0 sg13_lv_pmos ad=0.2128p pd=1.5u as=0.2128p ps=1.5u w=1.12u l=0.13u
X4188 sg13cmos5l_inv_16_34.Y sg13cmos5l_inv_16_41.A VPWR.t656 VPWR.t0 sg13_lv_pmos ad=0.2128p pd=1.5u as=0.2128p ps=1.5u w=1.12u l=0.13u
X4189 sg13cmos5l_inv_16_103.A sg13cmos5l_inv_16_11.A VGND.t370 VGND.t371 sg13_lv_nmos ad=0.1406p pd=1.12u as=0.1406p ps=1.12u w=0.74u l=0.13u
X4190 sg13cmos5l_inv_16_14.Y sg13cmos5l_inv_16_14.A VPWR.t915 VPWR.t4 sg13_lv_pmos ad=0.2128p pd=1.5u as=0.2128p ps=1.5u w=1.12u l=0.13u
X4191 sg13cmos5l_inv_16_79.Y sg13cmos5l_inv_16_79.A VGND.t1792 VGND.t380 sg13_lv_nmos ad=0.1406p pd=1.12u as=0.1406p ps=1.12u w=0.74u l=0.13u
X4192 VPWR.t1939 sg13cmos5l_inv_16_111.A sg13cmos5l_inv_16_98.Y VPWR.t9 sg13_lv_pmos ad=0.4368p pd=3.02u as=0.2128p ps=1.5u w=1.12u l=0.13u
X4193 sg13cmos5l_inv_16_84.A sg13cmos5l_inv_16_81.Y VGND.t1029 VGND.t881 sg13_lv_nmos ad=0.1406p pd=1.12u as=0.1406p ps=1.12u w=0.74u l=0.13u
X4194 sg13cmos5l_inv_16_95.Y sg13cmos5l_inv_16_73.Y VPWR.t2189 VPWR.t16 sg13_lv_pmos ad=0.2128p pd=1.5u as=0.2128p ps=1.5u w=1.12u l=0.13u
X4195 VPWR.t982 sg13cmos5l_inv_16_8.Y sg13cmos5l_inv_16_20.A VPWR.t0 sg13_lv_pmos ad=0.2128p pd=1.5u as=0.2128p ps=1.5u w=1.12u l=0.13u
X4196 VPWR.t1088 sg13cmos5l_inv_16_1.A sg13cmos5l_inv_16_17.A VPWR.t177 sg13_lv_pmos ad=0.2128p pd=1.5u as=0.2128p ps=1.5u w=1.12u l=0.13u
X4197 VGND.t1718 sg13cmos5l_inv_16_46.A sg13cmos5l_inv_16_47.A VGND.t380 sg13_lv_nmos ad=0.1406p pd=1.12u as=0.1406p ps=1.12u w=0.74u l=0.13u
X4198 VGND.t827 VPWR.t2468 VGND.t827 VGND.t2121 sg13_lv_nmos ad=0.1428p pd=1.52u as=0 ps=0 w=0.42u l=1u
X4199 VPWR.t2162 sg13cmos5l_inv_16_79.A sg13cmos5l_inv_16_79.Y VPWR.t16 sg13_lv_pmos ad=0.2128p pd=1.5u as=0.2128p ps=1.5u w=1.12u l=0.13u
X4200 sg13cmos5l_and2_1_2.X a_3597_916# VGND.t125 VGND.t124 sg13_lv_nmos ad=0.2516p pd=2.16u as=0.1331p ps=1.12u w=0.74u l=0.13u
X4201 VGND.t226 sg13cmos5l_inv_8_3.Y sg13cmos5l_inv_16_41.A VGND.t819 sg13_lv_nmos ad=0.1406p pd=1.12u as=0.1406p ps=1.12u w=0.74u l=0.13u
X4202 VPWR.t235 VGND.t162 VPWR.t234 VPWR.t0 sg13_lv_pmos ad=0.34p pd=2.68u as=0 ps=0 w=1u l=1u
X4203 sg13cmos5l_inv_8_0.Y sg13cmos5l_inv_4_0.Y VGND.t588 VGND.t1799 sg13_lv_nmos ad=0.1406p pd=1.12u as=0.1406p ps=1.12u w=0.74u l=0.13u
X4204 sg13cmos5l_inv_16_59.Y sg13cmos5l_inv_16_61.A VPWR.t1573 VPWR.t9 sg13_lv_pmos ad=0.2128p pd=1.5u as=0.2128p ps=1.5u w=1.12u l=0.13u
X4205 sg13cmos5l_inv_16_87.A sg13cmos5l_inv_16_73.A VGND.t1469 VGND.t1479 sg13_lv_nmos ad=0.1406p pd=1.12u as=0.1406p ps=1.12u w=0.74u l=0.13u
X4206 VGND.t291 sg13cmos5l_inv_16_11.A sg13cmos5l_inv_16_103.A VGND.t367 sg13_lv_nmos ad=0.1406p pd=1.12u as=0.1406p ps=1.12u w=0.74u l=0.13u
X4207 VGND.t472 sg13cmos5l_inv_16_77.A sg13cmos5l_inv_16_77.Y VGND.t2177 sg13_lv_nmos ad=0.2516p pd=2.16u as=0.1406p ps=1.12u w=0.74u l=0.13u
X4208 VPWR.t1139 sg13cmos5l_inv_16_9.A sg13cmos5l_inv_16_10.Y VPWR.t0 sg13_lv_pmos ad=0.2128p pd=1.5u as=0.2128p ps=1.5u w=1.12u l=0.13u
X4209 sg13cmos5l_inv_16_108.Y sg13cmos5l_inv_16_6.Y VGND.t635 VGND.t2357 sg13_lv_nmos ad=0.1406p pd=1.12u as=0.1406p ps=1.12u w=0.74u l=0.13u
X4210 sg13cmos5l_inv_16_30.A sg13cmos5l_inv_16_26.A VPWR.t1721 VPWR.t4 sg13_lv_pmos ad=0.2128p pd=1.5u as=0.2128p ps=1.5u w=1.12u l=0.13u
X4211 sg13cmos5l_inv_16_98.Y sg13cmos5l_inv_16_111.A VPWR.t1935 VPWR.t9 sg13_lv_pmos ad=0.2128p pd=1.5u as=0.2128p ps=1.5u w=1.12u l=0.13u
X4212 VGND.t1029 sg13cmos5l_inv_16_73.Y sg13cmos5l_inv_16_90.Y VGND.t881 sg13_lv_nmos ad=0.1406p pd=1.12u as=0.1406p ps=1.12u w=0.74u l=0.13u
X4213 sg13cmos5l_inv_16_71.Y sg13cmos5l_inv_16_56.Y VPWR.t2040 VPWR.t16 sg13_lv_pmos ad=0.2128p pd=1.5u as=0.2128p ps=1.5u w=1.12u l=0.13u
X4214 VPWR.t937 sg13cmos5l_inv_16_15.A sg13cmos5l_inv_16_13.Y VPWR.t0 sg13_lv_pmos ad=0.2128p pd=1.5u as=0.2128p ps=1.5u w=1.12u l=0.13u
X4215 sg13cmos5l_inv_16_52.Y sg13cmos5l_inv_16_56.Y VGND.t1663 VGND.t380 sg13_lv_nmos ad=0.1406p pd=1.12u as=0.2516p ps=2.16u w=0.74u l=0.13u
X4216 VGND.t1100 VPWR.t2519 VGND.t1100 VGND.t2028 sg13_lv_nmos ad=0.1428p pd=1.52u as=0 ps=0 w=0.42u l=1u
X4217 VPWR.t1600 sg13cmos5l_inv_1_3.Y sg13cmos5l_inv_2_7.Y VPWR.t0 sg13_lv_pmos ad=0.3808p pd=2.92u as=0.2128p ps=1.5u w=1.12u l=0.13u
X4218 sg13cmos5l_inv_16_20.Y sg13cmos5l_inv_16_20.A VGND.t375 VGND.t462 sg13_lv_nmos ad=0.1406p pd=1.12u as=0.1406p ps=1.12u w=0.74u l=0.13u
X4219 sg13cmos5l_inv_16_9.Y sg13cmos5l_inv_16_9.A VPWR.t1153 VPWR.t4 sg13_lv_pmos ad=0.2128p pd=1.5u as=0.2128p ps=1.5u w=1.12u l=0.13u
X4220 sg13cmos5l_inv_16_41.A sg13cmos5l_inv_8_3.Y VGND.t226 VGND.t816 sg13_lv_nmos ad=0.1406p pd=1.12u as=0.1406p ps=1.12u w=0.74u l=0.13u
X4221 VGND.t1469 sg13cmos5l_inv_16_73.A sg13cmos5l_inv_16_87.A VGND.t1476 sg13_lv_nmos ad=0.1406p pd=1.12u as=0.1406p ps=1.12u w=0.74u l=0.13u
X4222 sg13cmos5l_and2_1_4.X a_6957_3492# VPWR.t686 VPWR.t4 sg13_lv_pmos ad=0.3808p pd=2.92u as=0.1918p ps=1.5u w=1.12u l=0.13u
X4223 VGND.t353 sg13cmos5l_inv_16_11.A sg13cmos5l_inv_16_105.A VGND.t355 sg13_lv_nmos ad=0.1406p pd=1.12u as=0.1406p ps=1.12u w=0.74u l=0.13u
X4224 sg13cmos5l_inv_16_103.A sg13cmos5l_inv_16_11.A VGND.t291 VGND.t364 sg13_lv_nmos ad=0.1406p pd=1.12u as=0.1406p ps=1.12u w=0.74u l=0.13u
X4225 VGND.t756 sg13cmos5l_inv_16_111.A sg13cmos5l_inv_16_111.Y VGND.t380 sg13_lv_nmos ad=0.1406p pd=1.12u as=0.1406p ps=1.12u w=0.74u l=0.13u
X4226 sg13cmos5l_inv_16_47.Y sg13cmos5l_inv_16_47.A VGND.t15 VGND.t2222 sg13_lv_nmos ad=0.1406p pd=1.12u as=0.1406p ps=1.12u w=0.74u l=0.13u
X4227 VGND.t635 sg13cmos5l_inv_16_6.Y sg13cmos5l_inv_16_108.Y VGND.t2354 sg13_lv_nmos ad=0.1406p pd=1.12u as=0.1406p ps=1.12u w=0.74u l=0.13u
X4228 sg13cmos5l_inv_16_110.Y sg13cmos5l_inv_16_5.Y VGND.t637 VGND.t642 sg13_lv_nmos ad=0.1406p pd=1.12u as=0.1406p ps=1.12u w=0.74u l=0.13u
X4229 VPWR.t1719 sg13cmos5l_inv_16_26.A sg13cmos5l_inv_16_30.A VPWR.t4 sg13_lv_pmos ad=0.2128p pd=1.5u as=0.2128p ps=1.5u w=1.12u l=0.13u
X4230 VGND.t756 sg13cmos5l_inv_8_7.Y sg13cmos5l_inv_16_48.A VGND.t380 sg13_lv_nmos ad=0.2516p pd=2.16u as=0.1406p ps=1.12u w=0.74u l=0.13u
X4231 VPWR.t1205 sg13cmos5l_inv_16_99.A sg13cmos5l_inv_16_99.Y VPWR.t0 sg13_lv_pmos ad=0.2128p pd=1.5u as=0.2128p ps=1.5u w=1.12u l=0.13u
X4232 VPWR.t1933 sg13cmos5l_inv_16_111.A sg13cmos5l_inv_16_98.Y VPWR.t9 sg13_lv_pmos ad=0.2128p pd=1.5u as=0.2128p ps=1.5u w=1.12u l=0.13u
X4233 sg13cmos5l_inv_16_79.A sg13cmos5l_inv_16_81.Y VPWR.t1454 VPWR.t16 sg13_lv_pmos ad=0.2128p pd=1.5u as=0.2128p ps=1.5u w=1.12u l=0.13u
X4234 sg13cmos5l_inv_16_45.Y sg13cmos5l_inv_16_47.A VPWR.t2293 VPWR.t16 sg13_lv_pmos ad=0.2128p pd=1.5u as=0.2128p ps=1.5u w=1.12u l=0.13u
X4235 sg13cmos5l_inv_16_31.Y sg13cmos5l_inv_16_30.A VPWR.t178 VPWR.t177 sg13_lv_pmos ad=0.2128p pd=1.5u as=0.2128p ps=1.5u w=1.12u l=0.13u
X4236 sg13cmos5l_inv_16_15.Y sg13cmos5l_inv_16_15.A VPWR.t951 VPWR.t4 sg13_lv_pmos ad=0.2128p pd=1.5u as=0.2128p ps=1.5u w=1.12u l=0.13u
X4237 VGND.t1260 sg13cmos5l_inv_16_6.Y sg13cmos5l_inv_16_25.Y VGND.t2340 sg13_lv_nmos ad=0.1406p pd=1.12u as=0.1406p ps=1.12u w=0.74u l=0.13u
X4238 sg13cmos5l_inv_2_6.Y sg13cmos5l_inv_1_7.Y VPWR.t864 VPWR.t0 sg13_lv_pmos ad=0.2128p pd=1.5u as=0.3808p ps=2.92u w=1.12u l=0.13u
X4239 sg13cmos5l_inv_16_2.A sg13cmos5l_inv_16_1.A VPWR.t1079 VPWR.t4 sg13_lv_pmos ad=0.2128p pd=1.5u as=0.2128p ps=1.5u w=1.12u l=0.13u
X4240 sg13cmos5l_inv_16_13.Y sg13cmos5l_inv_16_15.A VPWR.t933 VPWR.t0 sg13_lv_pmos ad=0.2128p pd=1.5u as=0.2128p ps=1.5u w=1.12u l=0.13u
X4241 sg13cmos5l_inv_16_99.A sg13cmos5l_inv_16_34.Y VGND.t593 VGND.t592 sg13_lv_nmos ad=0.1406p pd=1.12u as=0.2516p ps=2.16u w=0.74u l=0.13u
X4242 VGND.t2108 VPWR.t2474 VGND.t423 VGND.t2107 sg13_lv_nmos ad=0.1428p pd=1.52u as=0 ps=0 w=0.42u l=1u
X4243 sg13cmos5l_inv_16_6.Y sg13cmos5l_inv_16_6.A VGND.t862 VGND.t1405 sg13_lv_nmos ad=0.1406p pd=1.12u as=0.1406p ps=1.12u w=0.74u l=0.13u
X4244 VPWR.t1446 sg13cmos5l_inv_16_81.Y sg13cmos5l_inv_16_84.A VPWR.t9 sg13_lv_pmos ad=0.3808p pd=2.92u as=0.2128p ps=1.5u w=1.12u l=0.13u
X4245 sg13cmos5l_inv_16_47.A sg13cmos5l_inv_16_46.A VPWR.t2115 VPWR.t16 sg13_lv_pmos ad=0.2128p pd=1.5u as=0.2128p ps=1.5u w=1.12u l=0.13u
X4246 VGND.t882 sg13cmos5l_inv_16_71.Y sg13cmos5l_inv_16_68.A VGND.t881 sg13_lv_nmos ad=0.1406p pd=1.12u as=0.1406p ps=1.12u w=0.74u l=0.13u
X4247 VGND.t637 sg13cmos5l_inv_16_5.Y sg13cmos5l_inv_16_110.Y VGND.t639 sg13_lv_nmos ad=0.1406p pd=1.12u as=0.1406p ps=1.12u w=0.74u l=0.13u
X4248 VPWR.t1452 sg13cmos5l_inv_16_81.Y sg13cmos5l_inv_16_79.A VPWR.t16 sg13_lv_pmos ad=0.2128p pd=1.5u as=0.2128p ps=1.5u w=1.12u l=0.13u
X4249 sg13cmos5l_inv_16_58.Y sg13cmos5l_inv_16_69.Y VPWR.t1312 VPWR.t9 sg13_lv_pmos ad=0.2128p pd=1.5u as=0.2128p ps=1.5u w=1.12u l=0.13u
X4250 VPWR.t751 sg13cmos5l_inv_16_4.Y sg13cmos5l_inv_16_6.A VPWR.t4 sg13_lv_pmos ad=0.2128p pd=1.5u as=0.2128p ps=1.5u w=1.12u l=0.13u
X4251 sg13cmos5l_inv_16_44.Y sg13cmos5l_inv_16_44.A VGND.t198 VGND.t206 sg13_lv_nmos ad=0.1406p pd=1.12u as=0.1406p ps=1.12u w=0.74u l=0.13u
X4252 sg13cmos5l_inv_16_76.A sg13cmos5l_inv_16_94.A VGND.t1507 VGND.t881 sg13_lv_nmos ad=0.1406p pd=1.12u as=0.1406p ps=1.12u w=0.74u l=0.13u
X4253 sg13cmos5l_inv_16_46.A sg13cmos5l_inv_16_48.A VGND.t1718 VGND.t380 sg13_lv_nmos ad=0.1406p pd=1.12u as=0.1406p ps=1.12u w=0.74u l=0.13u
X4254 VGND.t432 sg13cmos5l_inv_4_4.Y sg13cmos5l_inv_8_7.Y VGND.t631 sg13_lv_nmos ad=0.1406p pd=1.12u as=0.1406p ps=1.12u w=0.74u l=0.13u
X4255 VGND.t545 sg13cmos5l_inv_16_96.A sg13cmos5l_inv_16_96.Y VGND.t946 sg13_lv_nmos ad=0.1406p pd=1.12u as=0.1406p ps=1.12u w=0.74u l=0.13u
X4256 VPWR.t1 osc[3] a_2920_4656# VPWR.t0 sg13_lv_pmos ad=0.2114p pd=1.54u as=0.2856p ps=2.36u w=0.84u l=0.13u
X4257 VGND.t450 VPWR.t2500 VGND.t450 VGND.t2060 sg13_lv_nmos ad=0.1428p pd=1.52u as=0 ps=0 w=0.42u l=1u
X4258 VPWR.t2113 sg13cmos5l_inv_16_46.A sg13cmos5l_inv_16_47.A VPWR.t16 sg13_lv_pmos ad=0.2128p pd=1.5u as=0.2128p ps=1.5u w=1.12u l=0.13u
X4259 VGND.t1715 sg13cmos5l_inv_16_47.A sg13cmos5l_inv_16_45.Y VGND.t380 sg13_lv_nmos ad=0.1406p pd=1.12u as=0.1406p ps=1.12u w=0.74u l=0.13u
X4260 VPWR.t572 sg13cmos5l_inv_16_36.A sg13cmos5l_inv_16_100.Y VPWR.t0 sg13_lv_pmos ad=0.4368p pd=3.02u as=0.2128p ps=1.5u w=1.12u l=0.13u
X4261 sg13cmos5l_inv_16_110.Y sg13cmos5l_inv_16_5.Y VGND.t635 VGND.t634 sg13_lv_nmos ad=0.1406p pd=1.12u as=0.2516p ps=2.16u w=0.74u l=0.13u
X4262 VPWR.t421 VGND.t450 VPWR.t420 VPWR.t4 sg13_lv_pmos ad=0.34p pd=2.68u as=0 ps=0 w=1u l=1u
X4263 sg13cmos5l_inv_16_20.Y sg13cmos5l_inv_16_20.A VGND.t375 VGND.t458 sg13_lv_nmos ad=0.1406p pd=1.12u as=0.1406p ps=1.12u w=0.74u l=0.13u
X4264 VGND.t1241 osc[5] a_2920_7680# VGND.t881 sg13_lv_nmos ad=0.14875p pd=1.16u as=0.187p ps=1.78u w=0.55u l=0.13u
X4265 VGND.t345 sg13cmos5l_inv_16_11.A sg13cmos5l_inv_16_105.A VGND.t350 sg13_lv_nmos ad=0.1406p pd=1.12u as=0.1406p ps=1.12u w=0.74u l=0.13u
X4266 VGND.t1680 sg13cmos5l_inv_16_53.A sg13cmos5l_inv_16_53.Y VGND.t380 sg13_lv_nmos ad=0.1406p pd=1.12u as=0.1406p ps=1.12u w=0.74u l=0.13u
X4267 sg13cmos5l_inv_16_103.Y sg13cmos5l_inv_16_103.A VPWR.t1609 VPWR.t0 sg13_lv_pmos ad=0.2128p pd=1.5u as=0.2128p ps=1.5u w=1.12u l=0.13u
X4268 VPWR.t2370 sg13cmos5l_inv_8_4.Y sg13cmos5l_inv_16_56.Y VPWR.t25 sg13_lv_pmos ad=0.4368p pd=3.02u as=0.2128p ps=1.5u w=1.12u l=0.13u
X4269 sg13cmos5l_inv_16_30.Y sg13cmos5l_inv_16_30.A VPWR.t480 VPWR.t177 sg13_lv_pmos ad=0.2128p pd=1.5u as=0.2128p ps=1.5u w=1.12u l=0.13u
X4270 sg13cmos5l_inv_16_6.A sg13cmos5l_inv_16_4.Y VPWR.t747 VPWR.t4 sg13_lv_pmos ad=0.2128p pd=1.5u as=0.2128p ps=1.5u w=1.12u l=0.13u
X4271 sg13cmos5l_inv_16_94.A sg13cmos5l_inv_16_88.A VGND.t898 VGND.t881 sg13_lv_nmos ad=0.1406p pd=1.12u as=0.1406p ps=1.12u w=0.74u l=0.13u
X4272 sg13cmos5l_inv_16_45.Y sg13cmos5l_inv_16_47.A VPWR.t2289 VPWR.t16 sg13_lv_pmos ad=0.2128p pd=1.5u as=0.2128p ps=1.5u w=1.12u l=0.13u
X4273 VGND.t1715 sg13cmos5l_inv_16_46.A sg13cmos5l_inv_16_47.A VGND.t380 sg13_lv_nmos ad=0.1406p pd=1.12u as=0.1406p ps=1.12u w=0.74u l=0.13u
X4274 sg13cmos5l_inv_16_105.A sg13cmos5l_inv_16_11.A VPWR.t780 VPWR.t25 sg13_lv_pmos ad=0.2128p pd=1.5u as=0.2128p ps=1.5u w=1.12u l=0.13u
X4275 a_20397_1980# sg13cmos5l_buf_1_2.X VPWR.t1013 VPWR.t177 sg13_lv_pmos ad=0.1596p pd=1.22u as=0.2856p ps=2.36u w=0.84u l=0.13u
X4276 sg13cmos5l_inv_1_0.Y sg13cmos5l_and2_1_0.X VPWR.t329 VPWR.t177 sg13_lv_pmos ad=0.3808p pd=2.92u as=0.3808p ps=2.92u w=1.12u l=0.13u
X4277 VGND.t198 sg13cmos5l_inv_16_44.A sg13cmos5l_inv_16_44.Y VGND.t203 sg13_lv_nmos ad=0.1406p pd=1.12u as=0.1406p ps=1.12u w=0.74u l=0.13u
X4278 VGND.t1879 VPWR.t2603 VGND.t1879 VGND.t1880 sg13_lv_nmos ad=79.8f pd=0.8u as=0 ps=0 w=0.42u l=1u
X4279 VPWR.t2312 sg13cmos5l_inv_16_47.A sg13cmos5l_inv_16_47.Y VPWR.t25 sg13_lv_pmos ad=0.2128p pd=1.5u as=0.2128p ps=1.5u w=1.12u l=0.13u
X4280 VPWR.t274 VGND.t1469 VPWR.t273 VPWR.t9 sg13_lv_pmos ad=0.34p pd=2.68u as=0 ps=0 w=1u l=1u
X4281 VPWR.t1054 sg13cmos5l_inv_4_4.Y sg13cmos5l_inv_8_7.Y VPWR.t25 sg13_lv_pmos ad=0.3808p pd=2.92u as=0.2184p ps=1.51u w=1.12u l=0.13u
X4282 sg13cmos5l_inv_16_45.Y sg13cmos5l_inv_16_47.A VGND.t1944 VGND.t380 sg13_lv_nmos ad=0.1406p pd=1.12u as=0.1406p ps=1.12u w=0.74u l=0.13u
X4283 VPWR.t1183 sg13cmos5l_inv_8_7.Y sg13cmos5l_inv_16_48.A VPWR.t25 sg13_lv_pmos ad=0.2128p pd=1.5u as=0.2128p ps=1.5u w=1.12u l=0.13u
X4284 VGND.t1132 sg13cmos5l_inv_16_67.A sg13cmos5l_inv_16_67.Y VGND.t881 sg13_lv_nmos ad=0.1406p pd=1.12u as=0.1406p ps=1.12u w=0.74u l=0.13u
X4285 sg13cmos5l_inv_16_100.Y sg13cmos5l_inv_16_36.A VPWR.t568 VPWR.t0 sg13_lv_pmos ad=0.2128p pd=1.5u as=0.2128p ps=1.5u w=1.12u l=0.13u
X4286 VGND.t1147 sg13cmos5l_inv_16_109.Y sg13cmos5l_inv_16_111.A VGND.t881 sg13_lv_nmos ad=0.1406p pd=1.12u as=0.1406p ps=1.12u w=0.74u l=0.13u
X4287 sg13cmos5l_inv_4_6.A sg13cmos5l_inv_1_5.Y VGND.t381 VGND.t380 sg13_lv_nmos ad=0.1406p pd=1.12u as=0.2516p ps=2.16u w=0.74u l=0.13u
X4288 VGND.t882 sg13cmos5l_inv_16_71.Y sg13cmos5l_inv_16_68.A VGND.t881 sg13_lv_nmos ad=0.1406p pd=1.12u as=0.1406p ps=1.12u w=0.74u l=0.13u
X4289 VPWR.t1941 sg13cmos5l_inv_16_111.A sg13cmos5l_inv_16_111.Y VPWR.t16 sg13_lv_pmos ad=0.2128p pd=1.5u as=0.2128p ps=1.5u w=1.12u l=0.13u
X4290 sg13cmos5l_inv_16_56.Y sg13cmos5l_inv_8_4.Y VPWR.t2366 VPWR.t25 sg13_lv_pmos ad=0.2128p pd=1.5u as=0.2128p ps=1.5u w=1.12u l=0.13u
X4291 VGND.t122 sg13cmos5l_inv_4_6.A sg13cmos5l_inv_4_6.Y VGND.t808 sg13_lv_nmos ad=0.2516p pd=2.16u as=0.1406p ps=1.12u w=0.74u l=0.13u
X4292 sg13cmos5l_inv_16_34.Y sg13cmos5l_inv_16_41.A VGND.t226 VGND.t233 sg13_lv_nmos ad=0.1406p pd=1.12u as=0.1406p ps=1.12u w=0.74u l=0.13u
X4293 sg13cmos5l_inv_16_77.A sg13cmos5l_inv_16_76.A VGND.t390 VGND.t380 sg13_lv_nmos ad=0.1406p pd=1.12u as=0.1406p ps=1.12u w=0.74u l=0.13u
X4294 VPWR.t480 sg13cmos5l_inv_16_30.A sg13cmos5l_inv_16_30.Y VPWR.t177 sg13_lv_pmos ad=0.2128p pd=1.5u as=0.2128p ps=1.5u w=1.12u l=0.13u
X4295 VPWR.t745 sg13cmos5l_inv_16_4.Y sg13cmos5l_inv_16_6.A VPWR.t4 sg13_lv_pmos ad=0.2128p pd=1.5u as=0.2128p ps=1.5u w=1.12u l=0.13u
X4296 VGND.t898 sg13cmos5l_inv_16_88.A sg13cmos5l_inv_16_94.A VGND.t881 sg13_lv_nmos ad=0.1406p pd=1.12u as=0.1406p ps=1.12u w=0.74u l=0.13u
X4297 VPWR.t767 sg13cmos5l_inv_16_26.A sg13cmos5l_inv_16_26.Y VPWR.t177 sg13_lv_pmos ad=0.2128p pd=1.5u as=0.2128p ps=1.5u w=1.12u l=0.13u
X4298 VPWR.t885 sg13cmos5l_inv_16_20.A sg13cmos5l_inv_16_20.Y VPWR.t4 sg13_lv_pmos ad=0.2128p pd=1.5u as=0.2128p ps=1.5u w=1.12u l=0.13u
X4299 sg13cmos5l_inv_4_2.Y sg13cmos5l_inv_2_3.Y VPWR.t480 VPWR.t177 sg13_lv_pmos ad=0.2128p pd=1.5u as=0.3808p ps=2.92u w=1.12u l=0.13u
X4300 VPWR.t287 VGND.t827 VPWR.t299 VPWR.t4 sg13_lv_pmos ad=0.34p pd=2.68u as=0 ps=0 w=1u l=1u
X4301 VGND.t1 sg13cmos5l_inv_16_99.A sg13cmos5l_inv_16_51.Y VGND.t789 sg13_lv_nmos ad=0.2516p pd=2.16u as=0.1406p ps=1.12u w=0.74u l=0.13u
X4302 VGND.t1243 sg13cmos5l_inv_16_27.Y sg13cmos5l_inv_16_26.A VGND.t1268 sg13_lv_nmos ad=0.1406p pd=1.12u as=0.1406p ps=1.12u w=0.74u l=0.13u
X4303 sg13cmos5l_inv_2_2.A sg13cmos5l_and2_1_3.X VGND.t326 VGND.t1227 sg13_lv_nmos ad=0.2516p pd=2.16u as=0.2516p ps=2.16u w=0.74u l=0.13u
X4304 VGND.t1469 sg13cmos5l_inv_16_73.A sg13cmos5l_inv_16_87.A VGND.t1472 sg13_lv_nmos ad=0.1406p pd=1.12u as=0.1406p ps=1.12u w=0.74u l=0.13u
X4305 VPWR.t2417 sg13cmos5l_inv_8_0.Y sg13cmos5l_inv_16_0.A VPWR.t177 sg13_lv_pmos ad=0.2128p pd=1.5u as=0.2128p ps=1.5u w=1.12u l=0.13u
X4306 sg13cmos5l_buf_1_8.X a_2920_908# VGND.t591 VGND.t590 sg13_lv_nmos ad=0.2886p pd=2.26u as=0.14875p ps=1.16u w=0.74u l=0.13u
X4307 sg13cmos5l_inv_16_111.A sg13cmos5l_inv_16_109.Y VGND.t1147 VGND.t881 sg13_lv_nmos ad=0.1406p pd=1.12u as=0.2516p ps=2.16u w=0.74u l=0.13u
X4308 VGND.t390 VPWR.t2555 VGND.t390 VGND.t380 sg13_lv_nmos ad=0.1428p pd=1.52u as=0 ps=0 w=0.42u l=1u
X4309 sg13cmos5l_inv_16_94.A sg13cmos5l_inv_16_88.A VPWR.t2024 VPWR.t9 sg13_lv_pmos ad=0.2128p pd=1.5u as=0.2128p ps=1.5u w=1.12u l=0.13u
X4310 sg13cmos5l_inv_16_68.Y sg13cmos5l_inv_16_68.A VGND.t882 VGND.t881 sg13_lv_nmos ad=0.1406p pd=1.12u as=0.1406p ps=1.12u w=0.74u l=0.13u
X4311 sg13cmos5l_inv_16_55.Y sg13cmos5l_inv_16_101.Y VGND.t1663 VGND.t380 sg13_lv_nmos ad=0.1406p pd=1.12u as=0.1406p ps=1.12u w=0.74u l=0.13u
X4312 sg13cmos5l_inv_16_41.A sg13cmos5l_inv_8_3.Y VPWR.t1226 VPWR.t4 sg13_lv_pmos ad=0.2128p pd=1.5u as=0.2128p ps=1.5u w=1.12u l=0.13u
X4313 sg13cmos5l_inv_16_96.A sg13cmos5l_inv_4_6.Y VPWR.t1364 VPWR.t25 sg13_lv_pmos ad=0.2128p pd=1.5u as=0.2128p ps=1.5u w=1.12u l=0.13u
X4314 VGND.t390 sg13cmos5l_inv_16_76.A sg13cmos5l_inv_16_77.A VGND.t380 sg13_lv_nmos ad=0.1406p pd=1.12u as=0.1406p ps=1.12u w=0.74u l=0.13u
X4315 sg13cmos5l_inv_8_7.Y sg13cmos5l_inv_4_4.Y VPWR.t1052 VPWR.t25 sg13_lv_pmos ad=0.2184p pd=1.51u as=0.2128p ps=1.5u w=1.12u l=0.13u
X4316 sg13cmos5l_inv_4_6.Y sg13cmos5l_inv_4_6.A VGND.t429 VGND.t805 sg13_lv_nmos ad=0.1406p pd=1.12u as=0.2516p ps=2.16u w=0.74u l=0.13u
X4317 VGND.t1245 sg13cmos5l_inv_16_6.Y sg13cmos5l_inv_16_25.Y VGND.t2336 sg13_lv_nmos ad=0.1406p pd=1.12u as=0.1406p ps=1.12u w=0.74u l=0.13u
X4318 sg13cmos5l_inv_16_2.A sg13cmos5l_inv_16_1.A VPWR.t1075 VPWR.t4 sg13_lv_pmos ad=0.2128p pd=1.5u as=0.2128p ps=1.5u w=1.12u l=0.13u
X4319 sg13cmos5l_inv_16_103.Y sg13cmos5l_inv_16_103.A VPWR.t1605 VPWR.t0 sg13_lv_pmos ad=0.2128p pd=1.5u as=0.2128p ps=1.5u w=1.12u l=0.13u
X4320 sg13cmos5l_inv_16_23.Y sg13cmos5l_inv_16_0.A VGND.t827 VGND.t831 sg13_lv_nmos ad=0.1406p pd=1.12u as=0.1406p ps=1.12u w=0.74u l=0.13u
X4321 VPWR.t138 VGND.t472 VPWR.t409 VPWR.t0 sg13_lv_pmos ad=0.34p pd=2.68u as=0 ps=0 w=1u l=1u
X4322 VPWR.t707 sg13cmos5l_inv_16_29.A sg13cmos5l_inv_16_29.Y VPWR.t177 sg13_lv_pmos ad=0.2128p pd=1.5u as=0.2128p ps=1.5u w=1.12u l=0.13u
X4323 sg13cmos5l_inv_16_26.A sg13cmos5l_inv_16_27.Y VGND.t1243 VGND.t1265 sg13_lv_nmos ad=0.1406p pd=1.12u as=0.1406p ps=1.12u w=0.74u l=0.13u
X4324 VGND.t1553 VPWR.t2599 VGND.t1553 VGND.t1889 sg13_lv_nmos ad=0.1428p pd=1.52u as=0 ps=0 w=0.42u l=1u
X4325 sg13cmos5l_inv_16_0.A sg13cmos5l_inv_8_0.Y VPWR.t2413 VPWR.t177 sg13_lv_pmos ad=0.2128p pd=1.5u as=0.2128p ps=1.5u w=1.12u l=0.13u
X4326 sg13cmos5l_inv_16_90.Y sg13cmos5l_inv_16_73.Y VPWR.t2203 VPWR.t16 sg13_lv_pmos ad=0.2128p pd=1.5u as=0.2128p ps=1.5u w=1.12u l=0.13u
X4327 VPWR.t2022 sg13cmos5l_inv_16_88.A sg13cmos5l_inv_16_94.A VPWR.t9 sg13_lv_pmos ad=0.2128p pd=1.5u as=0.2128p ps=1.5u w=1.12u l=0.13u
X4328 VPWR.t1362 sg13cmos5l_inv_4_6.Y sg13cmos5l_inv_16_96.A VPWR.t25 sg13_lv_pmos ad=0.2128p pd=1.5u as=0.2128p ps=1.5u w=1.12u l=0.13u
X4329 VPWR.t480 sg13cmos5l_inv_16_30.A sg13cmos5l_inv_16_31.Y VPWR.t177 sg13_lv_pmos ad=0.2128p pd=1.5u as=0.2128p ps=1.5u w=1.12u l=0.13u
X4330 VPWR.t184 VGND.t146 VPWR.t182 VPWR.t4 sg13_lv_pmos ad=0.19p pd=1.38u as=0 ps=0 w=1u l=1u
X4331 a_3691_916# sg13cmos5l_buf_1_8.X a_3597_916# VGND.t120 sg13_lv_nmos ad=0.1216p pd=1.02u as=0.2176p ps=1.96u w=0.64u l=0.13u
X4332 VGND.t845 sg13cmos5l_inv_16_0.A sg13cmos5l_inv_16_1.A VGND.t844 sg13_lv_nmos ad=0.1406p pd=1.12u as=0.1406p ps=1.12u w=0.74u l=0.13u
X4333 sg13cmos5l_inv_16_87.A sg13cmos5l_inv_16_73.A VPWR.t1854 VPWR.t9 sg13_lv_pmos ad=0.2128p pd=1.5u as=0.3808p ps=2.92u w=1.12u l=0.13u
X4334 VPWR.t415 VGND.t450 VPWR.t414 VPWR.t0 sg13_lv_pmos ad=0.34p pd=2.68u as=0 ps=0 w=1u l=1u
X4335 sg13cmos5l_inv_16_25.Y sg13cmos5l_inv_16_6.Y VGND.t1245 VGND.t2333 sg13_lv_nmos ad=0.1406p pd=1.12u as=0.1406p ps=1.12u w=0.74u l=0.13u
X4336 VPWR.t1073 sg13cmos5l_inv_16_1.A sg13cmos5l_inv_16_2.A VPWR.t4 sg13_lv_pmos ad=0.2128p pd=1.5u as=0.2128p ps=1.5u w=1.12u l=0.13u
X4337 sg13cmos5l_inv_16_2.A sg13cmos5l_inv_16_1.A VGND.t655 VGND.t665 sg13_lv_nmos ad=0.1406p pd=1.12u as=0.1406p ps=1.12u w=0.74u l=0.13u
X4338 VGND.t545 sg13cmos5l_inv_16_96.A sg13cmos5l_inv_16_96.Y VGND.t942 sg13_lv_nmos ad=0.1406p pd=1.12u as=0.1406p ps=1.12u w=0.74u l=0.13u
X4339 sg13cmos5l_inv_16_77.Y sg13cmos5l_inv_16_77.A VPWR.t2262 VPWR.t25 sg13_lv_pmos ad=0.2128p pd=1.5u as=0.2128p ps=1.5u w=1.12u l=0.13u
X4340 VGND.t827 sg13cmos5l_inv_16_0.A sg13cmos5l_inv_16_23.Y VGND.t828 sg13_lv_nmos ad=0.1406p pd=1.12u as=0.1406p ps=1.12u w=0.74u l=0.13u
X4341 sg13cmos5l_inv_16_111.A sg13cmos5l_inv_16_109.Y VPWR.t1555 VPWR.t9 sg13_lv_pmos ad=0.2128p pd=1.5u as=0.2128p ps=1.5u w=1.12u l=0.13u
X4342 VGND.t1164 sg13cmos5l_inv_16_52.Y sg13cmos5l_inv_16_53.A VGND.t881 sg13_lv_nmos ad=0.1406p pd=1.12u as=0.1406p ps=1.12u w=0.74u l=0.13u
X4343 VGND.t5 sg13cmos5l_inv_2_7.Y sg13cmos5l_inv_4_5.Y VGND.t416 sg13_lv_nmos ad=0.1406p pd=1.12u as=0.1406p ps=1.12u w=0.74u l=0.13u
X4344 sg13cmos5l_inv_16_68.A sg13cmos5l_inv_16_71.Y VPWR.t1384 VPWR.t9 sg13_lv_pmos ad=0.2128p pd=1.5u as=0.2128p ps=1.5u w=1.12u l=0.13u
X4345 VGND.t1243 sg13cmos5l_inv_16_27.Y sg13cmos5l_inv_16_26.A VGND.t1262 sg13_lv_nmos ad=0.1406p pd=1.12u as=0.1406p ps=1.12u w=0.74u l=0.13u
X4346 VPWR.t365 VGND.t423 VPWR.t364 VPWR.t4 sg13_lv_pmos ad=0.34p pd=2.68u as=0 ps=0 w=1u l=1u
X4347 sg13cmos5l_inv_16_85.Y sg13cmos5l_inv_16_84.A VGND.t1067 VGND.t1079 sg13_lv_nmos ad=0.1406p pd=1.12u as=0.1406p ps=1.12u w=0.74u l=0.13u
X4348 VPWR.t2411 sg13cmos5l_inv_8_0.Y sg13cmos5l_inv_16_0.A VPWR.t177 sg13_lv_pmos ad=0.2128p pd=1.5u as=0.2128p ps=1.5u w=1.12u l=0.13u
X4349 VPWR.t18 VGND.t882 VPWR.t17 VPWR.t16 sg13_lv_pmos ad=0.34p pd=2.68u as=0 ps=0 w=1u l=1u
X4350 sg13cmos5l_inv_16_46.A sg13cmos5l_inv_16_48.A VPWR.t2104 VPWR.t25 sg13_lv_pmos ad=0.2128p pd=1.5u as=0.2128p ps=1.5u w=1.12u l=0.13u
X4351 sg13cmos5l_inv_16_99.Y sg13cmos5l_inv_16_99.A VPWR.t1217 VPWR.t0 sg13_lv_pmos ad=0.2128p pd=1.5u as=0.2128p ps=1.5u w=1.12u l=0.13u
X4352 VPWR.t606 sg13cmos5l_inv_16_43.Y sg13cmos5l_inv_16_36.A VPWR.t0 sg13_lv_pmos ad=0.2128p pd=1.5u as=0.2128p ps=1.5u w=1.12u l=0.13u
X4353 sg13cmos5l_inv_16_94.A sg13cmos5l_inv_16_88.A VPWR.t2018 VPWR.t9 sg13_lv_pmos ad=0.2128p pd=1.5u as=0.2128p ps=1.5u w=1.12u l=0.13u
X4354 VGND.t381 sg13cmos5l_inv_16_73.A sg13cmos5l_inv_16_73.Y VGND.t380 sg13_lv_nmos ad=0.1406p pd=1.12u as=0.1406p ps=1.12u w=0.74u l=0.13u
X4355 sg13cmos5l_inv_16_29.A sg13cmos5l_inv_16_28.A VGND.t198 VGND.t206 sg13_lv_nmos ad=0.1406p pd=1.12u as=0.1406p ps=1.12u w=0.74u l=0.13u
X4356 VPWR.t818 sg13cmos5l_inv_16_75.A sg13cmos5l_inv_16_74.Y VPWR.t25 sg13_lv_pmos ad=0.4368p pd=3.02u as=0.2128p ps=1.5u w=1.12u l=0.13u
X4357 VPWR.t901 sg13cmos5l_inv_16_14.A sg13cmos5l_inv_16_104.Y VPWR.t0 sg13_lv_pmos ad=0.2128p pd=1.5u as=0.2128p ps=1.5u w=1.12u l=0.13u
X4358 VPWR.t246 sg13cmos5l_inv_16_6.A sg13cmos5l_inv_16_6.Y VPWR.t177 sg13_lv_pmos ad=0.2128p pd=1.5u as=0.2128p ps=1.5u w=1.12u l=0.13u
X4359 sg13cmos5l_inv_16_68.Y sg13cmos5l_inv_16_68.A VGND.t882 VGND.t881 sg13_lv_nmos ad=0.1406p pd=1.12u as=0.2516p ps=2.16u w=0.74u l=0.13u
X4360 sg13cmos5l_inv_16_76.A sg13cmos5l_inv_16_94.A VPWR.t1918 VPWR.t16 sg13_lv_pmos ad=0.2128p pd=1.5u as=0.2128p ps=1.5u w=1.12u l=0.13u
X4361 VPWR.t96 VGND.t953 VPWR.t95 VPWR.t25 sg13_lv_pmos ad=0.34p pd=2.68u as=0 ps=0 w=1u l=1u
X4362 VGND.t353 VPWR.t2532 VGND.t353 VGND.t2008 sg13_lv_nmos ad=79.8f pd=0.8u as=0 ps=0 w=0.42u l=1u
X4363 sg13cmos5l_inv_16_105.A sg13cmos5l_inv_16_11.A VPWR.t776 VPWR.t25 sg13_lv_pmos ad=0.2128p pd=1.5u as=0.2128p ps=1.5u w=1.12u l=0.13u
X4364 sg13cmos5l_inv_16_37.A sg13cmos5l_inv_16_43.Y VPWR.t602 VPWR.t0 sg13_lv_pmos ad=0.2128p pd=1.5u as=0.2128p ps=1.5u w=1.12u l=0.13u
X4365 VGND.t994 sg13cmos5l_inv_16_87.A sg13cmos5l_inv_16_93.Y VGND.t1009 sg13_lv_nmos ad=0.2516p pd=2.16u as=0.1406p ps=1.12u w=0.74u l=0.13u
X4366 VGND.t1970 sg13cmos5l_inv_16_76.A sg13cmos5l_inv_16_75.A VGND.t380 sg13_lv_nmos ad=0.2516p pd=2.16u as=0.1406p ps=1.12u w=0.74u l=0.13u
X4367 sg13cmos5l_inv_16_96.Y sg13cmos5l_inv_16_96.A VGND.t545 VGND.t939 sg13_lv_nmos ad=0.1406p pd=1.12u as=0.1406p ps=1.12u w=0.74u l=0.13u
X4368 VPWR.t844 sg13cmos5l_inv_16_27.A sg13cmos5l_inv_16_27.Y VPWR.t177 sg13_lv_pmos ad=0.4368p pd=3.02u as=0.2128p ps=1.5u w=1.12u l=0.13u
X4369 VPWR.t335 VGND.t2158 VPWR.t333 VPWR.t177 sg13_lv_pmos ad=0.19p pd=1.38u as=0 ps=0 w=1u l=1u
X4370 VPWR.t1553 sg13cmos5l_inv_16_109.Y sg13cmos5l_inv_16_111.A VPWR.t9 sg13_lv_pmos ad=0.2128p pd=1.5u as=0.2128p ps=1.5u w=1.12u l=0.13u
X4371 VGND.t1083 sg13cmos5l_inv_16_79.A sg13cmos5l_inv_16_91.Y VGND.t881 sg13_lv_nmos ad=0.1406p pd=1.12u as=0.1406p ps=1.12u w=0.74u l=0.13u
X4372 VPWR.t272 VGND.t242 VPWR.t272 VPWR.t177 sg13_lv_pmos ad=0.34p pd=2.68u as=0 ps=0 w=1u l=1u
X4373 VPWR.t1221 sg13cmos5l_inv_4_6.A sg13cmos5l_inv_4_6.Y VPWR.t25 sg13_lv_pmos ad=0.2128p pd=1.5u as=0.2128p ps=1.5u w=1.12u l=0.13u
X4374 VPWR.t1215 sg13cmos5l_inv_16_99.A sg13cmos5l_inv_16_99.Y VPWR.t0 sg13_lv_pmos ad=0.2128p pd=1.5u as=0.2128p ps=1.5u w=1.12u l=0.13u
X4375 VGND.t593 sg13cmos5l_inv_16_34.Y sg13cmos5l_inv_16_101.Y VGND.t602 sg13_lv_nmos ad=0.1406p pd=1.12u as=0.1406p ps=1.12u w=0.74u l=0.13u
X4376 sg13cmos5l_inv_16_43.Y sg13cmos5l_inv_16_27.Y VPWR.t1646 VPWR.t4 sg13_lv_pmos ad=0.2128p pd=1.5u as=0.2128p ps=1.5u w=1.12u l=0.13u
X4377 VGND.t198 sg13cmos5l_inv_16_28.A sg13cmos5l_inv_16_29.A VGND.t203 sg13_lv_nmos ad=0.1406p pd=1.12u as=0.1406p ps=1.12u w=0.74u l=0.13u
X4378 VGND.t353 sg13cmos5l_inv_16_103.A sg13cmos5l_inv_16_103.Y VGND.t361 sg13_lv_nmos ad=0.2516p pd=2.16u as=0.1406p ps=1.12u w=0.74u l=0.13u
X4379 sg13cmos5l_inv_16_104.Y sg13cmos5l_inv_16_14.A VPWR.t898 VPWR.t0 sg13_lv_pmos ad=0.2128p pd=1.5u as=0.3808p ps=2.92u w=1.12u l=0.13u
X4380 sg13cmos5l_inv_16_6.Y sg13cmos5l_inv_16_6.A VPWR.t246 VPWR.t177 sg13_lv_pmos ad=0.2128p pd=1.5u as=0.2128p ps=1.5u w=1.12u l=0.13u
X4381 VGND.t588 sg13cmos5l_inv_4_0.A sg13cmos5l_inv_4_0.Y VGND.t1575 sg13_lv_nmos ad=0.1406p pd=1.12u as=0.1406p ps=1.12u w=0.74u l=0.13u
X4382 VGND.t52 sg13cmos5l_inv_16_14.A sg13cmos5l_inv_16_14.Y VGND.t500 sg13_lv_nmos ad=0.2516p pd=2.16u as=0.1406p ps=1.12u w=0.74u l=0.13u
X4383 VGND.t1201 sg13cmos5l_inv_4_7.Y sg13cmos5l_inv_16_88.A VGND.t1225 sg13_lv_nmos ad=0.2516p pd=2.16u as=0.1443p ps=1.13u w=0.74u l=0.13u
X4384 VPWR.t1916 sg13cmos5l_inv_16_94.A sg13cmos5l_inv_16_76.A VPWR.t16 sg13_lv_pmos ad=0.2128p pd=1.5u as=0.2128p ps=1.5u w=1.12u l=0.13u
X4385 sg13cmos5l_inv_16_75.Y sg13cmos5l_inv_16_75.A VGND.t122 VGND.t401 sg13_lv_nmos ad=0.1406p pd=1.12u as=0.1406p ps=1.12u w=0.74u l=0.13u
X4386 sg13cmos5l_inv_16_37.A sg13cmos5l_inv_16_43.Y VGND.t3 VGND.t171 sg13_lv_nmos ad=0.1406p pd=1.12u as=0.1406p ps=1.12u w=0.74u l=0.13u
X4387 VGND.t705 sg13cmos5l_inv_16_29.A sg13cmos5l_inv_16_29.Y VGND.t720 sg13_lv_nmos ad=0.2516p pd=2.16u as=0.1406p ps=1.12u w=0.74u l=0.13u
X4388 VGND.t39 sg13cmos5l_inv_4_2.Y sg13cmos5l_inv_8_3.Y VGND.t1233 sg13_lv_nmos ad=0.1406p pd=1.12u as=0.1406p ps=1.12u w=0.74u l=0.13u
X4389 VPWR.t1480 sg13cmos5l_inv_16_84.A sg13cmos5l_inv_16_85.Y VPWR.t9 sg13_lv_pmos ad=0.2128p pd=1.5u as=0.2128p ps=1.5u w=1.12u l=0.13u
X4390 VPWR.t767 sg13cmos5l_inv_16_26.A sg13cmos5l_inv_16_26.Y VPWR.t177 sg13_lv_pmos ad=0.2128p pd=1.5u as=0.2128p ps=1.5u w=1.12u l=0.13u
X4391 VPWR.t600 sg13cmos5l_inv_16_43.Y sg13cmos5l_inv_16_37.A VPWR.t0 sg13_lv_pmos ad=0.2128p pd=1.5u as=0.2128p ps=1.5u w=1.12u l=0.13u
X4392 sg13cmos5l_inv_16_27.Y sg13cmos5l_inv_16_27.A VPWR.t844 VPWR.t177 sg13_lv_pmos ad=0.2128p pd=1.5u as=0.2128p ps=1.5u w=1.12u l=0.13u
X4393 sg13cmos5l_inv_16_28.A sg13cmos5l_inv_16_41.A VGND.t39 VGND.t247 sg13_lv_nmos ad=0.1406p pd=1.12u as=0.1406p ps=1.12u w=0.74u l=0.13u
X4394 sg13cmos5l_inv_16_93.Y sg13cmos5l_inv_16_87.A VGND.t994 VGND.t1006 sg13_lv_nmos ad=0.1406p pd=1.12u as=0.1406p ps=1.12u w=0.74u l=0.13u
X4395 sg13cmos5l_inv_16_50.Y sg13cmos5l_inv_16_46.Y VPWR.t2275 VPWR.t25 sg13_lv_pmos ad=0.2128p pd=1.5u as=0.2128p ps=1.5u w=1.12u l=0.13u
X4396 sg13cmos5l_inv_1_0.Y sg13cmos5l_and2_1_0.X VGND.t310 VGND.t1501 sg13_lv_nmos ad=0.2516p pd=2.16u as=0.2516p ps=2.16u w=0.74u l=0.13u
X4397 sg13cmos5l_inv_16_91.Y sg13cmos5l_inv_16_79.A VGND.t1083 VGND.t881 sg13_lv_nmos ad=0.1406p pd=1.12u as=0.1406p ps=1.12u w=0.74u l=0.13u
X4398 sg13cmos5l_inv_16_48.A sg13cmos5l_inv_8_7.Y VPWR.t1175 VPWR.t25 sg13_lv_pmos ad=0.2128p pd=1.5u as=0.2128p ps=1.5u w=1.12u l=0.13u
X4399 sg13cmos5l_inv_16_29.Y sg13cmos5l_inv_16_29.A VGND.t705 VGND.t715 sg13_lv_nmos ad=0.1406p pd=1.12u as=0.1406p ps=1.12u w=0.74u l=0.13u
X4400 VPWR.t329 sg13cmos5l_inv_1_0.Y sg13cmos5l_inv_2_1.Y VPWR.t177 sg13_lv_pmos ad=0.3864p pd=2.93u as=0.2128p ps=1.5u w=1.12u l=0.13u
X4401 VPWR.t1644 sg13cmos5l_inv_16_27.Y sg13cmos5l_inv_16_43.Y VPWR.t4 sg13_lv_pmos ad=0.2128p pd=1.5u as=0.2128p ps=1.5u w=1.12u l=0.13u
X4402 VPWR.t1974 sg13cmos5l_inv_16_67.A sg13cmos5l_inv_16_65.Y VPWR.t9 sg13_lv_pmos ad=0.2128p pd=1.5u as=0.2128p ps=1.5u w=1.12u l=0.13u
X4403 sg13cmos5l_inv_16_46.A sg13cmos5l_inv_16_48.A VPWR.t2100 VPWR.t25 sg13_lv_pmos ad=0.2128p pd=1.5u as=0.2128p ps=1.5u w=1.12u l=0.13u
X4404 VPWR.t408 VGND.t472 VPWR.t136 VPWR.t25 sg13_lv_pmos ad=0.34p pd=2.68u as=0 ps=0 w=1u l=1u
X4405 sg13cmos5l_inv_16_43.Y sg13cmos5l_inv_16_27.Y VGND.t1245 VGND.t1256 sg13_lv_nmos ad=0.1406p pd=1.12u as=0.1406p ps=1.12u w=0.74u l=0.13u
X4406 sg13cmos5l_inv_8_7.Y sg13cmos5l_inv_4_4.Y VPWR.t1048 VPWR.t25 sg13_lv_pmos ad=0.2128p pd=1.5u as=0.2128p ps=1.5u w=1.12u l=0.13u
X4407 sg13cmos5l_inv_16_96.Y sg13cmos5l_inv_16_96.A VPWR.t1348 VPWR.t25 sg13_lv_pmos ad=0.2128p pd=1.5u as=0.2128p ps=1.5u w=1.12u l=0.13u
X4408 VGND.t1944 VPWR.t2552 VGND.t1944 VGND.t380 sg13_lv_nmos ad=79.8f pd=0.8u as=0 ps=0 w=0.42u l=1u
X4409 VPWR.t201 VGND.t1 VPWR.t200 VPWR.t25 sg13_lv_pmos ad=0.34p pd=2.68u as=0 ps=0 w=1u l=1u
X4410 sg13cmos5l_inv_4_5.Y sg13cmos5l_inv_2_7.Y VPWR.t837 VPWR.t25 sg13_lv_pmos ad=0.2128p pd=1.5u as=0.2128p ps=1.5u w=1.12u l=0.13u
X4411 VGND.t122 sg13cmos5l_inv_16_75.A sg13cmos5l_inv_16_75.Y VGND.t398 sg13_lv_nmos ad=0.1406p pd=1.12u as=0.1406p ps=1.12u w=0.74u l=0.13u
X4412 VGND.t3 sg13cmos5l_inv_16_43.Y sg13cmos5l_inv_16_37.A VGND.t168 sg13_lv_nmos ad=0.1406p pd=1.12u as=0.1406p ps=1.12u w=0.74u l=0.13u
X4413 sg13cmos5l_inv_16_109.Y sg13cmos5l_inv_16_48.A VPWR.t2080 VPWR.t16 sg13_lv_pmos ad=0.2128p pd=1.5u as=0.2128p ps=1.5u w=1.12u l=0.13u
X4414 sg13cmos5l_inv_16_54.Y sg13cmos5l_inv_16_101.Y VGND.t1680 VGND.t380 sg13_lv_nmos ad=0.1406p pd=1.12u as=0.1406p ps=1.12u w=0.74u l=0.13u
X4415 sg13cmos5l_inv_16_61.Y sg13cmos5l_inv_16_61.A VGND.t1164 VGND.t881 sg13_lv_nmos ad=0.1406p pd=1.12u as=0.1406p ps=1.12u w=0.74u l=0.13u
X4416 sg13cmos5l_inv_16_17.Y sg13cmos5l_inv_16_17.A VPWR.t544 VPWR.t177 sg13_lv_pmos ad=0.2128p pd=1.5u as=0.2128p ps=1.5u w=1.12u l=0.13u
X4417 VPWR.t1774 sg13cmos5l_inv_2_2.Y sg13cmos5l_inv_8_2.A VPWR.t4 sg13_lv_pmos ad=0.2128p pd=1.5u as=0.2128p ps=1.5u w=1.12u l=0.13u
X4418 sg13cmos5l_inv_16_28.A sg13cmos5l_inv_16_41.A VPWR.t671 VPWR.t4 sg13_lv_pmos ad=0.2128p pd=1.5u as=0.2128p ps=1.5u w=1.12u l=0.13u
X4419 sg13cmos5l_inv_16_55.Y sg13cmos5l_inv_16_101.Y VPWR.t2346 VPWR.t25 sg13_lv_pmos ad=0.2128p pd=1.5u as=0.2128p ps=1.5u w=1.12u l=0.13u
X4420 VPWR.t2273 sg13cmos5l_inv_16_46.Y sg13cmos5l_inv_16_50.Y VPWR.t25 sg13_lv_pmos ad=0.2128p pd=1.5u as=0.2128p ps=1.5u w=1.12u l=0.13u
X4421 sg13cmos5l_inv_16_105.A sg13cmos5l_inv_16_11.A VPWR.t772 VPWR.t25 sg13_lv_pmos ad=0.2128p pd=1.5u as=0.2128p ps=1.5u w=1.12u l=0.13u
X4422 VGND.t655 sg13cmos5l_inv_16_2.A sg13cmos5l_inv_16_2.Y VGND.t1433 sg13_lv_nmos ad=0.1406p pd=1.12u as=0.1406p ps=1.12u w=0.74u l=0.13u
X4423 VGND.t1083 VPWR.t2576 VGND.t1147 VGND.t881 sg13_lv_nmos ad=0.1428p pd=1.52u as=0 ps=0 w=0.42u l=1u
X4424 VPWR.t1001 sg13cmos5l_inv_16_6.Y sg13cmos5l_inv_16_108.Y VPWR.t177 sg13_lv_pmos ad=0.2128p pd=1.5u as=0.2128p ps=1.5u w=1.12u l=0.13u
X4425 VPWR.t735 sg13cmos5l_inv_16_4.Y sg13cmos5l_inv_16_8.Y VPWR.t4 sg13_lv_pmos ad=0.2128p pd=1.5u as=0.2128p ps=1.5u w=1.12u l=0.13u
X4426 VPWR.t192 VGND.t1718 VPWR.t189 VPWR.t16 sg13_lv_pmos ad=0.19p pd=1.38u as=0 ps=0 w=1u l=1u
X4427 VGND.t1718 VPWR.t2564 VGND.t1718 VGND.t380 sg13_lv_nmos ad=79.8f pd=0.8u as=0 ps=0 w=0.42u l=1u
X4428 VPWR.t1631 sg13cmos5l_inv_2_5.Y sg13cmos5l_inv_4_7.Y VPWR.t9 sg13_lv_pmos ad=0.3808p pd=2.92u as=0.2128p ps=1.5u w=1.12u l=0.13u
X4429 VPWR.t1408 sg13cmos5l_inv_16_87.A sg13cmos5l_inv_16_93.Y VPWR.t9 sg13_lv_pmos ad=0.2128p pd=1.5u as=0.2128p ps=1.5u w=1.12u l=0.13u
X4430 sg13cmos5l_inv_16_43.Y sg13cmos5l_inv_16_27.Y VPWR.t1641 VPWR.t4 sg13_lv_pmos ad=0.2128p pd=1.5u as=0.3808p ps=2.92u w=1.12u l=0.13u
X4431 VPWR.t2098 sg13cmos5l_inv_16_48.A sg13cmos5l_inv_16_46.A VPWR.t25 sg13_lv_pmos ad=0.2128p pd=1.5u as=0.2128p ps=1.5u w=1.12u l=0.13u
X4432 sg13cmos5l_inv_16_74.Y sg13cmos5l_inv_16_75.A VGND.t381 VGND.t380 sg13_lv_nmos ad=0.1406p pd=1.12u as=0.1406p ps=1.12u w=0.74u l=0.13u
X4433 VPWR.t1346 sg13cmos5l_inv_16_96.A sg13cmos5l_inv_16_96.Y VPWR.t25 sg13_lv_pmos ad=0.2128p pd=1.5u as=0.2128p ps=1.5u w=1.12u l=0.13u
X4434 VGND.t1245 sg13cmos5l_inv_16_27.Y sg13cmos5l_inv_16_43.Y VGND.t1253 sg13_lv_nmos ad=0.1406p pd=1.12u as=0.1406p ps=1.12u w=0.74u l=0.13u
X4435 VGND.t1663 sg13cmos5l_inv_16_56.Y sg13cmos5l_inv_16_52.Y VGND.t380 sg13_lv_nmos ad=0.1406p pd=1.12u as=0.1406p ps=1.12u w=0.74u l=0.13u
X4436 VPWR.t1476 sg13cmos5l_inv_16_84.A sg13cmos5l_inv_16_85.Y VPWR.t9 sg13_lv_pmos ad=0.2128p pd=1.5u as=0.2128p ps=1.5u w=1.12u l=0.13u
X4437 VPWR.t2344 sg13cmos5l_inv_16_101.Y sg13cmos5l_inv_16_55.Y VPWR.t25 sg13_lv_pmos ad=0.2128p pd=1.5u as=0.2128p ps=1.5u w=1.12u l=0.13u
X4438 VPWR.t1167 sg13cmos5l_inv_16_9.A sg13cmos5l_inv_16_9.Y VPWR.t4 sg13_lv_pmos ad=0.4368p pd=3.02u as=0.2128p ps=1.5u w=1.12u l=0.13u
X4439 VGND.t259 sg13cmos5l_inv_16_29.A sg13cmos5l_inv_16_35.Y VGND.t267 sg13_lv_nmos ad=0.1406p pd=1.12u as=0.1406p ps=1.12u w=0.74u l=0.13u
X4440 sg13cmos5l_inv_16_108.Y sg13cmos5l_inv_16_6.Y VPWR.t1001 VPWR.t177 sg13_lv_pmos ad=0.2128p pd=1.5u as=0.2128p ps=1.5u w=1.12u l=0.13u
X4441 sg13cmos5l_inv_16_28.A sg13cmos5l_inv_16_41.A VGND.t242 VGND.t243 sg13_lv_nmos ad=0.1406p pd=1.12u as=0.1406p ps=1.12u w=0.74u l=0.13u
X4442 VGND.t3 sg13cmos5l_inv_16_37.A sg13cmos5l_inv_16_37.Y VGND.t35 sg13_lv_nmos ad=0.1406p pd=1.12u as=0.1406p ps=1.12u w=0.74u l=0.13u
X4443 VPWR.t1298 sg13cmos5l_inv_16_68.A sg13cmos5l_inv_16_68.Y VPWR.t16 sg13_lv_pmos ad=0.2128p pd=1.5u as=0.2128p ps=1.5u w=1.12u l=0.13u
X4444 VGND.t953 sg13cmos5l_inv_16_96.Y sg13cmos5l_inv_16_11.A VGND.t380 sg13_lv_nmos ad=0.1406p pd=1.12u as=0.1406p ps=1.12u w=0.74u l=0.13u
X4445 sg13cmos5l_inv_16_105.Y sg13cmos5l_inv_16_105.A VGND.t1100 VGND.t1104 sg13_lv_nmos ad=0.1406p pd=1.12u as=0.1406p ps=1.12u w=0.74u l=0.13u
X4446 VGND.t2123 sg13cmos5l_inv_8_0.Y sg13cmos5l_inv_16_0.A VGND.t2330 sg13_lv_nmos ad=0.2516p pd=2.16u as=0.1406p ps=1.12u w=0.74u l=0.13u
X4447 VGND.t1882 VPWR.t2602 VGND.t1580 VGND.t1881 sg13_lv_nmos ad=0.1428p pd=1.52u as=0 ps=0 w=0.42u l=1u
X4448 sg13cmos5l_inv_4_7.Y sg13cmos5l_inv_2_5.Y VPWR.t1628 VPWR.t9 sg13_lv_pmos ad=0.2128p pd=1.5u as=0.3808p ps=2.92u w=1.12u l=0.13u
X4449 VPWR.t2330 sg13cmos5l_inv_16_101.Y sg13cmos5l_inv_16_54.Y VPWR.t25 sg13_lv_pmos ad=0.2128p pd=1.5u as=0.2128p ps=1.5u w=1.12u l=0.13u
X4450 sg13cmos5l_inv_16_14.A sg13cmos5l_inv_16_23.Y VPWR.t516 VPWR.t0 sg13_lv_pmos ad=0.2128p pd=1.5u as=0.2128p ps=1.5u w=1.12u l=0.13u
X4451 sg13cmos5l_inv_16_27.A sg13cmos5l_inv_8_2.A VPWR.t1001 VPWR.t177 sg13_lv_pmos ad=0.2128p pd=1.5u as=0.2128p ps=1.5u w=1.12u l=0.13u
X4452 sg13cmos5l_inv_16_36.A sg13cmos5l_inv_16_43.Y VGND.t146 VGND.t193 sg13_lv_nmos ad=0.1406p pd=1.12u as=0.1406p ps=1.12u w=0.74u l=0.13u
X4453 sg13cmos5l_inv_16_25.Y sg13cmos5l_inv_16_6.Y VPWR.t844 VPWR.t177 sg13_lv_pmos ad=0.2128p pd=1.5u as=0.2128p ps=1.5u w=1.12u l=0.13u
X4454 VGND.t472 sg13cmos5l_inv_16_14.A sg13cmos5l_inv_16_104.Y VGND.t482 sg13_lv_nmos ad=0.1406p pd=1.12u as=0.1406p ps=1.12u w=0.74u l=0.13u
X4455 sg13cmos5l_inv_16_9.A sg13cmos5l_inv_16_8.Y VGND.t291 VGND.t566 sg13_lv_nmos ad=0.1406p pd=1.12u as=0.1406p ps=1.12u w=0.74u l=0.13u
X4456 sg13cmos5l_inv_16_51.Y sg13cmos5l_inv_16_99.A VPWR.t1200 VPWR.t25 sg13_lv_pmos ad=0.2128p pd=1.5u as=0.2128p ps=1.5u w=1.12u l=0.13u
X4457 VGND.t198 sg13cmos5l_inv_16_44.A sg13cmos5l_inv_16_44.Y VGND.t199 sg13_lv_nmos ad=0.1406p pd=1.12u as=0.1406p ps=1.12u w=0.74u l=0.13u
X4458 sg13cmos5l_inv_16_36.Y sg13cmos5l_inv_16_36.A VGND.t146 VGND.t156 sg13_lv_nmos ad=0.1406p pd=1.12u as=0.1406p ps=1.12u w=0.74u l=0.13u
X4459 sg13cmos5l_inv_16_22.Y sg13cmos5l_inv_16_20.A VGND.t375 VGND.t445 sg13_lv_nmos ad=0.1406p pd=1.12u as=0.1406p ps=1.12u w=0.74u l=0.13u
X4460 sg13cmos5l_inv_16_29.Y sg13cmos5l_inv_16_29.A VPWR.t707 VPWR.t177 sg13_lv_pmos ad=0.2128p pd=1.5u as=0.2128p ps=1.5u w=1.12u l=0.13u
X4461 sg13cmos5l_inv_16_35.Y sg13cmos5l_inv_16_29.A VGND.t259 VGND.t264 sg13_lv_nmos ad=0.1406p pd=1.12u as=0.1406p ps=1.12u w=0.74u l=0.13u
X4462 sg13cmos5l_inv_16_15.A sg13cmos5l_inv_16_23.Y VGND.t45 VGND.t61 sg13_lv_nmos ad=0.1406p pd=1.12u as=0.1406p ps=1.12u w=0.74u l=0.13u
X4463 VGND.t432 VPWR.t2521 VGND.t432 VGND.t2025 sg13_lv_nmos ad=79.8f pd=0.8u as=0 ps=0 w=0.42u l=1u
R0 VPWR.n1647 VPWR.t683 20.5294
R1 VPWR.n748 VPWR.t1721 20.5294
R2 VPWR.n190 VPWR.t1654 20.5294
R3 VPWR.n1587 VPWR.t751 20.5294
R4 VPWR.n797 VPWR.t1149 20.5294
R5 VPWR.n820 VPWR.t998 20.5294
R6 VPWR.n1518 VPWR.t500 20.5294
R7 VPWR.n155 VPWR.t504 20.5294
R8 VPWR.n939 VPWR.t1028 20.5294
R9 VPWR.n389 VPWR.t2316 20.5294
R10 VPWR.n1435 VPWR.t1356 20.5294
R11 VPWR.n1165 VPWR.t2125 20.5294
R12 VPWR.n68 VPWR.t2373 20.5294
R13 VPWR.n1202 VPWR.t1596 20.5294
R14 VPWR.n1218 VPWR.t1384 20.5294
R15 VPWR.n1559 VPWR.t959 20.5284
R16 VPWR.n390 VPWR.t1044 20.5284
R17 VPWR.n65 VPWR.t462 20.5284
R18 VPWR.n808 VPWR.t1532 20.5284
R19 VPWR.n831 VPWR.t1615 20.5284
R20 VPWR.n153 VPWR.t911 20.5284
R21 VPWR.n918 VPWR.t2338 20.5284
R22 VPWR.n1472 VPWR.t1173 20.5284
R23 VPWR.n70 VPWR.t1920 20.5284
R24 VPWR.n1214 VPWR.t1581 20.5284
R25 VPWR.n1223 VPWR.t1288 20.5284
R26 VPWR.n1647 VPWR.t685 17.74
R27 VPWR.n748 VPWR.t1723 17.74
R28 VPWR.n190 VPWR.t1656 17.74
R29 VPWR.n1587 VPWR.t753 17.74
R30 VPWR.n797 VPWR.t1152 17.74
R31 VPWR.n820 VPWR.t1000 17.74
R32 VPWR.n1518 VPWR.t502 17.74
R33 VPWR.n155 VPWR.t503 17.74
R34 VPWR.n939 VPWR.t1030 17.74
R35 VPWR.n389 VPWR.t2318 17.74
R36 VPWR.n1435 VPWR.t1358 17.74
R37 VPWR.n1165 VPWR.t2127 17.74
R38 VPWR.n68 VPWR.t2372 17.74
R39 VPWR.n1202 VPWR.t1598 17.74
R40 VPWR.n1218 VPWR.t1367 17.74
R41 VPWR.n1559 VPWR.t961 17.7396
R42 VPWR.n390 VPWR.t1046 17.7396
R43 VPWR.n65 VPWR.t464 17.7396
R44 VPWR.n808 VPWR.t1534 17.7396
R45 VPWR.n831 VPWR.t1617 17.7396
R46 VPWR.n153 VPWR.t913 17.7396
R47 VPWR.n918 VPWR.t2337 17.7396
R48 VPWR.n1472 VPWR.t1172 17.7396
R49 VPWR.n70 VPWR.t1922 17.7396
R50 VPWR.n1214 VPWR.t1583 17.7396
R51 VPWR.n1223 VPWR.t1290 17.7396
R52 VPWR.n663 VPWR.t2009 17.2247
R53 VPWR.n579 VPWR.t520 17.2247
R54 VPWR.n1481 VPWR.t2286 17.2247
R55 VPWR.n1481 VPWR.t1 17.2247
R56 VPWR.n583 VPWR.t846 17.2247
R57 VPWR.n587 VPWR.t1640 17.2247
R58 VPWR.n591 VPWR.t1960 17.2247
R59 VPWR.n1192 VPWR.t1673 17.2247
R60 VPWR.n710 VPWR.t2010 17.2247
R61 VPWR.n678 VPWR.t1923 17.2247
R62 VPWR.t16 VPWR.n1142 17.0012
R63 VPWR.t16 VPWR.n1145 17.0012
R64 VPWR.t177 VPWR.n677 17.0005
R65 VPWR.t177 VPWR.n45 2.29716
R66 VPWR.n54 VPWR.n79 0.121761
R67 VPWR.t177 VPWR.n680 17.0005
R68 VPWR.t177 VPWR.n682 17.0005
R69 VPWR.t177 VPWR.n684 17.0005
R70 VPWR.t177 VPWR.n686 17.0005
R71 VPWR.t177 VPWR.n688 17.0005
R72 VPWR.t177 VPWR.n690 17.0005
R73 VPWR.t177 VPWR.n692 17.0005
R74 VPWR.t177 VPWR.n694 17.0005
R75 VPWR.t177 VPWR.n696 17.0005
R76 VPWR.t177 VPWR.n698 17.0005
R77 VPWR.t177 VPWR.n700 17.0005
R78 VPWR.t177 VPWR.n702 17.0005
R79 VPWR.t177 VPWR.n378 8.47328
R80 VPWR.n327 VPWR.n326 0.060789
R81 VPWR.t177 VPWR.n327 8.47111
R82 VPWR.t177 VPWR.n709 17.0005
R83 VPWR.t177 VPWR.n661 17.0005
R84 VPWR.t177 VPWR.n648 17.0005
R85 VPWR.t177 VPWR.n659 17.0005
R86 VPWR.t177 VPWR.n649 17.0005
R87 VPWR.t177 VPWR.n656 17.0005
R88 VPWR.t177 VPWR.n650 17.0005
R89 VPWR.t177 VPWR.n653 17.0005
R90 VPWR.t177 VPWR.n338 8.47328
R91 VPWR.n630 VPWR.t177 5.64741
R92 VPWR.t4 VPWR.n100 5.61896
R93 VPWR.t4 VPWR.n281 4.19539
R94 VPWR.n281 VPWR.n504 0.144037
R95 VPWR.t4 VPWR.n102 5.61896
R96 VPWR.t4 VPWR.n283 4.19539
R97 VPWR.n283 VPWR.n507 0.144037
R98 VPWR.n380 VPWR.n229 0.060789
R99 VPWR.t4 VPWR.n230 17.0005
R100 VPWR.t4 VPWR.n285 5.61759
R101 VPWR.n285 VPWR.n510 0.116312
R102 VPWR.t4 VPWR.n36 1.51602
R103 VPWR.n42 VPWR.n52 0.118616
R104 VPWR.n52 VPWR.n63 0.12332
R105 VPWR.t4 VPWR.n1555 17.0005
R106 VPWR.t4 VPWR.n1553 17.0005
R107 VPWR.t4 VPWR.n1551 17.0005
R108 VPWR.t4 VPWR.n1547 17.0005
R109 VPWR.t4 VPWR.n1544 17.0005
R110 VPWR.t4 VPWR.n380 8.47111
R111 VPWR.t4 VPWR.n1556 17.0005
R112 VPWR.t4 VPWR.n1596 17.0005
R113 VPWR.t4 VPWR.n1594 17.0005
R114 VPWR.n227 VPWR.n393 0.11686
R115 VPWR.t4 VPWR.n227 5.61835
R116 VPWR.t4 VPWR.n572 4.24187
R117 VPWR.t4 VPWR.n527 5.61512
R118 VPWR.n410 VPWR.n408 0.0546454
R119 VPWR.t4 VPWR.n407 17.0005
R120 VPWR.t4 VPWR.n405 5.61622
R121 VPWR.t4 VPWR.n29 1.48009
R122 VPWR.n29 VPWR.n28 0.132221
R123 VPWR.t4 VPWR.n1558 17.0005
R124 VPWR.t4 VPWR.n1560 17.0005
R125 VPWR.t4 VPWR.n201 5.61813
R126 VPWR.t4 VPWR.n290 4.19539
R127 VPWR.n290 VPWR.n523 0.144037
R128 VPWR.t4 VPWR.n110 5.61896
R129 VPWR.t4 VPWR.n288 8.4739
R130 VPWR.n521 VPWR.t4 8.47142
R131 VPWR.n521 VPWR.n520 0.0601683
R132 VPWR.t4 VPWR.n107 5.61896
R133 VPWR.t4 VPWR.n287 8.4739
R134 VPWR.t4 VPWR.n286 5.61731
R135 VPWR.t4 VPWR.n516 5.61512
R136 VPWR.t4 VPWR.n1586 17.0005
R137 VPWR.t4 VPWR.n1588 17.0005
R138 VPWR.t4 VPWR.n203 5.61813
R139 VPWR.n32 VPWR.n391 0.252137
R140 VPWR.n8 VPWR.n437 0.825643
R141 VPWR.t4 VPWR.n8 1.1898
R142 VPWR.n8 VPWR.n7 0.227798
R143 VPWR.n13 VPWR.n190 0.280415
R144 VPWR.n14 VPWR.n10 0.429068
R145 VPWR.t4 VPWR.n511 8.47142
R146 VPWR.t4 VPWR.n745 17.0005
R147 VPWR.t4 VPWR.n734 17.0005
R148 VPWR.t4 VPWR.n343 8.47328
R149 VPWR.t4 VPWR.n105 8.47576
R150 VPWR.t4 VPWR.n165 8.47266
R151 VPWR.t4 VPWR.n166 17.0005
R152 VPWR.t4 VPWR.n1658 17.0005
R153 VPWR.t4 VPWR.n1601 17.0005
R154 VPWR.t4 VPWR.n1655 17.0005
R155 VPWR.t4 VPWR.n1602 17.0005
R156 VPWR.t4 VPWR.n1652 17.0005
R157 VPWR.t4 VPWR.n340 8.47328
R158 VPWR.t4 VPWR.n1608 17.0005
R159 VPWR.t4 VPWR.n1649 17.0005
R160 VPWR.t4 VPWR.n382 17.0005
R161 VPWR.t4 VPWR.n580 3.36164
R162 VPWR.n580 VPWR.n579 0.0442396
R163 VPWR.n93 VPWR.t0 5.61485
R164 VPWR.t0 VPWR.n528 5.61512
R165 VPWR.t0 VPWR.n432 17.0005
R166 VPWR.t0 VPWR.n864 17.0005
R167 VPWR.t0 VPWR.n1530 17.0005
R168 VPWR.t0 VPWR.n532 8.47142
R169 VPWR.t0 VPWR.n152 5.61622
R170 VPWR.t0 VPWR.n1525 17.0005
R171 VPWR.t0 VPWR.n1504 17.0005
R172 VPWR.t0 VPWR.n1523 17.0005
R173 VPWR.t0 VPWR.n413 5.61622
R174 VPWR.t0 VPWR.n1519 17.0005
R175 VPWR.t0 VPWR.n1505 17.0005
R176 VPWR.t0 VPWR.n396 5.61759
R177 VPWR.n299 VPWR.n298 0.060789
R178 VPWR.t0 VPWR.n299 8.47111
R179 VPWR.t0 VPWR.n297 3.3634
R180 VPWR.n297 VPWR.n113 0.044486
R181 VPWR.t0 VPWR.n115 8.47328
R182 VPWR.t0 VPWR.n1 0.817207
R183 VPWR.t0 VPWR.n255 5.61622
R184 VPWR.t0 VPWR.n832 17.0005
R185 VPWR.t0 VPWR.n830 17.0005
R186 VPWR.t0 VPWR.n817 17.0005
R187 VPWR.t0 VPWR.n815 17.0005
R188 VPWR.t0 VPWR.n348 8.47328
R189 VPWR.t0 VPWR.n809 17.0005
R190 VPWR.t0 VPWR.n807 17.0005
R191 VPWR.t0 VPWR.n794 17.0005
R192 VPWR.t0 VPWR.n792 17.0005
R193 VPWR.t0 VPWR.n347 8.47328
R194 VPWR.t0 VPWR.n786 17.0005
R195 VPWR.t0 VPWR.n783 17.0005
R196 VPWR.t0 VPWR.n78 4.17595
R197 VPWR.n78 VPWR.n77 0.123894
R198 VPWR.t0 VPWR.n781 17.0005
R199 VPWR.t0 VPWR.n775 17.0005
R200 VPWR.t0 VPWR.n149 8.47266
R201 VPWR.t0 VPWR.n294 5.61759
R202 VPWR.n294 VPWR.n531 0.116312
R203 VPWR.t0 VPWR.n48 2.71038
R204 VPWR.n48 VPWR.n47 0.20819
R205 VPWR.t0 VPWR.n772 17.0005
R206 VPWR.t0 VPWR.n404 5.61622
R207 VPWR.t0 VPWR.n346 17.0005
R208 VPWR.n66 VPWR.n65 0.184811
R209 VPWR.t0 VPWR.n66 4.17847
R210 VPWR.t0 VPWR.n412 5.61622
R211 VPWR.t0 VPWR.n762 17.0005
R212 VPWR.t0 VPWR.n758 17.0005
R213 VPWR.t0 VPWR.n91 5.61239
R214 VPWR.n91 VPWR.n90 0.129947
R215 VPWR.n162 VPWR.n89 0.076514
R216 VPWR.t0 VPWR.n162 2.05458
R217 VPWR.t0 VPWR.n163 17.0005
R218 VPWR.t0 VPWR.n1502 17.0005
R219 VPWR.t0 VPWR.n865 17.0005
R220 VPWR.t0 VPWR.n1498 17.0005
R221 VPWR.t0 VPWR.n293 3.3634
R222 VPWR.n293 VPWR.n602 0.044486
R223 VPWR.t0 VPWR.n112 17.0005
R224 VPWR.n12 VPWR.n390 0.280415
R225 VPWR.t0 VPWR.n1486 17.0005
R226 VPWR.t0 VPWR.n869 17.0005
R227 VPWR.t0 VPWR.n411 8.47266
R228 VPWR.t0 VPWR.n291 4.17941
R229 VPWR.n291 VPWR.n429 0.176366
R230 VPWR.n479 VPWR.n478 0.0360754
R231 VPWR.t25 VPWR.n966 17.0005
R232 VPWR.t25 VPWR.n538 8.47142
R233 VPWR.n538 VPWR.n537 0.0601683
R234 VPWR.t25 VPWR.n132 8.47576
R235 VPWR.t25 VPWR.n985 17.0005
R236 VPWR.t25 VPWR.n34 1.2032
R237 VPWR.n43 VPWR.n53 0.118616
R238 VPWR.n53 VPWR.n73 0.12332
R239 VPWR.t25 VPWR.n982 17.0005
R240 VPWR.t25 VPWR.n632 5.64741
R241 VPWR.n994 VPWR.t25 17.0005
R242 VPWR.t25 VPWR.n1017 17.0005
R243 VPWR.t25 VPWR.n1021 17.0005
R244 VPWR.t25 VPWR.n1434 17.0005
R245 VPWR.t25 VPWR.n1436 17.0005
R246 VPWR.n25 VPWR.n27 0.0947466
R247 VPWR.n24 VPWR.n25 0.0809458
R248 VPWR.t25 VPWR.n20 0.590152
R249 VPWR.n20 VPWR.n18 0.14033
R250 VPWR.t25 VPWR.n129 8.47576
R251 VPWR.t25 VPWR.n1444 17.0005
R252 VPWR.t25 VPWR.n354 3.36862
R253 VPWR.t25 VPWR.n88 5.61239
R254 VPWR.n88 VPWR.n87 0.134063
R255 VPWR.n459 VPWR.n597 0.0975726
R256 VPWR.n460 VPWR.n459 0.0601157
R257 VPWR.t25 VPWR.n127 8.47111
R258 VPWR.n127 VPWR.n126 0.060789
R259 VPWR.t25 VPWR.n303 5.61731
R260 VPWR.n462 VPWR.n467 0.029877
R261 VPWR.n463 VPWR.n462 0.0380158
R262 VPWR.t25 VPWR.n463 2.36552
R263 VPWR.t25 VPWR.n1462 17.0005
R264 VPWR.t25 VPWR.n1464 17.0005
R265 VPWR.t25 VPWR.n1466 17.0005
R266 VPWR.n55 VPWR.n75 0.12332
R267 VPWR.n56 VPWR.n55 0.118616
R268 VPWR.t25 VPWR.n1471 17.0005
R269 VPWR.t25 VPWR.n1473 17.0005
R270 VPWR.t25 VPWR.n415 5.61622
R271 VPWR.t25 VPWR.n302 3.3634
R272 VPWR.n302 VPWR.n123 0.044486
R273 VPWR.t25 VPWR.n125 17.0005
R274 VPWR.t25 VPWR.n414 5.61622
R275 VPWR.n40 VPWR.n145 0.214853
R276 VPWR.n41 VPWR.n40 0.118035
R277 VPWR.n469 VPWR.n472 0.0320076
R278 VPWR.n470 VPWR.n469 0.0409954
R279 VPWR.t25 VPWR.n470 2.77418
R280 VPWR.t25 VPWR.n963 17.0005
R281 VPWR.t25 VPWR.n888 17.0005
R282 VPWR.t25 VPWR.n960 17.0005
R283 VPWR.t25 VPWR.n889 17.0005
R284 VPWR.t25 VPWR.n957 17.0005
R285 VPWR.t25 VPWR.n890 17.0005
R286 VPWR.t25 VPWR.n353 8.47328
R287 VPWR.n61 VPWR.n60 0.120692
R288 VPWR.t25 VPWR.n935 17.0005
R289 VPWR.t25 VPWR.n891 17.0005
R290 VPWR.t25 VPWR.n352 8.47328
R291 VPWR.t25 VPWR.n349 8.47328
R292 VPWR.t25 VPWR.n923 17.0005
R293 VPWR.t25 VPWR.n892 17.0005
R294 VPWR.t25 VPWR.n584 3.36164
R295 VPWR.n584 VPWR.n583 0.0442396
R296 VPWR.t16 VPWR.n305 4.19539
R297 VPWR.n305 VPWR.n540 0.144037
R298 VPWR.t16 VPWR.n71 4.17847
R299 VPWR.n71 VPWR.n70 0.184811
R300 VPWR.t16 VPWR.n195 5.61868
R301 VPWR.n69 VPWR.n68 0.184811
R302 VPWR.t16 VPWR.n69 4.17847
R303 VPWR.t16 VPWR.n1033 17.0005
R304 VPWR.t16 VPWR.n151 8.47266
R305 VPWR.t16 VPWR.n314 5.61759
R306 VPWR.n314 VPWR.n550 0.116312
R307 VPWR.t16 VPWR.n144 5.61896
R308 VPWR.n143 VPWR.n142 0.0695427
R309 VPWR.t16 VPWR.n143 8.46673
R310 VPWR.t16 VPWR.n1078 17.0005
R311 VPWR.t16 VPWR.n1034 17.0005
R312 VPWR.t16 VPWR.n1075 17.0005
R313 VPWR.t16 VPWR.n1035 17.0005
R314 VPWR.t16 VPWR.n364 8.47328
R315 VPWR.t16 VPWR.n361 8.47328
R316 VPWR.t16 VPWR.n1065 17.0005
R317 VPWR.t16 VPWR.n1036 17.0005
R318 VPWR.t16 VPWR.n1062 17.0005
R319 VPWR.t16 VPWR.n1037 17.0005
R320 VPWR.t16 VPWR.n1059 17.0005
R321 VPWR.t16 VPWR.n313 3.3634
R322 VPWR.n313 VPWR.n594 0.044486
R323 VPWR.t16 VPWR.n140 8.47328
R324 VPWR.t16 VPWR.n121 8.47576
R325 VPWR.t16 VPWR.n120 17.0005
R326 VPWR.t16 VPWR.n1056 17.0005
R327 VPWR.t16 VPWR.n1048 17.0005
R328 VPWR.t16 VPWR.n1053 17.0005
R329 VPWR.t16 VPWR.n1049 17.0005
R330 VPWR.n170 VPWR.n169 0.0615752
R331 VPWR.t16 VPWR.n170 5.61485
R332 VPWR.t16 VPWR.n98 8.47666
R333 VPWR.t16 VPWR.n1423 17.0005
R334 VPWR.t16 VPWR.n1421 17.0005
R335 VPWR.t16 VPWR.n1419 17.0005
R336 VPWR.t16 VPWR.n360 8.47328
R337 VPWR.t16 VPWR.n309 8.4739
R338 VPWR.t16 VPWR.n306 5.61759
R339 VPWR.n306 VPWR.n547 0.116312
R340 VPWR.t16 VPWR.n138 5.61896
R341 VPWR.t16 VPWR.n329 2.77597
R342 VPWR.n329 VPWR.n208 0.0696366
R343 VPWR.n135 VPWR.n435 0.115496
R344 VPWR.t16 VPWR.n135 5.61868
R345 VPWR.t16 VPWR.n118 17.0005
R346 VPWR.t16 VPWR.n328 8.4742
R347 VPWR.t16 VPWR.n541 8.47142
R348 VPWR.t16 VPWR.n1162 17.0005
R349 VPWR.t16 VPWR.n1095 17.0005
R350 VPWR.t16 VPWR.n359 8.47328
R351 VPWR.t16 VPWR.n134 8.47576
R352 VPWR.t16 VPWR.n1153 17.0005
R353 VPWR.t16 VPWR.n1096 17.0005
R354 VPWR.t16 VPWR.n1151 17.0005
R355 VPWR.t16 VPWR.n1097 17.0005
R356 VPWR.t16 VPWR.n1148 17.0005
R357 VPWR.t16 VPWR.n356 8.47328
R358 VPWR.n6 VPWR.n421 0.789648
R359 VPWR.t16 VPWR.n133 0.793687
R360 VPWR.t16 VPWR.n1099 17.0005
R361 VPWR.t16 VPWR.n1100 17.0005
R362 VPWR.t16 VPWR.n1139 17.0005
R363 VPWR.t16 VPWR.n418 8.47266
R364 VPWR.t16 VPWR.n180 5.62664
R365 VPWR.t16 VPWR.n181 5.61677
R366 VPWR.t16 VPWR.n493 17.0005
R367 VPWR.t16 VPWR.n588 3.36164
R368 VPWR.n588 VPWR.n587 0.0442396
R369 VPWR.n1387 VPWR.t9 17.0005
R370 VPWR.t9 VPWR.n19 1.36959
R371 VPWR.t9 VPWR.n1337 17.0005
R372 VPWR.t9 VPWR.n376 8.47328
R373 VPWR.t9 VPWR.n323 8.4739
R374 VPWR.t9 VPWR.n1376 17.0005
R375 VPWR.t9 VPWR.n1338 17.0005
R376 VPWR.t9 VPWR.n1374 17.0005
R377 VPWR.t9 VPWR.n1339 17.0005
R378 VPWR.t9 VPWR.n1371 17.0005
R379 VPWR.t9 VPWR.n372 8.47328
R380 VPWR.t9 VPWR.n371 8.47328
R381 VPWR.t9 VPWR.n1344 17.0005
R382 VPWR.t9 VPWR.n1367 17.0005
R383 VPWR.t9 VPWR.n1345 17.0005
R384 VPWR.t9 VPWR.n1364 17.0005
R385 VPWR.t9 VPWR.n1346 17.0005
R386 VPWR.t9 VPWR.n322 5.61759
R387 VPWR.n322 VPWR.n567 0.116312
R388 VPWR.t9 VPWR.n225 5.61896
R389 VPWR.t9 VPWR.n320 8.4739
R390 VPWR.t9 VPWR.n23 0.873347
R391 VPWR.n23 VPWR.n263 0.104309
R392 VPWR.t9 VPWR.n1263 17.0005
R393 VPWR.t9 VPWR.n423 8.47266
R394 VPWR.n400 VPWR.n399 0.0638915
R395 VPWR.t9 VPWR.n400 8.46955
R396 VPWR.t9 VPWR.n565 8.47142
R397 VPWR.n565 VPWR.n564 0.0601683
R398 VPWR.t9 VPWR.n224 5.61896
R399 VPWR.t9 VPWR.n319 4.19539
R400 VPWR.n319 VPWR.n562 0.144037
R401 VPWR.t9 VPWR.n222 5.61896
R402 VPWR.n158 VPWR.n157 0.070093
R403 VPWR.t9 VPWR.n158 8.46645
R404 VPWR.t9 VPWR.n1270 17.0005
R405 VPWR.t9 VPWR.n1272 17.0005
R406 VPWR.t9 VPWR.n1274 17.0005
R407 VPWR.t9 VPWR.n58 4.16516
R408 VPWR.n58 VPWR.n57 0.0894752
R409 VPWR.n368 VPWR.n367 0.060789
R410 VPWR.t9 VPWR.n368 8.47111
R411 VPWR.t9 VPWR.n1279 17.0005
R412 VPWR.t9 VPWR.n1281 17.0005
R413 VPWR.t9 VPWR.n1283 17.0005
R414 VPWR.t9 VPWR.n1285 17.0005
R415 VPWR.t9 VPWR.n1287 17.0005
R416 VPWR.t9 VPWR.n1289 17.0005
R417 VPWR.t9 VPWR.n558 5.61512
R418 VPWR.t9 VPWR.n1224 17.0005
R419 VPWR.t9 VPWR.n1183 17.0005
R420 VPWR.t9 VPWR.n1186 17.0005
R421 VPWR.t9 VPWR.n1220 17.0005
R422 VPWR.t9 VPWR.n316 4.19539
R423 VPWR.n316 VPWR.n557 0.144037
R424 VPWR.t9 VPWR.n221 5.61896
R425 VPWR.t9 VPWR.n161 17.0005
R426 VPWR.t9 VPWR.n331 8.4742
R427 VPWR.t9 VPWR.n551 8.47142
R428 VPWR.t9 VPWR.n1211 17.0005
R429 VPWR.t9 VPWR.n1188 17.0005
R430 VPWR.t9 VPWR.n365 8.47328
R431 VPWR.t9 VPWR.n1203 17.0005
R432 VPWR.t9 VPWR.n1189 17.0005
R433 VPWR.n442 VPWR.n489 0.0360754
R434 VPWR.t9 VPWR.n218 8.47576
R435 VPWR.t9 VPWR.n1300 17.0005
R436 VPWR.t9 VPWR.n592 3.36164
R437 VPWR.n592 VPWR.n591 0.0442396
R438 VPWR.n407 VPWR.t1254 16.4594
R439 VPWR.n37 VPWR.t1085 16.3494
R440 VPWR.n459 VPWR.t1516 16.3494
R441 VPWR.n493 VPWR.t1756 16.2384
R442 VPWR.n4 VPWR.t1953 16.1552
R443 VPWR.n570 VPWR.t895 16.1542
R444 VPWR.n627 VPWR.t1412 16.1542
R445 VPWR.n49 VPWR.t2465 15.2621
R446 VPWR.n1542 VPWR.t2476 15.2621
R447 VPWR.n28 VPWR.t2469 15.2621
R448 VPWR.n572 VPWR.t2467 15.2621
R449 VPWR.n1484 VPWR.t2508 15.2621
R450 VPWR.n1500 VPWR.t2506 15.2621
R451 VPWR.n760 VPWR.t2504 15.2621
R452 VPWR.n776 VPWR.t2501 15.2621
R453 VPWR.n2 VPWR.t2499 15.2621
R454 VPWR.n915 VPWR.t2537 15.2621
R455 VPWR.n18 VPWR.t2531 15.2621
R456 VPWR.n992 VPWR.t2530 15.2621
R457 VPWR.n1090 VPWR.t2554 15.2621
R458 VPWR.n1298 VPWR.t2591 15.2621
R459 VPWR.n1261 VPWR.t2584 15.2621
R460 VPWR.n637 VPWR.t2462 15.2621
R461 VPWR.n1545 VPWR.t2489 15.2617
R462 VPWR.n1600 VPWR.t2495 15.2617
R463 VPWR.n1662 VPWR.t2483 15.2617
R464 VPWR.n431 VPWR.t2523 15.2617
R465 VPWR.n861 VPWR.t2522 15.2617
R466 VPWR.n427 VPWR.t2528 15.2617
R467 VPWR.n576 VPWR.t2525 15.2617
R468 VPWR.n784 VPWR.t2519 15.2617
R469 VPWR.n845 VPWR.t2517 15.2617
R470 VPWR.n2 VPWR.t2515 15.2617
R471 VPWR.n384 VPWR.t2511 15.2617
R472 VPWR.n59 VPWR.t2553 15.2617
R473 VPWR.n39 VPWR.t2551 15.2617
R474 VPWR.n27 VPWR.t2543 15.2617
R475 VPWR.n1015 VPWR.t2541 15.2617
R476 VPWR.n990 VPWR.t2539 15.2617
R477 VPWR.n6 VPWR.t2579 15.2617
R478 VPWR.n1136 VPWR.t2580 15.2617
R479 VPWR.n1425 VPWR.t2574 15.2617
R480 VPWR.n1031 VPWR.t2571 15.2617
R481 VPWR.n1091 VPWR.t2570 15.2617
R482 VPWR.n1264 VPWR.t2598 15.2617
R483 VPWR.n22 VPWR.t2596 15.2617
R484 VPWR.n19 VPWR.t2593 15.2617
R485 VPWR.n847 VPWR.t800 14.6994
R486 VPWR.n848 VPWR.n847 14.6305
R487 VPWR.n493 VPWR.n618 0.117228
R488 VPWR.n23 VPWR.n22 0.786932
R489 VPWR.n263 VPWR.t1431 12.9
R490 VPWR.n292 VPWR.t670 12.79
R491 VPWR.n296 VPWR.t945 12.79
R492 VPWR.n301 VPWR.t2283 12.7896
R493 VPWR.n312 VPWR.t2205 12.7896
R494 VPWR.n491 VPWR.t2266 12.5958
R495 VPWR.n1140 VPWR.t2056 11.8394
R496 VPWR.n1143 VPWR.t2028 11.8384
R497 VPWR.n602 VPWR.t668 10.8756
R498 VPWR.n113 VPWR.t943 10.8756
R499 VPWR.n123 VPWR.t2281 10.8746
R500 VPWR.n594 VPWR.t2203 10.8746
R501 VPWR.n22 VPWR.t1432 10.7394
R502 VPWR.n407 VPWR.n409 0.112772
R503 VPWR.n94 VPWR.n95 1.09959
R504 VPWR.n848 VPWR.t802 8.94001
R505 VPWR.n408 VPWR.t927 8.82532
R506 VPWR.n40 VPWR.t2306 8.79492
R507 VPWR.n168 VPWR.t2229 8.79492
R508 VPWR.n22 VPWR.t1438 8.79492
R509 VPWR.n50 VPWR.t1843 8.79392
R510 VPWR.n993 VPWR.t2388 8.79392
R511 VPWR.n610 VPWR.t675 8.78742
R512 VPWR.n474 VPWR.t1711 8.78742
R513 VPWR.n344 VPWR.t600 8.78742
R514 VPWR.n839 VPWR.t796 8.78742
R515 VPWR.n613 VPWR.t488 8.78742
R516 VPWR.n481 VPWR.t1506 8.78742
R517 VPWR.n1455 VPWR.t1512 8.78742
R518 VPWR.n455 VPWR.t782 8.78742
R519 VPWR.n483 VPWR.t2113 8.78742
R520 VPWR.n489 VPWR.t1586 8.78742
R521 VPWR.n624 VPWR.t1892 8.78742
R522 VPWR.n425 VPWR.t519 8.78642
R523 VPWR.n16 VPWR.t885 8.78642
R524 VPWR.n18 VPWR.t2238 8.78642
R525 VPWR.t16 VPWR.t2038 8.78642
R526 VPWR.n616 VPWR.t1448 8.78642
R527 VPWR.n1354 VPWR.t1406 8.78642
R528 VPWR.n607 VPWR.t1260 8.78642
R529 VPWR.n7 VPWR.t1774 8.7647
R530 VPWR.n7 VPWR.t1776 8.7647
R531 VPWR.n265 VPWR.t841 8.7647
R532 VPWR.n1580 VPWR.t843 8.7647
R533 VPWR.n951 VPWR.t837 8.7647
R534 VPWR.n948 VPWR.t836 8.7647
R535 VPWR.n1470 VPWR.t965 8.7647
R536 VPWR.n1474 VPWR.t964 8.7647
R537 VPWR.n1018 VPWR.t1223 8.7647
R538 VPWR.n417 VPWR.t1221 8.7647
R539 VPWR.n695 VPWR.t1957 8.7647
R540 VPWR.n691 VPWR.t1959 8.7647
R541 VPWR.n279 VPWR.t1628 8.7637
R542 VPWR.n1334 VPWR.t1629 8.7637
R543 VPWR.n655 VPWR.t1814 8.76154
R544 VPWR.n652 VPWR.t1812 8.76154
R545 VPWR.n644 VPWR.t538 8.76154
R546 VPWR.n642 VPWR.t540 8.76154
R547 VPWR.n640 VPWR.t542 8.76154
R548 VPWR.n666 VPWR.t544 8.76154
R549 VPWR.n668 VPWR.t546 8.76154
R550 VPWR.n670 VPWR.t548 8.76154
R551 VPWR.n35 VPWR.t1066 8.76154
R552 VPWR.n42 VPWR.t1064 8.76154
R553 VPWR.n52 VPWR.t1062 8.76154
R554 VPWR.n63 VPWR.t1060 8.76154
R555 VPWR.n1554 VPWR.t1058 8.76154
R556 VPWR.n1550 VPWR.t1056 8.76154
R557 VPWR.n1626 VPWR.t623 8.76154
R558 VPWR.n1623 VPWR.t625 8.76154
R559 VPWR.n1621 VPWR.t627 8.76154
R560 VPWR.n1628 VPWR.t629 8.76154
R561 VPWR.n1630 VPWR.t631 8.76154
R562 VPWR.n1632 VPWR.t633 8.76154
R563 VPWR.n1646 VPWR.t673 8.76154
R564 VPWR.n1642 VPWR.t671 8.76154
R565 VPWR.n1611 VPWR.t681 8.76154
R566 VPWR.n1614 VPWR.t679 8.76154
R567 VPWR.n382 VPWR.t677 8.76154
R568 VPWR.n1651 VPWR.t1635 8.76154
R569 VPWR.n341 VPWR.t1633 8.76154
R570 VPWR.n739 VPWR.t1709 8.76154
R571 VPWR.n744 VPWR.t1719 8.76154
R572 VPWR.n189 VPWR.t1717 8.76154
R573 VPWR.n741 VPWR.t1715 8.76154
R574 VPWR.n446 VPWR.t1713 8.76154
R575 VPWR.n13 VPWR.t1652 8.76154
R576 VPWR.n13 VPWR.t1650 8.76154
R577 VPWR.n13 VPWR.t1648 8.76154
R578 VPWR.n13 VPWR.t1646 8.76154
R579 VPWR.n10 VPWR.t1644 8.76154
R580 VPWR.n10 VPWR.t1642 8.76154
R581 VPWR.n200 VPWR.t749 8.76154
R582 VPWR.n204 VPWR.t747 8.76154
R583 VPWR.n1591 VPWR.t745 8.76154
R584 VPWR.n31 VPWR.t743 8.76154
R585 VPWR.n31 VPWR.t741 8.76154
R586 VPWR.n31 VPWR.t739 8.76154
R587 VPWR.n1557 VPWR.t1083 8.76154
R588 VPWR.n1561 VPWR.t1081 8.76154
R589 VPWR.n198 VPWR.t1079 8.76154
R590 VPWR.n202 VPWR.t1077 8.76154
R591 VPWR.n1564 VPWR.t1075 8.76154
R592 VPWR.n1567 VPWR.t1073 8.76154
R593 VPWR.n241 VPWR.t1252 8.76154
R594 VPWR.n402 VPWR.t1250 8.76154
R595 VPWR.n239 VPWR.t1248 8.76154
R596 VPWR.n237 VPWR.t1246 8.76154
R597 VPWR.n235 VPWR.t1244 8.76154
R598 VPWR.n233 VPWR.t1242 8.76154
R599 VPWR.n880 VPWR.t1104 8.76154
R600 VPWR.n882 VPWR.t1106 8.76154
R601 VPWR.n884 VPWR.t1108 8.76154
R602 VPWR.n885 VPWR.t1110 8.76154
R603 VPWR.n876 VPWR.t1112 8.76154
R604 VPWR.n874 VPWR.t1114 8.76154
R605 VPWR.n12 VPWR.t660 8.76154
R606 VPWR.n12 VPWR.t658 8.76154
R607 VPWR.n12 VPWR.t656 8.76154
R608 VPWR.n602 VPWR.t666 8.76154
R609 VPWR.n1487 VPWR.t664 8.76154
R610 VPWR.n390 VPWR.t662 8.76154
R611 VPWR.n753 VPWR.t592 8.76154
R612 VPWR.n756 VPWR.t590 8.76154
R613 VPWR.n346 VPWR.t598 8.76154
R614 VPWR.n64 VPWR.t596 8.76154
R615 VPWR.n65 VPWR.t594 8.76154
R616 VPWR.n251 VPWR.t616 8.76154
R617 VPWR.n249 VPWR.t614 8.76154
R618 VPWR.n84 VPWR.t612 8.76154
R619 VPWR.n85 VPWR.t610 8.76154
R620 VPWR.n247 VPWR.t608 8.76154
R621 VPWR.n269 VPWR.t618 8.76154
R622 VPWR.n47 VPWR.t555 8.76154
R623 VPWR.n771 VPWR.t621 8.76154
R624 VPWR.n782 VPWR.t1139 8.76154
R625 VPWR.n77 VPWR.t1137 8.76154
R626 VPWR.n793 VPWR.t1147 8.76154
R627 VPWR.n188 VPWR.t1145 8.76154
R628 VPWR.n790 VPWR.t1143 8.76154
R629 VPWR.n787 VPWR.t1141 8.76154
R630 VPWR.n804 VPWR.t986 8.76154
R631 VPWR.n816 VPWR.t996 8.76154
R632 VPWR.n186 VPWR.t994 8.76154
R633 VPWR.n813 VPWR.t992 8.76154
R634 VPWR.n810 VPWR.t990 8.76154
R635 VPWR.n806 VPWR.t988 8.76154
R636 VPWR.n827 VPWR.t788 8.76154
R637 VPWR.n836 VPWR.t794 8.76154
R638 VPWR.n833 VPWR.t792 8.76154
R639 VPWR.n829 VPWR.t790 8.76154
R640 VPWR.n841 VPWR.t798 8.76154
R641 VPWR.n271 VPWR.t868 8.76154
R642 VPWR.n258 VPWR.t878 8.76154
R643 VPWR.n256 VPWR.t876 8.76154
R644 VPWR.n254 VPWR.t874 8.76154
R645 VPWR.n82 VPWR.t872 8.76154
R646 VPWR.n253 VPWR.t870 8.76154
R647 VPWR.n113 VPWR.t941 8.76154
R648 VPWR.n114 VPWR.t939 8.76154
R649 VPWR.n2 VPWR.t937 8.76154
R650 VPWR.n2 VPWR.t935 8.76154
R651 VPWR.n2 VPWR.t933 8.76154
R652 VPWR.n2 VPWR.t931 8.76154
R653 VPWR.n385 VPWR.t494 8.76154
R654 VPWR.n397 VPWR.t492 8.76154
R655 VPWR.n1509 VPWR.t490 8.76154
R656 VPWR.n1514 VPWR.t498 8.76154
R657 VPWR.n1511 VPWR.t496 8.76154
R658 VPWR.n153 VPWR.t510 8.76154
R659 VPWR.n1526 VPWR.t508 8.76154
R660 VPWR.n1521 VPWR.t506 8.76154
R661 VPWR.n534 VPWR.t514 8.76154
R662 VPWR.n495 VPWR.t512 8.76154
R663 VPWR.n1529 VPWR.t516 8.76154
R664 VPWR.n904 VPWR.t1190 8.76154
R665 VPWR.n906 VPWR.t1192 8.76154
R666 VPWR.n908 VPWR.t1194 8.76154
R667 VPWR.n909 VPWR.t1196 8.76154
R668 VPWR.n900 VPWR.t1198 8.76154
R669 VPWR.n898 VPWR.t1200 8.76154
R670 VPWR.n934 VPWR.t1026 8.76154
R671 VPWR.n351 VPWR.t1024 8.76154
R672 VPWR.n930 VPWR.t1022 8.76154
R673 VPWR.n927 VPWR.t1020 8.76154
R674 VPWR.n924 VPWR.t1018 8.76154
R675 VPWR.n921 VPWR.t1016 8.76154
R676 VPWR.n955 VPWR.t1464 8.76154
R677 VPWR.n958 VPWR.t1466 8.76154
R678 VPWR.n40 VPWR.t2304 8.76154
R679 VPWR.n974 VPWR.t2314 8.76154
R680 VPWR.n971 VPWR.t2312 8.76154
R681 VPWR.n145 VPWR.t2310 8.76154
R682 VPWR.n40 VPWR.t2308 8.76154
R683 VPWR.n262 VPWR.t2138 8.76154
R684 VPWR.n260 VPWR.t2136 8.76154
R685 VPWR.n403 VPWR.t2134 8.76154
R686 VPWR.n80 VPWR.t2132 8.76154
R687 VPWR.n259 VPWR.t2130 8.76154
R688 VPWR.n277 VPWR.t2140 8.76154
R689 VPWR.n75 VPWR.t1050 8.76154
R690 VPWR.n55 VPWR.t1048 8.76154
R691 VPWR.n1458 VPWR.t1504 8.76154
R692 VPWR.n1457 VPWR.t1510 8.76154
R693 VPWR.n450 VPWR.t1508 8.76154
R694 VPWR.n1452 VPWR.t1514 8.76154
R695 VPWR.n128 VPWR.t774 8.76154
R696 VPWR.n87 VPWR.t772 8.76154
R697 VPWR.n355 VPWR.t780 8.76154
R698 VPWR.n456 VPWR.t778 8.76154
R699 VPWR.n1448 VPWR.t776 8.76154
R700 VPWR.n24 VPWR.t1344 8.76154
R701 VPWR.n27 VPWR.t1348 8.76154
R702 VPWR.n27 VPWR.t1346 8.76154
R703 VPWR.n1440 VPWR.t1354 8.76154
R704 VPWR.n26 VPWR.t1352 8.76154
R705 VPWR.n27 VPWR.t1350 8.76154
R706 VPWR.n1012 VPWR.t820 8.76154
R707 VPWR.n1010 VPWR.t822 8.76154
R708 VPWR.n1008 VPWR.t824 8.76154
R709 VPWR.n1006 VPWR.t826 8.76154
R710 VPWR.n1004 VPWR.t828 8.76154
R711 VPWR.n1002 VPWR.t830 8.76154
R712 VPWR.n38 VPWR.t2258 8.76154
R713 VPWR.n43 VPWR.t2256 8.76154
R714 VPWR.n53 VPWR.t2254 8.76154
R715 VPWR.n73 VPWR.t2252 8.76154
R716 VPWR.n33 VPWR.t2260 8.76154
R717 VPWR.n983 VPWR.t2262 8.76154
R718 VPWR.n1114 VPWR.t2060 8.76154
R719 VPWR.n1116 VPWR.t2062 8.76154
R720 VPWR.n1118 VPWR.t2064 8.76154
R721 VPWR.n1119 VPWR.t2066 8.76154
R722 VPWR.n1110 VPWR.t2068 8.76154
R723 VPWR.n1108 VPWR.t2070 8.76154
R724 VPWR.n1138 VPWR.t2054 8.76154
R725 VPWR.n179 VPWR.t2052 8.76154
R726 VPWR.n1135 VPWR.t2050 8.76154
R727 VPWR.n1132 VPWR.t2048 8.76154
R728 VPWR.n1129 VPWR.t2046 8.76154
R729 VPWR.n1126 VPWR.t2044 8.76154
R730 VPWR.n1146 VPWR.t2299 8.76154
R731 VPWR.n358 VPWR.t2297 8.76154
R732 VPWR.n420 VPWR.t2295 8.76154
R733 VPWR.n6 VPWR.t2293 8.76154
R734 VPWR.n6 VPWR.t2291 8.76154
R735 VPWR.n6 VPWR.t2289 8.76154
R736 VPWR.n1161 VPWR.t2123 8.76154
R737 VPWR.n184 VPWR.t2121 8.76154
R738 VPWR.n1158 VPWR.t2119 8.76154
R739 VPWR.n1155 VPWR.t2117 8.76154
R740 VPWR.n451 VPWR.t2115 8.76154
R741 VPWR.n4 VPWR.t1951 8.76154
R742 VPWR.n4 VPWR.t1949 8.76154
R743 VPWR.n4 VPWR.t1947 8.76154
R744 VPWR.n4 VPWR.t1945 8.76154
R745 VPWR.n4 VPWR.t1943 8.76154
R746 VPWR.n4 VPWR.t1941 8.76154
R747 VPWR.n1397 VPWR.t2160 8.76154
R748 VPWR.n1399 VPWR.t2162 8.76154
R749 VPWR.n1401 VPWR.t2164 8.76154
R750 VPWR.n1403 VPWR.t2166 8.76154
R751 VPWR.n1405 VPWR.t2168 8.76154
R752 VPWR.n1407 VPWR.t2170 8.76154
R753 VPWR.n1422 VPWR.t2223 8.76154
R754 VPWR.n1418 VPWR.t2221 8.76154
R755 VPWR.n99 VPWR.t2225 8.76154
R756 VPWR.n169 VPWR.t2227 8.76154
R757 VPWR.n1050 VPWR.t2231 8.76154
R758 VPWR.n1074 VPWR.t1881 8.76154
R759 VPWR.n363 VPWR.t1879 8.76154
R760 VPWR.n1069 VPWR.t1877 8.76154
R761 VPWR.n1066 VPWR.t1875 8.76154
R762 VPWR.n1063 VPWR.t1873 8.76154
R763 VPWR.n1060 VPWR.t1871 8.76154
R764 VPWR.n70 VPWR.t2381 8.76154
R765 VPWR.n1080 VPWR.t2379 8.76154
R766 VPWR.n193 VPWR.t2377 8.76154
R767 VPWR.n196 VPWR.t2375 8.76154
R768 VPWR.n1085 VPWR.t2385 8.76154
R769 VPWR.n1082 VPWR.t2383 8.76154
R770 VPWR.n1312 VPWR.t1328 8.76154
R771 VPWR.n1314 VPWR.t1330 8.76154
R772 VPWR.n1316 VPWR.t1332 8.76154
R773 VPWR.n1317 VPWR.t1334 8.76154
R774 VPWR.n1308 VPWR.t1336 8.76154
R775 VPWR.n1306 VPWR.t1338 8.76154
R776 VPWR.n487 VPWR.t1584 8.76154
R777 VPWR.n1198 VPWR.t1594 8.76154
R778 VPWR.n1195 VPWR.t1592 8.76154
R779 VPWR.n1193 VPWR.t1590 8.76154
R780 VPWR.n442 VPWR.t1588 8.76154
R781 VPWR.n1213 VPWR.t1375 8.76154
R782 VPWR.n1212 VPWR.t1373 8.76154
R783 VPWR.n1209 VPWR.t1371 8.76154
R784 VPWR.n183 VPWR.t1369 8.76154
R785 VPWR.n553 VPWR.t1379 8.76154
R786 VPWR.n337 VPWR.t1377 8.76154
R787 VPWR.n1225 VPWR.t1396 8.76154
R788 VPWR.n1221 VPWR.t1394 8.76154
R789 VPWR.n502 VPWR.t1392 8.76154
R790 VPWR.n500 VPWR.t1390 8.76154
R791 VPWR.n498 VPWR.t1388 8.76154
R792 VPWR.n497 VPWR.t1386 8.76154
R793 VPWR.n1174 VPWR.t1538 8.76154
R794 VPWR.n1172 VPWR.t1540 8.76154
R795 VPWR.n1170 VPWR.t1542 8.76154
R796 VPWR.n1231 VPWR.t1544 8.76154
R797 VPWR.n1233 VPWR.t1546 8.76154
R798 VPWR.n1235 VPWR.t1548 8.76154
R799 VPWR.n1275 VPWR.t1563 8.76154
R800 VPWR.n57 VPWR.t1561 8.76154
R801 VPWR.n1276 VPWR.t1559 8.76154
R802 VPWR.n367 VPWR.t1557 8.76154
R803 VPWR.n1280 VPWR.t1555 8.76154
R804 VPWR.n1271 VPWR.t1536 8.76154
R805 VPWR.n1257 VPWR.t1488 8.76154
R806 VPWR.n1255 VPWR.t1490 8.76154
R807 VPWR.n1253 VPWR.t1492 8.76154
R808 VPWR.n1251 VPWR.t1494 8.76154
R809 VPWR.n1249 VPWR.t1496 8.76154
R810 VPWR.n1247 VPWR.t1498 8.76154
R811 VPWR.n22 VPWR.t1436 8.76154
R812 VPWR.n22 VPWR.t1434 8.76154
R813 VPWR.n22 VPWR.t1444 8.76154
R814 VPWR.n22 VPWR.t1442 8.76154
R815 VPWR.n22 VPWR.t1440 8.76154
R816 VPWR.n1373 VPWR.t1428 8.76154
R817 VPWR.n1370 VPWR.t1426 8.76154
R818 VPWR.n373 VPWR.t1424 8.76154
R819 VPWR.n1342 VPWR.t1422 8.76154
R820 VPWR.n370 VPWR.t1420 8.76154
R821 VPWR.n1365 VPWR.t1418 8.76154
R822 VPWR.n1336 VPWR.t1902 8.76154
R823 VPWR.n375 VPWR.t1900 8.76154
R824 VPWR.n1383 VPWR.t1898 8.76154
R825 VPWR.n1381 VPWR.t1896 8.76154
R826 VPWR.n622 VPWR.t1894 8.76154
R827 VPWR.n19 VPWR.t2024 8.76154
R828 VPWR.n19 VPWR.t2022 8.76154
R829 VPWR.n19 VPWR.t2020 8.76154
R830 VPWR.n395 VPWR.t2018 8.76154
R831 VPWR.n1322 VPWR.t2016 8.76154
R832 VPWR.n1325 VPWR.t2014 8.76154
R833 VPWR.n726 VPWR.t1088 8.76154
R834 VPWR.n724 VPWR.t1090 8.76154
R835 VPWR.n722 VPWR.t1092 8.76154
R836 VPWR.n720 VPWR.t1094 8.76154
R837 VPWR.n718 VPWR.t1096 8.76154
R838 VPWR.n716 VPWR.t1098 8.76154
R839 VPWR.n679 VPWR.t2180 8.76154
R840 VPWR.n683 VPWR.t2178 8.76154
R841 VPWR.t329 VPWR.t1839 8.76054
R842 VPWR.n50 VPWR.t1841 8.76054
R843 VPWR.n339 VPWR.t1845 8.76054
R844 VPWR.n651 VPWR.t1847 8.76054
R845 VPWR.n662 VPWR.t1013 8.76054
R846 VPWR.n664 VPWR.t689 8.76054
R847 VPWR.n644 VPWR.t523 8.76054
R848 VPWR.n642 VPWR.t525 8.76054
R849 VPWR.n640 VPWR.t527 8.76054
R850 VPWR.n666 VPWR.t529 8.76054
R851 VPWR.n668 VPWR.t531 8.76054
R852 VPWR.n670 VPWR.t533 8.76054
R853 VPWR.n62 VPWR.t1153 8.76054
R854 VPWR.n63 VPWR.t1155 8.76054
R855 VPWR.n52 VPWR.t1157 8.76054
R856 VPWR.n42 VPWR.t1159 8.76054
R857 VPWR.n35 VPWR.t1161 8.76054
R858 VPWR.n1595 VPWR.t1163 8.76054
R859 VPWR.n1626 VPWR.t691 8.76054
R860 VPWR.n1623 VPWR.t693 8.76054
R861 VPWR.n1621 VPWR.t695 8.76054
R862 VPWR.n1628 VPWR.t697 8.76054
R863 VPWR.n1630 VPWR.t699 8.76054
R864 VPWR.n1632 VPWR.t701 8.76054
R865 VPWR.n1610 VPWR.t1226 8.76054
R866 VPWR.n1648 VPWR.t1228 8.76054
R867 VPWR.n1607 VPWR.t1230 8.76054
R868 VPWR.n1604 VPWR.t1232 8.76054
R869 VPWR.n342 VPWR.t1234 8.76054
R870 VPWR.n1650 VPWR.t1236 8.76054
R871 VPWR.n735 VPWR.t686 8.76054
R872 VPWR.n189 VPWR.t465 8.76054
R873 VPWR.n743 VPWR.t467 8.76054
R874 VPWR.n746 VPWR.t469 8.76054
R875 VPWR.n747 VPWR.t471 8.76054
R876 VPWR.n333 VPWR.t473 8.76054
R877 VPWR.n513 VPWR.t475 8.76054
R878 VPWR.n13 VPWR.t574 8.76054
R879 VPWR.n13 VPWR.t576 8.76054
R880 VPWR.n13 VPWR.t578 8.76054
R881 VPWR.n190 VPWR.t580 8.76054
R882 VPWR.n7 VPWR.t582 8.76054
R883 VPWR.n7 VPWR.t584 8.76054
R884 VPWR.n31 VPWR.t723 8.76054
R885 VPWR.n30 VPWR.t725 8.76054
R886 VPWR.n204 VPWR.t727 8.76054
R887 VPWR.n200 VPWR.t729 8.76054
R888 VPWR.n1589 VPWR.t731 8.76054
R889 VPWR.n1585 VPWR.t733 8.76054
R890 VPWR.n16 VPWR.t883 8.76054
R891 VPWR.n16 VPWR.t887 8.76054
R892 VPWR.n16 VPWR.t889 8.76054
R893 VPWR.n16 VPWR.t891 8.76054
R894 VPWR.n15 VPWR.t893 8.76054
R895 VPWR.n1572 VPWR.t947 8.76054
R896 VPWR.n1569 VPWR.t949 8.76054
R897 VPWR.n1566 VPWR.t951 8.76054
R898 VPWR.n1563 VPWR.t953 8.76054
R899 VPWR.n202 VPWR.t955 8.76054
R900 VPWR.n198 VPWR.t957 8.76054
R901 VPWR.n235 VPWR.t915 8.76054
R902 VPWR.n237 VPWR.t917 8.76054
R903 VPWR.n239 VPWR.t919 8.76054
R904 VPWR.n402 VPWR.t921 8.76054
R905 VPWR.n241 VPWR.t923 8.76054
R906 VPWR.n406 VPWR.t925 8.76054
R907 VPWR.n880 VPWR.t1205 8.76054
R908 VPWR.n882 VPWR.t1207 8.76054
R909 VPWR.n884 VPWR.t1209 8.76054
R910 VPWR.n885 VPWR.t1211 8.76054
R911 VPWR.n876 VPWR.t1213 8.76054
R912 VPWR.n874 VPWR.t1215 8.76054
R913 VPWR.n1483 VPWR.t1032 8.76054
R914 VPWR.n11 VPWR.t1034 8.76054
R915 VPWR.n12 VPWR.t1036 8.76054
R916 VPWR.n12 VPWR.t1038 8.76054
R917 VPWR.n12 VPWR.t1040 8.76054
R918 VPWR.n12 VPWR.t1042 8.76054
R919 VPWR.n90 VPWR.t450 8.76054
R920 VPWR.n759 VPWR.t452 8.76054
R921 VPWR.n763 VPWR.t454 8.76054
R922 VPWR.n387 VPWR.t456 8.76054
R923 VPWR.n757 VPWR.t458 8.76054
R924 VPWR.n754 VPWR.t460 8.76054
R925 VPWR.n267 VPWR.t558 8.76054
R926 VPWR.n247 VPWR.t560 8.76054
R927 VPWR.n85 VPWR.t562 8.76054
R928 VPWR.n84 VPWR.t564 8.76054
R929 VPWR.n249 VPWR.t566 8.76054
R930 VPWR.n251 VPWR.t568 8.76054
R931 VPWR.n188 VPWR.t1520 8.76054
R932 VPWR.n791 VPWR.t1522 8.76054
R933 VPWR.n795 VPWR.t1524 8.76054
R934 VPWR.n798 VPWR.t1526 8.76054
R935 VPWR.n800 VPWR.t1528 8.76054
R936 VPWR.n803 VPWR.t1530 8.76054
R937 VPWR.n186 VPWR.t1603 8.76054
R938 VPWR.n814 VPWR.t1605 8.76054
R939 VPWR.n818 VPWR.t1607 8.76054
R940 VPWR.n821 VPWR.t1609 8.76054
R941 VPWR.n823 VPWR.t1611 8.76054
R942 VPWR.n826 VPWR.t1613 8.76054
R943 VPWR.n253 VPWR.t972 8.76054
R944 VPWR.n82 VPWR.t974 8.76054
R945 VPWR.n254 VPWR.t976 8.76054
R946 VPWR.n256 VPWR.t978 8.76054
R947 VPWR.n258 VPWR.t980 8.76054
R948 VPWR.n273 VPWR.t982 8.76054
R949 VPWR.n2 VPWR.t554 8.76054
R950 VPWR.n2 VPWR.t1224 8.76054
R951 VPWR.n1515 VPWR.t899 8.76054
R952 VPWR.n1516 VPWR.t901 8.76054
R953 VPWR.n1520 VPWR.t903 8.76054
R954 VPWR.n155 VPWR.t905 8.76054
R955 VPWR.n1522 VPWR.t907 8.76054
R956 VPWR.n1524 VPWR.t909 8.76054
R957 VPWR.n904 VPWR.t2322 8.76054
R958 VPWR.n906 VPWR.t2324 8.76054
R959 VPWR.n908 VPWR.t2326 8.76054
R960 VPWR.n909 VPWR.t2328 8.76054
R961 VPWR.n900 VPWR.t2330 8.76054
R962 VPWR.n898 VPWR.t2332 8.76054
R963 VPWR.n922 VPWR.t2340 8.76054
R964 VPWR.n350 VPWR.t2342 8.76054
R965 VPWR.n926 VPWR.t2344 8.76054
R966 VPWR.n929 VPWR.t2346 8.76054
R967 VPWR.n931 VPWR.t2348 8.76054
R968 VPWR.n933 VPWR.t2350 8.76054
R969 VPWR.n943 VPWR.t2356 8.76054
R970 VPWR.n946 VPWR.t2358 8.76054
R971 VPWR.n949 VPWR.t2360 8.76054
R972 VPWR.n952 VPWR.t2362 8.76054
R973 VPWR.n192 VPWR.t2364 8.76054
R974 VPWR.n956 VPWR.t2366 8.76054
R975 VPWR.n145 VPWR.t2269 8.76054
R976 VPWR.n972 VPWR.t2271 8.76054
R977 VPWR.n975 VPWR.t2273 8.76054
R978 VPWR.n389 VPWR.t2275 8.76054
R979 VPWR.n124 VPWR.t2277 8.76054
R980 VPWR.n123 VPWR.t2279 8.76054
R981 VPWR.n275 VPWR.t2096 8.76054
R982 VPWR.n259 VPWR.t2098 8.76054
R983 VPWR.n80 VPWR.t2100 8.76054
R984 VPWR.n403 VPWR.t2102 8.76054
R985 VPWR.n260 VPWR.t2104 8.76054
R986 VPWR.n262 VPWR.t2106 8.76054
R987 VPWR.n243 VPWR.t1175 8.76054
R988 VPWR.n1467 VPWR.t1177 8.76054
R989 VPWR.n55 VPWR.t1179 8.76054
R990 VPWR.n75 VPWR.t1181 8.76054
R991 VPWR.n1465 VPWR.t1183 8.76054
R992 VPWR.n1461 VPWR.t1185 8.76054
R993 VPWR.n18 VPWR.t2236 8.76054
R994 VPWR.n18 VPWR.t2240 8.76054
R995 VPWR.n18 VPWR.t2242 8.76054
R996 VPWR.n18 VPWR.t2244 8.76054
R997 VPWR.n5 VPWR.t2246 8.76054
R998 VPWR.n1439 VPWR.t1362 8.76054
R999 VPWR.n1437 VPWR.t1364 8.76054
R1000 VPWR.n1012 VPWR.t804 8.76054
R1001 VPWR.n1010 VPWR.t806 8.76054
R1002 VPWR.n1008 VPWR.t808 8.76054
R1003 VPWR.n1006 VPWR.t810 8.76054
R1004 VPWR.n1004 VPWR.t812 8.76054
R1005 VPWR.n1002 VPWR.t814 8.76054
R1006 VPWR.n981 VPWR.t2390 8.76054
R1007 VPWR.n73 VPWR.t2392 8.76054
R1008 VPWR.n53 VPWR.t2394 8.76054
R1009 VPWR.n43 VPWR.t2396 8.76054
R1010 VPWR.n38 VPWR.t2398 8.76054
R1011 VPWR.n1114 VPWR.t1740 8.76054
R1012 VPWR.n1116 VPWR.t1742 8.76054
R1013 VPWR.n1118 VPWR.t1744 8.76054
R1014 VPWR.n1119 VPWR.t1746 8.76054
R1015 VPWR.n1110 VPWR.t1748 8.76054
R1016 VPWR.n1108 VPWR.t1750 8.76054
R1017 VPWR.n1101 VPWR.t1758 8.76054
R1018 VPWR.n182 VPWR.t1760 8.76054
R1019 VPWR.n1125 VPWR.t1762 8.76054
R1020 VPWR.n1128 VPWR.t1764 8.76054
R1021 VPWR.n1131 VPWR.t1766 8.76054
R1022 VPWR.n1134 VPWR.t1768 8.76054
R1023 VPWR.t16 VPWR.t2030 8.76054
R1024 VPWR.t16 VPWR.t2032 8.76054
R1025 VPWR.t16 VPWR.t2034 8.76054
R1026 VPWR.t16 VPWR.t2036 8.76054
R1027 VPWR.t16 VPWR.t2040 8.76054
R1028 VPWR.n6 VPWR.t1292 8.76054
R1029 VPWR.n6 VPWR.t1294 8.76054
R1030 VPWR.n6 VPWR.t1296 8.76054
R1031 VPWR.n421 VPWR.t1298 8.76054
R1032 VPWR.n357 VPWR.t1300 8.76054
R1033 VPWR.n1147 VPWR.t1302 8.76054
R1034 VPWR.n184 VPWR.t1978 8.76054
R1035 VPWR.n1160 VPWR.t1980 8.76054
R1036 VPWR.n1163 VPWR.t1982 8.76054
R1037 VPWR.n1164 VPWR.t1984 8.76054
R1038 VPWR.n335 VPWR.t1986 8.76054
R1039 VPWR.n543 VPWR.t1988 8.76054
R1040 VPWR.n3 VPWR.t2082 8.76054
R1041 VPWR.n4 VPWR.t2084 8.76054
R1042 VPWR.n4 VPWR.t2086 8.76054
R1043 VPWR.n4 VPWR.t2088 8.76054
R1044 VPWR.n4 VPWR.t2090 8.76054
R1045 VPWR.n4 VPWR.t2092 8.76054
R1046 VPWR.n1397 VPWR.t2144 8.76054
R1047 VPWR.n1399 VPWR.t2146 8.76054
R1048 VPWR.n1401 VPWR.t2148 8.76054
R1049 VPWR.n1403 VPWR.t2150 8.76054
R1050 VPWR.n1405 VPWR.t2152 8.76054
R1051 VPWR.n1407 VPWR.t2154 8.76054
R1052 VPWR.n308 VPWR.t1450 8.76054
R1053 VPWR.n1415 VPWR.t1452 8.76054
R1054 VPWR.n1417 VPWR.t1454 8.76054
R1055 VPWR.n147 VPWR.t1456 8.76054
R1056 VPWR.n1420 VPWR.t1458 8.76054
R1057 VPWR.n1055 VPWR.t2191 8.76054
R1058 VPWR.n122 VPWR.t2193 8.76054
R1059 VPWR.n139 VPWR.t2195 8.76054
R1060 VPWR.n1045 VPWR.t2197 8.76054
R1061 VPWR.n217 VPWR.t2199 8.76054
R1062 VPWR.n594 VPWR.t2201 8.76054
R1063 VPWR.n1064 VPWR.t2188 8.76054
R1064 VPWR.n362 VPWR.t2209 8.76054
R1065 VPWR.n1068 VPWR.t2211 8.76054
R1066 VPWR.n1070 VPWR.t2213 8.76054
R1067 VPWR.n1072 VPWR.t2215 8.76054
R1068 VPWR.n1073 VPWR.t2189 8.76054
R1069 VPWR.n1025 VPWR.t1908 8.76054
R1070 VPWR.n1022 VPWR.t1910 8.76054
R1071 VPWR.n68 VPWR.t1912 8.76054
R1072 VPWR.n67 VPWR.t1914 8.76054
R1073 VPWR.n196 VPWR.t1916 8.76054
R1074 VPWR.n193 VPWR.t1918 8.76054
R1075 VPWR.n1312 VPWR.t1312 8.76054
R1076 VPWR.n1314 VPWR.t1314 8.76054
R1077 VPWR.n1316 VPWR.t1316 8.76054
R1078 VPWR.n1317 VPWR.t1318 8.76054
R1079 VPWR.n1308 VPWR.t1320 8.76054
R1080 VPWR.n1306 VPWR.t1322 8.76054
R1081 VPWR.n1199 VPWR.t1569 8.76054
R1082 VPWR.n1200 VPWR.t1571 8.76054
R1083 VPWR.n1204 VPWR.t1573 8.76054
R1084 VPWR.n1207 VPWR.t1575 8.76054
R1085 VPWR.n183 VPWR.t1577 8.76054
R1086 VPWR.n1210 VPWR.t1579 8.76054
R1087 VPWR.n1219 VPWR.t1276 8.76054
R1088 VPWR.n1185 VPWR.t1278 8.76054
R1089 VPWR.n497 VPWR.t1280 8.76054
R1090 VPWR.n498 VPWR.t1282 8.76054
R1091 VPWR.n500 VPWR.t1284 8.76054
R1092 VPWR.n502 VPWR.t1286 8.76054
R1093 VPWR.n1174 VPWR.t1962 8.76054
R1094 VPWR.n1172 VPWR.t1964 8.76054
R1095 VPWR.n1170 VPWR.t1966 8.76054
R1096 VPWR.n1231 VPWR.t1968 8.76054
R1097 VPWR.n1233 VPWR.t1970 8.76054
R1098 VPWR.n1235 VPWR.t1972 8.76054
R1099 VPWR.n1286 VPWR.t1925 8.76054
R1100 VPWR.n1282 VPWR.t1927 8.76054
R1101 VPWR.n1278 VPWR.t1929 8.76054
R1102 VPWR.n366 VPWR.t1931 8.76054
R1103 VPWR.n57 VPWR.t1933 8.76054
R1104 VPWR.n57 VPWR.t1935 8.76054
R1105 VPWR.n1257 VPWR.t1472 8.76054
R1106 VPWR.n1255 VPWR.t1474 8.76054
R1107 VPWR.n1253 VPWR.t1476 8.76054
R1108 VPWR.n1251 VPWR.t1478 8.76054
R1109 VPWR.n1249 VPWR.t1480 8.76054
R1110 VPWR.n1247 VPWR.t1482 8.76054
R1111 VPWR.n22 VPWR.t1400 8.76054
R1112 VPWR.n228 VPWR.t1402 8.76054
R1113 VPWR.n1352 VPWR.t1404 8.76054
R1114 VPWR.n1348 VPWR.t1408 8.76054
R1115 VPWR.n440 VPWR.t1410 8.76054
R1116 VPWR.n1366 VPWR.t1855 8.76054
R1117 VPWR.n1368 VPWR.t1857 8.76054
R1118 VPWR.n369 VPWR.t1859 8.76054
R1119 VPWR.n1341 VPWR.t1861 8.76054
R1120 VPWR.n374 VPWR.t1863 8.76054
R1121 VPWR.n1369 VPWR.t1865 8.76054
R1122 VPWR.n1384 VPWR.t1777 8.76054
R1123 VPWR.n1386 VPWR.t1601 8.76054
R1124 VPWR.n1326 VPWR.t1619 8.76054
R1125 VPWR.n1323 VPWR.t1621 8.76054
R1126 VPWR.n726 VPWR.t1820 8.76054
R1127 VPWR.n724 VPWR.t1822 8.76054
R1128 VPWR.n722 VPWR.t1824 8.76054
R1129 VPWR.n720 VPWR.t1826 8.76054
R1130 VPWR.n718 VPWR.t1828 8.76054
R1131 VPWR.n716 VPWR.t1830 8.76054
R1132 VPWR.n705 VPWR.t1258 8.76054
R1133 VPWR.n605 VPWR.t1262 8.76054
R1134 VPWR.n325 VPWR.t1264 8.76054
R1135 VPWR.n379 VPWR.t1266 8.76054
R1136 VPWR.n701 VPWR.t1268 8.76054
R1137 VPWR.n681 VPWR.t2409 8.76054
R1138 VPWR.n79 VPWR.t2411 8.76054
R1139 VPWR.n54 VPWR.t2413 8.76054
R1140 VPWR.n44 VPWR.t2415 8.76054
R1141 VPWR.n676 VPWR.t2417 8.76054
R1142 VPWR.n673 VPWR.t2419 8.76054
R1143 VPWR.n672 VPWR.t550 8.75942
R1144 VPWR.n1597 VPWR.t1068 8.75942
R1145 VPWR.n1634 VPWR.t635 8.75942
R1146 VPWR.n872 VPWR.t1116 8.75942
R1147 VPWR.n344 VPWR.t602 8.75942
R1148 VPWR.n267 VPWR.t606 8.75942
R1149 VPWR.n273 VPWR.t880 8.75942
R1150 VPWR.n896 VPWR.t1202 8.75942
R1151 VPWR.n275 VPWR.t2128 8.75942
R1152 VPWR.n455 VPWR.t784 8.75942
R1153 VPWR.n1000 VPWR.t832 8.75942
R1154 VPWR.n986 VPWR.t2264 8.75942
R1155 VPWR.n1106 VPWR.t2072 8.75942
R1156 VPWR.n1149 VPWR.t2301 8.75942
R1157 VPWR.n1409 VPWR.t2172 8.75942
R1158 VPWR.n1051 VPWR.t2233 8.75942
R1159 VPWR.n1077 VPWR.t1883 8.75942
R1160 VPWR.n1304 VPWR.t1340 8.75942
R1161 VPWR.n1216 VPWR.t1381 8.75942
R1162 VPWR.n1237 VPWR.t1550 8.75942
R1163 VPWR.n1284 VPWR.t1553 8.75942
R1164 VPWR.n1245 VPWR.t1500 8.75942
R1165 VPWR.n1362 VPWR.t1416 8.75942
R1166 VPWR.n279 VPWR.t1904 8.75942
R1167 VPWR.n1328 VPWR.t2012 8.75942
R1168 VPWR.n714 VPWR.t1100 8.75942
R1169 VPWR.n654 VPWR.t1849 8.75843
R1170 VPWR.n672 VPWR.t535 8.75843
R1171 VPWR.n1592 VPWR.t1165 8.75843
R1172 VPWR.n1634 VPWR.t703 8.75843
R1173 VPWR.n1653 VPWR.t1238 8.75843
R1174 VPWR.n9 VPWR.t477 8.75843
R1175 VPWR.n7 VPWR.t586 8.75843
R1176 VPWR.n1583 VPWR.t735 8.75843
R1177 VPWR.n872 VPWR.t1217 8.75843
R1178 VPWR.n269 VPWR.t570 8.75843
R1179 VPWR.n271 VPWR.t970 8.75843
R1180 VPWR.n896 VPWR.t2334 8.75843
R1181 VPWR.n959 VPWR.t2368 8.75843
R1182 VPWR.n277 VPWR.t2108 8.75843
R1183 VPWR.n5 VPWR.t2248 8.75843
R1184 VPWR.n1000 VPWR.t816 8.75843
R1185 VPWR.n33 VPWR.t2400 8.75843
R1186 VPWR.n1106 VPWR.t1752 8.75843
R1187 VPWR.n1150 VPWR.t1304 8.75843
R1188 VPWR.n1167 VPWR.t1990 8.75843
R1189 VPWR.n1390 VPWR.t2080 8.75843
R1190 VPWR.n1409 VPWR.t2156 8.75843
R1191 VPWR.n97 VPWR.t1460 8.75843
R1192 VPWR.n1061 VPWR.t2206 8.75843
R1193 VPWR.n1304 VPWR.t1324 8.75843
R1194 VPWR.n1237 VPWR.t1974 8.75843
R1195 VPWR.n1273 VPWR.t1937 8.75843
R1196 VPWR.n1245 VPWR.t1484 8.75843
R1197 VPWR.n1372 VPWR.t1867 8.75843
R1198 VPWR.n714 VPWR.t1832 8.75843
R1199 VPWR.n697 VPWR.t1270 8.75843
R1200 VPWR.n685 VPWR.t2407 8.75843
R1201 VPWR.t177 VPWR.n629 5.64923
R1202 VPWR.t16 VPWR.n1093 8.50183
R1203 VPWR.n50 VPWR.n51 0.124691
R1204 VPWR.t272 VPWR.n630 0.0317231
R1205 VPWR.n232 VPWR.t4 5.64741
R1206 VPWR.n426 VPWR.t4 2.81243
R1207 VPWR.n993 VPWR.n632 0.0317231
R1208 VPWR.n1016 VPWR.n631 0.0768462
R1209 VPWR.n628 VPWR.t16 5.64879
R1210 VPWR.n634 VPWR.t16 5.64741
R1211 VPWR.n635 VPWR.t9 5.64741
R1212 VPWR.n608 VPWR.n607 0.0341352
R1213 VPWR.n611 VPWR.n610 0.0341352
R1214 VPWR.n614 VPWR.n613 0.0341352
R1215 VPWR.n617 VPWR.n616 0.0341352
R1216 VPWR.n621 VPWR.n620 0.0335761
R1217 VPWR.n625 VPWR.n624 0.0341352
R1218 VPWR.t0 VPWR.n844 8.47949
R1219 VPWR.t0 VPWR.n850 8.47794
R1220 VPWR.t25 VPWR.n980 8.47671
R1221 VPWR.t9 VPWR.n1244 8.47177
R1222 VPWR.t177 VPWR.n713 8.47177
R1223 VPWR.t4 VPWR.n1635 8.47177
R1224 VPWR.t0 VPWR.n871 8.47177
R1225 VPWR.n999 VPWR.t25 8.47177
R1226 VPWR.t25 VPWR.n895 8.47177
R1227 VPWR.t16 VPWR.n1410 8.47177
R1228 VPWR.t16 VPWR.n1105 8.47177
R1229 VPWR.t9 VPWR.n1238 8.47177
R1230 VPWR.t9 VPWR.n1303 8.47177
R1231 VPWR.t4 VPWR.n410 5.6369
R1232 VPWR.t4 VPWR.n1582 8.47144
R1233 VPWR.t0 VPWR.n852 8.47144
R1234 VPWR.t0 VPWR.n270 8.47144
R1235 VPWR.t0 VPWR.n268 8.47144
R1236 VPWR.t0 VPWR.n266 8.47144
R1237 VPWR.t0 VPWR.n465 2.75433
R1238 VPWR.t25 VPWR.n1446 8.47144
R1239 VPWR.t25 VPWR.n976 8.47144
R1240 VPWR.t25 VPWR.n967 8.47144
R1241 VPWR.t9 VPWR.n1330 8.47144
R1242 VPWR.t9 VPWR.n278 8.47144
R1243 VPWR.t177 VPWR.n1671 8.47111
R1244 VPWR.t177 VPWR.n675 8.47111
R1245 VPWR.n45 VPWR.n44 0.0572404
R1246 VPWR.n44 VPWR.n54 0.117148
R1247 VPWR.t177 VPWR.n704 8.47111
R1248 VPWR.t177 VPWR.n608 4.22715
R1249 VPWR.t177 VPWR.n707 8.47111
R1250 VPWR.t177 VPWR.n715 8.47111
R1251 VPWR.t177 VPWR.n717 8.47111
R1252 VPWR.t177 VPWR.n721 8.47111
R1253 VPWR.t177 VPWR.n723 8.47111
R1254 VPWR.t177 VPWR.n725 8.47111
R1255 VPWR.t177 VPWR.n727 8.47111
R1256 VPWR.t177 VPWR.n671 8.47111
R1257 VPWR.t177 VPWR.n669 8.47111
R1258 VPWR.t177 VPWR.n639 8.47111
R1259 VPWR.t177 VPWR.n641 8.47111
R1260 VPWR.t177 VPWR.n643 8.47111
R1261 VPWR.t177 VPWR.n645 8.47111
R1262 VPWR.t177 VPWR.n665 8.47111
R1263 VPWR.n51 VPWR.t177 2.73226
R1264 VPWR.n36 VPWR.n35 0.10715
R1265 VPWR.n35 VPWR.n42 0.112755
R1266 VPWR.t4 VPWR.n1549 8.47111
R1267 VPWR.t4 VPWR.n1667 8.47111
R1268 VPWR.n527 VPWR.n1664 0.121665
R1269 VPWR.t4 VPWR.n1659 8.47111
R1270 VPWR.t4 VPWR.n240 8.47111
R1271 VPWR.t4 VPWR.n401 8.47111
R1272 VPWR.t4 VPWR.n238 8.47111
R1273 VPWR.t4 VPWR.n236 8.47111
R1274 VPWR.t4 VPWR.n234 8.47111
R1275 VPWR.n28 VPWR.n37 0.28527
R1276 VPWR.t4 VPWR.n197 8.47111
R1277 VPWR.t4 VPWR.n1562 8.47111
R1278 VPWR.t4 VPWR.n1565 8.47111
R1279 VPWR.t4 VPWR.n1568 8.47111
R1280 VPWR.t4 VPWR.n1571 8.47111
R1281 VPWR.t4 VPWR.n176 8.47111
R1282 VPWR.n107 VPWR.n1575 0.115922
R1283 VPWR.t4 VPWR.n468 2.77913
R1284 VPWR.t4 VPWR.n16 1.43504
R1285 VPWR.t4 VPWR.n1579 8.47111
R1286 VPWR.t4 VPWR.n264 8.47111
R1287 VPWR.t4 VPWR.n1584 8.47111
R1288 VPWR.t4 VPWR.n199 8.47111
R1289 VPWR.t4 VPWR.n1590 8.47111
R1290 VPWR.n32 VPWR.n31 0.63723
R1291 VPWR.t4 VPWR.n32 1.16023
R1292 VPWR.t4 VPWR.n14 0.510658
R1293 VPWR.t4 VPWR.n332 8.47111
R1294 VPWR.t4 VPWR.n749 8.47111
R1295 VPWR.t4 VPWR.n742 8.47111
R1296 VPWR.n447 VPWR.n740 0.162495
R1297 VPWR.t4 VPWR.n738 8.47111
R1298 VPWR.t4 VPWR.n1603 8.47111
R1299 VPWR.t4 VPWR.n1606 8.47111
R1300 VPWR.t4 VPWR.n1609 8.47111
R1301 VPWR.t4 VPWR.n1612 8.47111
R1302 VPWR.t4 VPWR.n1615 8.47111
R1303 VPWR.t4 VPWR.n611 4.22715
R1304 VPWR.t4 VPWR.n1644 8.47111
R1305 VPWR.t4 VPWR.n1616 8.47111
R1306 VPWR.t4 VPWR.n1618 8.47111
R1307 VPWR.t4 VPWR.n1638 8.47111
R1308 VPWR.t4 VPWR.n1633 8.47111
R1309 VPWR.t4 VPWR.n1631 8.47111
R1310 VPWR.t4 VPWR.n1620 8.47111
R1311 VPWR.t4 VPWR.n1622 8.47111
R1312 VPWR.t4 VPWR.n1624 8.47111
R1313 VPWR.n93 VPWR.n92 0.0605362
R1314 VPWR.t0 VPWR.n769 8.47111
R1315 VPWR.n528 VPWR.n767 0.185415
R1316 VPWR.t0 VPWR.n494 8.47111
R1317 VPWR.n152 VPWR.n495 0.140025
R1318 VPWR.t0 VPWR.n1527 8.47111
R1319 VPWR.t0 VPWR.n154 8.47111
R1320 VPWR.t0 VPWR.n1517 8.47111
R1321 VPWR.t0 VPWR.n1513 8.47111
R1322 VPWR.t0 VPWR.n1510 8.47111
R1323 VPWR.t0 VPWR.n614 4.22715
R1324 VPWR.t0 VPWR.n1508 8.47111
R1325 VPWR.n2 VPWR.n114 0.94066
R1326 VPWR.t0 VPWR.n860 8.47111
R1327 VPWR.t0 VPWR.n854 8.47111
R1328 VPWR.t0 VPWR.n272 8.47111
R1329 VPWR.t0 VPWR.n257 8.47111
R1330 VPWR.n83 VPWR.n82 0.119605
R1331 VPWR.t0 VPWR.n83 4.177
R1332 VPWR.t0 VPWR.n252 8.47111
R1333 VPWR.t0 VPWR.n843 8.47111
R1334 VPWR.t0 VPWR.n840 8.47111
R1335 VPWR.t0 VPWR.n834 8.47111
R1336 VPWR.t0 VPWR.n828 8.47111
R1337 VPWR.t0 VPWR.n825 8.47111
R1338 VPWR.t0 VPWR.n819 8.47111
R1339 VPWR.t0 VPWR.n185 8.47111
R1340 VPWR.t0 VPWR.n811 8.47111
R1341 VPWR.t0 VPWR.n805 8.47111
R1342 VPWR.t0 VPWR.n802 8.47111
R1343 VPWR.t0 VPWR.n796 8.47111
R1344 VPWR.t0 VPWR.n187 8.47111
R1345 VPWR.t0 VPWR.n788 8.47111
R1346 VPWR.t0 VPWR.n778 8.47111
R1347 VPWR.n48 VPWR.n529 0.323079
R1348 VPWR.t0 VPWR.n250 8.47111
R1349 VPWR.t0 VPWR.n248 8.47111
R1350 VPWR.n86 VPWR.n85 0.119605
R1351 VPWR.t0 VPWR.n86 4.177
R1352 VPWR.t0 VPWR.n246 8.47111
R1353 VPWR.t0 VPWR.n765 8.47111
R1354 VPWR.t0 VPWR.n752 8.47111
R1355 VPWR.t0 VPWR.n755 8.47111
R1356 VPWR.t0 VPWR.n386 8.47111
R1357 VPWR.t0 VPWR.n866 8.47111
R1358 VPWR.t0 VPWR.n1495 8.47111
R1359 VPWR.t0 VPWR.n1490 8.47111
R1360 VPWR.t0 VPWR.n1488 8.47111
R1361 VPWR.t0 VPWR.n12 1.29414
R1362 VPWR.n291 VPWR.n175 0.171173
R1363 VPWR.t0 VPWR.n1482 8.47111
R1364 VPWR.t0 VPWR.n873 8.47111
R1365 VPWR.t0 VPWR.n875 8.47111
R1366 VPWR.t0 VPWR.n886 8.47111
R1367 VPWR.t0 VPWR.n883 8.47111
R1368 VPWR.t0 VPWR.n881 8.47111
R1369 VPWR.t25 VPWR.n979 8.47111
R1370 VPWR.t25 VPWR.n989 8.47111
R1371 VPWR.n34 VPWR.n33 0.0997282
R1372 VPWR.n33 VPWR.n38 0.106425
R1373 VPWR.n38 VPWR.n43 0.112755
R1374 VPWR.n997 VPWR.t25 8.47111
R1375 VPWR.n1001 VPWR.t25 8.47111
R1376 VPWR.n1003 VPWR.t25 8.47111
R1377 VPWR.n1007 VPWR.t25 8.47111
R1378 VPWR.n1009 VPWR.t25 8.47111
R1379 VPWR.n1011 VPWR.t25 8.47111
R1380 VPWR.n1013 VPWR.t25 8.47111
R1381 VPWR.n631 VPWR.t25 4.20591
R1382 VPWR.t25 VPWR.n416 8.47111
R1383 VPWR.t25 VPWR.n458 2.75085
R1384 VPWR.t25 VPWR.n575 4.22715
R1385 VPWR.t25 VPWR.n1432 8.47111
R1386 VPWR.t25 VPWR.n1438 8.47111
R1387 VPWR.t25 VPWR.n1441 8.47111
R1388 VPWR.t25 VPWR.n461 4.19446
R1389 VPWR.t25 VPWR.n1450 8.47111
R1390 VPWR.t25 VPWR.n460 2.37503
R1391 VPWR.t25 VPWR.n1453 8.47111
R1392 VPWR.t25 VPWR.n56 2.71944
R1393 VPWR.t25 VPWR.n242 8.47111
R1394 VPWR.t25 VPWR.n1469 8.47111
R1395 VPWR.t25 VPWR.n276 8.47111
R1396 VPWR.t25 VPWR.n261 8.47111
R1397 VPWR.n81 VPWR.n80 0.119605
R1398 VPWR.t25 VPWR.n81 4.177
R1399 VPWR.t25 VPWR.n274 8.47111
R1400 VPWR.t25 VPWR.n969 8.47111
R1401 VPWR.t25 VPWR.n388 8.47111
R1402 VPWR.t25 VPWR.n973 8.47111
R1403 VPWR.t25 VPWR.n970 8.47111
R1404 VPWR.t25 VPWR.n41 1.74726
R1405 VPWR.t25 VPWR.n953 8.47111
R1406 VPWR.t25 VPWR.n950 8.47111
R1407 VPWR.t25 VPWR.n947 8.47111
R1408 VPWR.t25 VPWR.n945 8.47111
R1409 VPWR.n60 VPWR.n941 0.119672
R1410 VPWR.t25 VPWR.n61 3.30696
R1411 VPWR.t25 VPWR.n937 8.47111
R1412 VPWR.t25 VPWR.n932 8.47111
R1413 VPWR.t25 VPWR.n928 8.47111
R1414 VPWR.t25 VPWR.n925 8.47111
R1415 VPWR.t25 VPWR.n920 8.47111
R1416 VPWR.t25 VPWR.n917 8.47111
R1417 VPWR.t25 VPWR.n914 8.47111
R1418 VPWR.t25 VPWR.n912 8.47111
R1419 VPWR.t25 VPWR.n893 8.47111
R1420 VPWR.t25 VPWR.n897 8.47111
R1421 VPWR.t25 VPWR.n899 8.47111
R1422 VPWR.t25 VPWR.n910 8.47111
R1423 VPWR.t25 VPWR.n907 8.47111
R1424 VPWR.t25 VPWR.n905 8.47111
R1425 VPWR.t16 VPWR.n1089 8.47111
R1426 VPWR.t16 VPWR.n1084 8.47111
R1427 VPWR.n71 VPWR.n1082 0.211357
R1428 VPWR.t16 VPWR.n1081 8.47111
R1429 VPWR.t16 VPWR.n194 8.47111
R1430 VPWR.t16 VPWR.n1023 8.47111
R1431 VPWR.t16 VPWR.n1026 8.47111
R1432 VPWR.t16 VPWR.n1030 8.47111
R1433 VPWR.n144 VPWR.n548 0.115922
R1434 VPWR.t16 VPWR.n1071 8.47111
R1435 VPWR.t16 VPWR.n1067 8.47111
R1436 VPWR.t16 VPWR.n633 8.47111
R1437 VPWR.n1426 VPWR.t16 8.47111
R1438 VPWR.t16 VPWR.n216 8.47111
R1439 VPWR.t16 VPWR.n1047 8.47111
R1440 VPWR.t16 VPWR.n146 8.47111
R1441 VPWR.t16 VPWR.n1416 8.47111
R1442 VPWR.t16 VPWR.n617 4.22715
R1443 VPWR.t16 VPWR.n1412 8.47111
R1444 VPWR.t16 VPWR.n1408 8.47111
R1445 VPWR.t16 VPWR.n1406 8.47111
R1446 VPWR.t16 VPWR.n1402 8.47111
R1447 VPWR.t16 VPWR.n1400 8.47111
R1448 VPWR.t16 VPWR.n1398 8.47111
R1449 VPWR.t16 VPWR.n1396 8.47111
R1450 VPWR.t16 VPWR.n1394 8.47111
R1451 VPWR.n138 VPWR.n545 0.115922
R1452 VPWR.t16 VPWR.n1391 8.47111
R1453 VPWR.t16 VPWR.n334 8.47111
R1454 VPWR.t16 VPWR.n1166 8.47111
R1455 VPWR.t16 VPWR.n1159 8.47111
R1456 VPWR.t16 VPWR.n1156 8.47111
R1457 VPWR.n452 VPWR.n1155 0.207495
R1458 VPWR.t16 VPWR.n1098 8.47111
R1459 VPWR.t16 VPWR.n1133 8.47111
R1460 VPWR.t16 VPWR.n1130 8.47111
R1461 VPWR.t16 VPWR.n1127 8.47111
R1462 VPWR.t16 VPWR.n1124 8.47111
R1463 VPWR.t16 VPWR.n1102 8.47111
R1464 VPWR.t16 VPWR.n621 4.22743
R1465 VPWR.t16 VPWR.n1122 8.47111
R1466 VPWR.t16 VPWR.n1103 8.47111
R1467 VPWR.t16 VPWR.n1107 8.47111
R1468 VPWR.t16 VPWR.n1109 8.47111
R1469 VPWR.t16 VPWR.n1120 8.47111
R1470 VPWR.t16 VPWR.n1117 8.47111
R1471 VPWR.t16 VPWR.n1115 8.47111
R1472 VPWR.t9 VPWR.n1240 8.47111
R1473 VPWR.t9 VPWR.n394 8.47111
R1474 VPWR.t9 VPWR.n1324 8.47111
R1475 VPWR.t9 VPWR.n1327 8.47111
R1476 VPWR.t9 VPWR.n1333 8.47111
R1477 VPWR.t9 VPWR.n1335 8.47111
R1478 VPWR.t9 VPWR.n1385 8.47111
R1479 VPWR.t9 VPWR.n1382 8.47111
R1480 VPWR.t9 VPWR.n625 4.22715
R1481 VPWR.t9 VPWR.n1378 8.47111
R1482 VPWR.t9 VPWR.n1340 8.47111
R1483 VPWR.t9 VPWR.n1343 8.47111
R1484 VPWR.n225 VPWR.n1358 0.115922
R1485 VPWR.n439 VPWR.n627 0.0969641
R1486 VPWR.t9 VPWR.n439 2.7791
R1487 VPWR.t9 VPWR.n1355 8.47111
R1488 VPWR.t9 VPWR.n1350 8.47111
R1489 VPWR.n22 VPWR.n228 0.692219
R1490 VPWR.t9 VPWR.n1242 8.47111
R1491 VPWR.t9 VPWR.n1246 8.47111
R1492 VPWR.t9 VPWR.n1248 8.47111
R1493 VPWR.t9 VPWR.n1252 8.47111
R1494 VPWR.t9 VPWR.n1254 8.47111
R1495 VPWR.t9 VPWR.n1256 8.47111
R1496 VPWR.t9 VPWR.n1258 8.47111
R1497 VPWR.t9 VPWR.n1260 8.47111
R1498 VPWR.n222 VPWR.n1268 0.115922
R1499 VPWR.t9 VPWR.n1277 8.47111
R1500 VPWR.t9 VPWR.n1293 8.47111
R1501 VPWR.t9 VPWR.n1236 8.47111
R1502 VPWR.t9 VPWR.n1234 8.47111
R1503 VPWR.t9 VPWR.n1169 8.47111
R1504 VPWR.t9 VPWR.n1171 8.47111
R1505 VPWR.t9 VPWR.n1173 8.47111
R1506 VPWR.t9 VPWR.n1175 8.47111
R1507 VPWR.t9 VPWR.n1177 8.47111
R1508 VPWR.t9 VPWR.n1179 8.47111
R1509 VPWR.n558 VPWR.n1182 0.121665
R1510 VPWR.t9 VPWR.n1230 8.47111
R1511 VPWR.t9 VPWR.n1226 8.47111
R1512 VPWR.t9 VPWR.n1222 8.47111
R1513 VPWR.t9 VPWR.n501 8.47111
R1514 VPWR.t9 VPWR.n496 8.47111
R1515 VPWR.t9 VPWR.n1184 8.47111
R1516 VPWR.t9 VPWR.n171 8.47111
R1517 VPWR.n221 VPWR.n555 0.115922
R1518 VPWR.t9 VPWR.n336 8.47111
R1519 VPWR.t9 VPWR.n1215 8.47111
R1520 VPWR.t9 VPWR.n1208 8.47111
R1521 VPWR.t9 VPWR.n1205 8.47111
R1522 VPWR.t9 VPWR.n1201 8.47111
R1523 VPWR.t9 VPWR.n1197 8.47111
R1524 VPWR.t9 VPWR.n1190 8.47111
R1525 VPWR.t9 VPWR.n1191 8.47111
R1526 VPWR.t9 VPWR.n1321 8.47111
R1527 VPWR.t9 VPWR.n1301 8.47111
R1528 VPWR.t9 VPWR.n1305 8.47111
R1529 VPWR.t9 VPWR.n1307 8.47111
R1530 VPWR.t9 VPWR.n1318 8.47111
R1531 VPWR.t9 VPWR.n1315 8.47111
R1532 VPWR.t9 VPWR.n1313 8.47111
R1533 VPWR.t305 VPWR.t2464 7.62628
R1534 VPWR.n436 VPWR.t2479 7.62628
R1535 VPWR.n1599 VPWR.t2478 7.62628
R1536 VPWR.n1598 VPWR.t2477 7.62628
R1537 VPWR.n392 VPWR.t2475 7.62628
R1538 VPWR.n424 VPWR.t2481 7.62628
R1539 VPWR.n512 VPWR.t2480 7.62628
R1540 VPWR.n1576 VPWR.t2474 7.62628
R1541 VPWR.n16 VPWR.t2473 7.62628
R1542 VPWR.n569 VPWR.t2472 7.62628
R1543 VPWR.n519 VPWR.t2471 7.62628
R1544 VPWR.n522 VPWR.t2470 7.62628
R1545 VPWR.n524 VPWR.t2468 7.62628
R1546 VPWR.n430 VPWR.t2503 7.62628
R1547 VPWR.n428 VPWR.t2509 7.62628
R1548 VPWR.n1493 VPWR.t2507 7.62628
R1549 VPWR.n577 VPWR.t2505 7.62628
R1550 VPWR.n773 VPWR.t2502 7.62628
R1551 VPWR.n858 VPWR.t2500 7.62628
R1552 VPWR.n477 VPWR.t2534 7.62628
R1553 VPWR.n581 VPWR.t2538 7.62628
R1554 VPWR.n940 VPWR.t2536 7.62628
R1555 VPWR.n598 VPWR.t2535 7.62628
R1556 VPWR.n466 VPWR.t2533 7.62628
R1557 VPWR.n17 VPWR.t2532 7.62628
R1558 VPWR.n536 VPWR.t2529 7.62628
R1559 VPWR.n434 VPWR.t2563 7.62628
R1560 VPWR.n599 VPWR.t2562 7.62628
R1561 VPWR.n585 VPWR.t2569 7.62628
R1562 VPWR.n619 VPWR.t2568 7.62628
R1563 VPWR.t16 VPWR.t2567 7.62628
R1564 VPWR.t16 VPWR.t2566 7.62628
R1565 VPWR.n6 VPWR.t2565 7.62628
R1566 VPWR.n542 VPWR.t2564 7.62628
R1567 VPWR.n1392 VPWR.t2561 7.62628
R1568 VPWR.n615 VPWR.t2560 7.62628
R1569 VPWR.n1044 VPWR.t2559 7.62628
R1570 VPWR.n593 VPWR.t2558 7.62628
R1571 VPWR.n1040 VPWR.t2557 7.62628
R1572 VPWR.n549 VPWR.t2556 7.62628
R1573 VPWR.n1027 VPWR.t2555 7.62628
R1574 VPWR.n485 VPWR.t2588 7.62628
R1575 VPWR.n589 VPWR.t2592 7.62628
R1576 VPWR.n556 VPWR.t2590 7.62628
R1577 VPWR.n1180 VPWR.t2589 7.62628
R1578 VPWR.n1295 VPWR.t2587 7.62628
R1579 VPWR.n561 VPWR.t2586 7.62628
R1580 VPWR.n563 VPWR.t2585 7.62628
R1581 VPWR.n1353 VPWR.t2583 7.62628
R1582 VPWR.n626 VPWR.t2582 7.62628
R1583 VPWR.n566 VPWR.t2581 7.62628
R1584 VPWR.n606 VPWR.t2463 7.62628
R1585 VPWR.t445 VPWR.t2466 7.62594
R1586 VPWR.n503 VPWR.t2492 7.62594
R1587 VPWR.n506 VPWR.t2491 7.62594
R1588 VPWR.n509 VPWR.t2490 7.62594
R1589 VPWR.n578 VPWR.t2498 7.62594
R1590 VPWR.n1639 VPWR.t2497 7.62594
R1591 VPWR.n609 VPWR.t2496 7.62594
R1592 VPWR.n473 VPWR.t2494 7.62594
R1593 VPWR.n10 VPWR.t2493 7.62594
R1594 VPWR.n603 VPWR.t2488 7.62594
R1595 VPWR.n517 VPWR.t2487 7.62594
R1596 VPWR.n1574 VPWR.t2486 7.62594
R1597 VPWR.n1573 VPWR.t2485 7.62594
R1598 VPWR.n37 VPWR.t2484 7.62594
R1599 VPWR.n1663 VPWR.t2482 7.62594
R1600 VPWR.n601 VPWR.t2527 7.62594
R1601 VPWR.n1492 VPWR.t2526 7.62594
R1602 VPWR.n464 VPWR.t2524 7.62594
R1603 VPWR.n530 VPWR.t2521 7.62594
R1604 VPWR.n779 VPWR.t2520 7.62594
R1605 VPWR.n838 VPWR.t2518 7.62594
R1606 VPWR.n857 VPWR.t2516 7.62594
R1607 VPWR.n2 VPWR.t2514 7.62594
R1608 VPWR.n600 VPWR.t2513 7.62594
R1609 VPWR.n612 VPWR.t2512 7.62594
R1610 VPWR.n533 VPWR.t2510 7.62594
R1611 VPWR.n476 VPWR.t2550 7.62594
R1612 VPWR.n471 VPWR.t2552 7.62594
R1613 VPWR.n1459 VPWR.t2549 7.62594
R1614 VPWR.n480 VPWR.t2548 7.62594
R1615 VPWR.n1454 VPWR.t2547 7.62594
R1616 VPWR.n596 VPWR.t2546 7.62594
R1617 VPWR.n1447 VPWR.t2545 7.62594
R1618 VPWR.n453 VPWR.t2544 7.62594
R1619 VPWR.n573 VPWR.t2542 7.62594
R1620 VPWR.n490 VPWR.t2540 7.62594
R1621 VPWR.n539 VPWR.t2577 7.62594
R1622 VPWR.n482 VPWR.t2578 7.62594
R1623 VPWR.n4 VPWR.t2576 7.62594
R1624 VPWR.n546 VPWR.t2575 7.62594
R1625 VPWR.n1039 VPWR.t2573 7.62594
R1626 VPWR.n1079 VPWR.t2572 7.62594
R1627 VPWR.n484 VPWR.t2602 7.62594
R1628 VPWR.n488 VPWR.t2606 7.62594
R1629 VPWR.n552 VPWR.t2605 7.62594
R1630 VPWR.n1217 VPWR.t2604 7.62594
R1631 VPWR.n559 VPWR.t2603 7.62594
R1632 VPWR.n1294 VPWR.t2601 7.62594
R1633 VPWR.n1267 VPWR.t2600 7.62594
R1634 VPWR.n1266 VPWR.t2599 7.62594
R1635 VPWR.n21 VPWR.t2597 7.62594
R1636 VPWR.n1357 VPWR.t2595 7.62594
R1637 VPWR.n623 VPWR.t2594 7.62594
R1638 VPWR.n618 VPWR.t1755 7.42681
R1639 VPWR.n37 VPWR.t1087 7.29001
R1640 VPWR.n980 VPWR.t137 6.02473
R1641 VPWR.n231 VPWR.t1241 6.0055
R1642 VPWR.n19 VPWR.t2026 6.0055
R1643 VPWR.n638 VPWR.t2421 6.00507
R1644 VPWR.n383 VPWR.t283 6.00339
R1645 VPWR.n89 VPWR.t142 6.00339
R1646 VPWR.n1640 VPWR.t654 5.99801
R1647 VPWR.n10 VPWR.t1641 5.99801
R1648 VPWR.n941 VPWR.t2355 5.99757
R1649 VPWR.n391 VPWR.t282 5.99589
R1650 VPWR.n1460 VPWR.t116 5.99589
R1651 VPWR.n393 VPWR.t277 5.99545
R1652 VPWR.n467 VPWR.t363 5.99545
R1653 VPWR.n1092 VPWR.t101 5.99428
R1654 VPWR.n1503 VPWR.t518 5.9894
R1655 VPWR.n7 VPWR.t1773 5.9747
R1656 VPWR.n1583 VPWR.t840 5.9747
R1657 VPWR.n192 VPWR.t839 5.9747
R1658 VPWR.n243 VPWR.t967 5.9747
R1659 VPWR.n457 VPWR.t1220 5.9747
R1660 VPWR.n699 VPWR.t1956 5.9747
R1661 VPWR.n1331 VPWR.t1631 5.97426
R1662 VPWR.n50 VPWR.t1811 5.97212
R1663 VPWR.n658 VPWR.t1816 5.97212
R1664 VPWR.n660 VPWR.t1818 5.97212
R1665 VPWR.n646 VPWR.t521 5.97212
R1666 VPWR.n1548 VPWR.t1055 5.97212
R1667 VPWR.n1625 VPWR.t622 5.97212
R1668 VPWR.n1654 VPWR.t1637 5.97212
R1669 VPWR.n1605 VPWR.t1632 5.97212
R1670 VPWR.n1657 VPWR.t1639 5.97212
R1671 VPWR.n737 VPWR.t1708 5.97212
R1672 VPWR.n391 VPWR.t738 5.97212
R1673 VPWR.n1570 VPWR.t1072 5.97212
R1674 VPWR.n878 VPWR.t1103 5.97212
R1675 VPWR.n12 VPWR.t655 5.97212
R1676 VPWR.n387 VPWR.t589 5.97212
R1677 VPWR.n751 VPWR.t620 5.97212
R1678 VPWR.n76 VPWR.t1136 5.97212
R1679 VPWR.n801 VPWR.t985 5.97212
R1680 VPWR.n824 VPWR.t787 5.97212
R1681 VPWR.n851 VPWR.t867 5.97212
R1682 VPWR.n2 VPWR.t930 5.97212
R1683 VPWR.n1506 VPWR.t487 5.97212
R1684 VPWR.n902 VPWR.t1189 5.97212
R1685 VPWR.n919 VPWR.t1015 5.97212
R1686 VPWR.n954 VPWR.t1463 5.97212
R1687 VPWR.n472 VPWR.t1470 5.97212
R1688 VPWR.n961 VPWR.t1468 5.97212
R1689 VPWR.n964 VPWR.t2287 5.97212
R1690 VPWR.n977 VPWR.t2142 5.97212
R1691 VPWR.n1463 VPWR.t1054 5.97212
R1692 VPWR.n74 VPWR.t1052 5.97212
R1693 VPWR.n1468 VPWR.t1047 5.97212
R1694 VPWR.n173 VPWR.t1503 5.97212
R1695 VPWR.n597 VPWR.t771 5.97212
R1696 VPWR.n5 VPWR.t1343 5.97212
R1697 VPWR.n1014 VPWR.t819 5.97212
R1698 VPWR.n72 VPWR.t2251 5.97212
R1699 VPWR.n1112 VPWR.t2059 5.97212
R1700 VPWR.n182 VPWR.t2043 5.97212
R1701 VPWR.n6 VPWR.t2288 5.97212
R1702 VPWR.n1154 VPWR.t2112 5.97212
R1703 VPWR.n4 VPWR.t1940 5.97212
R1704 VPWR.n1395 VPWR.t2159 5.97212
R1705 VPWR.n147 VPWR.t2220 5.97212
R1706 VPWR.n1057 VPWR.t1870 5.97212
R1707 VPWR.n1087 VPWR.t2387 5.97212
R1708 VPWR.n1310 VPWR.t1327 5.97212
R1709 VPWR.n219 VPWR.t1567 5.97212
R1710 VPWR.n1206 VPWR.t1368 5.97212
R1711 VPWR.n1228 VPWR.t1398 5.97212
R1712 VPWR.n1176 VPWR.t1537 5.97212
R1713 VPWR.n157 VPWR.t1566 5.97212
R1714 VPWR.n1259 VPWR.t1487 5.97212
R1715 VPWR.n228 VPWR.t1446 5.97212
R1716 VPWR.n1375 VPWR.t1430 5.97212
R1717 VPWR.n1380 VPWR.t1891 5.97212
R1718 VPWR.n728 VPWR.t1071 5.97212
R1719 VPWR.n377 VPWR.t1012 5.97212
R1720 VPWR.n703 VPWR.t1011 5.97212
R1721 VPWR.n687 VPWR.t2177 5.97212
R1722 VPWR.n54 VPWR.t2184 5.97212
R1723 VPWR.n79 VPWR.t2182 5.97212
R1724 VPWR.n646 VPWR.t522 5.97169
R1725 VPWR.n1552 VPWR.t1150 5.97169
R1726 VPWR.n1625 VPWR.t690 5.97169
R1727 VPWR.n1613 VPWR.t1225 5.97169
R1728 VPWR.n740 VPWR.t448 5.97169
R1729 VPWR.n13 VPWR.t573 5.97169
R1730 VPWR.n31 VPWR.t722 5.97169
R1731 VPWR.n178 VPWR.t866 5.97169
R1732 VPWR.n177 VPWR.t946 5.97169
R1733 VPWR.n233 VPWR.t914 5.97169
R1734 VPWR.n878 VPWR.t1188 5.97169
R1735 VPWR.n175 VPWR.t1031 5.97169
R1736 VPWR.n1496 VPWR.t1599 5.97169
R1737 VPWR.n1499 VPWR.t1600 5.97169
R1738 VPWR.n89 VPWR.t449 5.97169
R1739 VPWR.n766 VPWR.t557 5.97169
R1740 VPWR.n46 VPWR.t864 5.97169
R1741 VPWR.n47 VPWR.t865 5.97169
R1742 VPWR.n789 VPWR.t1519 5.97169
R1743 VPWR.n812 VPWR.t1602 5.97169
R1744 VPWR.n853 VPWR.t984 5.97169
R1745 VPWR.n1512 VPWR.t898 5.97169
R1746 VPWR.n902 VPWR.t2321 5.97169
R1747 VPWR.n936 VPWR.t2352 5.97169
R1748 VPWR.n40 VPWR.t2268 5.97169
R1749 VPWR.n968 VPWR.t2095 5.97169
R1750 VPWR.n467 VPWR.t1187 5.97169
R1751 VPWR.n1443 VPWR.t2219 5.97169
R1752 VPWR.n27 VPWR.t1359 5.97169
R1753 VPWR.n1442 VPWR.t1360 5.97169
R1754 VPWR.n1433 VPWR.t1366 5.97169
R1755 VPWR.n457 VPWR.t1309 5.97169
R1756 VPWR.n417 VPWR.t1310 5.97169
R1757 VPWR.n1014 VPWR.t803 5.97169
R1758 VPWR.n995 VPWR.t2371 5.97169
R1759 VPWR.n1112 VPWR.t1739 5.97169
R1760 VPWR.n179 VPWR.t1770 5.97169
R1761 VPWR.t16 VPWR.t2042 5.97169
R1762 VPWR.n6 VPWR.t1291 5.97169
R1763 VPWR.n1157 VPWR.t1977 5.97169
R1764 VPWR.n4 VPWR.t2094 5.97169
R1765 VPWR.n1395 VPWR.t2143 5.97169
R1766 VPWR.n1414 VPWR.t1447 5.97169
R1767 VPWR.n1052 VPWR.t2190 5.97169
R1768 VPWR.n1076 VPWR.t2218 5.97169
R1769 VPWR.n1028 VPWR.t1907 5.97169
R1770 VPWR.n1083 VPWR.t1307 5.97169
R1771 VPWR.n1086 VPWR.t1308 5.97169
R1772 VPWR.n1310 VPWR.t1311 5.97169
R1773 VPWR.n1196 VPWR.t1568 5.97169
R1774 VPWR.n172 VPWR.t1275 5.97169
R1775 VPWR.n1176 VPWR.t1961 5.97169
R1776 VPWR.n1290 VPWR.t1924 5.97169
R1777 VPWR.n1259 VPWR.t1471 5.97169
R1778 VPWR.n22 VPWR.t1399 5.97169
R1779 VPWR.n1363 VPWR.t1854 5.97169
R1780 VPWR.n1329 VPWR.t1618 5.97169
R1781 VPWR.n395 VPWR.t1623 5.97169
R1782 VPWR.n19 VPWR.t1625 5.97169
R1783 VPWR.n728 VPWR.t1819 5.97169
R1784 VPWR.n708 VPWR.t1257 5.97169
R1785 VPWR.n1537 VPWR.t486 5.97001
R1786 VPWR.n213 VPWR.t389 5.97001
R1787 VPWR.n280 VPWR.t388 5.97001
R1788 VPWR.n212 VPWR.t393 5.97001
R1789 VPWR.n282 VPWR.t392 5.97001
R1790 VPWR.n284 VPWR.t396 5.97001
R1791 VPWR.n1593 VPWR.t1070 5.97001
R1792 VPWR.n226 VPWR.t244 5.97001
R1793 VPWR.n1636 VPWR.t637 5.97001
R1794 VPWR.n736 VPWR.t286 5.97001
R1795 VPWR.n333 VPWR.t435 5.97001
R1796 VPWR.n10 VPWR.t437 5.97001
R1797 VPWR.n7 VPWR.t386 5.97001
R1798 VPWR.n1578 VPWR.t364 5.97001
R1799 VPWR.n106 VPWR.t412 5.97001
R1800 VPWR.n178 VPWR.t411 5.97001
R1801 VPWR.n15 VPWR.t440 5.97001
R1802 VPWR.n16 VPWR.t439 5.97001
R1803 VPWR.n108 VPWR.t175 5.97001
R1804 VPWR.n211 VPWR.t164 5.97001
R1805 VPWR.n111 VPWR.t443 5.97001
R1806 VPWR.n210 VPWR.t442 5.97001
R1807 VPWR.n177 VPWR.t248 5.97001
R1808 VPWR.n409 VPWR.t1256 6.04238
R1809 VPWR.n1661 VPWR.t299 5.97001
R1810 VPWR.n1665 VPWR.t288 5.97001
R1811 VPWR.n92 VPWR.t234 5.97001
R1812 VPWR.n768 VPWR.t237 5.97001
R1813 VPWR.n887 VPWR.t1118 5.97001
R1814 VPWR.n245 VPWR.t2 5.97001
R1815 VPWR.n175 VPWR.t369 5.97001
R1816 VPWR.n1491 VPWR.t403 5.97001
R1817 VPWR.n867 VPWR.t2404 5.97001
R1818 VPWR.n90 VPWR.t145 5.97001
R1819 VPWR.n764 VPWR.t604 5.97001
R1820 VPWR.n766 VPWR.t605 5.97001
R1821 VPWR.n47 VPWR.t257 5.97001
R1822 VPWR.n148 VPWR.t250 5.97001
R1823 VPWR.n853 VPWR.t882 5.97001
R1824 VPWR.n855 VPWR.t414 5.97001
R1825 VPWR.n0 VPWR.t417 5.97001
R1826 VPWR.n978 VPWR.t223 5.97001
R1827 VPWR.n894 VPWR.t1204 5.97001
R1828 VPWR.n582 VPWR.t196 5.97001
R1829 VPWR.n911 VPWR.t199 5.97001
R1830 VPWR.n60 VPWR.t401 5.97001
R1831 VPWR.n944 VPWR.t155 5.97001
R1832 VPWR.n125 VPWR.t168 5.97001
R1833 VPWR.n300 VPWR.t170 5.97001
R1834 VPWR.n968 VPWR.t2111 5.97001
R1835 VPWR.n1476 VPWR.t226 5.97001
R1836 VPWR.n462 VPWR.t113 5.97001
R1837 VPWR.n1445 VPWR.t786 5.97001
R1838 VPWR.n130 VPWR.t312 5.97001
R1839 VPWR.n18 VPWR.t315 5.97001
R1840 VPWR.n998 VPWR.t834 5.97001
R1841 VPWR.n438 VPWR.t408 5.97001
R1842 VPWR.n209 VPWR.t123 5.97001
R1843 VPWR.n304 VPWR.t192 5.97001
R1844 VPWR.n1104 VPWR.t2074 5.97001
R1845 VPWR.n586 VPWR.t297 5.97001
R1846 VPWR.n1123 VPWR.t309 5.97001
R1847 VPWR.n1121 VPWR.t308 5.97001
R1848 VPWR.n492 VPWR.t311 5.97001
R1849 VPWR.n1144 VPWR.t2058 5.97001
R1850 VPWR.t16 VPWR.t71 5.97001
R1851 VPWR.t16 VPWR.t69 5.97001
R1852 VPWR.n133 VPWR.t1169 5.97001
R1853 VPWR.t16 VPWR.t76 5.97001
R1854 VPWR.t16 VPWR.t74 5.97001
R1855 VPWR.n6 VPWR.t78 5.97001
R1856 VPWR.n119 VPWR.t2303 5.97001
R1857 VPWR.n335 VPWR.t186 5.97001
R1858 VPWR.n117 VPWR.t188 5.97001
R1859 VPWR.n118 VPWR.t190 5.97001
R1860 VPWR.n330 VPWR.t362 5.97001
R1861 VPWR.n4 VPWR.t1955 5.97001
R1862 VPWR.n136 VPWR.t21 5.97001
R1863 VPWR.n307 VPWR.t24 5.97001
R1864 VPWR.n1411 VPWR.t2174 5.97001
R1865 VPWR.n1413 VPWR.t349 5.97001
R1866 VPWR.n310 VPWR.t352 5.97001
R1867 VPWR.n1054 VPWR.t2235 5.97001
R1868 VPWR.n140 VPWR.t88 5.97001
R1869 VPWR.n217 VPWR.t87 5.97001
R1870 VPWR.n122 VPWR.t86 5.97001
R1871 VPWR.n311 VPWR.t90 5.97001
R1872 VPWR.n1427 VPWR.t91 5.97001
R1873 VPWR.n1042 VPWR.t98 5.97001
R1874 VPWR.n142 VPWR.t1885 5.97001
R1875 VPWR.n141 VPWR.t338 5.97001
R1876 VPWR.n150 VPWR.t342 5.97001
R1877 VPWR.n151 VPWR.t341 5.97001
R1878 VPWR.n1024 VPWR.t345 5.97001
R1879 VPWR.n1168 VPWR.t848 5.97001
R1880 VPWR.n1302 VPWR.t1342 5.97001
R1881 VPWR.n590 VPWR.t126 5.97001
R1882 VPWR.n1319 VPWR.t431 5.97001
R1883 VPWR.n161 VPWR.t1383 5.97001
R1884 VPWR.n159 VPWR.t12 5.97001
R1885 VPWR.n172 VPWR.t15 5.97001
R1886 VPWR.n1229 VPWR.t858 5.97001
R1887 VPWR.n1178 VPWR.t860 5.97001
R1888 VPWR.n1239 VPWR.t1552 5.97001
R1889 VPWR.n445 VPWR.t851 5.97001
R1890 VPWR.n443 VPWR.t852 5.97001
R1891 VPWR.n1292 VPWR.t2428 5.97001
R1892 VPWR.n1288 VPWR.t1535 5.97001
R1893 VPWR.n156 VPWR.t638 5.97001
R1894 VPWR.n206 VPWR.t642 5.97001
R1895 VPWR.n207 VPWR.t641 5.97001
R1896 VPWR.n399 VPWR.t645 5.97001
R1897 VPWR.n1243 VPWR.t1502 5.97001
R1898 VPWR.n1351 VPWR.t58 5.97001
R1899 VPWR.n440 VPWR.t62 5.97001
R1900 VPWR.n1347 VPWR.t61 5.97001
R1901 VPWR.n191 VPWR.t42 5.97001
R1902 VPWR.n205 VPWR.t40 5.97001
R1903 VPWR.n1359 VPWR.t45 5.97001
R1904 VPWR.n1360 VPWR.t1415 5.97001
R1905 VPWR.n1334 VPWR.t1906 5.97001
R1906 VPWR.n1332 VPWR.t2011 5.97001
R1907 VPWR.n730 VPWR.t306 5.97001
R1908 VPWR.n712 VPWR.t1102 5.97001
R1909 VPWR.n706 VPWR.t332 5.97001
R1910 VPWR.n326 VPWR.t335 5.97001
R1911 VPWR.n657 VPWR.t1851 5.96957
R1912 VPWR.n213 VPWR.t241 5.96957
R1913 VPWR.n101 VPWR.t242 5.96957
R1914 VPWR.n212 VPWR.t259 5.96957
R1915 VPWR.n103 VPWR.t260 5.96957
R1916 VPWR.n230 VPWR.t254 5.96957
R1917 VPWR.n393 VPWR.t1167 5.96957
R1918 VPWR.n1636 VPWR.t705 5.96957
R1919 VPWR.n1637 VPWR.t366 5.96957
R1920 VPWR.n1619 VPWR.t6 5.96957
R1921 VPWR.n1617 VPWR.t7 5.96957
R1922 VPWR.n1643 VPWR.t373 5.96957
R1923 VPWR.n1645 VPWR.t374 5.96957
R1924 VPWR.n381 VPWR.t377 5.96957
R1925 VPWR.n1656 VPWR.t1240 5.96957
R1926 VPWR.n104 VPWR.t148 5.96957
R1927 VPWR.n446 VPWR.t151 5.96957
R1928 VPWR.n10 VPWR.t479 5.96957
R1929 VPWR.n10 VPWR.t181 5.96957
R1930 VPWR.n10 VPWR.t184 5.96957
R1931 VPWR.n7 VPWR.t588 5.96957
R1932 VPWR.n7 VPWR.t239 5.96957
R1933 VPWR.n31 VPWR.t280 5.96957
R1934 VPWR.n265 VPWR.t737 5.96957
R1935 VPWR.n1581 VPWR.t330 5.96957
R1936 VPWR.n1577 VPWR.t337 5.96957
R1937 VPWR.n568 VPWR.t897 5.96957
R1938 VPWR.n211 VPWR.t420 5.96957
R1939 VPWR.n288 VPWR.t423 5.96957
R1940 VPWR.n210 VPWR.t424 5.96957
R1941 VPWR.n289 VPWR.t427 5.96957
R1942 VPWR.n28 VPWR.t294 5.96957
R1943 VPWR.n1660 VPWR.t929 5.96957
R1944 VPWR.n525 VPWR.t204 5.96957
R1945 VPWR.n571 VPWR.t207 5.96957
R1946 VPWR.n37 VPWR.t292 5.96957
R1947 VPWR.n887 VPWR.t1219 5.96957
R1948 VPWR.n112 VPWR.t402 5.96957
R1949 VPWR.n1489 VPWR.t156 5.96957
R1950 VPWR.n1491 VPWR.t158 5.96957
R1951 VPWR.n867 VPWR.t161 5.96957
R1952 VPWR.n345 VPWR.t171 5.96957
R1953 VPWR.n344 VPWR.t174 5.96957
R1954 VPWR.n751 VPWR.t572 5.96957
R1955 VPWR.n47 VPWR.t380 5.96957
R1956 VPWR.n149 VPWR.t383 5.96957
R1957 VPWR.n774 VPWR.t384 5.96957
R1958 VPWR.n77 VPWR.t118 5.96957
R1959 VPWR.n835 VPWR.t318 5.96957
R1960 VPWR.n842 VPWR.t321 5.96957
R1961 VPWR.n851 VPWR.t969 5.96957
R1962 VPWR.n855 VPWR.t179 5.96957
R1963 VPWR.n0 VPWR.t302 5.96957
R1964 VPWR.n2 VPWR.t210 5.96957
R1965 VPWR.n114 VPWR.t213 5.96957
R1966 VPWR.n115 VPWR.t214 5.96957
R1967 VPWR.n295 VPWR.t216 5.96957
R1968 VPWR.n1507 VPWR.t217 5.96957
R1969 VPWR.n298 VPWR.t220 5.96957
R1970 VPWR.n495 VPWR.t409 5.96957
R1971 VPWR.n1528 VPWR.t139 5.96957
R1972 VPWR.n978 VPWR.t193 5.96957
R1973 VPWR.n894 VPWR.t2336 5.96957
R1974 VPWR.n962 VPWR.t2370 5.96957
R1975 VPWR.n469 VPWR.t79 5.96957
R1976 VPWR.n965 VPWR.t82 5.96957
R1977 VPWR.n977 VPWR.t2110 5.96957
R1978 VPWR.n1476 VPWR.t195 5.96957
R1979 VPWR.n173 VPWR.t27 5.96957
R1980 VPWR.n126 VPWR.t28 5.96957
R1981 VPWR.n450 VPWR.t31 5.96957
R1982 VPWR.n448 VPWR.t32 5.96957
R1983 VPWR.n1451 VPWR.t35 5.96957
R1984 VPWR.n459 VPWR.t37 5.96957
R1985 VPWR.n87 VPWR.t39 5.96957
R1986 VPWR.n87 VPWR.t353 5.96957
R1987 VPWR.n456 VPWR.t356 5.96957
R1988 VPWR.n456 VPWR.t357 5.96957
R1989 VPWR.n454 VPWR.t360 5.96957
R1990 VPWR.n25 VPWR.t2250 5.96957
R1991 VPWR.n1431 VPWR.t95 5.96957
R1992 VPWR.n1020 VPWR.t100 5.96957
R1993 VPWR.n998 VPWR.t818 5.96957
R1994 VPWR.n984 VPWR.t2402 5.96957
R1995 VPWR.n131 VPWR.t103 5.96957
R1996 VPWR.n987 VPWR.t106 5.96957
R1997 VPWR.n209 VPWR.t857 5.96957
R1998 VPWR.n1104 VPWR.t1754 5.96957
R1999 VPWR.n1141 VPWR.t2027 5.96957
R2000 VPWR.n1152 VPWR.t1306 5.96957
R2001 VPWR.n119 VPWR.t19 5.96957
R2002 VPWR.n451 VPWR.t862 5.96957
R2003 VPWR.n118 VPWR.t1992 5.96957
R2004 VPWR.n116 VPWR.t855 5.96957
R2005 VPWR.n208 VPWR.t2079 5.96957
R2006 VPWR.n4 VPWR.t2429 5.96957
R2007 VPWR.n136 VPWR.t648 5.96957
R2008 VPWR.n137 VPWR.t650 5.96957
R2009 VPWR.n1393 VPWR.t653 5.96957
R2010 VPWR.n1411 VPWR.t2158 5.96957
R2011 VPWR.n1424 VPWR.t1462 5.96957
R2012 VPWR.n1427 VPWR.t46 5.96957
R2013 VPWR.n1042 VPWR.t49 5.96957
R2014 VPWR.n1058 VPWR.t2187 5.96957
R2015 VPWR.n142 VPWR.t134 5.96957
R2016 VPWR.n315 VPWR.t326 5.96957
R2017 VPWR.n1168 VPWR.t166 5.96957
R2018 VPWR.n1302 VPWR.t1326 5.96957
R2019 VPWR.n220 VPWR.t125 5.96957
R2020 VPWR.n441 VPWR.t51 5.96957
R2021 VPWR.n337 VPWR.t2422 5.96957
R2022 VPWR.n160 VPWR.t2425 5.96957
R2023 VPWR.n161 VPWR.t2426 5.96957
R2024 VPWR.n317 VPWR.t66 5.96957
R2025 VPWR.n1227 VPWR.t67 5.96957
R2026 VPWR.n1181 VPWR.t122 5.96957
R2027 VPWR.n1239 VPWR.t1976 5.96957
R2028 VPWR.n445 VPWR.t229 5.96957
R2029 VPWR.n443 VPWR.t230 5.96957
R2030 VPWR.n1292 VPWR.t11 5.96957
R2031 VPWR.n1269 VPWR.t1939 5.96957
R2032 VPWR.n157 VPWR.t262 5.96957
R2033 VPWR.n318 VPWR.t265 5.96957
R2034 VPWR.n207 VPWR.t266 5.96957
R2035 VPWR.n1265 VPWR.t269 5.96957
R2036 VPWR.n1243 VPWR.t1486 5.96957
R2037 VPWR.n1241 VPWR.t53 5.96957
R2038 VPWR.n22 VPWR.t55 5.96957
R2039 VPWR.n1356 VPWR.t1414 5.96957
R2040 VPWR.n205 VPWR.t109 5.96957
R2041 VPWR.n321 VPWR.t112 5.96957
R2042 VPWR.n1377 VPWR.t1869 5.96957
R2043 VPWR.n1379 VPWR.t273 5.96957
R2044 VPWR.n324 VPWR.t276 5.96957
R2045 VPWR.n730 VPWR.t446 5.96957
R2046 VPWR.n712 VPWR.t1834 5.96957
R2047 VPWR.n693 VPWR.t1272 5.96957
R2048 VPWR.n689 VPWR.t2406 5.96957
R2049 VPWR.n167 VPWR.t1627 5.96578
R2050 VPWR.n16 VPWR.t1778 5.96578
R2051 VPWR.n164 VPWR.t1135 5.96578
R2052 VPWR.n574 VPWR.t847 5.96578
R2053 VPWR.n767 VPWR.t968 5.96534
R2054 VPWR.n19 VPWR.t1889 5.96534
R2055 VPWR.n50 VPWR.t231 5.96091
R2056 VPWR.n230 VPWR.t397 5.96091
R2057 VPWR.n37 VPWR.t129 5.96091
R2058 VPWR.n1666 VPWR.t289 5.96091
R2059 VPWR.n174 VPWR.t371 5.96091
R2060 VPWR.n1497 VPWR.t141 5.96091
R2061 VPWR.n90 VPWR.t147 5.96091
R2062 VPWR.n149 VPWR.t251 5.96091
R2063 VPWR.n2 VPWR.t418 5.96091
R2064 VPWR.n913 VPWR.t200 5.96091
R2065 VPWR.n18 VPWR.t316 5.96091
R2066 VPWR.n996 VPWR.t208 5.96091
R2067 VPWR.n1320 VPWR.t432 5.96091
R2068 VPWR.n398 VPWR.t646 5.96091
R2069 VPWR.n674 VPWR.t428 5.96091
R2070 VPWR.n229 VPWR.t255 5.96047
R2071 VPWR.n167 VPWR.t405 5.96047
R2072 VPWR.n28 VPWR.t295 5.96047
R2073 VPWR.n92 VPWR.t227 5.96047
R2074 VPWR.n863 VPWR.t378 5.96047
R2075 VPWR.n245 VPWR.t202 5.96047
R2076 VPWR.n164 VPWR.t162 5.96047
R2077 VPWR.n77 VPWR.t119 5.96047
R2078 VPWR.n846 VPWR.t323 5.96047
R2079 VPWR.n2 VPWR.t303 5.96047
R2080 VPWR.n397 VPWR.t221 5.96047
R2081 VPWR.n938 VPWR.t1170 5.96047
R2082 VPWR.n40 VPWR.t83 5.96047
R2083 VPWR.n27 VPWR.t93 5.96047
R2084 VPWR.n1019 VPWR.t346 5.96047
R2085 VPWR.n988 VPWR.t107 5.96047
R2086 VPWR.n419 VPWR.t132 5.96047
R2087 VPWR.n6 VPWR.t17 6.00636
R2088 VPWR.n169 VPWR.t63 5.96047
R2089 VPWR.n151 VPWR.t327 5.96047
R2090 VPWR.n1088 VPWR.t152 5.96047
R2091 VPWR.n399 VPWR.t270 5.96047
R2092 VPWR.n22 VPWR.t56 5.96047
R2093 VPWR.n19 VPWR.t130 5.96047
R2094 VPWR.n436 VPWR.t385 5.65005
R2095 VPWR.n503 VPWR.t238 5.65005
R2096 VPWR.n1599 VPWR.t390 5.65005
R2097 VPWR.n506 VPWR.t243 5.65005
R2098 VPWR.n1598 VPWR.t394 5.65005
R2099 VPWR.n509 VPWR.t253 5.65005
R2100 VPWR.n392 VPWR.t245 5.65005
R2101 VPWR.n578 VPWR.t5 5.65005
R2102 VPWR.n1639 VPWR.t8 5.65005
R2103 VPWR.n609 VPWR.t375 5.65005
R2104 VPWR.n424 VPWR.t284 5.65005
R2105 VPWR.n473 VPWR.t149 5.65005
R2106 VPWR.n512 VPWR.t434 5.65005
R2107 VPWR.n10 VPWR.t182 5.65005
R2108 VPWR.n603 VPWR.t278 5.65005
R2109 VPWR.n517 VPWR.t331 5.65005
R2110 VPWR.n1576 VPWR.t365 5.65005
R2111 VPWR.n16 VPWR.t413 5.65005
R2112 VPWR.n569 VPWR.t165 5.65005
R2113 VPWR.n519 VPWR.t176 5.65005
R2114 VPWR.n1574 VPWR.t421 5.65005
R2115 VPWR.n522 VPWR.t247 5.65005
R2116 VPWR.n1573 VPWR.t425 5.65005
R2117 VPWR.n37 VPWR.t291 5.65005
R2118 VPWR.n524 VPWR.t287 5.65005
R2119 VPWR.n1663 VPWR.t205 5.65005
R2120 VPWR.n430 VPWR.t235 5.65005
R2121 VPWR.n428 VPWR.t3 5.65005
R2122 VPWR.n601 VPWR.t157 5.65005
R2123 VPWR.n1492 VPWR.t159 5.65005
R2124 VPWR.n1493 VPWR.t404 5.65005
R2125 VPWR.n577 VPWR.t143 5.65005
R2126 VPWR.n464 VPWR.t172 5.65005
R2127 VPWR.n773 VPWR.t249 5.65005
R2128 VPWR.n530 VPWR.t381 5.65005
R2129 VPWR.n779 VPWR.t117 5.65005
R2130 VPWR.n838 VPWR.t319 5.65005
R2131 VPWR.n857 VPWR.t180 5.65005
R2132 VPWR.n858 VPWR.t415 5.65005
R2133 VPWR.n2 VPWR.t211 5.65005
R2134 VPWR.n600 VPWR.t215 5.65005
R2135 VPWR.n612 VPWR.t218 5.65005
R2136 VPWR.n533 VPWR.t138 5.65005
R2137 VPWR.n476 VPWR.t194 5.65005
R2138 VPWR.n477 VPWR.t224 5.65005
R2139 VPWR.n581 VPWR.t197 5.65005
R2140 VPWR.n940 VPWR.t154 5.65005
R2141 VPWR.n471 VPWR.t80 5.65005
R2142 VPWR.n598 VPWR.t169 5.65005
R2143 VPWR.n466 VPWR.t114 5.65005
R2144 VPWR.n1459 VPWR.t26 5.65005
R2145 VPWR.n480 VPWR.t29 5.65005
R2146 VPWR.n1454 VPWR.t33 5.65005
R2147 VPWR.n596 VPWR.t36 5.65005
R2148 VPWR.n1447 VPWR.t354 5.65005
R2149 VPWR.n453 VPWR.t358 5.65005
R2150 VPWR.n17 VPWR.t313 5.65005
R2151 VPWR.n573 VPWR.t96 5.65005
R2152 VPWR.n490 VPWR.t104 5.65005
R2153 VPWR.n536 VPWR.t136 5.65005
R2154 VPWR.n434 VPWR.t189 5.65005
R2155 VPWR.n539 VPWR.t854 5.65005
R2156 VPWR.n599 VPWR.t124 5.65005
R2157 VPWR.n585 VPWR.t298 5.65005
R2158 VPWR.n619 VPWR.t310 5.65005
R2159 VPWR.t16 VPWR.t70 5.65005
R2160 VPWR.t16 VPWR.t72 5.65005
R2161 VPWR.n6 VPWR.t75 5.65005
R2162 VPWR.n482 VPWR.t20 5.65005
R2163 VPWR.n542 VPWR.t185 5.65005
R2164 VPWR.n4 VPWR.t649 5.65005
R2165 VPWR.n1392 VPWR.t22 5.65005
R2166 VPWR.n546 VPWR.t651 5.65005
R2167 VPWR.n615 VPWR.t350 5.65005
R2168 VPWR.n1044 VPWR.t85 5.65005
R2169 VPWR.n593 VPWR.t89 5.65005
R2170 VPWR.n1039 VPWR.t47 5.65005
R2171 VPWR.n1040 VPWR.t92 5.65005
R2172 VPWR.n549 VPWR.t339 5.65005
R2173 VPWR.n1079 VPWR.t135 5.65005
R2174 VPWR.n1027 VPWR.t343 5.65005
R2175 VPWR.n484 VPWR.t167 5.65005
R2176 VPWR.n485 VPWR.t849 5.65005
R2177 VPWR.n589 VPWR.t127 5.65005
R2178 VPWR.n488 VPWR.t50 5.65005
R2179 VPWR.n552 VPWR.t2423 5.65005
R2180 VPWR.n556 VPWR.t13 5.65005
R2181 VPWR.n1217 VPWR.t65 5.65005
R2182 VPWR.n559 VPWR.t68 5.65005
R2183 VPWR.n1180 VPWR.t859 5.65005
R2184 VPWR.n1294 VPWR.t10 5.65005
R2185 VPWR.n1295 VPWR.t853 5.65005
R2186 VPWR.n561 VPWR.t639 5.65005
R2187 VPWR.n1267 VPWR.t263 5.65005
R2188 VPWR.n563 VPWR.t643 5.65005
R2189 VPWR.n1266 VPWR.t267 5.65005
R2190 VPWR.n21 VPWR.t52 5.65005
R2191 VPWR.n1353 VPWR.t59 5.65005
R2192 VPWR.n626 VPWR.t41 5.65005
R2193 VPWR.n566 VPWR.t43 5.65005
R2194 VPWR.n1357 VPWR.t110 5.65005
R2195 VPWR.n623 VPWR.t274 5.65005
R2196 VPWR.n606 VPWR.t333 5.65005
R2197 VPWR.t0 VPWR.n770 5.64719
R2198 VPWR.n49 VPWR.t232 5.64493
R2199 VPWR.n1542 VPWR.t398 5.64493
R2200 VPWR.n1545 VPWR.t256 5.64493
R2201 VPWR.n1600 VPWR.t406 5.64493
R2202 VPWR.n28 VPWR.t128 5.64493
R2203 VPWR.n1662 VPWR.t296 5.64493
R2204 VPWR.n572 VPWR.t290 5.64493
R2205 VPWR.n431 VPWR.t228 5.64493
R2206 VPWR.n861 VPWR.t379 5.64493
R2207 VPWR.n427 VPWR.t203 5.64493
R2208 VPWR.n1484 VPWR.t370 5.64493
R2209 VPWR.n1500 VPWR.t140 5.64493
R2210 VPWR.n576 VPWR.t163 5.64493
R2211 VPWR.n760 VPWR.t146 5.64493
R2212 VPWR.n776 VPWR.t252 5.64493
R2213 VPWR.n784 VPWR.t120 5.64493
R2214 VPWR.n845 VPWR.t322 5.64493
R2215 VPWR.n2 VPWR.t304 5.64493
R2216 VPWR.n2 VPWR.t419 5.64493
R2217 VPWR.n384 VPWR.t222 5.64493
R2218 VPWR.n915 VPWR.t201 5.64493
R2219 VPWR.n59 VPWR.t1171 5.64493
R2220 VPWR.n39 VPWR.t84 5.64493
R2221 VPWR.n18 VPWR.t317 5.64493
R2222 VPWR.n27 VPWR.t94 5.64493
R2223 VPWR.n1015 VPWR.t347 5.64493
R2224 VPWR.n992 VPWR.t209 5.64493
R2225 VPWR.n990 VPWR.t108 5.64493
R2226 VPWR.n6 VPWR.t18 5.64493
R2227 VPWR.n1136 VPWR.t133 5.64493
R2228 VPWR.n1425 VPWR.t64 5.64493
R2229 VPWR.n1031 VPWR.t328 5.64493
R2230 VPWR.n1091 VPWR.t153 5.64493
R2231 VPWR.n1090 VPWR.t102 5.64493
R2232 VPWR.n1298 VPWR.t433 5.64493
R2233 VPWR.n1261 VPWR.t647 5.64493
R2234 VPWR.n1264 VPWR.t271 5.64493
R2235 VPWR.n22 VPWR.t57 5.64493
R2236 VPWR.n19 VPWR.t131 5.64493
R2237 VPWR.n637 VPWR.t429 5.64493
R2238 VPWR.t177 VPWR.n731 5.64096
R2239 VPWR.t4 VPWR.n447 2.80505
R2240 VPWR.n426 VPWR.n735 0.151433
R2241 VPWR.t4 VPWR.n1641 5.64096
R2242 VPWR.n465 VPWR.n344 0.10076
R2243 VPWR.t0 VPWR.n868 5.64096
R2244 VPWR.t25 VPWR.n438 4.22751
R2245 VPWR.n354 VPWR.n455 0.0230381
R2246 VPWR.t25 VPWR.n449 2.80505
R2247 VPWR.t25 VPWR.n479 4.2275
R2248 VPWR.n472 VPWR.n964 0.146015
R2249 VPWR.t25 VPWR.n942 5.64096
R2250 VPWR.t16 VPWR.n1043 5.64096
R2251 VPWR.t16 VPWR.n452 2.80505
R2252 VPWR.t9 VPWR.n1349 5.64096
R2253 VPWR.t9 VPWR.n444 2.80505
R2254 VPWR.t9 VPWR.n442 4.2275
R2255 VPWR.n468 VPWR.n570 0.097998
R2256 VPWR.t0 VPWR.n856 5.64013
R2257 VPWR.t0 VPWR.n837 5.64013
R2258 VPWR.t25 VPWR.n1456 5.64013
R2259 VPWR.t9 VPWR.n1297 5.64013
R2260 VPWR.t4 VPWR.n1627 5.6326
R2261 VPWR.t0 VPWR.n879 5.6326
R2262 VPWR.t25 VPWR.n903 5.6326
R2263 VPWR.t16 VPWR.n1113 5.6326
R2264 VPWR.t9 VPWR.n1311 5.6326
R2265 VPWR.t177 VPWR.n711 5.61485
R2266 VPWR.t177 VPWR.n719 5.61485
R2267 VPWR.t177 VPWR.n667 5.61485
R2268 VPWR.t177 VPWR.n647 5.61485
R2269 VPWR.t4 VPWR.n733 5.61485
R2270 VPWR.t4 VPWR.n1629 5.61485
R2271 VPWR.t0 VPWR.n822 5.61485
R2272 VPWR.t0 VPWR.n799 5.61485
R2273 VPWR.t0 VPWR.n244 5.61485
R2274 VPWR.t0 VPWR.n870 5.61485
R2275 VPWR.t0 VPWR.n1480 5.61485
R2276 VPWR.t0 VPWR.n877 5.61485
R2277 VPWR.n1005 VPWR.t25 5.61485
R2278 VPWR.t25 VPWR.n901 5.61485
R2279 VPWR.t16 VPWR.n1404 5.61485
R2280 VPWR.t16 VPWR.n1094 5.61485
R2281 VPWR.t16 VPWR.n1111 5.61485
R2282 VPWR.t9 VPWR.n1361 5.61485
R2283 VPWR.t9 VPWR.n1250 5.61485
R2284 VPWR.t9 VPWR.n1232 5.61485
R2285 VPWR.t9 VPWR.n499 5.61485
R2286 VPWR.t9 VPWR.n1187 5.61485
R2287 VPWR.t9 VPWR.n1194 5.61485
R2288 VPWR.t9 VPWR.n1309 5.61485
R2289 VPWR.n591 VPWR.n595 5.16578
R2290 VPWR.n1429 VPWR.n191 5.16578
R2291 VPWR.n1389 VPWR.n1388 5.16578
R2292 VPWR.n587 VPWR.n595 4.5005
R2293 VPWR.n1477 VPWR.n583 4.5005
R2294 VPWR.n1479 VPWR.n1478 4.5005
R2295 VPWR.n579 VPWR.n604 4.5005
R2296 VPWR.n1672 VPWR.t687 4.5005
R2297 VPWR.n1429 VPWR.n1428 4.5005
R2298 VPWR.n575 VPWR.n1430 4.5005
R2299 VPWR.n859 VPWR.n732 4.5005
R2300 VPWR.n1669 VPWR.n1668 4.5005
R2301 VPWR.n435 VPWR.n1389 4.5005
R2302 VPWR.n475 VPWR.n750 4.5005
R2303 VPWR.n1532 VPWR.n1531 4.5005
R2304 VPWR.n437 VPWR.n1541 4.5005
R2305 VPWR.n1672 VPWR.n215 0.549501
R2306 VPWR.n215 VPWR.n214 1.09934
R2307 VPWR.n96 VPWR.n94 3.29959
R2308 VPWR.t0 VPWR.n1503 4.30605
R2309 VPWR.n467 VPWR.n1460 0.0786469
R2310 VPWR.t177 VPWR.t537 4.17802
R2311 VPWR.t16 VPWR.n1038 4.17719
R2312 VPWR.t177 VPWR.n729 4.17712
R2313 VPWR.t9 VPWR.n1291 4.177
R2314 VPWR.t25 VPWR.n1475 3.31334
R2315 VPWR.n1535 VPWR.t1001 1.0772
R2316 VPWR.t233 VPWR.n1533 1.04671
R2317 VPWR.n1533 VPWR.t844 1.03869
R2318 VPWR.n1538 VPWR.t767 1.03167
R2319 VPWR.n1539 VPWR.t178 1.03079
R2320 VPWR.t844 VPWR.n1538 1.02695
R2321 VPWR.n1535 VPWR.t246 1.01867
R2322 VPWR.n1534 VPWR.t1001 1.01304
R2323 VPWR.n1540 VPWR.t480 1.00604
R2324 VPWR.t707 VPWR.t687 0.99267
R2325 VPWR.t246 VPWR.n1536 0.975843
R2326 VPWR.t767 VPWR.n1539 0.968773
R2327 VPWR.t178 VPWR.n1540 0.940983
R2328 VPWR.t687 VPWR.n636 0.928523
R2329 VPWR.n1534 VPWR.t233 0.861157
R2330 VPWR.t707 VPWR.t706 0.827113
R2331 VPWR.n1536 VPWR.t329 0.799458
R2332 VPWR.n636 VPWR.t272 0.753478
R2333 VPWR.t177 VPWR.n636 0.674989
R2334 VPWR.n1478 VPWR.n604 0.66578
R2335 VPWR.n1478 VPWR.n1477 0.66578
R2336 VPWR.n1477 VPWR.n595 0.66578
R2337 VPWR.n1669 VPWR.n732 0.66578
R2338 VPWR.n1430 VPWR.n732 0.66578
R2339 VPWR.n1430 VPWR.n1429 0.66578
R2340 VPWR.n1541 VPWR.n1532 0.66578
R2341 VPWR.n1532 VPWR.n750 0.66578
R2342 VPWR.n1389 VPWR.n750 0.66578
R2343 VPWR.n1539 VPWR.t177 0.555227
R2344 VPWR.n1540 VPWR.t177 0.554125
R2345 VPWR.n1536 VPWR.t177 0.552623
R2346 VPWR.n1538 VPWR.t177 0.507431
R2347 VPWR.t707 VPWR.t177 0.507275
R2348 VPWR.n1534 VPWR.t177 0.471808
R2349 VPWR.n1533 VPWR.t177 0.468644
R2350 VPWR.n1535 VPWR.t177 0.4641
R2351 VPWR.n1672 VPWR 0.3525
R2352 VPWR.n1475 VPWR.n1474 0.289549
R2353 VPWR.t348 VPWR.t537 0.258178
R2354 VPWR.t537 VPWR.n672 0.256308
R2355 VPWR.n1476 VPWR.n1475 0.249558
R2356 VPWR.n1291 VPWR.n1290 0.233644
R2357 VPWR.n729 VPWR.n728 0.233511
R2358 VPWR.n1058 VPWR.n1038 0.232896
R2359 VPWR.n458 VPWR.n457 0.144628
R2360 VPWR.n1479 VPWR.n870 0.200825
R2361 VPWR.n244 VPWR.n1481 0.195825
R2362 VPWR.n711 VPWR.n710 0.195486
R2363 VPWR.n1042 VPWR.n1038 0.19153
R2364 VPWR.n730 VPWR.n729 0.191273
R2365 VPWR.n1020 VPWR.n458 0.262461
R2366 VPWR.n1292 VPWR.n1291 0.191144
R2367 VPWR.n868 VPWR.n867 0.190118
R2368 VPWR.n479 VPWR.n1476 0.202255
R2369 VPWR.n1043 VPWR.n1042 0.190118
R2370 VPWR.n731 VPWR.n730 0.190118
R2371 VPWR.n856 VPWR.n855 0.183859
R2372 VPWR.n443 VPWR.n1297 0.183859
R2373 VPWR.n518 VPWR.n516 0.119663
R2374 VPWR.n527 VPWR.n526 0.119663
R2375 VPWR.n528 VPWR.n433 0.119663
R2376 VPWR.n560 VPWR.n558 0.119663
R2377 VPWR.n15 VPWR.n468 0.125999
R2378 VPWR.n666 VPWR.n639 0.174539
R2379 VPWR.n1628 VPWR.n1620 0.174539
R2380 VPWR.n886 VPWR.n885 0.174539
R2381 VPWR.n85 VPWR.n84 0.174539
R2382 VPWR.n254 VPWR.n82 0.174539
R2383 VPWR.n413 VPWR.n155 0.116372
R2384 VPWR.n153 VPWR.n152 0.116372
R2385 VPWR.n910 VPWR.n909 0.174539
R2386 VPWR.n914 VPWR.n913 0.174539
R2387 VPWR.n403 VPWR.n80 0.174539
R2388 VPWR.n1007 VPWR.n1006 0.174539
R2389 VPWR.n1120 VPWR.n1119 0.174539
R2390 VPWR.n1403 VPWR.n1402 0.174539
R2391 VPWR.n1417 VPWR.n1416 0.174539
R2392 VPWR.n1318 VPWR.n1317 0.174539
R2393 VPWR.n1193 VPWR.n1190 0.174539
R2394 VPWR.n1231 VPWR.n1169 0.174539
R2395 VPWR.n1252 VPWR.n1251 0.174539
R2396 VPWR.n1383 VPWR.n1382 0.174539
R2397 VPWR.n721 VPWR.n720 0.174539
R2398 VPWR.n647 VPWR.n646 0.174236
R2399 VPWR.n1361 VPWR.n1360 0.17387
R2400 VPWR.n1480 VPWR.n887 0.173853
R2401 VPWR.n712 VPWR.n711 0.173853
R2402 VPWR.n669 VPWR.n668 0.172039
R2403 VPWR.n1631 VPWR.n1630 0.172039
R2404 VPWR.n402 VPWR.n401 0.172039
R2405 VPWR.n876 VPWR.n875 0.172039
R2406 VPWR.n900 VPWR.n899 0.172039
R2407 VPWR.n1004 VPWR.n1003 0.172039
R2408 VPWR.n1110 VPWR.n1109 0.172039
R2409 VPWR.n1406 VPWR.n1405 0.172039
R2410 VPWR.n1308 VPWR.n1307 0.172039
R2411 VPWR.n498 VPWR.n496 0.172039
R2412 VPWR.n501 VPWR.n500 0.172039
R2413 VPWR.n1234 VPWR.n1233 0.172039
R2414 VPWR.n1249 VPWR.n1248 0.172039
R2415 VPWR.n718 VPWR.n717 0.172039
R2416 VPWR.n1627 VPWR.n1626 0.171487
R2417 VPWR.n880 VPWR.n879 0.171487
R2418 VPWR.n904 VPWR.n903 0.171487
R2419 VPWR.n1114 VPWR.n1113 0.171487
R2420 VPWR.n1312 VPWR.n1311 0.171487
R2421 VPWR.n286 VPWR.n178 0.113079
R2422 VPWR.n0 VPWR.n860 0.169539
R2423 VPWR.n303 VPWR.n173 0.113079
R2424 VPWR.n217 VPWR.n216 0.169539
R2425 VPWR.n1179 VPWR.n1178 0.169539
R2426 VPWR.n1293 VPWR.n1292 0.169539
R2427 VPWR.n383 VPWR.n1600 0.16689
R2428 VPWR.n231 VPWR.n1662 0.16689
R2429 VPWR.n862 VPWR.n861 0.16689
R2430 VPWR.n89 VPWR.n576 0.16689
R2431 VPWR.n849 VPWR.n845 0.16689
R2432 VPWR.n40 VPWR.n39 0.16689
R2433 VPWR.n1016 VPWR.n1015 0.16689
R2434 VPWR.n168 VPWR.n1425 0.16689
R2435 VPWR.n1092 VPWR.n1091 0.16689
R2436 VPWR.n50 VPWR.n49 0.166554
R2437 VPWR.n993 VPWR.n992 0.166554
R2438 VPWR.n1093 VPWR.n1090 0.166554
R2439 VPWR.n1299 VPWR.n1298 0.166554
R2440 VPWR.n638 VPWR.n637 0.166554
R2441 VPWR.n663 VPWR.n647 0.165825
R2442 VPWR.n1481 VPWR.n870 0.165486
R2443 VPWR.n101 VPWR.n100 0.108137
R2444 VPWR.n103 VPWR.n102 0.108137
R2445 VPWR.n1617 VPWR.n1616 0.162039
R2446 VPWR.n333 VPWR.n332 0.162039
R2447 VPWR.n108 VPWR.n107 0.108137
R2448 VPWR.n111 VPWR.n110 0.108137
R2449 VPWR.n1482 VPWR.n245 0.162039
R2450 VPWR.n1495 VPWR.n1491 0.162039
R2451 VPWR.n209 VPWR.n208 0.195002
R2452 VPWR.n621 VPWR.n1123 0.195002
R2453 VPWR.n335 VPWR.n334 0.162039
R2454 VPWR.n138 VPWR.n137 0.108137
R2455 VPWR.n141 VPWR.n144 0.108137
R2456 VPWR.n337 VPWR.n336 0.162039
R2457 VPWR.n159 VPWR.n221 0.108137
R2458 VPWR.n156 VPWR.n222 0.108137
R2459 VPWR.n206 VPWR.n224 0.108137
R2460 VPWR.n225 VPWR.n191 0.108137
R2461 VPWR.n1480 VPWR.n1479 0.160486
R2462 VPWR.n641 VPWR.n640 0.159539
R2463 VPWR.n1622 VPWR.n1621 0.159539
R2464 VPWR.n1590 VPWR.n204 0.159539
R2465 VPWR.n1562 VPWR.n202 0.159539
R2466 VPWR.n239 VPWR.n238 0.159539
R2467 VPWR.n884 VPWR.n883 0.159539
R2468 VPWR.n249 VPWR.n248 0.159539
R2469 VPWR.n257 VPWR.n256 0.159539
R2470 VPWR.n495 VPWR.n494 0.159539
R2471 VPWR.n908 VPWR.n907 0.159539
R2472 VPWR.n261 VPWR.n260 0.159539
R2473 VPWR.n1009 VPWR.n1008 0.159539
R2474 VPWR.n1118 VPWR.n1117 0.159539
R2475 VPWR.n1401 VPWR.n1400 0.159539
R2476 VPWR.n1316 VPWR.n1315 0.159539
R2477 VPWR.n1171 VPWR.n1170 0.159539
R2478 VPWR.n1254 VPWR.n1253 0.159539
R2479 VPWR.n723 VPWR.n722 0.159539
R2480 VPWR.n671 VPWR.n670 0.157039
R2481 VPWR.n1633 VPWR.n1632 0.157039
R2482 VPWR.n200 VPWR.n199 0.157039
R2483 VPWR.n1585 VPWR.n1584 0.157039
R2484 VPWR.n198 VPWR.n197 0.157039
R2485 VPWR.n1557 VPWR.n37 0.277164
R2486 VPWR.n241 VPWR.n240 0.157039
R2487 VPWR.n874 VPWR.n873 0.157039
R2488 VPWR.n898 VPWR.n897 0.157039
R2489 VPWR.n1002 VPWR.n1001 0.157039
R2490 VPWR.n1108 VPWR.n1107 0.157039
R2491 VPWR.n1102 VPWR.n1101 0.157039
R2492 VPWR.n3 VPWR.n1391 0.157039
R2493 VPWR.n1408 VPWR.n1407 0.157039
R2494 VPWR.n196 VPWR.n194 0.157039
R2495 VPWR.n1081 VPWR.n193 0.157039
R2496 VPWR.n1306 VPWR.n1305 0.157039
R2497 VPWR.n1184 VPWR.n497 0.157039
R2498 VPWR.n1222 VPWR.n502 0.157039
R2499 VPWR.n1236 VPWR.n1235 0.157039
R2500 VPWR.n1247 VPWR.n1246 0.157039
R2501 VPWR.n440 VPWR.n439 0.12592
R2502 VPWR.n1336 VPWR.n1335 0.157039
R2503 VPWR.n716 VPWR.n715 0.157039
R2504 VPWR.n631 VPWR.n1014 0.190618
R2505 VPWR.n1642 VPWR.n1641 0.150118
R2506 VPWR.n943 VPWR.n942 0.150118
R2507 VPWR.n665 VPWR.n662 0.147039
R2508 VPWR.n643 VPWR.n642 0.144539
R2509 VPWR.n1624 VPWR.n1623 0.144539
R2510 VPWR.n1648 VPWR.n1609 0.144539
R2511 VPWR.n31 VPWR.n30 0.144539
R2512 VPWR.n1565 VPWR.n1564 0.144539
R2513 VPWR.n237 VPWR.n236 0.144539
R2514 VPWR.n882 VPWR.n881 0.144539
R2515 VPWR.n247 VPWR.n246 0.144539
R2516 VPWR.n251 VPWR.n250 0.144539
R2517 VPWR.n806 VPWR.n805 0.144539
R2518 VPWR.n829 VPWR.n828 0.144539
R2519 VPWR.n253 VPWR.n252 0.144539
R2520 VPWR.n272 VPWR.n258 0.144539
R2521 VPWR.n1517 VPWR.n1516 0.144539
R2522 VPWR.n906 VPWR.n905 0.144539
R2523 VPWR.n946 VPWR.n945 0.144539
R2524 VPWR.n274 VPWR.n259 0.144539
R2525 VPWR.n276 VPWR.n262 0.144539
R2526 VPWR.n1011 VPWR.n1010 0.144539
R2527 VPWR.n1116 VPWR.n1115 0.144539
R2528 VPWR.n1399 VPWR.n1398 0.144539
R2529 VPWR.n1023 VPWR.n1022 0.144539
R2530 VPWR.n1314 VPWR.n1313 0.144539
R2531 VPWR.n1201 VPWR.n1200 0.144539
R2532 VPWR.n1173 VPWR.n1172 0.144539
R2533 VPWR.n1256 VPWR.n1255 0.144539
R2534 VPWR.n725 VPWR.n724 0.144539
R2535 VPWR.n676 VPWR.n675 0.144539
R2536 VPWR.n953 VPWR.n192 0.142039
R2537 VPWR.n1469 VPWR.n243 0.142039
R2538 VPWR.n1438 VPWR.n1437 0.142039
R2539 VPWR.n1583 VPWR.n1582 0.140457
R2540 VPWR.n1635 VPWR.n1634 0.138909
R2541 VPWR.n872 VPWR.n871 0.138909
R2542 VPWR.n896 VPWR.n895 0.138909
R2543 VPWR.n1000 VPWR.n999 0.138909
R2544 VPWR.n1106 VPWR.n1105 0.138909
R2545 VPWR.n1410 VPWR.n1409 0.138909
R2546 VPWR.n1304 VPWR.n1303 0.138909
R2547 VPWR.n1238 VPWR.n1237 0.138909
R2548 VPWR.n1245 VPWR.n1244 0.138909
R2549 VPWR.n714 VPWR.n713 0.138909
R2550 VPWR.n1192 VPWR.n1191 0.135789
R2551 VPWR.n771 VPWR.n770 0.133694
R2552 VPWR.n1546 VPWR.n1545 0.13351
R2553 VPWR.n433 VPWR.n431 0.13351
R2554 VPWR.n429 VPWR.n427 0.13351
R2555 VPWR.n785 VPWR.n784 0.13351
R2556 VPWR.n385 VPWR.n384 0.13351
R2557 VPWR.n60 VPWR.n59 0.13351
R2558 VPWR.n991 VPWR.n990 0.13351
R2559 VPWR.n1137 VPWR.n1136 0.13351
R2560 VPWR.n1032 VPWR.n1031 0.13351
R2561 VPWR.n422 VPWR.n1264 0.13351
R2562 VPWR.n1543 VPWR.n1542 0.133174
R2563 VPWR.n1485 VPWR.n1484 0.133174
R2564 VPWR.n1501 VPWR.n1500 0.133174
R2565 VPWR.n761 VPWR.n760 0.133174
R2566 VPWR.n777 VPWR.n776 0.133174
R2567 VPWR.n916 VPWR.n915 0.133174
R2568 VPWR.n1262 VPWR.n1261 0.133174
R2569 VPWR.n1361 VPWR.n1359 0.132075
R2570 VPWR.n719 VPWR.n718 0.129575
R2571 VPWR.n800 VPWR.n799 0.129575
R2572 VPWR.n1405 VPWR.n1404 0.129575
R2573 VPWR.n645 VPWR.n644 0.129539
R2574 VPWR.n1550 VPWR.n1549 0.129539
R2575 VPWR.n742 VPWR.n189 0.129539
R2576 VPWR.n176 VPWR.n1572 0.129539
R2577 VPWR.n1568 VPWR.n1567 0.129539
R2578 VPWR.n235 VPWR.n234 0.129539
R2579 VPWR.n188 VPWR.n187 0.129539
R2580 VPWR.n186 VPWR.n185 0.129539
R2581 VPWR.n1442 VPWR.n1441 0.129539
R2582 VPWR.n1013 VPWR.n1012 0.129539
R2583 VPWR.n1159 VPWR.n184 0.129539
R2584 VPWR.n1397 VPWR.n1396 0.129539
R2585 VPWR.n1026 VPWR.n1025 0.129539
R2586 VPWR.n1208 VPWR.n183 0.129539
R2587 VPWR.n1219 VPWR.n171 0.129539
R2588 VPWR.n1226 VPWR.n1225 0.129539
R2589 VPWR.n1175 VPWR.n1174 0.129539
R2590 VPWR.n1258 VPWR.n1257 0.129539
R2591 VPWR.n395 VPWR.n394 0.129539
R2592 VPWR.n727 VPWR.n726 0.129539
R2593 VPWR.n668 VPWR.n667 0.129236
R2594 VPWR.n1630 VPWR.n1629 0.129236
R2595 VPWR.n877 VPWR.n876 0.129236
R2596 VPWR.n823 VPWR.n822 0.129236
R2597 VPWR.n901 VPWR.n900 0.129236
R2598 VPWR.n1005 VPWR.n1004 0.129236
R2599 VPWR.n1111 VPWR.n1110 0.129236
R2600 VPWR.n1309 VPWR.n1308 0.129236
R2601 VPWR.n1195 VPWR.n1194 0.129236
R2602 VPWR.n1233 VPWR.n1232 0.129236
R2603 VPWR.n1250 VPWR.n1249 0.129236
R2604 VPWR.n1670 VPWR.t445 0.12922
R2605 VPWR.n579 VPWR.n578 0.12922
R2606 VPWR.n1640 VPWR.n1639 0.12922
R2607 VPWR.n610 VPWR.n609 0.12922
R2608 VPWR.n474 VPWR.n473 0.12922
R2609 VPWR.n391 VPWR.n603 0.12922
R2610 VPWR.n602 VPWR.n601 0.12922
R2611 VPWR.n1494 VPWR.n1492 0.12922
R2612 VPWR.n344 VPWR.n464 0.12922
R2613 VPWR.n839 VPWR.n838 0.12922
R2614 VPWR.n859 VPWR.n857 0.12922
R2615 VPWR.n113 VPWR.n600 0.12922
R2616 VPWR.n613 VPWR.n612 0.12922
R2617 VPWR.n478 VPWR.n476 0.12922
R2618 VPWR.n472 VPWR.n471 0.12922
R2619 VPWR.n1460 VPWR.n1459 0.12922
R2620 VPWR.n481 VPWR.n480 0.12922
R2621 VPWR.n1455 VPWR.n1454 0.12922
R2622 VPWR.n597 VPWR.n596 0.12922
R2623 VPWR.n455 VPWR.n453 0.12922
R2624 VPWR.n575 VPWR.n573 0.12922
R2625 VPWR.n491 VPWR.n490 0.12922
R2626 VPWR.n483 VPWR.n482 0.12922
R2627 VPWR.n1041 VPWR.n1039 0.12922
R2628 VPWR.n486 VPWR.n484 0.12922
R2629 VPWR.n489 VPWR.n488 0.12922
R2630 VPWR.n1296 VPWR.n1294 0.12922
R2631 VPWR.n22 VPWR.n21 0.12922
R2632 VPWR.n624 VPWR.n623 0.12922
R2633 VPWR.n1670 VPWR.t305 0.128884
R2634 VPWR.n393 VPWR.n392 0.128884
R2635 VPWR.n425 VPWR.n424 0.128884
R2636 VPWR.n570 VPWR.n569 0.128884
R2637 VPWR.n1494 VPWR.n1493 0.128884
R2638 VPWR.n89 VPWR.n577 0.128884
R2639 VPWR.n859 VPWR.n858 0.128884
R2640 VPWR.n478 VPWR.n477 0.128884
R2641 VPWR.n583 VPWR.n581 0.128884
R2642 VPWR.n941 VPWR.n940 0.128884
R2643 VPWR.n123 VPWR.n598 0.128884
R2644 VPWR.n467 VPWR.n466 0.128884
R2645 VPWR.n18 VPWR.n17 0.128884
R2646 VPWR.n208 VPWR.n599 0.128884
R2647 VPWR.n587 VPWR.n585 0.128884
R2648 VPWR.n620 VPWR.n619 0.128884
R2649 VPWR.n616 VPWR.n615 0.128884
R2650 VPWR.n594 VPWR.n593 0.128884
R2651 VPWR.n1041 VPWR.n1040 0.128884
R2652 VPWR.n486 VPWR.n485 0.128884
R2653 VPWR.n591 VPWR.n589 0.128884
R2654 VPWR.n1296 VPWR.n1295 0.128884
R2655 VPWR.n1354 VPWR.n1353 0.128884
R2656 VPWR.n627 VPWR.n626 0.128884
R2657 VPWR.n607 VPWR.n606 0.128884
R2658 VPWR.n190 VPWR.n7 0.182758
R2659 VPWR.n1488 VPWR.n390 0.128289
R2660 VPWR.n918 VPWR.n917 0.128289
R2661 VPWR.n61 VPWR.n939 0.309241
R2662 VPWR.n389 VPWR.n388 0.128289
R2663 VPWR.n267 VPWR.n266 0.128097
R2664 VPWR.n269 VPWR.n268 0.128097
R2665 VPWR.n271 VPWR.n270 0.128097
R2666 VPWR.n852 VPWR.n273 0.128097
R2667 VPWR.n967 VPWR.n275 0.128097
R2668 VPWR.n976 VPWR.n277 0.128097
R2669 VPWR.n279 VPWR.n278 0.128097
R2670 VPWR.n667 VPWR.n666 0.127075
R2671 VPWR.n1629 VPWR.n1628 0.127075
R2672 VPWR.n747 VPWR.n733 0.127075
R2673 VPWR.n885 VPWR.n877 0.127075
R2674 VPWR.n822 VPWR.n821 0.127075
R2675 VPWR.n909 VPWR.n901 0.127075
R2676 VPWR.n1006 VPWR.n1005 0.127075
R2677 VPWR.n1119 VPWR.n1111 0.127075
R2678 VPWR.n1164 VPWR.n1094 0.127075
R2679 VPWR.n1317 VPWR.n1309 0.127075
R2680 VPWR.n1194 VPWR.n1193 0.127075
R2681 VPWR.n1213 VPWR.n1187 0.127075
R2682 VPWR.n1232 VPWR.n1231 0.127075
R2683 VPWR.n1251 VPWR.n1250 0.127075
R2684 VPWR.n646 VPWR.n645 0.127039
R2685 VPWR.n1549 VPWR.n1548 0.127039
R2686 VPWR.n1613 VPWR.n1612 0.127039
R2687 VPWR.n177 VPWR.n176 0.127039
R2688 VPWR.n387 VPWR.n386 0.127039
R2689 VPWR.n802 VPWR.n801 0.127039
R2690 VPWR.n825 VPWR.n824 0.127039
R2691 VPWR.n1506 VPWR.n614 0.160559
R2692 VPWR.n1513 VPWR.n1512 0.127039
R2693 VPWR.n951 VPWR.n950 0.127039
R2694 VPWR.n1014 VPWR.n1013 0.127039
R2695 VPWR.n1124 VPWR.n182 0.127039
R2696 VPWR.n180 VPWR.n179 0.0850392
R2697 VPWR.n1396 VPWR.n1395 0.127039
R2698 VPWR.n617 VPWR.n1414 0.160559
R2699 VPWR.n1028 VPWR.n1026 0.127039
R2700 VPWR.n1197 VPWR.n1196 0.127039
R2701 VPWR.n172 VPWR.n171 0.127039
R2702 VPWR.n1176 VPWR.n1175 0.127039
R2703 VPWR.n1259 VPWR.n1258 0.127039
R2704 VPWR.n625 VPWR.n1380 0.160559
R2705 VPWR.n728 VPWR.n727 0.127039
R2706 VPWR.n708 VPWR.n707 0.127039
R2707 VPWR.n799 VPWR.n798 0.126736
R2708 VPWR.n1404 VPWR.n1403 0.126736
R2709 VPWR.n720 VPWR.n719 0.126736
R2710 VPWR.n266 VPWR.n766 0.125625
R2711 VPWR.n268 VPWR.n751 0.125625
R2712 VPWR.n270 VPWR.n851 0.125625
R2713 VPWR.n853 VPWR.n852 0.125625
R2714 VPWR.n968 VPWR.n967 0.125625
R2715 VPWR.n977 VPWR.n976 0.125625
R2716 VPWR.n1446 VPWR.n1445 0.125625
R2717 VPWR.n278 VPWR.n1334 0.125625
R2718 VPWR.n778 VPWR.n777 0.124539
R2719 VPWR.n1510 VPWR.n385 0.124539
R2720 VPWR.n917 VPWR.n916 0.124539
R2721 VPWR.n1032 VPWR.n1030 0.124539
R2722 VPWR.n1262 VPWR.n1260 0.124539
R2723 VPWR.n1244 VPWR.n1243 0.124243
R2724 VPWR.n1636 VPWR.n1635 0.124243
R2725 VPWR.n887 VPWR.n871 0.124243
R2726 VPWR.n895 VPWR.n894 0.124243
R2727 VPWR.n999 VPWR.n998 0.124243
R2728 VPWR.n1105 VPWR.n1104 0.124243
R2729 VPWR.n1411 VPWR.n1410 0.124243
R2730 VPWR.n1303 VPWR.n1302 0.124243
R2731 VPWR.n1239 VPWR.n1238 0.124243
R2732 VPWR.n713 VPWR.n712 0.124243
R2733 VPWR.n1084 VPWR.n1083 0.120789
R2734 VPWR.n504 VPWR.n437 0.11925
R2735 VPWR.n507 VPWR.n505 0.11925
R2736 VPWR.n510 VPWR.n508 0.11925
R2737 VPWR.n514 VPWR.n511 0.0601683
R2738 VPWR.n1575 VPWR.n520 0.11925
R2739 VPWR.n109 VPWR.n523 0.11925
R2740 VPWR.n531 VPWR.n529 0.11925
R2741 VPWR.n781 VPWR.n780 0.11925
R2742 VPWR.n535 VPWR.n532 0.0601683
R2743 VPWR.n540 VPWR.n435 0.11925
R2744 VPWR.n544 VPWR.n541 0.0601683
R2745 VPWR.n547 VPWR.n545 0.11925
R2746 VPWR.n550 VPWR.n548 0.11925
R2747 VPWR.n554 VPWR.n551 0.0601683
R2748 VPWR.n557 VPWR.n555 0.11925
R2749 VPWR.n1268 VPWR.n562 0.11925
R2750 VPWR.n223 VPWR.n564 0.11925
R2751 VPWR.n1358 VPWR.n567 0.11925
R2752 VPWR.n991 VPWR.n980 0.118934
R2753 VPWR.n620 VPWR.n618 0.00121456
R2754 VPWR.n1482 VPWR.n429 0.117039
R2755 VPWR.n916 VPWR.n914 0.117039
R2756 VPWR.n610 VPWR.n382 0.115375
R2757 VPWR.n738 VPWR.n737 0.114539
R2758 VPWR.n1571 VPWR.n1570 0.114539
R2759 VPWR.n789 VPWR.n788 0.114539
R2760 VPWR.n812 VPWR.n811 0.114539
R2761 VPWR.n920 VPWR.n919 0.114539
R2762 VPWR.n937 VPWR.n936 0.114539
R2763 VPWR.n1470 VPWR.n1469 0.114539
R2764 VPWR.n1439 VPWR.n1438 0.114539
R2765 VPWR.n1157 VPWR.n1156 0.114539
R2766 VPWR.n1395 VPWR.n1394 0.114539
R2767 VPWR.n147 VPWR.n146 0.114539
R2768 VPWR.n219 VPWR.n1191 0.114539
R2769 VPWR.n1206 VPWR.n1205 0.114539
R2770 VPWR.n1230 VPWR.n1228 0.114539
R2771 VPWR.n1177 VPWR.n1176 0.114539
R2772 VPWR.n1260 VPWR.n1259 0.114539
R2773 VPWR.n1324 VPWR.n1323 0.114539
R2774 VPWR.n167 VPWR.n165 0.0576854
R2775 VPWR.n409 VPWR.n408 0.00177417
R2776 VPWR.n864 VPWR.n863 0.11425
R2777 VPWR.n411 VPWR.n174 0.0576854
R2778 VPWR.n1498 VPWR.n1497 0.11425
R2779 VPWR.n65 VPWR.n64 0.11425
R2780 VPWR.n397 VPWR.n396 0.114321
R2781 VPWR.n988 VPWR.n537 0.11425
R2782 VPWR.n419 VPWR.n418 0.0576854
R2783 VPWR.n421 VPWR.n420 0.11425
R2784 VPWR.n68 VPWR.n67 0.11425
R2785 VPWR.n1080 VPWR.n70 0.11425
R2786 VPWR.n1320 VPWR.n1300 0.11425
R2787 VPWR.n367 VPWR.n366 0.11425
R2788 VPWR.n1276 VPWR.n57 0.11425
R2789 VPWR.n398 VPWR.n423 0.0576854
R2790 VPWR.n326 VPWR.n325 0.11425
R2791 VPWR.n265 VPWR.n264 0.114174
R2792 VPWR.n1660 VPWR.n1659 0.114174
R2793 VPWR.n765 VPWR.n764 0.114174
R2794 VPWR.n766 VPWR.n765 0.114174
R2795 VPWR.n751 VPWR.n92 0.114174
R2796 VPWR.n854 VPWR.n853 0.114174
R2797 VPWR.n969 VPWR.n968 0.114174
R2798 VPWR.n979 VPWR.n977 0.114174
R2799 VPWR.n1378 VPWR.n1377 0.114174
R2800 VPWR.n1334 VPWR.n1333 0.114174
R2801 VPWR.n1333 VPWR.n1332 0.114174
R2802 VPWR.n1638 VPWR.n1636 0.113817
R2803 VPWR.n894 VPWR.n893 0.113817
R2804 VPWR.n998 VPWR.n997 0.113817
R2805 VPWR.n1104 VPWR.n1103 0.113817
R2806 VPWR.n1412 VPWR.n1411 0.113817
R2807 VPWR.n1302 VPWR.n1301 0.113817
R2808 VPWR.n1240 VPWR.n1239 0.113817
R2809 VPWR.n1243 VPWR.n1242 0.113817
R2810 VPWR.n749 VPWR.n748 0.113289
R2811 VPWR.n797 VPWR.n796 0.113289
R2812 VPWR.n820 VPWR.n819 0.113289
R2813 VPWR.n920 VPWR.n918 0.113289
R2814 VPWR.n1166 VPWR.n1165 0.113289
R2815 VPWR.n1215 VPWR.n1214 0.113289
R2816 VPWR.n1046 VPWR.n1045 0.113
R2817 VPWR.n644 VPWR.n643 0.112039
R2818 VPWR.n1626 VPWR.n1624 0.112039
R2819 VPWR.n1610 VPWR.n1609 0.112039
R2820 VPWR.n1580 VPWR.n1579 0.112039
R2821 VPWR.n1572 VPWR.n1571 0.112039
R2822 VPWR.n881 VPWR.n880 0.112039
R2823 VPWR.n756 VPWR.n755 0.112039
R2824 VPWR.n805 VPWR.n804 0.112039
R2825 VPWR.n828 VPWR.n827 0.112039
R2826 VPWR.n1517 VPWR.n1515 0.112039
R2827 VPWR.n905 VPWR.n904 0.112039
R2828 VPWR.n948 VPWR.n947 0.112039
R2829 VPWR.n970 VPWR.n145 0.112039
R2830 VPWR.n1012 VPWR.n1011 0.112039
R2831 VPWR.n1115 VPWR.n1114 0.112039
R2832 VPWR.n1127 VPWR.n1126 0.112039
R2833 VPWR.n1134 VPWR.n1133 0.112039
R2834 VPWR.n1398 VPWR.n1397 0.112039
R2835 VPWR.n1085 VPWR.n1084 0.112039
R2836 VPWR.n1313 VPWR.n1312 0.112039
R2837 VPWR.n1201 VPWR.n1199 0.112039
R2838 VPWR.n1174 VPWR.n1173 0.112039
R2839 VPWR.n1257 VPWR.n1256 0.112039
R2840 VPWR.n726 VPWR.n725 0.112039
R2841 VPWR.n705 VPWR.n608 0.145559
R2842 VPWR.n339 VPWR.n338 0.0564436
R2843 VPWR.n342 VPWR.n340 0.0564436
R2844 VPWR.n1589 VPWR.n1588 0.11175
R2845 VPWR.n1561 VPWR.n1560 0.11175
R2846 VPWR.n346 VPWR.n344 0.11175
R2847 VPWR.n1523 VPWR.n1522 0.11175
R2848 VPWR.n1526 VPWR.n1525 0.11175
R2849 VPWR.n350 VPWR.n349 0.0564436
R2850 VPWR.n352 VPWR.n351 0.0564436
R2851 VPWR.n355 VPWR.n354 0.0896319
R2852 VPWR.n358 VPWR.n356 0.0564436
R2853 VPWR.n362 VPWR.n361 0.0564436
R2854 VPWR.n364 VPWR.n363 0.0564436
R2855 VPWR.n371 VPWR.n370 0.0564436
R2856 VPWR.n374 VPWR.n372 0.0564436
R2857 VPWR.n376 VPWR.n375 0.0564436
R2858 VPWR.n379 VPWR.n378 0.0564436
R2859 VPWR.n665 VPWR.n664 0.109539
R2860 VPWR.n281 VPWR.n280 0.0843926
R2861 VPWR.n283 VPWR.n282 0.0843926
R2862 VPWR.n285 VPWR.n284 0.112669
R2863 VPWR.n580 VPWR.n1619 0.283011
R2864 VPWR.n292 VPWR.n293 0.175124
R2865 VPWR.n296 VPWR.n297 0.175124
R2866 VPWR.n290 VPWR.n289 0.0843926
R2867 VPWR.n90 VPWR.n89 0.16484
R2868 VPWR.n148 VPWR.n294 0.112669
R2869 VPWR.n1530 VPWR.n1528 0.10925
R2870 VPWR.n911 VPWR.n584 0.283011
R2871 VPWR.n1021 VPWR.n1020 0.10925
R2872 VPWR.n305 VPWR.n304 0.0843926
R2873 VPWR.n1121 VPWR.n588 0.283011
R2874 VPWR.n307 VPWR.n306 0.112669
R2875 VPWR.n310 VPWR.n309 0.0552016
R2876 VPWR.n315 VPWR.n314 0.112669
R2877 VPWR.n1319 VPWR.n592 0.283011
R2878 VPWR.n317 VPWR.n316 0.0843926
R2879 VPWR.n319 VPWR.n318 0.0843926
R2880 VPWR.n565 VPWR.n1265 0.168918
R2881 VPWR.n322 VPWR.n321 0.112669
R2882 VPWR.n324 VPWR.n323 0.0552016
R2883 VPWR.n328 VPWR.n117 0.0545945
R2884 VPWR.n330 VPWR.n329 0.191412
R2885 VPWR.n331 VPWR.n160 0.0545945
R2886 VPWR.n515 VPWR.n1577 0.108
R2887 VPWR.n1665 VPWR.n1664 0.108
R2888 VPWR.n1069 VPWR.n1068 0.108
R2889 VPWR.n1182 VPWR.n1181 0.108
R2890 VPWR.n1342 VPWR.n1341 0.108
R2891 VPWR.n1089 VPWR.n1086 0.104539
R2892 VPWR.n704 VPWR.n703 0.104539
R2893 VPWR.n518 VPWR.n517 0.103337
R2894 VPWR.n1575 VPWR.n1574 0.103337
R2895 VPWR.n109 VPWR.n1573 0.103337
R2896 VPWR.n1664 VPWR.n1663 0.103337
R2897 VPWR.n780 VPWR.n779 0.103337
R2898 VPWR.n535 VPWR.n533 0.103337
R2899 VPWR.n1449 VPWR.n1447 0.103337
R2900 VPWR.n548 VPWR.n1079 0.103337
R2901 VPWR.n554 VPWR.n552 0.103337
R2902 VPWR.n555 VPWR.n1217 0.103337
R2903 VPWR.n560 VPWR.n559 0.103337
R2904 VPWR.n1268 VPWR.n1267 0.103337
R2905 VPWR.n223 VPWR.n1266 0.103337
R2906 VPWR.n1358 VPWR.n1357 0.103337
R2907 VPWR.n437 VPWR.n436 0.103002
R2908 VPWR.n505 VPWR.n1599 0.103002
R2909 VPWR.n508 VPWR.n1598 0.103002
R2910 VPWR.n514 VPWR.n512 0.103002
R2911 VPWR.n515 VPWR.n1576 0.103002
R2912 VPWR.n526 VPWR.n524 0.103002
R2913 VPWR.n433 VPWR.n430 0.103002
R2914 VPWR.n529 VPWR.n773 0.103002
R2915 VPWR.n435 VPWR.n434 0.103002
R2916 VPWR.n544 VPWR.n542 0.103002
R2917 VPWR.n545 VPWR.n1392 0.103002
R2918 VPWR.n1046 VPWR.n1044 0.103002
R2919 VPWR.n1029 VPWR.n1027 0.103002
R2920 VPWR.n1182 VPWR.n1180 0.103002
R2921 VPWR.n1666 VPWR.n571 0.103
R2922 VPWR.n1637 VPWR.n579 0.132198
R2923 VPWR.n105 VPWR.n104 0.0514747
R2924 VPWR.n602 VPWR.n112 0.120044
R2925 VPWR.n775 VPWR.n774 0.10175
R2926 VPWR.n115 VPWR.n113 0.120044
R2927 VPWR.n978 VPWR.n966 0.10175
R2928 VPWR.n583 VPWR.n582 0.132198
R2929 VPWR.n125 VPWR.n123 0.120044
R2930 VPWR.n130 VPWR.n129 0.0514747
R2931 VPWR.n132 VPWR.n131 0.0514747
R2932 VPWR.n587 VPWR.n586 0.132198
R2933 VPWR.n594 VPWR.n140 0.120044
R2934 VPWR.n150 VPWR.n1033 0.10175
R2935 VPWR.n1387 VPWR.n1168 0.10175
R2936 VPWR.n591 VPWR.n590 0.132198
R2937 VPWR.n220 VPWR.n218 0.0514747
R2938 VPWR.n1671 VPWR.t348 0.100789
R2939 VPWR.n1428 VPWR.n633 0.100789
R2940 VPWR.n851 VPWR.n850 0.100509
R2941 VPWR.n847 VPWR.n846 0.1005
R2942 VPWR.n1348 VPWR.n1347 0.1005
R2943 VPWR.n607 VPWR.n605 0.100375
R2944 VPWR.n341 VPWR.n1603 0.099539
R2945 VPWR.n1327 VPWR.n1326 0.099539
R2946 VPWR.n1608 VPWR.n1607 0.09925
R2947 VPWR.n746 VPWR.n745 0.09925
R2948 VPWR.n763 VPWR.n762 0.09925
R2949 VPWR.n787 VPWR.n786 0.09925
R2950 VPWR.n795 VPWR.n794 0.09925
R2951 VPWR.n810 VPWR.n809 0.09925
R2952 VPWR.n818 VPWR.n817 0.09925
R2953 VPWR.n833 VPWR.n832 0.09925
R2954 VPWR.n1520 VPWR.n1519 0.09925
R2955 VPWR.n1163 VPWR.n1162 0.09925
R2956 VPWR.n121 VPWR.n139 0.150225
R2957 VPWR.n1204 VPWR.n1203 0.09925
R2958 VPWR.n1212 VPWR.n1211 0.09925
R2959 VPWR.n1279 VPWR.n1278 0.09925
R2960 VPWR.n1584 VPWR.n1583 0.0991738
R2961 VPWR.n1391 VPWR.n1390 0.0991738
R2962 VPWR.n1328 VPWR.n1327 0.0991738
R2963 VPWR.n672 VPWR.n671 0.0988168
R2964 VPWR.n1634 VPWR.n1633 0.0988168
R2965 VPWR.n873 VPWR.n872 0.0988168
R2966 VPWR.n897 VPWR.n896 0.0988168
R2967 VPWR.n1001 VPWR.n1000 0.0988168
R2968 VPWR.n1107 VPWR.n1106 0.0988168
R2969 VPWR.n1409 VPWR.n1408 0.0988168
R2970 VPWR.n1305 VPWR.n1304 0.0988168
R2971 VPWR.n1237 VPWR.n1236 0.0988168
R2972 VPWR.n1246 VPWR.n1245 0.0988168
R2973 VPWR.n715 VPWR.n714 0.0988168
R2974 VPWR.n1331 VPWR.n1330 0.0984341
R2975 VPWR.n99 VPWR.n98 0.0496804
R2976 VPWR.n1449 VPWR.n1448 0.098
R2977 VPWR.n642 VPWR.n641 0.097039
R2978 VPWR.n1623 VPWR.n1622 0.097039
R2979 VPWR.n611 VPWR.n1646 0.130559
R2980 VPWR.n1569 VPWR.n1568 0.097039
R2981 VPWR.n883 VPWR.n882 0.097039
R2982 VPWR.n753 VPWR.n66 0.211357
R2983 VPWR.n534 VPWR.n494 0.097039
R2984 VPWR.n907 VPWR.n906 0.097039
R2985 VPWR.n925 VPWR.n924 0.097039
R2986 VPWR.n932 VPWR.n931 0.097039
R2987 VPWR.n947 VPWR.n946 0.097039
R2988 VPWR.n973 VPWR.n972 0.097039
R2989 VPWR.n128 VPWR.n1450 0.097039
R2990 VPWR.n1010 VPWR.n1009 0.097039
R2991 VPWR.n1117 VPWR.n1116 0.097039
R2992 VPWR.n1130 VPWR.n1129 0.097039
R2993 VPWR.n1131 VPWR.n1130 0.097039
R2994 VPWR.n1400 VPWR.n1399 0.097039
R2995 VPWR.n1022 VPWR.n69 0.211357
R2996 VPWR.n1315 VPWR.n1314 0.097039
R2997 VPWR.n1185 VPWR.n1184 0.097039
R2998 VPWR.n1222 VPWR.n1221 0.097039
R2999 VPWR.n1172 VPWR.n1171 0.097039
R3000 VPWR.n1255 VPWR.n1254 0.097039
R3001 VPWR.n724 VPWR.n723 0.097039
R3002 VPWR.n651 VPWR.n650 0.09675
R3003 VPWR.n1650 VPWR.n1602 0.09675
R3004 VPWR.n745 VPWR.n744 0.09675
R3005 VPWR.n794 VPWR.n793 0.09675
R3006 VPWR.n817 VPWR.n816 0.09675
R3007 VPWR.n1523 VPWR.n1521 0.09675
R3008 VPWR.n1525 VPWR.n1524 0.09675
R3009 VPWR.n922 VPWR.n892 0.09675
R3010 VPWR.n935 VPWR.n934 0.09675
R3011 VPWR.n954 VPWR.n890 0.09675
R3012 VPWR.n957 VPWR.n956 0.09675
R3013 VPWR.n1434 VPWR.n1433 0.09675
R3014 VPWR.n1139 VPWR.n1138 0.09675
R3015 VPWR.n1148 VPWR.n1147 0.09675
R3016 VPWR.n1146 VPWR.n1097 0.09675
R3017 VPWR.n1162 VPWR.n1161 0.09675
R3018 VPWR.n1421 VPWR.n1420 0.09675
R3019 VPWR.n1050 VPWR.n1049 0.09675
R3020 VPWR.n1064 VPWR.n1036 0.09675
R3021 VPWR.n1075 VPWR.n1074 0.09675
R3022 VPWR.n1211 VPWR.n1210 0.09675
R3023 VPWR.n1281 VPWR.n1280 0.09675
R3024 VPWR.n1367 VPWR.n1365 0.09675
R3025 VPWR.n1369 VPWR.n1339 0.09675
R3026 VPWR.n701 VPWR.n700 0.09675
R3027 VPWR.n682 VPWR.n681 0.09675
R3028 VPWR.n1595 VPWR.n1556 0.0956685
R3029 VPWR.n687 VPWR.n686 0.0956685
R3030 VPWR.n836 VPWR.n835 0.0955
R3031 VPWR.n448 VPWR.n1457 0.0955
R3032 VPWR.n1385 VPWR.n1384 0.094539
R3033 VPWR.n232 VPWR.n231 0.0317231
R3034 VPWR.n927 VPWR.n926 0.093
R3035 VPWR.n930 VPWR.n929 0.093
R3036 VPWR.n168 VPWR.n634 0.0317231
R3037 VPWR.n1299 VPWR.n635 0.0317231
R3038 VPWR.n1605 VPWR.n1604 0.0905
R3039 VPWR.n987 VPWR.n438 0.0905
R3040 VPWR.n1349 VPWR.n1348 0.0901177
R3041 VPWR.n837 VPWR.n836 0.0888585
R3042 VPWR.n1457 VPWR.n1456 0.0888585
R3043 VPWR.n1468 VPWR.n1467 0.088
R3044 VPWR.n660 VPWR.n648 0.08675
R3045 VPWR.n165 VPWR.n383 0.143935
R3046 VPWR.n231 VPWR.n29 0.714288
R3047 VPWR.n864 VPWR.n862 0.08675
R3048 VPWR.n1464 VPWR.n1463 0.08675
R3049 VPWR.n1017 VPWR.n1016 0.08675
R3050 VPWR.n994 VPWR.n993 0.08675
R3051 VPWR.n169 VPWR.n168 0.143935
R3052 VPWR.n1092 VPWR.n628 0.0296542
R3053 VPWR.n1300 VPWR.n1299 0.08675
R3054 VPWR.n629 VPWR.n638 0.0296564
R3055 VPWR.n1657 VPWR.n1601 0.0857809
R3056 VPWR.n842 VPWR.n841 0.0855
R3057 VPWR.n1452 VPWR.n1451 0.0855
R3058 VPWR.n1627 VPWR.n1625 0.0854657
R3059 VPWR.n879 VPWR.n878 0.0854657
R3060 VPWR.n903 VPWR.n902 0.0854657
R3061 VPWR.n1113 VPWR.n1112 0.0854657
R3062 VPWR.n1311 VPWR.n1310 0.0854657
R3063 VPWR.n1509 VPWR.n613 0.085375
R3064 VPWR.n308 VPWR.n616 0.085375
R3065 VPWR.n624 VPWR.n622 0.085375
R3066 VPWR.n670 VPWR.n669 0.084539
R3067 VPWR.n1632 VPWR.n1631 0.084539
R3068 VPWR.n1612 VPWR.n1611 0.084539
R3069 VPWR.n1606 VPWR.n1605 0.084539
R3070 VPWR.n513 VPWR.n332 0.084539
R3071 VPWR.n406 VPWR.n240 0.084539
R3072 VPWR.n875 VPWR.n874 0.084539
R3073 VPWR.n755 VPWR.n754 0.084539
R3074 VPWR.n803 VPWR.n802 0.084539
R3075 VPWR.n826 VPWR.n825 0.084539
R3076 VPWR.n841 VPWR.n840 0.084539
R3077 VPWR.n1514 VPWR.n1513 0.084539
R3078 VPWR.n899 VPWR.n898 0.084539
R3079 VPWR.n974 VPWR.n973 0.084539
R3080 VPWR.n242 VPWR.n1468 0.084539
R3081 VPWR.n1453 VPWR.n1452 0.084539
R3082 VPWR.n20 VPWR.n5 0.110648
R3083 VPWR.n1441 VPWR.n1440 0.084539
R3084 VPWR.n1433 VPWR.n1432 0.084539
R3085 VPWR.n1003 VPWR.n1002 0.084539
R3086 VPWR.n1109 VPWR.n1108 0.084539
R3087 VPWR.n1101 VPWR.n181 0.141705
R3088 VPWR.n543 VPWR.n334 0.084539
R3089 VPWR.n4 VPWR.n3 0.850277
R3090 VPWR.n1407 VPWR.n1406 0.084539
R3091 VPWR.n1307 VPWR.n1306 0.084539
R3092 VPWR.n1198 VPWR.n1197 0.084539
R3093 VPWR.n553 VPWR.n336 0.084539
R3094 VPWR.n1235 VPWR.n1234 0.084539
R3095 VPWR.n1248 VPWR.n1247 0.084539
R3096 VPWR.n1325 VPWR.n1324 0.084539
R3097 VPWR.n717 VPWR.n716 0.084539
R3098 VPWR.n1554 VPWR.n1553 0.08425
R3099 VPWR.n343 VPWR.n743 0.140194
R3100 VPWR.n11 VPWR.n1486 0.08425
R3101 VPWR.n91 VPWR.n759 0.206197
R3102 VPWR.n782 VPWR.n78 0.264811
R3103 VPWR.n791 VPWR.n347 0.140194
R3104 VPWR.n814 VPWR.n348 0.140194
R3105 VPWR.n1465 VPWR.n1464 0.08425
R3106 VPWR.n88 VPWR.n128 0.202063
R3107 VPWR.n981 VPWR.n632 0.146193
R3108 VPWR.n359 VPWR.n1160 0.140194
R3109 VPWR.n1422 VPWR.n1421 0.08425
R3110 VPWR.n122 VPWR.n120 0.08425
R3111 VPWR.n1065 VPWR.n1063 0.08425
R3112 VPWR.n1072 VPWR.n1035 0.08425
R3113 VPWR.n365 VPWR.n1209 0.140194
R3114 VPWR.n1186 VPWR.n1185 0.08425
R3115 VPWR.n1221 VPWR.n1183 0.08425
R3116 VPWR.n1283 VPWR.n1282 0.08425
R3117 VPWR.n1275 VPWR.n1274 0.08425
R3118 VPWR.n1368 VPWR.n1344 0.08425
R3119 VPWR.n1371 VPWR.n1370 0.08425
R3120 VPWR.n1330 VPWR.n1329 0.0836027
R3121 VPWR.n640 VPWR.n639 0.082039
R3122 VPWR.n1621 VPWR.n1620 0.082039
R3123 VPWR.n1607 VPWR.n1606 0.082039
R3124 VPWR.n749 VPWR.n746 0.082039
R3125 VPWR.n1566 VPWR.n1565 0.082039
R3126 VPWR.n886 VPWR.n884 0.082039
R3127 VPWR.n412 VPWR.n763 0.140025
R3128 VPWR.n788 VPWR.n787 0.082039
R3129 VPWR.n796 VPWR.n795 0.082039
R3130 VPWR.n811 VPWR.n810 0.082039
R3131 VPWR.n819 VPWR.n818 0.082039
R3132 VPWR.n834 VPWR.n833 0.082039
R3133 VPWR.n413 VPWR.n1520 0.140025
R3134 VPWR.n910 VPWR.n908 0.082039
R3135 VPWR.n928 VPWR.n927 0.082039
R3136 VPWR.n929 VPWR.n928 0.082039
R3137 VPWR.n950 VPWR.n949 0.082039
R3138 VPWR.n414 VPWR.n975 0.140025
R3139 VPWR.n1448 VPWR.n461 0.166223
R3140 VPWR.n1008 VPWR.n1007 0.082039
R3141 VPWR.n1120 VPWR.n1118 0.082039
R3142 VPWR.n1128 VPWR.n1127 0.082039
R3143 VPWR.n1133 VPWR.n1132 0.082039
R3144 VPWR.n1156 VPWR.n1155 0.082039
R3145 VPWR.n1166 VPWR.n1163 0.082039
R3146 VPWR.n1402 VPWR.n1401 0.082039
R3147 VPWR.n1416 VPWR.n1415 0.082039
R3148 VPWR.n139 VPWR.n1047 0.082039
R3149 VPWR.n1067 VPWR.n1066 0.082039
R3150 VPWR.n1071 VPWR.n1070 0.082039
R3151 VPWR.n1318 VPWR.n1316 0.082039
R3152 VPWR.n1205 VPWR.n1204 0.082039
R3153 VPWR.n1215 VPWR.n1212 0.082039
R3154 VPWR.n1170 VPWR.n1169 0.082039
R3155 VPWR.n1253 VPWR.n1252 0.082039
R3156 VPWR.n1355 VPWR.n1352 0.082039
R3157 VPWR.n369 VPWR.n1343 0.082039
R3158 VPWR.n373 VPWR.n1340 0.082039
R3159 VPWR.n1382 VPWR.n1381 0.082039
R3160 VPWR.n722 VPWR.n721 0.082039
R3161 VPWR.n653 VPWR.n652 0.08175
R3162 VPWR.n955 VPWR.n889 0.08175
R3163 VPWR.n699 VPWR.n698 0.08175
R3164 VPWR.n683 VPWR.n682 0.08175
R3165 VPWR.n410 VPWR.n1661 0.10589
R3166 VPWR.n654 VPWR.n649 0.0808371
R3167 VPWR.n1597 VPWR.n1596 0.0808371
R3168 VPWR.n1653 VPWR.n1601 0.0808371
R3169 VPWR.n960 VPWR.n959 0.0808371
R3170 VPWR.n986 VPWR.n491 0.0808371
R3171 VPWR.n1151 VPWR.n1150 0.0808371
R3172 VPWR.n328 VPWR.n1167 0.134932
R3173 VPWR.n98 VPWR.n97 0.130017
R3174 VPWR.n1051 VPWR.n1048 0.0808371
R3175 VPWR.n1061 VPWR.n1037 0.0808371
R3176 VPWR.n1078 VPWR.n1077 0.0808371
R3177 VPWR.n331 VPWR.n1216 0.134932
R3178 VPWR.n1285 VPWR.n1284 0.0808371
R3179 VPWR.n1273 VPWR.n1272 0.0808371
R3180 VPWR.n1364 VPWR.n1362 0.0808371
R3181 VPWR.n1372 VPWR.n1338 0.0808371
R3182 VPWR.n697 VPWR.n696 0.0808371
R3183 VPWR.n686 VPWR.n685 0.0808371
R3184 VPWR.n1668 VPWR.n521 0.140168
R3185 VPWR.n1352 VPWR.n1351 0.0805
R3186 VPWR.n1149 VPWR.n1096 0.0799444
R3187 VPWR.n1638 VPWR.n1637 0.079539
R3188 VPWR.n1618 VPWR.n1617 0.079539
R3189 VPWR.n1645 VPWR.n1644 0.079539
R3190 VPWR.n264 VPWR.n1581 0.079539
R3191 VPWR.n1579 VPWR.n1578 0.079539
R3192 VPWR.n525 VPWR.n1659 0.079539
R3193 VPWR.n1491 VPWR.n1490 0.079539
R3194 VPWR.n345 VPWR.n752 0.079539
R3195 VPWR.n835 VPWR.n834 0.079539
R3196 VPWR.n855 VPWR.n854 0.079539
R3197 VPWR.n1508 VPWR.n1507 0.079539
R3198 VPWR.n979 VPWR.n978 0.079539
R3199 VPWR.n893 VPWR.n582 0.079539
R3200 VPWR.n449 VPWR.n448 0.127495
R3201 VPWR.n1432 VPWR.n1431 0.079539
R3202 VPWR.n586 VPWR.n1103 0.079539
R3203 VPWR.n1123 VPWR.n1122 0.079539
R3204 VPWR.n1413 VPWR.n1412 0.079539
R3205 VPWR.n1427 VPWR.n1426 0.079539
R3206 VPWR.n1240 VPWR.n1168 0.079539
R3207 VPWR.n590 VPWR.n1301 0.079539
R3208 VPWR.n1227 VPWR.n1226 0.079539
R3209 VPWR.n1230 VPWR.n1229 0.079539
R3210 VPWR.n444 VPWR.n443 0.127495
R3211 VPWR.n1242 VPWR.n1241 0.079539
R3212 VPWR.n1351 VPWR.n1350 0.079539
R3213 VPWR.n1379 VPWR.n1378 0.079539
R3214 VPWR.n707 VPWR.n706 0.079539
R3215 VPWR.n1502 VPWR.n1499 0.07675
R3216 VPWR.n47 VPWR.n46 0.134633
R3217 VPWR.n972 VPWR.n971 0.0755
R3218 VPWR.n975 VPWR.n974 0.0755
R3219 VPWR.n45 VPWR.n678 0.427535
R3220 VPWR.n1140 VPWR.n1100 0.07425
R3221 VPWR.n1537 VPWR.n51 0.321197
R3222 VPWR.n1619 VPWR.n1618 0.072039
R3223 VPWR.n1644 VPWR.n1643 0.072039
R3224 VPWR.n381 VPWR.n1615 0.072039
R3225 VPWR.n738 VPWR.n736 0.072039
R3226 VPWR.n447 VPWR.n446 0.0246817
R3227 VPWR.n1577 VPWR.n286 0.128385
R3228 VPWR.n1667 VPWR.n1665 0.072039
R3229 VPWR.n769 VPWR.n768 0.072039
R3230 VPWR.n1490 VPWR.n1489 0.072039
R3231 VPWR.n867 VPWR.n866 0.072039
R3232 VPWR.n843 VPWR.n842 0.072039
R3233 VPWR.n1 VPWR.n0 0.893909
R3234 VPWR.n295 VPWR.n1508 0.072039
R3235 VPWR.n912 VPWR.n911 0.072039
R3236 VPWR.n945 VPWR.n944 0.072039
R3237 VPWR.n41 VPWR.n965 0.4949
R3238 VPWR.n300 VPWR.n969 0.072039
R3239 VPWR.n450 VPWR.n449 0.0246817
R3240 VPWR.n1451 VPWR.n460 0.220661
R3241 VPWR.n989 VPWR.n987 0.072039
R3242 VPWR.n1122 VPWR.n1121 0.072039
R3243 VPWR.n492 VPWR.n1102 0.072039
R3244 VPWR.n452 VPWR.n451 0.0246817
R3245 VPWR.n1394 VPWR.n1393 0.072039
R3246 VPWR.n1426 VPWR.n311 0.072039
R3247 VPWR.n1024 VPWR.n1023 0.072039
R3248 VPWR.n1321 VPWR.n1319 0.072039
R3249 VPWR.n441 VPWR.n1190 0.072039
R3250 VPWR.n1181 VPWR.n1179 0.072039
R3251 VPWR.n1178 VPWR.n1177 0.072039
R3252 VPWR.n445 VPWR.n444 0.0246817
R3253 VPWR.n1386 VPWR.n1337 0.07175
R3254 VPWR.n454 VPWR.n1446 0.0712431
R3255 VPWR.n1615 VPWR.n1614 0.069539
R3256 VPWR.n199 VPWR.n1589 0.069539
R3257 VPWR.n197 VPWR.n1561 0.069539
R3258 VPWR.n1488 VPWR.n1487 0.069539
R3259 VPWR.n386 VPWR.n757 0.069539
R3260 VPWR.n1511 VPWR.n1510 0.069539
R3261 VPWR.n1522 VPWR.n154 0.069539
R3262 VPWR.n1527 VPWR.n1526 0.069539
R3263 VPWR.n971 VPWR.n970 0.069539
R3264 VPWR.n124 VPWR.n388 0.069539
R3265 VPWR.n1467 VPWR.n56 0.308592
R3266 VPWR.n27 VPWR.n26 0.174124
R3267 VPWR.n357 VPWR.n1098 0.069539
R3268 VPWR.n1322 VPWR.n394 0.069539
R3269 VPWR.n62 VPWR.n1555 0.06925
R3270 VPWR.n1654 VPWR.n1602 0.06925
R3271 VPWR.n105 VPWR.n739 0.120225
R3272 VPWR.n411 VPWR.n1483 0.126435
R3273 VPWR.n1530 VPWR.n1529 0.06925
R3274 VPWR.n923 VPWR.n921 0.06925
R3275 VPWR.n933 VPWR.n891 0.06925
R3276 VPWR.n963 VPWR.n961 0.06925
R3277 VPWR.n1474 VPWR.n1473 0.06925
R3278 VPWR.n75 VPWR.n74 0.118982
R3279 VPWR.n127 VPWR.n1458 0.129539
R3280 VPWR.n1418 VPWR.n360 0.125194
R3281 VPWR.n1062 VPWR.n1060 0.06925
R3282 VPWR.n1073 VPWR.n1034 0.06925
R3283 VPWR.n487 VPWR.n218 0.120225
R3284 VPWR.n1366 VPWR.n1345 0.06925
R3285 VPWR.n1374 VPWR.n1373 0.06925
R3286 VPWR.n692 VPWR.n691 0.06925
R3287 VPWR.n673 VPWR.n629 0.127053
R3288 VPWR.n658 VPWR.n649 0.0684775
R3289 VPWR.n1055 VPWR.n1048 0.0684775
R3290 VPWR.n1287 VPWR.n1286 0.0684775
R3291 VPWR.n1271 VPWR.n1270 0.0684775
R3292 VPWR.n1647 VPWR.n1608 0.068
R3293 VPWR.n1587 VPWR.n1586 0.068
R3294 VPWR.n1559 VPWR.n1558 0.068
R3295 VPWR.n809 VPWR.n808 0.068
R3296 VPWR.n832 VPWR.n831 0.068
R3297 VPWR.n1519 VPWR.n1518 0.068
R3298 VPWR.n1473 VPWR.n1472 0.068
R3299 VPWR.n1435 VPWR.n1434 0.068
R3300 VPWR.n1203 VPWR.n1202 0.068
R3301 VPWR.n1220 VPWR.n1218 0.068
R3302 VPWR.n1224 VPWR.n1223 0.068
R3303 VPWR.n1356 VPWR.n627 0.0671236
R3304 VPWR.n1604 VPWR.n1603 0.067039
R3305 VPWR.n742 VPWR.n741 0.067039
R3306 VPWR.n1591 VPWR.n1590 0.067039
R3307 VPWR.n1563 VPWR.n1562 0.067039
R3308 VPWR.n1667 VPWR.n1666 0.067039
R3309 VPWR.n863 VPWR.n769 0.067039
R3310 VPWR.n1497 VPWR.n866 0.067039
R3311 VPWR.n64 VPWR.n752 0.067039
R3312 VPWR.n187 VPWR.n790 0.067039
R3313 VPWR.n185 VPWR.n813 0.067039
R3314 VPWR.n846 VPWR.n843 0.067039
R3315 VPWR.n913 VPWR.n912 0.067039
R3316 VPWR.n926 VPWR.n925 0.067039
R3317 VPWR.n932 VPWR.n930 0.067039
R3318 VPWR.n938 VPWR.n937 0.067039
R3319 VPWR.n953 VPWR.n952 0.067039
R3320 VPWR.n416 VPWR.n1019 0.067039
R3321 VPWR.n997 VPWR.n996 0.067039
R3322 VPWR.n989 VPWR.n988 0.067039
R3323 VPWR.n1125 VPWR.n1124 0.067039
R3324 VPWR.n180 VPWR.n1135 0.109413
R3325 VPWR.n420 VPWR.n1098 0.067039
R3326 VPWR.n1159 VPWR.n1158 0.067039
R3327 VPWR.n146 VPWR.n1417 0.067039
R3328 VPWR.n1045 VPWR.n216 0.067039
R3329 VPWR.n1068 VPWR.n1067 0.067039
R3330 VPWR.n1071 VPWR.n1069 0.067039
R3331 VPWR.n67 VPWR.n194 0.067039
R3332 VPWR.n1081 VPWR.n1080 0.067039
R3333 VPWR.n1089 VPWR.n1088 0.067039
R3334 VPWR.n1321 VPWR.n1320 0.067039
R3335 VPWR.n1208 VPWR.n1207 0.067039
R3336 VPWR.n366 VPWR.n1277 0.067039
R3337 VPWR.n1277 VPWR.n1276 0.067039
R3338 VPWR.n1343 VPWR.n1342 0.067039
R3339 VPWR.n1341 VPWR.n1340 0.067039
R3340 VPWR.n1385 VPWR.n1383 0.067039
R3341 VPWR.n325 VPWR.n704 0.067039
R3342 VPWR.n675 VPWR.n674 0.067039
R3343 VPWR.n656 VPWR.n655 0.06675
R3344 VPWR.n1553 VPWR.n1552 0.06675
R3345 VPWR.n1652 VPWR.n1651 0.06675
R3346 VPWR.n77 VPWR.n76 0.121452
R3347 VPWR.n919 VPWR.n892 0.06675
R3348 VPWR.n936 VPWR.n935 0.06675
R3349 VPWR.n1471 VPWR.n1470 0.06675
R3350 VPWR.n995 VPWR.n994 0.06675
R3351 VPWR.n73 VPWR.n72 0.116482
R3352 VPWR.n1154 VPWR.n483 0.06675
R3353 VPWR.n1053 VPWR.n1052 0.06675
R3354 VPWR.n1290 VPWR.n1289 0.06675
R3355 VPWR.n679 VPWR.n79 0.122694
R3356 VPWR.n575 VPWR.n574 0.066625
R3357 VPWR.n659 VPWR.n657 0.0660056
R3358 VPWR.n1593 VPWR.n1556 0.0660056
R3359 VPWR.n1658 VPWR.n1656 0.0660056
R3360 VPWR.n570 VPWR.n568 0.0660056
R3361 VPWR.n958 VPWR.n888 0.0660056
R3362 VPWR.n962 VPWR.n888 0.0660056
R3363 VPWR.n984 VPWR.n34 0.673619
R3364 VPWR.n1153 VPWR.n119 0.0660056
R3365 VPWR.n1056 VPWR.n1054 0.0660056
R3366 VPWR.n1059 VPWR.n1058 0.0660056
R3367 VPWR.n1057 VPWR.n1037 0.0660056
R3368 VPWR.n1078 VPWR.n1076 0.0660056
R3369 VPWR.n1288 VPWR.n1287 0.0660056
R3370 VPWR.n1270 VPWR.n1269 0.0660056
R3371 VPWR.n1360 VPWR.n1346 0.0660056
R3372 VPWR.n1364 VPWR.n1363 0.0660056
R3373 VPWR.n1375 VPWR.n1338 0.0660056
R3374 VPWR.n1377 VPWR.n1376 0.0660056
R3375 VPWR.n695 VPWR.n694 0.0660056
R3376 VPWR.n694 VPWR.n693 0.0660056
R3377 VPWR.n689 VPWR.n688 0.0660056
R3378 VPWR.n1671 VPWR.n1670 0.065789
R3379 VPWR.n1640 VPWR.n1616 0.065789
R3380 VPWR.n1495 VPWR.n1494 0.065789
R3381 VPWR.n1041 VPWR.n633 0.065789
R3382 VPWR.n1355 VPWR.n1354 0.065789
R3383 VPWR.n1646 VPWR.n1645 0.0655
R3384 VPWR.n1141 VPWR.n1099 0.0652778
R3385 VPWR.n1144 VPWR.n1099 0.0652778
R3386 VPWR.n1152 VPWR.n1096 0.0652778
R3387 VPWR.n1544 VPWR.n1543 0.06425
R3388 VPWR.n1547 VPWR.n1546 0.06425
R3389 VPWR.n1486 VPWR.n1485 0.06425
R3390 VPWR.n1502 VPWR.n1501 0.06425
R3391 VPWR.n762 VPWR.n761 0.06425
R3392 VPWR.n786 VPWR.n785 0.06425
R3393 VPWR.n1137 VPWR.n1100 0.06425
R3394 VPWR.n422 VPWR.n1263 0.06425
R3395 VPWR.n1019 VPWR.n1018 0.063
R3396 VPWR.n1126 VPWR.n1125 0.063
R3397 VPWR.n1129 VPWR.n1128 0.063
R3398 VPWR.n1132 VPWR.n1131 0.063
R3399 VPWR.n1135 VPWR.n1134 0.063
R3400 VPWR.n505 VPWR.n100 0.115922
R3401 VPWR.n508 VPWR.n102 0.115922
R3402 VPWR.n516 VPWR.n515 0.121665
R3403 VPWR.n110 VPWR.n109 0.115922
R3404 VPWR.n780 VPWR.n778 0.062039
R3405 VPWR.n840 VPWR.n839 0.062039
R3406 VPWR.n860 VPWR.n859 0.062039
R3407 VPWR.n1460 VPWR.n303 0.118385
R3408 VPWR.n1455 VPWR.n1453 0.062039
R3409 VPWR.n1450 VPWR.n1449 0.062039
R3410 VPWR.n1047 VPWR.n1046 0.062039
R3411 VPWR.n1030 VPWR.n1029 0.062039
R3412 VPWR.n1296 VPWR.n1293 0.062039
R3413 VPWR.n224 VPWR.n223 0.115922
R3414 VPWR.n748 VPWR.n747 0.06175
R3415 VPWR.n798 VPWR.n797 0.06175
R3416 VPWR.n821 VPWR.n820 0.06175
R3417 VPWR.n1165 VPWR.n1164 0.06175
R3418 VPWR.n1428 VPWR.n1427 0.06175
R3419 VPWR.n1214 VPWR.n1213 0.06175
R3420 VPWR.n1528 VPWR.n1503 0.0615309
R3421 VPWR.n736 VPWR.n735 0.0605
R3422 VPWR.n741 VPWR.n740 0.0605
R3423 VPWR.n1531 VPWR.n93 0.180486
R3424 VPWR.n1531 VPWR.n432 0.0605
R3425 VPWR.n1498 VPWR.n1496 0.0605
R3426 VPWR.n1496 VPWR.n865 0.0605
R3427 VPWR.n757 VPWR.n756 0.0605
R3428 VPWR.n754 VPWR.n753 0.0605
R3429 VPWR.n790 VPWR.n789 0.0605
R3430 VPWR.n813 VPWR.n812 0.0605
R3431 VPWR.n475 VPWR.n966 0.0605
R3432 VPWR.n478 VPWR.n475 0.0605
R3433 VPWR.n1158 VPWR.n1157 0.0605
R3434 VPWR.n1088 VPWR.n1087 0.0605
R3435 VPWR.n1388 VPWR.n1387 0.0605
R3436 VPWR.n1388 VPWR.n486 0.0605
R3437 VPWR.n1207 VPWR.n1206 0.0605
R3438 VPWR.n378 VPWR.n377 0.116444
R3439 VPWR.n377 VPWR.n702 0.0605
R3440 VPWR.n1093 VPWR.n1092 0.05925
R3441 VPWR.n1326 VPWR.n1325 0.058
R3442 VPWR.n1323 VPWR.n1322 0.058
R3443 VPWR.n847 VPWR.n844 0.0577659
R3444 VPWR.n1329 VPWR.n1328 0.0573539
R3445 VPWR.n1543 VPWR.n380 0.117039
R3446 VPWR.n1546 VPWR.n1544 0.05675
R3447 VPWR.n1485 VPWR.n869 0.05675
R3448 VPWR.n1501 VPWR.n865 0.05675
R3449 VPWR.n761 VPWR.n758 0.05675
R3450 VPWR.n777 VPWR.n775 0.05675
R3451 VPWR.n785 VPWR.n783 0.05675
R3452 VPWR.n538 VPWR.n991 0.116418
R3453 VPWR.n1139 VPWR.n1137 0.05675
R3454 VPWR.n1033 VPWR.n1032 0.05675
R3455 VPWR.n423 VPWR.n422 0.113935
R3456 VPWR.n1263 VPWR.n1262 0.05675
R3457 VPWR.n965 VPWR.n964 0.0555
R3458 VPWR.n574 VPWR.n1021 0.0555
R3459 VPWR.n215 VPWR.n604 0.120708
R3460 VPWR.n96 VPWR.n1669 0.120884
R3461 VPWR.n1541 VPWR.n95 0.120884
R3462 VPWR.n655 VPWR.n650 0.05425
R3463 VPWR.n1548 VPWR.n1547 0.05425
R3464 VPWR.n1552 VPWR.n1551 0.05425
R3465 VPWR.n1651 VPWR.n340 0.110194
R3466 VPWR.n233 VPWR.n232 0.116193
R3467 VPWR.n76 VPWR.n781 0.05425
R3468 VPWR.n1444 VPWR.n1443 0.05425
R3469 VPWR.n72 VPWR.n982 0.05425
R3470 VPWR.n134 VPWR.n1154 0.105225
R3471 VPWR.n1052 VPWR.n1049 0.05425
R3472 VPWR.n1087 VPWR.n628 0.112055
R3473 VPWR.n709 VPWR.n708 0.05425
R3474 VPWR.n680 VPWR.n679 0.05425
R3475 VPWR.n657 VPWR.n648 0.0538848
R3476 VPWR.n1594 VPWR.n1593 0.0538848
R3477 VPWR.n1656 VPWR.n166 0.0538848
R3478 VPWR.n568 VPWR.n287 0.108586
R3479 VPWR.n963 VPWR.n962 0.0538848
R3480 VPWR.n1445 VPWR.n1444 0.0538848
R3481 VPWR.n985 VPWR.n984 0.0538848
R3482 VPWR.n1054 VPWR.n120 0.0538848
R3483 VPWR.n1289 VPWR.n1288 0.0538848
R3484 VPWR.n320 VPWR.n1356 0.108586
R3485 VPWR.n693 VPWR.n692 0.0538848
R3486 VPWR.n690 VPWR.n689 0.0538848
R3487 VPWR.n1142 VPWR.n1141 0.053789
R3488 VPWR.n1145 VPWR.n1144 0.053789
R3489 VPWR.n960 VPWR.n958 0.0536461
R3490 VPWR.n1059 VPWR.n1057 0.0536461
R3491 VPWR.n1363 VPWR.n1346 0.0536461
R3492 VPWR.n1376 VPWR.n1375 0.0536461
R3493 VPWR.n696 VPWR.n695 0.0536461
R3494 VPWR.n1153 VPWR.n1152 0.053289
R3495 VPWR.n1649 VPWR.n1647 0.053
R3496 VPWR.n1588 VPWR.n1587 0.053
R3497 VPWR.n1560 VPWR.n1559 0.053
R3498 VPWR.n808 VPWR.n807 0.053
R3499 VPWR.n831 VPWR.n830 0.053
R3500 VPWR.n1518 VPWR.n1505 0.053
R3501 VPWR.n1472 VPWR.n1471 0.053
R3502 VPWR.n1436 VPWR.n1435 0.053
R3503 VPWR.n1029 VPWR.n1028 0.053
R3504 VPWR.n1202 VPWR.n1189 0.053
R3505 VPWR.n1218 VPWR.n1186 0.053
R3506 VPWR.n1223 VPWR.n1183 0.053
R3507 VPWR.n1551 VPWR.n1550 0.05175
R3508 VPWR.n63 VPWR.n62 0.101482
R3509 VPWR.n1655 VPWR.n1654 0.05175
R3510 VPWR.n739 VPWR.n474 0.05175
R3511 VPWR.n1483 VPWR.n869 0.05175
R3512 VPWR.n1529 VPWR.n532 0.111418
R3513 VPWR.n921 VPWR.n349 0.107694
R3514 VPWR.n352 VPWR.n933 0.107694
R3515 VPWR.n74 VPWR.n1466 0.05175
R3516 VPWR.n1462 VPWR.n1461 0.05175
R3517 VPWR.n1458 VPWR.n481 0.05175
R3518 VPWR.n1018 VPWR.n1017 0.05175
R3519 VPWR.n1419 VPWR.n1418 0.05175
R3520 VPWR.n1060 VPWR.n1036 0.05175
R3521 VPWR.n1075 VPWR.n1073 0.05175
R3522 VPWR.n489 VPWR.n487 0.05175
R3523 VPWR.n1220 VPWR.n1219 0.05175
R3524 VPWR.n1225 VPWR.n1224 0.05175
R3525 VPWR.n1367 VPWR.n1366 0.05175
R3526 VPWR.n1373 VPWR.n1339 0.05175
R3527 VPWR.n691 VPWR.n690 0.05175
R3528 VPWR.n659 VPWR.n658 0.0511742
R3529 VPWR.n1056 VPWR.n1055 0.0511742
R3530 VPWR.n1286 VPWR.n1285 0.0511742
R3531 VPWR.n1272 VPWR.n1271 0.0511742
R3532 VPWR.n1581 VPWR.n1580 0.0505
R3533 VPWR.n706 VPWR.n705 0.0505
R3534 VPWR.n772 VPWR.n771 0.04925
R3535 VPWR.n376 VPWR.n1386 0.105194
R3536 VPWR.n949 VPWR.n948 0.048
R3537 VPWR.n952 VPWR.n951 0.048
R3538 VPWR.n996 VPWR.n995 0.048
R3539 VPWR.n1228 VPWR.n1227 0.048
R3540 VPWR.n1661 VPWR.n1660 0.0474663
R3541 VPWR.n850 VPWR.n849 0.0471245
R3542 VPWR.n939 VPWR.n938 0.04675
R3543 VPWR.n1142 VPWR.n1140 0.0467303
R3544 VPWR.n1145 VPWR.n1143 0.0467303
R3545 VPWR.n1614 VPWR.n1613 0.0455
R3546 VPWR.n1611 VPWR.n1610 0.0455
R3547 VPWR.n801 VPWR.n800 0.0455
R3548 VPWR.n804 VPWR.n803 0.0455
R3549 VPWR.n824 VPWR.n823 0.0455
R3550 VPWR.n827 VPWR.n826 0.0455
R3551 VPWR.n1512 VPWR.n1511 0.0455
R3552 VPWR.n1515 VPWR.n1514 0.0455
R3553 VPWR.n635 VPWR.n1192 0.107443
R3554 VPWR.n1196 VPWR.n1195 0.0455
R3555 VPWR.n1199 VPWR.n1198 0.0455
R3556 VPWR.n710 VPWR.n709 0.0455
R3557 VPWR.n678 VPWR.n677 0.0455
R3558 VPWR.n674 VPWR.n673 0.0455
R3559 VPWR.n859 VPWR.n856 0.0448003
R3560 VPWR.n839 VPWR.n837 0.0448003
R3561 VPWR.n1456 VPWR.n1455 0.0448003
R3562 VPWR.n1297 VPWR.n1296 0.0448003
R3563 VPWR.n768 VPWR.n767 0.04425
R3564 VPWR.n1499 VPWR.n163 0.04425
R3565 VPWR.n46 VPWR.n772 0.04425
R3566 VPWR.n849 VPWR.n844 0.0440159
R3567 VPWR.t348 VPWR.n96 5.05031
R3568 VPWR.n26 VPWR.n1442 0.043
R3569 VPWR.n1440 VPWR.n1439 0.043
R3570 VPWR.n1670 VPWR.n731 0.0423097
R3571 VPWR.n393 VPWR.n391 0.0768541
R3572 VPWR.n426 VPWR.n425 0.0218396
R3573 VPWR.n1641 VPWR.n1640 0.0423097
R3574 VPWR.n1494 VPWR.n868 0.0423097
R3575 VPWR.n942 VPWR.n941 0.0423097
R3576 VPWR.n1043 VPWR.n1041 0.0423097
R3577 VPWR.n1354 VPWR.n1349 0.0423097
R3578 VPWR.n1643 VPWR.n1642 0.0405
R3579 VPWR.n944 VPWR.n943 0.0405
R3580 VPWR.n1025 VPWR.n1024 0.0405
R3581 VPWR.t480 VPWR.n630 0.101193
R3582 VPWR.n652 VPWR.n338 0.0951936
R3583 VPWR.n957 VPWR.n955 0.03925
R3584 VPWR.n1437 VPWR.n1436 0.03925
R3585 VPWR.n700 VPWR.n699 0.03925
R3586 VPWR.n684 VPWR.n683 0.03925
R3587 VPWR.n656 VPWR.n654 0.0388848
R3588 VPWR.n36 VPWR.n1597 0.550903
R3589 VPWR.n1594 VPWR.n1592 0.0388848
R3590 VPWR.n1655 VPWR.n1653 0.0388848
R3591 VPWR.n9 VPWR.n511 0.0985532
R3592 VPWR.n959 VPWR.n889 0.0388848
R3593 VPWR.n132 VPWR.n986 0.0898595
R3594 VPWR.n1150 VPWR.n1097 0.0388848
R3595 VPWR.n1167 VPWR.n541 0.0985532
R3596 VPWR.n97 VPWR.n1423 0.0388848
R3597 VPWR.n1053 VPWR.n1051 0.0388848
R3598 VPWR.n1062 VPWR.n1061 0.0388848
R3599 VPWR.n1077 VPWR.n1034 0.0388848
R3600 VPWR.n1216 VPWR.n551 0.0985532
R3601 VPWR.n1284 VPWR.n1283 0.0388848
R3602 VPWR.n1274 VPWR.n1273 0.0388848
R3603 VPWR.n1362 VPWR.n1345 0.0388848
R3604 VPWR.n1374 VPWR.n1372 0.0388848
R3605 VPWR.n698 VPWR.n697 0.0388848
R3606 VPWR.n685 VPWR.n684 0.0388848
R3607 VPWR.n1151 VPWR.n1149 0.0384576
R3608 VPWR.n1555 VPWR.n1554 0.03675
R3609 VPWR.n1649 VPWR.n1648 0.03675
R3610 VPWR.n743 VPWR.n734 0.03675
R3611 VPWR.n759 VPWR.n758 0.03675
R3612 VPWR.n783 VPWR.n782 0.03675
R3613 VPWR.n792 VPWR.n791 0.03675
R3614 VPWR.n807 VPWR.n806 0.03675
R3615 VPWR.n815 VPWR.n814 0.03675
R3616 VPWR.n830 VPWR.n829 0.03675
R3617 VPWR.n1516 VPWR.n1505 0.03675
R3618 VPWR.n1466 VPWR.n1465 0.03675
R3619 VPWR.n982 VPWR.n981 0.03675
R3620 VPWR.n1160 VPWR.n1095 0.03675
R3621 VPWR.n309 VPWR.n308 0.0914516
R3622 VPWR.n1423 VPWR.n1422 0.03675
R3623 VPWR.n1063 VPWR.n361 0.0926936
R3624 VPWR.n364 VPWR.n1072 0.0926936
R3625 VPWR.n1200 VPWR.n1189 0.03675
R3626 VPWR.n1209 VPWR.n1188 0.03675
R3627 VPWR.n1282 VPWR.n1281 0.03675
R3628 VPWR.n58 VPWR.n1275 0.304297
R3629 VPWR.n371 VPWR.n1368 0.0926936
R3630 VPWR.n1370 VPWR.n372 0.0926936
R3631 VPWR.n622 VPWR.n323 0.0914516
R3632 VPWR.n677 VPWR.n676 0.03675
R3633 VPWR.n1507 VPWR.n1506 0.0355
R3634 VPWR.n1414 VPWR.n1413 0.0355
R3635 VPWR.n1380 VPWR.n1379 0.0355
R3636 VPWR.n661 VPWR.n660 0.03425
R3637 VPWR.n662 VPWR.n661 0.03425
R3638 VPWR.n1463 VPWR.n1462 0.03425
R3639 VPWR.n849 VPWR.n848 0.0338793
R3640 VPWR.n1658 VPWR.n1657 0.0338708
R3641 VPWR.n862 VPWR.n770 0.0317219
R3642 VPWR.n30 VPWR.n1591 0.0305
R3643 VPWR.n1570 VPWR.n1569 0.0305
R3644 VPWR.n1567 VPWR.n1566 0.0305
R3645 VPWR.n1564 VPWR.n1563 0.0305
R3646 VPWR.n1332 VPWR.n1331 0.027691
R3647 VPWR.n664 VPWR.n663 0.02675
R3648 VPWR.t1518 VPWR.n597 7.31613
R3649 VPWR.n214 VPWR.n94 2.2005
R3650 VPWR VPWR.n214 0.452035
R3651 VPWR.n164 VPWR.n162 0.284135
R3652 VPWR.n764 VPWR.n465 0.326044
R3653 VPWR.n1461 VPWR.n463 0.295333
R3654 VPWR.n572 VPWR.n571 0.264727
R3655 VPWR.n16 VPWR.n15 0.256078
R3656 VPWR.n457 VPWR.n417 0.256078
R3657 VPWR.n470 VPWR.n961 0.254515
R3658 VPWR.n451 VPWR.n483 0.237831
R3659 VPWR.n450 VPWR.n481 0.237831
R3660 VPWR.n446 VPWR.n474 0.237831
R3661 VPWR.n445 VPWR.n486 0.237831
R3662 VPWR.n455 VPWR.n454 0.236679
R3663 VPWR.n461 VPWR.n456 0.235262
R3664 VPWR.n597 VPWR.n87 0.231089
R3665 VPWR.n1431 VPWR.n575 0.229194
R3666 VPWR.n301 VPWR.n302 0.175124
R3667 VPWR.n312 VPWR.n313 0.175124
R3668 VPWR.n442 VPWR.n441 0.202255
R3669 VPWR.n155 VPWR.n154 0.187039
R3670 VPWR.n1527 VPWR.n153 0.187039
R3671 VPWR.n289 VPWR.n177 0.186153
R3672 VPWR.n317 VPWR.n172 0.186153
R3673 VPWR.n170 VPWR.n1424 0.175933
R3674 VPWR.n419 VPWR.n179 0.1805
R3675 VPWR.n182 VPWR.n181 0.177225
R3676 VPWR.n396 VPWR.n385 0.17716
R3677 VPWR.n412 VPWR.n387 0.176372
R3678 VPWR.n414 VPWR.n389 0.175122
R3679 VPWR.n429 VPWR.n428 0.168002
R3680 VPWR.n1347 VPWR.n440 0.156078
R3681 VPWR.n438 VPWR.n491 0.147775
R3682 VPWR.n499 VPWR.n498 0.129575
R3683 VPWR.n500 VPWR.n499 0.129236
R3684 VPWR.n116 VPWR.n135 0.108548
R3685 VPWR.n304 VPWR.n209 0.151153
R3686 VPWR.n217 VPWR.n140 0.151137
R3687 VPWR.n115 VPWR.n114 0.151137
R3688 VPWR.n151 VPWR.n150 0.151121
R3689 VPWR.n774 VPWR.n149 0.151121
R3690 VPWR.n207 VPWR.n206 0.1505
R3691 VPWR.n212 VPWR.n103 0.1505
R3692 VPWR.n213 VPWR.n101 0.1505
R3693 VPWR.n161 VPWR.n160 0.149264
R3694 VPWR.n118 VPWR.n117 0.149264
R3695 VPWR.n195 VPWR.n193 0.144693
R3696 VPWR.n196 VPWR.n195 0.144354
R3697 VPWR.n203 VPWR.n200 0.14384
R3698 VPWR.n201 VPWR.n198 0.14384
R3699 VPWR.n204 VPWR.n203 0.142675
R3700 VPWR.n202 VPWR.n201 0.142675
R3701 VPWR.n405 VPWR.n402 0.131372
R3702 VPWR.n84 VPWR.n404 0.128872
R3703 VPWR.n255 VPWR.n254 0.128872
R3704 VPWR.n415 VPWR.n403 0.128872
R3705 VPWR.n417 VPWR.n416 0.127039
R3706 VPWR.n397 VPWR.n298 0.12675
R3707 VPWR.n227 VPWR.n226 0.108665
R3708 VPWR.n415 VPWR.n260 0.140025
R3709 VPWR.n256 VPWR.n255 0.140025
R3710 VPWR.n404 VPWR.n249 0.140025
R3711 VPWR.n405 VPWR.n239 0.140025
R3712 VPWR.n1269 VPWR.n158 0.123478
R3713 VPWR.n1187 VPWR.n337 0.139236
R3714 VPWR.n1094 VPWR.n335 0.139236
R3715 VPWR.n733 VPWR.n333 0.139236
R3716 VPWR.n245 VPWR.n244 0.139236
R3717 VPWR.n143 VPWR.n1076 0.122689
R3718 VPWR.n175 VPWR.n174 0.138
R3719 VPWR.n230 VPWR.n229 0.13175
R3720 VPWR.n178 VPWR.n106 0.13175
R3721 VPWR.n173 VPWR.n126 0.13175
R3722 VPWR.n360 VPWR.n147 0.131444
R3723 VPWR.n125 VPWR.n124 0.1305
R3724 VPWR.n1487 VPWR.n112 0.1305
R3725 VPWR.n234 VPWR.n233 0.127039
R3726 VPWR.n167 VPWR.n166 0.12675
R3727 VPWR.n164 VPWR.n163 0.12675
R3728 VPWR.n1582 VPWR.n265 0.125625
R3729 VPWR.n134 VPWR.n119 0.12361
R3730 VPWR.n1265 VPWR.n400 0.0751415
R3731 VPWR.n433 VPWR.n432 0.12175
R3732 VPWR.n318 VPWR.n207 0.121153
R3733 VPWR.n282 VPWR.n212 0.121153
R3734 VPWR.n280 VPWR.n213 0.121153
R3735 VPWR.n399 VPWR.n398 0.1205
R3736 VPWR.n358 VPWR.n357 0.1205
R3737 VPWR.n1359 VPWR.n321 0.1205
R3738 VPWR.n315 VPWR.n151 0.1205
R3739 VPWR.n312 VPWR.n311 0.1205
R3740 VPWR.n1393 VPWR.n307 0.1205
R3741 VPWR.n301 VPWR.n300 0.1205
R3742 VPWR.n296 VPWR.n295 0.1205
R3743 VPWR.n149 VPWR.n148 0.1205
R3744 VPWR.n1489 VPWR.n292 0.1205
R3745 VPWR.n284 VPWR.n230 0.1205
R3746 VPWR.n157 VPWR.n156 0.1205
R3747 VPWR.n161 VPWR.n159 0.1205
R3748 VPWR.n205 VPWR.n191 0.1205
R3749 VPWR.n142 VPWR.n141 0.1205
R3750 VPWR.n137 VPWR.n136 0.1205
R3751 VPWR.n118 VPWR.n116 0.1205
R3752 VPWR.n210 VPWR.n111 0.1205
R3753 VPWR.n211 VPWR.n108 0.1205
R3754 VPWR.n1509 VPWR.n299 0.097039
R3755 VPWR.n605 VPWR.n327 0.082039
R3756 VPWR.n1278 VPWR.n368 0.082039
R3757 VPWR.n343 VPWR.n189 0.116444
R3758 VPWR.n347 VPWR.n188 0.116444
R3759 VPWR.n348 VPWR.n186 0.116444
R3760 VPWR.n359 VPWR.n184 0.116444
R3761 VPWR.n365 VPWR.n183 0.116444
R3762 VPWR.n382 VPWR.n381 0.1155
R3763 VPWR.n983 VPWR.n131 0.1155
R3764 VPWR.n1350 VPWR.n228 0.114539
R3765 VPWR.n1241 VPWR.n263 0.11425
R3766 VPWR.n493 VPWR.n492 0.113
R3767 VPWR.n236 VPWR.n235 0.112039
R3768 VPWR.n1335 VPWR.n279 0.111533
R3769 VPWR.n277 VPWR.n276 0.111533
R3770 VPWR.n275 VPWR.n274 0.111533
R3771 VPWR.n273 VPWR.n272 0.111533
R3772 VPWR.n252 VPWR.n271 0.111533
R3773 VPWR.n250 VPWR.n269 0.111533
R3774 VPWR.n246 VPWR.n267 0.111533
R3775 VPWR.n456 VPWR.n355 0.1105
R3776 VPWR.n346 VPWR.n345 0.1105
R3777 VPWR.n1381 VPWR.n324 0.1105
R3778 VPWR.n1415 VPWR.n310 0.1105
R3779 VPWR.n374 VPWR.n373 0.108
R3780 VPWR.n370 VPWR.n369 0.108
R3781 VPWR.n1070 VPWR.n363 0.108
R3782 VPWR.n1066 VPWR.n362 0.108
R3783 VPWR.n122 VPWR.n121 0.106475
R3784 VPWR.n339 VPWR.n50 0.1055
R3785 VPWR.n547 VPWR.n546 0.104587
R3786 VPWR.n540 VPWR.n539 0.104587
R3787 VPWR.n531 VPWR.n530 0.104587
R3788 VPWR.n510 VPWR.n509 0.104587
R3789 VPWR.n507 VPWR.n506 0.104587
R3790 VPWR.n504 VPWR.n503 0.104587
R3791 VPWR.n567 VPWR.n566 0.104252
R3792 VPWR.n564 VPWR.n563 0.104252
R3793 VPWR.n562 VPWR.n561 0.104252
R3794 VPWR.n557 VPWR.n556 0.104252
R3795 VPWR.n550 VPWR.n549 0.104252
R3796 VPWR.n537 VPWR.n536 0.104252
R3797 VPWR.n523 VPWR.n522 0.104252
R3798 VPWR.n520 VPWR.n519 0.104252
R3799 VPWR.n353 VPWR.n192 0.103944
R3800 VPWR.n1229 VPWR.n560 0.103
R3801 VPWR.n526 VPWR.n525 0.103
R3802 VPWR.n1578 VPWR.n518 0.103
R3803 VPWR.n407 VPWR.n406 0.103
R3804 VPWR.n243 VPWR.n242 0.099539
R3805 VPWR.n1592 VPWR.n226 0.0993764
R3806 VPWR.n383 VPWR.n425 0.0986657
R3807 VPWR.n554 VPWR.n553 0.098
R3808 VPWR.n544 VPWR.n543 0.098
R3809 VPWR.n514 VPWR.n513 0.098
R3810 VPWR.n262 VPWR.n261 0.097039
R3811 VPWR.n259 VPWR.n81 0.216144
R3812 VPWR.n258 VPWR.n257 0.097039
R3813 VPWR.n83 VPWR.n253 0.216144
R3814 VPWR.n248 VPWR.n251 0.097039
R3815 VPWR.n86 VPWR.n247 0.216144
R3816 VPWR.n238 VPWR.n237 0.097039
R3817 VPWR.n1384 VPWR.n375 0.0955
R3818 VPWR.n1668 VPWR.n288 0.0952016
R3819 VPWR.n931 VPWR.n351 0.093
R3820 VPWR.n924 VPWR.n350 0.093
R3821 VPWR.n1143 VPWR.n133 0.093
R3822 VPWR.n1390 VPWR.n330 0.0919607
R3823 VPWR.n342 VPWR.n341 0.0905
R3824 VPWR.n1424 VPWR.n99 0.0870168
R3825 VPWR.t329 VPWR.n1537 0.0255
R3826 VPWR.n1086 VPWR.n1085 0.0255
R3827 VPWR.n653 VPWR.n651 0.02425
R3828 VPWR.n1652 VPWR.n1650 0.02425
R3829 VPWR.n744 VPWR.n734 0.02425
R3830 VPWR.n1586 VPWR.n1585 0.02425
R3831 VPWR.n1558 VPWR.n1557 0.02425
R3832 VPWR.n793 VPWR.n792 0.02425
R3833 VPWR.n816 VPWR.n815 0.02425
R3834 VPWR.n1521 VPWR.n1504 0.02425
R3835 VPWR.n1524 VPWR.n1504 0.02425
R3836 VPWR.n923 VPWR.n922 0.02425
R3837 VPWR.n934 VPWR.n891 0.02425
R3838 VPWR.n353 VPWR.n954 0.0801936
R3839 VPWR.n956 VPWR.n890 0.02425
R3840 VPWR.n985 VPWR.n983 0.02425
R3841 VPWR.n1138 VPWR.n418 0.0814354
R3842 VPWR.n1147 VPWR.n356 0.0801936
R3843 VPWR.n1148 VPWR.n1146 0.02425
R3844 VPWR.n1161 VPWR.n1095 0.02425
R3845 VPWR.n1420 VPWR.n1419 0.02425
R3846 VPWR.n634 VPWR.n1050 0.0861926
R3847 VPWR.n535 VPWR.n534 0.0855
R3848 VPWR.n703 VPWR.n379 0.0855
R3849 VPWR.n220 VPWR.n219 0.0855
R3850 VPWR.n1443 VPWR.n130 0.0855
R3851 VPWR.n737 VPWR.n104 0.0855
R3852 VPWR.n287 VPWR.n211 0.0852016
R3853 VPWR.n288 VPWR.n210 0.0852016
R3854 VPWR.n320 VPWR.n205 0.0852016
R3855 VPWR.n502 VPWR.n501 0.084539
R3856 VPWR.n497 VPWR.n496 0.084539
R3857 VPWR.n401 VPWR.n241 0.084539
R3858 VPWR.n1065 VPWR.n1064 0.02425
R3859 VPWR.n1074 VPWR.n1035 0.02425
R3860 VPWR.n1083 VPWR.n1082 0.02425
R3861 VPWR.n1210 VPWR.n1188 0.02425
R3862 VPWR.n1280 VPWR.n1279 0.02425
R3863 VPWR.n1365 VPWR.n1344 0.02425
R3864 VPWR.n1371 VPWR.n1369 0.02425
R3865 VPWR.n1337 VPWR.n1336 0.02425
R3866 VPWR.n702 VPWR.n701 0.02425
R3867 VPWR.n681 VPWR.n680 0.02425
R3868 VPWR.n1596 VPWR.n1595 0.0239831
R3869 VPWR.n688 VPWR.n687 0.0239831
R3870 VPWR.t233 VPWR.n95 5.05031
R3871 VPWR.t16 VPWR.n6 1.37275
R3872 VPWR.t16 VPWR.n4 0.955482
R3873 VPWR.n10 VPWR.n9 1.09006
R3874 VPWR.n12 VPWR.n11 1.08704
R3875 VPWR.n14 VPWR.n13 0.358883
R3876 VPWR.n19 VPWR.n395 1.07828
R3877 VPWR.n16 VPWR.n106 1.07689
R3878 VPWR.n4 VPWR.n136 1.06596
R3879 VPWR.n5 VPWR.n24 1.03786
R3880 VPWR.n2 VPWR.n1 0.0991128
R3881 VPWR.n129 VPWR.n18 1.01756
R3882 VGND.n857 VGND.n856 7406.23
R3883 VGND.t881 VGND.n853 6725.96
R3884 VGND.n856 VGND.n855 6300
R3885 VGND.n855 VGND.n854 6300
R3886 VGND.n854 VGND.t380 6300
R3887 VGND.t380 VGND.t881 6300
R3888 VGND.t540 VGND.n839 423.471
R3889 VGND.n97 VGND.t721 423.469
R3890 VGND.t428 VGND.n774 422.846
R3891 VGND.n129 VGND.t198 16.0236
R3892 VGND.t722 VGND.n88 419.209
R3893 VGND.n82 VGND.n122 0.613875
R3894 VGND.t592 VGND.n75 22.9131
R3895 VGND.t194 VGND.n91 419.185
R3896 VGND.n81 VGND.t1762 419.185
R3897 VGND.t145 VGND.n92 419.183
R3898 VGND.n102 VGND.t558 419.183
R3899 VGND.n105 VGND.t501 419.183
R3900 VGND.t44 VGND.n84 419.183
R3901 VGND.n80 VGND.t126 419.183
R3902 VGND.n810 VGND.t344 419.183
R3903 VGND.n21 VGND.t1279 418.56
R3904 VGND.n71 VGND.t4 418.56
R3905 VGND.n856 VGND.n412 411.43
R3906 VGND.n132 VGND.t2109 242.846
R3907 VGND.n855 VGND.n173 411.43
R3908 VGND.n854 VGND.n134 411.43
R3909 VGND.n838 VGND.t536 409.99
R3910 VGND.t808 VGND.n768 409.99
R3911 VGND.t1448 VGND.n404 407.144
R3912 VGND.n14 VGND.t1165 22.5536
R3913 VGND.t1468 VGND.n10 22.5536
R3914 VGND.n113 VGND.t1580 0.634044
R3915 VGND.t1580 VGND.n125 0.634044
R3916 VGND.t993 VGND.n9 22.5536
R3917 VGND.t863 VGND.n7 22.5538
R3918 VGND.n412 VGND.t197 402.858
R3919 VGND.t325 VGND.n389 402.858
R3920 VGND.n443 VGND.t1261 402.858
R3921 VGND.t307 VGND.n363 402.858
R3922 VGND.n40 VGND.t198 0.613851
R3923 VGND.t843 VGND.n1042 402.858
R3924 VGND.t256 VGND.n173 402.858
R3925 VGND.n130 VGND.t216 418.56
R3926 VGND.n277 VGND.t810 402.858
R3927 VGND.t772 VGND.n134 402.858
R3928 VGND.n704 VGND.t1062 402.858
R3929 VGND.n749 VGND.t468 402.858
R3930 VGND.n13 VGND.t1228 29.7249
R3931 VGND.t199 VGND.n411 394.286
R3932 VGND.n419 VGND.t235 394.286
R3933 VGND.t1262 VGND.n380 394.286
R3934 VGND.t2362 VGND.n954 394.286
R3935 VGND.n956 VGND.t636 394.286
R3936 VGND.t309 VGND.n980 394.286
R3937 VGND.t87 VGND.n359 394.286
R3938 VGND.n1024 VGND.t1433 394.286
R3939 VGND.n1044 VGND.t844 394.286
R3940 VGND.n174 VGND.t258 394.286
R3941 VGND.n278 VGND.t218 394.286
R3942 VGND.n288 VGND.t23 394.286
R3943 VGND.n312 VGND.t724 394.286
R3944 VGND.t559 VGND.n235 394.286
R3945 VGND.n335 VGND.t453 394.286
R3946 VGND.t502 VGND.n206 394.286
R3947 VGND.n1071 VGND.t46 394.286
R3948 VGND.t775 VGND.n687 394.286
R3949 VGND.n695 VGND.t594 394.286
R3950 VGND.t415 VGND.n673 394.286
R3951 VGND.t1063 VGND.n668 394.286
R3952 VGND.t631 VGND.n828 394.286
R3953 VGND.t1101 VGND.n824 394.286
R3954 VGND.t346 VGND.n808 394.286
R3955 VGND.t398 VGND.n765 394.286
R3956 VGND.t469 VGND.n747 394.286
R3957 VGND.n853 VGND.t902 388.43
R3958 VGND.t1229 VGND.n554 388.43
R3959 VGND.n559 VGND.t1222 388.43
R3960 VGND.t1313 VGND.t327 385.714
R3961 VGND.t6 VGND.t2198 385.714
R3962 VGND.t904 VGND.n500 380.166
R3963 VGND.t1167 VGND.n509 380.166
R3964 VGND.n602 VGND.t865 380.166
R3965 VGND.n595 VGND.t1581 380.166
R3966 VGND.t1542 VGND.n528 380.166
R3967 VGND.n582 VGND.t1068 380.166
R3968 VGND.n575 VGND.t995 380.166
R3969 VGND.n568 VGND.t1470 380.166
R3970 VGND.t1223 VGND.n558 380.166
R3971 VGND.t212 VGND.n139 74.4158
R3972 VGND.n434 VGND.t1294 377.144
R3973 VGND.t1328 VGND.n381 377.144
R3974 VGND.t2347 VGND.n941 377.144
R3975 VGND.n979 VGND.t1402 377.144
R3976 VGND.n1005 VGND.t1465 377.144
R3977 VGND.t670 VGND.n1041 377.144
R3978 VGND.n119 VGND.t272 74.4159
R3979 VGND.n285 VGND.t825 377.144
R3980 VGND.n299 VGND.t178 377.144
R3981 VGND.t179 VGND.n254 377.144
R3982 VGND.t161 VGND.n247 377.144
R3983 VGND.t740 VGND.n237 377.144
R3984 VGND.t379 VGND.n217 377.144
R3985 VGND.n343 VGND.t452 377.144
R3986 VGND.n1069 VGND.t516 377.144
R3987 VGND.n124 VGND.t789 42.9373
R3988 VGND.t608 VGND.n123 42.9373
R3989 VGND.t417 VGND.n672 377.144
R3990 VGND.t1061 VGND.n670 377.144
R3991 VGND.n714 VGND.t2229 377.144
R3992 VGND.n715 VGND.t1731 377.144
R3993 VGND.n722 VGND.t143 377.144
R3994 VGND.n831 VGND.t629 377.144
R3995 VGND.n811 VGND.t1115 377.144
R3996 VGND.n795 VGND.t361 377.144
R3997 VGND.t541 VGND.n111 42.9388
R3998 VGND.n778 VGND.t952 377.144
R3999 VGND.n752 VGND.t412 377.144
R4000 VGND.n731 VGND.t2177 377.144
R4001 VGND.n49 VGND.t1200 64.291
R4002 VGND.n413 VGND.t200 368.572
R4003 VGND.n420 VGND.t236 368.572
R4004 VGND.t328 VGND.n388 368.572
R4005 VGND.t2360 VGND.n953 368.572
R4006 VGND.n958 VGND.t638 368.572
R4007 VGND.n981 VGND.t311 368.572
R4008 VGND.t88 VGND.n347 368.572
R4009 VGND.n1025 VGND.t1434 368.572
R4010 VGND.t2328 VGND.n1007 368.572
R4011 VGND.t260 VGND.n172 368.572
R4012 VGND.t219 VGND.n275 368.572
R4013 VGND.t24 VGND.n266 368.572
R4014 VGND.t725 VGND.n243 368.572
R4015 VGND.n320 VGND.t560 368.572
R4016 VGND.n1063 VGND.t503 368.572
R4017 VGND.t47 VGND.n197 368.572
R4018 VGND.n1086 VGND.t77 368.572
R4019 VGND.n688 VGND.t776 368.572
R4020 VGND.t595 VGND.n679 368.572
R4021 VGND.n706 VGND.t1064 368.572
R4022 VGND.n707 VGND.t7 368.572
R4023 VGND.t632 VGND.n827 368.572
R4024 VGND.t1102 VGND.n823 368.572
R4025 VGND.t347 VGND.n807 368.572
R4026 VGND.t399 VGND.n764 368.572
R4027 VGND.n773 VGND.t805 367.755
R4028 VGND.n78 VGND.t418 367.132
R4029 VGND.t539 VGND.n834 367.132
R4030 VGND.n114 VGND.t920 41.7631
R4031 VGND.t1181 VGND.n66 72.2278
R4032 VGND.n58 VGND.t879 72.2278
R4033 VGND.t1595 VGND.n59 41.7623
R4034 VGND.t1556 VGND.n64 72.2278
R4035 VGND.n62 VGND.t1081 72.2278
R4036 VGND.t1009 VGND.n117 41.7623
R4037 VGND.n118 VGND.t1483 72.2278
R4038 VGND.n561 VGND.t1230 363.637
R4039 VGND.t1221 VGND.n557 363.637
R4040 VGND.t42 VGND.t250 360
R4041 VGND.t1383 VGND.t2346 360
R4042 VGND.t1695 VGND.n360 360
R4043 VGND.n287 VGND.t251 360
R4044 VGND.n309 VGND.t253 360
R4045 VGND.t454 VGND.t435 360
R4046 VGND.t537 VGND.t431 360
R4047 VGND.t538 VGND.t433 360
R4048 VGND.t470 VGND.t2162 360
R4049 VGND.t1796 VGND.n115 80.9157
R4050 VGND.n65 VGND.t1277 45.2807
R4051 VGND.n852 VGND.t906 355.373
R4052 VGND.n608 VGND.t1168 355.373
R4053 VGND.t867 VGND.n516 355.373
R4054 VGND.t1582 VGND.n522 355.373
R4055 VGND.n588 VGND.t1543 355.373
R4056 VGND.t1069 VGND.n535 355.373
R4057 VGND.t996 VGND.n541 355.373
R4058 VGND.t1471 VGND.n547 355.373
R4059 VGND.n48 VGND.t1224 358.313
R4060 VGND.t1231 VGND.n12 354.502
R4061 VGND.t212 VGND.n405 351.43
R4062 VGND.t249 VGND.n398 351.43
R4063 VGND.n442 VGND.t1327 351.43
R4064 VGND.t2345 VGND.n364 351.43
R4065 VGND.n942 VGND.t2348 351.43
R4066 VGND.t1401 VGND.n978 351.43
R4067 VGND.t1464 VGND.n362 351.43
R4068 VGND.n356 VGND.t102 351.43
R4069 VGND.t669 VGND.n1040 351.43
R4070 VGND.n180 VGND.t272 351.43
R4071 VGND.t824 VGND.n269 351.43
R4072 VGND.t177 VGND.n256 351.43
R4073 VGND.n301 VGND.t180 351.43
R4074 VGND.n307 VGND.t160 351.43
R4075 VGND.n318 VGND.t739 351.43
R4076 VGND.n218 VGND.t378 351.43
R4077 VGND.t451 VGND.n208 351.43
R4078 VGND.t515 VGND.n200 351.43
R4079 VGND.t788 VGND.n681 351.43
R4080 VGND.n701 VGND.t607 351.43
R4081 VGND.t2228 VGND.n660 351.43
R4082 VGND.t1748 VGND.n657 351.43
R4083 VGND.t142 VGND.n651 351.43
R4084 VGND.n832 VGND.t628 351.43
R4085 VGND.n812 VGND.t1114 351.43
R4086 VGND.n796 VGND.t360 351.43
R4087 VGND.t121 VGND.t806 351.43
R4088 VGND.t1378 VGND.t807 351.43
R4089 VGND.n753 VGND.t411 351.43
R4090 VGND.n732 VGND.t2176 351.43
R4091 VGND.t80 VGND.n94 349.99
R4092 VGND.t123 VGND.n90 349.99
R4093 VGND.t1065 VGND.n71 349.99
R4094 VGND.n135 VGND.t1200 350.048
R4095 VGND.t201 VGND.n410 342.858
R4096 VGND.n436 VGND.t329 342.858
R4097 VGND.t1264 VGND.n379 342.858
R4098 VGND.t2359 VGND.n952 342.858
R4099 VGND.n959 VGND.t639 342.858
R4100 VGND.n983 VGND.t312 342.858
R4101 VGND.n348 VGND.t89 342.858
R4102 VGND.n1045 VGND.t847 342.858
R4103 VGND.n1058 VGND.t2327 342.858
R4104 VGND.n175 VGND.t261 342.858
R4105 VGND.n279 VGND.t220 342.858
R4106 VGND.n313 VGND.t726 342.858
R4107 VGND.n336 VGND.t455 342.858
R4108 VGND.t504 VGND.n205 342.858
R4109 VGND.t76 VGND.n182 342.858
R4110 VGND.t777 VGND.n686 342.858
R4111 VGND.n696 VGND.t596 342.858
R4112 VGND.t8 VGND.n666 342.858
R4113 VGND.t1103 VGND.n822 342.858
R4114 VGND.t348 VGND.n806 342.858
R4115 VGND.t542 VGND.t937 342.858
R4116 VGND.t557 VGND.t951 342.858
R4117 VGND.t471 VGND.n745 342.858
R4118 VGND.t919 VGND.n508 338.844
R4119 VGND.t1181 VGND.n515 338.844
R4120 VGND.n596 VGND.t879 338.844
R4121 VGND.n589 VGND.t1594 338.844
R4122 VGND.t1556 VGND.n534 338.844
R4123 VGND.n576 VGND.t1081 338.844
R4124 VGND.n569 VGND.t1008 338.844
R4125 VGND.n562 VGND.t1483 338.844
R4126 VGND.n560 VGND.t1220 338.844
R4127 VGND.t1384 VGND.n135 58.5755
R4128 VGND.n48 VGND.t1580 13.3882
R4129 VGND.n132 VGND.t589 349.99
R4130 VGND.t654 VGND.t1435 334.286
R4131 VGND.t809 VGND.n769 334.286
R4132 VGND.t907 VGND.n503 330.579
R4133 VGND.t1169 VGND.n510 330.579
R4134 VGND.n601 VGND.t868 330.579
R4135 VGND.n594 VGND.t1583 330.579
R4136 VGND.t1544 VGND.n529 330.579
R4137 VGND.n581 VGND.t1070 330.579
R4138 VGND.n574 VGND.t997 330.579
R4139 VGND.n567 VGND.t1472 330.579
R4140 VGND.n128 VGND.t198 1.55712
R4141 VGND.n108 VGND.t2197 328.841
R4142 VGND.t0 VGND.n73 328.841
R4143 VGND.n418 VGND.t211 325.714
R4144 VGND.n425 VGND.t248 325.714
R4145 VGND.n433 VGND.t1292 325.714
R4146 VGND.t1326 VGND.n382 325.714
R4147 VGND.n458 VGND.t2344 325.714
R4148 VGND.n943 VGND.t2349 325.714
R4149 VGND.n357 VGND.t100 325.714
R4150 VGND.t668 VGND.n1039 325.714
R4151 VGND.t271 VGND.n167 325.714
R4152 VGND.n284 VGND.t823 325.714
R4153 VGND.t181 VGND.n253 325.714
R4154 VGND.t159 VGND.n248 325.714
R4155 VGND.t737 VGND.n238 325.714
R4156 VGND.n334 VGND.t377 325.714
R4157 VGND.n342 VGND.t449 325.714
R4158 VGND.n1068 VGND.t514 325.714
R4159 VGND.n693 VGND.t787 325.714
R4160 VGND.t606 VGND.n674 325.714
R4161 VGND.n713 VGND.t2227 325.714
R4162 VGND.n716 VGND.t1749 325.714
R4163 VGND.n721 VGND.t141 325.714
R4164 VGND.n813 VGND.t1113 325.714
R4165 VGND.n797 VGND.t359 325.714
R4166 VGND.t543 VGND.n792 325.714
R4167 VGND.n780 VGND.t950 325.714
R4168 VGND.n733 VGND.t2175 325.714
R4169 VGND.n115 VGND.t1580 1.56831
R4170 VGND.t1795 VGND.n65 80.9165
R4171 VGND.n414 VGND.t202 317.144
R4172 VGND.t330 VGND.n387 317.144
R4173 VGND.n445 VGND.t1265 317.144
R4174 VGND.t1248 VGND.n372 317.144
R4175 VGND.t2358 VGND.n951 317.144
R4176 VGND.n960 VGND.t640 317.144
R4177 VGND.n996 VGND.t1453 317.144
R4178 VGND.n1027 VGND.t1436 317.144
R4179 VGND.t848 VGND.n1022 317.144
R4180 VGND.t2326 VGND.n1008 317.144
R4181 VGND.t262 VGND.n171 317.144
R4182 VGND.t222 VGND.n274 317.144
R4183 VGND.t26 VGND.n265 317.144
R4184 VGND.t727 VGND.n242 317.144
R4185 VGND.n321 VGND.t562 317.144
R4186 VGND.t456 VGND.n215 317.144
R4187 VGND.n1064 VGND.t505 317.144
R4188 VGND.t53 VGND.n196 317.144
R4189 VGND.n689 VGND.t778 317.144
R4190 VGND.t597 VGND.n678 317.144
R4191 VGND.n708 VGND.t9 317.144
R4192 VGND.t1104 VGND.n821 317.144
R4193 VGND.t349 VGND.n805 317.144
R4194 VGND.t401 VGND.n762 317.144
R4195 VGND.t473 VGND.n744 317.144
R4196 VGND.n78 VGND.t1058 315.704
R4197 VGND.n834 VGND.t626 315.704
R4198 VGND.n847 VGND.t918 314.05
R4199 VGND.n603 VGND.t1180 314.05
R4200 VGND.t878 VGND.n521 314.05
R4201 VGND.t1593 VGND.n527 314.05
R4202 VGND.n583 VGND.t1555 314.05
R4203 VGND.t1080 VGND.n540 314.05
R4204 VGND.t1007 VGND.n546 314.05
R4205 VGND.t1482 VGND.n553 314.05
R4206 VGND.t1219 VGND.n556 314.05
R4207 VGND.t1501 VGND.t313 312.858
R4208 VGND.t1385 VGND.t90 312.858
R4209 VGND.t1280 VGND.t1233 308.572
R4210 VGND.t1234 VGND.t1281 308.572
R4211 VGND.t1282 VGND.t1235 308.572
R4212 VGND.t1237 VGND.t1283 308.572
R4213 VGND.t1274 VGND.t1244 308.572
R4214 VGND.t1246 VGND.t1275 308.572
R4215 VGND.t1276 VGND.t1247 308.572
R4216 VGND.t322 VGND.t1450 308.572
R4217 VGND.t323 VGND.t1451 308.572
R4218 VGND.t324 VGND.t1452 308.572
R4219 VGND.t1059 VGND.t1198 308.572
R4220 VGND.t1199 VGND.t1060 308.572
R4221 VGND.n851 VGND.t908 305.786
R4222 VGND.n607 VGND.t1170 305.786
R4223 VGND.t869 VGND.n517 305.786
R4224 VGND.t1584 VGND.n523 305.786
R4225 VGND.n587 VGND.t1545 305.786
R4226 VGND.t1071 VGND.n536 305.786
R4227 VGND.t998 VGND.n542 305.786
R4228 VGND.t1473 VGND.n548 305.786
R4229 VGND.n12 VGND.t1218 304.916
R4230 VGND.t210 VGND.n406 300
R4231 VGND.t237 VGND.t583 300
R4232 VGND.t584 VGND.t238 300
R4233 VGND.t247 VGND.n399 300
R4234 VGND.t1232 VGND.n397 300
R4235 VGND.t1291 VGND.n391 300
R4236 VGND.n441 VGND.t1325 300
R4237 VGND.n448 VGND.t1273 300
R4238 VGND.t2343 VGND.n365 300
R4239 VGND.t1399 VGND.n976 300
R4240 VGND.t321 VGND.n991 300
R4241 VGND.t1462 VGND.n1003 300
R4242 VGND.n358 VGND.t99 300
R4243 VGND.t667 VGND.n1038 300
R4244 VGND.n179 VGND.t270 300
R4245 VGND.t822 VGND.n270 300
R4246 VGND.t175 VGND.n257 300
R4247 VGND.n302 VGND.t182 300
R4248 VGND.n306 VGND.t158 300
R4249 VGND.n317 VGND.t736 300
R4250 VGND.t376 VGND.n219 300
R4251 VGND.t448 VGND.n209 300
R4252 VGND.t513 VGND.n201 300
R4253 VGND.t786 VGND.n682 300
R4254 VGND.n700 VGND.t605 300
R4255 VGND.t2226 VGND.n661 300
R4256 VGND.t1750 VGND.n656 300
R4257 VGND.t140 VGND.n652 300
R4258 VGND.n814 VGND.t1112 300
R4259 VGND.n798 VGND.t358 300
R4260 VGND.t544 VGND.n791 300
R4261 VGND.n781 VGND.t949 300
R4262 VGND.n755 VGND.t409 300
R4263 VGND.n734 VGND.t2174 300
R4264 VGND.t203 VGND.n409 291.43
R4265 VGND.t239 VGND.n402 291.43
R4266 VGND.t1284 VGND.n394 291.43
R4267 VGND.n437 VGND.t331 291.43
R4268 VGND.n451 VGND.t1249 291.43
R4269 VGND.n985 VGND.t314 291.43
R4270 VGND.n997 VGND.t1454 291.43
R4271 VGND.n350 VGND.t91 291.43
R4272 VGND.n1028 VGND.t1437 291.43
R4273 VGND.t849 VGND.n1021 291.43
R4274 VGND.n176 VGND.t263 291.43
R4275 VGND.n280 VGND.t223 291.43
R4276 VGND.n290 VGND.t27 291.43
R4277 VGND.n314 VGND.t728 291.43
R4278 VGND.t563 VGND.n233 291.43
R4279 VGND.t367 VGND.n222 291.43
R4280 VGND.n337 VGND.t457 291.43
R4281 VGND.t506 VGND.n204 291.43
R4282 VGND.n1073 VGND.t54 291.43
R4283 VGND.t490 VGND.n190 291.43
R4284 VGND.t74 VGND.n183 291.43
R4285 VGND.t779 VGND.n685 291.43
R4286 VGND.n697 VGND.t598 291.43
R4287 VGND.t10 VGND.n665 291.43
R4288 VGND.t1105 VGND.n820 291.43
R4289 VGND.t350 VGND.n804 291.43
R4290 VGND.t402 VGND.n761 291.43
R4291 VGND.t474 VGND.n743 291.43
R4292 VGND.t917 VGND.n507 289.257
R4293 VGND.t1179 VGND.n514 289.257
R4294 VGND.n597 VGND.t877 289.257
R4295 VGND.n590 VGND.t1592 289.257
R4296 VGND.t1554 VGND.n533 289.257
R4297 VGND.n577 VGND.t1079 289.257
R4298 VGND.n570 VGND.t1006 289.257
R4299 VGND.n563 VGND.t1481 289.257
R4300 VGND.t705 VGND.t2160 8.19919
R4301 VGND.t363 VGND.t303 282.858
R4302 VGND.t304 VGND.t364 282.858
R4303 VGND.t365 VGND.t305 282.858
R4304 VGND.t306 VGND.t366 282.858
R4305 VGND.t486 VGND.t61 282.858
R4306 VGND.t62 VGND.t487 282.858
R4307 VGND.t488 VGND.t63 282.858
R4308 VGND.t64 VGND.t489 282.858
R4309 VGND.t909 VGND.n504 280.993
R4310 VGND.t1171 VGND.n511 280.993
R4311 VGND.n600 VGND.t870 280.993
R4312 VGND.n593 VGND.t1585 280.993
R4313 VGND.t1546 VGND.n530 280.993
R4314 VGND.n580 VGND.t1072 280.993
R4315 VGND.n573 VGND.t999 280.993
R4316 VGND.n566 VGND.t1474 280.993
R4317 VGND.n63 VGND.t652 18.9626
R4318 VGND.n35 VGND.t585 35.453
R4319 VGND.t705 VGND.n30 1.7155
R4320 VGND.n55 VGND.t705 1.8718
R4321 VGND.t2133 VGND.t705 72.4439
R4322 VGND.t705 VGND.n44 1.71557
R4323 VGND.t2150 VGND.t705 72.4619
R4324 VGND.n417 VGND.t209 274.286
R4325 VGND.n424 VGND.t246 274.286
R4326 VGND.n432 VGND.t1290 274.286
R4327 VGND.t1324 VGND.n383 274.286
R4328 VGND.t1272 VGND.n375 274.286
R4329 VGND.n457 VGND.t2342 274.286
R4330 VGND.n945 VGND.t2351 274.286
R4331 VGND.t1397 VGND.n975 274.286
R4332 VGND.t320 VGND.n990 274.286
R4333 VGND.n1002 VGND.t1461 274.286
R4334 VGND.t666 VGND.n1037 274.286
R4335 VGND.t838 VGND.n1015 274.286
R4336 VGND.t2319 VGND.n1012 274.286
R4337 VGND.t269 VGND.n168 274.286
R4338 VGND.n283 VGND.t821 274.286
R4339 VGND.n297 VGND.t174 274.286
R4340 VGND.t183 VGND.n252 274.286
R4341 VGND.t157 VGND.n249 274.286
R4342 VGND.t735 VGND.n239 274.286
R4343 VGND.t302 VGND.n225 274.286
R4344 VGND.n341 VGND.t446 274.286
R4345 VGND.n1067 VGND.t512 274.286
R4346 VGND.t60 VGND.n193 274.286
R4347 VGND.n692 VGND.t785 274.286
R4348 VGND.t604 VGND.n675 274.286
R4349 VGND.n712 VGND.t2225 274.286
R4350 VGND.n717 VGND.t1751 274.286
R4351 VGND.n720 VGND.t138 274.286
R4352 VGND.n815 VGND.t1111 274.286
R4353 VGND.n799 VGND.t357 274.286
R4354 VGND.t546 VGND.n790 274.286
R4355 VGND.n782 VGND.t948 274.286
R4356 VGND.n756 VGND.t408 274.286
R4357 VGND.n735 VGND.t2173 274.286
R4358 VGND.n0 VGND.t1403 18.9626
R4359 VGND.t1344 VGND.n4 18.9623
R4360 VGND.t1278 VGND.n5 18.9623
R4361 VGND.t1612 VGND.n3 18.9623
R4362 VGND.t83 VGND.n900 270.01
R4363 VGND.n415 VGND.t204 265.714
R4364 VGND.n422 VGND.t240 265.714
R4365 VGND.n430 VGND.t1285 265.714
R4366 VGND.t332 VGND.n386 265.714
R4367 VGND.n446 VGND.t1267 265.714
R4368 VGND.t2356 VGND.n949 265.714
R4369 VGND.n962 VGND.t642 265.714
R4370 VGND.n986 VGND.t315 265.714
R4371 VGND.n351 VGND.t92 265.714
R4372 VGND.n1029 VGND.t1438 265.714
R4373 VGND.t2315 VGND.t839 265.714
R4374 VGND.t840 VGND.t2316 265.714
R4375 VGND.t2317 VGND.t841 265.714
R4376 VGND.t842 VGND.t2318 265.714
R4377 VGND.t2324 VGND.n1010 265.714
R4378 VGND.t264 VGND.n170 265.714
R4379 VGND.t224 VGND.n273 265.714
R4380 VGND.t28 VGND.n264 265.714
R4381 VGND.t729 VGND.n241 265.714
R4382 VGND.t564 VGND.n232 265.714
R4383 VGND.n331 VGND.t368 265.714
R4384 VGND.t458 VGND.n213 265.714
R4385 VGND.n1065 VGND.t507 265.714
R4386 VGND.t55 VGND.n195 265.714
R4387 VGND.n1079 VGND.t491 265.714
R4388 VGND.n1084 VGND.t73 265.714
R4389 VGND.n690 VGND.t780 265.714
R4390 VGND.t599 VGND.n677 265.714
R4391 VGND.n709 VGND.t11 265.714
R4392 VGND.t1106 VGND.n819 265.714
R4393 VGND.t351 VGND.n803 265.714
R4394 VGND.t475 VGND.n742 265.714
R4395 VGND.t1577 VGND.n923 264.586
R4396 VGND.n848 VGND.t915 264.464
R4397 VGND.n604 VGND.t1177 264.464
R4398 VGND.t876 VGND.n520 264.464
R4399 VGND.t1591 VGND.n526 264.464
R4400 VGND.n584 VGND.t1552 264.464
R4401 VGND.t1078 VGND.n539 264.464
R4402 VGND.t1005 VGND.n545 264.464
R4403 VGND.t1480 VGND.n551 264.464
R4404 VGND.t1250 VGND.t2331 257.144
R4405 VGND.t826 VGND.t850 257.144
R4406 VGND.n850 VGND.t910 256.199
R4407 VGND.n606 VGND.t1172 256.199
R4408 VGND.t871 VGND.n518 256.199
R4409 VGND.t1586 VGND.n524 256.199
R4410 VGND.n586 VGND.t1547 256.199
R4411 VGND.t1073 VGND.n537 256.199
R4412 VGND.t1000 VGND.n543 256.199
R4413 VGND.t1475 VGND.n549 256.199
R4414 VGND.n857 VGND.t704 254.974
R4415 VGND.n887 VGND.t579 254.974
R4416 VGND.t1427 VGND.n897 254.974
R4417 VGND.n925 VGND.t1576 254.974
R4418 VGND.n919 VGND.t1801 254.974
R4419 VGND.t2063 VGND.n108 108.639
R4420 VGND.n109 VGND.t52 0.0153688
R4421 VGND.n73 VGND.t1996 108.639
R4422 VGND.t1999 VGND.n76 108.993
R4423 VGND.n72 VGND.t2017 252.065
R4424 VGND.n794 VGND.t2007 252.065
R4425 VGND.n47 VGND.t198 9.63482
R4426 VGND.t2100 VGND.t198 108.989
R4427 VGND.t2048 VGND.n96 252.041
R4428 VGND.t2055 VGND.n91 252.041
R4429 VGND.n90 VGND.t2078 251.417
R4430 VGND.n69 VGND.t2020 251.417
R4431 VGND.n68 VGND.t2001 251.417
R4432 VGND.n777 VGND.t2032 251.417
R4433 VGND.n768 VGND.t2035 251.417
R4434 VGND.t706 VGND.n498 249.548
R4435 VGND.n864 VGND.t1295 249.548
R4436 VGND.t1343 VGND.n476 249.548
R4437 VGND.n878 VGND.t1613 249.548
R4438 VGND.t580 VGND.n468 249.548
R4439 VGND.t1404 VGND.n467 249.548
R4440 VGND.n899 VGND.t1428 249.548
R4441 VGND.n902 VGND.t104 249.548
R4442 VGND.t671 VGND.n938 249.548
R4443 VGND.n35 VGND.t587 23.0278
R4444 VGND.t1802 VGND.n917 249.548
R4445 VGND.n18 VGND.t705 1.32541
R4446 VGND.t208 VGND.n407 248.571
R4447 VGND.t245 VGND.n400 248.571
R4448 VGND.t1289 VGND.n392 248.571
R4449 VGND.n440 VGND.t1323 248.571
R4450 VGND.n376 VGND.t1271 248.571
R4451 VGND.t2341 VGND.n366 248.571
R4452 VGND.n946 VGND.t2352 248.571
R4453 VGND.t319 VGND.n989 248.571
R4454 VGND.t97 VGND.n354 248.571
R4455 VGND.t665 VGND.n1036 248.571
R4456 VGND.n1051 VGND.t837 248.571
R4457 VGND.n1055 VGND.t2320 248.571
R4458 VGND.n178 VGND.t268 248.571
R4459 VGND.t820 VGND.n271 248.571
R4460 VGND.n303 VGND.t184 248.571
R4461 VGND.n305 VGND.t156 248.571
R4462 VGND.n316 VGND.t733 248.571
R4463 VGND.n327 VGND.t301 248.571
R4464 VGND.t373 VGND.n220 248.571
R4465 VGND.t445 VGND.n210 248.571
R4466 VGND.t511 VGND.n202 248.571
R4467 VGND.n1075 VGND.t59 248.571
R4468 VGND.t784 VGND.n683 248.571
R4469 VGND.n699 VGND.t603 248.571
R4470 VGND.t2224 VGND.n662 248.571
R4471 VGND.t1752 VGND.n655 248.571
R4472 VGND.t137 VGND.n653 248.571
R4473 VGND.n816 VGND.t1110 248.571
R4474 VGND.n800 VGND.t356 248.571
R4475 VGND.t547 VGND.n789 248.571
R4476 VGND.n783 VGND.t947 248.571
R4477 VGND.n736 VGND.t2172 248.571
R4478 VGND.t124 VGND.n55 26.866
R4479 VGND.t1377 VGND.n6 46.6976
R4480 VGND.n57 VGND.t2264 46.695
R4481 VGND.t1871 VGND.t1580 105.382
R4482 VGND.t1884 VGND.t1580 105.382
R4483 VGND.t1887 VGND.t1580 105.382
R4484 VGND.t1580 VGND.t1892 105.382
R4485 VGND.t1580 VGND.t1895 105.382
R4486 VGND.n137 VGND.n82 0.0148803
R4487 VGND.n112 VGND.t52 0.00915178
R4488 VGND.n110 VGND.t52 0.0148802
R4489 VGND.t2000 VGND.n72 243.494
R4490 VGND.t2008 VGND.n120 109.986
R4491 VGND.t198 VGND.n52 9.30746
R4492 VGND.t2058 VGND.n89 243.47
R4493 VGND.n80 VGND.t2002 243.47
R4494 VGND.t2049 VGND.n94 242.846
R4495 VGND.n79 VGND.t2021 242.846
R4496 VGND.t2033 VGND.n775 242.846
R4497 VGND.t205 VGND.n408 240
R4498 VGND.t241 VGND.n401 240
R4499 VGND.t1286 VGND.n393 240
R4500 VGND.n438 VGND.t333 240
R4501 VGND.t1268 VGND.n377 240
R4502 VGND.n452 VGND.t1251 240
R4503 VGND.t2355 VGND.n948 240
R4504 VGND.n963 VGND.t643 240
R4505 VGND.n972 VGND.t1393 240
R4506 VGND.n352 VGND.t93 240
R4507 VGND.n1030 VGND.t1439 240
R4508 VGND.t851 VGND.n1020 240
R4509 VGND.n1056 VGND.t2323 240
R4510 VGND.n177 VGND.t265 240
R4511 VGND.n281 VGND.t225 240
R4512 VGND.n291 VGND.t29 240
R4513 VGND.t170 VGND.n259 240
R4514 VGND.n315 VGND.t730 240
R4515 VGND.t369 VGND.n221 240
R4516 VGND.n338 VGND.t459 240
R4517 VGND.t508 VGND.n203 240
R4518 VGND.t492 VGND.n189 240
R4519 VGND.t72 VGND.n185 240
R4520 VGND.t781 VGND.n684 240
R4521 VGND.n698 VGND.t600 240
R4522 VGND.t12 VGND.n664 240
R4523 VGND.t1107 VGND.n818 240
R4524 VGND.t352 VGND.n802 240
R4525 VGND.t404 VGND.n759 240
R4526 VGND.t476 VGND.n741 240
R4527 VGND.t914 VGND.n506 239.669
R4528 VGND.t1176 VGND.n513 239.669
R4529 VGND.n598 VGND.t875 239.669
R4530 VGND.n591 VGND.t1590 239.669
R4531 VGND.t1551 VGND.n532 239.669
R4532 VGND.n578 VGND.t1077 239.669
R4533 VGND.n571 VGND.t1004 239.669
R4534 VGND.n564 VGND.t1479 239.669
R4535 VGND.t719 VGND.n138 51.8055
R4536 VGND.t1309 VGND.n54 30.6823
R4537 VGND.n31 VGND.t1312 30.6429
R4538 VGND.t1627 VGND.n53 30.6823
R4539 VGND.t578 VGND.n469 238.698
R4540 VGND.n41 VGND.t1421 30.6436
R4541 VGND.t1426 VGND.n896 238.698
R4542 VGND.t119 VGND.n60 30.6823
R4543 VGND.t686 VGND.n61 51.8057
R4544 VGND.n34 VGND.t1575 240.899
R4545 VGND.n920 VGND.t1800 238.698
R4546 VGND.t705 VGND.n34 13.8152
R4547 VGND.t2195 VGND.n126 55.6695
R4548 VGND.t533 VGND.n17 33.0859
R4549 VGND.n30 VGND.t535 33.1245
R4550 VGND.n39 VGND.t861 33.0852
R4551 VGND.n33 VGND.t1629 32.4767
R4552 VGND.t2178 VGND.n37 33.0852
R4553 VGND.t2094 VGND.n390 235.714
R4554 VGND.n47 VGND.t2126 242.431
R4555 VGND.t2105 VGND.n974 235.714
R4556 VGND.n1004 VGND.t2107 235.714
R4557 VGND.n1006 VGND.t2110 235.714
R4558 VGND.t2115 VGND.n346 235.714
R4559 VGND.t2129 VGND.n51 105.683
R4560 VGND.t2070 VGND.n267 235.714
R4561 VGND.t2072 VGND.n258 235.714
R4562 VGND.t2057 VGND.n245 235.714
R4563 VGND.t2081 VGND.n236 235.714
R4564 VGND.t2085 VGND.n207 235.714
R4565 VGND.n344 VGND.t2087 235.714
R4566 VGND.n1070 VGND.t2089 235.714
R4567 VGND.n1085 VGND.t2092 235.714
R4568 VGND.n833 VGND.t2024 235.714
R4569 VGND.n757 VGND.t2039 235.714
R4570 VGND.n730 VGND.t2042 235.714
R4571 VGND.t1898 VGND.t1580 106.338
R4572 VGND.t1880 VGND.t1580 106.338
R4573 VGND.t1580 VGND.t1875 106.337
R4574 VGND.t1883 VGND.t1580 106.338
R4575 VGND.n858 VGND.t707 233.274
R4576 VGND.t1296 VGND.n488 233.274
R4577 VGND.n877 VGND.t1342 233.274
R4578 VGND.t1614 VGND.n475 233.274
R4579 VGND.n888 VGND.t1405 233.274
R4580 VGND.n32 VGND.t1429 236.103
R4581 VGND.n903 VGND.t105 233.274
R4582 VGND.t673 VGND.n937 233.274
R4583 VGND.t646 VGND.t1387 231.429
R4584 VGND.t647 VGND.t1388 231.429
R4585 VGND.t648 VGND.t1389 231.429
R4586 VGND.t649 VGND.t1390 231.429
R4587 VGND.t650 VGND.t1391 231.429
R4588 VGND.t651 VGND.t1392 231.429
R4589 VGND.t1460 VGND.t422 231.429
R4590 VGND.t164 VGND.t32 231.429
R4591 VGND.t33 VGND.t165 231.429
R4592 VGND.t166 VGND.t34 231.429
R4593 VGND.t35 VGND.t167 231.429
R4594 VGND.t168 VGND.t36 231.429
R4595 VGND.t37 VGND.t169 231.429
R4596 VGND.t290 VGND.t565 231.429
R4597 VGND.t911 VGND.n505 231.405
R4598 VGND.t1173 VGND.n512 231.405
R4599 VGND.n599 VGND.t872 231.405
R4600 VGND.n592 VGND.t1587 231.405
R4601 VGND.t1548 VGND.n531 231.405
R4602 VGND.n579 VGND.t1074 231.405
R4603 VGND.n572 VGND.t1001 231.405
R4604 VGND.n565 VGND.t1476 231.405
R4605 VGND.n127 VGND.t860 230.678
R4606 VGND.t1377 VGND.n16 230.679
R4607 VGND.n42 VGND.t2264 230.679
R4608 VGND.n127 VGND.t705 13.1872
R4609 VGND.t1804 VGND.n36 37.8702
R4610 VGND.t705 VGND.n32 13.1865
R4611 VGND.t582 VGND.n38 37.8702
R4612 VGND.n16 VGND.t43 37.8701
R4613 VGND.n42 VGND.t705 13.1865
R4614 VGND.t2095 VGND.n389 227.143
R4615 VGND.t2097 VGND.n378 227.143
R4616 VGND.t2099 VGND.n52 234.188
R4617 VGND.n130 VGND.t2068 242.846
R4618 VGND.t2077 VGND.n246 227.143
R4619 VGND.n310 VGND.t2079 227.143
R4620 VGND.t2082 VGND.n234 227.143
R4621 VGND.n344 VGND.t2061 227.143
R4622 VGND.n1072 VGND.t2090 227.143
R4623 VGND.n702 VGND.t2018 227.143
R4624 VGND.n840 VGND.t2004 227.143
R4625 VGND.t2006 VGND.n121 235.006
R4626 VGND.t2038 VGND.n760 227.143
R4627 VGND.n416 VGND.t207 222.857
R4628 VGND.n423 VGND.t244 222.857
R4629 VGND.n431 VGND.t1288 222.857
R4630 VGND.t1322 VGND.n384 222.857
R4631 VGND.n447 VGND.t1270 222.857
R4632 VGND.n456 VGND.t2340 222.857
R4633 VGND.n947 VGND.t2353 222.857
R4634 VGND.t645 VGND.n964 222.857
R4635 VGND.t1395 VGND.n973 222.857
R4636 VGND.t318 VGND.n988 222.857
R4637 VGND.t1458 VGND.n1000 222.857
R4638 VGND.t95 VGND.n353 222.857
R4639 VGND.t664 VGND.n1035 222.857
R4640 VGND.t836 VGND.n1016 222.857
R4641 VGND.t2321 VGND.n1011 222.857
R4642 VGND.t267 VGND.n169 222.857
R4643 VGND.n282 VGND.t819 222.857
R4644 VGND.t31 VGND.n263 222.857
R4645 VGND.n296 VGND.t172 222.857
R4646 VGND.t185 VGND.n251 222.857
R4647 VGND.t155 VGND.n250 222.857
R4648 VGND.t732 VGND.n240 222.857
R4649 VGND.t300 VGND.n226 222.857
R4650 VGND.n332 VGND.t372 222.857
R4651 VGND.n340 VGND.t444 222.857
R4652 VGND.n1066 VGND.t510 222.857
R4653 VGND.t58 VGND.n194 222.857
R4654 VGND.n691 VGND.t783 222.857
R4655 VGND.t602 VGND.n676 222.857
R4656 VGND.n711 VGND.t2223 222.857
R4657 VGND.n718 VGND.t1753 222.857
R4658 VGND.n719 VGND.t136 222.857
R4659 VGND.n817 VGND.t1109 222.857
R4660 VGND.n801 VGND.t355 222.857
R4661 VGND.t548 VGND.n788 222.857
R4662 VGND.n784 VGND.t946 222.857
R4663 VGND.n758 VGND.t406 222.857
R4664 VGND.n737 VGND.t2171 222.857
R4665 VGND.t719 VGND.n492 222.423
R4666 VGND.n870 VGND.t1308 222.423
R4667 VGND.t1329 VGND.n482 222.423
R4668 VGND.n884 VGND.t1626 222.423
R4669 VGND.n886 VGND.t577 222.423
R4670 VGND.t1420 VGND.n461 222.423
R4671 VGND.t1425 VGND.n895 222.423
R4672 VGND.t118 VGND.n914 222.423
R4673 VGND.n926 VGND.t686 222.423
R4674 VGND.n921 VGND.t1799 222.423
R4675 VGND.t1998 VGND.n82 111.034
R4676 VGND.t2059 VGND.n88 222.065
R4677 VGND.n121 VGND.n82 8.48859
R4678 VGND.n82 VGND.n111 1.93645
R4679 VGND.t52 VGND.t2047 222.065
R4680 VGND.n82 VGND.t2009 111.032
R4681 VGND.n105 VGND.t2062 222.042
R4682 VGND.t2034 VGND.n773 222.042
R4683 VGND.t2080 VGND.n89 222.041
R4684 VGND.n81 VGND.t2022 222.041
R4685 VGND.n839 VGND.t2023 222.041
R4686 VGND.t2069 VGND.n95 221.417
R4687 VGND.t2023 VGND.n838 221.417
R4688 VGND.n774 VGND.t2034 221.417
R4689 VGND.n751 VGND.t2041 221.417
R4690 VGND.t2041 VGND.n750 221.417
R4691 VGND.n750 VGND.t2010 221.417
R4692 VGND.t2112 VGND.t85 218.571
R4693 VGND.t2 VGND.t2053 218.571
R4694 VGND.t2025 VGND.t630 218.571
R4695 VGND.t2036 VGND.t397 218.571
R4696 VGND.t708 VGND.n497 216.999
R4697 VGND.n865 VGND.t1297 216.999
R4698 VGND.t1341 VGND.n477 216.999
R4699 VGND.n879 VGND.t1615 216.999
R4700 VGND.t1406 VGND.n466 216.999
R4701 VGND.n904 VGND.t106 216.999
R4702 VGND.t674 VGND.n936 216.999
R4703 VGND.n849 VGND.t913 214.876
R4704 VGND.n605 VGND.t1175 214.876
R4705 VGND.t874 VGND.n519 214.876
R4706 VGND.t1589 VGND.n525 214.876
R4707 VGND.n585 VGND.t1550 214.876
R4708 VGND.t1076 VGND.n538 214.876
R4709 VGND.t1003 VGND.n544 214.876
R4710 VGND.t1478 VGND.n550 214.876
R4711 VGND.t1894 VGND.t1580 107.338
R4712 VGND.t1580 VGND.t1891 107.338
R4713 VGND.n416 VGND.t206 214.286
R4714 VGND.n431 VGND.t1287 214.286
R4715 VGND.t334 VGND.n385 214.286
R4716 VGND.n447 VGND.t1269 214.286
R4717 VGND.t1252 VGND.n370 214.286
R4718 VGND.t2354 VGND.n947 214.286
R4719 VGND.n973 VGND.t1394 214.286
R4720 VGND.n1031 VGND.t1440 214.286
R4721 VGND.n1047 VGND.t852 214.286
R4722 VGND.t2322 VGND.n1011 214.286
R4723 VGND.t266 VGND.n169 214.286
R4724 VGND.t227 VGND.n272 214.286
R4725 VGND.n296 VGND.t171 214.286
R4726 VGND.t731 VGND.n240 214.286
R4727 VGND.t566 VGND.n231 214.286
R4728 VGND.t299 VGND.n226 214.286
R4729 VGND.t460 VGND.n212 214.286
R4730 VGND.n1066 VGND.t509 214.286
R4731 VGND.t57 VGND.n194 214.286
R4732 VGND.n1080 VGND.t493 214.286
R4733 VGND.n1083 VGND.t51 214.286
R4734 VGND.n691 VGND.t782 214.286
R4735 VGND.t601 VGND.n676 214.286
R4736 VGND.n710 VGND.t13 214.286
R4737 VGND.t1108 VGND.n817 214.286
R4738 VGND.t354 VGND.n801 214.286
R4739 VGND.t405 VGND.n758 214.286
R4740 VGND.t477 VGND.n740 214.286
R4741 VGND.t413 VGND.n30 55.6649
R4742 VGND.t1696 VGND.n45 55.6672
R4743 VGND.n17 VGND.t1806 55.6697
R4744 VGND.n900 VGND.t2230 213.048
R4745 VGND.t78 VGND.t2093 210
R4746 VGND.n849 VGND.t912 206.613
R4747 VGND.n605 VGND.t1174 206.613
R4748 VGND.t873 VGND.n519 206.613
R4749 VGND.t1588 VGND.n525 206.613
R4750 VGND.n585 VGND.t1549 206.613
R4751 VGND.t1075 VGND.n538 206.613
R4752 VGND.t1002 VGND.n544 206.613
R4753 VGND.t1477 VGND.n550 206.613
R4754 VGND.n863 VGND.t718 206.149
R4755 VGND.t1307 VGND.n483 206.149
R4756 VGND.n872 VGND.t1330 206.149
R4757 VGND.t1625 VGND.n470 206.149
R4758 VGND.t576 VGND.n133 210.236
R4759 VGND.n893 VGND.t1418 206.149
R4760 VGND.t1424 VGND.n46 210.236
R4761 VGND.t117 VGND.n913 206.149
R4762 VGND.n927 VGND.t685 206.149
R4763 VGND.n922 VGND.t1798 206.149
R4764 VGND.t705 VGND.n133 11.9299
R4765 VGND.n423 VGND.t2125 205.714
R4766 VGND.t2104 VGND.n950 205.714
R4767 VGND.n961 VGND.t2128 205.714
R4768 VGND.t1386 VGND.t644 205.714
R4769 VGND.t419 VGND.t1455 205.714
R4770 VGND.t420 VGND.t1456 205.714
R4771 VGND.t421 VGND.t1457 205.714
R4772 VGND.t2120 VGND.n1023 205.714
R4773 VGND.n1059 VGND.t2124 205.714
R4774 VGND.n286 VGND.t2069 205.714
R4775 VGND.t2051 VGND.n268 205.714
R4776 VGND.n289 VGND.t2054 205.714
R4777 VGND.t30 VGND.t163 205.714
R4778 VGND.n311 VGND.t2080 205.714
R4779 VGND.n311 VGND.t2059 205.714
R4780 VGND.t567 VGND.t292 205.714
R4781 VGND.t293 VGND.t568 205.714
R4782 VGND.t569 VGND.t294 205.714
R4783 VGND.t295 VGND.t570 205.714
R4784 VGND.t571 VGND.t296 205.714
R4785 VGND.t297 VGND.t572 205.714
R4786 VGND.t573 VGND.t298 205.714
R4787 VGND.n1074 VGND.t2091 205.714
R4788 VGND.t2019 VGND.n669 205.714
R4789 VGND.n705 VGND.t2019 205.714
R4790 VGND.n121 VGND.t2028 102.709
R4791 VGND.t2010 VGND.n749 205.714
R4792 VGND.n923 VGND.t1797 204.911
R4793 VGND.n859 VGND.t709 200.724
R4794 VGND.t1298 VGND.n487 200.724
R4795 VGND.n876 VGND.t1340 200.724
R4796 VGND.t1616 VGND.n474 200.724
R4797 VGND.n889 VGND.t1407 200.724
R4798 VGND.n905 VGND.t107 200.724
R4799 VGND.t676 VGND.n935 200.724
R4800 VGND.t2119 VGND.t198 109.7
R4801 VGND.n56 VGND.t2101 102.457
R4802 VGND.t198 VGND.t2112 200.613
R4803 VGND.n51 VGND.t2116 106.677
R4804 VGND.t198 VGND.n50 86.7544
R4805 VGND.t2068 VGND.n106 200.613
R4806 VGND.n98 VGND.t2071 200.613
R4807 VGND.t2053 VGND.n93 200.613
R4808 VGND.n110 VGND.t2056 109.986
R4809 VGND.n104 VGND.t2086 200.613
R4810 VGND.t2061 VGND.n87 200.613
R4811 VGND.t2088 VGND.n86 200.613
R4812 VGND.t2004 VGND.n67 200.613
R4813 VGND.n826 VGND.t2027 200.613
R4814 VGND.n825 VGND.t2006 200.613
R4815 VGND.n776 VGND.t2033 200.613
R4816 VGND.n767 VGND.t2036 200.613
R4817 VGND.n729 VGND.t2043 200.613
R4818 VGND.n137 VGND.t2013 109.987
R4819 VGND.n22 VGND.t2095 199.989
R4820 VGND.n24 VGND.t2099 199.989
R4821 VGND.n95 VGND.t2049 199.989
R4822 VGND.t2079 VGND.n100 199.989
R4823 VGND.t2002 VGND.n79 199.989
R4824 VGND.t206 VGND.n408 197.143
R4825 VGND.t243 VGND.n401 197.143
R4826 VGND.n439 VGND.t1321 197.143
R4827 VGND.t1269 VGND.n377 197.143
R4828 VGND.t2339 VGND.n367 197.143
R4829 VGND.n948 VGND.t2354 197.143
R4830 VGND.t644 VGND.n963 197.143
R4831 VGND.t1394 VGND.n972 197.143
R4832 VGND.t1466 VGND.t316 197.143
R4833 VGND.t317 VGND.n987 197.143
R4834 VGND.t1467 VGND.t317 197.143
R4835 VGND.t1457 VGND.n999 197.143
R4836 VGND.t94 VGND.n352 197.143
R4837 VGND.t663 VGND.n1034 197.143
R4838 VGND.n1050 VGND.t835 197.143
R4839 VGND.n177 VGND.t266 197.143
R4840 VGND.t818 VGND.n272 197.143
R4841 VGND.n291 VGND.t30 197.143
R4842 VGND.t171 VGND.n259 197.143
R4843 VGND.n304 VGND.t186 197.143
R4844 VGND.n304 VGND.t154 197.143
R4845 VGND.n315 VGND.t731 197.143
R4846 VGND.n322 VGND.t566 197.143
R4847 VGND.n326 VGND.t299 197.143
R4848 VGND.t371 VGND.n221 197.143
R4849 VGND.t443 VGND.n211 197.143
R4850 VGND.t509 VGND.n203 197.143
R4851 VGND.n1074 VGND.t57 197.143
R4852 VGND.t782 VGND.n684 197.143
R4853 VGND.n698 VGND.t601 197.143
R4854 VGND.t2222 VGND.n663 197.143
R4855 VGND.t1754 VGND.n654 197.143
R4856 VGND.t135 VGND.n654 197.143
R4857 VGND.n818 VGND.t1108 197.143
R4858 VGND.n802 VGND.t354 197.143
R4859 VGND.t549 VGND.n787 197.143
R4860 VGND.n785 VGND.t945 197.143
R4861 VGND.n759 VGND.t405 197.143
R4862 VGND.n738 VGND.t2170 197.143
R4863 VGND.t1872 VGND.t1580 106.338
R4864 VGND.t1580 VGND.t1874 105.382
R4865 VGND.t1580 VGND.t1877 106.296
R4866 VGND.t1878 VGND.t1580 105.382
R4867 VGND.t1881 VGND.t1580 105.382
R4868 VGND.t1886 VGND.t1580 106.338
R4869 VGND.t1888 VGND.t1580 106.337
R4870 VGND.t1580 VGND.t1890 106.338
R4871 VGND.t1580 VGND.t1893 106.338
R4872 VGND.t1580 VGND.t1896 106.338
R4873 VGND.t1897 VGND.t1580 105.382
R4874 VGND.t2096 VGND.t1263 192.857
R4875 VGND.t198 VGND.n51 3.31704
R4876 VGND.t2087 VGND.n86 192.042
R4877 VGND.t2060 VGND.n87 192.042
R4878 VGND.n104 VGND.t2085 192.042
R4879 VGND.n109 VGND.t2076 108.993
R4880 VGND.n110 VGND.t2055 192.054
R4881 VGND.t2052 VGND.n93 192.042
R4882 VGND.n98 VGND.t2070 192.042
R4883 VGND.t2067 VGND.n106 192.042
R4884 VGND.n112 VGND.t2044 109.001
R4885 VGND.t2011 VGND.n137 192.054
R4886 VGND.t2042 VGND.n729 192.042
R4887 VGND.t2035 VGND.n767 192.042
R4888 VGND.t2032 VGND.n776 192.042
R4889 VGND.t2007 VGND.n120 192.054
R4890 VGND.t2005 VGND.n825 192.042
R4891 VGND.t2026 VGND.n826 192.042
R4892 VGND.t2003 VGND.n67 192.042
R4893 VGND.t2000 VGND.n76 200.624
R4894 VGND.t2118 VGND.n50 22.241
R4895 VGND.t2126 VGND.n24 191.417
R4896 VGND.n100 VGND.t2057 191.417
R4897 VGND.t2020 VGND.n68 191.417
R4898 VGND.t912 VGND.n505 190.083
R4899 VGND.t1174 VGND.n512 190.083
R4900 VGND.n599 VGND.t873 190.083
R4901 VGND.n592 VGND.t1588 190.083
R4902 VGND.t1549 VGND.n531 190.083
R4903 VGND.n579 VGND.t1075 190.083
R4904 VGND.n572 VGND.t1002 190.083
R4905 VGND.n565 VGND.t1477 190.083
R4906 VGND.t717 VGND.n493 189.874
R4907 VGND.n869 VGND.t1306 189.874
R4908 VGND.t1331 VGND.n481 189.874
R4909 VGND.n883 VGND.t1624 189.874
R4910 VGND.t1417 VGND.n462 189.874
R4911 VGND.t116 VGND.n912 189.874
R4912 VGND.n928 VGND.t684 189.874
R4913 VGND.t207 VGND.n407 188.571
R4914 VGND.t244 VGND.n400 188.571
R4915 VGND.t1288 VGND.n392 188.571
R4916 VGND.n439 VGND.t335 188.571
R4917 VGND.t1270 VGND.n376 188.571
R4918 VGND.n453 VGND.t1253 188.571
R4919 VGND.t2340 VGND.n366 188.571
R4920 VGND.n965 VGND.t645 188.571
R4921 VGND.n974 VGND.t1395 188.571
R4922 VGND.n989 VGND.t318 188.571
R4923 VGND.n1001 VGND.t1458 188.571
R4924 VGND.n354 VGND.t95 188.571
R4925 VGND.n1032 VGND.t1441 188.571
R4926 VGND.t853 VGND.n1019 188.571
R4927 VGND.n1051 VGND.t836 188.571
R4928 VGND.n1055 VGND.t2321 188.571
R4929 VGND.t2124 VGND.t2329 188.571
R4930 VGND.n178 VGND.t267 188.571
R4931 VGND.t2314 VGND.t2064 188.571
R4932 VGND.n282 VGND.t228 188.571
R4933 VGND.n292 VGND.t31 188.571
R4934 VGND.t172 VGND.n258 188.571
R4935 VGND.n316 VGND.t732 188.571
R4936 VGND.n323 VGND.t567 188.571
R4937 VGND.n327 VGND.t300 188.571
R4938 VGND.t372 VGND.n220 188.571
R4939 VGND.n339 VGND.t461 188.571
R4940 VGND.t510 VGND.n202 188.571
R4941 VGND.n1075 VGND.t58 188.571
R4942 VGND.t494 VGND.n188 188.571
R4943 VGND.t71 VGND.n186 188.571
R4944 VGND.t783 VGND.n683 188.571
R4945 VGND.t1997 VGND.t430 188.571
R4946 VGND.n699 VGND.t602 188.571
R4947 VGND.t14 VGND.n663 188.571
R4948 VGND.t1109 VGND.n816 188.571
R4949 VGND.t355 VGND.n800 188.571
R4950 VGND.t406 VGND.n757 188.571
R4951 VGND.t478 VGND.n739 188.571
R4952 VGND.t1876 VGND.t1580 105.376
R4953 VGND.t710 VGND.n496 184.448
R4954 VGND.n866 VGND.t1299 184.448
R4955 VGND.t1339 VGND.n478 184.448
R4956 VGND.n880 VGND.t1617 184.448
R4957 VGND.t1408 VGND.n465 184.448
R4958 VGND.n906 VGND.t108 184.448
R4959 VGND.t677 VGND.n934 184.448
R4960 VGND.t2127 VGND.n52 100.886
R4961 VGND.t2103 VGND.n946 184.286
R4962 VGND.n977 VGND.t2106 184.286
R4963 VGND.n361 VGND.t2109 184.286
R4964 VGND.t2114 VGND.n355 184.286
R4965 VGND.n1057 VGND.t2122 184.286
R4966 VGND.t2064 VGND.n166 184.286
R4967 VGND.n298 VGND.t2073 184.286
R4968 VGND.n310 VGND.t2058 184.286
R4969 VGND.n333 VGND.t2084 184.286
R4970 VGND.t2093 VGND.n181 184.286
R4971 VGND.n694 VGND.t1997 184.286
R4972 VGND.t2021 VGND.n659 184.286
R4973 VGND.n830 VGND.t2025 184.286
R4974 VGND.n754 VGND.t2040 184.286
R4975 VGND.t913 VGND.n506 181.819
R4976 VGND.t1175 VGND.n513 181.819
R4977 VGND.n598 VGND.t874 181.819
R4978 VGND.n591 VGND.t1589 181.819
R4979 VGND.t1550 VGND.n532 181.819
R4980 VGND.n578 VGND.t1076 181.819
R4981 VGND.n571 VGND.t1003 181.819
R4982 VGND.n564 VGND.t1478 181.819
R4983 VGND.t2332 VGND.t1252 180
R4984 VGND.t1253 VGND.t2333 180
R4985 VGND.t2334 VGND.t1254 180
R4986 VGND.t1255 VGND.t2335 180
R4987 VGND.t2336 VGND.t1256 180
R4988 VGND.t1257 VGND.t2337 180
R4989 VGND.t2338 VGND.t1258 180
R4990 VGND.t1259 VGND.t2339 180
R4991 VGND.t852 VGND.t828 180
R4992 VGND.t829 VGND.t853 180
R4993 VGND.t854 VGND.t830 180
R4994 VGND.t831 VGND.t855 180
R4995 VGND.t856 VGND.t832 180
R4996 VGND.t833 VGND.t857 180
R4997 VGND.t858 VGND.t834 180
R4998 VGND.t835 VGND.t859 180
R4999 VGND.t1226 VGND.t2051 180
R5000 VGND.n444 VGND.t2096 175.714
R5001 VGND.n47 VGND.t2098 99.5774
R5002 VGND.n944 VGND.t2102 175.714
R5003 VGND.n353 VGND.t2113 175.714
R5004 VGND.n1056 VGND.t2121 175.714
R5005 VGND.n286 VGND.t2048 175.714
R5006 VGND.t2078 VGND.n245 175.714
R5007 VGND.n319 VGND.t2081 175.714
R5008 VGND.n332 VGND.t2083 175.714
R5009 VGND.t2089 VGND.n199 175.714
R5010 VGND.t2017 VGND.n673 175.714
R5011 VGND.t2018 VGND.t416 175.714
R5012 VGND.t2001 VGND.n659 175.714
R5013 VGND.t2037 VGND.n763 175.714
R5014 VGND.n862 VGND.t716 173.6
R5015 VGND.t1305 VGND.n484 173.6
R5016 VGND.n873 VGND.t1332 173.6
R5017 VGND.t1623 VGND.n471 173.6
R5018 VGND.n892 VGND.t1415 173.6
R5019 VGND.t115 VGND.n911 173.6
R5020 VGND.n929 VGND.t683 173.6
R5021 VGND.n415 VGND.t205 171.429
R5022 VGND.n422 VGND.t241 171.429
R5023 VGND.t1320 VGND.n385 171.429
R5024 VGND.n446 VGND.t1268 171.429
R5025 VGND.t1251 VGND.n371 171.429
R5026 VGND.n455 VGND.t2338 171.429
R5027 VGND.n949 VGND.t2355 171.429
R5028 VGND.t643 VGND.n962 171.429
R5029 VGND.t1393 VGND.n971 171.429
R5030 VGND.t316 VGND.n986 171.429
R5031 VGND.t1456 VGND.n998 171.429
R5032 VGND.t93 VGND.n351 171.429
R5033 VGND.t662 VGND.n1033 171.429
R5034 VGND.n1046 VGND.t851 171.429
R5035 VGND.t834 VGND.n1017 171.429
R5036 VGND.t2323 VGND.n1010 171.429
R5037 VGND.t265 VGND.n170 171.429
R5038 VGND.n281 VGND.t817 171.429
R5039 VGND.t29 VGND.n264 171.429
R5040 VGND.n295 VGND.t170 171.429
R5041 VGND.t153 VGND.n251 171.429
R5042 VGND.t187 VGND.n250 171.429
R5043 VGND.t730 VGND.n241 171.429
R5044 VGND.t565 VGND.n232 171.429
R5045 VGND.t298 VGND.n227 171.429
R5046 VGND.n331 VGND.t369 171.429
R5047 VGND.n339 VGND.t442 171.429
R5048 VGND.n1065 VGND.t508 171.429
R5049 VGND.t56 VGND.n195 171.429
R5050 VGND.n1079 VGND.t492 171.429
R5051 VGND.n1084 VGND.t72 171.429
R5052 VGND.n690 VGND.t781 171.429
R5053 VGND.t600 VGND.n677 171.429
R5054 VGND.n710 VGND.t2221 171.429
R5055 VGND.n718 VGND.t133 171.429
R5056 VGND.n719 VGND.t1755 171.429
R5057 VGND.n819 VGND.t1107 171.429
R5058 VGND.n803 VGND.t352 171.429
R5059 VGND.t550 VGND.n786 171.429
R5060 VGND.n786 VGND.t944 171.429
R5061 VGND.n760 VGND.t404 171.429
R5062 VGND.n739 VGND.t2169 171.429
R5063 VGND.n860 VGND.t711 168.174
R5064 VGND.t1300 VGND.n486 168.174
R5065 VGND.n875 VGND.t1338 168.174
R5066 VGND.t1618 VGND.n473 168.174
R5067 VGND.n890 VGND.t1409 168.174
R5068 VGND.n907 VGND.t109 168.174
R5069 VGND.t678 VGND.n933 168.174
R5070 VGND.t400 VGND.t2037 167.143
R5071 VGND.n850 VGND.t911 165.29
R5072 VGND.n606 VGND.t1173 165.29
R5073 VGND.t872 VGND.n518 165.29
R5074 VGND.t1587 VGND.n524 165.29
R5075 VGND.n586 VGND.t1548 165.29
R5076 VGND.t1074 VGND.n537 165.29
R5077 VGND.t1001 VGND.n543 165.29
R5078 VGND.t1476 VGND.n549 165.29
R5079 VGND.t705 VGND.t2157 71.8413
R5080 VGND.n417 VGND.t208 162.857
R5081 VGND.n424 VGND.t245 162.857
R5082 VGND.t336 VGND.n384 162.857
R5083 VGND.t1271 VGND.n375 162.857
R5084 VGND.t1254 VGND.n369 162.857
R5085 VGND.n457 VGND.t2341 162.857
R5086 VGND.t2352 VGND.n945 162.857
R5087 VGND.n966 VGND.t646 162.857
R5088 VGND.n975 VGND.t1396 162.857
R5089 VGND.n990 VGND.t319 162.857
R5090 VGND.n1002 VGND.t1460 162.857
R5091 VGND.n355 VGND.t97 162.857
R5092 VGND.n1033 VGND.t1442 162.857
R5093 VGND.t846 VGND.t2120 162.857
R5094 VGND.n1048 VGND.t854 162.857
R5095 VGND.t837 VGND.n1015 162.857
R5096 VGND.t2320 VGND.n1012 162.857
R5097 VGND.t268 VGND.n168 162.857
R5098 VGND.t229 VGND.n271 162.857
R5099 VGND.t32 VGND.n262 162.857
R5100 VGND.n297 VGND.t173 162.857
R5101 VGND.t733 VGND.n239 162.857
R5102 VGND.t568 VGND.n230 162.857
R5103 VGND.n333 VGND.t373 162.857
R5104 VGND.t462 VGND.n211 162.857
R5105 VGND.n1067 VGND.t511 162.857
R5106 VGND.t493 VGND.t65 162.857
R5107 VGND.t67 VGND.t494 162.857
R5108 VGND.t495 VGND.t49 162.857
R5109 VGND.n1081 VGND.t495 162.857
R5110 VGND.t68 VGND.t496 162.857
R5111 VGND.t497 VGND.t69 162.857
R5112 VGND.n1082 VGND.t70 162.857
R5113 VGND.t70 VGND.t498 162.857
R5114 VGND.t499 VGND.t71 162.857
R5115 VGND.t51 VGND.t500 162.857
R5116 VGND.n692 VGND.t784 162.857
R5117 VGND.t603 VGND.n675 162.857
R5118 VGND.n711 VGND.t16 162.857
R5119 VGND.t1110 VGND.n815 162.857
R5120 VGND.t356 VGND.n799 162.857
R5121 VGND.t407 VGND.n756 162.857
R5122 VGND.t479 VGND.n738 162.857
R5123 VGND.t1227 VGND.t1289 158.571
R5124 VGND.t195 VGND.t2077 158.571
R5125 VGND.t633 VGND.t2026 158.571
R5126 VGND.t715 VGND.n494 157.325
R5127 VGND.n868 VGND.t1304 157.325
R5128 VGND.t1333 VGND.n480 157.325
R5129 VGND.n882 VGND.t1622 157.325
R5130 VGND.t1414 VGND.n463 157.325
R5131 VGND.t114 VGND.n910 157.325
R5132 VGND.n930 VGND.t682 157.325
R5133 VGND.n848 VGND.t914 157.025
R5134 VGND.n604 VGND.t1176 157.025
R5135 VGND.t875 VGND.n520 157.025
R5136 VGND.t1590 VGND.n526 157.025
R5137 VGND.n584 VGND.t1551 157.025
R5138 VGND.t1077 VGND.n539 157.025
R5139 VGND.t1004 VGND.n545 157.025
R5140 VGND.t1479 VGND.n551 157.025
R5141 VGND.t301 VGND.t362 154.286
R5142 VGND.t59 VGND.t485 154.286
R5143 VGND.t712 VGND.n495 151.899
R5144 VGND.n867 VGND.t1301 151.899
R5145 VGND.t1337 VGND.n479 151.899
R5146 VGND.n881 VGND.t1619 151.899
R5147 VGND.t1410 VGND.n464 151.899
R5148 VGND.n908 VGND.t110 151.899
R5149 VGND.t679 VGND.n932 151.899
R5150 VGND.t2110 VGND.t254 150
R5151 VGND.t705 VGND.t2138 71.8576
R5152 VGND.t2143 VGND.t705 71.8411
R5153 VGND.t705 VGND.t2153 71.8576
R5154 VGND.t705 VGND.t2152 73.0791
R5155 VGND.t204 VGND.n409 145.714
R5156 VGND.t240 VGND.n402 145.714
R5157 VGND.n438 VGND.t1319 145.714
R5158 VGND.t1267 VGND.n378 145.714
R5159 VGND.n451 VGND.t1250 145.714
R5160 VGND.t2337 VGND.n368 145.714
R5161 VGND.n950 VGND.t2356 145.714
R5162 VGND.t642 VGND.n961 145.714
R5163 VGND.t1392 VGND.n970 145.714
R5164 VGND.t315 VGND.n985 145.714
R5165 VGND.t1455 VGND.n997 145.714
R5166 VGND.t92 VGND.n350 145.714
R5167 VGND.t661 VGND.n1032 145.714
R5168 VGND.t850 VGND.n1021 145.714
R5169 VGND.n1049 VGND.t833 145.714
R5170 VGND.n1057 VGND.t2324 145.714
R5171 VGND.n176 VGND.t264 145.714
R5172 VGND.t816 VGND.n273 145.714
R5173 VGND.n290 VGND.t28 145.714
R5174 VGND.t169 VGND.n260 145.714
R5175 VGND.n303 VGND.t152 145.714
R5176 VGND.n305 VGND.t188 145.714
R5177 VGND.n314 VGND.t729 145.714
R5178 VGND.n233 VGND.t564 145.714
R5179 VGND.n325 VGND.t297 145.714
R5180 VGND.t368 VGND.n222 145.714
R5181 VGND.t441 VGND.n212 145.714
R5182 VGND.t507 VGND.n204 145.714
R5183 VGND.n1073 VGND.t55 145.714
R5184 VGND.t491 VGND.n190 145.714
R5185 VGND.t73 VGND.n183 145.714
R5186 VGND.t780 VGND.n685 145.714
R5187 VGND.n697 VGND.t599 145.714
R5188 VGND.t2220 VGND.n664 145.714
R5189 VGND.t132 VGND.n655 145.714
R5190 VGND.t1756 VGND.n653 145.714
R5191 VGND.n820 VGND.t1106 145.714
R5192 VGND.n804 VGND.t351 145.714
R5193 VGND.n787 VGND.t943 145.714
R5194 VGND.t551 VGND.n785 145.714
R5195 VGND.n761 VGND.t403 145.714
R5196 VGND.n740 VGND.t2168 145.714
R5197 VGND.t2137 VGND.t705 72.461
R5198 VGND.t2159 VGND.t705 72.4473
R5199 VGND.t2106 VGND.t1400 141.429
R5200 VGND.t103 VGND.t2115 141.429
R5201 VGND.t2073 VGND.t176 141.429
R5202 VGND.t2040 VGND.t410 141.429
R5203 VGND.n861 VGND.t714 141.049
R5204 VGND.t1303 VGND.n485 141.049
R5205 VGND.n874 VGND.t1335 141.049
R5206 VGND.t1621 VGND.n472 141.049
R5207 VGND.n891 VGND.t1413 141.049
R5208 VGND.t113 VGND.n909 141.049
R5209 VGND.n931 VGND.t681 141.049
R5210 VGND.t910 VGND.n504 140.496
R5211 VGND.t1172 VGND.n511 140.496
R5212 VGND.n600 VGND.t871 140.496
R5213 VGND.n593 VGND.t1586 140.496
R5214 VGND.t1547 VGND.n530 140.496
R5215 VGND.n580 VGND.t1073 140.496
R5216 VGND.n573 VGND.t1000 140.496
R5217 VGND.n566 VGND.t1475 140.496
R5218 VGND.t209 VGND.n406 137.143
R5219 VGND.t1290 VGND.n391 137.143
R5220 VGND.n440 VGND.t337 137.143
R5221 VGND.n454 VGND.t1255 137.143
R5222 VGND.t2351 VGND.n944 137.143
R5223 VGND.n967 VGND.t647 137.143
R5224 VGND.n976 VGND.t1397 137.143
R5225 VGND.n1003 VGND.t1461 137.143
R5226 VGND.n358 VGND.t98 137.143
R5227 VGND.n1034 VGND.t1443 137.143
R5228 VGND.t855 VGND.n1018 137.143
R5229 VGND.n1052 VGND.t838 137.143
R5230 VGND.n1054 VGND.t2319 137.143
R5231 VGND.n179 VGND.t269 137.143
R5232 VGND.n283 VGND.t230 137.143
R5233 VGND.t2054 VGND.t25 137.143
R5234 VGND.n293 VGND.t33 137.143
R5235 VGND.t174 VGND.n257 137.143
R5236 VGND.n317 VGND.t735 137.143
R5237 VGND.n324 VGND.t569 137.143
R5238 VGND.n328 VGND.t302 137.143
R5239 VGND.t374 VGND.n219 137.143
R5240 VGND.n340 VGND.t463 137.143
R5241 VGND.t512 VGND.n201 137.143
R5242 VGND.n1076 VGND.t60 137.143
R5243 VGND.t496 VGND.n187 137.143
R5244 VGND.t69 VGND.n187 137.143
R5245 VGND.t785 VGND.n682 137.143
R5246 VGND.n700 VGND.t604 137.143
R5247 VGND.t17 VGND.n662 137.143
R5248 VGND.t1111 VGND.n814 137.143
R5249 VGND.t357 VGND.n798 137.143
R5250 VGND.t408 VGND.n755 137.143
R5251 VGND.t480 VGND.n737 137.143
R5252 VGND.n861 VGND.t713 135.625
R5253 VGND.t1302 VGND.n485 135.625
R5254 VGND.n874 VGND.t1336 135.625
R5255 VGND.t1620 VGND.n472 135.625
R5256 VGND.n891 VGND.t1412 135.625
R5257 VGND.n909 VGND.t112 135.625
R5258 VGND.t680 VGND.n931 135.625
R5259 VGND.t2145 VGND.t705 72.4475
R5260 VGND.t915 VGND.n507 132.232
R5261 VGND.t1177 VGND.n514 132.232
R5262 VGND.n597 VGND.t876 132.232
R5263 VGND.n590 VGND.t1591 132.232
R5264 VGND.t1552 VGND.n533 132.232
R5265 VGND.n577 VGND.t1078 132.232
R5266 VGND.n570 VGND.t1005 132.232
R5267 VGND.n563 VGND.t1480 132.232
R5268 VGND.t1285 VGND.t1238 128.571
R5269 VGND.t1239 VGND.t1286 128.571
R5270 VGND.t1242 VGND.t1272 128.571
R5271 VGND.t1449 VGND.t320 128.571
R5272 VGND.t705 VGND.t2155 72.4623
R5273 VGND.t2147 VGND.t705 71.8576
R5274 VGND.t705 VGND.t2141 72.4624
R5275 VGND.t2134 VGND.t705 71.8582
R5276 VGND.t2131 VGND.t705 71.8428
R5277 VGND.t713 VGND.n495 124.775
R5278 VGND.n867 VGND.t1302 124.775
R5279 VGND.t1336 VGND.n479 124.775
R5280 VGND.n881 VGND.t1620 124.775
R5281 VGND.t1412 VGND.n464 124.775
R5282 VGND.t112 VGND.n908 124.775
R5283 VGND.n932 VGND.t680 124.775
R5284 VGND.t2102 VGND.t2350 124.287
R5285 VGND.n414 VGND.t203 120.001
R5286 VGND.n421 VGND.t239 120.001
R5287 VGND.n429 VGND.t1284 120.001
R5288 VGND.t1287 VGND.t1240 120.001
R5289 VGND.t1318 VGND.n386 120.001
R5290 VGND.n445 VGND.t1266 120.001
R5291 VGND.t1249 VGND.n372 120.001
R5292 VGND.n454 VGND.t2336 120.001
R5293 VGND.n951 VGND.t2357 120.001
R5294 VGND.t641 VGND.n960 120.001
R5295 VGND.t1391 VGND.n969 120.001
R5296 VGND.t314 VGND.n984 120.001
R5297 VGND.t1454 VGND.n996 120.001
R5298 VGND.t91 VGND.n349 120.001
R5299 VGND.t660 VGND.n1031 120.001
R5300 VGND.n1022 VGND.t849 120.001
R5301 VGND.t832 VGND.n1018 120.001
R5302 VGND.t2325 VGND.n1008 120.001
R5303 VGND.t263 VGND.n171 120.001
R5304 VGND.n280 VGND.t815 120.001
R5305 VGND.t27 VGND.n265 120.001
R5306 VGND.n294 VGND.t168 120.001
R5307 VGND.t151 VGND.n252 120.001
R5308 VGND.t189 VGND.n249 120.001
R5309 VGND.t728 VGND.n242 120.001
R5310 VGND.n321 VGND.t563 120.001
R5311 VGND.t296 VGND.n229 120.001
R5312 VGND.n330 VGND.t367 120.001
R5313 VGND.n338 VGND.t440 120.001
R5314 VGND.n1064 VGND.t506 120.001
R5315 VGND.t54 VGND.n196 120.001
R5316 VGND.n1078 VGND.t490 120.001
R5317 VGND.n1085 VGND.t74 120.001
R5318 VGND.n689 VGND.t779 120.001
R5319 VGND.t598 VGND.n678 120.001
R5320 VGND.n709 VGND.t2219 120.001
R5321 VGND.n717 VGND.t131 120.001
R5322 VGND.n720 VGND.t1757 120.001
R5323 VGND.n821 VGND.t1105 120.001
R5324 VGND.n805 VGND.t350 120.001
R5325 VGND.n788 VGND.t942 120.001
R5326 VGND.t552 VGND.n784 120.001
R5327 VGND.n762 VGND.t402 120.001
R5328 VGND.n741 VGND.t2167 120.001
R5329 VGND.t714 VGND.n494 119.35
R5330 VGND.n868 VGND.t1303 119.35
R5331 VGND.t1335 VGND.n480 119.35
R5332 VGND.n882 VGND.t1621 119.35
R5333 VGND.t1413 VGND.n463 119.35
R5334 VGND.n910 VGND.t113 119.35
R5335 VGND.t681 VGND.n930 119.35
R5336 VGND.t1293 VGND.t2094 115.715
R5337 VGND.t561 VGND.t2082 115.715
R5338 VGND.t2090 VGND.t48 115.715
R5339 VGND.n851 VGND.t909 115.703
R5340 VGND.n607 VGND.t1171 115.703
R5341 VGND.t870 VGND.n517 115.703
R5342 VGND.t1585 VGND.n523 115.703
R5343 VGND.n587 VGND.t1546 115.703
R5344 VGND.t1072 VGND.n536 115.703
R5345 VGND.t999 VGND.n542 115.703
R5346 VGND.t1474 VGND.n548 115.703
R5347 VGND.n418 VGND.t210 111.43
R5348 VGND.n427 VGND.t1232 111.43
R5349 VGND.n433 VGND.t1291 111.43
R5350 VGND.t338 VGND.n383 111.43
R5351 VGND.t1273 VGND.n374 111.43
R5352 VGND.t1256 VGND.n368 111.43
R5353 VGND.t2350 VGND.n943 111.43
R5354 VGND.n968 VGND.t648 111.43
R5355 VGND.n977 VGND.t1399 111.43
R5356 VGND.n992 VGND.t321 111.43
R5357 VGND.n1004 VGND.t1462 111.43
R5358 VGND.t99 VGND.n357 111.43
R5359 VGND.n1035 VGND.t1444 111.43
R5360 VGND.n1039 VGND.t667 111.43
R5361 VGND.n1049 VGND.t856 111.43
R5362 VGND.t839 VGND.n1014 111.43
R5363 VGND.t2318 VGND.n1013 111.43
R5364 VGND.t270 VGND.n167 111.43
R5365 VGND.t231 VGND.n270 111.43
R5366 VGND.t34 VGND.n261 111.43
R5367 VGND.n298 VGND.t175 111.43
R5368 VGND.t736 VGND.n238 111.43
R5369 VGND.t570 VGND.n229 111.43
R5370 VGND.t303 VGND.n224 111.43
R5371 VGND.n334 VGND.t376 111.43
R5372 VGND.t464 VGND.n210 111.43
R5373 VGND.n1068 VGND.t513 111.43
R5374 VGND.t61 VGND.n192 111.43
R5375 VGND.n1081 VGND.t68 111.43
R5376 VGND.n1082 VGND.t497 111.43
R5377 VGND.n693 VGND.t786 111.43
R5378 VGND.t605 VGND.n674 111.43
R5379 VGND.t1058 VGND.n671 111.43
R5380 VGND.n712 VGND.t18 111.43
R5381 VGND.t626 VGND.n833 111.43
R5382 VGND.t1112 VGND.n813 111.43
R5383 VGND.t358 VGND.n797 111.43
R5384 VGND.t409 VGND.n754 111.43
R5385 VGND.t481 VGND.n736 111.43
R5386 VGND.n860 VGND.t712 108.499
R5387 VGND.t1301 VGND.n486 108.499
R5388 VGND.n875 VGND.t1337 108.499
R5389 VGND.t1619 VGND.n473 108.499
R5390 VGND.n890 VGND.t1410 108.499
R5391 VGND.t110 VGND.n907 108.499
R5392 VGND.n933 VGND.t679 108.499
R5393 VGND.n847 VGND.t917 107.439
R5394 VGND.n603 VGND.t1179 107.439
R5395 VGND.t877 VGND.n521 107.439
R5396 VGND.t1592 VGND.n527 107.439
R5397 VGND.n583 VGND.t1554 107.439
R5398 VGND.t1079 VGND.n540 107.439
R5399 VGND.t1006 VGND.n546 107.439
R5400 VGND.t1481 VGND.n553 107.439
R5401 VGND.t1218 VGND.n556 107.439
R5402 VGND.t2122 VGND.t2325 107.144
R5403 VGND.n862 VGND.t715 103.075
R5404 VGND.t1304 VGND.n484 103.075
R5405 VGND.n873 VGND.t1333 103.075
R5406 VGND.t1622 VGND.n471 103.075
R5407 VGND.n892 VGND.t1414 103.075
R5408 VGND.n911 VGND.t114 103.075
R5409 VGND.t682 VGND.n929 103.075
R5410 VGND.t1437 VGND.t656 102.858
R5411 VGND.t1438 VGND.t657 102.858
R5412 VGND.t1439 VGND.t658 102.858
R5413 VGND.t1440 VGND.t659 102.858
R5414 VGND.t1441 VGND.t660 102.858
R5415 VGND.t1442 VGND.t661 102.858
R5416 VGND.t1443 VGND.t662 102.858
R5417 VGND.t1444 VGND.t663 102.858
R5418 VGND.t1445 VGND.t664 102.858
R5419 VGND.t1446 VGND.t665 102.858
R5420 VGND.t1447 VGND.t666 102.858
R5421 VGND.n128 VGND.t1698 83.6308
R5422 VGND.t2197 VGND.n166 98.5719
R5423 VGND.n694 VGND.t0 98.5719
R5424 VGND.t202 VGND.n410 94.2862
R5425 VGND.t238 VGND.n403 94.2862
R5426 VGND.t1283 VGND.n395 94.2862
R5427 VGND.n437 VGND.t1317 94.2862
R5428 VGND.t1265 VGND.n379 94.2862
R5429 VGND.n450 VGND.t1248 94.2862
R5430 VGND.t2335 VGND.n369 94.2862
R5431 VGND.n952 VGND.t2358 94.2862
R5432 VGND.t640 VGND.n959 94.2862
R5433 VGND.t1390 VGND.n968 94.2862
R5434 VGND.t313 VGND.n983 94.2862
R5435 VGND.t1453 VGND.n995 94.2862
R5436 VGND.t90 VGND.n348 94.2862
R5437 VGND.t1436 VGND.n1026 94.2862
R5438 VGND.t659 VGND.n1030 94.2862
R5439 VGND.n1045 VGND.t848 94.2862
R5440 VGND.n1048 VGND.t831 94.2862
R5441 VGND.n1058 VGND.t2326 94.2862
R5442 VGND.n175 VGND.t262 94.2862
R5443 VGND.t814 VGND.n274 94.2862
R5444 VGND.n289 VGND.t26 94.2862
R5445 VGND.t167 VGND.n261 94.2862
R5446 VGND.n302 VGND.t150 94.2862
R5447 VGND.n306 VGND.t190 94.2862
R5448 VGND.n313 VGND.t727 94.2862
R5449 VGND.t562 VGND.n234 94.2862
R5450 VGND.n324 VGND.t295 94.2862
R5451 VGND.t366 VGND.n223 94.2862
R5452 VGND.t439 VGND.n213 94.2862
R5453 VGND.t505 VGND.n205 94.2862
R5454 VGND.n1072 VGND.t53 94.2862
R5455 VGND.t489 VGND.n191 94.2862
R5456 VGND.t75 VGND.n182 94.2862
R5457 VGND.t778 VGND.n686 94.2862
R5458 VGND.n696 VGND.t597 94.2862
R5459 VGND.t2218 VGND.n665 94.2862
R5460 VGND.t130 VGND.n656 94.2862
R5461 VGND.t1758 VGND.n652 94.2862
R5462 VGND.n822 VGND.t1104 94.2862
R5463 VGND.n806 VGND.t349 94.2862
R5464 VGND.t938 VGND.t544 94.2862
R5465 VGND.t939 VGND.t546 94.2862
R5466 VGND.t940 VGND.t547 94.2862
R5467 VGND.n789 VGND.t941 94.2862
R5468 VGND.t941 VGND.t548 94.2862
R5469 VGND.t942 VGND.t549 94.2862
R5470 VGND.t943 VGND.t550 94.2862
R5471 VGND.t944 VGND.t551 94.2862
R5472 VGND.t945 VGND.t552 94.2862
R5473 VGND.t946 VGND.t553 94.2862
R5474 VGND.t553 VGND.n783 94.2862
R5475 VGND.t947 VGND.t554 94.2862
R5476 VGND.t948 VGND.t555 94.2862
R5477 VGND.t949 VGND.t556 94.2862
R5478 VGND.n763 VGND.t401 94.2862
R5479 VGND.n742 VGND.t2166 94.2862
R5480 VGND.t711 VGND.n496 92.2247
R5481 VGND.n866 VGND.t1300 92.2247
R5482 VGND.t1338 VGND.n478 92.2247
R5483 VGND.n880 VGND.t1618 92.2247
R5484 VGND.t1409 VGND.n465 92.2247
R5485 VGND.t109 VGND.n906 92.2247
R5486 VGND.n934 VGND.t678 92.2247
R5487 VGND.t908 VGND.n503 90.9096
R5488 VGND.t1170 VGND.n510 90.9096
R5489 VGND.n601 VGND.t869 90.9096
R5490 VGND.n594 VGND.t1584 90.9096
R5491 VGND.t1545 VGND.n529 90.9096
R5492 VGND.n581 VGND.t1071 90.9096
R5493 VGND.n574 VGND.t998 90.9096
R5494 VGND.n567 VGND.t1473 90.9096
R5495 VGND.t2107 VGND.t1463 90.0005
R5496 VGND.t98 VGND.t2114 90.0005
R5497 VGND.t2084 VGND.t374 90.0005
R5498 VGND.t2024 VGND.t627 90.0005
R5499 VGND.t716 VGND.n493 86.7998
R5500 VGND.n869 VGND.t1305 86.7998
R5501 VGND.t1332 VGND.n481 86.7998
R5502 VGND.n883 VGND.t1623 86.7998
R5503 VGND.t1415 VGND.n462 86.7998
R5504 VGND.n912 VGND.t115 86.7998
R5505 VGND.t683 VGND.n928 86.7998
R5506 VGND.t211 VGND.n405 85.7148
R5507 VGND.t1233 VGND.n396 85.7148
R5508 VGND.t1292 VGND.n390 85.7148
R5509 VGND.n441 VGND.t339 85.7148
R5510 VGND.n449 VGND.t1274 85.7148
R5511 VGND.n455 VGND.t1257 85.7148
R5512 VGND.t2349 VGND.n942 85.7148
R5513 VGND.t2357 VGND.t2104 85.7148
R5514 VGND.t2128 VGND.t641 85.7148
R5515 VGND.n969 VGND.t649 85.7148
R5516 VGND.n978 VGND.t1400 85.7148
R5517 VGND.n993 VGND.t322 85.7148
R5518 VGND.t1463 VGND.n362 85.7148
R5519 VGND.t100 VGND.n356 85.7148
R5520 VGND.n1036 VGND.t1445 85.7148
R5521 VGND.n1040 VGND.t668 85.7148
R5522 VGND.t857 VGND.n1017 85.7148
R5523 VGND.n1053 VGND.t840 85.7148
R5524 VGND.n1053 VGND.t2317 85.7148
R5525 VGND.n180 VGND.t271 85.7148
R5526 VGND.n284 VGND.t232 85.7148
R5527 VGND.n294 VGND.t35 85.7148
R5528 VGND.t176 VGND.n256 85.7148
R5529 VGND.n318 VGND.t737 85.7148
R5530 VGND.n325 VGND.t571 85.7148
R5531 VGND.n329 VGND.t304 85.7148
R5532 VGND.t377 VGND.n218 85.7148
R5533 VGND.n341 VGND.t465 85.7148
R5534 VGND.t449 VGND.n208 85.7148
R5535 VGND.t514 VGND.n200 85.7148
R5536 VGND.n1077 VGND.t62 85.7148
R5537 VGND.t49 VGND.n188 85.7148
R5538 VGND.t498 VGND.n186 85.7148
R5539 VGND.t787 VGND.n681 85.7148
R5540 VGND.n701 VGND.t606 85.7148
R5541 VGND.n703 VGND.t1059 85.7148
R5542 VGND.t19 VGND.n661 85.7148
R5543 VGND.t627 VGND.n832 85.7148
R5544 VGND.t1113 VGND.n812 85.7148
R5545 VGND.t359 VGND.n796 85.7148
R5546 VGND.n793 VGND.t543 85.7148
R5547 VGND.t950 VGND.n779 85.7148
R5548 VGND.t410 VGND.n753 85.7148
R5549 VGND.t482 VGND.n735 85.7148
R5550 VGND.t2175 VGND.n732 85.7148
R5551 VGND.t918 VGND.n508 82.6451
R5552 VGND.t1180 VGND.n515 82.6451
R5553 VGND.n596 VGND.t878 82.6451
R5554 VGND.n589 VGND.t1593 82.6451
R5555 VGND.t1555 VGND.n534 82.6451
R5556 VGND.n576 VGND.t1080 82.6451
R5557 VGND.n569 VGND.t1007 82.6451
R5558 VGND.n562 VGND.t1482 82.6451
R5559 VGND.n560 VGND.t1219 82.6451
R5560 VGND.t2092 VGND.t75 81.4291
R5561 VGND.t246 VGND.t38 77.1434
R5562 VGND.t40 VGND.t247 77.1434
R5563 VGND.t248 VGND.t41 77.1434
R5564 VGND.t1240 VGND.n393 77.1434
R5565 VGND.t2342 VGND.t1379 77.1434
R5566 VGND.t1380 VGND.t2343 77.1434
R5567 VGND.t2344 VGND.t1382 77.1434
R5568 VGND.t589 VGND.n360 77.1434
R5569 VGND.n287 VGND.t80 77.1434
R5570 VGND.n309 VGND.t123 77.1434
R5571 VGND.t436 VGND.t456 77.1434
R5572 VGND.t457 VGND.t437 77.1434
R5573 VGND.t438 VGND.t458 77.1434
R5574 VGND.t459 VGND.t439 77.1434
R5575 VGND.t440 VGND.t460 77.1434
R5576 VGND.t461 VGND.t441 77.1434
R5577 VGND.t442 VGND.t462 77.1434
R5578 VGND.t463 VGND.t443 77.1434
R5579 VGND.t444 VGND.t464 77.1434
R5580 VGND.t465 VGND.t445 77.1434
R5581 VGND.t446 VGND.t466 77.1434
R5582 VGND.t467 VGND.t448 77.1434
R5583 VGND.n706 VGND.t1065 77.1434
R5584 VGND.n827 VGND.t633 77.1434
R5585 VGND.n770 VGND.t809 77.1434
R5586 VGND.t2163 VGND.t473 77.1434
R5587 VGND.t2164 VGND.t474 77.1434
R5588 VGND.t2165 VGND.t475 77.1434
R5589 VGND.t2166 VGND.t476 77.1434
R5590 VGND.t2167 VGND.t477 77.1434
R5591 VGND.t2168 VGND.t478 77.1434
R5592 VGND.t2169 VGND.t479 77.1434
R5593 VGND.t2170 VGND.t480 77.1434
R5594 VGND.t2171 VGND.t481 77.1434
R5595 VGND.t2172 VGND.t482 77.1434
R5596 VGND.t2173 VGND.t483 77.1434
R5597 VGND.t2174 VGND.t484 77.1434
R5598 VGND.n859 VGND.t710 75.9499
R5599 VGND.t1299 VGND.n487 75.9499
R5600 VGND.n876 VGND.t1339 75.9499
R5601 VGND.t1617 VGND.n474 75.9499
R5602 VGND.n889 VGND.t1408 75.9499
R5603 VGND.t108 VGND.n905 75.9499
R5604 VGND.n935 VGND.t677 75.9499
R5605 VGND.n48 VGND.t1225 58.5742
R5606 VGND.n863 VGND.t717 70.5249
R5607 VGND.t1306 VGND.n483 70.5249
R5608 VGND.n872 VGND.t1331 70.5249
R5609 VGND.t1624 VGND.n470 70.5249
R5610 VGND.t574 VGND.n133 49.4882
R5611 VGND.n893 VGND.t1417 70.5249
R5612 VGND.n913 VGND.t116 70.5249
R5613 VGND.t684 VGND.n927 70.5249
R5614 VGND.t1797 VGND.n922 70.5249
R5615 VGND.n413 VGND.t201 68.5719
R5616 VGND.n420 VGND.t237 68.5719
R5617 VGND.n428 VGND.t1282 68.5719
R5618 VGND.t1316 VGND.n387 68.5719
R5619 VGND.n444 VGND.t1264 68.5719
R5620 VGND.t1247 VGND.n373 68.5719
R5621 VGND.n453 VGND.t2334 68.5719
R5622 VGND.n953 VGND.t2359 68.5719
R5623 VGND.t639 VGND.n958 68.5719
R5624 VGND.t1389 VGND.n967 68.5719
R5625 VGND.t312 VGND.n981 68.5719
R5626 VGND.t1452 VGND.n994 68.5719
R5627 VGND.t89 VGND.n347 68.5719
R5628 VGND.t1435 VGND.n1025 68.5719
R5629 VGND.t658 VGND.n1029 68.5719
R5630 VGND.t847 VGND.n1023 68.5719
R5631 VGND.t830 VGND.n1019 68.5719
R5632 VGND.t2327 VGND.n1007 68.5719
R5633 VGND.t261 VGND.n172 68.5719
R5634 VGND.n279 VGND.t813 68.5719
R5635 VGND.t25 VGND.n266 68.5719
R5636 VGND.n293 VGND.t166 68.5719
R5637 VGND.t149 VGND.n253 68.5719
R5638 VGND.t191 VGND.n248 68.5719
R5639 VGND.t726 VGND.n243 68.5719
R5640 VGND.n320 VGND.t561 68.5719
R5641 VGND.t294 VGND.n230 68.5719
R5642 VGND.n329 VGND.t365 68.5719
R5643 VGND.t455 VGND.n216 68.5719
R5644 VGND.n337 VGND.t438 68.5719
R5645 VGND.n1063 VGND.t504 68.5719
R5646 VGND.t48 VGND.n197 68.5719
R5647 VGND.n1077 VGND.t488 68.5719
R5648 VGND.n1086 VGND.t76 68.5719
R5649 VGND.n688 VGND.t777 68.5719
R5650 VGND.t596 VGND.n679 68.5719
R5651 VGND.n708 VGND.t2217 68.5719
R5652 VGND.n716 VGND.t129 68.5719
R5653 VGND.n721 VGND.t1759 68.5719
R5654 VGND.n823 VGND.t1103 68.5719
R5655 VGND.n807 VGND.t348 68.5719
R5656 VGND.n790 VGND.t940 68.5719
R5657 VGND.t554 VGND.n782 68.5719
R5658 VGND.n764 VGND.t400 68.5719
R5659 VGND.n746 VGND.t471 68.5719
R5660 VGND.n743 VGND.t2165 68.5719
R5661 VGND.n852 VGND.t907 66.1162
R5662 VGND.n608 VGND.t1169 66.1162
R5663 VGND.t868 VGND.n516 66.1162
R5664 VGND.t1583 VGND.n522 66.1162
R5665 VGND.n588 VGND.t1544 66.1162
R5666 VGND.t1070 VGND.n535 66.1162
R5667 VGND.t997 VGND.n541 66.1162
R5668 VGND.t1472 VGND.n547 66.1162
R5669 VGND.t1266 VGND.t2097 64.2862
R5670 VGND.n39 VGND.t1697 55.6713
R5671 VGND.n44 VGND.t2231 55.6672
R5672 VGND.t2230 VGND.n33 76.0633
R5673 VGND.t1630 VGND.n45 33.1245
R5674 VGND.n37 VGND.t1538 55.6695
R5675 VGND.t38 VGND.n399 60.0005
R5676 VGND.n426 VGND.t249 60.0005
R5677 VGND.n428 VGND.t1234 60.0005
R5678 VGND.n434 VGND.t1293 60.0005
R5679 VGND.t340 VGND.n382 60.0005
R5680 VGND.t1327 VGND.n381 60.0005
R5681 VGND.t1275 VGND.n373 60.0005
R5682 VGND.t1258 VGND.n367 60.0005
R5683 VGND.t1379 VGND.n365 60.0005
R5684 VGND.n459 VGND.t2345 60.0005
R5685 VGND.t2348 VGND.n941 60.0005
R5686 VGND.n970 VGND.t650 60.0005
R5687 VGND.n979 VGND.t1401 60.0005
R5688 VGND.n994 VGND.t323 60.0005
R5689 VGND.n998 VGND.t419 60.0005
R5690 VGND.n1005 VGND.t1464 60.0005
R5691 VGND.t102 VGND.n346 60.0005
R5692 VGND.n1037 VGND.t1446 60.0005
R5693 VGND.n1041 VGND.t669 60.0005
R5694 VGND.n1050 VGND.t858 60.0005
R5695 VGND.t2316 VGND.n1014 60.0005
R5696 VGND.t841 VGND.n1013 60.0005
R5697 VGND.t233 VGND.n269 60.0005
R5698 VGND.t36 VGND.n260 60.0005
R5699 VGND.n299 VGND.t177 60.0005
R5700 VGND.t739 VGND.n237 60.0005
R5701 VGND.t572 VGND.n227 60.0005
R5702 VGND.t305 VGND.n223 60.0005
R5703 VGND.t378 VGND.n217 60.0005
R5704 VGND.t466 VGND.n209 60.0005
R5705 VGND.n343 VGND.t451 60.0005
R5706 VGND.n1069 VGND.t515 60.0005
R5707 VGND.t63 VGND.n191 60.0005
R5708 VGND.n1080 VGND.t67 60.0005
R5709 VGND.n1083 VGND.t499 60.0005
R5710 VGND.n124 VGND.t788 74.4159
R5711 VGND.t607 VGND.n123 74.4159
R5712 VGND.t418 VGND.n672 60.0005
R5713 VGND.t1060 VGND.n670 60.0005
R5714 VGND.n713 VGND.t21 60.0005
R5715 VGND.n714 VGND.t2228 60.0005
R5716 VGND.n835 VGND.t539 60.0005
R5717 VGND.t628 VGND.n831 60.0005
R5718 VGND.t1114 VGND.n811 60.0005
R5719 VGND.t360 VGND.n795 60.0005
R5720 VGND.n111 VGND.t542 74.4158
R5721 VGND.t951 VGND.n778 60.0005
R5722 VGND.t805 VGND.n772 60.0005
R5723 VGND.t411 VGND.n752 60.0005
R5724 VGND.t483 VGND.n734 60.0005
R5725 VGND.t2176 VGND.n731 60.0005
R5726 VGND.t709 VGND.n497 59.675
R5727 VGND.n865 VGND.t1298 59.675
R5728 VGND.t1340 VGND.n477 59.675
R5729 VGND.n879 VGND.t1616 59.675
R5730 VGND.t1407 VGND.n466 59.675
R5731 VGND.t107 VGND.n904 59.675
R5732 VGND.n936 VGND.t676 59.675
R5733 VGND.n114 VGND.t919 72.2278
R5734 VGND.t1594 VGND.n59 72.2278
R5735 VGND.t1008 VGND.n117 72.2278
R5736 VGND.n561 VGND.t1231 57.8517
R5737 VGND.t1220 VGND.n557 57.8517
R5738 VGND.t81 VGND.n128 46.5768
R5739 VGND.t52 VGND.t2314 54.9227
R5740 VGND.t430 VGND.n82 54.9239
R5741 VGND.t718 VGND.n492 54.25
R5742 VGND.n870 VGND.t1307 54.25
R5743 VGND.t1330 VGND.n482 54.25
R5744 VGND.n884 VGND.t1625 54.25
R5745 VGND.n886 VGND.t576 54.25
R5746 VGND.t1418 VGND.n461 54.25
R5747 VGND.n895 VGND.t1424 54.25
R5748 VGND.n914 VGND.t117 54.25
R5749 VGND.t685 VGND.n926 54.25
R5750 VGND.t1798 VGND.n921 54.25
R5751 VGND.t1578 VGND.n115 45.2821
R5752 VGND.n65 VGND.t1580 1.56797
R5753 VGND.t329 VGND.t1314 51.4291
R5754 VGND.t1315 VGND.t330 51.4291
R5755 VGND.t331 VGND.t1316 51.4291
R5756 VGND.t1317 VGND.t332 51.4291
R5757 VGND.t333 VGND.t1318 51.4291
R5758 VGND.t1319 VGND.t334 51.4291
R5759 VGND.t335 VGND.t1320 51.4291
R5760 VGND.t1321 VGND.t336 51.4291
R5761 VGND.t337 VGND.t1322 51.4291
R5762 VGND.t1323 VGND.t338 51.4291
R5763 VGND.t339 VGND.t1324 51.4291
R5764 VGND.t1325 VGND.t340 51.4291
R5765 VGND.t341 VGND.t1326 51.4291
R5766 VGND.n1006 VGND.t1695 51.4291
R5767 VGND.t2130 VGND.n50 23.2337
R5768 VGND.t251 VGND.n268 51.4291
R5769 VGND.t2071 VGND.t2052 51.4291
R5770 VGND.t253 VGND.n246 51.4291
R5771 VGND.t2086 VGND.t2060 51.4291
R5772 VGND.t2215 VGND.t8 51.4291
R5773 VGND.t9 VGND.t2216 51.4291
R5774 VGND.t2217 VGND.t10 51.4291
R5775 VGND.t11 VGND.t2218 51.4291
R5776 VGND.t2219 VGND.t12 51.4291
R5777 VGND.t13 VGND.t2220 51.4291
R5778 VGND.t2221 VGND.t14 51.4291
R5779 VGND.t16 VGND.t2222 51.4291
R5780 VGND.t2223 VGND.t17 51.4291
R5781 VGND.t18 VGND.t2224 51.4291
R5782 VGND.t2225 VGND.t19 51.4291
R5783 VGND.t21 VGND.t2226 51.4291
R5784 VGND.t2227 VGND.t22 51.4291
R5785 VGND.t2027 VGND.t2005 51.4291
R5786 VGND.n771 VGND.t1378 51.4291
R5787 VGND.t2043 VGND.t2011 51.4291
R5788 VGND.t213 VGND.n139 42.9388
R5789 VGND.n119 VGND.t273 42.9373
R5790 VGND.n124 VGND.n82 1.93639
R5791 VGND.n82 VGND.n123 1.93639
R5792 VGND.t361 VGND.n794 50.637
R5793 VGND.t198 VGND.t103 50.6131
R5794 VGND.t2346 VGND.t198 50.6131
R5795 VGND.t516 VGND.n84 50.6131
R5796 VGND.n102 VGND.t740 50.6131
R5797 VGND.t178 VGND.n92 50.6131
R5798 VGND.t825 VGND.n96 50.6131
R5799 VGND.t1115 VGND.n810 50.6131
R5800 VGND.t250 VGND.n21 49.9891
R5801 VGND.t1294 VGND.n22 49.9891
R5802 VGND.t2229 VGND.n69 49.9891
R5803 VGND.t952 VGND.n777 49.9891
R5804 VGND.t412 VGND.n751 49.9891
R5805 VGND.n114 VGND.t1580 1.95338
R5806 VGND.t1182 VGND.n66 41.7623
R5807 VGND.n58 VGND.t880 41.7623
R5808 VGND.t1580 VGND.n59 1.95334
R5809 VGND.t1557 VGND.n64 41.7623
R5810 VGND.n62 VGND.t1082 41.7623
R5811 VGND.t1580 VGND.n117 1.95334
R5812 VGND.n118 VGND.t1484 41.7623
R5813 VGND.n127 VGND.t120 37.8723
R5814 VGND.t581 VGND.n38 236.103
R5815 VGND.n42 VGND.t1505 37.8701
R5816 VGND.t1430 VGND.n32 37.8702
R5817 VGND.t1803 VGND.n36 236.103
R5818 VGND.n858 VGND.t708 43.4001
R5819 VGND.t1297 VGND.n488 43.4001
R5820 VGND.n877 VGND.t1341 43.4001
R5821 VGND.t1615 VGND.n475 43.4001
R5822 VGND.n888 VGND.t1406 43.4001
R5823 VGND.t106 VGND.n903 43.4001
R5824 VGND.n937 VGND.t674 43.4001
R5825 VGND.t200 VGND.n411 42.8576
R5826 VGND.t236 VGND.n419 42.8576
R5827 VGND.t583 VGND.n403 42.8576
R5828 VGND.t1281 VGND.n396 42.8576
R5829 VGND.n430 VGND.t1239 42.8576
R5830 VGND.n435 VGND.t328 42.8576
R5831 VGND.n436 VGND.t1315 42.8576
R5832 VGND.t1263 VGND.n380 42.8576
R5833 VGND.n449 VGND.t1246 42.8576
R5834 VGND.t2333 VGND.n370 42.8576
R5835 VGND.t1388 VGND.n966 42.8576
R5836 VGND.t311 VGND.n980 42.8576
R5837 VGND.n987 VGND.t1466 42.8576
R5838 VGND.t1451 VGND.n993 42.8576
R5839 VGND.n359 VGND.t88 42.8576
R5840 VGND.t1434 VGND.n1024 42.8576
R5841 VGND.t657 VGND.n1028 42.8576
R5842 VGND.n1044 VGND.t846 42.8576
R5843 VGND.n1047 VGND.t829 42.8576
R5844 VGND.n1059 VGND.t2328 42.8576
R5845 VGND.n174 VGND.t260 42.8576
R5846 VGND.t812 VGND.n275 42.8576
R5847 VGND.n288 VGND.t24 42.8576
R5848 VGND.t165 VGND.n262 42.8576
R5849 VGND.t180 VGND.t147 42.8576
R5850 VGND.n301 VGND.t148 42.8576
R5851 VGND.t148 VGND.t181 42.8576
R5852 VGND.t182 VGND.t149 42.8576
R5853 VGND.t150 VGND.t183 42.8576
R5854 VGND.t184 VGND.t151 42.8576
R5855 VGND.t152 VGND.t185 42.8576
R5856 VGND.t186 VGND.t153 42.8576
R5857 VGND.t154 VGND.t187 42.8576
R5858 VGND.t188 VGND.t155 42.8576
R5859 VGND.t156 VGND.t189 42.8576
R5860 VGND.t190 VGND.t157 42.8576
R5861 VGND.t158 VGND.t191 42.8576
R5862 VGND.t192 VGND.t159 42.8576
R5863 VGND.n307 VGND.t192 42.8576
R5864 VGND.t160 VGND.t193 42.8576
R5865 VGND.n312 VGND.t725 42.8576
R5866 VGND.t560 VGND.n235 42.8576
R5867 VGND.n323 VGND.t293 42.8576
R5868 VGND.t364 VGND.n224 42.8576
R5869 VGND.n335 VGND.t454 42.8576
R5870 VGND.t437 VGND.n215 42.8576
R5871 VGND.t503 VGND.n206 42.8576
R5872 VGND.n1071 VGND.t47 42.8576
R5873 VGND.t487 VGND.n192 42.8576
R5874 VGND.t77 VGND.n181 42.8576
R5875 VGND.t776 VGND.n687 42.8576
R5876 VGND.n695 VGND.t595 42.8576
R5877 VGND.n703 VGND.t1199 42.8576
R5878 VGND.t1064 VGND.n668 42.8576
R5879 VGND.t7 VGND.n667 42.8576
R5880 VGND.t2216 VGND.n666 42.8576
R5881 VGND.t127 VGND.t1748 42.8576
R5882 VGND.t128 VGND.n657 42.8576
R5883 VGND.t1749 VGND.t128 42.8576
R5884 VGND.t129 VGND.t1750 42.8576
R5885 VGND.t1751 VGND.t130 42.8576
R5886 VGND.t131 VGND.t1752 42.8576
R5887 VGND.t1753 VGND.t132 42.8576
R5888 VGND.t133 VGND.t1754 42.8576
R5889 VGND.t1755 VGND.t135 42.8576
R5890 VGND.t136 VGND.t1756 42.8576
R5891 VGND.t1757 VGND.t137 42.8576
R5892 VGND.t138 VGND.t1758 42.8576
R5893 VGND.t1759 VGND.t140 42.8576
R5894 VGND.t141 VGND.t1760 42.8576
R5895 VGND.t1760 VGND.n651 42.8576
R5896 VGND.t1761 VGND.t142 42.8576
R5897 VGND.t431 VGND.n836 42.8576
R5898 VGND.n828 VGND.t632 42.8576
R5899 VGND.n824 VGND.t1102 42.8576
R5900 VGND.n808 VGND.t347 42.8576
R5901 VGND.n791 VGND.t939 42.8576
R5902 VGND.t555 VGND.n781 42.8576
R5903 VGND.n765 VGND.t399 42.8576
R5904 VGND.n747 VGND.t470 42.8576
R5905 VGND.n744 VGND.t2164 42.8576
R5906 VGND.t254 VGND.t198 42.0417
R5907 VGND.n97 VGND.t1226 42.0417
R5908 VGND.t906 VGND.n500 41.3228
R5909 VGND.t1168 VGND.n509 41.3228
R5910 VGND.n602 VGND.t867 41.3228
R5911 VGND.n595 VGND.t1582 41.3228
R5912 VGND.t1543 VGND.n528 41.3228
R5913 VGND.n582 VGND.t1069 41.3228
R5914 VGND.n575 VGND.t996 41.3228
R5915 VGND.n568 VGND.t1471 41.3228
R5916 VGND.t1224 VGND.n558 41.3228
R5917 VGND.n49 VGND.t1311 35.544
R5918 VGND.t590 VGND.n126 33.1268
R5919 VGND.t1502 VGND.n44 33.1245
R5920 VGND.t705 VGND.n17 1.71331
R5921 VGND.n39 VGND.t705 1.71332
R5922 VGND.n33 VGND.t705 2.3405
R5923 VGND.t705 VGND.n37 1.71327
R5924 VGND.t2113 VGND.t94 38.5719
R5925 VGND.t2083 VGND.t371 38.5719
R5926 VGND.t403 VGND.t2038 38.5719
R5927 VGND.t1308 VGND.n54 51.8056
R5928 VGND.n31 VGND.t1329 51.8082
R5929 VGND.t1626 VGND.n53 51.8056
R5930 VGND.t577 VGND.n469 37.9752
R5931 VGND.n41 VGND.t1420 51.8082
R5932 VGND.n896 VGND.t1425 37.9752
R5933 VGND.n60 VGND.t118 51.8056
R5934 VGND.t1574 VGND.n34 30.8593
R5935 VGND.t1799 VGND.n920 37.9752
R5936 VGND.t720 VGND.n138 30.6847
R5937 VGND.t687 VGND.n61 30.6816
R5938 VGND.n41 VGND.t705 2.18336
R5939 VGND.t705 VGND.n53 2.18611
R5940 VGND.t705 VGND.n54 2.18611
R5941 VGND.t705 VGND.n60 2.18611
R5942 VGND.n31 VGND.t705 2.18331
R5943 VGND.n425 VGND.t40 34.2862
R5944 VGND.t1235 VGND.n395 34.2862
R5945 VGND.n442 VGND.t341 34.2862
R5946 VGND.n443 VGND.t1328 34.2862
R5947 VGND.n450 VGND.t1276 34.2862
R5948 VGND.n456 VGND.t1259 34.2862
R5949 VGND.n458 VGND.t1380 34.2862
R5950 VGND.n56 VGND.t2347 42.9689
R5951 VGND.t634 VGND.t2360 34.2862
R5952 VGND.t638 VGND.t2363 34.2862
R5953 VGND.n971 VGND.t651 34.2862
R5954 VGND.t1402 VGND.n363 34.2862
R5955 VGND.n995 VGND.t324 34.2862
R5956 VGND.n999 VGND.t420 34.2862
R5957 VGND.t1465 VGND.n361 34.2862
R5958 VGND.n1038 VGND.t1447 34.2862
R5959 VGND.n1042 VGND.t670 34.2862
R5960 VGND.t859 VGND.n1016 34.2862
R5961 VGND.n1052 VGND.t2315 34.2862
R5962 VGND.n1054 VGND.t842 34.2862
R5963 VGND.n285 VGND.t234 34.2862
R5964 VGND.n295 VGND.t37 34.2862
R5965 VGND.n300 VGND.t179 34.2862
R5966 VGND.n308 VGND.t161 34.2862
R5967 VGND.n326 VGND.t573 34.2862
R5968 VGND.n330 VGND.t306 34.2862
R5969 VGND.n342 VGND.t467 34.2862
R5970 VGND.t452 VGND.n207 34.2862
R5971 VGND.t2091 VGND.t56 34.2862
R5972 VGND.n1078 VGND.t64 34.2862
R5973 VGND.t65 VGND.n189 34.2862
R5974 VGND.t500 VGND.n185 34.2862
R5975 VGND.n702 VGND.t417 34.2862
R5976 VGND.n704 VGND.t1061 34.2862
R5977 VGND.t22 VGND.n660 34.2862
R5978 VGND.t1731 VGND.n658 34.2862
R5979 VGND.t143 VGND.n650 34.2862
R5980 VGND.n836 VGND.t538 34.2862
R5981 VGND.t629 VGND.n830 34.2862
R5982 VGND.t806 VGND.n771 34.2862
R5983 VGND.t484 VGND.n733 34.2862
R5984 VGND.t2177 VGND.n730 34.2862
R5985 VGND.t1230 VGND.n554 33.0583
R5986 VGND.n559 VGND.t1221 33.0583
R5987 VGND.t79 VGND.t78 32.8822
R5988 VGND.t2329 VGND.t2330 32.8822
R5989 VGND.n20 VGND.t199 32.8462
R5990 VGND.t327 VGND.n19 32.8462
R5991 VGND.n23 VGND.t1262 32.8462
R5992 VGND.n25 VGND.t309 32.8462
R5993 VGND.t844 VGND.n1043 32.8462
R5994 VGND.t258 VGND.n107 32.8462
R5995 VGND.t23 VGND.n99 32.8462
R5996 VGND.t724 VGND.n101 32.8462
R5997 VGND.t453 VGND.n103 32.8462
R5998 VGND.n85 VGND.t502 32.8462
R5999 VGND.n74 VGND.t775 32.8462
R6000 VGND.t594 VGND.n75 32.8822
R6001 VGND.n77 VGND.t415 32.8462
R6002 VGND.n70 VGND.t6 32.8462
R6003 VGND.t536 VGND.n837 32.8462
R6004 VGND.n829 VGND.t631 32.8462
R6005 VGND.n122 VGND.t1101 32.8822
R6006 VGND.n809 VGND.t346 32.8462
R6007 VGND.n766 VGND.t398 32.8462
R6008 VGND.n748 VGND.t469 32.8462
R6009 VGND.t860 VGND.n55 46.695
R6010 VGND.n57 VGND.t1503 26.8652
R6011 VGND.t342 VGND.n6 26.8256
R6012 VGND.n15 VGND.t904 32.1879
R6013 VGND.n13 VGND.t1229 23.9743
R6014 VGND.n11 VGND.t1223 32.1879
R6015 VGND.t2047 VGND.t2067 30.0005
R6016 VGND.t2022 VGND.t2003 30.0005
R6017 VGND.t707 VGND.n498 27.1253
R6018 VGND.n864 VGND.t1296 27.1253
R6019 VGND.t1342 VGND.n476 27.1253
R6020 VGND.n18 VGND.t424 35.4519
R6021 VGND.n878 VGND.t1614 27.1253
R6022 VGND.t581 VGND.n468 27.1253
R6023 VGND.t1405 VGND.n467 27.1253
R6024 VGND.t1429 VGND.n899 27.1253
R6025 VGND.t105 VGND.n902 27.1253
R6026 VGND.n938 VGND.t673 27.1253
R6027 VGND.n917 VGND.t1803 27.1253
R6028 VGND.n35 VGND.t705 1.32546
R6029 VGND.t426 VGND.n18 23.0278
R6030 VGND.n2 VGND.t706 25.8876
R6031 VGND.t1295 VGND.n5 25.9568
R6032 VGND.t1613 VGND.n3 25.9568
R6033 VGND.n1 VGND.t580 25.8876
R6034 VGND.n0 VGND.t1404 25.9568
R6035 VGND.t1428 VGND.n898 25.8876
R6036 VGND.t104 VGND.n901 25.8876
R6037 VGND.n63 VGND.t671 25.9568
R6038 VGND.n924 VGND.t1577 25.8876
R6039 VGND.n918 VGND.t1802 25.8876
R6040 VGND.t811 VGND.t219 25.7148
R6041 VGND.t220 VGND.t812 25.7148
R6042 VGND.t813 VGND.t222 25.7148
R6043 VGND.t223 VGND.t814 25.7148
R6044 VGND.t815 VGND.t224 25.7148
R6045 VGND.t225 VGND.t816 25.7148
R6046 VGND.t817 VGND.t227 25.7148
R6047 VGND.t228 VGND.t818 25.7148
R6048 VGND.t819 VGND.t229 25.7148
R6049 VGND.t230 VGND.t820 25.7148
R6050 VGND.t821 VGND.t231 25.7148
R6051 VGND.t232 VGND.t822 25.7148
R6052 VGND.t823 VGND.t233 25.7148
R6053 VGND.t234 VGND.t824 25.7148
R6054 VGND.t434 VGND.t379 25.7148
R6055 VGND.n772 VGND.t121 25.7148
R6056 VGND.t197 VGND.n20 24.2748
R6057 VGND.n19 VGND.t325 24.2748
R6058 VGND.t1261 VGND.n23 24.2748
R6059 VGND.n25 VGND.t307 24.2748
R6060 VGND.n40 VGND.t1431 22.9122
R6061 VGND.n1043 VGND.t843 24.2748
R6062 VGND.n107 VGND.t256 24.2748
R6063 VGND.n99 VGND.t2 24.2748
R6064 VGND.n101 VGND.t722 24.2748
R6065 VGND.n103 VGND.t434 24.2748
R6066 VGND.t501 VGND.n85 24.2748
R6067 VGND.n74 VGND.t772 24.2748
R6068 VGND.t416 VGND.n77 24.2748
R6069 VGND.t4 VGND.n70 24.2748
R6070 VGND.n837 VGND.t537 24.2748
R6071 VGND.t630 VGND.n829 24.2748
R6072 VGND.t1099 VGND.n122 22.9131
R6073 VGND.t344 VGND.n809 24.2748
R6074 VGND.t397 VGND.n766 24.2748
R6075 VGND.t468 VGND.n748 24.2748
R6076 VGND.n15 VGND.t902 23.9234
R6077 VGND.n14 VGND.t1167 32.2258
R6078 VGND.t865 VGND.n7 32.2258
R6079 VGND.n113 VGND.t1579 22.5536
R6080 VGND.t1540 VGND.n125 22.5536
R6081 VGND.t1068 VGND.n8 32.2258
R6082 VGND.t995 VGND.n9 32.2258
R6083 VGND.t1470 VGND.n10 32.2258
R6084 VGND.t1222 VGND.n11 23.9234
R6085 VGND.n887 VGND.t578 21.7003
R6086 VGND.n897 VGND.t1426 21.7003
R6087 VGND.t1575 VGND.n925 21.7003
R6088 VGND.t1800 VGND.n919 21.7003
R6089 VGND.t2121 VGND.t2322 21.4291
R6090 VGND.t2062 VGND.t2088 21.4291
R6091 VGND.t704 VGND.n2 20.4626
R6092 VGND.t1343 VGND.n4 25.9568
R6093 VGND.t579 VGND.n1 20.4626
R6094 VGND.n898 VGND.t1427 20.4626
R6095 VGND.n901 VGND.t83 20.4626
R6096 VGND.t1576 VGND.n924 20.4626
R6097 VGND.t1801 VGND.n918 20.4626
R6098 VGND.t1504 VGND.t1580 19.4541
R6099 VGND.n775 VGND.t428 19.9891
R6100 VGND.t235 VGND.n404 17.1434
R6101 VGND.n421 VGND.t584 17.1434
R6102 VGND.n426 VGND.t42 17.1434
R6103 VGND.n427 VGND.t1280 17.1434
R6104 VGND.t1238 VGND.n394 17.1434
R6105 VGND.t1314 VGND.n388 17.1434
R6106 VGND.t1244 VGND.n374 17.1434
R6107 VGND.n452 VGND.t2332 17.1434
R6108 VGND.n459 VGND.t1383 17.1434
R6109 VGND.n955 VGND.t2362 17.1434
R6110 VGND.t636 VGND.n955 17.1434
R6111 VGND.t1387 VGND.n965 17.1434
R6112 VGND.n988 VGND.t1467 17.1434
R6113 VGND.t1450 VGND.n992 17.1434
R6114 VGND.t422 VGND.n1001 17.1434
R6115 VGND.n116 VGND.t87 32.8462
R6116 VGND.t656 VGND.n1027 17.1434
R6117 VGND.t828 VGND.n1020 17.1434
R6118 VGND.t218 VGND.n276 17.1434
R6119 VGND.n278 VGND.t811 17.1434
R6120 VGND.n292 VGND.t164 17.1434
R6121 VGND.t147 VGND.n254 17.1434
R6122 VGND.t193 VGND.n247 17.1434
R6123 VGND.n319 VGND.t559 17.1434
R6124 VGND.t292 VGND.n231 17.1434
R6125 VGND.n328 VGND.t363 17.1434
R6126 VGND.n336 VGND.t436 17.1434
R6127 VGND.t46 VGND.n199 17.1434
R6128 VGND.n1076 VGND.t486 17.1434
R6129 VGND.t1198 VGND.n671 17.1434
R6130 VGND.n705 VGND.t1063 17.1434
R6131 VGND.n707 VGND.t2215 17.1434
R6132 VGND.n715 VGND.t127 17.1434
R6133 VGND.n722 VGND.t1761 17.1434
R6134 VGND.t433 VGND.n835 17.1434
R6135 VGND.n792 VGND.t938 17.1434
R6136 VGND.t556 VGND.n780 17.1434
R6137 VGND.n769 VGND.t808 17.1434
R6138 VGND.n745 VGND.t2163 17.1434
R6139 VGND.n45 VGND.t705 1.71557
R6140 VGND.n61 VGND.t705 2.18606
R6141 VGND.n926 VGND.t705 17.0005
R6142 VGND.n927 VGND.t705 17.0005
R6143 VGND.n928 VGND.t705 17.0005
R6144 VGND.n929 VGND.t705 17.0005
R6145 VGND.n930 VGND.t705 17.0005
R6146 VGND.n931 VGND.t705 17.0005
R6147 VGND.n932 VGND.t705 17.0005
R6148 VGND.n933 VGND.t705 17.0005
R6149 VGND.n934 VGND.t705 17.0005
R6150 VGND.n935 VGND.t705 17.0005
R6151 VGND.n936 VGND.t705 17.0005
R6152 VGND.n937 VGND.t705 17.0005
R6153 VGND.n938 VGND.t705 17.0005
R6154 VGND.n36 VGND.t705 13.1865
R6155 VGND.n917 VGND.t705 17.0005
R6156 VGND.n919 VGND.t705 17.0005
R6157 VGND.n920 VGND.t705 17.0005
R6158 VGND.n921 VGND.t705 17.0005
R6159 VGND.n922 VGND.t705 17.0005
R6160 VGND.n925 VGND.t705 17.0005
R6161 VGND.n914 VGND.t705 17.0005
R6162 VGND.n913 VGND.t705 17.0005
R6163 VGND.n912 VGND.t705 17.0005
R6164 VGND.n911 VGND.t705 17.0005
R6165 VGND.n910 VGND.t705 17.0005
R6166 VGND.n909 VGND.t705 17.0005
R6167 VGND.n908 VGND.t705 17.0005
R6168 VGND.n907 VGND.t705 17.0005
R6169 VGND.n906 VGND.t705 17.0005
R6170 VGND.n905 VGND.t705 17.0005
R6171 VGND.n904 VGND.t705 17.0005
R6172 VGND.n903 VGND.t705 17.0005
R6173 VGND.n902 VGND.t705 17.0005
R6174 VGND.n899 VGND.t705 17.0005
R6175 VGND.n897 VGND.t705 17.0005
R6176 VGND.n896 VGND.t705 17.0005
R6177 VGND.n895 VGND.t705 17.0005
R6178 VGND.n46 VGND.t705 11.9295
R6179 VGND.t705 VGND.n57 1.87175
R6180 VGND.t705 VGND.n461 17.0005
R6181 VGND.t705 VGND.n893 17.0005
R6182 VGND.t705 VGND.n462 17.0005
R6183 VGND.t705 VGND.n892 17.0005
R6184 VGND.t705 VGND.n463 17.0005
R6185 VGND.t705 VGND.n891 17.0005
R6186 VGND.t705 VGND.n464 17.0005
R6187 VGND.t705 VGND.n890 17.0005
R6188 VGND.t705 VGND.n465 17.0005
R6189 VGND.t705 VGND.n889 17.0005
R6190 VGND.t705 VGND.n466 17.0005
R6191 VGND.t705 VGND.n888 17.0005
R6192 VGND.t705 VGND.n467 17.0005
R6193 VGND.t705 VGND.n38 13.1865
R6194 VGND.t705 VGND.n468 17.0005
R6195 VGND.t705 VGND.n887 17.0005
R6196 VGND.t705 VGND.n469 17.0005
R6197 VGND.t705 VGND.n886 17.0005
R6198 VGND.n151 VGND.t705 5.64548
R6199 VGND.n885 VGND.t705 17.0005
R6200 VGND.t705 VGND.n884 17.0005
R6201 VGND.t705 VGND.n470 17.0005
R6202 VGND.t705 VGND.n883 17.0005
R6203 VGND.t705 VGND.n471 17.0005
R6204 VGND.t705 VGND.n882 17.0005
R6205 VGND.t705 VGND.n472 17.0005
R6206 VGND.t705 VGND.n881 17.0005
R6207 VGND.t705 VGND.n473 17.0005
R6208 VGND.t705 VGND.n880 17.0005
R6209 VGND.t705 VGND.n474 17.0005
R6210 VGND.t705 VGND.n879 17.0005
R6211 VGND.t705 VGND.n475 17.0005
R6212 VGND.t705 VGND.n878 17.0005
R6213 VGND.t705 VGND.n476 17.0005
R6214 VGND.t705 VGND.n877 17.0005
R6215 VGND.t705 VGND.n477 17.0005
R6216 VGND.t705 VGND.n876 17.0005
R6217 VGND.t705 VGND.n478 17.0005
R6218 VGND.t705 VGND.n875 17.0005
R6219 VGND.t705 VGND.n479 17.0005
R6220 VGND.t705 VGND.n874 17.0005
R6221 VGND.t705 VGND.n480 17.0005
R6222 VGND.t705 VGND.n873 17.0005
R6223 VGND.t705 VGND.n481 17.0005
R6224 VGND.t705 VGND.n872 17.0005
R6225 VGND.t705 VGND.n482 17.0005
R6226 VGND.n871 VGND.t705 17.0005
R6227 VGND.t705 VGND.n870 17.0005
R6228 VGND.t705 VGND.n483 17.0005
R6229 VGND.t705 VGND.n869 17.0005
R6230 VGND.t705 VGND.n484 17.0005
R6231 VGND.t705 VGND.n868 17.0005
R6232 VGND.t705 VGND.n485 17.0005
R6233 VGND.t705 VGND.n867 17.0005
R6234 VGND.t705 VGND.n486 17.0005
R6235 VGND.t705 VGND.n866 17.0005
R6236 VGND.t705 VGND.n487 17.0005
R6237 VGND.t705 VGND.n865 17.0005
R6238 VGND.t705 VGND.n488 17.0005
R6239 VGND.t705 VGND.n864 17.0005
R6240 VGND.t705 VGND.n6 1.86898
R6241 VGND.t705 VGND.n16 13.1865
R6242 VGND.t705 VGND.n126 1.71548
R6243 VGND.t705 VGND.n138 2.18628
R6244 VGND.t705 VGND.n492 17.0005
R6245 VGND.t705 VGND.n863 17.0005
R6246 VGND.t705 VGND.n493 17.0005
R6247 VGND.t705 VGND.n862 17.0005
R6248 VGND.t705 VGND.n494 17.0005
R6249 VGND.t705 VGND.n861 17.0005
R6250 VGND.t705 VGND.n495 17.0005
R6251 VGND.t705 VGND.n860 17.0005
R6252 VGND.t705 VGND.n496 17.0005
R6253 VGND.t705 VGND.n859 17.0005
R6254 VGND.t705 VGND.n497 17.0005
R6255 VGND.t705 VGND.n858 17.0005
R6256 VGND.t705 VGND.n498 17.0005
R6257 VGND.t705 VGND.n857 17.0005
R6258 VGND.t198 VGND.n941 17.0005
R6259 VGND.t198 VGND.n56 7.66905
R6260 VGND.t198 VGND.n363 17.0005
R6261 VGND.t198 VGND.n979 17.0005
R6262 VGND.n978 VGND.t198 17.0005
R6263 VGND.t198 VGND.n977 17.0005
R6264 VGND.t198 VGND.n976 17.0005
R6265 VGND.t198 VGND.n975 17.0005
R6266 VGND.t198 VGND.n974 17.0005
R6267 VGND.t198 VGND.n973 17.0005
R6268 VGND.t198 VGND.n972 17.0005
R6269 VGND.t198 VGND.n971 17.0005
R6270 VGND.t198 VGND.n970 17.0005
R6271 VGND.t198 VGND.n969 17.0005
R6272 VGND.t198 VGND.n968 17.0005
R6273 VGND.t198 VGND.n967 17.0005
R6274 VGND.t198 VGND.n966 17.0005
R6275 VGND.t198 VGND.n965 17.0005
R6276 VGND.t198 VGND.n964 17.0005
R6277 VGND.t198 VGND.n963 17.0005
R6278 VGND.t198 VGND.n962 17.0005
R6279 VGND.t198 VGND.n961 17.0005
R6280 VGND.t198 VGND.n960 17.0005
R6281 VGND.t198 VGND.n959 17.0005
R6282 VGND.t198 VGND.n958 17.0005
R6283 VGND.t198 VGND.n956 17.0005
R6284 VGND.t198 VGND.n955 17.0005
R6285 VGND.t198 VGND.n954 17.0005
R6286 VGND.t198 VGND.n953 17.0005
R6287 VGND.t198 VGND.n952 17.0005
R6288 VGND.t198 VGND.n951 17.0005
R6289 VGND.t198 VGND.n950 17.0005
R6290 VGND.t198 VGND.n949 17.0005
R6291 VGND.t198 VGND.n948 17.0005
R6292 VGND.t198 VGND.n947 17.0005
R6293 VGND.t198 VGND.n946 17.0005
R6294 VGND.t198 VGND.n945 17.0005
R6295 VGND.t198 VGND.n944 17.0005
R6296 VGND.t198 VGND.n943 17.0005
R6297 VGND.t198 VGND.n942 17.0005
R6298 VGND.t198 VGND.n980 17.0005
R6299 VGND.t198 VGND.n116 0.649813
R6300 VGND.t198 VGND.n1006 17.0005
R6301 VGND.t198 VGND.n360 17.0005
R6302 VGND.n132 VGND.t198 0.649813
R6303 VGND.t198 VGND.n361 17.0005
R6304 VGND.t198 VGND.n1005 17.0005
R6305 VGND.t198 VGND.n362 17.0005
R6306 VGND.t198 VGND.n1004 17.0005
R6307 VGND.n1003 VGND.t198 17.0005
R6308 VGND.t198 VGND.n1002 17.0005
R6309 VGND.t198 VGND.n1001 17.0005
R6310 VGND.t198 VGND.n1000 17.0005
R6311 VGND.t198 VGND.n999 17.0005
R6312 VGND.t198 VGND.n998 17.0005
R6313 VGND.t198 VGND.n997 17.0005
R6314 VGND.t198 VGND.n996 17.0005
R6315 VGND.t198 VGND.n995 17.0005
R6316 VGND.t198 VGND.n994 17.0005
R6317 VGND.t198 VGND.n993 17.0005
R6318 VGND.t198 VGND.n992 17.0005
R6319 VGND.t198 VGND.n991 17.0005
R6320 VGND.t198 VGND.n990 17.0005
R6321 VGND.t198 VGND.n989 17.0005
R6322 VGND.t198 VGND.n988 17.0005
R6323 VGND.t198 VGND.n987 17.0005
R6324 VGND.t198 VGND.n986 17.0005
R6325 VGND.t198 VGND.n985 17.0005
R6326 VGND.t198 VGND.n984 17.0005
R6327 VGND.t198 VGND.n983 17.0005
R6328 VGND.t198 VGND.n981 17.0005
R6329 VGND.t198 VGND.n347 17.0005
R6330 VGND.t198 VGND.n359 17.0005
R6331 VGND.t198 VGND.n346 17.0005
R6332 VGND.n356 VGND.t198 17.0005
R6333 VGND.n357 VGND.t198 17.0005
R6334 VGND.t198 VGND.n358 17.0005
R6335 VGND.t198 VGND.n355 17.0005
R6336 VGND.t198 VGND.n354 17.0005
R6337 VGND.t198 VGND.n353 17.0005
R6338 VGND.t198 VGND.n352 17.0005
R6339 VGND.t198 VGND.n351 17.0005
R6340 VGND.t198 VGND.n350 17.0005
R6341 VGND.t198 VGND.n349 17.0005
R6342 VGND.t198 VGND.n348 17.0005
R6343 VGND.t198 VGND.n155 17.0005
R6344 VGND.n1039 VGND.t198 17.0005
R6345 VGND.n1038 VGND.t198 17.0005
R6346 VGND.n1037 VGND.t198 17.0005
R6347 VGND.n1036 VGND.t198 17.0005
R6348 VGND.n1035 VGND.t198 17.0005
R6349 VGND.n1034 VGND.t198 17.0005
R6350 VGND.n1033 VGND.t198 17.0005
R6351 VGND.n1032 VGND.t198 17.0005
R6352 VGND.n1031 VGND.t198 17.0005
R6353 VGND.n1030 VGND.t198 17.0005
R6354 VGND.n1029 VGND.t198 17.0005
R6355 VGND.n1028 VGND.t198 17.0005
R6356 VGND.n1027 VGND.t198 17.0005
R6357 VGND.n1026 VGND.t198 17.0005
R6358 VGND.n1025 VGND.t198 17.0005
R6359 VGND.n1024 VGND.t198 17.0005
R6360 VGND.n1041 VGND.t198 17.0005
R6361 VGND.n1040 VGND.t198 17.0005
R6362 VGND.t198 VGND.n1059 17.0005
R6363 VGND.t198 VGND.n1007 17.0005
R6364 VGND.t198 VGND.n1058 17.0005
R6365 VGND.t198 VGND.n1008 17.0005
R6366 VGND.t198 VGND.n1057 17.0005
R6367 VGND.t198 VGND.n1010 17.0005
R6368 VGND.t198 VGND.n1056 17.0005
R6369 VGND.t198 VGND.n1011 17.0005
R6370 VGND.t198 VGND.n1055 17.0005
R6371 VGND.t198 VGND.n1012 17.0005
R6372 VGND.t198 VGND.n1054 17.0005
R6373 VGND.t198 VGND.n1013 17.0005
R6374 VGND.t198 VGND.n1053 17.0005
R6375 VGND.t198 VGND.n1014 17.0005
R6376 VGND.t198 VGND.n1052 17.0005
R6377 VGND.t198 VGND.n1015 17.0005
R6378 VGND.t198 VGND.n1051 17.0005
R6379 VGND.t198 VGND.n1016 17.0005
R6380 VGND.t198 VGND.n1050 17.0005
R6381 VGND.t198 VGND.n1017 17.0005
R6382 VGND.t198 VGND.n1049 17.0005
R6383 VGND.t198 VGND.n1018 17.0005
R6384 VGND.t198 VGND.n1048 17.0005
R6385 VGND.t198 VGND.n1019 17.0005
R6386 VGND.t198 VGND.n1047 17.0005
R6387 VGND.t198 VGND.n1020 17.0005
R6388 VGND.t198 VGND.n1046 17.0005
R6389 VGND.t198 VGND.n1021 17.0005
R6390 VGND.t198 VGND.n1022 17.0005
R6391 VGND.t198 VGND.n1045 17.0005
R6392 VGND.t198 VGND.n1023 17.0005
R6393 VGND.t198 VGND.n1044 17.0005
R6394 VGND.n1060 VGND.t198 17.0005
R6395 VGND.n1042 VGND.t198 17.0005
R6396 VGND.t198 VGND.n459 17.0005
R6397 VGND.t198 VGND.n364 17.0005
R6398 VGND.t198 VGND.n458 17.0005
R6399 VGND.t198 VGND.n365 17.0005
R6400 VGND.t198 VGND.n457 17.0005
R6401 VGND.t198 VGND.n366 17.0005
R6402 VGND.t198 VGND.n456 17.0005
R6403 VGND.t198 VGND.n367 17.0005
R6404 VGND.t198 VGND.n455 17.0005
R6405 VGND.t198 VGND.n368 17.0005
R6406 VGND.t198 VGND.n454 17.0005
R6407 VGND.t198 VGND.n369 17.0005
R6408 VGND.t198 VGND.n453 17.0005
R6409 VGND.t198 VGND.n370 17.0005
R6410 VGND.t198 VGND.n452 17.0005
R6411 VGND.t198 VGND.n371 17.0005
R6412 VGND.t198 VGND.n451 17.0005
R6413 VGND.t198 VGND.n372 17.0005
R6414 VGND.t198 VGND.n450 17.0005
R6415 VGND.t198 VGND.n373 17.0005
R6416 VGND.t198 VGND.n449 17.0005
R6417 VGND.t198 VGND.n374 17.0005
R6418 VGND.t198 VGND.n448 17.0005
R6419 VGND.t198 VGND.n375 17.0005
R6420 VGND.t198 VGND.n376 17.0005
R6421 VGND.t198 VGND.n447 17.0005
R6422 VGND.t198 VGND.n377 17.0005
R6423 VGND.t198 VGND.n446 17.0005
R6424 VGND.t198 VGND.n378 17.0005
R6425 VGND.t198 VGND.n445 17.0005
R6426 VGND.t198 VGND.n379 17.0005
R6427 VGND.t198 VGND.n444 17.0005
R6428 VGND.t198 VGND.n380 17.0005
R6429 VGND.t198 VGND.n443 17.0005
R6430 VGND.t198 VGND.n381 17.0005
R6431 VGND.t198 VGND.n442 17.0005
R6432 VGND.t198 VGND.n382 17.0005
R6433 VGND.t198 VGND.n441 17.0005
R6434 VGND.t198 VGND.n383 17.0005
R6435 VGND.t198 VGND.n440 17.0005
R6436 VGND.t198 VGND.n384 17.0005
R6437 VGND.t198 VGND.n439 17.0005
R6438 VGND.t198 VGND.n385 17.0005
R6439 VGND.t198 VGND.n438 17.0005
R6440 VGND.t198 VGND.n386 17.0005
R6441 VGND.t198 VGND.n437 17.0005
R6442 VGND.t198 VGND.n387 17.0005
R6443 VGND.t198 VGND.n436 17.0005
R6444 VGND.t198 VGND.n388 17.0005
R6445 VGND.t198 VGND.n435 17.0005
R6446 VGND.t198 VGND.n389 17.0005
R6447 VGND.t198 VGND.n434 17.0005
R6448 VGND.t198 VGND.n390 17.0005
R6449 VGND.t198 VGND.n433 17.0005
R6450 VGND.t198 VGND.n391 17.0005
R6451 VGND.t198 VGND.n432 17.0005
R6452 VGND.t198 VGND.n392 17.0005
R6453 VGND.t198 VGND.n431 17.0005
R6454 VGND.t198 VGND.n393 17.0005
R6455 VGND.t198 VGND.n430 17.0005
R6456 VGND.t198 VGND.n394 17.0005
R6457 VGND.t198 VGND.n429 17.0005
R6458 VGND.t198 VGND.n395 17.0005
R6459 VGND.t198 VGND.n428 17.0005
R6460 VGND.t198 VGND.n396 17.0005
R6461 VGND.t198 VGND.n427 17.0005
R6462 VGND.t198 VGND.n397 17.0005
R6463 VGND.t198 VGND.n426 17.0005
R6464 VGND.t198 VGND.n398 17.0005
R6465 VGND.t198 VGND.n425 17.0005
R6466 VGND.t198 VGND.n399 17.0005
R6467 VGND.t198 VGND.n424 17.0005
R6468 VGND.t198 VGND.n400 17.0005
R6469 VGND.t198 VGND.n423 17.0005
R6470 VGND.t198 VGND.n401 17.0005
R6471 VGND.t198 VGND.n422 17.0005
R6472 VGND.t198 VGND.n402 17.0005
R6473 VGND.t198 VGND.n421 17.0005
R6474 VGND.t198 VGND.n403 17.0005
R6475 VGND.t198 VGND.n420 17.0005
R6476 VGND.t198 VGND.n419 17.0005
R6477 VGND.t198 VGND.n404 17.0005
R6478 VGND.t198 VGND.n139 1.93645
R6479 VGND.t198 VGND.n405 17.0005
R6480 VGND.t198 VGND.n418 17.0005
R6481 VGND.t198 VGND.n406 17.0005
R6482 VGND.t198 VGND.n417 17.0005
R6483 VGND.t198 VGND.n407 17.0005
R6484 VGND.t198 VGND.n416 17.0005
R6485 VGND.t198 VGND.n408 17.0005
R6486 VGND.t198 VGND.n415 17.0005
R6487 VGND.t198 VGND.n409 17.0005
R6488 VGND.t198 VGND.n414 17.0005
R6489 VGND.t198 VGND.n410 17.0005
R6490 VGND.t198 VGND.n413 17.0005
R6491 VGND.t198 VGND.n411 17.0005
R6492 VGND.t198 VGND.n412 17.0005
R6493 VGND.n853 VGND.t1580 17.0005
R6494 VGND.t1580 VGND.n500 17.0005
R6495 VGND.t1580 VGND.n852 17.0005
R6496 VGND.t1580 VGND.n503 17.0005
R6497 VGND.t1580 VGND.n851 17.0005
R6498 VGND.t1580 VGND.n504 17.0005
R6499 VGND.t1580 VGND.n850 17.0005
R6500 VGND.t1580 VGND.n505 17.0005
R6501 VGND.t1580 VGND.n849 17.0005
R6502 VGND.t1580 VGND.n506 17.0005
R6503 VGND.t1580 VGND.n848 17.0005
R6504 VGND.t1580 VGND.n507 17.0005
R6505 VGND.t1580 VGND.n847 17.0005
R6506 VGND.t1580 VGND.n508 17.0005
R6507 VGND.t1580 VGND.n509 17.0005
R6508 VGND.t1580 VGND.n608 17.0005
R6509 VGND.t1580 VGND.n510 17.0005
R6510 VGND.t1580 VGND.n607 17.0005
R6511 VGND.t1580 VGND.n511 17.0005
R6512 VGND.t1580 VGND.n606 17.0005
R6513 VGND.t1580 VGND.n512 17.0005
R6514 VGND.t1580 VGND.n605 17.0005
R6515 VGND.t1580 VGND.n513 17.0005
R6516 VGND.t1580 VGND.n604 17.0005
R6517 VGND.t1580 VGND.n514 17.0005
R6518 VGND.t1580 VGND.n603 17.0005
R6519 VGND.t1580 VGND.n515 17.0005
R6520 VGND.t1580 VGND.n66 1.95334
R6521 VGND.t1580 VGND.n602 17.0005
R6522 VGND.t1580 VGND.n516 17.0005
R6523 VGND.t1580 VGND.n601 17.0005
R6524 VGND.t1580 VGND.n517 17.0005
R6525 VGND.t1580 VGND.n600 17.0005
R6526 VGND.t1580 VGND.n518 17.0005
R6527 VGND.t1580 VGND.n599 17.0005
R6528 VGND.t1580 VGND.n519 17.0005
R6529 VGND.t1580 VGND.n598 17.0005
R6530 VGND.t1580 VGND.n520 17.0005
R6531 VGND.t1580 VGND.n597 17.0005
R6532 VGND.t1580 VGND.n521 17.0005
R6533 VGND.t1580 VGND.n596 17.0005
R6534 VGND.t1580 VGND.n58 1.95334
R6535 VGND.t1580 VGND.n595 17.0005
R6536 VGND.t1580 VGND.n522 17.0005
R6537 VGND.t1580 VGND.n594 17.0005
R6538 VGND.t1580 VGND.n523 17.0005
R6539 VGND.t1580 VGND.n593 17.0005
R6540 VGND.t1580 VGND.n524 17.0005
R6541 VGND.t1580 VGND.n592 17.0005
R6542 VGND.t1580 VGND.n525 17.0005
R6543 VGND.t1580 VGND.n591 17.0005
R6544 VGND.t1580 VGND.n526 17.0005
R6545 VGND.t1580 VGND.n590 17.0005
R6546 VGND.t1580 VGND.n527 17.0005
R6547 VGND.t1580 VGND.n589 17.0005
R6548 VGND.t1580 VGND.n528 17.0005
R6549 VGND.t1580 VGND.n588 17.0005
R6550 VGND.t1580 VGND.n529 17.0005
R6551 VGND.t1580 VGND.n587 17.0005
R6552 VGND.t1580 VGND.n530 17.0005
R6553 VGND.t1580 VGND.n586 17.0005
R6554 VGND.t1580 VGND.n531 17.0005
R6555 VGND.t1580 VGND.n585 17.0005
R6556 VGND.t1580 VGND.n532 17.0005
R6557 VGND.t1580 VGND.n584 17.0005
R6558 VGND.t1580 VGND.n533 17.0005
R6559 VGND.t1580 VGND.n583 17.0005
R6560 VGND.t1580 VGND.n534 17.0005
R6561 VGND.t1580 VGND.n64 1.95334
R6562 VGND.t1580 VGND.n582 17.0005
R6563 VGND.t1580 VGND.n535 17.0005
R6564 VGND.t1580 VGND.n581 17.0005
R6565 VGND.t1580 VGND.n536 17.0005
R6566 VGND.t1580 VGND.n580 17.0005
R6567 VGND.t1580 VGND.n537 17.0005
R6568 VGND.t1580 VGND.n579 17.0005
R6569 VGND.t1580 VGND.n538 17.0005
R6570 VGND.t1580 VGND.n578 17.0005
R6571 VGND.t1580 VGND.n539 17.0005
R6572 VGND.t1580 VGND.n577 17.0005
R6573 VGND.t1580 VGND.n540 17.0005
R6574 VGND.t1580 VGND.n576 17.0005
R6575 VGND.t1580 VGND.n62 1.95334
R6576 VGND.t1580 VGND.n575 17.0005
R6577 VGND.t1580 VGND.n541 17.0005
R6578 VGND.t1580 VGND.n574 17.0005
R6579 VGND.t1580 VGND.n542 17.0005
R6580 VGND.t1580 VGND.n573 17.0005
R6581 VGND.t1580 VGND.n543 17.0005
R6582 VGND.t1580 VGND.n572 17.0005
R6583 VGND.t1580 VGND.n544 17.0005
R6584 VGND.t1580 VGND.n571 17.0005
R6585 VGND.t1580 VGND.n545 17.0005
R6586 VGND.t1580 VGND.n570 17.0005
R6587 VGND.t1580 VGND.n546 17.0005
R6588 VGND.t1580 VGND.n569 17.0005
R6589 VGND.t1580 VGND.n568 17.0005
R6590 VGND.t1580 VGND.n547 17.0005
R6591 VGND.t1580 VGND.n567 17.0005
R6592 VGND.t1580 VGND.n548 17.0005
R6593 VGND.t1580 VGND.n566 17.0005
R6594 VGND.t1580 VGND.n549 17.0005
R6595 VGND.t1580 VGND.n565 17.0005
R6596 VGND.t1580 VGND.n550 17.0005
R6597 VGND.t1580 VGND.n564 17.0005
R6598 VGND.t1580 VGND.n551 17.0005
R6599 VGND.t1580 VGND.n563 17.0005
R6600 VGND.t1580 VGND.n553 17.0005
R6601 VGND.t1580 VGND.n562 17.0005
R6602 VGND.t1580 VGND.n118 1.95334
R6603 VGND.t1580 VGND.n135 13.3885
R6604 VGND.t1580 VGND.n49 1.62571
R6605 VGND.t1580 VGND.n554 17.0005
R6606 VGND.t1580 VGND.n561 17.0005
R6607 VGND.t1580 VGND.n556 17.0005
R6608 VGND.t1580 VGND.n560 17.0005
R6609 VGND.t1580 VGND.n557 17.0005
R6610 VGND.t1580 VGND.n559 17.0005
R6611 VGND.t1580 VGND.n558 17.0005
R6612 VGND.t52 VGND.n181 17.0005
R6613 VGND.t52 VGND.n1086 17.0005
R6614 VGND.t52 VGND.n182 17.0005
R6615 VGND.t52 VGND.n1085 17.0005
R6616 VGND.t52 VGND.n183 17.0005
R6617 VGND.t52 VGND.n1084 17.0005
R6618 VGND.t52 VGND.n185 17.0005
R6619 VGND.t52 VGND.n1083 17.0005
R6620 VGND.t52 VGND.n186 17.0005
R6621 VGND.t52 VGND.n1082 17.0005
R6622 VGND.t52 VGND.n187 17.0005
R6623 VGND.t52 VGND.n1081 17.0005
R6624 VGND.t52 VGND.n188 17.0005
R6625 VGND.t52 VGND.n1080 17.0005
R6626 VGND.t52 VGND.n189 17.0005
R6627 VGND.t52 VGND.n1079 17.0005
R6628 VGND.t52 VGND.n190 17.0005
R6629 VGND.t52 VGND.n1078 17.0005
R6630 VGND.t52 VGND.n191 17.0005
R6631 VGND.t52 VGND.n1077 17.0005
R6632 VGND.t52 VGND.n192 17.0005
R6633 VGND.t52 VGND.n1076 17.0005
R6634 VGND.t52 VGND.n193 17.0005
R6635 VGND.t52 VGND.n1075 17.0005
R6636 VGND.t52 VGND.n194 17.0005
R6637 VGND.t52 VGND.n1074 17.0005
R6638 VGND.t52 VGND.n195 17.0005
R6639 VGND.t52 VGND.n1073 17.0005
R6640 VGND.t52 VGND.n196 17.0005
R6641 VGND.t52 VGND.n1072 17.0005
R6642 VGND.t52 VGND.n197 17.0005
R6643 VGND.t52 VGND.n1071 17.0005
R6644 VGND.t52 VGND.n199 17.0005
R6645 VGND.t52 VGND.n1070 17.0005
R6646 VGND.t52 VGND.n1069 17.0005
R6647 VGND.t52 VGND.n200 17.0005
R6648 VGND.t52 VGND.n1068 17.0005
R6649 VGND.t52 VGND.n201 17.0005
R6650 VGND.t52 VGND.n1067 17.0005
R6651 VGND.t52 VGND.n202 17.0005
R6652 VGND.t52 VGND.n1066 17.0005
R6653 VGND.t52 VGND.n203 17.0005
R6654 VGND.t52 VGND.n1065 17.0005
R6655 VGND.t52 VGND.n204 17.0005
R6656 VGND.t52 VGND.n1064 17.0005
R6657 VGND.t52 VGND.n205 17.0005
R6658 VGND.t52 VGND.n1063 17.0005
R6659 VGND.t52 VGND.n206 17.0005
R6660 VGND.t52 VGND.n344 17.0005
R6661 VGND.t52 VGND.n207 17.0005
R6662 VGND.t52 VGND.n343 17.0005
R6663 VGND.t52 VGND.n208 17.0005
R6664 VGND.t52 VGND.n342 17.0005
R6665 VGND.t52 VGND.n209 17.0005
R6666 VGND.t52 VGND.n341 17.0005
R6667 VGND.t52 VGND.n210 17.0005
R6668 VGND.t52 VGND.n340 17.0005
R6669 VGND.t52 VGND.n211 17.0005
R6670 VGND.t52 VGND.n339 17.0005
R6671 VGND.t52 VGND.n212 17.0005
R6672 VGND.t52 VGND.n338 17.0005
R6673 VGND.t52 VGND.n213 17.0005
R6674 VGND.t52 VGND.n337 17.0005
R6675 VGND.t52 VGND.n215 17.0005
R6676 VGND.t52 VGND.n336 17.0005
R6677 VGND.t52 VGND.n216 17.0005
R6678 VGND.t52 VGND.n335 17.0005
R6679 VGND.t52 VGND.n217 17.0005
R6680 VGND.t52 VGND.n218 17.0005
R6681 VGND.t52 VGND.n334 17.0005
R6682 VGND.t52 VGND.n219 17.0005
R6683 VGND.t52 VGND.n333 17.0005
R6684 VGND.t52 VGND.n220 17.0005
R6685 VGND.t52 VGND.n332 17.0005
R6686 VGND.t52 VGND.n221 17.0005
R6687 VGND.t52 VGND.n331 17.0005
R6688 VGND.t52 VGND.n222 17.0005
R6689 VGND.t52 VGND.n330 17.0005
R6690 VGND.t52 VGND.n223 17.0005
R6691 VGND.t52 VGND.n329 17.0005
R6692 VGND.t52 VGND.n224 17.0005
R6693 VGND.t52 VGND.n328 17.0005
R6694 VGND.t52 VGND.n225 17.0005
R6695 VGND.t52 VGND.n327 17.0005
R6696 VGND.t52 VGND.n226 17.0005
R6697 VGND.t52 VGND.n326 17.0005
R6698 VGND.t52 VGND.n227 17.0005
R6699 VGND.t52 VGND.n325 17.0005
R6700 VGND.t52 VGND.n229 17.0005
R6701 VGND.t52 VGND.n324 17.0005
R6702 VGND.t52 VGND.n230 17.0005
R6703 VGND.t52 VGND.n323 17.0005
R6704 VGND.t52 VGND.n231 17.0005
R6705 VGND.t52 VGND.n322 17.0005
R6706 VGND.t52 VGND.n232 17.0005
R6707 VGND.t52 VGND.n233 17.0005
R6708 VGND.t52 VGND.n321 17.0005
R6709 VGND.t52 VGND.n234 17.0005
R6710 VGND.t52 VGND.n320 17.0005
R6711 VGND.t52 VGND.n235 17.0005
R6712 VGND.t52 VGND.n319 17.0005
R6713 VGND.t52 VGND.n236 17.0005
R6714 VGND.t52 VGND.n237 17.0005
R6715 VGND.t52 VGND.n318 17.0005
R6716 VGND.t52 VGND.n238 17.0005
R6717 VGND.t52 VGND.n317 17.0005
R6718 VGND.t52 VGND.n239 17.0005
R6719 VGND.t52 VGND.n316 17.0005
R6720 VGND.t52 VGND.n240 17.0005
R6721 VGND.t52 VGND.n315 17.0005
R6722 VGND.t52 VGND.n241 17.0005
R6723 VGND.t52 VGND.n314 17.0005
R6724 VGND.t52 VGND.n242 17.0005
R6725 VGND.t52 VGND.n313 17.0005
R6726 VGND.t52 VGND.n243 17.0005
R6727 VGND.t52 VGND.n312 17.0005
R6728 VGND.t52 VGND.n311 17.0005
R6729 VGND.t52 VGND.n310 17.0005
R6730 VGND.t52 VGND.n245 17.0005
R6731 VGND.t52 VGND.n309 17.0005
R6732 VGND.t52 VGND.n246 17.0005
R6733 VGND.t52 VGND.n308 17.0005
R6734 VGND.t52 VGND.n247 17.0005
R6735 VGND.t52 VGND.n307 17.0005
R6736 VGND.t52 VGND.n248 17.0005
R6737 VGND.t52 VGND.n306 17.0005
R6738 VGND.t52 VGND.n249 17.0005
R6739 VGND.t52 VGND.n305 17.0005
R6740 VGND.t52 VGND.n250 17.0005
R6741 VGND.t52 VGND.n304 17.0005
R6742 VGND.t52 VGND.n251 17.0005
R6743 VGND.t52 VGND.n303 17.0005
R6744 VGND.t52 VGND.n252 17.0005
R6745 VGND.t52 VGND.n302 17.0005
R6746 VGND.t52 VGND.n253 17.0005
R6747 VGND.t52 VGND.n301 17.0005
R6748 VGND.t52 VGND.n254 17.0005
R6749 VGND.t52 VGND.n300 17.0005
R6750 VGND.t52 VGND.n299 17.0005
R6751 VGND.t52 VGND.n256 17.0005
R6752 VGND.t52 VGND.n298 17.0005
R6753 VGND.t52 VGND.n257 17.0005
R6754 VGND.t52 VGND.n297 17.0005
R6755 VGND.t52 VGND.n258 17.0005
R6756 VGND.t52 VGND.n296 17.0005
R6757 VGND.t52 VGND.n259 17.0005
R6758 VGND.t52 VGND.n295 17.0005
R6759 VGND.t52 VGND.n260 17.0005
R6760 VGND.t52 VGND.n294 17.0005
R6761 VGND.t52 VGND.n261 17.0005
R6762 VGND.t52 VGND.n293 17.0005
R6763 VGND.t52 VGND.n262 17.0005
R6764 VGND.t52 VGND.n292 17.0005
R6765 VGND.t52 VGND.n263 17.0005
R6766 VGND.t52 VGND.n291 17.0005
R6767 VGND.t52 VGND.n264 17.0005
R6768 VGND.t52 VGND.n290 17.0005
R6769 VGND.t52 VGND.n265 17.0005
R6770 VGND.t52 VGND.n289 17.0005
R6771 VGND.t52 VGND.n266 17.0005
R6772 VGND.t52 VGND.n288 17.0005
R6773 VGND.t52 VGND.n267 17.0005
R6774 VGND.t52 VGND.n268 17.0005
R6775 VGND.t52 VGND.n287 17.0005
R6776 VGND.t52 VGND.n286 17.0005
R6777 VGND.t52 VGND.n285 17.0005
R6778 VGND.t52 VGND.n269 17.0005
R6779 VGND.t52 VGND.n284 17.0005
R6780 VGND.t52 VGND.n270 17.0005
R6781 VGND.t52 VGND.n283 17.0005
R6782 VGND.t52 VGND.n271 17.0005
R6783 VGND.t52 VGND.n282 17.0005
R6784 VGND.t52 VGND.n272 17.0005
R6785 VGND.t52 VGND.n281 17.0005
R6786 VGND.t52 VGND.n273 17.0005
R6787 VGND.t52 VGND.n280 17.0005
R6788 VGND.t52 VGND.n274 17.0005
R6789 VGND.t52 VGND.n279 17.0005
R6790 VGND.t52 VGND.n275 17.0005
R6791 VGND.t52 VGND.n278 17.0005
R6792 VGND.t52 VGND.n276 17.0005
R6793 VGND.t52 VGND.n277 17.0005
R6794 VGND.n130 VGND.t52 0.649813
R6795 VGND.t52 VGND.n166 17.0005
R6796 VGND.t52 VGND.n119 1.93639
R6797 VGND.t52 VGND.n180 17.0005
R6798 VGND.t52 VGND.n167 17.0005
R6799 VGND.t52 VGND.n179 17.0005
R6800 VGND.t52 VGND.n168 17.0005
R6801 VGND.t52 VGND.n178 17.0005
R6802 VGND.t52 VGND.n169 17.0005
R6803 VGND.t52 VGND.n177 17.0005
R6804 VGND.t52 VGND.n170 17.0005
R6805 VGND.t52 VGND.n176 17.0005
R6806 VGND.t52 VGND.n171 17.0005
R6807 VGND.t52 VGND.n175 17.0005
R6808 VGND.t52 VGND.n172 17.0005
R6809 VGND.t52 VGND.n174 17.0005
R6810 VGND.t52 VGND.n173 17.0005
R6811 VGND.n730 VGND.n82 17.0005
R6812 VGND.n731 VGND.n82 17.0005
R6813 VGND.n732 VGND.n82 17.0005
R6814 VGND.n733 VGND.n82 17.0005
R6815 VGND.n734 VGND.n82 17.0005
R6816 VGND.n735 VGND.n82 17.0005
R6817 VGND.n736 VGND.n82 17.0005
R6818 VGND.n737 VGND.n82 17.0005
R6819 VGND.n738 VGND.n82 17.0005
R6820 VGND.n739 VGND.n82 17.0005
R6821 VGND.n740 VGND.n82 17.0005
R6822 VGND.n741 VGND.n82 17.0005
R6823 VGND.n742 VGND.n82 17.0005
R6824 VGND.n743 VGND.n82 17.0005
R6825 VGND.n744 VGND.n82 17.0005
R6826 VGND.n745 VGND.n82 17.0005
R6827 VGND.n746 VGND.n82 17.0005
R6828 VGND.n747 VGND.n82 17.0005
R6829 VGND.n749 VGND.n82 17.0005
R6830 VGND.n752 VGND.n82 17.0005
R6831 VGND.n753 VGND.n82 17.0005
R6832 VGND.n754 VGND.n82 17.0005
R6833 VGND.n755 VGND.n82 17.0005
R6834 VGND.n756 VGND.n82 17.0005
R6835 VGND.n757 VGND.n82 17.0005
R6836 VGND.n758 VGND.n82 17.0005
R6837 VGND.n759 VGND.n82 17.0005
R6838 VGND.n760 VGND.n82 17.0005
R6839 VGND.n761 VGND.n82 17.0005
R6840 VGND.n762 VGND.n82 17.0005
R6841 VGND.n763 VGND.n82 17.0005
R6842 VGND.n764 VGND.n82 17.0005
R6843 VGND.n765 VGND.n82 17.0005
R6844 VGND.n769 VGND.n82 17.0005
R6845 VGND.n770 VGND.n82 17.0005
R6846 VGND.n771 VGND.n82 17.0005
R6847 VGND.n772 VGND.n82 17.0005
R6848 VGND.n778 VGND.n82 17.0005
R6849 VGND.n779 VGND.n82 17.0005
R6850 VGND.n780 VGND.n82 17.0005
R6851 VGND.n781 VGND.n82 17.0005
R6852 VGND.n782 VGND.n82 17.0005
R6853 VGND.n783 VGND.n82 17.0005
R6854 VGND.n784 VGND.n82 17.0005
R6855 VGND.n785 VGND.n82 17.0005
R6856 VGND.n786 VGND.n82 17.0005
R6857 VGND.n787 VGND.n82 17.0005
R6858 VGND.n788 VGND.n82 17.0005
R6859 VGND.n789 VGND.n82 17.0005
R6860 VGND.n790 VGND.n82 17.0005
R6861 VGND.n791 VGND.n82 17.0005
R6862 VGND.n792 VGND.n82 17.0005
R6863 VGND.n793 VGND.n82 17.0005
R6864 VGND.n795 VGND.n82 17.0005
R6865 VGND.n796 VGND.n82 17.0005
R6866 VGND.n797 VGND.n82 17.0005
R6867 VGND.n798 VGND.n82 17.0005
R6868 VGND.n799 VGND.n82 17.0005
R6869 VGND.n800 VGND.n82 17.0005
R6870 VGND.n801 VGND.n82 17.0005
R6871 VGND.n802 VGND.n82 17.0005
R6872 VGND.n803 VGND.n82 17.0005
R6873 VGND.n804 VGND.n82 17.0005
R6874 VGND.n805 VGND.n82 17.0005
R6875 VGND.n806 VGND.n82 17.0005
R6876 VGND.n807 VGND.n82 17.0005
R6877 VGND.n808 VGND.n82 17.0005
R6878 VGND.n811 VGND.n82 17.0005
R6879 VGND.n812 VGND.n82 17.0005
R6880 VGND.n813 VGND.n82 17.0005
R6881 VGND.n814 VGND.n82 17.0005
R6882 VGND.n815 VGND.n82 17.0005
R6883 VGND.n816 VGND.n82 17.0005
R6884 VGND.n817 VGND.n82 17.0005
R6885 VGND.n818 VGND.n82 17.0005
R6886 VGND.n819 VGND.n82 17.0005
R6887 VGND.n820 VGND.n82 17.0005
R6888 VGND.n821 VGND.n82 17.0005
R6889 VGND.n822 VGND.n82 17.0005
R6890 VGND.n823 VGND.n82 17.0005
R6891 VGND.n824 VGND.n82 17.0005
R6892 VGND.n827 VGND.n82 17.0005
R6893 VGND.n828 VGND.n82 17.0005
R6894 VGND.n830 VGND.n82 17.0005
R6895 VGND.n831 VGND.n82 17.0005
R6896 VGND.n832 VGND.n82 17.0005
R6897 VGND.n833 VGND.n82 17.0005
R6898 VGND.n835 VGND.n82 17.0005
R6899 VGND.n836 VGND.n82 17.0005
R6900 VGND.n82 VGND.n840 17.0005
R6901 VGND.n82 VGND.n650 17.0005
R6902 VGND.n82 VGND.n722 17.0005
R6903 VGND.n82 VGND.n651 17.0005
R6904 VGND.n82 VGND.n721 17.0005
R6905 VGND.n82 VGND.n652 17.0005
R6906 VGND.n82 VGND.n720 17.0005
R6907 VGND.n82 VGND.n653 17.0005
R6908 VGND.n82 VGND.n719 17.0005
R6909 VGND.n82 VGND.n654 17.0005
R6910 VGND.n82 VGND.n718 17.0005
R6911 VGND.n82 VGND.n655 17.0005
R6912 VGND.n82 VGND.n717 17.0005
R6913 VGND.n82 VGND.n656 17.0005
R6914 VGND.n82 VGND.n716 17.0005
R6915 VGND.n82 VGND.n657 17.0005
R6916 VGND.n82 VGND.n715 17.0005
R6917 VGND.n82 VGND.n658 17.0005
R6918 VGND.n82 VGND.n659 17.0005
R6919 VGND.n82 VGND.n714 17.0005
R6920 VGND.n82 VGND.n660 17.0005
R6921 VGND.n82 VGND.n713 17.0005
R6922 VGND.n82 VGND.n661 17.0005
R6923 VGND.n82 VGND.n712 17.0005
R6924 VGND.n82 VGND.n662 17.0005
R6925 VGND.n82 VGND.n711 17.0005
R6926 VGND.n82 VGND.n663 17.0005
R6927 VGND.n82 VGND.n710 17.0005
R6928 VGND.n82 VGND.n664 17.0005
R6929 VGND.n82 VGND.n709 17.0005
R6930 VGND.n82 VGND.n665 17.0005
R6931 VGND.n82 VGND.n708 17.0005
R6932 VGND.n82 VGND.n666 17.0005
R6933 VGND.n82 VGND.n707 17.0005
R6934 VGND.n82 VGND.n667 17.0005
R6935 VGND.n82 VGND.n706 17.0005
R6936 VGND.n82 VGND.n668 17.0005
R6937 VGND.n82 VGND.n705 17.0005
R6938 VGND.n82 VGND.n669 17.0005
R6939 VGND.n82 VGND.n704 17.0005
R6940 VGND.n82 VGND.n670 17.0005
R6941 VGND.n82 VGND.n703 17.0005
R6942 VGND.n82 VGND.n671 17.0005
R6943 VGND.n82 VGND.n672 17.0005
R6944 VGND.n82 VGND.n702 17.0005
R6945 VGND.n82 VGND.n673 17.0005
R6946 VGND.n82 VGND.n701 17.0005
R6947 VGND.n82 VGND.n674 17.0005
R6948 VGND.n82 VGND.n700 17.0005
R6949 VGND.n82 VGND.n675 17.0005
R6950 VGND.n82 VGND.n699 17.0005
R6951 VGND.n82 VGND.n676 17.0005
R6952 VGND.n82 VGND.n698 17.0005
R6953 VGND.n82 VGND.n677 17.0005
R6954 VGND.n82 VGND.n697 17.0005
R6955 VGND.n82 VGND.n678 17.0005
R6956 VGND.n82 VGND.n696 17.0005
R6957 VGND.n82 VGND.n679 17.0005
R6958 VGND.n82 VGND.n695 17.0005
R6959 VGND.n82 VGND.n694 17.0005
R6960 VGND.n82 VGND.n681 17.0005
R6961 VGND.n82 VGND.n693 17.0005
R6962 VGND.n82 VGND.n682 17.0005
R6963 VGND.n82 VGND.n692 17.0005
R6964 VGND.n82 VGND.n683 17.0005
R6965 VGND.n82 VGND.n691 17.0005
R6966 VGND.n82 VGND.n684 17.0005
R6967 VGND.n82 VGND.n690 17.0005
R6968 VGND.n82 VGND.n685 17.0005
R6969 VGND.n82 VGND.n689 17.0005
R6970 VGND.n82 VGND.n686 17.0005
R6971 VGND.n82 VGND.n688 17.0005
R6972 VGND.n82 VGND.n687 17.0005
R6973 VGND.n82 VGND.n134 17.0005
R6974 VGND.t1396 VGND.t2105 12.8576
R6975 VGND.t173 VGND.t2072 12.8576
R6976 VGND.t2039 VGND.t407 12.8576
R6977 VGND.n1091 VGND.n1090 9.0005
R6978 VGND.n1094 VGND.n1093 9.0005
R6979 VGND.n647 VGND.n646 9.0005
R6980 VGND.n648 VGND.n647 9.0005
R6981 VGND.n643 VGND.n345 9.0005
R6982 VGND.n643 VGND.n642 9.0005
R6983 VGND.n129 VGND.t214 8.07964
R6984 VGND.t2125 VGND.t243 8.57193
R6985 VGND.t41 VGND.n398 8.57193
R6986 VGND.t1279 VGND.n397 8.57193
R6987 VGND.n429 VGND.t1237 8.57193
R6988 VGND.n435 VGND.t1313 8.57193
R6989 VGND.n448 VGND.t1242 8.57193
R6990 VGND.t2331 VGND.n371 8.57193
R6991 VGND.t1382 VGND.n364 8.57193
R6992 VGND.n954 VGND.t634 8.57193
R6993 VGND.t2363 VGND.n956 8.57193
R6994 VGND.n964 VGND.t1386 8.57193
R6995 VGND.n991 VGND.t1449 8.57193
R6996 VGND.n1000 VGND.t421 8.57193
R6997 VGND.n116 VGND.t85 24.2748
R6998 VGND.n1026 VGND.t654 8.57193
R6999 VGND.n1046 VGND.t826 8.57193
R7000 VGND.n277 VGND.t216 8.57193
R7001 VGND.t810 VGND.n276 8.57193
R7002 VGND.t163 VGND.n263 8.57193
R7003 VGND.n300 VGND.t145 8.57193
R7004 VGND.n308 VGND.t194 8.57193
R7005 VGND.t558 VGND.n236 8.57193
R7006 VGND.n322 VGND.t290 8.57193
R7007 VGND.t362 VGND.n225 8.57193
R7008 VGND.t435 VGND.n216 8.57193
R7009 VGND.n1070 VGND.t44 8.57193
R7010 VGND.t485 VGND.n193 8.57193
R7011 VGND.t1062 VGND.n669 8.57193
R7012 VGND.t2198 VGND.n667 8.57193
R7013 VGND.t126 VGND.n658 8.57193
R7014 VGND.t1762 VGND.n650 8.57193
R7015 VGND.t937 VGND.n793 8.57193
R7016 VGND.n779 VGND.t557 8.57193
R7017 VGND.t807 VGND.n770 8.57193
R7018 VGND.t2162 VGND.n746 8.57193
R7019 VGND.n136 VGND.t2012 0.903576
R7020 VGND.n141 VGND.t1539 0.0719145
R7021 VGND.n140 VGND.t705 2.74088
R7022 VGND.t705 VGND.t2156 8.501
R7023 VGND.t111 VGND.n145 0.130189
R7024 VGND.t705 VGND.n144 0.428194
R7025 VGND.t2151 VGND.t705 8.501
R7026 VGND.n143 VGND.t2148 0.130189
R7027 VGND.t2146 VGND.t705 8.501
R7028 VGND.n142 VGND.t1419 0.130189
R7029 VGND.n151 VGND.t2142 0.0346178
R7030 VGND.n150 VGND.t705 3.33079
R7031 VGND.t705 VGND.n149 0.39199
R7032 VGND.t2135 VGND.n148 0.130189
R7033 VGND.n147 VGND.t534 1.02973
R7034 VGND.t125 VGND.n146 0.130189
R7035 VGND.n152 VGND.t198 2.31501
R7036 VGND.n131 VGND.t198 0.991385
R7037 VGND.t255 VGND.n154 0.238005
R7038 VGND.t423 VGND.n153 0.129991
R7039 VGND.t101 VGND.n156 0.44091
R7040 VGND.t96 VGND.n131 0.577398
R7041 VGND.n157 VGND.t1432 0.898488
R7042 VGND.t845 VGND.n158 0.885525
R7043 VGND.n159 VGND.t52 0.466579
R7044 VGND.n83 VGND.n82 0.83594
R7045 VGND.t705 VGND.n141 4.2093
R7046 VGND.t257 VGND.t52 5.6326
R7047 VGND.t1679 VGND.n499 5.6326
R7048 VGND.t921 VGND.t898 5.6326
R7049 VGND.t705 VGND.n145 3.33079
R7050 VGND.t705 VGND.n143 3.33079
R7051 VGND.n142 VGND.t705 3.33079
R7052 VGND.n150 VGND.t2140 0.0863258
R7053 VGND.n148 VGND.t705 3.33079
R7054 VGND.n146 VGND.t705 3.33079
R7055 VGND.t198 VGND.n153 3.33087
R7056 VGND.t916 VGND.n846 5.16578
R7057 VGND.n1061 VGND.t653 5.16578
R7058 VGND.n844 VGND.t994 5.16578
R7059 VGND.n940 VGND.n939 5.16578
R7060 VGND.n615 VGND.t1882 5.16578
R7061 VGND.n846 VGND.t1241 4.5005
R7062 VGND.t427 VGND.n609 4.5005
R7063 VGND.t1 VGND.n162 4.5005
R7064 VGND.n1088 VGND.t2045 4.5005
R7065 VGND.t215 VGND.n164 4.5005
R7066 VGND.n491 VGND.n490 4.5005
R7067 VGND.t1820 VGND.n844 4.5005
R7068 VGND.n843 VGND.t1965 4.5005
R7069 VGND.t429 VGND.n622 4.5005
R7070 VGND.t450 VGND.n1062 4.5005
R7071 VGND.n1061 VGND.t2117 4.5005
R7072 VGND.t1143 VGND.n615 4.5005
R7073 VGND.t1954 VGND.n842 4.5005
R7074 VGND.n841 VGND.t432 4.5005
R7075 VGND.n460 VGND.t162 4.5005
R7076 VGND.t635 VGND.n940 4.5005
R7077 VGND.n1089 VGND.n160 4.49573
R7078 VGND.n1094 VGND.n161 4.49046
R7079 VGND.n1092 VGND.n1091 4.49046
R7080 VGND.n645 VGND.n163 4.49046
R7081 VGND.n647 VGND.n644 4.49046
R7082 VGND.n637 VGND.n163 4.49046
R7083 VGND.n639 VGND.n638 4.49046
R7084 VGND.n643 VGND.n640 4.49046
R7085 VGND.n641 VGND.n638 4.49046
R7086 VGND.n129 VGND.t1448 4.61432
R7087 VGND.n432 VGND.t1227 4.28621
R7088 VGND.t2353 VGND.t2103 4.28621
R7089 VGND.n984 VGND.t1501 4.28621
R7090 VGND.n349 VGND.t1385 4.28621
R7091 VGND.t721 VGND.n267 4.28621
R7092 VGND.n840 VGND.t540 4.28621
R7093 VGND.t586 VGND.n140 0.0914569
R7094 VGND.n630 VGND.n499 3.32876
R7095 VGND.t1580 VGND.n502 3.31733
R7096 VGND.t198 VGND.n154 2.31523
R7097 VGND.n724 VGND.n82 3.30706
R7098 VGND.n152 VGND.t310 0.270808
R7099 VGND.n489 VGND.t705 2.29788
R7100 VGND.t672 VGND.t705 2.29755
R7101 VGND.n1091 VGND.n163 2.17938
R7102 VGND.n647 VGND.n643 2.17938
R7103 VGND.n156 VGND.t198 1.35933
R7104 VGND.t1879 VGND.n29 0.434504
R7105 VGND.t705 VGND.t591 1.28777
R7106 VGND.t198 VGND.t82 1.28777
R7107 VGND.t52 VGND.n165 1.27916
R7108 VGND.t5 VGND.t15 1.21665
R7109 VGND.t343 VGND.n147 0.0371956
R7110 VGND.n228 VGND.t370 1.20056
R7111 VGND.t1310 VGND.t343 1.16309
R7112 VGND.t20 VGND.t15 1.12993
R7113 VGND.t738 VGND.t291 1.12545
R7114 VGND.n635 VGND.n499 1.12033
R7115 VGND.n555 VGND.t1201 1.11479
R7116 VGND.t221 VGND.t226 1.10659
R7117 VGND.n633 VGND.t1715 1.10525
R7118 VGND.n982 VGND.t310 1.10475
R7119 VGND.t326 VGND.n27 0.438412
R7120 VGND.n43 VGND.t1580 0.302271
R7121 VGND.t425 VGND.t1334 1.09618
R7122 VGND.t472 VGND.n723 1.09533
R7123 VGND.t425 VGND.t1628 1.09516
R7124 VGND.n620 VGND.t898 1.09167
R7125 VGND.n149 VGND.t414 0.922666
R7126 VGND.n626 VGND.t953 1.08544
R7127 VGND.t198 VGND.n1009 1.0849
R7128 VGND.t609 VGND.t5 1.08082
R7129 VGND.t864 VGND.t866 1.07259
R7130 VGND.t2050 VGND.t3 1.07152
R7131 VGND.n633 VGND.t1944 1.0697
R7132 VGND.n632 VGND.t1715 1.06676
R7133 VGND.t593 VGND.t609 1.06225
R7134 VGND.t723 VGND.t196 1.06169
R7135 VGND.t1010 VGND.t1507 1.06154
R7136 VGND.t963 VGND.n612 1.06122
R7137 VGND.n214 VGND.t375 1.05976
R7138 VGND.n501 VGND.t916 1.05873
R7139 VGND.n612 VGND.t882 1.05414
R7140 VGND.t1166 VGND.t1873 1.05409
R7141 VGND.t1539 VGND.n916 1.05401
R7142 VGND.n616 VGND.t1147 1.05281
R7143 VGND.n26 VGND.t1243 0.413741
R7144 VGND.n621 VGND.t1010 1.04844
R7145 VGND.t1260 VGND.t1245 1.04794
R7146 VGND.t723 VGND.t738 1.04777
R7147 VGND.t1423 VGND.n144 0.886229
R7148 VGND.t1411 VGND.t862 1.04653
R7149 VGND.n158 VGND.t827 1.13095
R7150 VGND.n619 VGND.t1029 1.04623
R7151 VGND.n728 VGND.t1100 1.04558
R7152 VGND.n198 VGND.t450 1.04478
R7153 VGND.t146 VGND.n244 1.0441
R7154 VGND.t862 VGND.t575 1.04364
R7155 VGND.t1166 VGND.t1178 1.04268
R7156 VGND.n1087 VGND.t259 1.04248
R7157 VGND.n845 VGND.t922 1.04248
R7158 VGND.n636 VGND.t1680 1.04248
R7159 VGND.n255 VGND.t146 1.04185
R7160 VGND.n723 VGND.t122 1.04062
R7161 VGND.t45 VGND.n198 1.04056
R7162 VGND.t953 VGND.n627 1.03975
R7163 VGND.n619 VGND.t1026 1.0396
R7164 VGND.t1245 VGND.n26 0.218108
R7165 VGND.n623 VGND.t381 1.03794
R7166 VGND.n618 VGND.t1026 1.03708
R7167 VGND.n915 VGND.t675 1.03671
R7168 VGND.t1792 VGND.n628 1.03484
R7169 VGND.t134 VGND.t20 1.03433
R7170 VGND.n629 VGND.t756 1.03264
R7171 VGND.t2158 VGND.n915 1.03204
R7172 VGND.t1580 VGND.n28 0.349964
R7173 VGND.n624 VGND.t390 1.03125
R7174 VGND.n159 VGND.t217 0.869344
R7175 VGND.n618 VGND.t1083 1.02969
R7176 VGND.t242 VGND.t39 1.02716
R7177 VGND.t1411 VGND.t1416 1.02559
R7178 VGND.n634 VGND.t1663 1.02557
R7179 VGND.t905 VGND.n501 1.02352
R7180 VGND.n611 VGND.t1164 1.01898
R7181 VGND.n916 VGND.t588 1.01801
R7182 VGND.n627 VGND.t1792 1.0167
R7183 VGND.n610 VGND.t1164 1.01655
R7184 VGND.n628 VGND.t1779 1.0155
R7185 VGND.n631 VGND.t1718 1.01472
R7186 VGND.t1779 VGND.n629 1.01264
R7187 VGND.n613 VGND.t1132 1.01169
R7188 VGND.n617 VGND.t1083 1.01116
R7189 VGND.t1954 VGND.n631 1.0108
R7190 VGND.n157 VGND.t655 1.06407
R7191 VGND.t1236 VGND.n27 0.173004
R7192 VGND.n726 VGND.t353 1.00698
R7193 VGND.n957 VGND.t637 1.00663
R7194 VGND.n136 VGND.t472 1.06085
R7195 VGND.n611 VGND.t963 1.00611
R7196 VGND.t308 VGND.t1398 1.0048
R7197 VGND.t39 VGND.t1236 1.00431
R7198 VGND.n727 VGND.t345 1.00426
R7199 VGND.t423 VGND.t1459 1.0033
R7200 VGND.n83 VGND.t139 0.0699
R7201 VGND.n725 VGND.t545 1.00204
R7202 VGND.t1469 VGND.n552 1.00171
R7203 VGND.n621 VGND.t1820 1.0009
R7204 VGND.t1718 VGND.n632 0.987059
R7205 VGND.n63 VGND.t705 0.911143
R7206 VGND.n918 VGND.t705 0.982665
R7207 VGND.n923 VGND.t705 0.982665
R7208 VGND.n924 VGND.t705 0.982665
R7209 VGND.n901 VGND.t705 0.982665
R7210 VGND.n900 VGND.t705 0.982665
R7211 VGND.n898 VGND.t705 0.982665
R7212 VGND.t705 VGND.n0 0.911142
R7213 VGND.t705 VGND.n1 0.982665
R7214 VGND.t705 VGND.n3 0.911128
R7215 VGND.t705 VGND.n4 0.911128
R7216 VGND.t705 VGND.n5 0.911128
R7217 VGND.t705 VGND.n2 0.982665
R7218 VGND.t545 VGND.n726 0.97779
R7219 VGND.n894 VGND.t705 0.975899
R7220 VGND.t198 VGND.t1381 0.975248
R7221 VGND.t429 VGND.n725 0.970875
R7222 VGND.t1873 VGND.t916 0.9685
R7223 VGND.t215 VGND.t242 0.9659
R7224 VGND.t3 VGND.n255 0.965256
R7225 VGND.n624 VGND.t381 0.948662
R7226 VGND.t637 VGND.t2361 0.947437
R7227 VGND.n623 VGND.t1965 0.94316
R7228 VGND.t345 VGND.n728 0.939334
R7229 VGND.t593 VGND.t1 0.937113
R7230 VGND.t447 VGND.t450 0.932833
R7231 VGND.n617 VGND.t1147 0.917446
R7232 VGND.n1087 VGND.t2045 0.916657
R7233 VGND.n636 VGND.t427 0.916657
R7234 VGND.n613 VGND.t882 0.914866
R7235 VGND.t864 VGND.t1178 0.914621
R7236 VGND.t162 VGND.n244 0.913655
R7237 VGND.t1580 VGND.t1067 0.413541
R7238 VGND.t353 VGND.n727 0.905904
R7239 VGND.n845 VGND.t1241 0.905407
R7240 VGND.n552 VGND.t1201 0.903042
R7241 VGND.t1965 VGND.n626 0.902
R7242 VGND.t291 VGND.n228 0.897711
R7243 VGND.t45 VGND.t66 0.893325
R7244 VGND.t1416 VGND.t1419 0.887329
R7245 VGND.t1469 VGND.n43 1.07403
R7246 VGND.t1541 VGND.t1885 0.836915
R7247 VGND.t994 VGND.n43 0.346409
R7248 VGND.t2361 VGND.t635 0.834169
R7249 VGND.n610 VGND.t1241 0.833952
R7250 VGND.n28 VGND.t1885 0.201986
R7251 VGND.n616 VGND.t1143 0.830966
R7252 VGND.t162 VGND.t196 0.826892
R7253 VGND.t1944 VGND.n634 0.824789
R7254 VGND.t375 VGND.t447 0.824019
R7255 VGND.t866 VGND.n29 0.114235
R7256 VGND.t226 VGND.t2050 0.807228
R7257 VGND.n894 VGND.t111 0.803777
R7258 VGND.t705 VGND.t1416 0.80054
R7259 VGND.t390 VGND.n625 0.791704
R7260 VGND.t1381 VGND.t635 0.791058
R7261 VGND.t1132 VGND.n614 0.789691
R7262 VGND.t134 VGND.t139 0.783962
R7263 VGND.t370 VGND.n214 0.7619
R7264 VGND.n614 VGND.t898 0.757409
R7265 VGND.n620 VGND.t1820 0.755189
R7266 VGND.n680 VGND.t1 0.753268
R7267 VGND.t84 VGND.n894 0.739124
R7268 VGND.t1580 VGND.t1553 0.381506
R7269 VGND.t52 VGND.t447 0.727758
R7270 VGND.n614 VGND.t1143 0.718703
R7271 VGND.t432 VGND.n649 0.714696
R7272 VGND.n625 VGND.n499 0.709601
R7273 VGND.n555 VGND.t1899 0.705752
R7274 VGND.t144 VGND.n83 0.585347
R7275 VGND.t1260 VGND.t1381 0.701829
R7276 VGND.t1100 VGND.n649 0.687786
R7277 VGND.n625 VGND.t1970 0.686414
R7278 VGND.t1580 VGND.n15 0.67201
R7279 VGND.t1580 VGND.n14 0.634044
R7280 VGND.t1580 VGND.n7 0.63405
R7281 VGND.n113 VGND.t1581 32.2258
R7282 VGND.n125 VGND.t1542 32.2258
R7283 VGND.t1580 VGND.n8 0.634044
R7284 VGND.t1580 VGND.n9 0.634044
R7285 VGND.t1580 VGND.n10 0.634044
R7286 VGND.t1580 VGND.n13 0.621115
R7287 VGND.t1580 VGND.n12 0.67201
R7288 VGND.t1580 VGND.n11 0.67201
R7289 VGND.n490 VGND.n164 0.66578
R7290 VGND.n1088 VGND.n164 0.66578
R7291 VGND.n609 VGND.n162 0.66578
R7292 VGND.n846 VGND.n609 0.66578
R7293 VGND.n1062 VGND.n1061 0.66578
R7294 VGND.n843 VGND.n622 0.66578
R7295 VGND.n844 VGND.n843 0.66578
R7296 VGND.n940 VGND.n460 0.66578
R7297 VGND.n842 VGND.n841 0.66578
R7298 VGND.n842 VGND.n615 0.66578
R7299 VGND.n1009 VGND.t827 0.65281
R7300 VGND.t198 VGND.n25 0.649813
R7301 VGND.t1433 VGND.n40 32.8822
R7302 VGND.n1043 VGND.t198 0.649813
R7303 VGND.t198 VGND.n24 0.649813
R7304 VGND.t198 VGND.n23 0.649813
R7305 VGND.t198 VGND.n19 0.649813
R7306 VGND.t198 VGND.n22 0.649813
R7307 VGND.t198 VGND.n21 0.649813
R7308 VGND.t198 VGND.n20 0.649813
R7309 VGND.t52 VGND.n85 0.649813
R7310 VGND.t52 VGND.n103 0.649813
R7311 VGND.t52 VGND.n101 0.649813
R7312 VGND.t52 VGND.n100 0.649813
R7313 VGND.t52 VGND.n90 0.649813
R7314 VGND.t52 VGND.n99 0.649813
R7315 VGND.t52 VGND.n94 0.649813
R7316 VGND.t52 VGND.n95 0.649813
R7317 VGND.t52 VGND.n108 0.369515
R7318 VGND.t52 VGND.n107 0.649813
R7319 VGND.n748 VGND.n82 0.649813
R7320 VGND.n750 VGND.n82 0.649813
R7321 VGND.n751 VGND.n82 0.649813
R7322 VGND.n766 VGND.n82 0.649813
R7323 VGND.n768 VGND.n82 0.649813
R7324 VGND.n774 VGND.n82 0.649813
R7325 VGND.n775 VGND.n82 0.649813
R7326 VGND.n777 VGND.n82 0.649813
R7327 VGND.n809 VGND.n82 0.649813
R7328 VGND.n829 VGND.n82 0.649813
R7329 VGND.n834 VGND.n82 0.649813
R7330 VGND.n837 VGND.n82 0.649813
R7331 VGND.n838 VGND.n82 0.649813
R7332 VGND.n82 VGND.n79 0.649813
R7333 VGND.n82 VGND.n68 0.649813
R7334 VGND.n82 VGND.n69 0.649813
R7335 VGND.n82 VGND.n70 0.649813
R7336 VGND.n82 VGND.n71 0.649813
R7337 VGND.n82 VGND.n78 0.649813
R7338 VGND.n82 VGND.n77 0.649813
R7339 VGND.n82 VGND.n75 0.613875
R7340 VGND.n82 VGND.n73 0.369515
R7341 VGND.n82 VGND.n74 0.649813
R7342 VGND.t198 VGND.t2361 0.621083
R7343 VGND.t198 VGND.t2330 0.613929
R7344 VGND.t52 VGND.t79 0.613876
R7345 VGND.t86 VGND.n131 0.573076
R7346 VGND.n649 VGND.n82 0.611017
R7347 VGND.n727 VGND.n82 0.605458
R7348 VGND.t1663 VGND.n635 0.599206
R7349 VGND.n28 VGND.t1882 0.250181
R7350 VGND.t2123 VGND.n1009 0.577479
R7351 VGND.n156 VGND.t2117 0.659145
R7352 VGND.n634 VGND.n499 0.565549
R7353 VGND.n82 VGND.n680 0.563328
R7354 VGND VGND.n1094 0.56194
R7355 VGND.n623 VGND.n499 0.55469
R7356 VGND.t198 VGND.n982 0.554435
R7357 VGND.n728 VGND.n82 0.553357
R7358 VGND.n159 VGND.t221 0.0574123
R7359 VGND.t198 VGND.n26 0.220445
R7360 VGND.n613 VGND.t898 0.539753
R7361 VGND.n620 VGND.t1029 0.537436
R7362 VGND.n165 VGND.t217 0.536974
R7363 VGND.t198 VGND.t242 0.529134
R7364 VGND.n631 VGND.n499 0.526674
R7365 VGND.t1580 VGND.n555 0.525454
R7366 VGND.n1093 VGND.n162 0.52498
R7367 VGND.n642 VGND.n622 0.52498
R7368 VGND.n841 VGND.n648 0.52498
R7369 VGND.t52 VGND.n214 0.520096
R7370 VGND.n610 VGND.t898 0.512087
R7371 VGND.n611 VGND.t898 0.507733
R7372 VGND.n136 VGND.n82 0.42852
R7373 VGND.t198 VGND.n957 0.507235
R7374 VGND.n632 VGND.n499 0.507101
R7375 VGND.n618 VGND.t898 0.506806
R7376 VGND.n157 VGND.t198 0.427944
R7377 VGND.n916 VGND.t705 0.505927
R7378 VGND.t84 VGND.n144 1.09382
R7379 VGND.t52 VGND.n228 0.505143
R7380 VGND.n184 VGND.t50 0.488351
R7381 VGND.n726 VGND.n82 0.480946
R7382 VGND.n635 VGND.t427 0.470486
R7383 VGND.t52 VGND.t2050 0.466635
R7384 VGND.n621 VGND.t898 0.463111
R7385 VGND.n149 VGND.t1334 1.10351
R7386 VGND.t1580 VGND.n501 0.462662
R7387 VGND.n624 VGND.n499 0.458144
R7388 VGND.t1580 VGND.t1873 0.457263
R7389 VGND.t1580 VGND.n552 0.456656
R7390 VGND.t125 VGND.n489 0.455026
R7391 VGND.n725 VGND.n82 0.450927
R7392 VGND.n616 VGND.t898 0.443304
R7393 VGND.n1087 VGND.t52 0.442431
R7394 VGND.n636 VGND.n499 0.442431
R7395 VGND.n845 VGND.t898 0.442431
R7396 VGND.n628 VGND.n499 0.441994
R7397 VGND.t52 VGND.n244 0.441325
R7398 VGND.t52 VGND.t196 0.441247
R7399 VGND.n629 VGND.n499 0.439811
R7400 VGND.n619 VGND.t898 0.439269
R7401 VGND.t52 VGND.t738 0.437827
R7402 VGND.t675 VGND.t672 0.435691
R7403 VGND.n915 VGND.t705 0.435601
R7404 VGND.t198 VGND.n27 0.189034
R7405 VGND.n617 VGND.t898 0.418054
R7406 VGND.n612 VGND.t898 0.403998
R7407 VGND.n491 VGND.n489 0.402637
R7408 VGND.t52 VGND.n255 0.401389
R7409 VGND.t52 VGND.n198 0.393925
R7410 VGND.t705 VGND.t425 0.388004
R7411 VGND.n627 VGND.n499 0.382279
R7412 VGND.t2045 VGND.n165 0.377757
R7413 VGND.t1580 VGND.t1178 0.37102
R7414 VGND.t1580 VGND.t1541 1.16059
R7415 VGND.t672 VGND.t653 0.361931
R7416 VGND.n82 VGND.t593 0.359257
R7417 VGND.n82 VGND.t20 0.354424
R7418 VGND.n626 VGND.n499 0.345845
R7419 VGND.t86 VGND.t2111 0.344973
R7420 VGND.t308 VGND.n152 0.238295
R7421 VGND.n154 VGND.t2111 0.0931939
R7422 VGND.n680 VGND.t773 0.325116
R7423 VGND.t905 VGND.n502 0.311597
R7424 VGND.t705 VGND.n147 0.254956
R7425 VGND.t122 VGND.n724 0.292368
R7426 VGND.t52 VGND.n184 0.290931
R7427 VGND.n140 VGND.t2158 0.185108
R7428 VGND.n633 VGND.n499 0.270231
R7429 VGND.t898 VGND.t1507 0.256325
R7430 VGND.n724 VGND.t429 0.247996
R7431 VGND.n630 VGND.t1954 0.239484
R7432 VGND.t588 VGND.t586 0.238644
R7433 VGND.n723 VGND.n82 0.232987
R7434 VGND.t2108 VGND.t255 0.227075
R7435 VGND.t534 VGND.t2132 0.226736
R7436 VGND.t414 VGND.t2136 0.226736
R7437 VGND.t2140 VGND.t2142 0.226736
R7438 VGND.t2144 VGND.t2146 0.226736
R7439 VGND.t2151 VGND.t2149 0.226736
R7440 VGND.t2156 VGND.t2154 0.226736
R7441 VGND.n142 VGND.t2144 0.0863258
R7442 VGND.n145 VGND.t2154 0.0863258
R7443 VGND.t2149 VGND.n143 0.0863258
R7444 VGND.n150 VGND.t2139 0.130189
R7445 VGND.t2136 VGND.n148 0.0863258
R7446 VGND.t2132 VGND.n146 0.0863258
R7447 VGND.n153 VGND.t2108 0.0861948
R7448 VGND.n184 VGND.t66 0.198348
R7449 VGND.t756 VGND.n630 0.198006
R7450 VGND.t591 VGND.n491 0.190486
R7451 VGND.t215 VGND.t82 0.190486
R7452 VGND.t259 VGND.t257 0.171487
R7453 VGND.t1680 VGND.t1679 0.171487
R7454 VGND.t922 VGND.t921 0.171487
R7455 VGND.n82 VGND.t5 0.156107
R7456 VGND.n939 VGND.t575 0.150825
R7457 VGND.n141 VGND.t2161 0.0716963
R7458 VGND.t903 VGND.n502 0.111744
R7459 VGND.t1432 VGND.n155 0.10675
R7460 VGND.t2135 VGND.n871 0.10425
R7461 VGND.t2139 VGND.n885 0.10425
R7462 VGND.n1060 VGND.t845 0.093
R7463 VGND.t2156 VGND.t653 0.09175
R7464 VGND.n939 VGND.n151 0.158232
R7465 VGND.t2146 VGND.t2148 0.0855
R7466 VGND.t101 VGND.t96 0.0855
R7467 VGND.t1423 VGND.t2151 0.07425
R7468 VGND.t432 VGND.t144 0.07425
R7469 VGND.n871 VGND.t1310 0.06675
R7470 VGND.n885 VGND.t1628 0.06675
R7471 VGND.t655 VGND.n1060 0.06675
R7472 VGND.t1398 VGND.n957 0.0655121
R7473 VGND.t380 VGND.n499 0.0579324
R7474 VGND.t881 VGND.t898 0.0579324
R7475 VGND.t1422 VGND.n46 49.4862
R7476 VGND.n1092 VGND.n161 0.0436411
R7477 VGND.n645 VGND.n644 0.0436411
R7478 VGND.n640 VGND.n639 0.0436411
R7479 VGND.n641 VGND.n640 0.0436411
R7480 VGND.n644 VGND.n637 0.0436411
R7481 VGND.n1090 VGND.n1089 0.04274
R7482 VGND.t1459 VGND.n982 0.0339237
R7483 VGND.t1580 VGND.t1889 105.382
R7484 VGND.t52 VGND.n84 0.0258175
R7485 VGND.t52 VGND.n105 0.0258175
R7486 VGND.t52 VGND.n86 0.0258175
R7487 VGND.t52 VGND.n87 0.0258175
R7488 VGND.t52 VGND.n104 0.0258175
R7489 VGND.t52 VGND.n102 0.0258175
R7490 VGND.t52 VGND.n89 0.0258175
R7491 VGND.n109 VGND.t195 42.0522
R7492 VGND.t52 VGND.n91 0.0258175
R7493 VGND.t52 VGND.n92 0.0258175
R7494 VGND.t52 VGND.n93 0.0258175
R7495 VGND.t52 VGND.n98 0.0258175
R7496 VGND.t52 VGND.n97 0.0258175
R7497 VGND.t52 VGND.n96 0.0258175
R7498 VGND.t52 VGND.n106 0.0258175
R7499 VGND.n112 VGND.t2046 109.992
R7500 VGND.n729 VGND.n82 0.0258175
R7501 VGND.n767 VGND.n82 0.0258175
R7502 VGND.n773 VGND.n82 0.0258175
R7503 VGND.n776 VGND.n82 0.0258175
R7504 VGND.n120 VGND.n82 0.0148802
R7505 VGND.n810 VGND.n82 0.0258175
R7506 VGND.n825 VGND.n82 0.0258175
R7507 VGND.n826 VGND.n82 0.0258175
R7508 VGND.n839 VGND.n82 0.0258175
R7509 VGND.n82 VGND.n67 0.0258175
R7510 VGND.n82 VGND.n81 0.0258175
R7511 VGND.n82 VGND.n80 0.0258175
R7512 VGND.n82 VGND.n76 0.0153688
R7513 VGND.n1090 VGND.n161 0.0220706
R7514 VGND.n1093 VGND.n1092 0.0220706
R7515 VGND.n648 VGND.n637 0.0220706
R7516 VGND.n639 VGND.n345 0.0220706
R7517 VGND.n642 VGND.n641 0.0220706
R7518 VGND.n646 VGND.n645 0.0220706
R7519 VGND.n647 VGND.n163 0.02162
R7520 VGND.n643 VGND.n638 0.02162
R7521 VGND.n490 VGND 0.01986
R7522 VGND.n1089 VGND.n1088 0.01458
R7523 VGND.n1062 VGND.n345 0.01458
R7524 VGND.n646 VGND.n460 0.01458
R7525 VGND.n1091 VGND.n160 0.0115476
R7526 VGND.n1094 VGND.n160 0.0115476
R7527 VGND.t2117 VGND.n155 0.0105
R7528 VGND.t52 VGND.n88 0.00874641
R7529 VGND.n82 VGND.n72 0.00814697
R7530 VGND.n794 VGND.n82 0.00534784
R7531 VGND.n8 VGND.t1066 22.5536
R7532 VGND.t198 VGND.n158 1.23356
R7533 VGND.t705 VGND.t862 1.17267
R7534 VGND.t1580 VGND.n29 1.10737
C0 sg13cmos5l_inv_4_6.A VPWR 0.8508f
C1 a_3976_7050# sg13cmos5l_inv_16_101.Y 0.01393f
C2 sg13cmos5l_inv_16_46.Y VPWR 4.08525f
C3 a_3304_1002# a_3488_1002# 0.11523f
C4 sg13cmos5l_and2_1_7.B sg13cmos5l_inv_16_34.Y 0.0838f
C5 sg13cmos5l_buf_1_5.X sg13cmos5l_inv_16_40.Y 0.02358f
C6 sg13cmos5l_inv_8_2.A VPWR 4.13833f
C7 sg13cmos5l_inv_16_77.Y VPWR 2.69204f
C8 sg13cmos5l_and2_1_7.X a_23272_5538# 0.04348f
C9 sg13cmos5l_and2_1_0.B sg13cmos5l_inv_1_2.Y 0.2143f
C10 sg13cmos5l_inv_1_5.Y a_22880_5538# 0.01122f
C11 sg13cmos5l_and2_1_2.B sg13cmos5l_and2_1_2.X 0.04942f
C12 sg13cmos5l_buf_1_0.X sg13cmos5l_inv_16_14.Y 0.08749f
C13 a_3488_1002# VPWR 0.06551f
C14 sg13cmos5l_inv_1_5.Y sg13cmos5l_inv_4_6.A 0.52423f
C15 a_3592_9192# osc[7] 0.33302f
C16 sg13cmos5l_and2_1_7.X a_23648_4915# 0.12944f
C17 sg13cmos5l_inv_2_3.Y en[1] 0.01301f
C18 sg13cmos5l_inv_16_41.A sg13cmos5l_inv_1_2.Y 0.01916f
C19 a_13960_8562# a_14144_8562# 0.11523f
C20 a_14144_8562# VPWR 0.07035f
C21 sg13cmos5l_inv_2_5.Y sg13cmos5l_inv_16_94.A 0.2634f
C22 sg13cmos5l_inv_4_7.Y sg13cmos5l_inv_16_88.A 0.89124f
C23 sg13cmos5l_inv_2_5.Y sg13cmos5l_inv_2_5.A 1.18709f
C24 sg13cmos5l_inv_16_87.A VPWR 5.39152f
C25 sg13cmos5l_inv_16_84.A sg13cmos5l_inv_16_84.Y 0.89305f
C26 sg13cmos5l_inv_16_75.Y sg13cmos5l_buf_1_1.X 0.03188f
C27 sg13cmos5l_inv_16_31.Y VPWR 2.66912f
C28 a_2920_1632# VPWR 0.31524f
C29 sg13cmos5l_inv_16_14.A sg13cmos5l_inv_16_15.A 0.01412f
C30 sg13cmos5l_inv_16_29.A a_2632_4026# 0.04344f
C31 sg13cmos5l_and2_1_1.B sg13cmos5l_buf_1_5.X 0.07999f
C32 a_25384_1718# VPWR 0.15173f
C33 sg13cmos5l_and2_1_7.B sg13cmos5l_inv_16_105.A 0.08278f
C34 sg13cmos5l_and2_1_0.B a_3688_5538# 0.01107f
C35 sg13cmos5l_inv_16_37.A sg13cmos5l_inv_16_27.Y 0.01166f
C36 sg13cmos5l_buf_1_0.X sg13cmos5l_inv_16_104.Y 0.09848f
C37 sg13cmos5l_and2_1_3.X sg13cmos5l_inv_16_30.A 0.05372f
C38 sg13cmos5l_and2_1_0.B sg13cmos5l_and2_1_2.X 0.23498f
C39 sg13cmos5l_and2_1_3.B a_5133_916# 0.34797f
C40 sg13cmos5l_inv_16_17.A sg13cmos5l_inv_16_17.Y 0.89021f
C41 sg13cmos5l_inv_16_34.Y a_4360_4026# 0.01713f
C42 sg13cmos5l_and2_1_7.B osc[7] 0.0426f
C43 sg13cmos5l_and2_1_7.X sg13cmos5l_buf_1_1.X 0.04588f
C44 a_2920_7680# a_3304_7766# 0.03269f
C45 sg13cmos5l_and2_1_1.B sg13cmos5l_buf_1_15.X 0.15719f
C46 a_2816_7766# VPWR 0.07638f
C47 sg13cmos5l_inv_16_53.A osc[5] 0.1751f
C48 sg13cmos5l_inv_16_41.A sg13cmos5l_and2_1_2.X 0.01207f
C49 sg13cmos5l_buf_1_4.X sg13cmos5l_inv_16_110.Y 0.01105f
C50 sg13cmos5l_inv_2_5.Y sg13cmos5l_inv_16_88.A 0.17471f
C51 sg13cmos5l_inv_16_30.A sg13cmos5l_inv_16_26.Y 0.13338f
C52 sg13cmos5l_inv_16_6.Y en[3] 0.5748f
C53 a_4832_9278# VPWR 0.07064f
C54 sg13cmos5l_inv_16_9.A sg13cmos5l_inv_16_9.Y 0.87328f
C55 a_2920_6168# VPWR 0.31783f
C56 sg13cmos5l_inv_16_36.A sg13cmos5l_inv_16_36.Y 0.88827f
C57 sg13cmos5l_inv_16_103.A sg13cmos5l_inv_16_9.A 0.01465f
C58 sg13cmos5l_inv_16_36.A sg13cmos5l_inv_16_43.Y 1.23147f
C59 sg13cmos5l_inv_8_0.Y VPWR 2.95715f
C60 sg13cmos5l_and2_1_1.B sg13cmos5l_inv_16_108.Y 0.09452f
C61 sg13cmos5l_and2_1_7.B sg13cmos5l_inv_16_99.A 0.09378f
C62 sg13cmos5l_and2_1_1.B sg13cmos5l_inv_2_2.Y 0.02824f
C63 sg13cmos5l_and2_1_0.B a_3304_6254# 0.02116f
C64 sg13cmos5l_inv_4_2.Y sg13cmos5l_inv_16_30.A 0.09372f
C65 sg13cmos5l_and2_1_0.B sg13cmos5l_and2_1_2.B 0.38061f
C66 sg13cmos5l_and2_1_3.B sg13cmos5l_and2_1_3.A 0.11631f
C67 sg13cmos5l_buf_1_1.X sg13cmos5l_inv_16_2.A 0.30424f
C68 sg13cmos5l_inv_4_6.Y sg13cmos5l_inv_4_6.A 0.68325f
C69 sg13cmos5l_inv_16_29.A en[0] 0.12488f
C70 a_2632_7766# a_2816_7766# 0.11523f
C71 a_2920_7680# sg13cmos5l_and2_1_1.B 0.29825f
C72 a_13288_7766# VPWR 0.14779f
C73 sg13cmos5l_inv_16_88.A a_29120_8562# 0.03443f
C74 sg13cmos5l_inv_16_109.Y VPWR 5.38197f
C75 sg13cmos5l_inv_16_109.Y a_13960_8562# 0.01133f
C76 sg13cmos5l_inv_16_44.A osc[1] 0.01483f
C77 sg13cmos5l_inv_16_4.Y a_17696_3230# 0.03837f
C78 sg13cmos5l_buf_1_3.X a_16941_916# 0.18466f
C79 sg13cmos5l_buf_1_5.X sg13cmos5l_and2_1_3.X 0.06174f
C80 sg13cmos5l_buf_1_4.X sg13cmos5l_inv_16_5.Y 0.01249f
C81 sg13cmos5l_inv_16_30.A sg13cmos5l_inv_2_3.Y 0.03656f
C82 sg13cmos5l_inv_16_26.Y a_8204_834# 0.01552f
C83 sg13cmos5l_inv_16_73.A a_23552_7050# 0.03438f
C84 sg13cmos5l_and2_1_4.B sg13cmos5l_and2_1_4.X 0.2209f
C85 a_4648_9278# a_4832_9278# 0.11523f
C86 a_28556_834# VPWR 0.35141f
C87 VPWR en[1] 0.21737f
C88 sg13cmos5l_and2_1_7.B a_3592_9192# 0.04556f
C89 sg13cmos5l_inv_16_28.A osc[0] 0.01166f
C90 sg13cmos5l_inv_16_99.A osc[4] 0.12424f
C91 a_13472_4026# VPWR 0.07077f
C92 sg13cmos5l_inv_16_35.Y VPWR 2.67793f
C93 a_2816_9278# osc[6] 0.05842f
C94 sg13cmos5l_buf_1_5.X sg13cmos5l_inv_16_26.Y 0.02294f
C95 sg13cmos5l_buf_1_0.X sg13cmos5l_inv_16_14.A 0.10479f
C96 sg13cmos5l_inv_16_6.Y sg13cmos5l_inv_16_108.Y 0.93099f
C97 a_21160_2514# sg13cmos5l_inv_16_17.A 0.01134f
C98 sg13cmos5l_inv_16_14.A sg13cmos5l_inv_16_0.A 0.1425f
C99 sg13cmos5l_inv_2_2.Y sg13cmos5l_inv_16_6.Y 0.04739f
C100 sg13cmos5l_and2_1_1.X sg13cmos5l_inv_2_0.A 0.11868f
C101 sg13cmos5l_inv_16_53.Y VPWR 2.67839f
C102 sg13cmos5l_and2_1_0.B sg13cmos5l_inv_16_41.A 0.03923f
C103 sg13cmos5l_inv_16_99.A a_2920_4656# 0.01133f
C104 a_14920_1002# en[3] 0.0634f
C105 sg13cmos5l_buf_1_4.X sg13cmos5l_inv_8_2.A 0.20639f
C106 sg13cmos5l_buf_1_5.X sg13cmos5l_inv_4_2.Y 0.02585f
C107 sg13cmos5l_inv_8_3.Y sg13cmos5l_and2_1_3.X 0.24489f
C108 sg13cmos5l_inv_16_44.A sg13cmos5l_inv_16_44.Y 0.88146f
C109 sg13cmos5l_inv_16_11.A sg13cmos5l_inv_16_4.Y 0.05666f
C110 sg13cmos5l_inv_16_48.A sg13cmos5l_inv_16_111.Y 0.01338f
C111 sg13cmos5l_inv_16_14.A sg13cmos5l_inv_16_14.Y 0.88732f
C112 sg13cmos5l_inv_16_101.Y VPWR 5.41842f
C113 sg13cmos5l_inv_16_61.A VPWR 5.25629f
C114 sg13cmos5l_inv_16_67.A sg13cmos5l_inv_16_65.Y 0.90342f
C115 sg13cmos5l_inv_4_0.Y VPWR 1.34505f
C116 a_17696_3230# VPWR 0.09237f
C117 sg13cmos5l_inv_16_36.A sg13cmos5l_inv_16_100.Y 0.90342f
C118 sg13cmos5l_and2_1_7.B sg13cmos5l_inv_8_7.Y 0.05505f
C119 a_2920_2420# VPWR 0.33885f
C120 a_2816_1002# en[0] 0.05861f
C121 sg13cmos5l_and2_1_0.B sg13cmos5l_inv_16_6.A 0.07772f
C122 sg13cmos5l_inv_16_77.A a_26624_5538# 0.03438f
C123 sg13cmos5l_inv_2_2.Y sg13cmos5l_inv_16_26.Y 0.01372f
C124 sg13cmos5l_inv_2_6.Y sg13cmos5l_inv_1_7.Y 0.16446f
C125 a_15016_3230# sg13cmos5l_inv_16_5.Y 0.01188f
C126 sg13cmos5l_and2_1_0.B sg13cmos5l_and2_1_4.B 0.02495f
C127 sg13cmos5l_inv_16_67.Y VPWR 2.69072f
C128 a_8104_5538# VPWR 0.15415f
C129 sg13cmos5l_inv_16_14.A sg13cmos5l_inv_16_104.Y 0.90311f
C130 a_13472_1002# VPWR 0.06889f
C131 sg13cmos5l_inv_8_3.Y sg13cmos5l_inv_4_2.Y 0.88483f
C132 sg13cmos5l_inv_16_77.A VPWR 4.141f
C133 sg13cmos5l_buf_1_12.X VPWR 3.08212f
C134 a_3872_1718# VPWR 0.08224f
C135 sg13cmos5l_inv_16_103.A sg13cmos5l_inv_16_4.Y 0.01124f
C136 sg13cmos5l_buf_1_12.X sg13cmos5l_inv_16_85.Y 0.07166f
C137 sg13cmos5l_inv_16_101.Y sg13cmos5l_inv_16_54.Y 0.8657f
C138 sg13cmos5l_and2_1_4.B sg13cmos5l_inv_16_41.A 0.05553f
C139 sg13cmos5l_inv_4_0.A VPWR 0.77209f
C140 sg13cmos5l_inv_16_61.A a_4648_9278# 0.01139f
C141 sg13cmos5l_buf_1_5.X a_6848_3230# 0.04857f
C142 sg13cmos5l_inv_16_11.A VPWR 5.77979f
C143 sg13cmos5l_inv_16_29.A VPWR 6.19787f
C144 a_15872_4742# VPWR 0.1201f
C145 sg13cmos5l_inv_16_26.A sg13cmos5l_inv_16_30.A 0.88711f
C146 sg13cmos5l_inv_16_30.A VPWR 5.51313f
C147 sg13cmos5l_inv_16_75.A a_24320_5538# 0.03438f
C148 sg13cmos5l_inv_16_27.A en[3] 1.01092f
C149 a_26152_9278# a_26336_9278# 0.11523f
C150 sg13cmos5l_inv_16_73.Y sg13cmos5l_inv_16_90.Y 0.8657f
C151 sg13cmos5l_inv_16_58.Y VPWR 2.67373f
C152 sg13cmos5l_buf_1_1.X a_25484_834# 0.33363f
C153 a_13288_4026# a_13472_4026# 0.11523f
C154 sg13cmos5l_inv_16_76.A VPWR 5.3618f
C155 sg13cmos5l_inv_16_69.Y sg13cmos5l_inv_16_58.Y 0.90686f
C156 a_6957_3492# VPWR 0.50857f
C157 sg13cmos5l_inv_16_68.A a_8000_7766# 0.03438f
C158 sg13cmos5l_inv_16_51.Y osc[3] 0.02047f
C159 sg13cmos5l_inv_16_9.Y VPWR 2.73603f
C160 sg13cmos5l_and2_1_3.A a_5133_916# 0.22241f
C161 sg13cmos5l_inv_16_103.A VPWR 4.01291f
C162 sg13cmos5l_buf_1_15.X sg13cmos5l_inv_1_3.Y 0.03528f
C163 a_3688_4742# VPWR 0.18537f
C164 sg13cmos5l_and2_1_7.B sg13cmos5l_inv_16_10.Y 0.0212f
C165 sg13cmos5l_inv_16_26.A a_8204_834# 0.02275f
C166 VPWR en[3] 0.29765f
C167 a_8204_834# VPWR 0.32266f
C168 a_26152_9278# VPWR 0.14015f
C169 sg13cmos5l_buf_1_1.X sg13cmos5l_inv_16_1.A 0.5844f
C170 sg13cmos5l_inv_16_75.A sg13cmos5l_inv_16_15.A 0.01004f
C171 sg13cmos5l_inv_16_111.Y VPWR 2.68099f
C172 a_9832_2514# a_10016_2514# 0.11523f
C173 sg13cmos5l_buf_1_1.X sg13cmos5l_inv_16_23.Y 0.03764f
C174 sg13cmos5l_inv_16_20.A sg13cmos5l_inv_16_17.A 0.01891f
C175 a_20680_5538# VPWR 0.18824f
C176 sg13cmos5l_buf_1_5.X sg13cmos5l_inv_16_26.A 0.01777f
C177 sg13cmos5l_buf_1_5.X VPWR 1.02729f
C178 sg13cmos5l_and2_1_7.B sg13cmos5l_inv_16_46.A 0.02505f
C179 sg13cmos5l_inv_16_52.Y sg13cmos5l_inv_16_101.Y 0.04376f
C180 sg13cmos5l_and2_1_1.B sg13cmos5l_inv_1_2.Y 0.20816f
C181 sg13cmos5l_inv_16_61.A sg13cmos5l_inv_16_52.Y 0.13185f
C182 sg13cmos5l_and2_1_0.B a_14636_834# 0.01043f
C183 sg13cmos5l_buf_1_12.X sg13cmos5l_inv_16_84.A 0.14926f
C184 sg13cmos5l_inv_16_75.Y VPWR 2.67783f
C185 a_9832_2514# VPWR 0.15655f
C186 sg13cmos5l_inv_2_2.Y sg13cmos5l_inv_16_27.A 0.0133f
C187 a_8204_834# en[2] 0.31925f
C188 sg13cmos5l_and2_1_1.B sg13cmos5l_inv_16_43.Y 0.01143f
C189 a_13288_6254# a_13288_5538# 0.01275f
C190 a_2816_1002# VPWR 0.07267f
C191 sg13cmos5l_buf_1_2.X en[5] 0.01563f
C192 sg13cmos5l_buf_1_15.X VPWR 1.43082f
C193 sg13cmos5l_and2_1_1.X a_20397_1980# 0.12891f
C194 sg13cmos5l_buf_1_5.X en[2] 0.0271f
C195 sg13cmos5l_and2_1_6.X VPWR 0.43215f
C196 a_17696_9278# VPWR 0.12022f
C197 sg13cmos5l_buf_1_1.X sg13cmos5l_inv_2_0.A 0.04417f
C198 sg13cmos5l_inv_2_1.Y sg13cmos5l_inv_16_6.A 0.02148f
C199 sg13cmos5l_buf_1_8.X a_3597_916# 0.15054f
C200 sg13cmos5l_inv_16_105.A sg13cmos5l_inv_16_103.Y 0.0227f
C201 a_26144_2514# VPWR 0.12437f
C202 sg13cmos5l_and2_1_7.X VPWR 0.69497f
C203 sg13cmos5l_inv_16_67.A sg13cmos5l_inv_16_46.A 0.07494f
C204 sg13cmos5l_buf_1_5.X sg13cmos5l_inv_2_2.A 0.0607f
C205 sg13cmos5l_inv_8_3.Y VPWR 2.99854f
C206 sg13cmos5l_inv_16_55.Y VPWR 2.67749f
C207 sg13cmos5l_inv_16_29.Y osc[1] 0.0165f
C208 sg13cmos5l_buf_1_12.X sg13cmos5l_inv_16_52.Y 0.02825f
C209 a_2816_6254# osc[4] 0.05842f
C210 sg13cmos5l_inv_16_108.Y VPWR 2.69197f
C211 sg13cmos5l_inv_16_26.A sg13cmos5l_inv_2_2.Y 0.01034f
C212 sg13cmos5l_inv_2_2.Y VPWR 2.92083f
C213 sg13cmos5l_inv_1_5.Y sg13cmos5l_and2_1_7.X 0.14986f
C214 sg13cmos5l_inv_16_96.A a_20680_5538# 0.03325f
C215 a_3488_2514# VPWR 0.07352f
C216 a_2920_7680# VPWR 0.32158f
C217 sg13cmos5l_and2_1_7.B sg13cmos5l_inv_16_20.A 0.11915f
C218 sg13cmos5l_inv_16_73.A sg13cmos5l_inv_16_87.Y 0.03084f
C219 sg13cmos5l_and2_1_7.B sg13cmos5l_inv_16_102.Y 0.09703f
C220 sg13cmos5l_inv_4_7.Y VPWR 1.38004f
C221 sg13cmos5l_inv_16_73.A a_23552_9278# 0.03438f
C222 sg13cmos5l_inv_16_2.A VPWR 4.11811f
C223 sg13cmos5l_inv_16_29.A sg13cmos5l_inv_16_28.A 1.71469f
C224 sg13cmos5l_and2_1_1.B sg13cmos5l_inv_16_53.A 0.02356f
C225 sg13cmos5l_inv_16_30.Y en[1] 0.08319f
C226 sg13cmos5l_inv_16_37.A a_8776_4026# 0.02917f
C227 a_13288_1002# a_13472_1002# 0.11523f
C228 sg13cmos5l_inv_8_3.Y sg13cmos5l_inv_2_2.A 0.01888f
C229 sg13cmos5l_inv_16_44.A VPWR 4.02858f
C230 sg13cmos5l_inv_16_111.A sg13cmos5l_inv_16_48.A 0.10887f
C231 sg13cmos5l_buf_1_0.X sg13cmos5l_inv_16_75.A 0.29459f
C232 a_23368_1718# VPWR 0.17256f
C233 sg13cmos5l_and2_1_1.B sg13cmos5l_and2_1_2.B 0.04133f
C234 sg13cmos5l_and2_1_7.B sg13cmos5l_inv_4_4.Y 0.01117f
C235 sg13cmos5l_inv_2_2.A sg13cmos5l_inv_2_2.Y 0.4962f
C236 sg13cmos5l_inv_16_47.A sg13cmos5l_inv_16_50.Y 0.13769f
C237 a_20588_834# sg13cmos5l_inv_16_17.Y 0.02222f
C238 sg13cmos5l_inv_8_7.Y sg13cmos5l_inv_4_4.Y 0.97512f
C239 sg13cmos5l_inv_2_0.A a_26432_1002# 0.04751f
C240 sg13cmos5l_and2_1_1.B osc[5] 0.28805f
C241 sg13cmos5l_inv_16_61.Y VPWR 2.68234f
C242 sg13cmos5l_inv_16_47.A a_8096_7050# 0.03438f
C243 sg13cmos5l_inv_4_6.Y sg13cmos5l_inv_16_75.Y 0.01822f
C244 sg13cmos5l_inv_2_5.Y VPWR 0.96821f
C245 sg13cmos5l_inv_16_20.A a_21160_2514# 0.01121f
C246 sg13cmos5l_inv_16_98.Y VPWR 2.67939f
C247 sg13cmos5l_inv_16_27.Y a_9832_2514# 0.01109f
C248 sg13cmos5l_inv_16_84.A a_17696_9278# 0.03438f
C249 VPWR en[5] 0.1245f
C250 sg13cmos5l_buf_1_12.X sg13cmos5l_inv_16_95.Y 0.01156f
C251 sg13cmos5l_inv_4_5.Y a_8104_5538# 0.03654f
C252 sg13cmos5l_inv_16_76.A a_26824_7050# 0.06053f
C253 a_2920_9192# a_3304_9278# 0.03269f
C254 sg13cmos5l_and2_1_1.B sg13cmos5l_and2_1_0.B 0.55227f
C255 sg13cmos5l_buf_1_4.X en[3] 0.0153f
C256 a_2632_4742# a_2632_4026# 0.01275f
C257 sg13cmos5l_and2_1_7.B sg13cmos5l_inv_2_6.Y 0.01812f
C258 a_2920_9192# osc[6] 0.32955f
C259 a_2816_2514# osc[1] 0.05855f
C260 sg13cmos5l_inv_16_2.A sg13cmos5l_inv_16_2.Y 0.8657f
C261 sg13cmos5l_inv_1_2.Y sg13cmos5l_inv_2_3.Y 0.17393f
C262 sg13cmos5l_buf_1_0.X sg13cmos5l_inv_16_77.Y 0.03365f
C263 sg13cmos5l_inv_8_7.Y sg13cmos5l_inv_2_6.Y 0.06107f
C264 sg13cmos5l_and2_1_1.B sg13cmos5l_inv_16_41.A 0.01099f
C265 a_29120_8562# VPWR 0.07084f
C266 sg13cmos5l_inv_2_5.A sg13cmos5l_inv_16_94.A 0.15383f
C267 sg13cmos5l_inv_16_87.A a_25376_8562# 0.03452f
C268 sg13cmos5l_and2_1_7.B sg13cmos5l_inv_16_103.Y 0.09062f
C269 sg13cmos5l_inv_16_73.A sg13cmos5l_inv_16_94.A 0.89112f
C270 sg13cmos5l_and2_1_7.B sg13cmos5l_inv_16_37.A 0.0608f
C271 sg13cmos5l_inv_16_48.A a_13864_7050# 0.02083f
C272 sg13cmos5l_inv_16_27.Y sg13cmos5l_inv_2_2.Y 0.62853f
C273 sg13cmos5l_inv_16_96.Y a_19424_7050# 0.03438f
C274 sg13cmos5l_inv_1_7.A a_13472_4026# 0.01864f
C275 sg13cmos5l_buf_1_15.X sg13cmos5l_buf_1_4.X 0.11044f
C276 a_29032_4026# VPWR 0.13614f
C277 a_13664_4097# VPWR 0.49258f
C278 sg13cmos5l_and2_1_1.B sg13cmos5l_inv_16_6.A 1.03228f
C279 sg13cmos5l_and2_1_0.B sg13cmos5l_inv_16_6.Y 0.21032f
C280 sg13cmos5l_inv_16_101.Y a_3488_6254# 0.04317f
C281 a_28936_3230# VPWR 0.14432f
C282 sg13cmos5l_inv_16_0.A a_25384_1718# 0.03325f
C283 sg13cmos5l_inv_16_30.A sg13cmos5l_inv_16_30.Y 0.88175f
C284 sg13cmos5l_inv_16_29.Y en[0] 0.09825f
C285 sg13cmos5l_inv_2_0.A sg13cmos5l_buf_1_2.X 0.03606f
C286 sg13cmos5l_and2_1_1.B sg13cmos5l_and2_1_4.B 0.1546f
C287 a_3304_1718# a_3304_1002# 0.01275f
C288 sg13cmos5l_inv_16_68.Y VPWR 2.69198f
C289 sg13cmos5l_inv_16_99.Y osc[3] 0.10917f
C290 sg13cmos5l_inv_16_52.Y a_2920_7680# 0.02246f
C291 sg13cmos5l_buf_1_4.X sg13cmos5l_inv_16_108.Y 0.12096f
C292 sg13cmos5l_inv_16_88.A sg13cmos5l_inv_16_94.A 1.27501f
C293 sg13cmos5l_inv_16_71.Y VPWR 5.12431f
C294 sg13cmos5l_inv_16_96.Y sg13cmos5l_inv_16_8.Y 0.0151f
C295 a_17516_834# VPWR 0.33888f
C296 sg13cmos5l_inv_16_88.A sg13cmos5l_inv_2_5.A 0.06394f
C297 sg13cmos5l_inv_16_111.A VPWR 5.51144f
C298 a_3304_1718# VPWR 0.12265f
C299 a_3304_9278# VPWR 0.12307f
C300 a_23552_7050# VPWR 0.07126f
C301 sg13cmos5l_inv_16_29.A a_2632_1002# 0.04409f
C302 a_25484_834# VPWR 0.33861f
C303 sg13cmos5l_and2_1_3.B en[1] 0.06507f
C304 VPWR osc[6] 0.90531f
C305 sg13cmos5l_and2_1_1.B a_20397_1980# 0.33613f
C306 a_13472_6254# VPWR 0.07289f
C307 sg13cmos5l_inv_16_41.A sg13cmos5l_and2_1_3.X 0.24593f
C308 sg13cmos5l_and2_1_0.X a_17516_834# 0.02102f
C309 a_28936_4742# VPWR 0.15432f
C310 sg13cmos5l_inv_16_101.Y sg13cmos5l_inv_16_34.Y 1.05971f
C311 sg13cmos5l_buf_1_0.X sg13cmos5l_inv_8_0.Y 0.17552f
C312 sg13cmos5l_and2_1_1.B sg13cmos5l_and2_1_1.X 0.01645f
C313 sg13cmos5l_inv_16_69.Y osc[6] 0.1229f
C314 sg13cmos5l_inv_8_1.A a_20588_834# 0.03705f
C315 sg13cmos5l_and2_1_7.B sg13cmos5l_inv_16_46.Y 0.03028f
C316 sg13cmos5l_and2_1_0.B sg13cmos5l_inv_16_26.Y 0.07227f
C317 sg13cmos5l_inv_16_0.A sg13cmos5l_inv_8_0.Y 1.18496f
C318 a_2920_2420# a_3304_2514# 0.03269f
C319 sg13cmos5l_inv_16_6.A sg13cmos5l_inv_16_6.Y 0.93258f
C320 sg13cmos5l_inv_16_28.A sg13cmos5l_inv_16_44.A 1.95882f
C321 a_23368_7766# VPWR 0.15835f
C322 sg13cmos5l_inv_16_36.A sg13cmos5l_inv_16_6.Y 0.0138f
C323 sg13cmos5l_buf_1_5.X sg13cmos5l_inv_16_30.Y 0.04916f
C324 a_2816_4026# osc[2] 0.05855f
C325 sg13cmos5l_inv_1_2.Y VPWR 0.48532f
C326 sg13cmos5l_inv_16_61.A a_3688_8562# 0.03325f
C327 sg13cmos5l_inv_16_1.A VPWR 5.42317f
C328 sg13cmos5l_and2_1_1.B osc[3] 0.14085f
C329 sg13cmos5l_buf_1_0.X a_28556_834# 0.29661f
C330 sg13cmos5l_inv_1_3.Y sg13cmos5l_and2_1_4.X 0.13028f
C331 sg13cmos5l_inv_16_36.Y VPWR 2.697f
C332 sg13cmos5l_inv_16_56.Y a_5800_6254# 0.0168f
C333 sg13cmos5l_inv_16_23.Y VPWR 5.71037f
C334 sg13cmos5l_inv_16_43.Y VPWR 5.52881f
C335 sg13cmos5l_inv_16_41.A sg13cmos5l_inv_4_2.Y 0.06029f
C336 sg13cmos5l_and2_1_1.B sg13cmos5l_inv_2_1.Y 1.20332f
C337 VPWR en[7] 0.14003f
C338 a_2920_2420# sg13cmos5l_and2_1_3.B 0.28823f
C339 sg13cmos5l_inv_16_6.A a_17608_1718# 0.05032f
C340 sg13cmos5l_inv_4_6.A a_23456_5538# 0.03912f
C341 a_23368_1718# a_23368_1002# 0.01275f
C342 a_13864_7050# VPWR 0.14173f
C343 sg13cmos5l_inv_16_56.Y VPWR 5.32203f
C344 sg13cmos5l_inv_16_41.A sg13cmos5l_inv_2_3.Y 0.04584f
C345 sg13cmos5l_inv_16_71.Y a_8192_8562# 0.04465f
C346 a_3688_5538# VPWR 0.18741f
C347 sg13cmos5l_inv_16_81.Y sg13cmos5l_inv_16_96.Y 0.99045f
C348 a_2632_1002# a_2816_1002# 0.11523f
C349 sg13cmos5l_and2_1_2.X VPWR 0.64382f
C350 a_2816_1718# osc[0] 0.05831f
C351 sg13cmos5l_inv_16_20.A sg13cmos5l_inv_16_20.Y 0.87321f
C352 sg13cmos5l_buf_1_12.X a_26445_9540# 0.34797f
C353 sg13cmos5l_inv_2_0.A VPWR 1.48017f
C354 a_24136_5538# VPWR 0.1434f
C355 sg13cmos5l_inv_16_29.Y VPWR 2.67041f
C356 sg13cmos5l_inv_16_56.Y sg13cmos5l_inv_8_4.Y 0.90709f
C357 sg13cmos5l_buf_1_8.X osc[0] 0.14409f
C358 sg13cmos5l_buf_1_0.X sg13cmos5l_inv_4_0.Y 0.08506f
C359 sg13cmos5l_inv_16_43.Y sg13cmos5l_inv_2_2.A 0.23402f
C360 sg13cmos5l_and2_1_4.X VPWR 0.59762f
C361 sg13cmos5l_buf_1_15.X sg13cmos5l_inv_1_7.Y 0.03271f
C362 sg13cmos5l_inv_16_101.Y sg13cmos5l_inv_16_99.A 0.46789f
C363 sg13cmos5l_inv_16_0.A sg13cmos5l_inv_4_0.Y 0.01799f
C364 sg13cmos5l_inv_16_6.A a_14920_1002# 0.03325f
C365 a_2632_4742# VPWR 0.16017f
C366 sg13cmos5l_inv_16_1.A sg13cmos5l_inv_16_2.Y 0.02268f
C367 sg13cmos5l_inv_16_11.A sg13cmos5l_inv_16_105.A 0.94207f
C368 sg13cmos5l_buf_1_12.X osc[7] 0.01142f
C369 sg13cmos5l_inv_16_105.A a_15872_4742# 0.03438f
C370 a_13664_4097# sg13cmos5l_buf_1_4.X 0.12372f
C371 sg13cmos5l_inv_16_53.A VPWR 4.41809f
C372 sg13cmos5l_inv_16_34.Y a_3688_4742# 0.03325f
C373 a_15784_5538# VPWR 0.15713f
C374 sg13cmos5l_inv_16_87.A sg13cmos5l_inv_16_73.Y 0.22788f
C375 sg13cmos5l_buf_1_1.X a_23648_4915# 0.13074f
C376 a_2920_6168# osc[4] 0.32433f
C377 sg13cmos5l_buf_1_8.X a_3488_1002# 0.04766f
C378 a_13288_1718# VPWR 0.15611f
C379 sg13cmos5l_inv_16_69.Y sg13cmos5l_inv_16_53.A 0.02547f
C380 a_3304_6254# VPWR 0.1343f
C381 sg13cmos5l_and2_1_2.B VPWR 0.26623f
C382 sg13cmos5l_inv_16_6.Y a_14636_834# 0.02907f
C383 sg13cmos5l_and2_1_0.B sg13cmos5l_inv_16_27.A 1.81557f
C384 sg13cmos5l_buf_1_12.X sg13cmos5l_buf_1_0.X 0.50595f
C385 sg13cmos5l_inv_16_47.A sg13cmos5l_inv_16_47.Y 0.8814f
C386 sg13cmos5l_buf_1_0.X sg13cmos5l_inv_16_77.A 0.02316f
C387 sg13cmos5l_inv_2_6.Y sg13cmos5l_inv_4_4.Y 0.77619f
C388 sg13cmos5l_inv_16_46.A sg13cmos5l_inv_16_46.Y 1.18634f
C389 sg13cmos5l_inv_16_8.Y sg13cmos5l_inv_16_9.A 0.95791f
C390 sg13cmos5l_inv_16_52.Y osc[6] 0.06458f
C391 a_28936_3230# a_29120_3230# 0.11523f
C392 sg13cmos5l_inv_16_22.Y VPWR 2.6761f
C393 sg13cmos5l_buf_1_0.X sg13cmos5l_inv_4_0.A 0.07701f
C394 sg13cmos5l_buf_1_15.X sg13cmos5l_inv_1_7.A 0.20425f
C395 sg13cmos5l_inv_16_37.A sg13cmos5l_inv_16_102.Y 0.88119f
C396 sg13cmos5l_inv_16_58.Y osc[7] 0.02747f
C397 sg13cmos5l_inv_16_100.Y VPWR 2.68618f
C398 sg13cmos5l_inv_16_0.A sg13cmos5l_inv_4_0.A 0.03692f
C399 sg13cmos5l_buf_1_2.X a_20397_1980# 0.15938f
C400 VPWR osc[5] 0.77668f
C401 sg13cmos5l_inv_2_0.A sg13cmos5l_inv_16_2.Y 0.03454f
C402 sg13cmos5l_and2_1_1.X sg13cmos5l_buf_1_2.X 0.02397f
C403 a_23656_2514# VPWR 0.15513f
C404 sg13cmos5l_inv_16_69.Y osc[5] 0.05928f
C405 sg13cmos5l_inv_16_105.A sg13cmos5l_inv_16_103.A 0.05152f
C406 sg13cmos5l_inv_16_99.A sg13cmos5l_inv_16_29.A 0.17935f
C407 sg13cmos5l_and2_1_1.B a_3304_7766# 0.02116f
C408 sg13cmos5l_buf_1_0.X sg13cmos5l_inv_16_76.A 0.23634f
C409 sg13cmos5l_inv_16_34.Y sg13cmos5l_buf_1_15.X 0.0568f
C410 sg13cmos5l_inv_16_4.Y sg13cmos5l_inv_16_6.A 0.92354f
C411 a_17516_834# en[4] 0.32418f
C412 sg13cmos5l_inv_16_51.Y VPWR 2.67933f
C413 a_5133_916# en[1] 0.01671f
C414 sg13cmos5l_inv_16_43.Y sg13cmos5l_inv_16_27.Y 0.90793f
C415 sg13cmos5l_and2_1_0.B sg13cmos5l_inv_16_26.A 0.68392f
C416 sg13cmos5l_inv_16_79.A sg13cmos5l_inv_16_79.Y 0.88439f
C417 sg13cmos5l_and2_1_1.B sg13cmos5l_inv_16_40.Y 0.07487f
C418 sg13cmos5l_and2_1_0.B VPWR 1.52248f
C419 sg13cmos5l_inv_16_67.A sg13cmos5l_inv_16_109.Y 1.25172f
C420 sg13cmos5l_buf_1_12.X sg13cmos5l_inv_16_65.Y 0.06943f
C421 a_3304_9278# a_3488_9278# 0.11523f
C422 a_3592_9192# sg13cmos5l_buf_1_12.X 0.2916f
C423 sg13cmos5l_and2_1_7.B sg13cmos5l_inv_16_61.A 0.01135f
C424 sg13cmos5l_and2_1_7.B sg13cmos5l_inv_16_101.Y 0.29335f
C425 a_3304_1718# a_3488_1718# 0.11523f
C426 sg13cmos5l_inv_16_75.A sg13cmos5l_inv_16_74.Y 0.89565f
C427 sg13cmos5l_inv_16_41.A VPWR 5.35239f
C428 sg13cmos5l_inv_8_1.Y a_20397_1980# 0.03542f
C429 sg13cmos5l_and2_1_0.B sg13cmos5l_and2_1_0.X 0.05571f
C430 a_3304_2514# a_3488_2514# 0.11523f
C431 sg13cmos5l_inv_16_15.A sg13cmos5l_inv_16_2.A 0.01793f
C432 sg13cmos5l_and2_1_1.B osc[1] 0.56912f
C433 a_2816_2514# VPWR 0.073f
C434 sg13cmos5l_inv_4_6.Y a_24136_5538# 0.0166f
C435 sg13cmos5l_and2_1_0.B en[2] 0.33823f
C436 a_26445_9540# sg13cmos5l_and2_1_6.X 0.13389f
C437 sg13cmos5l_inv_16_4.Y a_20397_1980# 0.01501f
C438 sg13cmos5l_inv_16_54.Y osc[5] 0.01542f
C439 sg13cmos5l_inv_16_53.Y osc[4] 0.01542f
C440 sg13cmos5l_inv_16_52.Y sg13cmos5l_inv_16_56.Y 0.99452f
C441 a_13472_5538# VPWR 0.07198f
C442 a_28936_4742# a_29120_4742# 0.11523f
C443 a_14636_834# a_14920_1002# 0.01225f
C444 sg13cmos5l_inv_8_3.Y sg13cmos5l_and2_1_3.B 0.01484f
C445 sg13cmos5l_and2_1_3.A en[1] 0.02273f
C446 sg13cmos5l_and2_1_0.B sg13cmos5l_inv_2_2.A 0.01439f
C447 sg13cmos5l_buf_1_12.X sg13cmos5l_inv_16_90.Y 0.01195f
C448 sg13cmos5l_inv_16_101.Y osc[4] 0.16414f
C449 sg13cmos5l_inv_16_6.A VPWR 5.58619f
C450 sg13cmos5l_inv_16_44.Y osc[1] 0.01914f
C451 sg13cmos5l_and2_1_7.B sg13cmos5l_buf_1_12.X 0.04481f
C452 sg13cmos5l_inv_1_2.Y a_3488_1718# 0.01076f
C453 sg13cmos5l_and2_1_4.B VPWR 0.66166f
C454 sg13cmos5l_inv_16_1.A a_23368_1002# 0.03325f
C455 sg13cmos5l_and2_1_7.B sg13cmos5l_inv_16_11.A 0.04451f
C456 sg13cmos5l_inv_16_36.A VPWR 5.43341f
C457 sg13cmos5l_inv_16_87.Y VPWR 2.67336f
C458 a_23552_9278# VPWR 0.07076f
C459 sg13cmos5l_inv_2_1.Y sg13cmos5l_inv_8_1.Y 0.04953f
C460 sg13cmos5l_inv_16_6.A sg13cmos5l_and2_1_0.X 0.06853f
C461 sg13cmos5l_inv_16_87.A a_23456_8562# 0.04214f
C462 sg13cmos5l_buf_1_0.X sg13cmos5l_and2_1_6.X 0.02356f
C463 sg13cmos5l_inv_16_5.Y sg13cmos5l_inv_16_110.Y 0.88827f
C464 sg13cmos5l_inv_16_47.A VPWR 5.23249f
C465 sg13cmos5l_inv_16_9.A a_15104_4026# 0.03438f
C466 sg13cmos5l_inv_16_52.Y sg13cmos5l_inv_16_53.A 2.8133f
C467 sg13cmos5l_inv_16_4.Y sg13cmos5l_inv_2_1.Y 0.87924f
C468 sg13cmos5l_inv_16_99.A sg13cmos5l_buf_1_15.X 0.02711f
C469 sg13cmos5l_inv_16_111.A a_14048_7050# 0.03438f
C470 sg13cmos5l_inv_16_67.A sg13cmos5l_inv_16_67.Y 0.88827f
C471 a_29120_6254# VPWR 0.10709f
C472 sg13cmos5l_inv_16_0.A a_26144_2514# 0.03723f
C473 a_20397_1980# VPWR 0.4798f
C474 sg13cmos5l_and2_1_1.B sg13cmos5l_inv_16_6.Y 1.75234f
C475 sg13cmos5l_inv_16_8.Y sg13cmos5l_inv_16_4.Y 1.05443f
C476 sg13cmos5l_buf_1_12.X sg13cmos5l_inv_16_67.A 0.12666f
C477 sg13cmos5l_and2_1_1.X VPWR 0.79089f
C478 sg13cmos5l_inv_16_30.A a_5133_916# 0.03436f
C479 sg13cmos5l_inv_16_26.Y sg13cmos5l_inv_16_40.Y 0.9304f
C480 sg13cmos5l_and2_1_2.X a_3488_1718# 0.03465f
C481 sg13cmos5l_inv_16_15.Y VPWR 2.73038f
C482 sg13cmos5l_and2_1_1.B sg13cmos5l_and2_1_3.X 0.01852f
C483 sg13cmos5l_inv_16_52.Y osc[5] 0.04911f
C484 sg13cmos5l_inv_16_77.A sg13cmos5l_inv_16_14.A 0.14138f
C485 a_29120_9278# VPWR 0.10556f
C486 sg13cmos5l_and2_1_7.B sg13cmos5l_inv_16_103.A 0.07602f
C487 sg13cmos5l_and2_1_0.B sg13cmos5l_inv_16_27.Y 0.14028f
C488 sg13cmos5l_inv_2_1.Y sg13cmos5l_inv_1_0.Y 0.15701f
C489 a_26445_9540# sg13cmos5l_inv_2_5.Y 0.03005f
C490 a_10600_9278# VPWR 0.15786f
C491 a_19424_7050# VPWR 0.07111f
C492 sg13cmos5l_inv_1_7.A a_13664_4097# 0.12973f
C493 VPWR osc[3] 0.50022f
C494 sg13cmos5l_buf_1_12.X sg13cmos5l_inv_16_73.Y 0.08615f
C495 sg13cmos5l_and2_1_1.B sg13cmos5l_inv_16_26.Y 0.0591f
C496 a_13288_1718# a_13288_1002# 0.01275f
C497 sg13cmos5l_inv_2_1.Y VPWR 0.96137f
C498 sg13cmos5l_inv_16_76.A sg13cmos5l_inv_16_14.A 0.01294f
C499 a_2920_908# en[0] 0.31471f
C500 sg13cmos5l_inv_16_8.Y VPWR 5.43976f
C501 sg13cmos5l_inv_16_46.Y a_8864_6254# 0.03438f
C502 sg13cmos5l_and2_1_0.B sg13cmos5l_inv_16_28.A 0.118f
C503 a_20768_7766# VPWR 0.11997f
C504 a_25484_834# en[6] 0.32489f
C505 sg13cmos5l_and2_1_1.B sg13cmos5l_inv_4_2.Y 0.5532f
C506 sg13cmos5l_inv_16_94.A VPWR 5.09025f
C507 osc[1] en[0] 0.05788f
C508 a_14636_834# VPWR 0.28249f
C509 sg13cmos5l_inv_2_5.A VPWR 0.64515f
C510 a_13864_7050# a_14048_7050# 0.11523f
C511 a_20680_9278# sg13cmos5l_inv_16_81.Y 0.01121f
C512 sg13cmos5l_and2_1_7.B sg13cmos5l_buf_1_15.X 4.65609f
C513 sg13cmos5l_inv_16_73.A VPWR 5.59753f
C514 a_3304_2514# a_3304_1718# 0.01095f
C515 a_2816_9278# VPWR 0.07202f
C516 sg13cmos5l_inv_16_87.A sg13cmos5l_inv_16_93.Y 0.8657f
C517 sg13cmos5l_inv_16_41.A sg13cmos5l_inv_16_28.A 0.86371f
C518 a_2920_3932# sg13cmos5l_and2_1_4.B 0.29008f
C519 sg13cmos5l_inv_16_37.Y VPWR 2.6834f
C520 sg13cmos5l_and2_1_0.B en[4] 0.23531f
C521 sg13cmos5l_inv_16_50.Y VPWR 2.68638f
C522 sg13cmos5l_and2_1_1.B sg13cmos5l_buf_1_2.X 0.28781f
C523 sg13cmos5l_and2_1_1.B sg13cmos5l_inv_2_3.Y 0.04664f
C524 sg13cmos5l_inv_16_36.A sg13cmos5l_inv_16_27.Y 0.08313f
C525 sg13cmos5l_and2_1_7.B sg13cmos5l_and2_1_7.X 0.18179f
C526 sg13cmos5l_buf_1_12.X sg13cmos5l_inv_16_68.A 0.12743f
C527 sg13cmos5l_and2_1_7.B sg13cmos5l_inv_16_55.Y 0.01769f
C528 sg13cmos5l_inv_16_17.A en[5] 0.04698f
C529 sg13cmos5l_inv_16_1.A en[6] 0.02503f
C530 a_8096_7050# VPWR 0.09478f
C531 a_24136_5538# a_24320_5538# 0.11523f
C532 sg13cmos5l_inv_16_15.A sg13cmos5l_inv_16_1.A 0.11058f
C533 sg13cmos5l_inv_16_88.A VPWR 2.86018f
C534 sg13cmos5l_inv_16_96.Y VPWR 5.22905f
C535 sg13cmos5l_inv_16_66.Y VPWR 2.68196f
C536 sg13cmos5l_inv_16_15.A sg13cmos5l_inv_16_23.Y 0.91592f
C537 sg13cmos5l_inv_16_48.A a_13472_7766# 0.04325f
C538 a_2920_1632# osc[0] 0.33696f
C539 sg13cmos5l_inv_16_111.A a_13960_9278# 0.03325f
C540 sg13cmos5l_inv_16_96.A sg13cmos5l_inv_16_8.Y 0.14134f
C541 a_23272_5538# VPWR 0.14846f
C542 sg13cmos5l_inv_16_37.Y sg13cmos5l_inv_2_2.A 0.05757f
C543 sg13cmos5l_buf_1_12.X sg13cmos5l_inv_16_79.A 0.0196f
C544 sg13cmos5l_and2_1_1.B sg13cmos5l_inv_8_1.Y 0.0595f
C545 sg13cmos5l_inv_16_1.A a_23840_2514# 0.03438f
C546 a_2632_4742# a_2816_4742# 0.11523f
C547 sg13cmos5l_inv_16_6.Y a_14920_1002# 0.02329f
C548 a_23648_4915# VPWR 0.49996f
C549 a_2920_4656# sg13cmos5l_buf_1_15.X 0.28897f
C550 sg13cmos5l_inv_16_6.A en[4] 0.22928f
C551 sg13cmos5l_inv_16_99.Y VPWR 2.67793f
C552 sg13cmos5l_inv_16_17.Y en[5] 0.02679f
C553 sg13cmos5l_inv_4_2.Y sg13cmos5l_and2_1_3.X 0.68595f
C554 sg13cmos5l_and2_1_1.B sg13cmos5l_inv_16_4.Y 0.14854f
C555 a_4744_908# VPWR 0.34324f
C556 sg13cmos5l_inv_2_0.A en[6] 0.17421f
C557 sg13cmos5l_inv_16_91.Y VPWR 2.67881f
C558 a_3304_7766# VPWR 0.1355f
C559 sg13cmos5l_inv_16_81.Y VPWR 5.27282f
C560 sg13cmos5l_and2_1_1.B sg13cmos5l_inv_16_27.A 0.01193f
C561 osc[6] osc[7] 0.14394f
C562 sg13cmos5l_inv_16_26.A sg13cmos5l_inv_16_40.Y 0.01845f
C563 sg13cmos5l_inv_16_29.A osc[2] 0.02664f
C564 a_2920_908# a_3304_1002# 0.03269f
C565 sg13cmos5l_inv_16_40.Y VPWR 2.67044f
C566 sg13cmos5l_and2_1_0.B sg13cmos5l_inv_16_30.Y 0.0922f
C567 sg13cmos5l_and2_1_7.B sg13cmos5l_inv_16_61.Y 0.01145f
C568 a_2632_1718# VPWR 0.1525f
C569 sg13cmos5l_inv_16_11.A sg13cmos5l_inv_16_20.A 0.0716f
C570 a_2920_908# VPWR 0.31226f
C571 sg13cmos5l_inv_16_34.Y a_3688_5538# 0.03325f
C572 sg13cmos5l_and2_1_1.B sg13cmos5l_inv_1_0.Y 0.03067f
C573 a_15104_4026# VPWR 0.12301f
C574 sg13cmos5l_buf_1_1.X VPWR 1.36297f
C575 a_3304_6254# a_3488_6254# 0.11523f
C576 sg13cmos5l_inv_16_96.Y sg13cmos5l_inv_16_96.A 0.96638f
C577 a_13288_1718# a_13472_1718# 0.11523f
C578 sg13cmos5l_inv_2_0.A sg13cmos5l_inv_16_19.Y 0.14276f
C579 VPWR osc[1] 1.046f
C580 sg13cmos5l_inv_2_2.Y sg13cmos5l_inv_16_25.Y 0.01395f
C581 sg13cmos5l_and2_1_1.B sg13cmos5l_inv_16_26.A 0.14366f
C582 sg13cmos5l_and2_1_1.B VPWR 4.68783f
C583 a_16941_916# a_17516_834# 0.02706f
C584 a_2632_6254# VPWR 0.16095f
C585 sg13cmos5l_inv_16_59.Y VPWR 2.67935f
C586 sg13cmos5l_inv_16_6.Y sg13cmos5l_inv_16_27.A 0.27521f
C587 sg13cmos5l_and2_1_3.B sg13cmos5l_and2_1_2.X 0.02346f
C588 sg13cmos5l_inv_4_2.Y sg13cmos5l_inv_2_3.Y 0.57486f
C589 a_23368_7050# a_23552_7050# 0.11523f
C590 sg13cmos5l_buf_1_0.X sg13cmos5l_inv_16_1.A 0.17707f
C591 sg13cmos5l_inv_16_62.Y osc[6] 0.09828f
C592 sg13cmos5l_and2_1_1.B sg13cmos5l_and2_1_0.X 0.03018f
C593 sg13cmos5l_buf_1_4.X a_14636_834# 0.29632f
C594 sg13cmos5l_inv_16_1.A sg13cmos5l_inv_16_0.A 0.8995f
C595 sg13cmos5l_buf_1_0.X sg13cmos5l_inv_16_23.Y 0.40428f
C596 sg13cmos5l_and2_1_1.B en[2] 0.08468f
C597 sg13cmos5l_inv_16_96.Y sg13cmos5l_inv_4_6.Y 0.02118f
C598 sg13cmos5l_inv_16_44.Y VPWR 2.91345f
C599 sg13cmos5l_inv_16_23.Y sg13cmos5l_inv_16_0.A 0.92427f
C600 sg13cmos5l_inv_16_15.A a_23656_2514# 0.01188f
C601 sg13cmos5l_buf_1_0.X en[7] 0.12762f
C602 sg13cmos5l_inv_16_1.A sg13cmos5l_inv_16_17.A 0.91821f
C603 a_13288_6254# a_13472_6254# 0.11523f
C604 sg13cmos5l_inv_16_4.Y a_17608_1718# 0.01166f
C605 a_13472_7766# VPWR 0.07785f
C606 sg13cmos5l_and2_1_1.B sg13cmos5l_inv_2_2.A 0.03486f
C607 sg13cmos5l_inv_16_43.Y a_8776_4026# 0.03325f
C608 sg13cmos5l_inv_16_109.Y a_14144_8562# 0.04458f
C609 a_23368_7766# a_23368_7050# 0.01275f
C610 sg13cmos5l_buf_1_3.X a_17516_834# 0.29546f
C611 sg13cmos5l_inv_16_84.A sg13cmos5l_inv_16_81.Y 1.18069f
C612 sg13cmos5l_inv_16_23.Y sg13cmos5l_inv_16_14.Y 0.12266f
C613 a_23656_2514# a_23840_2514# 0.11523f
C614 sg13cmos5l_buf_1_12.X sg13cmos5l_inv_16_84.Y 0.04882f
C615 sg13cmos5l_inv_16_6.Y VPWR 5.59804f
C616 sg13cmos5l_inv_16_94.A a_26824_7050# 0.01121f
C617 sg13cmos5l_buf_1_12.X sg13cmos5l_inv_16_93.Y 0.07166f
C618 sg13cmos5l_buf_1_0.X sg13cmos5l_inv_2_0.A 0.14224f
C619 sg13cmos5l_inv_16_105.A a_15784_5538# 0.03325f
C620 a_26432_1002# VPWR 0.09107f
C621 sg13cmos5l_and2_1_7.B a_3304_9278# 0.02116f
C622 sg13cmos5l_inv_16_99.A a_3688_5538# 0.01178f
C623 sg13cmos5l_inv_16_9.A VPWR 5.06176f
C624 sg13cmos5l_and2_1_0.B sg13cmos5l_inv_16_34.Y 0.01801f
C625 a_2632_4026# VPWR 0.16022f
C626 sg13cmos5l_inv_2_0.A sg13cmos5l_inv_16_0.A 0.03113f
C627 sg13cmos5l_inv_16_77.A sg13cmos5l_inv_16_75.A 0.0113f
C628 sg13cmos5l_inv_8_1.A en[5] 0.01421f
C629 sg13cmos5l_and2_1_7.B osc[6] 0.0616f
C630 sg13cmos5l_buf_1_15.X sg13cmos5l_inv_16_102.Y 0.04727f
C631 sg13cmos5l_inv_8_1.Y sg13cmos5l_buf_1_2.X 0.31918f
C632 sg13cmos5l_inv_16_111.A sg13cmos5l_inv_8_7.Y 0.10007f
C633 a_7912_4742# VPWR 0.19222f
C634 sg13cmos5l_and2_1_3.X VPWR 1.57752f
C635 sg13cmos5l_inv_2_0.A sg13cmos5l_inv_16_17.A 0.99116f
C636 sg13cmos5l_inv_16_34.Y sg13cmos5l_inv_16_41.A 0.97586f
C637 sg13cmos5l_inv_8_7.Y a_13472_6254# 0.04353f
C638 a_3976_7050# VPWR 0.14244f
C639 sg13cmos5l_inv_4_6.Y sg13cmos5l_buf_1_1.X 0.01759f
C640 sg13cmos5l_inv_16_73.A sg13cmos5l_inv_16_95.Y 0.01519f
C641 sg13cmos5l_inv_16_99.A a_2632_4742# 0.04404f
C642 a_24320_6254# VPWR 0.11929f
C643 sg13cmos5l_inv_16_44.A a_2632_2514# 0.0421f
C644 sg13cmos5l_and2_1_0.B sg13cmos5l_and2_1_3.B 0.06311f
C645 sg13cmos5l_inv_16_26.A sg13cmos5l_inv_16_26.Y 1.25282f
C646 a_17608_1718# VPWR 0.13231f
C647 sg13cmos5l_inv_16_26.Y VPWR 3.98445f
C648 sg13cmos5l_inv_16_76.A sg13cmos5l_inv_16_75.A 1.03398f
C649 a_20288_3230# VPWR 0.09196f
C650 sg13cmos5l_inv_16_103.A sg13cmos5l_inv_16_103.Y 0.87797f
C651 sg13cmos5l_and2_1_1.B a_2920_3932# 0.04186f
C652 sg13cmos5l_inv_16_41.A sg13cmos5l_and2_1_3.B 0.60531f
C653 sg13cmos5l_inv_16_29.A osc[0] 0.04653f
C654 sg13cmos5l_inv_1_3.Y a_7040_4742# 0.03463f
C655 sg13cmos5l_inv_16_28.A a_2632_1718# 0.04297f
C656 sg13cmos5l_inv_2_0.A sg13cmos5l_inv_16_17.Y 0.09974f
C657 sg13cmos5l_and2_1_1.B sg13cmos5l_inv_16_27.Y 0.50721f
C658 sg13cmos5l_inv_16_96.Y a_19424_6254# 0.03438f
C659 sg13cmos5l_inv_8_2.A a_13472_1002# 0.03906f
C660 sg13cmos5l_and2_1_3.X sg13cmos5l_inv_2_2.A 0.30391f
C661 sg13cmos5l_inv_4_2.Y VPWR 1.44315f
C662 sg13cmos5l_inv_16_44.A osc[2] 0.1061f
C663 sg13cmos5l_inv_16_77.A sg13cmos5l_inv_16_77.Y 0.88095f
C664 sg13cmos5l_inv_16_43.Y a_10600_3230# 0.02559f
C665 sg13cmos5l_inv_16_26.Y en[2] 0.16219f
C666 sg13cmos5l_inv_16_4.Y sg13cmos5l_inv_8_1.Y 0.97551f
C667 sg13cmos5l_inv_16_34.Y sg13cmos5l_and2_1_4.B 0.11217f
C668 sg13cmos5l_inv_16_48.A VPWR 5.57918f
C669 a_13960_8562# sg13cmos5l_inv_16_48.A 0.01109f
C670 sg13cmos5l_inv_16_52.Y sg13cmos5l_and2_1_1.B 0.01553f
C671 a_2816_4742# osc[3] 0.05849f
C672 a_14920_1002# VPWR 0.13847f
C673 sg13cmos5l_inv_16_47.Y VPWR 2.67331f
C674 VPWR en[0] 0.39037f
C675 sg13cmos5l_inv_16_28.A osc[1] 0.07003f
C676 sg13cmos5l_inv_16_15.A sg13cmos5l_inv_16_15.Y 0.87328f
C677 sg13cmos5l_inv_2_2.A sg13cmos5l_inv_16_26.Y 0.01875f
C678 sg13cmos5l_buf_1_2.X VPWR 0.41763f
C679 sg13cmos5l_inv_2_3.Y VPWR 0.90462f
C680 sg13cmos5l_buf_1_12.X sg13cmos5l_inv_16_87.A 0.4329f
C681 a_13864_7050# sg13cmos5l_inv_8_7.Y 0.0122f
C682 sg13cmos5l_inv_16_101.Y a_2920_6168# 0.02338f
C683 sg13cmos5l_inv_16_61.A a_4832_9278# 0.03723f
C684 sg13cmos5l_and2_1_1.B sg13cmos5l_inv_16_28.A 0.0346f
C685 sg13cmos5l_and2_1_1.B sg13cmos5l_buf_1_4.X 0.03235f
C686 sg13cmos5l_inv_16_99.A sg13cmos5l_inv_16_51.Y 0.8863f
C687 sg13cmos5l_inv_8_4.Y sg13cmos5l_inv_16_47.Y 0.01838f
C688 sg13cmos5l_and2_1_0.B sg13cmos5l_inv_16_99.A 0.10002f
C689 sg13cmos5l_inv_16_76.A sg13cmos5l_inv_16_77.Y 0.01586f
C690 sg13cmos5l_buf_1_15.X sg13cmos5l_inv_16_37.A 0.07665f
C691 sg13cmos5l_inv_16_105.Y VPWR 2.6862f
C692 sg13cmos5l_inv_1_0.Y sg13cmos5l_inv_8_1.Y 0.0374f
C693 a_7040_4742# VPWR 0.09323f
C694 sg13cmos5l_inv_16_75.A sg13cmos5l_inv_16_75.Y 0.88439f
C695 sg13cmos5l_and2_1_1.X sg13cmos5l_inv_16_19.Y 0.05567f
C696 a_20680_9278# VPWR 0.18831f
C697 sg13cmos5l_inv_8_0.Y sg13cmos5l_inv_4_0.Y 0.91998f
C698 sg13cmos5l_inv_16_30.A sg13cmos5l_inv_16_31.Y 0.88927f
C699 sg13cmos5l_inv_16_73.Y a_23368_7766# 0.04356f
C700 sg13cmos5l_inv_16_27.Y sg13cmos5l_inv_16_6.Y 0.2252f
C701 sg13cmos5l_inv_16_4.Y sg13cmos5l_inv_1_0.Y 0.03115f
C702 a_2920_9192# VPWR 0.31101f
C703 sg13cmos5l_and2_1_1.B en[4] 0.01528f
C704 sg13cmos5l_inv_16_14.A sg13cmos5l_inv_16_23.Y 1.29179f
C705 sg13cmos5l_inv_16_28.A sg13cmos5l_inv_16_44.Y 0.09317f
C706 sg13cmos5l_inv_16_68.A sg13cmos5l_inv_16_68.Y 0.88832f
C707 a_6848_3230# VPWR 0.11934f
C708 sg13cmos5l_inv_8_1.Y VPWR 2.82759f
C709 sg13cmos5l_and2_1_7.B sg13cmos5l_inv_16_53.A 0.02941f
C710 sg13cmos5l_and2_1_0.B a_16941_916# 0.31745f
C711 sg13cmos5l_inv_16_68.A sg13cmos5l_inv_16_71.Y 1.21225f
C712 sg13cmos5l_inv_8_2.A en[3] 0.04598f
C713 sg13cmos5l_inv_16_4.Y VPWR 5.56558f
C714 sg13cmos5l_inv_1_3.Y VPWR 0.78267f
C715 sg13cmos5l_and2_1_7.B sg13cmos5l_inv_16_22.Y 0.02027f
C716 sg13cmos5l_and2_1_2.X a_3597_916# 0.16364f
C717 sg13cmos5l_inv_4_0.Y a_28556_834# 0.03644f
C718 sg13cmos5l_buf_1_4.X sg13cmos5l_inv_16_6.Y 0.08988f
C719 a_26336_9278# VPWR 0.0673f
C720 sg13cmos5l_and2_1_7.B sg13cmos5l_inv_16_100.Y 0.09509f
C721 sg13cmos5l_inv_16_27.A VPWR 2.8321f
C722 sg13cmos5l_inv_16_27.Y sg13cmos5l_inv_16_26.Y 0.05147f
C723 sg13cmos5l_inv_16_52.Y a_3976_7050# 0.01848f
C724 sg13cmos5l_inv_16_4.Y sg13cmos5l_and2_1_0.X 0.01744f
C725 a_16640_7050# VPWR 0.09306f
C726 sg13cmos5l_inv_16_53.A osc[4] 0.01272f
C727 a_22696_5538# VPWR 0.17163f
C728 a_23368_6254# VPWR 0.1596f
C729 sg13cmos5l_and2_1_0.B sg13cmos5l_buf_1_3.X 0.29385f
C730 a_5800_6254# VPWR 0.18536f
C731 sg13cmos5l_inv_16_6.Y en[4] 0.01974f
C732 sg13cmos5l_inv_1_0.Y VPWR 0.50518f
C733 sg13cmos5l_buf_1_12.X sg13cmos5l_inv_16_109.Y 0.31408f
C734 sg13cmos5l_buf_1_5.X sg13cmos5l_inv_16_31.Y 0.0311f
C735 a_10016_2514# VPWR 0.0751f
C736 sg13cmos5l_and2_1_7.X a_22880_5538# 0.03553f
C737 a_26624_5538# VPWR 0.1193f
C738 sg13cmos5l_inv_16_6.A a_16941_916# 0.0438f
C739 a_20588_834# en[5] 0.33309f
C740 sg13cmos5l_and2_1_7.B sg13cmos5l_and2_1_0.B 1.32739f
C741 sg13cmos5l_inv_4_6.A sg13cmos5l_and2_1_7.X 0.01359f
C742 a_3304_1002# VPWR 0.12383f
C743 sg13cmos5l_inv_1_5.Y a_23368_6254# 0.04511f
C744 sg13cmos5l_inv_8_4.Y a_5800_6254# 0.03325f
C745 a_20397_1980# sg13cmos5l_inv_16_17.A 0.02859f
C746 sg13cmos5l_and2_1_0.X sg13cmos5l_inv_1_0.Y 0.19129f
C747 sg13cmos5l_and2_1_2.B a_3597_916# 0.32772f
C748 a_2632_1718# a_2632_1002# 0.01275f
C749 sg13cmos5l_inv_16_26.A VPWR 5.34053f
C750 sg13cmos5l_inv_2_2.A sg13cmos5l_inv_16_27.A 0.03569f
C751 sg13cmos5l_and2_1_1.X sg13cmos5l_inv_16_17.A 0.02434f
C752 a_13960_8562# VPWR 0.14114f
C753 osc[5] osc[4] 0.11949f
C754 sg13cmos5l_and2_1_1.B sg13cmos5l_inv_16_30.Y 0.01095f
C755 sg13cmos5l_inv_8_2.A sg13cmos5l_inv_16_108.Y 0.10718f
C756 sg13cmos5l_inv_16_85.Y VPWR 2.69188f
C757 a_29120_2514# VPWR 0.11078f
C758 sg13cmos5l_inv_16_105.A sg13cmos5l_inv_16_8.Y 0.06912f
C759 sg13cmos5l_inv_2_2.Y sg13cmos5l_inv_8_2.A 0.64036f
C760 sg13cmos5l_inv_16_69.Y VPWR 5.41858f
C761 sg13cmos5l_inv_16_30.A en[1] 0.04205f
C762 sg13cmos5l_inv_16_29.A sg13cmos5l_inv_16_35.Y 0.87075f
C763 sg13cmos5l_inv_16_51.Y osc[4] 0.04882f
C764 sg13cmos5l_inv_1_5.Y VPWR 0.68138f
C765 sg13cmos5l_inv_8_4.Y VPWR 2.99668f
C766 a_17608_1718# en[4] 0.01019f
C767 sg13cmos5l_and2_1_0.X VPWR 0.59969f
C768 sg13cmos5l_inv_16_26.A en[2] 0.79899f
C769 sg13cmos5l_inv_16_6.A sg13cmos5l_buf_1_3.X 0.08778f
C770 VPWR en[2] 0.18854f
C771 sg13cmos5l_buf_1_12.X sg13cmos5l_inv_16_61.A 0.15422f
C772 sg13cmos5l_inv_16_96.A a_22696_5538# 0.0421f
C773 sg13cmos5l_inv_16_99.A osc[3] 0.10923f
C774 sg13cmos5l_and2_1_0.B a_3597_916# 0.03373f
C775 a_2632_7766# VPWR 0.16095f
C776 sg13cmos5l_and2_1_2.B sg13cmos5l_buf_1_8.X 0.34944f
C777 sg13cmos5l_inv_2_2.A sg13cmos5l_inv_16_26.A 0.1596f
C778 sg13cmos5l_inv_2_2.A VPWR 5.60116f
C779 sg13cmos5l_inv_4_0.A sg13cmos5l_inv_4_0.Y 0.62442f
C780 sg13cmos5l_inv_16_94.A a_25376_8562# 0.03438f
C781 sg13cmos5l_and2_1_7.B sg13cmos5l_inv_16_36.A 0.05888f
C782 sg13cmos5l_buf_1_0.X sg13cmos5l_inv_16_94.A 0.12657f
C783 sg13cmos5l_inv_16_9.A a_15016_3230# 0.03325f
C784 sg13cmos5l_inv_16_54.Y VPWR 2.68058f
C785 a_4648_9278# VPWR 0.14225f
C786 sg13cmos5l_and2_1_0.B sg13cmos5l_and2_1_3.A 0.02557f
C787 sg13cmos5l_buf_1_1.X en[6] 0.2906f
C788 sg13cmos5l_inv_16_73.A sg13cmos5l_buf_1_0.X 0.26086f
C789 sg13cmos5l_inv_16_36.A a_10600_3230# 0.03325f
C790 sg13cmos5l_inv_16_41.A a_4360_4026# 0.03325f
C791 sg13cmos5l_buf_1_1.X sg13cmos5l_inv_16_15.A 0.29039f
C792 sg13cmos5l_and2_1_7.B sg13cmos5l_inv_16_47.A 0.01957f
C793 sg13cmos5l_inv_16_96.A VPWR 2.96497f
C794 sg13cmos5l_buf_1_12.X sg13cmos5l_inv_16_67.Y 0.01168f
C795 sg13cmos5l_inv_16_2.Y VPWR 2.70342f
C796 sg13cmos5l_and2_1_0.B sg13cmos5l_inv_16_25.Y 0.01582f
C797 sg13cmos5l_inv_16_27.Y sg13cmos5l_inv_16_27.A 0.89116f
C798 sg13cmos5l_inv_16_2.A a_25384_1718# 0.04663f
C799 sg13cmos5l_and2_1_3.X sg13cmos5l_inv_16_30.Y 0.05282f
C800 sg13cmos5l_and2_1_0.B sg13cmos5l_buf_1_8.X 0.18871f
C801 a_8192_8562# VPWR 0.09071f
C802 sg13cmos5l_inv_16_47.A sg13cmos5l_inv_16_45.Y 0.87706f
C803 sg13cmos5l_inv_16_84.A VPWR 5.24368f
C804 sg13cmos5l_buf_1_0.X sg13cmos5l_inv_16_88.A 0.02336f
C805 sg13cmos5l_inv_16_56.Y a_4160_7050# 0.03438f
C806 sg13cmos5l_inv_16_84.A sg13cmos5l_inv_16_85.Y 0.88439f
C807 sg13cmos5l_inv_16_27.Y a_10016_2514# 0.03718f
C808 sg13cmos5l_inv_16_76.A sg13cmos5l_inv_16_77.A 1.11379f
C809 a_13288_4026# VPWR 0.14662f
C810 sg13cmos5l_inv_4_6.Y VPWR 2.13762f
C811 a_2920_3932# VPWR 0.32724f
C812 sg13cmos5l_buf_1_4.X sg13cmos5l_inv_16_27.A 0.0458f
C813 sg13cmos5l_inv_16_26.A sg13cmos5l_inv_16_27.Y 0.96913f
C814 sg13cmos5l_inv_16_27.Y VPWR 5.6129f
C815 sg13cmos5l_inv_16_6.Y a_13472_1718# 0.04472f
C816 sg13cmos5l_inv_4_6.Y sg13cmos5l_inv_1_5.Y 0.76363f
C817 sg13cmos5l_and2_1_1.X a_21160_2514# 0.05706f
C818 a_29032_7766# VPWR 0.17298f
C819 sg13cmos5l_and2_1_1.B sg13cmos5l_and2_1_3.B 0.34061f
C820 sg13cmos5l_inv_16_99.A sg13cmos5l_inv_16_99.Y 0.87328f
C821 sg13cmos5l_inv_16_52.Y VPWR 5.35125f
C822 sg13cmos5l_and2_1_7.B sg13cmos5l_inv_16_8.Y 2.48339f
C823 sg13cmos5l_inv_16_101.Y sg13cmos5l_buf_1_15.X 0.04744f
C824 sg13cmos5l_inv_16_69.Y sg13cmos5l_inv_16_52.Y 1.11301f
C825 sg13cmos5l_inv_16_67.A a_10600_9278# 0.03325f
C826 sg13cmos5l_inv_16_11.A sg13cmos5l_inv_16_103.A 1.21894f
C827 sg13cmos5l_inv_16_20.A sg13cmos5l_inv_16_22.Y 0.97116f
C828 osc[4] osc[3] 0.11897f
C829 sg13cmos5l_inv_16_37.A sg13cmos5l_inv_16_43.Y 1.11826f
C830 sg13cmos5l_inv_16_28.A VPWR 7.59642f
C831 sg13cmos5l_buf_1_4.X VPWR 1.0185f
C832 sg13cmos5l_inv_16_36.A a_10600_4742# 0.03325f
C833 sg13cmos5l_inv_16_101.Y sg13cmos5l_inv_16_55.Y 0.96263f
C834 sg13cmos5l_buf_1_0.X sg13cmos5l_buf_1_1.X 0.17533f
C835 sg13cmos5l_inv_2_2.A sg13cmos5l_inv_16_27.Y 0.14379f
C836 a_2632_2514# a_2816_2514# 0.11523f
C837 a_29120_3230# VPWR 0.05787f
C838 sg13cmos5l_buf_1_1.X sg13cmos5l_inv_16_0.A 0.01654f
C839 sg13cmos5l_inv_16_46.A sg13cmos5l_inv_16_36.A 0.17573f
C840 sg13cmos5l_inv_4_6.Y sg13cmos5l_inv_16_96.A 1.18566f
C841 sg13cmos5l_inv_16_48.A sg13cmos5l_inv_1_7.Y 0.02452f
C842 sg13cmos5l_and2_1_1.X sg13cmos5l_inv_8_1.A 0.02405f
C843 a_10600_7766# VPWR 0.1669f
C844 a_2920_4656# osc[3] 0.31911f
C845 sg13cmos5l_buf_1_1.X sg13cmos5l_inv_16_17.A 0.02028f
C846 sg13cmos5l_buf_1_1.X sg13cmos5l_inv_16_13.Y 0.01883f
C847 sg13cmos5l_inv_4_5.Y sg13cmos5l_inv_1_3.Y 0.02087f
C848 sg13cmos5l_inv_16_52.Y a_2632_7766# 0.04409f
C849 a_6376_5538# VPWR 0.16227f
C850 a_13288_1002# VPWR 0.14164f
C851 VPWR en[4] 0.20546f
C852 sg13cmos5l_buf_1_5.X sg13cmos5l_inv_16_30.A 0.54241f
C853 sg13cmos5l_inv_16_47.A sg13cmos5l_inv_16_46.A 0.97607f
C854 a_26824_7050# VPWR 0.15829f
C855 a_3488_9278# VPWR 0.06184f
C856 a_3488_1718# VPWR 0.06555f
C857 sg13cmos5l_buf_1_12.X sg13cmos5l_and2_1_6.X 0.04492f
C858 sg13cmos5l_and2_1_1.B sg13cmos5l_inv_16_99.A 0.02883f
C859 a_23368_1002# VPWR 0.15732f
C860 a_13288_5538# a_13472_5538# 0.11523f
C861 sg13cmos5l_and2_1_7.B sg13cmos5l_inv_16_96.Y 0.02513f
C862 sg13cmos5l_inv_16_68.A sg13cmos5l_inv_16_47.A 0.15825f
C863 a_2920_1632# a_3304_1718# 0.03269f
C864 a_19424_6254# VPWR 0.09117f
C865 sg13cmos5l_and2_1_0.X en[4] 0.25235f
C866 sg13cmos5l_inv_8_4.Y a_6376_5538# 0.01121f
C867 sg13cmos5l_buf_1_5.X a_6957_3492# 0.1606f
C868 a_29120_4742# VPWR 0.05724f
C869 sg13cmos5l_and2_1_3.X sg13cmos5l_and2_1_3.B 0.46741f
C870 sg13cmos5l_and2_1_7.B a_23648_4915# 0.34416f
C871 sg13cmos5l_inv_16_105.A sg13cmos5l_inv_16_9.A 0.08285f
C872 sg13cmos5l_inv_2_1.Y sg13cmos5l_inv_8_1.A 0.56206f
C873 sg13cmos5l_inv_16_73.Y a_20768_7766# 0.03438f
C874 sg13cmos5l_inv_16_95.Y VPWR 2.68062f
C875 sg13cmos5l_inv_16_46.Y sg13cmos5l_inv_16_43.Y 0.01086f
C876 sg13cmos5l_inv_2_7.Y sg13cmos5l_inv_1_3.Y 0.16555f
C877 sg13cmos5l_inv_8_3.Y sg13cmos5l_inv_16_30.A 0.01277f
C878 sg13cmos5l_inv_4_5.Y VPWR 1.44953f
C879 sg13cmos5l_inv_16_73.A sg13cmos5l_inv_16_73.Y 1.02339f
C880 sg13cmos5l_buf_1_5.X a_8204_834# 0.29729f
C881 sg13cmos5l_inv_16_61.A sg13cmos5l_inv_16_61.Y 0.87273f
C882 sg13cmos5l_buf_1_12.X sg13cmos5l_inv_4_7.Y 0.0192f
C883 a_15016_3230# VPWR 0.19339f
C884 sg13cmos5l_inv_16_29.Y osc[0] 0.04955f
C885 sg13cmos5l_inv_8_4.Y sg13cmos5l_inv_4_5.Y 0.87425f
C886 a_13664_4742# VPWR 0.11792f
C887 a_23272_5538# a_23456_5538# 0.11523f
C888 sg13cmos5l_inv_4_2.Y sg13cmos5l_and2_1_3.B 0.19994f
C889 sg13cmos5l_inv_16_1.A a_25384_1718# 0.02147f
C890 sg13cmos5l_and2_1_7.B sg13cmos5l_buf_1_1.X 0.10969f
C891 sg13cmos5l_inv_4_6.A a_24136_5538# 0.03705f
C892 sg13cmos5l_inv_16_30.Y VPWR 2.67077f
C893 a_14048_7050# VPWR 0.07098f
C894 a_23368_9278# a_23552_9278# 0.11523f
C895 a_13664_4097# a_13472_4026# 0.02877f
C896 sg13cmos5l_inv_16_29.A sg13cmos5l_inv_16_44.A 0.64408f
C897 sg13cmos5l_inv_2_7.Y VPWR 0.84593f
C898 sg13cmos5l_inv_16_73.Y sg13cmos5l_inv_16_96.Y 0.02663f
C899 sg13cmos5l_inv_16_20.A sg13cmos5l_and2_1_1.X 0.01745f
C900 sg13cmos5l_inv_16_111.A sg13cmos5l_inv_16_109.Y 1.09457f
C901 sg13cmos5l_buf_1_12.X sg13cmos5l_inv_16_61.Y 0.04882f
C902 sg13cmos5l_and2_1_3.B sg13cmos5l_inv_2_3.Y 0.01154f
C903 sg13cmos5l_inv_16_6.Y a_16941_916# 0.01501f
C904 sg13cmos5l_and2_1_2.B osc[0] 0.60407f
C905 sg13cmos5l_buf_1_12.X sg13cmos5l_inv_2_5.Y 0.01219f
C906 sg13cmos5l_buf_1_12.X sg13cmos5l_inv_16_98.Y 0.07166f
C907 a_24320_5538# VPWR 0.0725f
C908 sg13cmos5l_inv_16_46.A sg13cmos5l_inv_16_50.Y 0.01386f
C909 sg13cmos5l_inv_2_6.Y a_13472_5538# 0.03538f
C910 a_2632_1002# VPWR 0.15182f
C911 a_4744_908# sg13cmos5l_and2_1_3.A 0.32332f
C912 sg13cmos5l_inv_8_3.Y sg13cmos5l_buf_1_5.X 0.03071f
C913 sg13cmos5l_inv_8_4.Y sg13cmos5l_inv_2_7.Y 0.03507f
C914 sg13cmos5l_inv_1_7.Y VPWR 0.68297f
C915 a_2816_4742# VPWR 0.07703f
C916 osc[3] osc[2] 0.05082f
C917 sg13cmos5l_and2_1_0.B sg13cmos5l_inv_16_5.Y 0.01023f
C918 sg13cmos5l_inv_16_105.A sg13cmos5l_inv_16_105.Y 0.891f
C919 a_3304_7766# a_3488_7766# 0.11523f
C920 sg13cmos5l_inv_16_81.Y sg13cmos5l_inv_16_73.Y 0.04305f
C921 sg13cmos5l_inv_2_5.Y sg13cmos5l_inv_16_76.A 0.01374f
C922 sg13cmos5l_and2_1_1.B osc[4] 0.29009f
C923 sg13cmos5l_inv_16_80.Y VPWR 2.67405f
C924 sg13cmos5l_inv_8_0.Y en[7] 0.0272f
C925 a_3488_6254# VPWR 0.07291f
C926 a_13472_1718# VPWR 0.07289f
C927 sg13cmos5l_inv_16_61.A sg13cmos5l_inv_16_71.Y 1.02749f
C928 sg13cmos5l_inv_16_68.A sg13cmos5l_inv_16_66.Y 0.90349f
C929 VPWR en[6] 0.14019f
C930 a_2632_1718# a_2816_1718# 0.11523f
C931 sg13cmos5l_inv_16_8.Y sg13cmos5l_inv_16_20.A 1.03447f
C932 a_2920_1632# sg13cmos5l_and2_1_2.B 0.28823f
C933 sg13cmos5l_inv_16_15.A VPWR 5.07987f
C934 sg13cmos5l_inv_16_37.A sg13cmos5l_inv_16_36.A 0.0127f
C935 sg13cmos5l_and2_1_1.B a_2920_4656# 0.04457f
C936 sg13cmos5l_inv_1_7.A VPWR 0.67422f
C937 sg13cmos5l_and2_1_7.B sg13cmos5l_inv_16_9.A 0.03142f
C938 a_3304_2514# VPWR 0.12771f
C939 sg13cmos5l_and2_1_0.B sg13cmos5l_inv_8_2.A 0.01696f
C940 sg13cmos5l_inv_4_7.Y sg13cmos5l_and2_1_6.X 0.23233f
C941 sg13cmos5l_inv_16_47.A sg13cmos5l_inv_16_37.A 0.15721f
C942 a_2920_908# sg13cmos5l_buf_1_8.X 0.29545f
C943 sg13cmos5l_inv_16_5.Y sg13cmos5l_inv_16_6.A 1.20524f
C944 a_23840_2514# VPWR 0.07545f
C945 a_28556_834# en[7] 0.33598f
C946 sg13cmos5l_inv_16_34.Y VPWR 5.23644f
C947 a_19240_7050# a_19424_7050# 0.11523f
C948 sg13cmos5l_and2_1_1.B sg13cmos5l_inv_16_25.Y 0.09578f
C949 sg13cmos5l_inv_16_19.Y VPWR 2.7117f
C950 sg13cmos5l_buf_1_12.X sg13cmos5l_inv_16_68.Y 0.01023f
C951 sg13cmos5l_and2_1_1.B sg13cmos5l_inv_8_1.A 0.04191f
C952 sg13cmos5l_buf_1_12.X sg13cmos5l_inv_16_71.Y 0.2033f
C953 a_2920_6168# a_3304_6254# 0.03269f
C954 sg13cmos5l_and2_1_0.B sg13cmos5l_inv_16_31.Y 0.01295f
C955 sg13cmos5l_buf_1_12.X sg13cmos5l_inv_16_111.A 0.11868f
C956 sg13cmos5l_and2_1_3.X a_5133_916# 0.12985f
C957 sg13cmos5l_and2_1_3.B VPWR 1.39805f
C958 a_2816_7766# osc[5] 0.05842f
C959 a_3688_8562# VPWR 0.18825f
C960 a_26445_9540# VPWR 0.46797f
C961 sg13cmos5l_inv_16_79.A sg13cmos5l_inv_16_91.Y 0.89565f
C962 a_13960_9278# a_13960_8562# 0.01275f
C963 sg13cmos5l_inv_2_5.Y sg13cmos5l_and2_1_6.X 1.59781f
C964 a_13960_9278# VPWR 0.15731f
C965 sg13cmos5l_buf_1_0.X a_26336_9278# 0.04857f
C966 a_2632_2514# a_2632_1718# 0.01095f
C967 sg13cmos5l_inv_16_81.Y sg13cmos5l_inv_16_79.A 0.97009f
C968 sg13cmos5l_inv_4_0.Y en[7] 0.01794f
C969 sg13cmos5l_inv_16_105.A VPWR 5.01793f
C970 sg13cmos5l_inv_4_5.Y a_6376_5538# 0.01928f
C971 sg13cmos5l_inv_16_61.A sg13cmos5l_inv_16_56.Y 0.01498f
C972 sg13cmos5l_and2_1_7.B sg13cmos5l_inv_16_48.A 0.03054f
C973 sg13cmos5l_inv_16_56.Y sg13cmos5l_inv_16_101.Y 0.08972f
C974 sg13cmos5l_inv_16_101.Y a_3688_5538# 0.01977f
C975 sg13cmos5l_and2_1_7.B sg13cmos5l_inv_16_47.Y 0.02385f
C976 sg13cmos5l_inv_16_58.Y osc[6] 0.03736f
C977 a_2920_6168# sg13cmos5l_and2_1_0.B 0.28869f
C978 a_2632_6254# a_2816_6254# 0.11523f
C979 sg13cmos5l_inv_16_2.A a_23368_1718# 0.03325f
C980 sg13cmos5l_inv_16_47.A sg13cmos5l_inv_16_46.Y 0.30799f
C981 sg13cmos5l_inv_16_6.Y sg13cmos5l_inv_16_25.Y 0.86422f
C982 VPWR osc[7] 0.16627f
C983 sg13cmos5l_inv_16_48.A sg13cmos5l_inv_8_7.Y 1.04541f
C984 sg13cmos5l_inv_1_2.Y a_3872_1718# 0.0481f
C985 sg13cmos5l_inv_16_103.Y sg13cmos5l_inv_16_8.Y 0.12351f
C986 sg13cmos5l_inv_16_69.Y osc[7] 0.02539f
C987 a_25376_8562# VPWR 0.08543f
C988 sg13cmos5l_and2_1_7.B sg13cmos5l_inv_16_105.Y 0.10408f
C989 sg13cmos5l_buf_1_0.X VPWR 1.89904f
C990 sg13cmos5l_inv_16_87.A sg13cmos5l_inv_16_87.Y 0.93071f
C991 sg13cmos5l_inv_2_5.Y sg13cmos5l_inv_4_7.Y 0.87313f
C992 sg13cmos5l_inv_16_53.A sg13cmos5l_inv_16_53.Y 0.88095f
C993 sg13cmos5l_inv_16_9.A sg13cmos5l_inv_16_10.Y 0.88453f
C994 sg13cmos5l_inv_16_0.A VPWR 5.24744f
C995 sg13cmos5l_inv_16_37.A sg13cmos5l_inv_16_37.Y 0.87085f
C996 sg13cmos5l_inv_16_111.A sg13cmos5l_inv_16_111.Y 0.88095f
C997 osc[2] osc[1] 0.04005f
C998 a_2920_9192# sg13cmos5l_and2_1_7.B 0.28875f
C999 sg13cmos5l_inv_1_7.A a_13288_4026# 0.0111f
C1000 a_2632_9278# a_2816_9278# 0.11523f
C1001 sg13cmos5l_inv_16_99.A VPWR 5.51256f
C1002 sg13cmos5l_buf_1_15.X a_13664_4097# 0.35157f
C1003 sg13cmos5l_inv_16_67.A sg13cmos5l_inv_16_48.A 0.01243f
C1004 sg13cmos5l_inv_2_7.Y a_6376_5538# 0.03573f
C1005 sg13cmos5l_buf_1_12.X sg13cmos5l_inv_16_56.Y 0.01004f
C1006 sg13cmos5l_inv_16_53.A sg13cmos5l_inv_16_101.Y 0.22954f
C1007 sg13cmos5l_inv_16_17.A VPWR 5.9592f
C1008 sg13cmos5l_inv_16_13.Y VPWR 2.69232f
C1009 a_8776_4026# VPWR 0.18782f
C1010 sg13cmos5l_inv_16_73.A sg13cmos5l_inv_16_75.A 0.09097f
C1011 a_23368_7050# a_23368_6254# 0.01095f
C1012 sg13cmos5l_and2_1_1.B osc[2] 0.74964f
C1013 sg13cmos5l_inv_16_14.Y VPWR 2.74458f
C1014 sg13cmos5l_and2_1_2.X a_3872_1718# 0.04606f
C1015 sg13cmos5l_and2_1_0.B en[1] 0.54168f
C1016 sg13cmos5l_inv_2_0.A sg13cmos5l_inv_4_0.A 0.19165f
C1017 sg13cmos5l_inv_16_53.Y osc[5] 0.07171f
C1018 a_8000_7766# VPWR 0.12607f
C1019 a_16941_916# VPWR 0.4673f
C1020 sg13cmos5l_inv_16_62.Y VPWR 2.67262f
C1021 sg13cmos5l_and2_1_7.B sg13cmos5l_inv_1_3.Y 0.03012f
C1022 sg13cmos5l_inv_16_65.Y VPWR 2.68629f
C1023 a_23368_7050# VPWR 0.14114f
C1024 sg13cmos5l_inv_16_81.Y a_19240_7050# 0.01513f
C1025 sg13cmos5l_inv_16_101.Y osc[5] 0.04702f
C1026 a_3592_9192# VPWR 0.266f
C1027 sg13cmos5l_inv_16_69.Y sg13cmos5l_inv_16_62.Y 0.93087f
C1028 sg13cmos5l_inv_16_29.A sg13cmos5l_inv_16_29.Y 0.89407f
C1029 sg13cmos5l_inv_16_17.Y VPWR 2.6831f
C1030 sg13cmos5l_inv_2_7.Y sg13cmos5l_inv_4_5.Y 0.76135f
C1031 a_13288_6254# VPWR 0.15611f
C1032 sg13cmos5l_buf_1_12.X sg13cmos5l_inv_16_53.A 0.01849f
C1033 sg13cmos5l_and2_1_0.X a_16941_916# 0.13034f
C1034 sg13cmos5l_inv_16_104.Y VPWR 2.69766f
C1035 sg13cmos5l_inv_16_101.Y sg13cmos5l_and2_1_0.B 0.3912f
C1036 sg13cmos5l_inv_8_2.A a_14636_834# 0.03712f
C1037 sg13cmos5l_inv_8_1.A sg13cmos5l_buf_1_2.X 0.01865f
C1038 sg13cmos5l_inv_16_46.Y sg13cmos5l_inv_16_50.Y 0.87679f
C1039 sg13cmos5l_and2_1_4.X a_6957_3492# 0.12891f
C1040 sg13cmos5l_inv_16_90.Y VPWR 2.71391f
C1041 a_3688_5538# a_3688_4742# 0.01095f
C1042 a_3688_8562# sg13cmos5l_inv_16_52.Y 0.0143f
C1043 sg13cmos5l_buf_1_3.X VPWR 0.27218f
C1044 sg13cmos5l_inv_16_48.A sg13cmos5l_inv_16_46.A 1.16179f
C1045 sg13cmos5l_inv_16_11.A sg13cmos5l_inv_16_22.Y 0.02571f
C1046 sg13cmos5l_inv_16_87.A sg13cmos5l_inv_16_73.A 1.08165f
C1047 sg13cmos5l_and2_1_7.B VPWR 2.26842f
C1048 a_2632_4026# a_2816_4026# 0.11523f
C1049 a_10600_3230# VPWR 0.16089f
C1050 sg13cmos5l_buf_1_15.X sg13cmos5l_inv_16_43.Y 0.02417f
C1051 sg13cmos5l_inv_16_28.A sg13cmos5l_and2_1_3.B 1.06385f
C1052 sg13cmos5l_inv_8_7.Y VPWR 2.94154f
C1053 sg13cmos5l_inv_1_7.Y a_13664_4742# 0.04608f
C1054 sg13cmos5l_and2_1_0.X sg13cmos5l_buf_1_3.X 0.33149f
C1055 sg13cmos5l_and2_1_1.B sg13cmos5l_inv_16_110.Y 0.01224f
C1056 sg13cmos5l_and2_1_7.B sg13cmos5l_inv_8_4.Y 0.01588f
C1057 sg13cmos5l_inv_8_1.A sg13cmos5l_inv_8_1.Y 1.00204f
C1058 a_5133_916# VPWR 0.44943f
C1059 sg13cmos5l_inv_16_45.Y VPWR 2.67652f
C1060 sg13cmos5l_inv_16_4.Y sg13cmos5l_inv_8_1.A 0.34141f
C1061 sg13cmos5l_inv_16_75.A sg13cmos5l_buf_1_1.X 0.02776f
C1062 sg13cmos5l_inv_16_36.Y sg13cmos5l_inv_2_2.Y 0.04863f
C1063 VPWR osc[4] 0.63166f
C1064 sg13cmos5l_inv_16_43.Y sg13cmos5l_inv_2_2.Y 0.47301f
C1065 a_3976_7050# a_4160_7050# 0.11523f
C1066 sg13cmos5l_and2_1_0.B sg13cmos5l_inv_16_30.A 0.06354f
C1067 sg13cmos5l_inv_16_67.A VPWR 5.42223f
C1068 sg13cmos5l_inv_16_20.A a_20288_3230# 0.03438f
C1069 sg13cmos5l_inv_16_111.A sg13cmos5l_inv_16_98.Y 0.88095f
C1070 a_21160_2514# VPWR 0.17036f
C1071 a_23456_5538# VPWR 0.07019f
C1072 sg13cmos5l_inv_16_103.A sg13cmos5l_inv_16_22.Y 0.01125f
C1073 a_3597_916# VPWR 0.45944f
C1074 sg13cmos5l_inv_16_1.A sg13cmos5l_inv_16_2.A 1.20565f
C1075 a_2920_908# osc[0] 0.05266f
C1076 a_4360_4026# VPWR 0.20262f
C1077 sg13cmos5l_inv_16_14.A VPWR 5.26379f
C1078 a_17608_1718# a_17792_1718# 0.11523f
C1079 sg13cmos5l_and2_1_7.B sg13cmos5l_inv_16_96.A 0.02191f
C1080 sg13cmos5l_and2_1_1.B sg13cmos5l_inv_16_5.Y 0.11503f
C1081 a_2920_4656# VPWR 0.32864f
C1082 osc[1] osc[0] 0.12795f
C1083 sg13cmos5l_and2_1_3.A VPWR 0.25419f
C1084 a_3488_9278# osc[7] 0.0611f
C1085 sg13cmos5l_inv_16_35.Y osc[3] 0.02525f
C1086 sg13cmos5l_inv_16_73.Y VPWR 5.60476f
C1087 sg13cmos5l_inv_4_6.A sg13cmos5l_buf_1_1.X 0.02259f
C1088 a_3488_7766# VPWR 0.07283f
C1089 sg13cmos5l_and2_1_1.B osc[0] 0.0149f
C1090 sg13cmos5l_and2_1_0.B a_3688_4742# 0.01107f
C1091 sg13cmos5l_inv_16_87.A sg13cmos5l_inv_16_81.Y 0.03214f
C1092 sg13cmos5l_inv_16_26.A sg13cmos5l_inv_16_25.Y 0.01125f
C1093 sg13cmos5l_and2_1_0.B en[3] 0.416f
C1094 sg13cmos5l_buf_1_12.X sg13cmos5l_inv_16_87.Y 0.0486f
C1095 sg13cmos5l_buf_1_8.X a_3304_1002# 0.02116f
C1096 sg13cmos5l_and2_1_0.B a_8204_834# 0.01206f
C1097 sg13cmos5l_inv_16_54.Y osc[4] 0.07565f
C1098 sg13cmos5l_inv_16_25.Y VPWR 2.69387f
C1099 a_2816_1718# VPWR 0.07295f
C1100 sg13cmos5l_inv_16_47.A a_8104_5538# 0.03325f
C1101 sg13cmos5l_inv_8_1.A VPWR 1.61877f
C1102 sg13cmos5l_inv_16_31.Y sg13cmos5l_inv_16_40.Y 0.01125f
C1103 sg13cmos5l_inv_16_10.Y VPWR 2.68631f
C1104 sg13cmos5l_inv_16_34.Y sg13cmos5l_inv_2_7.Y 0.03576f
C1105 sg13cmos5l_buf_1_8.X VPWR 0.21954f
C1106 sg13cmos5l_inv_1_7.A sg13cmos5l_inv_1_7.Y 0.23798f
C1107 sg13cmos5l_inv_2_0.A sg13cmos5l_inv_16_2.A 0.02605f
C1108 sg13cmos5l_inv_16_37.A a_7912_4742# 0.03325f
C1109 sg13cmos5l_and2_1_0.B sg13cmos5l_buf_1_5.X 0.34921f
C1110 sg13cmos5l_buf_1_15.X sg13cmos5l_inv_16_100.Y 0.0448f
C1111 a_10600_4742# VPWR 0.16757f
C1112 sg13cmos5l_and2_1_1.B sg13cmos5l_inv_8_2.A 0.03646f
C1113 sg13cmos5l_and2_1_7.B sg13cmos5l_inv_4_6.Y 0.04451f
C1114 sg13cmos5l_inv_16_5.Y sg13cmos5l_inv_16_6.Y 0.02933f
C1115 a_2920_1632# osc[1] 0.01297f
C1116 sg13cmos5l_inv_16_46.A VPWR 5.22693f
C1117 sg13cmos5l_and2_1_4.B a_6957_3492# 0.31587f
C1118 sg13cmos5l_buf_1_1.X a_25384_1718# 0.0131f
C1119 a_10600_3230# sg13cmos5l_inv_16_27.Y 0.01122f
C1120 a_16941_916# en[4] 0.02035f
C1121 sg13cmos5l_inv_16_9.A sg13cmos5l_inv_16_5.Y 0.12495f
C1122 sg13cmos5l_and2_1_0.B sg13cmos5l_buf_1_15.X 0.02755f
C1123 sg13cmos5l_and2_1_1.B sg13cmos5l_inv_16_31.Y 0.07577f
C1124 sg13cmos5l_inv_16_79.A a_16640_7050# 0.03438f
C1125 sg13cmos5l_and2_1_7.B sg13cmos5l_inv_16_52.Y 0.2508f
C1126 a_2816_6254# VPWR 0.07638f
C1127 sg13cmos5l_inv_16_68.A VPWR 5.17777f
C1128 sg13cmos5l_inv_16_75.A a_24320_6254# 0.03438f
C1129 sg13cmos5l_buf_1_2.X a_20588_834# 0.29036f
C1130 sg13cmos5l_and2_1_0.B sg13cmos5l_inv_16_55.Y 0.01507f
C1131 a_2920_7680# osc[5] 0.32872f
C1132 a_2632_2514# VPWR 0.15823f
C1133 sg13cmos5l_inv_8_2.A sg13cmos5l_inv_16_6.Y 0.29075f
C1134 sg13cmos5l_and2_1_0.B sg13cmos5l_inv_2_2.Y 0.02675f
C1135 sg13cmos5l_inv_16_29.A osc[3] 0.01113f
C1136 sg13cmos5l_inv_16_23.Y a_29032_4026# 0.03325f
C1137 sg13cmos5l_and2_1_4.B sg13cmos5l_buf_1_5.X 0.33058f
C1138 sg13cmos5l_inv_16_41.A sg13cmos5l_inv_8_3.Y 1.18925f
C1139 sg13cmos5l_inv_16_79.A VPWR 5.4499f
C1140 a_13288_5538# VPWR 0.14827f
C1141 sg13cmos5l_buf_1_3.X en[4] 0.19068f
C1142 a_4744_908# en[1] 0.32451f
C1143 a_23656_2514# sg13cmos5l_inv_16_2.A 0.01473f
C1144 sg13cmos5l_and2_1_1.B a_2920_6168# 0.0405f
C1145 sg13cmos5l_buf_1_12.X sg13cmos5l_inv_16_94.A 0.02738f
C1146 sg13cmos5l_buf_1_12.X sg13cmos5l_inv_16_73.A 0.10787f
C1147 sg13cmos5l_inv_16_73.Y sg13cmos5l_inv_4_6.Y 0.0117f
C1148 sg13cmos5l_inv_16_11.A sg13cmos5l_inv_16_8.Y 0.14544f
C1149 sg13cmos5l_inv_16_105.A sg13cmos5l_inv_16_80.Y 0.90235f
C1150 VPWR osc[2] 1.01878f
C1151 sg13cmos5l_inv_16_105.Y sg13cmos5l_inv_16_103.Y 0.01125f
C1152 sg13cmos5l_buf_1_15.X sg13cmos5l_and2_1_4.B 0.64976f
C1153 sg13cmos5l_inv_16_41.A a_3488_2514# 0.03438f
C1154 sg13cmos5l_buf_1_15.X sg13cmos5l_inv_16_36.A 0.07365f
C1155 a_2816_4026# VPWR 0.07703f
C1156 sg13cmos5l_inv_16_20.A VPWR 5.40802f
C1157 sg13cmos5l_inv_16_102.Y VPWR 2.6876f
C1158 sg13cmos5l_inv_16_1.A a_25484_834# 0.0432f
C1159 sg13cmos5l_and2_1_3.B a_3304_2514# 0.02116f
C1160 a_23456_8562# VPWR 0.09124f
C1161 sg13cmos5l_inv_16_27.Y sg13cmos5l_inv_16_25.Y 0.21602f
C1162 a_23368_9278# VPWR 0.14264f
C1163 sg13cmos5l_and2_1_3.X sg13cmos5l_inv_16_31.Y 0.07859f
C1164 a_4160_7050# VPWR 0.07064f
C1165 sg13cmos5l_inv_16_94.A sg13cmos5l_inv_16_76.A 1.03373f
C1166 sg13cmos5l_inv_2_5.A sg13cmos5l_inv_16_76.A 0.01738f
C1167 sg13cmos5l_inv_16_52.Y a_3488_7766# 0.04229f
C1168 sg13cmos5l_inv_4_4.Y VPWR 1.49105f
C1169 sg13cmos5l_inv_16_71.Y sg13cmos5l_inv_16_56.Y 1.09505f
C1170 osc[0] en[0] 0.31829f
C1171 sg13cmos5l_inv_16_74.Y VPWR 2.68822f
C1172 sg13cmos5l_inv_16_67.A a_10600_7766# 0.03325f
C1173 a_17792_1718# VPWR 0.06998f
C1174 sg13cmos5l_inv_16_36.A sg13cmos5l_inv_2_2.Y 0.05754f
C1175 sg13cmos5l_and2_1_7.B sg13cmos5l_inv_4_5.Y 0.01552f
C1176 sg13cmos5l_and2_1_1.B en[1] 0.04719f
C1177 sg13cmos5l_buf_1_12.X sg13cmos5l_inv_16_66.Y 0.06943f
C1178 sg13cmos5l_inv_16_20.Y VPWR 2.73321f
C1179 sg13cmos5l_inv_16_48.A sg13cmos5l_inv_16_46.Y 0.05266f
C1180 sg13cmos5l_inv_16_103.A sg13cmos5l_inv_16_8.Y 0.25045f
C1181 sg13cmos5l_buf_1_0.X sg13cmos5l_inv_16_15.A 0.11146f
C1182 sg13cmos5l_inv_2_0.A a_25484_834# 0.01103f
C1183 sg13cmos5l_inv_16_96.Y sg13cmos5l_inv_16_11.A 0.99783f
C1184 sg13cmos5l_and2_1_0.X a_17792_1718# 0.04568f
C1185 a_14636_834# en[3] 0.32282f
C1186 a_26152_9278# sg13cmos5l_inv_16_94.A 0.01121f
C1187 sg13cmos5l_inv_16_17.A en[6] 0.02692f
C1188 sg13cmos5l_inv_16_43.Y sg13cmos5l_inv_16_36.Y 0.02468f
C1189 a_19240_7050# VPWR 0.15025f
C1190 sg13cmos5l_inv_16_15.A sg13cmos5l_inv_16_13.Y 0.88453f
C1191 sg13cmos5l_inv_4_2.Y sg13cmos5l_inv_16_31.Y 0.066f
C1192 a_20680_5538# sg13cmos5l_inv_16_8.Y 0.01096f
C1193 a_13288_7766# a_13472_7766# 0.11523f
C1194 sg13cmos5l_inv_16_88.A sg13cmos5l_inv_16_76.A 0.0278f
C1195 a_20588_834# VPWR 0.31876f
C1196 sg13cmos5l_inv_2_6.Y VPWR 0.75953f
C1197 sg13cmos5l_inv_16_84.A sg13cmos5l_inv_16_79.A 0.06779f
C1198 sg13cmos5l_buf_1_12.X sg13cmos5l_inv_16_91.Y 0.01195f
C1199 sg13cmos5l_and2_1_1.B sg13cmos5l_inv_16_101.Y 0.02914f
C1200 sg13cmos5l_buf_1_12.X sg13cmos5l_inv_16_81.Y 0.10324f
C1201 sg13cmos5l_and2_1_7.B sg13cmos5l_inv_2_7.Y 0.03939f
C1202 sg13cmos5l_inv_16_110.Y VPWR 2.95576f
C1203 sg13cmos5l_inv_16_61.A sg13cmos5l_inv_16_59.Y 0.96323f
C1204 sg13cmos5l_inv_16_101.Y a_2632_6254# 0.04581f
C1205 a_2920_2420# osc[1] 0.32333f
C1206 sg13cmos5l_and2_1_2.X sg13cmos5l_inv_1_2.Y 0.30858f
C1207 sg13cmos5l_and2_1_2.B a_3304_1718# 0.02116f
C1208 sg13cmos5l_inv_16_99.A sg13cmos5l_inv_16_34.Y 0.89463f
C1209 sg13cmos5l_inv_2_0.A sg13cmos5l_inv_16_1.A 0.17651f
C1210 sg13cmos5l_inv_16_103.Y VPWR 2.67377f
C1211 sg13cmos5l_inv_16_37.A sg13cmos5l_inv_16_26.A 0.07643f
C1212 sg13cmos5l_inv_16_37.A VPWR 5.28244f
C1213 sg13cmos5l_inv_16_17.A sg13cmos5l_inv_16_19.Y 0.88284f
C1214 sg13cmos5l_and2_1_1.B a_2920_2420# 0.04281f
C1215 sg13cmos5l_inv_16_26.A a_10304_1002# 0.03475f
C1216 sg13cmos5l_inv_16_84.Y VPWR 2.69242f
C1217 a_10304_1002# VPWR 0.08357f
C1218 sg13cmos5l_and2_1_6.X sg13cmos5l_inv_16_94.A 0.01021f
C1219 sg13cmos5l_and2_1_7.B sg13cmos5l_inv_1_7.Y 0.98809f
C1220 sg13cmos5l_inv_16_93.Y VPWR 2.70632f
C1221 sg13cmos5l_and2_1_6.X sg13cmos5l_inv_2_5.A 0.10955f
C1222 a_10600_7766# sg13cmos5l_inv_16_46.A 0.01121f
C1223 sg13cmos5l_inv_16_73.Y sg13cmos5l_inv_16_95.Y 0.9431f
C1224 sg13cmos5l_inv_16_30.A sg13cmos5l_inv_16_40.Y 0.14765f
C1225 sg13cmos5l_buf_1_0.X a_26445_9540# 0.15026f
C1226 sg13cmos5l_inv_16_87.A a_20680_9278# 0.03325f
C1227 a_2632_9278# VPWR 0.15259f
C1228 a_2920_3932# osc[2] 0.32179f
C1229 sg13cmos5l_inv_8_7.Y sg13cmos5l_inv_1_7.Y 0.01847f
C1230 sg13cmos5l_and2_1_3.X en[1] 0.02197f
C1231 sg13cmos5l_inv_16_69.Y a_2632_9278# 0.04409f
C1232 osc[6] osc[5] 0.11548f
C1233 sg13cmos5l_inv_16_75.A VPWR 5.38454f
C1234 a_8864_6254# VPWR 0.11961f
C1235 sg13cmos5l_inv_16_96.Y a_20680_5538# 0.01654f
C1236 sg13cmos5l_and2_1_7.B sg13cmos5l_inv_16_80.Y 0.02329f
C1237 sg13cmos5l_inv_16_29.A osc[1] 0.12119f
C1238 a_22696_5538# a_22880_5538# 0.11523f
C1239 sg13cmos5l_inv_16_5.Y VPWR 4.07855f
C1240 sg13cmos5l_inv_8_2.A sg13cmos5l_inv_16_27.A 1.07092f
C1241 sg13cmos5l_buf_1_12.X sg13cmos5l_inv_16_59.Y 0.06984f
C1242 sg13cmos5l_and2_1_2.B sg13cmos5l_inv_1_2.Y 0.06704f
C1243 sg13cmos5l_inv_16_37.A sg13cmos5l_inv_2_2.A 0.03336f
C1244 sg13cmos5l_and2_1_1.B sg13cmos5l_inv_16_30.A 0.37354f
C1245 VPWR osc[0] 0.6162f
C1246 sg13cmos5l_inv_2_2.A a_10304_1002# 0.04572f
C1247 sg13cmos5l_inv_4_7.Y sg13cmos5l_inv_16_94.A 0.01985f
C1248 sg13cmos5l_and2_1_7.B sg13cmos5l_inv_1_7.A 0.01492f
C1249 sg13cmos5l_inv_16_28.A osc[2] 0.19437f
C1250 sg13cmos5l_and2_1_6.X sg13cmos5l_inv_16_88.A 0.0524f
C1251 sg13cmos5l_inv_16_79.Y VPWR 2.68562f
C1252 sg13cmos5l_buf_1_0.X sg13cmos5l_inv_16_0.A 0.17111f
C1253 sg13cmos5l_inv_16_109.Y sg13cmos5l_inv_16_48.A 1.05968f
C1254 a_22880_5538# VPWR 0.07457f
C1255 sg13cmos5l_inv_4_2.Y en[1] 0.03976f
C1256 VPWR VGND 0.2169p
C1257 a_26432_1002# VGND 0.08419f ; **FLOATING
C1258 a_23368_1002# VGND 0.15569f ; **FLOATING
C1259 sg13cmos5l_inv_16_17.Y VGND 5.96611f
C1260 a_17035_916# VGND 2.88038f
C1261 a_14920_1002# VGND 0.08516f ; **FLOATING
C1262 a_13472_1002# VGND 0.04284f ; **FLOATING
C1263 a_13288_1002# VGND 0.15123f ; **FLOATING
C1264 sg13cmos5l_buf_1_3.X VGND 0.13931f
C1265 a_10304_1002# VGND 0.04248f ; **FLOATING
C1266 a_5227_916# VGND 0.12406f
C1267 sg13cmos5l_inv_16_30.Y VGND 4.62213f
C1268 a_3691_916# VGND 0.54019f
C1269 sg13cmos5l_and2_1_3.A VGND 0.14033f
C1270 a_3488_1002# VGND 0.04226f ; **FLOATING
C1271 a_3304_1002# VGND 0.10863f ; **FLOATING
C1272 a_2816_1002# VGND 0.03768f ; **FLOATING
C1273 a_2632_1002# VGND 0.07896f ; **FLOATING
C1274 sg13cmos5l_inv_16_29.Y VGND 4.76733f
C1275 a_3597_916# VGND 0.11826f
C1276 a_25384_1718# VGND 0.08452f ; **FLOATING
C1277 sg13cmos5l_inv_16_2.Y VGND 4.00113f
C1278 a_23368_1718# VGND 0.15086f ; **FLOATING
C1279 sg13cmos5l_inv_16_19.Y VGND 2.80413f
C1280 a_20491_1980# VGND 2.42062f
C1281 a_20397_1980# VGND 0.45067f
C1282 a_17792_1718# VGND 0.03673f ; **FLOATING
C1283 a_17608_1718# VGND 0.07707f ; **FLOATING
C1284 sg13cmos5l_inv_8_1.Y VGND 0.05857f
C1285 sg13cmos5l_inv_16_108.Y VGND 5.89235f
C1286 a_13472_1718# VGND 0.0424f ; **FLOATING
C1287 a_13288_1718# VGND 0.14642f ; **FLOATING
C1288 sg13cmos5l_inv_16_25.Y VGND 2.17854f
C1289 sg13cmos5l_inv_16_40.Y VGND 5.94801f
C1290 sg13cmos5l_inv_16_31.Y VGND 2.17094f
C1291 a_3872_1718# VGND 0.03951f ; **FLOATING
C1292 a_3488_1718# VGND 0.04209f ; **FLOATING
C1293 a_3304_1718# VGND 0.10601f ; **FLOATING
C1294 sg13cmos5l_and2_1_2.X VGND 0.2586f
C1295 a_2816_1718# VGND 0.03664f ; **FLOATING
C1296 a_2632_1718# VGND 0.07534f ; **FLOATING
C1297 a_2920_1632# VGND 0.47982f
C1298 a_29120_2514# VGND 0.09578f ; **FLOATING
C1299 a_26144_2514# VGND 0.06386f ; **FLOATING
C1300 a_23840_2514# VGND 0.03946f ; **FLOATING
C1301 a_23656_2514# VGND 0.12679f ; **FLOATING
C1302 sg13cmos5l_inv_2_0.A VGND 0.03022f
C1303 a_21160_2514# VGND 0.12361f ; **FLOATING
C1304 sg13cmos5l_inv_2_1.Y VGND 0.20745f
C1305 sg13cmos5l_inv_16_110.Y VGND 4.00458f
C1306 a_10016_2514# VGND 0.04356f ; **FLOATING
C1307 a_9832_2514# VGND 0.12127f ; **FLOATING
C1308 sg13cmos5l_inv_2_2.A VGND 0.24642f
C1309 a_3488_2514# VGND 0.04684f ; **FLOATING
C1310 a_3304_2514# VGND 0.11526f ; **FLOATING
C1311 a_2816_2514# VGND 0.04152f ; **FLOATING
C1312 a_2632_2514# VGND 0.08411f ; **FLOATING
C1313 sg13cmos5l_inv_16_44.Y VGND 5.1169f
C1314 a_29120_3230# VGND 0.07589f ; **FLOATING
C1315 a_28936_3230# VGND 0.13449f ; **FLOATING
C1316 sg13cmos5l_inv_16_14.Y VGND 2.23682f
C1317 sg13cmos5l_inv_16_15.Y VGND 2.27957f
C1318 sg13cmos5l_inv_16_20.Y VGND 2.25375f
C1319 a_20288_3230# VGND 0.09128f ; **FLOATING
C1320 a_17696_3230# VGND 0.08675f ; **FLOATING
C1321 sg13cmos5l_inv_16_9.Y VGND 2.23789f
C1322 a_15016_3230# VGND 0.10673f ; **FLOATING
C1323 sg13cmos5l_inv_16_36.Y VGND 6.16583f
C1324 a_10600_3230# VGND 0.1291f ; **FLOATING
C1325 sg13cmos5l_inv_16_37.Y VGND 5.02699f
C1326 a_7051_3492# VGND 2.18071f
C1327 a_6848_3230# VGND 0.06385f ; **FLOATING
C1328 sg13cmos5l_buf_1_5.X VGND 0.25717f
C1329 a_29032_4026# VGND 0.1296f ; **FLOATING
C1330 sg13cmos5l_inv_16_13.Y VGND 5.41089f
C1331 sg13cmos5l_inv_16_22.Y VGND 7.27625f
C1332 sg13cmos5l_inv_16_10.Y VGND 5.1522f
C1333 a_15104_4026# VGND 0.06276f ; **FLOATING
C1334 a_13801_3940# VGND 0.01177f
C1335 a_13472_4026# VGND 0.05067f ; **FLOATING
C1336 a_13288_4026# VGND 0.16166f ; **FLOATING
C1337 a_13664_4097# VGND 1.93641f
C1338 a_8776_4026# VGND 0.10848f ; **FLOATING
C1339 sg13cmos5l_and2_1_4.X VGND 0.3179f
C1340 a_4360_4026# VGND 0.10582f ; **FLOATING
C1341 a_2816_4026# VGND 0.03653f ; **FLOATING
C1342 a_2632_4026# VGND 0.07916f ; **FLOATING
C1343 sg13cmos5l_inv_16_35.Y VGND 2.55608f
C1344 a_29120_4742# VGND 0.07584f ; **FLOATING
C1345 a_28936_4742# VGND 0.12201f ; **FLOATING
C1346 sg13cmos5l_inv_16_104.Y VGND 6.22529f
C1347 a_23785_5004# VGND 4.61649f
C1348 a_23648_4915# VGND 0.0603f
C1349 sg13cmos5l_buf_1_1.X VGND 0.23166f
C1350 sg13cmos5l_inv_16_103.Y VGND 6.06688f
C1351 sg13cmos5l_inv_16_105.Y VGND 4.83234f
C1352 a_15872_4742# VGND 0.0596f ; **FLOATING
C1353 a_13664_4742# VGND 0.059f ; **FLOATING
C1354 sg13cmos5l_inv_16_100.Y VGND 2.19194f
C1355 a_10600_4742# VGND 0.12669f ; **FLOATING
C1356 sg13cmos5l_inv_16_102.Y VGND 2.18624f
C1357 a_7912_4742# VGND 0.11267f ; **FLOATING
C1358 a_7040_4742# VGND 0.08627f ; **FLOATING
C1359 a_3688_4742# VGND 0.11516f ; **FLOATING
C1360 sg13cmos5l_buf_1_15.X VGND 0.1393f
C1361 a_2816_4742# VGND 0.03621f ; **FLOATING
C1362 a_2632_4742# VGND 0.07582f ; **FLOATING
C1363 sg13cmos5l_inv_16_99.Y VGND 4.69311f
C1364 sg13cmos5l_inv_16_77.Y VGND 4.10771f
C1365 a_26624_5538# VGND 0.05872f ; **FLOATING
C1366 sg13cmos5l_inv_16_75.Y VGND 4.72482f
C1367 a_24320_5538# VGND 0.03814f ; **FLOATING
C1368 a_24136_5538# VGND 0.08515f ; **FLOATING
C1369 a_23456_5538# VGND 0.04482f ; **FLOATING
C1370 a_23272_5538# VGND 0.1051f ; **FLOATING
C1371 a_22880_5538# VGND 0.04277f ; **FLOATING
C1372 a_22696_5538# VGND 0.08435f ; **FLOATING
C1373 a_20680_5538# VGND 0.09918f ; **FLOATING
C1374 sg13cmos5l_and2_1_7.X VGND 0.03137f
C1375 sg13cmos5l_inv_16_80.Y VGND 2.19125f
C1376 a_15784_5538# VGND 0.14321f ; **FLOATING
C1377 a_13472_5538# VGND 0.04243f ; **FLOATING
C1378 a_13288_5538# VGND 0.14832f ; **FLOATING
C1379 sg13cmos5l_inv_16_47.Y VGND 2.18002f
C1380 a_8104_5538# VGND 0.09624f ; **FLOATING
C1381 a_6376_5538# VGND 0.12644f ; **FLOATING
C1382 a_3688_5538# VGND 0.09808f ; **FLOATING
C1383 sg13cmos5l_inv_16_51.Y VGND 2.19962f
C1384 a_29120_6254# VGND 0.0963f ; **FLOATING
C1385 sg13cmos5l_inv_16_74.Y VGND 3.42802f
C1386 a_24320_6254# VGND 0.05941f ; **FLOATING
C1387 a_23368_6254# VGND 0.15334f ; **FLOATING
C1388 a_19424_6254# VGND 0.08511f ; **FLOATING
C1389 a_13472_6254# VGND 0.0424f ; **FLOATING
C1390 a_13288_6254# VGND 0.14642f ; **FLOATING
C1391 sg13cmos5l_inv_16_50.Y VGND 4.17682f
C1392 a_8864_6254# VGND 0.05931f ; **FLOATING
C1393 a_5800_6254# VGND 0.11487f ; **FLOATING
C1394 sg13cmos5l_inv_16_55.Y VGND 2.19383f
C1395 a_3488_6254# VGND 0.04544f ; **FLOATING
C1396 a_3304_6254# VGND 0.11632f ; **FLOATING
C1397 a_2816_6254# VGND 0.04109f ; **FLOATING
C1398 a_2632_6254# VGND 0.08445f ; **FLOATING
C1399 sg13cmos5l_inv_16_54.Y VGND 6.68174f
C1400 a_26824_7050# VGND 0.12501f ; **FLOATING
C1401 a_23552_7050# VGND 0.04237f ; **FLOATING
C1402 a_23368_7050# VGND 0.14686f ; **FLOATING
C1403 a_19424_7050# VGND 0.03819f ; **FLOATING
C1404 a_19240_7050# VGND 0.11979f ; **FLOATING
C1405 sg13cmos5l_inv_16_79.Y VGND 5.87302f
C1406 a_16640_7050# VGND 0.08649f ; **FLOATING
C1407 sg13cmos5l_inv_16_111.Y VGND 4.7934f
C1408 a_14048_7050# VGND 0.03858f ; **FLOATING
C1409 a_13864_7050# VGND 0.11922f ; **FLOATING
C1410 sg13cmos5l_inv_16_45.Y VGND 5.96257f
C1411 a_8096_7050# VGND 0.08635f ; **FLOATING
C1412 a_4160_7050# VGND 0.03831f ; **FLOATING
C1413 a_3976_7050# VGND 0.1198f ; **FLOATING
C1414 sg13cmos5l_inv_16_53.Y VGND 6.00122f
C1415 a_29032_7766# VGND 0.14444f ; **FLOATING
C1416 sg13cmos5l_inv_16_95.Y VGND 4.81708f
C1417 a_23368_7766# VGND 0.1535f ; **FLOATING
C1418 sg13cmos5l_inv_16_90.Y VGND 2.18903f
C1419 a_20768_7766# VGND 0.059f ; **FLOATING
C1420 sg13cmos5l_inv_16_91.Y VGND 2.19248f
C1421 a_13472_7766# VGND 0.04157f ; **FLOATING
C1422 a_13288_7766# VGND 0.16566f ; **FLOATING
C1423 sg13cmos5l_inv_16_67.Y VGND 6.68947f
C1424 a_10600_7766# VGND 0.12589f ; **FLOATING
C1425 sg13cmos5l_inv_16_68.Y VGND 5.97863f
C1426 a_8000_7766# VGND 0.05901f ; **FLOATING
C1427 a_3488_7766# VGND 0.04545f ; **FLOATING
C1428 a_3304_7766# VGND 0.11424f ; **FLOATING
C1429 sg13cmos5l_and2_1_1.B VGND 0.11962f
C1430 a_2816_7766# VGND 0.04109f ; **FLOATING
C1431 a_2632_7766# VGND 0.08445f ; **FLOATING
C1432 a_2920_7680# VGND 0.19612f
C1433 a_29120_8562# VGND 0.07988f ; **FLOATING
C1434 a_25376_8562# VGND 0.0451f ; **FLOATING
C1435 sg13cmos5l_inv_16_87.Y VGND 6.75283f
C1436 a_23456_8562# VGND 0.09212f ; **FLOATING
C1437 sg13cmos5l_inv_16_84.Y VGND 4.59505f
C1438 a_14144_8562# VGND 0.03895f ; **FLOATING
C1439 a_13960_8562# VGND 0.12335f ; **FLOATING
C1440 a_8192_8562# VGND 0.08383f ; **FLOATING
C1441 sg13cmos5l_inv_16_61.Y VGND 4.65725f
C1442 a_3688_8562# VGND 0.09936f ; **FLOATING
C1443 sg13cmos5l_inv_16_62.Y VGND 2.19962f
C1444 a_29120_9278# VGND 0.09627f ; **FLOATING
C1445 a_26539_9540# VGND 3.3324f
C1446 a_26336_9278# VGND 0.03848f ; **FLOATING
C1447 a_26152_9278# VGND 0.12289f ; **FLOATING
C1448 sg13cmos5l_and2_1_6.X VGND 0.56124f
C1449 a_26445_9540# VGND 0.23972f
C1450 sg13cmos5l_buf_1_0.X VGND 0.21253f
C1451 a_23552_9278# VGND 0.04282f ; **FLOATING
C1452 a_23368_9278# VGND 0.15173f ; **FLOATING
C1453 sg13cmos5l_inv_16_93.Y VGND 2.20561f
C1454 a_20680_9278# VGND 0.10162f ; **FLOATING
C1455 sg13cmos5l_inv_16_85.Y VGND 2.18361f
C1456 a_17696_9278# VGND 0.06045f ; **FLOATING
C1457 sg13cmos5l_inv_16_98.Y VGND 2.19442f
C1458 a_13960_9278# VGND 0.13254f ; **FLOATING
C1459 sg13cmos5l_inv_16_65.Y VGND 2.19023f
C1460 a_10600_9278# VGND 0.13855f ; **FLOATING
C1461 sg13cmos5l_inv_16_66.Y VGND 2.19833f
C1462 sg13cmos5l_inv_16_59.Y VGND 2.22633f
C1463 a_4832_9278# VGND 0.0393f ; **FLOATING
C1464 a_4648_9278# VGND 0.12321f ; **FLOATING
C1465 a_3488_9278# VGND 0.04687f ; **FLOATING
C1466 a_3304_9278# VGND 0.11834f ; **FLOATING
C1467 a_2816_9278# VGND 0.04256f ; **FLOATING
C1468 a_2632_9278# VGND 0.08767f ; **FLOATING
C1469 a_2920_9192# VGND 0.25612f
C1470 sg13cmos5l_inv_16_58.Y VGND 4.63355f
C1471 VGND.t198 VGND 0.29472f
C1472 VGND.t52 VGND 0.18764f
C1473 VGND.t3 VGND 0.73679f
C1474 VGND.t2050 VGND 0.04643f
C1475 VGND.t226 VGND 0.04643f
C1476 VGND.t2111 VGND 0.09382f
C1477 VGND.t86 VGND 0.03022f
C1478 VGND.t2108 VGND 0.09382f
C1479 VGND.t1398 VGND 0.09382f
C1480 VGND.t1381 VGND 0.76392f
C1481 VGND.t1260 VGND 0.07619f
C1482 VGND.t635 VGND 0.09287f
C1483 VGND.t1245 VGND 0.62539f
C1484 VGND.t326 VGND 0.24642f
C1485 VGND.t1236 VGND 0.05695f
C1486 VGND.t39 VGND 0.60536f
C1487 VGND.t82 VGND 0.23512f
C1488 VGND.t215 VGND 0.22779f
C1489 VGND.t2361 VGND 3.68993f
C1490 VGND.t575 VGND 1.27524f
C1491 VGND.t2142 VGND 0.86249f
C1492 VGND.t1419 VGND 3.01245f
C1493 VGND.t2144 VGND 1.05596f
C1494 VGND.t1411 VGND 2.44357f
C1495 VGND.t862 VGND 0.20543f
C1496 VGND.t425 VGND 1.23173f
C1497 VGND.t1334 VGND 4.09806f
C1498 VGND.t2136 VGND 0.51889f
C1499 VGND.t414 VGND 0.12894f
C1500 VGND.t343 VGND 3.00007f
C1501 VGND.t534 VGND 0.14033f
C1502 VGND.t125 VGND 0.2586f
C1503 VGND.t591 VGND 0.25126f
C1504 VGND.t898 VGND 0.37979f
C1505 VGND.t916 VGND 0.09382f
C1506 VGND.t1873 VGND 0.09382f
C1507 VGND.t866 VGND 0.09382f
C1508 VGND.t1879 VGND 0.09382f
C1509 VGND.t1882 VGND 0.18764f
C1510 VGND.t1201 VGND 4.27181f
C1511 VGND.t1164 VGND 0.04644f
C1512 VGND.t1026 VGND 2.57975f
C1513 VGND.t1010 VGND 1.91633f
C1514 VGND.t1715 VGND 1.82862f
C1515 VGND.t1944 VGND 0.11905f
C1516 VGND.t1663 VGND 0.09287f
C1517 VGND.t432 VGND 0.33245f
C1518 VGND.t134 VGND 0.3359f
C1519 VGND.t5 VGND 0.74085f
C1520 VGND.t609 VGND 0.09382f
C1521 VGND.t593 VGND 3.89425f
C1522 VGND.t773 VGND 2.49248f
C1523 VGND.t345 VGND 0.18711f
C1524 VGND.t1100 VGND 0.09287f
C1525 VGND.t922 VGND 0.10037f
C1526 VGND.t2140 VGND 0.86249f
C1527 VGND.t1423 VGND 0.09287f
C1528 VGND.t84 VGND 0.37235f
C1529 VGND.t2154 VGND 0.09382f
C1530 VGND.t2156 VGND 0.09382f
C1531 VGND.t2161 VGND 0.04644f
C1532 VGND.t675 VGND 0.5888f
C1533 VGND.t586 VGND 0.78158f
C1534 VGND.t588 VGND 1.15292f
C1535 VGND.t2146 VGND 0.43513f
C1536 VGND.t310 VGND 1.61555f
C1537 VGND.t655 VGND 1.78864f
C1538 VGND.t845 VGND 0.09287f
C1539 VPWR.n0 VGND 0.09026f
C1540 VPWR.n2 VGND 0.94768f
C1541 VPWR.n3 VGND 0.0575f
C1542 VPWR.n4 VGND 0.93471f
C1543 VPWR.n5 VGND 0.15971f
C1544 VPWR.n6 VGND 0.83522f
C1545 VPWR.n7 VGND 0.43137f
C1546 VPWR.n9 VGND 0.04744f
C1547 VPWR.n10 VGND 0.58872f
C1548 VPWR.n11 VGND 0.04689f
C1549 VPWR.n12 VGND 0.37996f
C1550 VPWR.n13 VGND 0.37996f
C1551 VPWR.n15 VGND 0.09742f
C1552 VPWR.n16 VGND 0.55545f
C1553 VPWR.t16 VGND 58.4445f
C1554 VPWR.n17 VGND 0.14813f
C1555 VPWR.n18 VGND 0.52351f
C1556 VPWR.n19 VGND 0.49901f
C1557 VPWR.n21 VGND 0.1481f
C1558 VPWR.n22 VGND 0.70996f
C1559 VPWR.n24 VGND 0.04311f
C1560 VPWR.n25 VGND 0.05195f
C1561 VPWR.n26 VGND 0.04364f
C1562 VPWR.n27 VGND 0.36176f
C1563 VPWR.n28 VGND 0.22933f
C1564 VPWR.n30 VGND 0.03976f
C1565 VPWR.n31 VGND 0.29235f
C1566 VPWR.n33 VGND 0.08808f
C1567 VPWR.n35 VGND 0.08787f
C1568 VPWR.n37 VGND 0.3903f
C1569 VPWR.n38 VGND 0.08823f
C1570 VPWR.n39 VGND 0.08877f
C1571 VPWR.n40 VGND 0.2904f
C1572 VPWR.n42 VGND 0.08823f
C1573 VPWR.n43 VGND 0.08798f
C1574 VPWR.n44 VGND 0.04932f
C1575 VPWR.n46 VGND 0.04645f
C1576 VPWR.n47 VGND 0.19431f
C1577 VPWR.n49 VGND 0.08879f
C1578 VPWR.n50 VGND 0.2332f
C1579 VPWR.n52 VGND 0.08845f
C1580 VPWR.n53 VGND 0.08828f
C1581 VPWR.n54 VGND 0.09553f
C1582 VPWR.n55 VGND 0.08826f
C1583 VPWR.n57 VGND 0.13072f
C1584 VPWR.n59 VGND 0.08081f
C1585 VPWR.n60 VGND 0.11066f
C1586 VPWR.n62 VGND 0.03934f
C1587 VPWR.n63 VGND 0.08888f
C1588 VPWR.n64 VGND 0.04264f
C1589 VPWR.n65 VGND 0.09139f
C1590 VPWR.n67 VGND 0.04264f
C1591 VPWR.n68 VGND 0.09139f
C1592 VPWR.n70 VGND 0.09139f
C1593 VPWR.n72 VGND 0.0465f
C1594 VPWR.n73 VGND 0.08874f
C1595 VPWR.t177 VGND 57.5128f
C1596 VPWR.n74 VGND 0.04647f
C1597 VPWR.n75 VGND 0.08872f
C1598 VPWR.n76 VGND 0.04719f
C1599 VPWR.n77 VGND 0.13528f
C1600 VPWR.n79 VGND 0.09576f
C1601 VPWR.n80 VGND 0.08758f
C1602 VPWR.n82 VGND 0.08758f
C1603 VPWR.n84 VGND 0.08086f
C1604 VPWR.n85 VGND 0.08758f
C1605 VPWR.n87 VGND 0.1276f
C1606 VPWR.n89 VGND 0.23494f
C1607 VPWR.n90 VGND 0.1323f
C1608 VPWR.n92 VGND 0.09124f
C1609 VPWR.n94 VGND 12.775f
C1610 VPWR.n95 VGND 0.92521f
C1611 VPWR.n96 VGND 7.97088f
C1612 VPWR.n97 VGND 0.03895f
C1613 VPWR.n99 VGND 0.04064f
C1614 VPWR.n101 VGND 0.05758f
C1615 VPWR.n103 VGND 0.05758f
C1616 VPWR.n104 VGND 0.04801f
C1617 VPWR.n106 VGND 0.05271f
C1618 VPWR.n108 VGND 0.05758f
C1619 VPWR.n109 VGND 0.06637f
C1620 VPWR.n111 VGND 0.05758f
C1621 VPWR.n112 VGND 0.05323f
C1622 VPWR.n113 VGND 0.14802f
C1623 VPWR.n114 VGND 0.09319f
C1624 VPWR.n115 VGND 0.05323f
C1625 VPWR.n116 VGND 0.05579f
C1626 VPWR.n117 VGND 0.04746f
C1627 VPWR.n118 VGND 0.08774f
C1628 VPWR.n119 VGND 0.08774f
C1629 VPWR.n120 VGND 0.0112f
C1630 VPWR.n121 VGND 0.01074f
C1631 VPWR.n122 VGND 0.07889f
C1632 VPWR.n123 VGND 0.14799f
C1633 VPWR.n124 VGND 0.04248f
C1634 VPWR.n125 VGND 0.05323f
C1635 VPWR.n126 VGND 0.04801f
C1636 VPWR.n128 VGND 0.05008f
C1637 VPWR.n130 VGND 0.04801f
C1638 VPWR.n131 VGND 0.05045f
C1639 VPWR.n133 VGND 0.05846f
C1640 VPWR.n136 VGND 0.09037f
C1641 VPWR.n137 VGND 0.05758f
C1642 VPWR.n139 VGND 0.04738f
C1643 VPWR.n140 VGND 0.05323f
C1644 VPWR.n141 VGND 0.05758f
C1645 VPWR.n142 VGND 0.08774f
C1646 VPWR.n145 VGND 0.08331f
C1647 VPWR.n147 VGND 0.08766f
C1648 VPWR.n148 VGND 0.05731f
C1649 VPWR.n149 VGND 0.08704f
C1650 VPWR.n150 VGND 0.04921f
C1651 VPWR.n151 VGND 0.08704f
C1652 VPWR.n153 VGND 0.08398f
C1653 VPWR.n155 VGND 0.08398f
C1654 VPWR.n156 VGND 0.05758f
C1655 VPWR.n157 VGND 0.08773f
C1656 VPWR.n159 VGND 0.05758f
C1657 VPWR.n160 VGND 0.04746f
C1658 VPWR.n161 VGND 0.08774f
C1659 VPWR.n164 VGND 0.09884f
C1660 VPWR.n167 VGND 0.0882f
C1661 VPWR.n168 VGND 0.09836f
C1662 VPWR.n169 VGND 0.08612f
C1663 VPWR.n171 VGND 0.01613f
C1664 VPWR.n172 VGND 0.09424f
C1665 VPWR.n173 VGND 0.09365f
C1666 VPWR.n174 VGND 0.04788f
C1667 VPWR.n175 VGND 0.10014f
C1668 VPWR.n176 VGND 0.01613f
C1669 VPWR.n177 VGND 0.09424f
C1670 VPWR.n178 VGND 0.09365f
C1671 VPWR.n179 VGND 0.08638f
C1672 VPWR.n182 VGND 0.093f
C1673 VPWR.n183 VGND 0.07872f
C1674 VPWR.n184 VGND 0.07872f
C1675 VPWR.n186 VGND 0.07872f
C1676 VPWR.n188 VGND 0.07872f
C1677 VPWR.n189 VGND 0.07872f
C1678 VPWR.n190 VGND 0.08865f
C1679 VPWR.n191 VGND 0.15358f
C1680 VPWR.n192 VGND 0.08525f
C1681 VPWR.n193 VGND 0.0821f
C1682 VPWR.n194 VGND 0.0118f
C1683 VPWR.n196 VGND 0.08214f
C1684 VPWR.n197 VGND 0.01216f
C1685 VPWR.n198 VGND 0.08187f
C1686 VPWR.n199 VGND 0.01216f
C1687 VPWR.n200 VGND 0.08187f
C1688 VPWR.n202 VGND 0.08207f
C1689 VPWR.n204 VGND 0.08207f
C1690 VPWR.n205 VGND 0.08124f
C1691 VPWR.n206 VGND 0.05758f
C1692 VPWR.n207 VGND 0.0845f
C1693 VPWR.n208 VGND 0.13821f
C1694 VPWR.n209 VGND 0.09327f
C1695 VPWR.n210 VGND 0.0845f
C1696 VPWR.n211 VGND 0.0845f
C1697 VPWR.n212 VGND 0.0845f
C1698 VPWR.n213 VGND 0.0845f
C1699 VPWR.n214 VGND 5.57526f
C1700 VPWR.n215 VGND 0.33638f
C1701 VPWR.n216 VGND 0.01295f
C1702 VPWR.n217 VGND 0.08257f
C1703 VPWR.n219 VGND 0.04822f
C1704 VPWR.n220 VGND 0.04801f
C1705 VPWR.n223 VGND 0.06637f
C1706 VPWR.n226 VGND 0.05472f
C1707 VPWR.n228 VGND 0.09262f
C1708 VPWR.n229 VGND 0.05175f
C1709 VPWR.n230 VGND 0.08438f
C1710 VPWR.n231 VGND 0.11351f
C1711 VPWR.t4 VGND 57.5128f
C1712 VPWR.n233 VGND 0.07943f
C1713 VPWR.n234 VGND 0.0146f
C1714 VPWR.n235 VGND 0.07323f
C1715 VPWR.n236 VGND 0.01443f
C1716 VPWR.n237 VGND 0.07355f
C1717 VPWR.n238 VGND 0.01406f
C1718 VPWR.n239 VGND 0.08041f
C1719 VPWR.n240 VGND 0.01414f
C1720 VPWR.n241 VGND 0.07404f
C1721 VPWR.n243 VGND 0.08123f
C1722 VPWR.n244 VGND 0.01594f
C1723 VPWR.n245 VGND 0.09702f
C1724 VPWR.n246 VGND 0.01469f
C1725 VPWR.n247 VGND 0.08118f
C1726 VPWR.n248 VGND 0.01437f
C1727 VPWR.n249 VGND 0.08009f
C1728 VPWR.n250 VGND 0.01469f
C1729 VPWR.n251 VGND 0.07324f
C1730 VPWR.n252 VGND 0.01469f
C1731 VPWR.n253 VGND 0.08118f
C1732 VPWR.n254 VGND 0.08086f
C1733 VPWR.n256 VGND 0.08009f
C1734 VPWR.n257 VGND 0.01437f
C1735 VPWR.n258 VGND 0.07324f
C1736 VPWR.n259 VGND 0.08118f
C1737 VPWR.n260 VGND 0.08009f
C1738 VPWR.n261 VGND 0.01437f
C1739 VPWR.n262 VGND 0.07324f
C1740 VPWR.n263 VGND 0.03422f
C1741 VPWR.n265 VGND 0.08075f
C1742 VPWR.n266 VGND 0.01631f
C1743 VPWR.n267 VGND 0.07308f
C1744 VPWR.n268 VGND 0.01631f
C1745 VPWR.n269 VGND 0.07308f
C1746 VPWR.n270 VGND 0.01631f
C1747 VPWR.n271 VGND 0.07308f
C1748 VPWR.n272 VGND 0.01469f
C1749 VPWR.n273 VGND 0.07308f
C1750 VPWR.n274 VGND 0.01469f
C1751 VPWR.n275 VGND 0.07308f
C1752 VPWR.n276 VGND 0.01469f
C1753 VPWR.n277 VGND 0.07308f
C1754 VPWR.n278 VGND 0.01631f
C1755 VPWR.n279 VGND 0.07343f
C1756 VPWR.n280 VGND 0.05731f
C1757 VPWR.n282 VGND 0.05731f
C1758 VPWR.n284 VGND 0.05731f
C1759 VPWR.n288 VGND 0.04423f
C1760 VPWR.n289 VGND 0.05731f
C1761 VPWR.n291 VGND 0.01246f
C1762 VPWR.n292 VGND 0.03433f
C1763 VPWR.n295 VGND 0.04998f
C1764 VPWR.n296 VGND 0.03433f
C1765 VPWR.n298 VGND 0.04993f
C1766 VPWR.n300 VGND 0.04998f
C1767 VPWR.n301 VGND 0.03433f
C1768 VPWR.n304 VGND 0.05731f
C1769 VPWR.n307 VGND 0.05731f
C1770 VPWR.n308 VGND 0.04052f
C1771 VPWR.n310 VGND 0.04993f
C1772 VPWR.n311 VGND 0.04998f
C1773 VPWR.n312 VGND 0.03433f
C1774 VPWR.n315 VGND 0.05731f
C1775 VPWR.n317 VGND 0.05731f
C1776 VPWR.n318 VGND 0.05731f
C1777 VPWR.n321 VGND 0.05731f
C1778 VPWR.n324 VGND 0.04993f
C1779 VPWR.n325 VGND 0.04264f
C1780 VPWR.n326 VGND 0.05115f
C1781 VPWR.n330 VGND 0.05639f
C1782 VPWR.n332 VGND 0.0146f
C1783 VPWR.n333 VGND 0.08804f
C1784 VPWR.n334 VGND 0.0146f
C1785 VPWR.n335 VGND 0.08804f
C1786 VPWR.n336 VGND 0.0146f
C1787 VPWR.n337 VGND 0.08804f
C1788 VPWR.n339 VGND 0.04188f
C1789 VPWR.n341 VGND 0.0412f
C1790 VPWR.n342 VGND 0.04065f
C1791 VPWR.n344 VGND 0.20502f
C1792 VPWR.n345 VGND 0.0497f
C1793 VPWR.n346 VGND 0.04228f
C1794 VPWR.n350 VGND 0.04086f
C1795 VPWR.n351 VGND 0.04086f
C1796 VPWR.n355 VGND 0.04228f
C1797 VPWR.n357 VGND 0.04248f
C1798 VPWR.n358 VGND 0.0431f
C1799 VPWR.n362 VGND 0.04208f
C1800 VPWR.n363 VGND 0.04208f
C1801 VPWR.n366 VGND 0.04264f
C1802 VPWR.n367 VGND 0.0433f
C1803 VPWR.n369 VGND 0.04183f
C1804 VPWR.n370 VGND 0.04208f
C1805 VPWR.n373 VGND 0.04183f
C1806 VPWR.n374 VGND 0.04208f
C1807 VPWR.n375 VGND 0.04106f
C1808 VPWR.n377 VGND 0.04747f
C1809 VPWR.n379 VGND 0.04025f
C1810 VPWR.n381 VGND 0.04998f
C1811 VPWR.n382 VGND 0.04278f
C1812 VPWR.n383 VGND 0.10603f
C1813 VPWR.n384 VGND 0.08081f
C1814 VPWR.n385 VGND 0.09393f
C1815 VPWR.n387 VGND 0.09278f
C1816 VPWR.n389 VGND 0.08245f
C1817 VPWR.n390 VGND 0.08584f
C1818 VPWR.n391 VGND 0.16168f
C1819 VPWR.n392 VGND 0.14813f
C1820 VPWR.n393 VGND 0.16038f
C1821 VPWR.n395 VGND 0.09014f
C1822 VPWR.n397 VGND 0.08374f
C1823 VPWR.n398 VGND 0.05175f
C1824 VPWR.n399 VGND 0.08438f
C1825 VPWR.n401 VGND 0.01354f
C1826 VPWR.n402 VGND 0.08109f
C1827 VPWR.n403 VGND 0.08086f
C1828 VPWR.n406 VGND 0.04172f
C1829 VPWR.n407 VGND 0.03086f
C1830 VPWR.n408 VGND 0.05542f
C1831 VPWR.n409 VGND 0.03441f
C1832 VPWR.n417 VGND 0.07998f
C1833 VPWR.n419 VGND 0.05155f
C1834 VPWR.n420 VGND 0.04264f
C1835 VPWR.n421 VGND 0.04574f
C1836 VPWR.n422 VGND 0.04907f
C1837 VPWR.n424 VGND 0.14813f
C1838 VPWR.n425 VGND 0.11075f
C1839 VPWR.n427 VGND 0.08081f
C1840 VPWR.n428 VGND 0.13783f
C1841 VPWR.n429 VGND 0.11861f
C1842 VPWR.n430 VGND 0.13783f
C1843 VPWR.n431 VGND 0.08081f
C1844 VPWR.n433 VGND 0.10525f
C1845 VPWR.n434 VGND 0.13783f
C1846 VPWR.n435 VGND 0.06994f
C1847 VPWR.n436 VGND 0.13783f
C1848 VPWR.n437 VGND 0.07368f
C1849 VPWR.n438 VGND 0.05182f
C1850 VPWR.n440 VGND 0.08686f
C1851 VPWR.n441 VGND 0.04194f
C1852 VPWR.n442 VGND 0.05058f
C1853 VPWR.n443 VGND 0.09084f
C1854 VPWR.n445 VGND 0.10017f
C1855 VPWR.n446 VGND 0.09252f
C1856 VPWR.n448 VGND 0.05084f
C1857 VPWR.n450 VGND 0.09252f
C1858 VPWR.n451 VGND 0.09252f
C1859 VPWR.n453 VGND 0.1481f
C1860 VPWR.n454 VGND 0.047f
C1861 VPWR.n455 VGND 0.15802f
C1862 VPWR.n456 VGND 0.13424f
C1863 VPWR.n457 VGND 0.11641f
C1864 VPWR.n458 VGND 0.01393f
C1865 VPWR.n459 VGND 0.09077f
C1866 VPWR.n462 VGND 0.05473f
C1867 VPWR.n464 VGND 0.1481f
C1868 VPWR.n466 VGND 0.14813f
C1869 VPWR.n467 VGND 0.15689f
C1870 VPWR.n469 VGND 0.05636f
C1871 VPWR.n471 VGND 0.1481f
C1872 VPWR.n472 VGND 0.1288f
C1873 VPWR.n473 VGND 0.1481f
C1874 VPWR.n474 VGND 0.10743f
C1875 VPWR.n476 VGND 0.1481f
C1876 VPWR.n477 VGND 0.14813f
C1877 VPWR.n478 VGND 0.11594f
C1878 VPWR.n479 VGND 0.01034f
C1879 VPWR.n480 VGND 0.1481f
C1880 VPWR.n481 VGND 0.10743f
C1881 VPWR.n482 VGND 0.1481f
C1882 VPWR.n483 VGND 0.10865f
C1883 VPWR.n484 VGND 0.1481f
C1884 VPWR.n485 VGND 0.14813f
C1885 VPWR.n486 VGND 0.11594f
C1886 VPWR.n487 VGND 0.03922f
C1887 VPWR.n488 VGND 0.1481f
C1888 VPWR.n489 VGND 0.10743f
C1889 VPWR.n490 VGND 0.1481f
C1890 VPWR.n491 VGND 0.10143f
C1891 VPWR.n492 VGND 0.04998f
C1892 VPWR.n493 VGND 0.03198f
C1893 VPWR.n494 VGND 0.01584f
C1894 VPWR.n495 VGND 0.0865f
C1895 VPWR.n496 VGND 0.01521f
C1896 VPWR.n497 VGND 0.07237f
C1897 VPWR.n498 VGND 0.07964f
C1898 VPWR.n500 VGND 0.07969f
C1899 VPWR.n501 VGND 0.01521f
C1900 VPWR.n502 VGND 0.07237f
C1901 VPWR.n503 VGND 0.13783f
C1902 VPWR.n504 VGND 0.0681f
C1903 VPWR.n505 VGND 0.06636f
C1904 VPWR.n506 VGND 0.13783f
C1905 VPWR.n507 VGND 0.0681f
C1906 VPWR.n508 VGND 0.06636f
C1907 VPWR.n509 VGND 0.13783f
C1908 VPWR.n510 VGND 0.06691f
C1909 VPWR.n512 VGND 0.13783f
C1910 VPWR.n513 VGND 0.04172f
C1911 VPWR.n514 VGND 0.05926f
C1912 VPWR.n515 VGND 0.06652f
C1913 VPWR.n517 VGND 0.13783f
C1914 VPWR.n518 VGND 0.06623f
C1915 VPWR.n519 VGND 0.13783f
C1916 VPWR.n520 VGND 0.06109f
C1917 VPWR.n522 VGND 0.13783f
C1918 VPWR.n523 VGND 0.06808f
C1919 VPWR.n524 VGND 0.13783f
C1920 VPWR.n525 VGND 0.0497f
C1921 VPWR.n526 VGND 0.06622f
C1922 VPWR.n528 VGND 0.01403f
C1923 VPWR.n529 VGND 0.0703f
C1924 VPWR.n530 VGND 0.13783f
C1925 VPWR.n531 VGND 0.06691f
C1926 VPWR.n533 VGND 0.13783f
C1927 VPWR.n534 VGND 0.04127f
C1928 VPWR.n535 VGND 0.05826f
C1929 VPWR.n536 VGND 0.13783f
C1930 VPWR.n537 VGND 0.06069f
C1931 VPWR.n539 VGND 0.13783f
C1932 VPWR.n540 VGND 0.0681f
C1933 VPWR.n542 VGND 0.13783f
C1934 VPWR.n543 VGND 0.04172f
C1935 VPWR.n544 VGND 0.05926f
C1936 VPWR.n545 VGND 0.06636f
C1937 VPWR.n546 VGND 0.13783f
C1938 VPWR.n547 VGND 0.06691f
C1939 VPWR.n548 VGND 0.06637f
C1940 VPWR.n549 VGND 0.13783f
C1941 VPWR.n550 VGND 0.06689f
C1942 VPWR.n552 VGND 0.13783f
C1943 VPWR.n553 VGND 0.04172f
C1944 VPWR.n554 VGND 0.05927f
C1945 VPWR.n555 VGND 0.06637f
C1946 VPWR.n556 VGND 0.13783f
C1947 VPWR.n557 VGND 0.06808f
C1948 VPWR.n559 VGND 0.13783f
C1949 VPWR.n560 VGND 0.06623f
C1950 VPWR.n561 VGND 0.13783f
C1951 VPWR.n562 VGND 0.06808f
C1952 VPWR.n563 VGND 0.13783f
C1953 VPWR.n564 VGND 0.06109f
C1954 VPWR.n565 VGND 0.01196f
C1955 VPWR.n566 VGND 0.13783f
C1956 VPWR.n567 VGND 0.06689f
C1957 VPWR.n568 VGND 0.04745f
C1958 VPWR.n569 VGND 0.14813f
C1959 VPWR.n570 VGND 0.10394f
C1960 VPWR.n571 VGND 0.04723f
C1961 VPWR.n572 VGND 0.1756f
C1962 VPWR.n573 VGND 0.1481f
C1963 VPWR.n574 VGND 0.04051f
C1964 VPWR.n575 VGND 0.10664f
C1965 VPWR.n576 VGND 0.08877f
C1966 VPWR.n577 VGND 0.14813f
C1967 VPWR.n578 VGND 0.1481f
C1968 VPWR.n579 VGND 0.12495f
C1969 VPWR.n581 VGND 0.14813f
C1970 VPWR.n582 VGND 0.05236f
C1971 VPWR.n583 VGND 0.12491f
C1972 VPWR.n585 VGND 0.14813f
C1973 VPWR.n586 VGND 0.05236f
C1974 VPWR.n587 VGND 0.12491f
C1975 VPWR.n589 VGND 0.14813f
C1976 VPWR.n590 VGND 0.05236f
C1977 VPWR.n591 VGND 0.21765f
C1978 VPWR.n593 VGND 0.14813f
C1979 VPWR.n594 VGND 0.14799f
C1980 VPWR.n595 VGND 1.32699f
C1981 VPWR.n596 VGND 0.1481f
C1982 VPWR.n597 VGND 0.15472f
C1983 VPWR.n598 VGND 0.14813f
C1984 VPWR.n599 VGND 0.14813f
C1985 VPWR.n600 VGND 0.1481f
C1986 VPWR.n601 VGND 0.1481f
C1987 VPWR.n602 VGND 0.14802f
C1988 VPWR.n603 VGND 0.1481f
C1989 VPWR.n604 VGND 0.42231f
C1990 VPWR.t9 VGND 57.5129f
C1991 VPWR.t0 VGND 57.5139f
C1992 VPWR.t25 VGND 57.5128f
C1993 VPWR.n605 VGND 0.04125f
C1994 VPWR.n606 VGND 0.14813f
C1995 VPWR.n607 VGND 0.11074f
C1996 VPWR.n609 VGND 0.1481f
C1997 VPWR.n610 VGND 0.112f
C1998 VPWR.n612 VGND 0.1481f
C1999 VPWR.n613 VGND 0.10956f
C2000 VPWR.n615 VGND 0.14813f
C2001 VPWR.n616 VGND 0.10952f
C2002 VPWR.n618 VGND 0.03451f
C2003 VPWR.n619 VGND 0.14813f
C2004 VPWR.n620 VGND 0.0792f
C2005 VPWR.n621 VGND 0.01003f
C2006 VPWR.n622 VGND 0.04052f
C2007 VPWR.n623 VGND 0.1481f
C2008 VPWR.n624 VGND 0.10956f
C2009 VPWR.n626 VGND 0.14813f
C2010 VPWR.n627 VGND 0.10398f
C2011 VPWR.n631 VGND 0.01029f
C2012 VPWR.n636 VGND 0.3568f
C2013 VPWR.t687 VGND 1.45753f
C2014 VPWR.t272 VGND 1.93692f
C2015 VPWR.t707 VGND 3.12424f
C2016 VPWR.t706 VGND 0.61799f
C2017 VPWR.t2421 VGND 0.13443f
C2018 VPWR.t429 VGND 0.32969f
C2019 VPWR.n637 VGND 0.08879f
C2020 VPWR.n638 VGND 0.09693f
C2021 VPWR.n639 VGND 0.01544f
C2022 VPWR.t527 VGND 0.0399f
C2023 VPWR.t542 VGND 0.0399f
C2024 VPWR.n640 VGND 0.07214f
C2025 VPWR.n641 VGND 0.01584f
C2026 VPWR.t525 VGND 0.0399f
C2027 VPWR.t540 VGND 0.0399f
C2028 VPWR.n642 VGND 0.07177f
C2029 VPWR.n643 VGND 0.01606f
C2030 VPWR.t523 VGND 0.0399f
C2031 VPWR.t538 VGND 3.8286f
C2032 VPWR.n644 VGND 0.0716f
C2033 VPWR.n645 VGND 0.01613f
C2034 VPWR.t522 VGND 0.03652f
C2035 VPWR.t521 VGND 0.03652f
C2036 VPWR.n646 VGND 0.09323f
C2037 VPWR.n647 VGND 0.01834f
C2038 VPWR.n648 VGND 0.01141f
C2039 VPWR.n649 VGND 0.01235f
C2040 VPWR.n650 VGND 0.01222f
C2041 VPWR.t1845 VGND 0.0399f
C2042 VPWR.t1811 VGND 0.03652f
C2043 VPWR.t1847 VGND 0.0399f
C2044 VPWR.n651 VGND 0.03332f
C2045 VPWR.t1812 VGND 0.0399f
C2046 VPWR.n652 VGND 0.04054f
C2047 VPWR.t1849 VGND 0.0399f
C2048 VPWR.n654 VGND 0.03332f
C2049 VPWR.t1814 VGND 0.0399f
C2050 VPWR.n655 VGND 0.03332f
C2051 VPWR.t1851 VGND 0.04169f
C2052 VPWR.n657 VGND 0.04075f
C2053 VPWR.t1816 VGND 0.09924f
C2054 VPWR.n658 VGND 0.04085f
C2055 VPWR.t1818 VGND 0.03652f
C2056 VPWR.n660 VGND 0.04074f
C2057 VPWR.t1013 VGND 0.1056f
C2058 VPWR.n662 VGND 0.04024f
C2059 VPWR.t689 VGND 0.03601f
C2060 VPWR.t2009 VGND 0.46859f
C2061 VPWR.n663 VGND 0.0363f
C2062 VPWR.n664 VGND 0.03726f
C2063 VPWR.n665 VGND 0.01603f
C2064 VPWR.t529 VGND 0.0399f
C2065 VPWR.t544 VGND 0.0399f
C2066 VPWR.n666 VGND 0.07942f
C2067 VPWR.t531 VGND 0.0399f
C2068 VPWR.t546 VGND 0.0399f
C2069 VPWR.n668 VGND 0.07936f
C2070 VPWR.n669 VGND 0.01552f
C2071 VPWR.t533 VGND 0.0399f
C2072 VPWR.t548 VGND 0.0399f
C2073 VPWR.n670 VGND 0.07206f
C2074 VPWR.n671 VGND 0.01585f
C2075 VPWR.t537 VGND 0.14102f
C2076 VPWR.t348 VGND 0.24199f
C2077 VPWR.t535 VGND 0.0399f
C2078 VPWR.t550 VGND 0.0399f
C2079 VPWR.n672 VGND 0.11742f
C2080 VPWR.t428 VGND 0.33097f
C2081 VPWR.t2419 VGND 0.0399f
C2082 VPWR.n673 VGND 0.03858f
C2083 VPWR.n674 VGND 0.0457f
C2084 VPWR.n675 VGND 0.01061f
C2085 VPWR.t2417 VGND 0.0399f
C2086 VPWR.n676 VGND 0.04027f
C2087 VPWR.t1923 VGND 0.25179f
C2088 VPWR.n678 VGND 0.03743f
C2089 VPWR.t2415 VGND 0.0399f
C2090 VPWR.t2413 VGND 0.0399f
C2091 VPWR.t2184 VGND 0.03652f
C2092 VPWR.t2182 VGND 0.04067f
C2093 VPWR.t2411 VGND 0.0399f
C2094 VPWR.t2180 VGND 0.0399f
C2095 VPWR.n679 VGND 0.03994f
C2096 VPWR.t2409 VGND 0.0399f
C2097 VPWR.n681 VGND 0.03332f
C2098 VPWR.n682 VGND 0.01446f
C2099 VPWR.t2178 VGND 0.2353f
C2100 VPWR.n683 VGND 0.03332f
C2101 VPWR.t2407 VGND 0.0399f
C2102 VPWR.n685 VGND 0.03332f
C2103 VPWR.n686 VGND 0.01462f
C2104 VPWR.t2177 VGND 0.03652f
C2105 VPWR.n687 VGND 0.04085f
C2106 VPWR.t2406 VGND 0.04169f
C2107 VPWR.n689 VGND 0.04075f
C2108 VPWR.t1959 VGND 0.03577f
C2109 VPWR.n691 VGND 0.03367f
C2110 VPWR.t1272 VGND 0.04169f
C2111 VPWR.n693 VGND 0.04075f
C2112 VPWR.n694 VGND 0.01091f
C2113 VPWR.t1957 VGND 0.39139f
C2114 VPWR.n695 VGND 0.03378f
C2115 VPWR.n696 VGND 0.01112f
C2116 VPWR.t1270 VGND 0.0399f
C2117 VPWR.n697 VGND 0.03332f
C2118 VPWR.t1956 VGND 0.03655f
C2119 VPWR.n699 VGND 0.04108f
C2120 VPWR.n700 VGND 0.01099f
C2121 VPWR.t1268 VGND 0.0399f
C2122 VPWR.n701 VGND 0.03332f
C2123 VPWR.t1012 VGND 0.03704f
C2124 VPWR.t1266 VGND 0.0399f
C2125 VPWR.t1011 VGND 0.03652f
C2126 VPWR.n703 VGND 0.04847f
C2127 VPWR.t1264 VGND 0.0399f
C2128 VPWR.t335 VGND 0.03275f
C2129 VPWR.t1262 VGND 0.0399f
C2130 VPWR.t1260 VGND 2.55479f
C2131 VPWR.t333 VGND 0.12899f
C2132 VPWR.t332 VGND 0.12658f
C2133 VPWR.t1258 VGND 0.0399f
C2134 VPWR.n705 VGND 0.041f
C2135 VPWR.n706 VGND 0.04553f
C2136 VPWR.n707 VGND 0.01062f
C2137 VPWR.t1257 VGND 0.03652f
C2138 VPWR.n708 VGND 0.04797f
C2139 VPWR.t2010 VGND 0.27092f
C2140 VPWR.n710 VGND 0.03956f
C2141 VPWR.n711 VGND 0.02146f
C2142 VPWR.t1834 VGND 0.04169f
C2143 VPWR.t1102 VGND 0.04169f
C2144 VPWR.n712 VGND 0.09345f
C2145 VPWR.n713 VGND 0.01774f
C2146 VPWR.t1832 VGND 0.0399f
C2147 VPWR.t1100 VGND 0.0399f
C2148 VPWR.n714 VGND 0.07197f
C2149 VPWR.n715 VGND 0.01585f
C2150 VPWR.t1830 VGND 0.0399f
C2151 VPWR.t1098 VGND 0.0399f
C2152 VPWR.n716 VGND 0.07206f
C2153 VPWR.n717 VGND 0.01552f
C2154 VPWR.t1828 VGND 0.0399f
C2155 VPWR.t1096 VGND 0.0399f
C2156 VPWR.n718 VGND 0.07932f
C2157 VPWR.t1826 VGND 0.0399f
C2158 VPWR.t1094 VGND 2.50586f
C2159 VPWR.n720 VGND 0.07946f
C2160 VPWR.n721 VGND 0.01544f
C2161 VPWR.t1824 VGND 0.0399f
C2162 VPWR.t1092 VGND 0.0399f
C2163 VPWR.n722 VGND 0.07214f
C2164 VPWR.n723 VGND 0.01584f
C2165 VPWR.t1822 VGND 0.0399f
C2166 VPWR.t1090 VGND 1.2973f
C2167 VPWR.n724 VGND 0.07177f
C2168 VPWR.n725 VGND 0.01606f
C2169 VPWR.t1820 VGND 0.0399f
C2170 VPWR.t1088 VGND 0.0399f
C2171 VPWR.n726 VGND 0.0716f
C2172 VPWR.n727 VGND 0.01613f
C2173 VPWR.t1819 VGND 0.03652f
C2174 VPWR.t1071 VGND 0.03652f
C2175 VPWR.n728 VGND 0.09985f
C2176 VPWR.n729 VGND 0.02072f
C2177 VPWR.t446 VGND 0.03275f
C2178 VPWR.t306 VGND 0.03275f
C2179 VPWR.n730 VGND 0.10246f
C2180 VPWR.n731 VGND 0.011f
C2181 VPWR.n732 VGND 0.69968f
C2182 VPWR.t423 VGND 0.03275f
C2183 VPWR.t176 VGND 0.26972f
C2184 VPWR.t1656 VGND 0.06229f
C2185 VPWR.t1654 VGND 0.05344f
C2186 VPWR.t1644 VGND 0.13539f
C2187 VPWR.t182 VGND 2.09214f
C2188 VPWR.t1641 VGND 0.03669f
C2189 VPWR.t181 VGND 2.08854f
C2190 VPWR.t479 VGND 0.04169f
C2191 VPWR.t473 VGND 0.0399f
C2192 VPWR.t435 VGND 0.03276f
C2193 VPWR.t519 VGND 0.02704f
C2194 VPWR.t284 VGND 2.0152f
C2195 VPWR.t286 VGND 0.03275f
C2196 VPWR.t686 VGND 0.03601f
C2197 VPWR.n735 VGND 0.04181f
C2198 VPWR.n736 VGND 0.04601f
C2199 VPWR.t1708 VGND 0.03652f
C2200 VPWR.n737 VGND 0.04822f
C2201 VPWR.t1709 VGND 0.0399f
C2202 VPWR.n739 VGND 0.03922f
C2203 VPWR.t148 VGND 0.03276f
C2204 VPWR.t149 VGND 1.40861f
C2205 VPWR.t1711 VGND 0.04f
C2206 VPWR.t151 VGND 1.40619f
C2207 VPWR.t1713 VGND 0.0399f
C2208 VPWR.t1715 VGND 0.0399f
C2209 VPWR.t448 VGND 0.03652f
C2210 VPWR.n740 VGND 0.05019f
C2211 VPWR.n741 VGND 0.03826f
C2212 VPWR.t465 VGND 0.0399f
C2213 VPWR.t467 VGND 0.0399f
C2214 VPWR.n743 VGND 0.03969f
C2215 VPWR.t1717 VGND 0.0399f
C2216 VPWR.t1719 VGND 0.0399f
C2217 VPWR.n744 VGND 0.03332f
C2218 VPWR.n745 VGND 0.01588f
C2219 VPWR.t469 VGND 0.0399f
C2220 VPWR.n746 VGND 0.04183f
C2221 VPWR.t1723 VGND 0.06229f
C2222 VPWR.t1721 VGND 0.05344f
C2223 VPWR.t471 VGND 0.0399f
C2224 VPWR.n747 VGND 0.04499f
C2225 VPWR.n748 VGND 0.03754f
C2226 VPWR.t434 VGND 0.24065f
C2227 VPWR.t475 VGND 0.0399f
C2228 VPWR.t437 VGND 0.23823f
C2229 VPWR.t477 VGND 0.0399f
C2230 VPWR.t184 VGND 0.03394f
C2231 VPWR.t1642 VGND 0.0399f
C2232 VPWR.t573 VGND 0.03652f
C2233 VPWR.t1646 VGND 0.0399f
C2234 VPWR.t1648 VGND 0.0399f
C2235 VPWR.t574 VGND 0.0399f
C2236 VPWR.t576 VGND 0.0399f
C2237 VPWR.t1650 VGND 0.0399f
C2238 VPWR.t578 VGND 0.0399f
C2239 VPWR.t1652 VGND 0.0399f
C2240 VPWR.t580 VGND 0.0399f
C2241 VPWR.t1773 VGND 0.03655f
C2242 VPWR.t582 VGND 0.0399f
C2243 VPWR.t1774 VGND 0.03992f
C2244 VPWR.t584 VGND 0.0399f
C2245 VPWR.t1776 VGND 0.03577f
C2246 VPWR.t586 VGND 0.0399f
C2247 VPWR.t386 VGND 0.03276f
C2248 VPWR.t588 VGND 0.04169f
C2249 VPWR.n750 VGND 0.69968f
C2250 VPWR.t234 VGND 0.03276f
C2251 VPWR.t227 VGND 0.03275f
C2252 VPWR.t572 VGND 0.04169f
C2253 VPWR.t620 VGND 0.03652f
C2254 VPWR.n751 VGND 0.08653f
C2255 VPWR.t570 VGND 0.0399f
C2256 VPWR.t618 VGND 0.0399f
C2257 VPWR.t568 VGND 0.0399f
C2258 VPWR.t616 VGND 0.0399f
C2259 VPWR.t566 VGND 0.0399f
C2260 VPWR.t614 VGND 0.0399f
C2261 VPWR.t612 VGND 2.6962f
C2262 VPWR.t596 VGND 0.0399f
C2263 VPWR.t460 VGND 0.0399f
C2264 VPWR.t592 VGND 0.0399f
C2265 VPWR.n753 VGND 0.04793f
C2266 VPWR.n754 VGND 0.03877f
C2267 VPWR.t458 VGND 0.0399f
C2268 VPWR.t590 VGND 0.0399f
C2269 VPWR.n756 VGND 0.04015f
C2270 VPWR.n757 VGND 0.03831f
C2271 VPWR.t589 VGND 0.03652f
C2272 VPWR.t143 VGND 0.97604f
C2273 VPWR.t449 VGND 0.03652f
C2274 VPWR.t450 VGND 0.0399f
C2275 VPWR.t145 VGND 0.97363f
C2276 VPWR.t452 VGND 0.0399f
C2277 VPWR.n759 VGND 0.04286f
C2278 VPWR.t147 VGND 0.2562f
C2279 VPWR.t146 VGND 0.25492f
C2280 VPWR.n760 VGND 0.08081f
C2281 VPWR.n761 VGND 0.04208f
C2282 VPWR.n762 VGND 0.01323f
C2283 VPWR.t454 VGND 0.0399f
C2284 VPWR.n763 VGND 0.04825f
C2285 VPWR.t456 VGND 0.0399f
C2286 VPWR.t464 VGND 0.06229f
C2287 VPWR.t462 VGND 0.05344f
C2288 VPWR.t594 VGND 0.0399f
C2289 VPWR.t598 VGND 0.0399f
C2290 VPWR.t171 VGND 0.12658f
C2291 VPWR.t172 VGND 0.12899f
C2292 VPWR.t600 VGND 0.04f
C2293 VPWR.t174 VGND 0.03275f
C2294 VPWR.t602 VGND 0.0399f
C2295 VPWR.t604 VGND 0.04169f
C2296 VPWR.n764 VGND 0.06156f
C2297 VPWR.n765 VGND 0.0133f
C2298 VPWR.t557 VGND 0.03652f
C2299 VPWR.t605 VGND 0.04169f
C2300 VPWR.n766 VGND 0.08653f
C2301 VPWR.t606 VGND 0.0399f
C2302 VPWR.t558 VGND 0.0399f
C2303 VPWR.t608 VGND 0.0399f
C2304 VPWR.t560 VGND 0.0399f
C2305 VPWR.t610 VGND 0.0399f
C2306 VPWR.t562 VGND 0.0399f
C2307 VPWR.t564 VGND 0.0399f
C2308 VPWR.t228 VGND 0.03147f
C2309 VPWR.t235 VGND 0.22281f
C2310 VPWR.t237 VGND 0.2204f
C2311 VPWR.t968 VGND 0.67536f
C2312 VPWR.n767 VGND 0.05343f
C2313 VPWR.n768 VGND 0.04469f
C2314 VPWR.t621 VGND 1.00116f
C2315 VPWR.n771 VGND 0.03953f
C2316 VPWR.t864 VGND 0.03652f
C2317 VPWR.t555 VGND 1.09372f
C2318 VPWR.t865 VGND 0.35647f
C2319 VPWR.t257 VGND 0.31422f
C2320 VPWR.t380 VGND 0.11401f
C2321 VPWR.t249 VGND 0.4095f
C2322 VPWR.n773 VGND 0.13783f
C2323 VPWR.t381 VGND 1.03105f
C2324 VPWR.t250 VGND 0.12562f
C2325 VPWR.t383 VGND 0.94739f
C2326 VPWR.t251 VGND 0.03275f
C2327 VPWR.t384 VGND 0.03276f
C2328 VPWR.n774 VGND 0.04921f
C2329 VPWR.n775 VGND 0.01283f
C2330 VPWR.t252 VGND 0.03147f
C2331 VPWR.n776 VGND 0.08081f
C2332 VPWR.n777 VGND 0.04936f
C2333 VPWR.t117 VGND 0.12899f
C2334 VPWR.n779 VGND 0.13783f
C2335 VPWR.n780 VGND 0.06101f
C2336 VPWR.n781 VGND 0.01405f
C2337 VPWR.t1136 VGND 0.03652f
C2338 VPWR.t118 VGND 0.12658f
C2339 VPWR.t1137 VGND 0.0399f
C2340 VPWR.t119 VGND 0.03275f
C2341 VPWR.t1139 VGND 0.0399f
C2342 VPWR.n782 VGND 0.04431f
C2343 VPWR.t120 VGND 0.03147f
C2344 VPWR.n784 VGND 0.08081f
C2345 VPWR.n785 VGND 0.04209f
C2346 VPWR.n786 VGND 0.01323f
C2347 VPWR.t1141 VGND 0.0399f
C2348 VPWR.n787 VGND 0.04183f
C2349 VPWR.t1143 VGND 0.0399f
C2350 VPWR.t1519 VGND 0.03652f
C2351 VPWR.n789 VGND 0.04771f
C2352 VPWR.n790 VGND 0.03826f
C2353 VPWR.t1520 VGND 0.0399f
C2354 VPWR.t1145 VGND 0.0399f
C2355 VPWR.t1522 VGND 0.0399f
C2356 VPWR.n791 VGND 0.03969f
C2357 VPWR.t1147 VGND 2.79814f
C2358 VPWR.n793 VGND 0.03332f
C2359 VPWR.n794 VGND 0.01588f
C2360 VPWR.t1524 VGND 0.0399f
C2361 VPWR.n795 VGND 0.04183f
C2362 VPWR.t1526 VGND 0.0399f
C2363 VPWR.t1152 VGND 0.06229f
C2364 VPWR.t1149 VGND 0.05344f
C2365 VPWR.n797 VGND 0.03754f
C2366 VPWR.n798 VGND 0.04504f
C2367 VPWR.t985 VGND 0.03652f
C2368 VPWR.t1528 VGND 0.0399f
C2369 VPWR.n800 VGND 0.04376f
C2370 VPWR.n801 VGND 0.04726f
C2371 VPWR.n802 VGND 0.01125f
C2372 VPWR.t986 VGND 0.0399f
C2373 VPWR.t1530 VGND 0.0399f
C2374 VPWR.n803 VGND 0.03755f
C2375 VPWR.n804 VGND 0.03893f
C2376 VPWR.n805 VGND 0.01606f
C2377 VPWR.t988 VGND 0.0399f
C2378 VPWR.n806 VGND 0.04027f
C2379 VPWR.t1534 VGND 0.06229f
C2380 VPWR.t1532 VGND 0.05344f
C2381 VPWR.n808 VGND 0.03054f
C2382 VPWR.n809 VGND 0.01354f
C2383 VPWR.t990 VGND 0.0399f
C2384 VPWR.n810 VGND 0.04183f
C2385 VPWR.t992 VGND 0.0399f
C2386 VPWR.t1602 VGND 0.03652f
C2387 VPWR.n812 VGND 0.04771f
C2388 VPWR.n813 VGND 0.03826f
C2389 VPWR.t1603 VGND 0.0399f
C2390 VPWR.t994 VGND 0.0399f
C2391 VPWR.t1605 VGND 0.0399f
C2392 VPWR.n814 VGND 0.03969f
C2393 VPWR.t996 VGND 0.0399f
C2394 VPWR.n816 VGND 0.03332f
C2395 VPWR.n817 VGND 0.01588f
C2396 VPWR.t1607 VGND 0.0399f
C2397 VPWR.n818 VGND 0.04183f
C2398 VPWR.t1609 VGND 0.0399f
C2399 VPWR.t1000 VGND 0.06229f
C2400 VPWR.t998 VGND 0.05344f
C2401 VPWR.n820 VGND 0.03754f
C2402 VPWR.n821 VGND 0.04499f
C2403 VPWR.t787 VGND 0.03652f
C2404 VPWR.t1611 VGND 0.0399f
C2405 VPWR.n823 VGND 0.04379f
C2406 VPWR.n824 VGND 0.04726f
C2407 VPWR.n825 VGND 0.01125f
C2408 VPWR.t788 VGND 0.0399f
C2409 VPWR.t1613 VGND 0.0399f
C2410 VPWR.n826 VGND 0.03755f
C2411 VPWR.n827 VGND 0.03893f
C2412 VPWR.n828 VGND 0.01606f
C2413 VPWR.t790 VGND 0.0399f
C2414 VPWR.n829 VGND 0.04027f
C2415 VPWR.t1617 VGND 0.08088f
C2416 VPWR.t1615 VGND 2.04404f
C2417 VPWR.n831 VGND 0.03054f
C2418 VPWR.n832 VGND 0.01354f
C2419 VPWR.t792 VGND 0.0399f
C2420 VPWR.n833 VGND 0.04183f
C2421 VPWR.t794 VGND 0.0399f
C2422 VPWR.t318 VGND 0.12658f
C2423 VPWR.n835 VGND 0.0492f
C2424 VPWR.n836 VGND 0.04158f
C2425 VPWR.t319 VGND 0.12899f
C2426 VPWR.n838 VGND 0.1481f
C2427 VPWR.t796 VGND 0.04f
C2428 VPWR.n839 VGND 0.11226f
C2429 VPWR.t321 VGND 0.03275f
C2430 VPWR.t798 VGND 0.0399f
C2431 VPWR.n841 VGND 0.04081f
C2432 VPWR.n842 VGND 0.04805f
C2433 VPWR.t322 VGND 0.0779f
C2434 VPWR.n845 VGND 0.08877f
C2435 VPWR.t802 VGND 0.08916f
C2436 VPWR.t800 VGND 4.03062f
C2437 VPWR.t323 VGND 0.07918f
C2438 VPWR.n846 VGND 0.05018f
C2439 VPWR.n847 VGND 0.02971f
C2440 VPWR.n848 VGND 0.02823f
C2441 VPWR.n849 VGND 0.06105f
C2442 VPWR.t969 VGND 0.04169f
C2443 VPWR.t867 VGND 0.03652f
C2444 VPWR.n851 VGND 0.08458f
C2445 VPWR.t970 VGND 0.0399f
C2446 VPWR.t868 VGND 0.0399f
C2447 VPWR.t972 VGND 0.0399f
C2448 VPWR.t870 VGND 0.0399f
C2449 VPWR.t974 VGND 0.0399f
C2450 VPWR.t872 VGND 0.0399f
C2451 VPWR.t874 VGND 0.0399f
C2452 VPWR.t976 VGND 0.0399f
C2453 VPWR.t978 VGND 0.0399f
C2454 VPWR.t876 VGND 0.86793f
C2455 VPWR.t980 VGND 0.06678f
C2456 VPWR.t878 VGND 0.0399f
C2457 VPWR.t982 VGND 0.0399f
C2458 VPWR.t880 VGND 0.0399f
C2459 VPWR.n852 VGND 0.01631f
C2460 VPWR.t984 VGND 0.03652f
C2461 VPWR.t882 VGND 0.04169f
C2462 VPWR.n853 VGND 0.08653f
C2463 VPWR.t179 VGND 1.56875f
C2464 VPWR.t414 VGND 0.03276f
C2465 VPWR.n855 VGND 0.0892f
C2466 VPWR.n856 VGND 0.01076f
C2467 VPWR.t180 VGND 1.61759f
C2468 VPWR.n857 VGND 0.1481f
C2469 VPWR.t415 VGND 0.03517f
C2470 VPWR.n858 VGND 0.14813f
C2471 VPWR.n859 VGND 0.12006f
C2472 VPWR.n860 VGND 0.01219f
C2473 VPWR.t302 VGND 0.07919f
C2474 VPWR.t417 VGND 0.03275f
C2475 VPWR.t303 VGND 0.07966f
C2476 VPWR.t418 VGND 0.03275f
C2477 VPWR.t379 VGND 0.07209f
C2478 VPWR.n861 VGND 0.08877f
C2479 VPWR.n862 VGND 0.06844f
C2480 VPWR.t378 VGND 0.07337f
C2481 VPWR.n863 VGND 0.0513f
C2482 VPWR.n864 VGND 0.01629f
C2483 VPWR.t163 VGND 0.03147f
C2484 VPWR.t142 VGND 0.03298f
C2485 VPWR.t161 VGND 0.33063f
C2486 VPWR.t2404 VGND 0.07966f
C2487 VPWR.n867 VGND 0.08916f
C2488 VPWR.n868 VGND 0.011f
C2489 VPWR.t1042 VGND 0.0399f
C2490 VPWR.t660 VGND 0.0399f
C2491 VPWR.t1040 VGND 0.0399f
C2492 VPWR.t658 VGND 0.0399f
C2493 VPWR.t656 VGND 0.0399f
C2494 VPWR.t3 VGND 0.31127f
C2495 VPWR.n870 VGND 0.02106f
C2496 VPWR.n871 VGND 0.01774f
C2497 VPWR.t1217 VGND 0.0399f
C2498 VPWR.t1116 VGND 0.0399f
C2499 VPWR.n872 VGND 0.07197f
C2500 VPWR.n873 VGND 0.01585f
C2501 VPWR.t1215 VGND 0.0399f
C2502 VPWR.t1114 VGND 0.0399f
C2503 VPWR.n874 VGND 0.07206f
C2504 VPWR.n875 VGND 0.01552f
C2505 VPWR.t1213 VGND 0.0399f
C2506 VPWR.t1112 VGND 0.0399f
C2507 VPWR.n876 VGND 0.07936f
C2508 VPWR.t1188 VGND 0.03652f
C2509 VPWR.t1103 VGND 0.03652f
C2510 VPWR.n878 VGND 0.09298f
C2511 VPWR.n879 VGND 0.0122f
C2512 VPWR.t1205 VGND 0.0399f
C2513 VPWR.t1104 VGND 0.0399f
C2514 VPWR.n880 VGND 0.07559f
C2515 VPWR.n881 VGND 0.01606f
C2516 VPWR.t1207 VGND 0.0399f
C2517 VPWR.t1106 VGND 0.0399f
C2518 VPWR.n882 VGND 0.07177f
C2519 VPWR.n883 VGND 0.01584f
C2520 VPWR.t1209 VGND 0.0399f
C2521 VPWR.t1108 VGND 0.0399f
C2522 VPWR.n884 VGND 0.07214f
C2523 VPWR.t1211 VGND 0.0399f
C2524 VPWR.t1110 VGND 0.0399f
C2525 VPWR.n885 VGND 0.07942f
C2526 VPWR.n886 VGND 0.01544f
C2527 VPWR.t1219 VGND 0.04169f
C2528 VPWR.t1118 VGND 0.04169f
C2529 VPWR.n887 VGND 0.09345f
C2530 VPWR.t196 VGND 0.09613f
C2531 VPWR.n888 VGND 0.01091f
C2532 VPWR.t401 VGND 0.03276f
C2533 VPWR.n892 VGND 0.01323f
C2534 VPWR.t197 VGND 0.09854f
C2535 VPWR.t2336 VGND 0.04169f
C2536 VPWR.t1204 VGND 0.04169f
C2537 VPWR.n894 VGND 0.08665f
C2538 VPWR.n895 VGND 0.01774f
C2539 VPWR.t2334 VGND 0.0399f
C2540 VPWR.t1202 VGND 0.0399f
C2541 VPWR.n896 VGND 0.07197f
C2542 VPWR.n897 VGND 0.01585f
C2543 VPWR.t2332 VGND 0.0399f
C2544 VPWR.t1200 VGND 0.0399f
C2545 VPWR.n898 VGND 0.07206f
C2546 VPWR.n899 VGND 0.01552f
C2547 VPWR.t2330 VGND 0.0399f
C2548 VPWR.t1198 VGND 0.0399f
C2549 VPWR.n900 VGND 0.07936f
C2550 VPWR.t2321 VGND 0.03652f
C2551 VPWR.t1189 VGND 0.03652f
C2552 VPWR.n902 VGND 0.09298f
C2553 VPWR.n903 VGND 0.0122f
C2554 VPWR.t2322 VGND 1.98703f
C2555 VPWR.t1190 VGND 0.0399f
C2556 VPWR.n904 VGND 0.07559f
C2557 VPWR.n905 VGND 0.01606f
C2558 VPWR.t2324 VGND 0.0399f
C2559 VPWR.t1192 VGND 0.0399f
C2560 VPWR.n906 VGND 0.07177f
C2561 VPWR.n907 VGND 0.01584f
C2562 VPWR.t2326 VGND 2.52975f
C2563 VPWR.t1194 VGND 0.0399f
C2564 VPWR.n908 VGND 0.07214f
C2565 VPWR.t2328 VGND 0.0399f
C2566 VPWR.t1196 VGND 0.0399f
C2567 VPWR.n909 VGND 0.07942f
C2568 VPWR.n910 VGND 0.01544f
C2569 VPWR.t846 VGND 0.24006f
C2570 VPWR.t199 VGND 0.03275f
C2571 VPWR.n911 VGND 0.05919f
C2572 VPWR.t200 VGND 0.07918f
C2573 VPWR.n913 VGND 0.05789f
C2574 VPWR.n914 VGND 0.01937f
C2575 VPWR.t201 VGND 0.0779f
C2576 VPWR.n915 VGND 0.08081f
C2577 VPWR.n916 VGND 0.05678f
C2578 VPWR.n917 VGND 0.01576f
C2579 VPWR.t2338 VGND 0.05344f
C2580 VPWR.t2337 VGND 0.06229f
C2581 VPWR.n918 VGND 0.04526f
C2582 VPWR.t1015 VGND 0.03652f
C2583 VPWR.n919 VGND 0.04822f
C2584 VPWR.n920 VGND 0.01321f
C2585 VPWR.t1016 VGND 0.0399f
C2586 VPWR.n921 VGND 0.04023f
C2587 VPWR.t2340 VGND 0.0399f
C2588 VPWR.n922 VGND 0.03332f
C2589 VPWR.t2342 VGND 0.0399f
C2590 VPWR.t1018 VGND 0.0399f
C2591 VPWR.n924 VGND 0.04127f
C2592 VPWR.t1020 VGND 0.0399f
C2593 VPWR.t2344 VGND 0.0399f
C2594 VPWR.n926 VGND 0.04091f
C2595 VPWR.n927 VGND 0.04132f
C2596 VPWR.t1022 VGND 0.0399f
C2597 VPWR.t2346 VGND 0.0399f
C2598 VPWR.n929 VGND 0.04132f
C2599 VPWR.n930 VGND 0.04091f
C2600 VPWR.t2348 VGND 0.0399f
C2601 VPWR.n931 VGND 0.04127f
C2602 VPWR.t2350 VGND 0.0399f
C2603 VPWR.n933 VGND 0.04023f
C2604 VPWR.t1024 VGND 0.0399f
C2605 VPWR.t1026 VGND 0.0399f
C2606 VPWR.n934 VGND 0.03332f
C2607 VPWR.n935 VGND 0.01323f
C2608 VPWR.t2352 VGND 0.03652f
C2609 VPWR.n936 VGND 0.04822f
C2610 VPWR.t1030 VGND 0.06229f
C2611 VPWR.t1028 VGND 0.05344f
C2612 VPWR.t1170 VGND 0.03275f
C2613 VPWR.n938 VGND 0.0458f
C2614 VPWR.n939 VGND 0.04603f
C2615 VPWR.t1171 VGND 0.03147f
C2616 VPWR.t2355 VGND 0.03669f
C2617 VPWR.t154 VGND 0.52408f
C2618 VPWR.n940 VGND 0.14813f
C2619 VPWR.n941 VGND 0.12501f
C2620 VPWR.t155 VGND 0.52167f
C2621 VPWR.t2356 VGND 0.0399f
C2622 VPWR.n943 VGND 0.04077f
C2623 VPWR.n944 VGND 0.04438f
C2624 VPWR.n945 VGND 0.01133f
C2625 VPWR.t2358 VGND 0.0399f
C2626 VPWR.n946 VGND 0.04822f
C2627 VPWR.n947 VGND 0.01119f
C2628 VPWR.t2360 VGND 0.0399f
C2629 VPWR.t836 VGND 0.03577f
C2630 VPWR.n948 VGND 0.03948f
C2631 VPWR.n949 VGND 0.03766f
C2632 VPWR.n950 VGND 0.01094f
C2633 VPWR.t2362 VGND 0.0399f
C2634 VPWR.t837 VGND 0.03992f
C2635 VPWR.n951 VGND 0.04039f
C2636 VPWR.n952 VGND 0.03725f
C2637 VPWR.t839 VGND 0.03655f
C2638 VPWR.n953 VGND 0.01037f
C2639 VPWR.t1463 VGND 0.03652f
C2640 VPWR.n954 VGND 0.04846f
C2641 VPWR.t2364 VGND 0.0399f
C2642 VPWR.t1464 VGND 0.0399f
C2643 VPWR.n955 VGND 0.03332f
C2644 VPWR.t2366 VGND 0.0399f
C2645 VPWR.n956 VGND 0.03332f
C2646 VPWR.n957 VGND 0.01099f
C2647 VPWR.t1466 VGND 0.0399f
C2648 VPWR.n958 VGND 0.03343f
C2649 VPWR.t2368 VGND 0.0399f
C2650 VPWR.n959 VGND 0.03332f
C2651 VPWR.n960 VGND 0.01112f
C2652 VPWR.t1468 VGND 0.04067f
C2653 VPWR.n961 VGND 0.04529f
C2654 VPWR.t2370 VGND 0.04169f
C2655 VPWR.n962 VGND 0.04075f
C2656 VPWR.t1470 VGND 0.03652f
C2657 VPWR.t79 VGND 0.2204f
C2658 VPWR.t80 VGND 0.22281f
C2659 VPWR.t82 VGND 0.03275f
C2660 VPWR.t2287 VGND 0.03652f
C2661 VPWR.n964 VGND 0.04883f
C2662 VPWR.n965 VGND 0.04787f
C2663 VPWR.t83 VGND 0.03275f
C2664 VPWR.t2304 VGND 0.0399f
C2665 VPWR.n966 VGND 0.01313f
C2666 VPWR.t2100 VGND 0.0399f
C2667 VPWR.t2132 VGND 0.0399f
C2668 VPWR.t2098 VGND 0.0399f
C2669 VPWR.t2130 VGND 0.0399f
C2670 VPWR.t2096 VGND 0.0399f
C2671 VPWR.t2128 VGND 0.0399f
C2672 VPWR.n967 VGND 0.01631f
C2673 VPWR.t2095 VGND 0.03652f
C2674 VPWR.t2111 VGND 0.04169f
C2675 VPWR.n968 VGND 0.08653f
C2676 VPWR.t170 VGND 0.03275f
C2677 VPWR.t2318 VGND 0.06229f
C2678 VPWR.t2316 VGND 0.05344f
C2679 VPWR.t84 VGND 0.03147f
C2680 VPWR.t2306 VGND 0.04002f
C2681 VPWR.t2268 VGND 0.03652f
C2682 VPWR.t2308 VGND 0.0399f
C2683 VPWR.t2310 VGND 0.0399f
C2684 VPWR.t2269 VGND 0.0399f
C2685 VPWR.t2271 VGND 0.0399f
C2686 VPWR.t2312 VGND 0.0399f
C2687 VPWR.n971 VGND 0.03953f
C2688 VPWR.n972 VGND 0.04056f
C2689 VPWR.t2273 VGND 0.0399f
C2690 VPWR.t2314 VGND 0.0399f
C2691 VPWR.n974 VGND 0.03999f
C2692 VPWR.n975 VGND 0.04631f
C2693 VPWR.t2275 VGND 0.0399f
C2694 VPWR.t168 VGND 0.12658f
C2695 VPWR.t2277 VGND 0.0399f
C2696 VPWR.t2279 VGND 0.0399f
C2697 VPWR.t169 VGND 0.12899f
C2698 VPWR.t2283 VGND 0.22617f
C2699 VPWR.t2281 VGND 0.0445f
C2700 VPWR.t2102 VGND 0.06021f
C2701 VPWR.t2134 VGND 0.0399f
C2702 VPWR.t2136 VGND 0.0399f
C2703 VPWR.t2104 VGND 0.05987f
C2704 VPWR.t2138 VGND 0.0399f
C2705 VPWR.t2106 VGND 0.0399f
C2706 VPWR.t2140 VGND 0.0399f
C2707 VPWR.t2108 VGND 0.71169f
C2708 VPWR.n976 VGND 0.01631f
C2709 VPWR.t2110 VGND 0.04169f
C2710 VPWR.t2142 VGND 0.03652f
C2711 VPWR.n977 VGND 0.08653f
C2712 VPWR.t193 VGND 0.03276f
C2713 VPWR.t223 VGND 0.12658f
C2714 VPWR.n978 VGND 0.08102f
C2715 VPWR.t803 VGND 0.03652f
C2716 VPWR.t819 VGND 0.03652f
C2717 VPWR.t804 VGND 0.0399f
C2718 VPWR.t820 VGND 2.40274f
C2719 VPWR.t806 VGND 0.0399f
C2720 VPWR.t822 VGND 0.0399f
C2721 VPWR.t808 VGND 0.0399f
C2722 VPWR.t824 VGND 0.0399f
C2723 VPWR.t810 VGND 0.0399f
C2724 VPWR.t826 VGND 0.0399f
C2725 VPWR.t812 VGND 0.0399f
C2726 VPWR.t828 VGND 0.0399f
C2727 VPWR.t814 VGND 0.0399f
C2728 VPWR.t830 VGND 0.0399f
C2729 VPWR.t816 VGND 0.0399f
C2730 VPWR.t832 VGND 0.0399f
C2731 VPWR.t818 VGND 0.04169f
C2732 VPWR.t834 VGND 0.04169f
C2733 VPWR.t208 VGND 1.88452f
C2734 VPWR.t2371 VGND 0.03652f
C2735 VPWR.t2388 VGND 0.04002f
C2736 VPWR.t137 VGND 0.03322f
C2737 VPWR.n980 VGND 0.05875f
C2738 VPWR.t2398 VGND 0.0399f
C2739 VPWR.t2258 VGND 0.0399f
C2740 VPWR.t2396 VGND 0.0399f
C2741 VPWR.t2256 VGND 0.0399f
C2742 VPWR.t2254 VGND 0.0399f
C2743 VPWR.t2390 VGND 0.0399f
C2744 VPWR.n981 VGND 0.03943f
C2745 VPWR.t2392 VGND 0.0399f
C2746 VPWR.t2251 VGND 0.03652f
C2747 VPWR.t2394 VGND 0.0399f
C2748 VPWR.t2252 VGND 0.0399f
C2749 VPWR.t2260 VGND 0.0399f
C2750 VPWR.t2400 VGND 0.0399f
C2751 VPWR.t2262 VGND 0.0399f
C2752 VPWR.n983 VGND 0.03332f
C2753 VPWR.t2402 VGND 0.04169f
C2754 VPWR.n984 VGND 0.05394f
C2755 VPWR.t2264 VGND 0.0399f
C2756 VPWR.n986 VGND 0.03984f
C2757 VPWR.t103 VGND 0.12563f
C2758 VPWR.t104 VGND 0.22186f
C2759 VPWR.t2266 VGND 0.05801f
C2760 VPWR.t106 VGND 0.12657f
C2761 VPWR.t408 VGND 0.03276f
C2762 VPWR.n987 VGND 0.04845f
C2763 VPWR.t107 VGND 0.03596f
C2764 VPWR.n988 VGND 0.0513f
C2765 VPWR.t108 VGND 0.03468f
C2766 VPWR.n990 VGND 0.08081f
C2767 VPWR.n991 VGND 0.05591f
C2768 VPWR.t136 VGND 0.03517f
C2769 VPWR.t209 VGND 1.88324f
C2770 VPWR.n992 VGND 0.08879f
C2771 VPWR.n993 VGND 0.09185f
C2772 VPWR.n994 VGND 0.01242f
C2773 VPWR.n995 VGND 0.04023f
C2774 VPWR.n996 VGND 0.0459f
C2775 VPWR.n998 VGND 0.08665f
C2776 VPWR.n999 VGND 0.01774f
C2777 VPWR.n1000 VGND 0.07197f
C2778 VPWR.n1001 VGND 0.01585f
C2779 VPWR.n1002 VGND 0.07206f
C2780 VPWR.n1003 VGND 0.01552f
C2781 VPWR.n1004 VGND 0.07936f
C2782 VPWR.n1006 VGND 0.07942f
C2783 VPWR.n1007 VGND 0.01544f
C2784 VPWR.n1008 VGND 0.07214f
C2785 VPWR.n1009 VGND 0.01584f
C2786 VPWR.n1010 VGND 0.07177f
C2787 VPWR.n1011 VGND 0.01606f
C2788 VPWR.n1012 VGND 0.0716f
C2789 VPWR.n1013 VGND 0.01613f
C2790 VPWR.n1014 VGND 0.09328f
C2791 VPWR.t347 VGND 0.3011f
C2792 VPWR.n1015 VGND 0.08877f
C2793 VPWR.n1016 VGND 0.07526f
C2794 VPWR.n1017 VGND 0.0112f
C2795 VPWR.t346 VGND 0.30237f
C2796 VPWR.t1223 VGND 0.03577f
C2797 VPWR.n1018 VGND 0.03316f
C2798 VPWR.n1019 VGND 0.04712f
C2799 VPWR.t1221 VGND 0.23341f
C2800 VPWR.t1310 VGND 0.03704f
C2801 VPWR.t1220 VGND 0.03655f
C2802 VPWR.t1309 VGND 0.42351f
C2803 VPWR.t100 VGND 0.12657f
C2804 VPWR.n1020 VGND 0.06845f
C2805 VPWR.n1021 VGND 0.01334f
C2806 VPWR.t847 VGND 0.81048f
C2807 VPWR.t96 VGND 0.32971f
C2808 VPWR.t95 VGND 0.23349f
C2809 VPWR.t46 VGND 0.03276f
C2810 VPWR.t91 VGND 0.07967f
C2811 VPWR.t90 VGND 0.03275f
C2812 VPWR.t1914 VGND 0.0399f
C2813 VPWR.t1910 VGND 0.76354f
C2814 VPWR.n1022 VGND 0.05681f
C2815 VPWR.n1023 VGND 0.01133f
C2816 VPWR.t1908 VGND 0.0399f
C2817 VPWR.t345 VGND 1.90224f
C2818 VPWR.n1024 VGND 0.04438f
C2819 VPWR.n1025 VGND 0.03959f
C2820 VPWR.n1026 VGND 0.01613f
C2821 VPWR.t343 VGND 1.90465f
C2822 VPWR.n1027 VGND 0.13783f
C2823 VPWR.t1907 VGND 0.03652f
C2824 VPWR.n1028 VGND 0.04787f
C2825 VPWR.n1029 VGND 0.0556f
C2826 VPWR.t328 VGND 1.44456f
C2827 VPWR.n1031 VGND 0.08081f
C2828 VPWR.n1032 VGND 0.04936f
C2829 VPWR.n1033 VGND 0.01283f
C2830 VPWR.t338 VGND 0.21367f
C2831 VPWR.n1036 VGND 0.01201f
C2832 VPWR.n1037 VGND 0.01215f
C2833 VPWR.n1038 VGND 0.02073f
C2834 VPWR.t47 VGND 0.03517f
C2835 VPWR.n1039 VGND 0.1481f
C2836 VPWR.t92 VGND 0.08208f
C2837 VPWR.n1040 VGND 0.14813f
C2838 VPWR.n1041 VGND 0.12005f
C2839 VPWR.t49 VGND 0.03275f
C2840 VPWR.t98 VGND 0.03275f
C2841 VPWR.n1042 VGND 0.10241f
C2842 VPWR.n1043 VGND 0.011f
C2843 VPWR.t85 VGND 1.46042f
C2844 VPWR.n1044 VGND 0.13783f
C2845 VPWR.t2197 VGND 0.0399f
C2846 VPWR.n1045 VGND 0.04254f
C2847 VPWR.n1046 VGND 0.06049f
C2848 VPWR.t2195 VGND 0.0399f
C2849 VPWR.n1048 VGND 0.01235f
C2850 VPWR.n1049 VGND 0.01222f
C2851 VPWR.t2231 VGND 0.0399f
C2852 VPWR.n1050 VGND 0.04017f
C2853 VPWR.t2233 VGND 0.0399f
C2854 VPWR.n1051 VGND 0.03332f
C2855 VPWR.t2190 VGND 0.03652f
C2856 VPWR.n1052 VGND 0.04074f
C2857 VPWR.t2235 VGND 0.04169f
C2858 VPWR.n1054 VGND 0.04075f
C2859 VPWR.t2191 VGND 0.0399f
C2860 VPWR.n1055 VGND 0.03343f
C2861 VPWR.t86 VGND 0.16377f
C2862 VPWR.t2193 VGND 0.0399f
C2863 VPWR.t2199 VGND 0.0399f
C2864 VPWR.t87 VGND 1.327f
C2865 VPWR.t2201 VGND 0.0399f
C2866 VPWR.t88 VGND 0.03276f
C2867 VPWR.t2205 VGND 0.05822f
C2868 VPWR.t2203 VGND 0.0445f
C2869 VPWR.t89 VGND 0.03517f
C2870 VPWR.t1870 VGND 0.03652f
C2871 VPWR.n1057 VGND 0.04085f
C2872 VPWR.t2187 VGND 0.04169f
C2873 VPWR.n1058 VGND 0.0617f
C2874 VPWR.t1871 VGND 0.0399f
C2875 VPWR.n1060 VGND 0.03332f
C2876 VPWR.t2206 VGND 0.0399f
C2877 VPWR.n1061 VGND 0.03332f
C2878 VPWR.t1873 VGND 0.0399f
C2879 VPWR.n1063 VGND 0.04061f
C2880 VPWR.t2188 VGND 2.64844f
C2881 VPWR.n1064 VGND 0.03332f
C2882 VPWR.t2209 VGND 0.0399f
C2883 VPWR.t1875 VGND 0.0399f
C2884 VPWR.n1066 VGND 0.04183f
C2885 VPWR.t1877 VGND 0.0399f
C2886 VPWR.t2211 VGND 0.0399f
C2887 VPWR.n1068 VGND 0.04213f
C2888 VPWR.n1069 VGND 0.04213f
C2889 VPWR.t2213 VGND 0.0399f
C2890 VPWR.n1070 VGND 0.04183f
C2891 VPWR.t2215 VGND 0.0399f
C2892 VPWR.n1072 VGND 0.04061f
C2893 VPWR.t1879 VGND 0.0399f
C2894 VPWR.t2189 VGND 0.0399f
C2895 VPWR.n1073 VGND 0.03332f
C2896 VPWR.t1881 VGND 0.0399f
C2897 VPWR.n1074 VGND 0.03332f
C2898 VPWR.n1075 VGND 0.01201f
C2899 VPWR.t2218 VGND 0.03652f
C2900 VPWR.n1076 VGND 0.04644f
C2901 VPWR.t1883 VGND 0.0399f
C2902 VPWR.n1077 VGND 0.03332f
C2903 VPWR.n1078 VGND 0.01215f
C2904 VPWR.t134 VGND 1.35553f
C2905 VPWR.t1885 VGND 0.04169f
C2906 VPWR.t339 VGND 0.40372f
C2907 VPWR.t135 VGND 1.35794f
C2908 VPWR.n1079 VGND 0.13783f
C2909 VPWR.t341 VGND 0.2204f
C2910 VPWR.t326 VGND 0.03275f
C2911 VPWR.t342 VGND 0.03276f
C2912 VPWR.t327 VGND 1.44584f
C2913 VPWR.t2373 VGND 0.05344f
C2914 VPWR.t2372 VGND 0.06229f
C2915 VPWR.t1912 VGND 0.0399f
C2916 VPWR.t1916 VGND 0.0399f
C2917 VPWR.t2375 VGND 0.0399f
C2918 VPWR.t2377 VGND 0.0399f
C2919 VPWR.t1918 VGND 0.05277f
C2920 VPWR.t2379 VGND 0.0399f
C2921 VPWR.n1080 VGND 0.04264f
C2922 VPWR.n1081 VGND 0.0118f
C2923 VPWR.t1922 VGND 0.06229f
C2924 VPWR.t1920 VGND 0.05344f
C2925 VPWR.t2381 VGND 0.0399f
C2926 VPWR.t1307 VGND 0.03704f
C2927 VPWR.t2383 VGND 0.0399f
C2928 VPWR.n1082 VGND 0.04497f
C2929 VPWR.n1083 VGND 0.04514f
C2930 VPWR.n1084 VGND 0.01372f
C2931 VPWR.t1308 VGND 0.03652f
C2932 VPWR.t2385 VGND 0.0399f
C2933 VPWR.n1085 VGND 0.0373f
C2934 VPWR.n1086 VGND 0.0443f
C2935 VPWR.t152 VGND 0.9869f
C2936 VPWR.t2387 VGND 0.03652f
C2937 VPWR.n1087 VGND 0.04614f
C2938 VPWR.n1088 VGND 0.04692f
C2939 VPWR.t102 VGND 0.03147f
C2940 VPWR.n1090 VGND 0.08879f
C2941 VPWR.t153 VGND 0.98562f
C2942 VPWR.n1091 VGND 0.08877f
C2943 VPWR.t101 VGND 0.03297f
C2944 VPWR.n1092 VGND 0.09767f
C2945 VPWR.n1093 VGND 0.06393f
C2946 VPWR.t1986 VGND 0.0399f
C2947 VPWR.t186 VGND 0.12658f
C2948 VPWR.n1096 VGND 0.01229f
C2949 VPWR.n1097 VGND 0.01102f
C2950 VPWR.t2295 VGND 0.0399f
C2951 VPWR.t76 VGND 0.03276f
C2952 VPWR.t2042 VGND 0.03652f
C2953 VPWR.t2040 VGND 0.0399f
C2954 VPWR.t74 VGND 0.11424f
C2955 VPWR.n1099 VGND 0.01104f
C2956 VPWR.n1100 VGND 0.0112f
C2957 VPWR.t1758 VGND 0.0399f
C2958 VPWR.n1101 VGND 0.05479f
C2959 VPWR.n1102 VGND 0.01251f
C2960 VPWR.t311 VGND 0.21124f
C2961 VPWR.t298 VGND 1.08656f
C2962 VPWR.t1754 VGND 0.04169f
C2963 VPWR.t2074 VGND 0.04169f
C2964 VPWR.n1104 VGND 0.08665f
C2965 VPWR.n1105 VGND 0.01774f
C2966 VPWR.t1752 VGND 0.0399f
C2967 VPWR.t2072 VGND 0.18809f
C2968 VPWR.n1106 VGND 0.07197f
C2969 VPWR.n1107 VGND 0.01585f
C2970 VPWR.t1750 VGND 0.0399f
C2971 VPWR.t2070 VGND 0.0399f
C2972 VPWR.n1108 VGND 0.07206f
C2973 VPWR.n1109 VGND 0.01552f
C2974 VPWR.t1748 VGND 0.0399f
C2975 VPWR.t2068 VGND 0.0399f
C2976 VPWR.n1110 VGND 0.07936f
C2977 VPWR.t1739 VGND 0.03652f
C2978 VPWR.t2059 VGND 0.03652f
C2979 VPWR.n1112 VGND 0.09298f
C2980 VPWR.n1113 VGND 0.0122f
C2981 VPWR.t1740 VGND 0.0399f
C2982 VPWR.t2060 VGND 0.0399f
C2983 VPWR.n1114 VGND 0.07559f
C2984 VPWR.n1115 VGND 0.01606f
C2985 VPWR.t1742 VGND 0.0399f
C2986 VPWR.t2062 VGND 0.0399f
C2987 VPWR.n1116 VGND 0.07177f
C2988 VPWR.n1117 VGND 0.01584f
C2989 VPWR.t1744 VGND 0.0399f
C2990 VPWR.t2064 VGND 0.0399f
C2991 VPWR.n1118 VGND 0.07214f
C2992 VPWR.t1746 VGND 0.0399f
C2993 VPWR.t2066 VGND 1.82906f
C2994 VPWR.n1119 VGND 0.07942f
C2995 VPWR.n1120 VGND 0.01544f
C2996 VPWR.t297 VGND 1.08415f
C2997 VPWR.t1640 VGND 0.355f
C2998 VPWR.t308 VGND 0.03275f
C2999 VPWR.n1121 VGND 0.05919f
C3000 VPWR.t309 VGND 0.03276f
C3001 VPWR.n1123 VGND 0.05848f
C3002 VPWR.t310 VGND 0.21365f
C3003 VPWR.t1756 VGND 0.05076f
C3004 VPWR.t1755 VGND 3.77629f
C3005 VPWR.t1760 VGND 0.0399f
C3006 VPWR.t2043 VGND 0.03652f
C3007 VPWR.t2044 VGND 0.0399f
C3008 VPWR.t1762 VGND 0.0399f
C3009 VPWR.n1125 VGND 0.03847f
C3010 VPWR.n1126 VGND 0.04035f
C3011 VPWR.t2046 VGND 2.61718f
C3012 VPWR.t1764 VGND 0.33628f
C3013 VPWR.n1128 VGND 0.03888f
C3014 VPWR.n1129 VGND 0.03954f
C3015 VPWR.t2048 VGND 0.0399f
C3016 VPWR.t1766 VGND 0.0399f
C3017 VPWR.n1131 VGND 0.03954f
C3018 VPWR.n1132 VGND 0.03888f
C3019 VPWR.t2050 VGND 0.0399f
C3020 VPWR.t1768 VGND 0.0399f
C3021 VPWR.n1134 VGND 0.04035f
C3022 VPWR.n1135 VGND 0.04193f
C3023 VPWR.t1770 VGND 0.03652f
C3024 VPWR.t132 VGND 0.13679f
C3025 VPWR.t2052 VGND 0.63267f
C3026 VPWR.t133 VGND 0.13551f
C3027 VPWR.n1136 VGND 0.08081f
C3028 VPWR.n1137 VGND 0.04209f
C3029 VPWR.t2054 VGND 0.0399f
C3030 VPWR.n1138 VGND 0.04124f
C3031 VPWR.n1139 VGND 0.01242f
C3032 VPWR.t2056 VGND 0.05911f
C3033 VPWR.n1140 VGND 0.02728f
C3034 VPWR.t2027 VGND 0.04169f
C3035 VPWR.n1141 VGND 0.0409f
C3036 VPWR.t2028 VGND 0.04602f
C3037 VPWR.n1143 VGND 0.02728f
C3038 VPWR.t2058 VGND 0.04169f
C3039 VPWR.n1144 VGND 0.0409f
C3040 VPWR.t1169 VGND 0.03276f
C3041 VPWR.t2030 VGND 0.0399f
C3042 VPWR.t2032 VGND 0.12139f
C3043 VPWR.t70 VGND 0.12899f
C3044 VPWR.t69 VGND 0.12658f
C3045 VPWR.t71 VGND 0.27552f
C3046 VPWR.t2034 VGND 0.0399f
C3047 VPWR.t2038 VGND 0.04f
C3048 VPWR.t72 VGND 0.35941f
C3049 VPWR.t2036 VGND 0.18884f
C3050 VPWR.t75 VGND 0.62793f
C3051 VPWR.t17 VGND 0.07963f
C3052 VPWR.t18 VGND 0.0779f
C3053 VPWR.t78 VGND 0.62552f
C3054 VPWR.t1291 VGND 0.03652f
C3055 VPWR.t1292 VGND 0.0399f
C3056 VPWR.t2288 VGND 0.03652f
C3057 VPWR.t1294 VGND 2.55619f
C3058 VPWR.t2289 VGND 0.0399f
C3059 VPWR.t1296 VGND 0.0399f
C3060 VPWR.t2291 VGND 0.0399f
C3061 VPWR.t1298 VGND 0.0399f
C3062 VPWR.t2293 VGND 0.0399f
C3063 VPWR.t2297 VGND 1.2672f
C3064 VPWR.t1300 VGND 0.0399f
C3065 VPWR.t2299 VGND 2.5285f
C3066 VPWR.n1146 VGND 0.03332f
C3067 VPWR.t1302 VGND 0.0399f
C3068 VPWR.n1147 VGND 0.04104f
C3069 VPWR.t2301 VGND 0.09859f
C3070 VPWR.n1149 VGND 0.03344f
C3071 VPWR.t1304 VGND 0.0399f
C3072 VPWR.n1150 VGND 0.03332f
C3073 VPWR.t2303 VGND 0.04169f
C3074 VPWR.t1306 VGND 0.04169f
C3075 VPWR.n1152 VGND 0.04086f
C3076 VPWR.t2112 VGND 0.03652f
C3077 VPWR.n1154 VGND 0.04689f
C3078 VPWR.t19 VGND 1.99777f
C3079 VPWR.t20 VGND 2.00018f
C3080 VPWR.t2113 VGND 0.04f
C3081 VPWR.t862 VGND 0.03275f
C3082 VPWR.t2115 VGND 0.0399f
C3083 VPWR.t2117 VGND 0.0399f
C3084 VPWR.n1155 VGND 0.05154f
C3085 VPWR.t2119 VGND 0.0399f
C3086 VPWR.t1977 VGND 2.51584f
C3087 VPWR.n1157 VGND 0.04771f
C3088 VPWR.n1158 VGND 0.03826f
C3089 VPWR.t1978 VGND 0.0399f
C3090 VPWR.t1980 VGND 0.0399f
C3091 VPWR.n1160 VGND 0.03969f
C3092 VPWR.t2121 VGND 2.4945f
C3093 VPWR.t2123 VGND 0.0399f
C3094 VPWR.n1161 VGND 0.03332f
C3095 VPWR.n1162 VGND 0.01588f
C3096 VPWR.t1982 VGND 0.0399f
C3097 VPWR.n1163 VGND 0.04183f
C3098 VPWR.t2127 VGND 0.07244f
C3099 VPWR.t2125 VGND 0.17065f
C3100 VPWR.t1984 VGND 0.0399f
C3101 VPWR.n1164 VGND 0.04499f
C3102 VPWR.n1165 VGND 0.03754f
C3103 VPWR.t185 VGND 0.23622f
C3104 VPWR.t1988 VGND 0.0399f
C3105 VPWR.t188 VGND 0.13998f
C3106 VPWR.t1990 VGND 0.0399f
C3107 VPWR.n1167 VGND 0.04744f
C3108 VPWR.t190 VGND 0.03276f
C3109 VPWR.t1992 VGND 0.04169f
C3110 VPWR.t166 VGND 0.05598f
C3111 VPWR.t848 VGND 0.03276f
C3112 VPWR.n1168 VGND 0.08102f
C3113 VPWR.n1169 VGND 0.01544f
C3114 VPWR.t1966 VGND 0.0399f
C3115 VPWR.t1542 VGND 0.0399f
C3116 VPWR.n1170 VGND 0.07214f
C3117 VPWR.n1171 VGND 0.01584f
C3118 VPWR.t1964 VGND 0.0399f
C3119 VPWR.t1540 VGND 0.0399f
C3120 VPWR.n1172 VGND 0.07177f
C3121 VPWR.n1173 VGND 0.01606f
C3122 VPWR.t1962 VGND 0.0399f
C3123 VPWR.t1538 VGND 0.0399f
C3124 VPWR.n1174 VGND 0.0716f
C3125 VPWR.n1175 VGND 0.01613f
C3126 VPWR.t1961 VGND 0.03652f
C3127 VPWR.t1537 VGND 0.03652f
C3128 VPWR.n1176 VGND 0.08642f
C3129 VPWR.t860 VGND 0.12658f
C3130 VPWR.n1178 VGND 0.05663f
C3131 VPWR.n1179 VGND 0.01367f
C3132 VPWR.t859 VGND 3.20188f
C3133 VPWR.n1180 VGND 0.13783f
C3134 VPWR.t122 VGND 0.03275f
C3135 VPWR.n1181 VGND 0.04988f
C3136 VPWR.n1182 VGND 0.06652f
C3137 VPWR.t68 VGND 0.03517f
C3138 VPWR.n1183 VGND 0.0111f
C3139 VPWR.t1386 VGND 0.0399f
C3140 VPWR.t1280 VGND 0.0399f
C3141 VPWR.n1184 VGND 0.01561f
C3142 VPWR.t1278 VGND 0.0399f
C3143 VPWR.n1185 VGND 0.04127f
C3144 VPWR.n1186 VGND 0.0111f
C3145 VPWR.t1275 VGND 0.03652f
C3146 VPWR.t12 VGND 0.03276f
C3147 VPWR.t1377 VGND 0.0399f
C3148 VPWR.t2422 VGND 0.05138f
C3149 VPWR.n1190 VGND 0.01412f
C3150 VPWR.t1588 VGND 0.0399f
C3151 VPWR.t51 VGND 0.03275f
C3152 VPWR.n1191 VGND 0.01547f
C3153 VPWR.t1673 VGND 1.21552f
C3154 VPWR.n1192 VGND 0.03933f
C3155 VPWR.t125 VGND 0.03276f
C3156 VPWR.t1567 VGND 0.03652f
C3157 VPWR.t50 VGND 0.03517f
C3158 VPWR.t1586 VGND 0.04f
C3159 VPWR.t1584 VGND 0.0399f
C3160 VPWR.t1590 VGND 0.0399f
C3161 VPWR.n1193 VGND 0.05587f
C3162 VPWR.t1568 VGND 0.03652f
C3163 VPWR.t1592 VGND 0.06027f
C3164 VPWR.n1195 VGND 0.04379f
C3165 VPWR.n1196 VGND 0.04726f
C3166 VPWR.n1197 VGND 0.01125f
C3167 VPWR.t1569 VGND 0.0399f
C3168 VPWR.t1594 VGND 0.0399f
C3169 VPWR.n1198 VGND 0.03755f
C3170 VPWR.n1199 VGND 0.03893f
C3171 VPWR.t1571 VGND 0.0399f
C3172 VPWR.n1200 VGND 0.04027f
C3173 VPWR.n1201 VGND 0.01606f
C3174 VPWR.t1598 VGND 0.06229f
C3175 VPWR.t1596 VGND 2.5108f
C3176 VPWR.n1202 VGND 0.03054f
C3177 VPWR.n1203 VGND 0.01354f
C3178 VPWR.t1573 VGND 0.0399f
C3179 VPWR.n1204 VGND 0.04183f
C3180 VPWR.t1575 VGND 0.0399f
C3181 VPWR.t1368 VGND 0.03652f
C3182 VPWR.n1206 VGND 0.04771f
C3183 VPWR.n1207 VGND 0.03826f
C3184 VPWR.t1369 VGND 0.0399f
C3185 VPWR.t1371 VGND 0.0399f
C3186 VPWR.n1209 VGND 0.03968f
C3187 VPWR.t1577 VGND 0.0399f
C3188 VPWR.t1579 VGND 0.0399f
C3189 VPWR.n1210 VGND 0.03332f
C3190 VPWR.n1211 VGND 0.01588f
C3191 VPWR.t1373 VGND 0.0399f
C3192 VPWR.n1212 VGND 0.04183f
C3193 VPWR.t1583 VGND 0.06229f
C3194 VPWR.t1581 VGND 0.05344f
C3195 VPWR.t1375 VGND 0.0399f
C3196 VPWR.n1213 VGND 0.04499f
C3197 VPWR.n1214 VGND 0.03754f
C3198 VPWR.t2423 VGND 0.14761f
C3199 VPWR.t1379 VGND 0.0399f
C3200 VPWR.t2425 VGND 0.12657f
C3201 VPWR.t1381 VGND 0.0399f
C3202 VPWR.n1216 VGND 0.04744f
C3203 VPWR.t2426 VGND 0.03276f
C3204 VPWR.t1383 VGND 0.04169f
C3205 VPWR.t13 VGND 0.12899f
C3206 VPWR.t65 VGND 0.12899f
C3207 VPWR.n1217 VGND 0.13783f
C3208 VPWR.t15 VGND 0.12658f
C3209 VPWR.t66 VGND 0.12657f
C3210 VPWR.t1384 VGND 0.05344f
C3211 VPWR.t1367 VGND 0.06229f
C3212 VPWR.n1218 VGND 0.03054f
C3213 VPWR.t1276 VGND 0.0399f
C3214 VPWR.n1219 VGND 0.04051f
C3215 VPWR.t1282 VGND 0.0399f
C3216 VPWR.t1388 VGND 0.0399f
C3217 VPWR.t1284 VGND 0.0399f
C3218 VPWR.t1390 VGND 0.0399f
C3219 VPWR.t1286 VGND 0.0399f
C3220 VPWR.t1392 VGND 0.0399f
C3221 VPWR.t1394 VGND 0.0399f
C3222 VPWR.n1221 VGND 0.04127f
C3223 VPWR.n1222 VGND 0.01561f
C3224 VPWR.t1290 VGND 0.06229f
C3225 VPWR.t1288 VGND 0.05344f
C3226 VPWR.n1223 VGND 0.03054f
C3227 VPWR.t1396 VGND 0.0399f
C3228 VPWR.n1225 VGND 0.04051f
C3229 VPWR.n1226 VGND 0.01087f
C3230 VPWR.t1398 VGND 0.03652f
C3231 VPWR.t67 VGND 0.03276f
C3232 VPWR.n1227 VGND 0.04533f
C3233 VPWR.n1228 VGND 0.0467f
C3234 VPWR.t858 VGND 3.10565f
C3235 VPWR.n1229 VGND 0.0497f
C3236 VPWR.t1968 VGND 0.0399f
C3237 VPWR.t1544 VGND 0.0399f
C3238 VPWR.n1231 VGND 0.07942f
C3239 VPWR.t1970 VGND 0.0399f
C3240 VPWR.t1546 VGND 0.0399f
C3241 VPWR.n1233 VGND 0.07936f
C3242 VPWR.n1234 VGND 0.01552f
C3243 VPWR.t1972 VGND 0.0399f
C3244 VPWR.t1548 VGND 0.0399f
C3245 VPWR.n1235 VGND 0.07206f
C3246 VPWR.n1236 VGND 0.01585f
C3247 VPWR.t1974 VGND 0.0399f
C3248 VPWR.t1550 VGND 0.0399f
C3249 VPWR.n1237 VGND 0.07197f
C3250 VPWR.n1238 VGND 0.01774f
C3251 VPWR.t1976 VGND 0.04169f
C3252 VPWR.t1552 VGND 0.04169f
C3253 VPWR.n1239 VGND 0.08665f
C3254 VPWR.t56 VGND 0.173f
C3255 VPWR.t1436 VGND 0.0399f
C3256 VPWR.t55 VGND 0.03275f
C3257 VPWR.t1434 VGND 0.0399f
C3258 VPWR.t52 VGND 0.03517f
C3259 VPWR.t1432 VGND 0.04423f
C3260 VPWR.t1431 VGND 0.05834f
C3261 VPWR.t53 VGND 0.03276f
C3262 VPWR.n1241 VGND 0.0497f
C3263 VPWR.t1486 VGND 0.04169f
C3264 VPWR.t1502 VGND 0.04169f
C3265 VPWR.n1243 VGND 0.08665f
C3266 VPWR.n1244 VGND 0.01774f
C3267 VPWR.t1484 VGND 0.0399f
C3268 VPWR.t1500 VGND 0.0399f
C3269 VPWR.n1245 VGND 0.07197f
C3270 VPWR.n1246 VGND 0.01585f
C3271 VPWR.t1482 VGND 0.0399f
C3272 VPWR.t1498 VGND 0.0399f
C3273 VPWR.n1247 VGND 0.07206f
C3274 VPWR.n1248 VGND 0.01552f
C3275 VPWR.t1480 VGND 0.0399f
C3276 VPWR.t1496 VGND 0.0399f
C3277 VPWR.n1249 VGND 0.07936f
C3278 VPWR.t1478 VGND 0.0399f
C3279 VPWR.t1494 VGND 0.0399f
C3280 VPWR.n1251 VGND 0.07942f
C3281 VPWR.n1252 VGND 0.01544f
C3282 VPWR.t1476 VGND 0.0399f
C3283 VPWR.t1492 VGND 0.0399f
C3284 VPWR.n1253 VGND 0.07214f
C3285 VPWR.n1254 VGND 0.01584f
C3286 VPWR.t1474 VGND 0.0399f
C3287 VPWR.t1490 VGND 0.0399f
C3288 VPWR.n1255 VGND 0.07177f
C3289 VPWR.n1256 VGND 0.01606f
C3290 VPWR.t1472 VGND 0.0399f
C3291 VPWR.t1488 VGND 2.45656f
C3292 VPWR.n1257 VGND 0.0716f
C3293 VPWR.n1258 VGND 0.01613f
C3294 VPWR.t1471 VGND 0.03652f
C3295 VPWR.t1487 VGND 0.03652f
C3296 VPWR.n1259 VGND 0.08642f
C3297 VPWR.n1260 VGND 0.01436f
C3298 VPWR.t647 VGND 0.03147f
C3299 VPWR.n1261 VGND 0.08081f
C3300 VPWR.n1262 VGND 0.04936f
C3301 VPWR.t271 VGND 0.24232f
C3302 VPWR.n1264 VGND 0.08081f
C3303 VPWR.t646 VGND 0.03275f
C3304 VPWR.t270 VGND 0.2436f
C3305 VPWR.t645 VGND 0.12657f
C3306 VPWR.t269 VGND 0.03275f
C3307 VPWR.n1265 VGND 0.05584f
C3308 VPWR.t643 VGND 0.12899f
C3309 VPWR.t267 VGND 0.03517f
C3310 VPWR.n1266 VGND 0.13783f
C3311 VPWR.t642 VGND 0.03276f
C3312 VPWR.t266 VGND 0.03276f
C3313 VPWR.t641 VGND 0.2204f
C3314 VPWR.t265 VGND 0.03275f
C3315 VPWR.t639 VGND 0.26925f
C3316 VPWR.t263 VGND 0.03517f
C3317 VPWR.n1267 VGND 0.13783f
C3318 VPWR.n1268 VGND 0.06637f
C3319 VPWR.t638 VGND 0.0792f
C3320 VPWR.t262 VGND 0.03276f
C3321 VPWR.t1566 VGND 0.03652f
C3322 VPWR.t1939 VGND 0.04169f
C3323 VPWR.n1269 VGND 0.04628f
C3324 VPWR.n1270 VGND 0.01112f
C3325 VPWR.t1536 VGND 0.0399f
C3326 VPWR.n1271 VGND 0.03343f
C3327 VPWR.n1272 VGND 0.01091f
C3328 VPWR.t1937 VGND 0.0399f
C3329 VPWR.n1273 VGND 0.03332f
C3330 VPWR.t1563 VGND 0.0399f
C3331 VPWR.n1275 VGND 0.04283f
C3332 VPWR.t1935 VGND 0.0399f
C3333 VPWR.t1561 VGND 0.0399f
C3334 VPWR.t1933 VGND 0.0399f
C3335 VPWR.t1559 VGND 0.0399f
C3336 VPWR.n1276 VGND 0.04264f
C3337 VPWR.t1931 VGND 0.0399f
C3338 VPWR.t1557 VGND 0.0399f
C3339 VPWR.t1929 VGND 0.0399f
C3340 VPWR.n1278 VGND 0.0413f
C3341 VPWR.t1555 VGND 0.0399f
C3342 VPWR.n1280 VGND 0.03332f
C3343 VPWR.n1281 VGND 0.01079f
C3344 VPWR.t1927 VGND 0.0399f
C3345 VPWR.n1282 VGND 0.03332f
C3346 VPWR.t1553 VGND 0.0399f
C3347 VPWR.n1284 VGND 0.03332f
C3348 VPWR.n1285 VGND 0.01091f
C3349 VPWR.t1925 VGND 0.0399f
C3350 VPWR.n1286 VGND 0.03343f
C3351 VPWR.n1287 VGND 0.01112f
C3352 VPWR.t1535 VGND 0.04169f
C3353 VPWR.n1288 VGND 0.04075f
C3354 VPWR.t1924 VGND 0.03652f
C3355 VPWR.n1290 VGND 0.06162f
C3356 VPWR.n1291 VGND 0.02079f
C3357 VPWR.t11 VGND 0.07966f
C3358 VPWR.t2428 VGND 0.03275f
C3359 VPWR.n1292 VGND 0.10109f
C3360 VPWR.n1293 VGND 0.01219f
C3361 VPWR.t10 VGND 0.08208f
C3362 VPWR.n1294 VGND 0.1481f
C3363 VPWR.t853 VGND 0.03517f
C3364 VPWR.n1295 VGND 0.14813f
C3365 VPWR.n1296 VGND 0.12006f
C3366 VPWR.n1297 VGND 0.01076f
C3367 VPWR.t230 VGND 0.03276f
C3368 VPWR.t852 VGND 0.03276f
C3369 VPWR.t167 VGND 0.1053f
C3370 VPWR.t849 VGND 0.03517f
C3371 VPWR.t229 VGND 0.07966f
C3372 VPWR.t851 VGND 0.03275f
C3373 VPWR.t433 VGND 0.03147f
C3374 VPWR.n1298 VGND 0.08879f
C3375 VPWR.n1299 VGND 0.06841f
C3376 VPWR.n1300 VGND 0.01629f
C3377 VPWR.t127 VGND 0.1053f
C3378 VPWR.t1326 VGND 2.47809f
C3379 VPWR.t1342 VGND 0.04169f
C3380 VPWR.n1302 VGND 0.08665f
C3381 VPWR.n1303 VGND 0.01774f
C3382 VPWR.t1324 VGND 0.0399f
C3383 VPWR.t1340 VGND 0.0399f
C3384 VPWR.n1304 VGND 0.07197f
C3385 VPWR.n1305 VGND 0.01585f
C3386 VPWR.t1322 VGND 0.0399f
C3387 VPWR.t1338 VGND 0.0399f
C3388 VPWR.n1306 VGND 0.07206f
C3389 VPWR.n1307 VGND 0.01552f
C3390 VPWR.t1320 VGND 0.0399f
C3391 VPWR.t1336 VGND 0.0399f
C3392 VPWR.n1308 VGND 0.07936f
C3393 VPWR.t1311 VGND 0.03652f
C3394 VPWR.t1327 VGND 0.03652f
C3395 VPWR.n1310 VGND 0.09298f
C3396 VPWR.n1311 VGND 0.0122f
C3397 VPWR.t1312 VGND 0.0399f
C3398 VPWR.t1328 VGND 0.0399f
C3399 VPWR.n1312 VGND 0.07559f
C3400 VPWR.n1313 VGND 0.01606f
C3401 VPWR.t1314 VGND 0.0399f
C3402 VPWR.t1330 VGND 0.0399f
C3403 VPWR.n1314 VGND 0.07177f
C3404 VPWR.n1315 VGND 0.01584f
C3405 VPWR.t1316 VGND 0.0399f
C3406 VPWR.t1332 VGND 0.0399f
C3407 VPWR.n1316 VGND 0.07214f
C3408 VPWR.t1318 VGND 0.0399f
C3409 VPWR.t1334 VGND 0.0399f
C3410 VPWR.n1317 VGND 0.07942f
C3411 VPWR.n1318 VGND 0.01544f
C3412 VPWR.t126 VGND 0.03276f
C3413 VPWR.t1960 VGND 0.41598f
C3414 VPWR.t431 VGND 0.10288f
C3415 VPWR.n1319 VGND 0.05919f
C3416 VPWR.t432 VGND 0.03275f
C3417 VPWR.n1320 VGND 0.0513f
C3418 VPWR.t1621 VGND 0.0399f
C3419 VPWR.t2016 VGND 0.0399f
C3420 VPWR.n1322 VGND 0.0381f
C3421 VPWR.n1323 VGND 0.04009f
C3422 VPWR.t1619 VGND 0.0399f
C3423 VPWR.t2014 VGND 0.0399f
C3424 VPWR.n1325 VGND 0.03857f
C3425 VPWR.n1326 VGND 0.03926f
C3426 VPWR.n1327 VGND 0.0101f
C3427 VPWR.t1618 VGND 0.03652f
C3428 VPWR.t2012 VGND 0.0399f
C3429 VPWR.n1328 VGND 0.03928f
C3430 VPWR.n1329 VGND 0.04615f
C3431 VPWR.t2011 VGND 0.04169f
C3432 VPWR.t1631 VGND 0.03655f
C3433 VPWR.n1331 VGND 0.04472f
C3434 VPWR.n1332 VGND 0.04506f
C3435 VPWR.n1333 VGND 0.0133f
C3436 VPWR.t1629 VGND 0.63266f
C3437 VPWR.t1906 VGND 0.04169f
C3438 VPWR.n1334 VGND 0.07946f
C3439 VPWR.t1904 VGND 0.0399f
C3440 VPWR.t1628 VGND 0.03577f
C3441 VPWR.n1335 VGND 0.01587f
C3442 VPWR.t1902 VGND 0.0399f
C3443 VPWR.n1336 VGND 0.04011f
C3444 VPWR.n1338 VGND 0.01215f
C3445 VPWR.n1339 VGND 0.01201f
C3446 VPWR.t1422 VGND 0.0399f
C3447 VPWR.t1861 VGND 0.0399f
C3448 VPWR.n1341 VGND 0.04213f
C3449 VPWR.n1342 VGND 0.04213f
C3450 VPWR.t1859 VGND 0.0399f
C3451 VPWR.t109 VGND 0.13584f
C3452 VPWR.t41 VGND 0.31663f
C3453 VPWR.t1412 VGND 0.0507f
C3454 VPWR.t62 VGND 0.03276f
C3455 VPWR.t1410 VGND 0.0399f
C3456 VPWR.t1408 VGND 0.0399f
C3457 VPWR.t61 VGND 0.03275f
C3458 VPWR.n1347 VGND 0.04927f
C3459 VPWR.n1348 VGND 0.04195f
C3460 VPWR.t57 VGND 0.17172f
C3461 VPWR.t1438 VGND 0.04002f
C3462 VPWR.t1440 VGND 0.0399f
C3463 VPWR.t1399 VGND 0.03652f
C3464 VPWR.t1442 VGND 0.0399f
C3465 VPWR.t1400 VGND 0.0399f
C3466 VPWR.t1444 VGND 0.0399f
C3467 VPWR.t1402 VGND 0.0399f
C3468 VPWR.t1446 VGND 0.03652f
C3469 VPWR.t1404 VGND 0.0399f
C3470 VPWR.t58 VGND 0.03276f
C3471 VPWR.n1351 VGND 0.04797f
C3472 VPWR.n1352 VGND 0.0403f
C3473 VPWR.t1406 VGND 0.04f
C3474 VPWR.t59 VGND 0.03517f
C3475 VPWR.n1353 VGND 0.14813f
C3476 VPWR.n1354 VGND 0.11221f
C3477 VPWR.t40 VGND 0.31422f
C3478 VPWR.t1414 VGND 0.04169f
C3479 VPWR.n1356 VGND 0.04754f
C3480 VPWR.t42 VGND 0.03276f
C3481 VPWR.t110 VGND 0.13825f
C3482 VPWR.n1357 VGND 0.13783f
C3483 VPWR.n1358 VGND 0.06637f
C3484 VPWR.t112 VGND 0.03275f
C3485 VPWR.t43 VGND 0.03517f
C3486 VPWR.t45 VGND 0.03275f
C3487 VPWR.n1359 VGND 0.05668f
C3488 VPWR.t1415 VGND 0.04169f
C3489 VPWR.n1360 VGND 0.05507f
C3490 VPWR.n1361 VGND 0.01436f
C3491 VPWR.t1416 VGND 0.0399f
C3492 VPWR.n1362 VGND 0.03332f
C3493 VPWR.t1854 VGND 0.03652f
C3494 VPWR.n1363 VGND 0.04085f
C3495 VPWR.n1364 VGND 0.01215f
C3496 VPWR.t1418 VGND 0.0399f
C3497 VPWR.n1365 VGND 0.03332f
C3498 VPWR.t1855 VGND 0.0399f
C3499 VPWR.n1366 VGND 0.03332f
C3500 VPWR.n1367 VGND 0.01201f
C3501 VPWR.t1420 VGND 0.0399f
C3502 VPWR.t1857 VGND 0.0399f
C3503 VPWR.n1368 VGND 0.04061f
C3504 VPWR.t1863 VGND 3.87256f
C3505 VPWR.t1424 VGND 0.0399f
C3506 VPWR.t1865 VGND 0.0399f
C3507 VPWR.n1369 VGND 0.03332f
C3508 VPWR.t1426 VGND 0.0399f
C3509 VPWR.n1370 VGND 0.04061f
C3510 VPWR.t1867 VGND 0.0399f
C3511 VPWR.n1372 VGND 0.03332f
C3512 VPWR.t1428 VGND 0.0399f
C3513 VPWR.n1373 VGND 0.03332f
C3514 VPWR.t1430 VGND 0.03652f
C3515 VPWR.n1375 VGND 0.04085f
C3516 VPWR.t1869 VGND 0.04169f
C3517 VPWR.n1377 VGND 0.04826f
C3518 VPWR.t1891 VGND 0.03652f
C3519 VPWR.t273 VGND 0.03276f
C3520 VPWR.n1379 VGND 0.04431f
C3521 VPWR.n1380 VGND 0.04827f
C3522 VPWR.t274 VGND 0.14751f
C3523 VPWR.t1892 VGND 0.04f
C3524 VPWR.t1894 VGND 0.0399f
C3525 VPWR.t276 VGND 0.1451f
C3526 VPWR.t1896 VGND 0.0399f
C3527 VPWR.n1381 VGND 0.04183f
C3528 VPWR.n1382 VGND 0.01544f
C3529 VPWR.t1898 VGND 0.0399f
C3530 VPWR.n1383 VGND 0.04924f
C3531 VPWR.t1777 VGND 0.08941f
C3532 VPWR.n1384 VGND 0.04135f
C3533 VPWR.t1601 VGND 0.34209f
C3534 VPWR.n1386 VGND 0.04029f
C3535 VPWR.t1900 VGND 0.0399f
C3536 VPWR.t2018 VGND 0.0399f
C3537 VPWR.t1623 VGND 0.04067f
C3538 VPWR.t2020 VGND 0.0399f
C3539 VPWR.t1625 VGND 0.03652f
C3540 VPWR.t1889 VGND 0.03649f
C3541 VPWR.t2022 VGND 0.0399f
C3542 VPWR.t130 VGND 0.07918f
C3543 VPWR.t2024 VGND 0.0399f
C3544 VPWR.t131 VGND 0.0779f
C3545 VPWR.t2026 VGND 0.03673f
C3546 VPWR.n1387 VGND 0.01313f
C3547 VPWR.n1388 VGND 0.10251f
C3548 VPWR.n1389 VGND 1.32699f
C3549 VPWR.t855 VGND 0.03276f
C3550 VPWR.t2079 VGND 0.04169f
C3551 VPWR.t362 VGND 0.03275f
C3552 VPWR.t2080 VGND 0.0399f
C3553 VPWR.n1390 VGND 0.04124f
C3554 VPWR.n1391 VGND 0.01587f
C3555 VPWR.t2082 VGND 0.0399f
C3556 VPWR.t2084 VGND 0.0399f
C3557 VPWR.t1940 VGND 0.03652f
C3558 VPWR.t1941 VGND 0.0399f
C3559 VPWR.t2086 VGND 0.0399f
C3560 VPWR.t1943 VGND 0.0399f
C3561 VPWR.t2088 VGND 0.0399f
C3562 VPWR.t1945 VGND 0.0399f
C3563 VPWR.t2090 VGND 0.0399f
C3564 VPWR.t1947 VGND 0.0399f
C3565 VPWR.t2092 VGND 0.0399f
C3566 VPWR.t2094 VGND 0.03652f
C3567 VPWR.t1949 VGND 0.0399f
C3568 VPWR.t1951 VGND 0.0399f
C3569 VPWR.t2429 VGND 1.52797f
C3570 VPWR.t649 VGND 1.6242f
C3571 VPWR.t1953 VGND 2.65324f
C3572 VPWR.t1955 VGND 0.04169f
C3573 VPWR.t648 VGND 0.12658f
C3574 VPWR.t21 VGND 0.03276f
C3575 VPWR.t650 VGND 0.03276f
C3576 VPWR.t22 VGND 0.03517f
C3577 VPWR.n1392 VGND 0.13783f
C3578 VPWR.t651 VGND 0.03517f
C3579 VPWR.t24 VGND 0.03275f
C3580 VPWR.t653 VGND 0.03275f
C3581 VPWR.n1393 VGND 0.04998f
C3582 VPWR.t2143 VGND 0.03652f
C3583 VPWR.t2159 VGND 0.03652f
C3584 VPWR.n1395 VGND 0.08642f
C3585 VPWR.n1396 VGND 0.01613f
C3586 VPWR.t2144 VGND 0.0399f
C3587 VPWR.t2160 VGND 1.32978f
C3588 VPWR.n1397 VGND 0.0716f
C3589 VPWR.n1398 VGND 0.01606f
C3590 VPWR.t2146 VGND 0.0399f
C3591 VPWR.t2162 VGND 0.0399f
C3592 VPWR.n1399 VGND 0.07177f
C3593 VPWR.n1400 VGND 0.01584f
C3594 VPWR.t2148 VGND 0.0399f
C3595 VPWR.t2164 VGND 0.0399f
C3596 VPWR.n1401 VGND 0.07214f
C3597 VPWR.n1402 VGND 0.01544f
C3598 VPWR.t2150 VGND 0.0399f
C3599 VPWR.t2166 VGND 0.0399f
C3600 VPWR.n1403 VGND 0.07946f
C3601 VPWR.t2152 VGND 0.0399f
C3602 VPWR.t2168 VGND 0.0399f
C3603 VPWR.n1405 VGND 0.07932f
C3604 VPWR.n1406 VGND 0.01552f
C3605 VPWR.t2154 VGND 0.0399f
C3606 VPWR.t2170 VGND 0.0399f
C3607 VPWR.n1407 VGND 0.07206f
C3608 VPWR.n1408 VGND 0.01585f
C3609 VPWR.t2156 VGND 0.0399f
C3610 VPWR.t2172 VGND 0.0399f
C3611 VPWR.n1409 VGND 0.07197f
C3612 VPWR.n1410 VGND 0.01774f
C3613 VPWR.t2158 VGND 0.04169f
C3614 VPWR.t2174 VGND 2.43097f
C3615 VPWR.n1411 VGND 0.08665f
C3616 VPWR.t1447 VGND 0.03652f
C3617 VPWR.t349 VGND 0.03276f
C3618 VPWR.n1413 VGND 0.04431f
C3619 VPWR.n1414 VGND 0.04827f
C3620 VPWR.t1448 VGND 0.04f
C3621 VPWR.t350 VGND 0.41696f
C3622 VPWR.t1450 VGND 0.0399f
C3623 VPWR.t352 VGND 0.41454f
C3624 VPWR.t1452 VGND 0.0399f
C3625 VPWR.n1415 VGND 0.04183f
C3626 VPWR.n1416 VGND 0.01544f
C3627 VPWR.t1454 VGND 0.0399f
C3628 VPWR.n1417 VGND 0.04924f
C3629 VPWR.t2220 VGND 0.03652f
C3630 VPWR.t1456 VGND 0.0399f
C3631 VPWR.t2221 VGND 0.0399f
C3632 VPWR.n1418 VGND 0.0399f
C3633 VPWR.t1458 VGND 0.0399f
C3634 VPWR.n1420 VGND 0.03332f
C3635 VPWR.n1421 VGND 0.01466f
C3636 VPWR.t2223 VGND 0.0399f
C3637 VPWR.n1422 VGND 0.03332f
C3638 VPWR.t1460 VGND 0.0399f
C3639 VPWR.t2225 VGND 0.0399f
C3640 VPWR.t1462 VGND 0.04169f
C3641 VPWR.n1424 VGND 0.05024f
C3642 VPWR.t2227 VGND 0.0399f
C3643 VPWR.t64 VGND 0.17172f
C3644 VPWR.n1425 VGND 0.08877f
C3645 VPWR.t2229 VGND 0.04002f
C3646 VPWR.t63 VGND 0.173f
C3647 VPWR.t124 VGND 0.12899f
C3648 VPWR.t123 VGND 0.12658f
C3649 VPWR.t857 VGND 0.2204f
C3650 VPWR.t192 VGND 0.03275f
C3651 VPWR.t854 VGND 0.22281f
C3652 VPWR.t189 VGND 0.03517f
C3653 VPWR.n1427 VGND 0.07776f
C3654 VPWR.n1428 VGND 0.01608f
C3655 VPWR.n1429 VGND 1.32699f
C3656 VPWR.n1430 VGND 0.69968f
C3657 VPWR.n1431 VGND 0.04645f
C3658 VPWR.t1366 VGND 0.03652f
C3659 VPWR.n1433 VGND 0.04914f
C3660 VPWR.n1434 VGND 0.01334f
C3661 VPWR.t1358 VGND 0.06229f
C3662 VPWR.t1356 VGND 0.05344f
C3663 VPWR.n1435 VGND 0.03054f
C3664 VPWR.t1364 VGND 0.0399f
C3665 VPWR.n1437 VGND 0.04031f
C3666 VPWR.n1438 VGND 0.01608f
C3667 VPWR.t1354 VGND 0.0399f
C3668 VPWR.t1362 VGND 0.33738f
C3669 VPWR.n1439 VGND 0.03887f
C3670 VPWR.n1440 VGND 0.03735f
C3671 VPWR.n1441 VGND 0.0115f
C3672 VPWR.t1352 VGND 0.0399f
C3673 VPWR.t1360 VGND 0.73078f
C3674 VPWR.n1442 VGND 0.04721f
C3675 VPWR.t1359 VGND 0.03652f
C3676 VPWR.t1350 VGND 0.0399f
C3677 VPWR.t94 VGND 0.03147f
C3678 VPWR.t1348 VGND 0.0399f
C3679 VPWR.t93 VGND 0.03275f
C3680 VPWR.t1346 VGND 0.0399f
C3681 VPWR.t2250 VGND 0.21422f
C3682 VPWR.t1344 VGND 0.0399f
C3683 VPWR.t2248 VGND 0.0399f
C3684 VPWR.t1343 VGND 0.03652f
C3685 VPWR.t2246 VGND 0.0399f
C3686 VPWR.t2244 VGND 0.0399f
C3687 VPWR.t317 VGND 0.0779f
C3688 VPWR.t316 VGND 0.07918f
C3689 VPWR.t2242 VGND 0.0399f
C3690 VPWR.t2240 VGND 0.0399f
C3691 VPWR.t315 VGND 2.58511f
C3692 VPWR.t2238 VGND 0.04f
C3693 VPWR.t313 VGND 2.58753f
C3694 VPWR.t2236 VGND 0.0399f
C3695 VPWR.t312 VGND 0.03276f
C3696 VPWR.t2219 VGND 0.03652f
C3697 VPWR.n1443 VGND 0.04074f
C3698 VPWR.t786 VGND 0.04169f
C3699 VPWR.n1445 VGND 0.04806f
C3700 VPWR.t784 VGND 0.0399f
C3701 VPWR.t360 VGND 0.03275f
C3702 VPWR.t358 VGND 0.03517f
C3703 VPWR.t782 VGND 0.32796f
C3704 VPWR.t780 VGND 0.0399f
C3705 VPWR.t357 VGND 0.03276f
C3706 VPWR.t356 VGND 0.22039f
C3707 VPWR.t778 VGND 0.0399f
C3708 VPWR.t354 VGND 0.22281f
C3709 VPWR.n1447 VGND 0.13783f
C3710 VPWR.t776 VGND 0.0399f
C3711 VPWR.n1448 VGND 0.04934f
C3712 VPWR.n1449 VGND 0.05928f
C3713 VPWR.t774 VGND 0.0399f
C3714 VPWR.t353 VGND 0.03276f
C3715 VPWR.t772 VGND 0.0399f
C3716 VPWR.t39 VGND 0.12657f
C3717 VPWR.t771 VGND 0.03652f
C3718 VPWR.t36 VGND 0.12899f
C3719 VPWR.t1518 VGND 0.04742f
C3720 VPWR.t1516 VGND 0.05084f
C3721 VPWR.t37 VGND 0.03276f
C3722 VPWR.t1514 VGND 0.0399f
C3723 VPWR.t35 VGND 0.12658f
C3724 VPWR.n1451 VGND 0.05099f
C3725 VPWR.n1452 VGND 0.04081f
C3726 VPWR.t33 VGND 0.22281f
C3727 VPWR.n1454 VGND 0.1481f
C3728 VPWR.t1512 VGND 0.04f
C3729 VPWR.n1455 VGND 0.11226f
C3730 VPWR.t32 VGND 0.12658f
C3731 VPWR.t1510 VGND 0.0399f
C3732 VPWR.n1457 VGND 0.04158f
C3733 VPWR.t1508 VGND 0.0399f
C3734 VPWR.t31 VGND 0.03275f
C3735 VPWR.t29 VGND 0.03517f
C3736 VPWR.t1506 VGND 0.04f
C3737 VPWR.t1504 VGND 0.0399f
C3738 VPWR.n1458 VGND 0.03979f
C3739 VPWR.t28 VGND 0.03276f
C3740 VPWR.t1503 VGND 0.03652f
C3741 VPWR.t27 VGND 0.17348f
C3742 VPWR.t26 VGND 0.22281f
C3743 VPWR.n1459 VGND 0.1481f
C3744 VPWR.t116 VGND 1.37572f
C3745 VPWR.n1460 VGND 0.12606f
C3746 VPWR.t363 VGND 0.07985f
C3747 VPWR.t114 VGND 1.37796f
C3748 VPWR.t1187 VGND 0.03652f
C3749 VPWR.t113 VGND 0.03276f
C3750 VPWR.t1185 VGND 1.3835f
C3751 VPWR.n1461 VGND 0.03879f
C3752 VPWR.t1054 VGND 0.03652f
C3753 VPWR.n1463 VGND 0.04074f
C3754 VPWR.n1464 VGND 0.01385f
C3755 VPWR.t1183 VGND 0.46881f
C3756 VPWR.n1465 VGND 0.03332f
C3757 VPWR.t1052 VGND 0.04067f
C3758 VPWR.t1181 VGND 0.12045f
C3759 VPWR.t1050 VGND 0.0399f
C3760 VPWR.t1179 VGND 0.0399f
C3761 VPWR.t1048 VGND 0.0399f
C3762 VPWR.t1047 VGND 0.03652f
C3763 VPWR.t1177 VGND 0.0399f
C3764 VPWR.n1467 VGND 0.0455f
C3765 VPWR.n1468 VGND 0.04843f
C3766 VPWR.t967 VGND 0.03655f
C3767 VPWR.t1175 VGND 0.0399f
C3768 VPWR.n1469 VGND 0.01608f
C3769 VPWR.t965 VGND 0.03992f
C3770 VPWR.n1470 VGND 0.04115f
C3771 VPWR.t1173 VGND 0.05344f
C3772 VPWR.t1172 VGND 0.06229f
C3773 VPWR.n1472 VGND 0.03054f
C3774 VPWR.n1473 VGND 0.0111f
C3775 VPWR.t964 VGND 0.03577f
C3776 VPWR.n1474 VGND 0.06114f
C3777 VPWR.n1475 VGND 0.02703f
C3778 VPWR.t195 VGND 0.2204f
C3779 VPWR.t226 VGND 0.07919f
C3780 VPWR.n1476 VGND 0.10959f
C3781 VPWR.t194 VGND 0.22281f
C3782 VPWR.t224 VGND 0.17543f
C3783 VPWR.n1477 VGND 0.69968f
C3784 VPWR.n1478 VGND 0.69968f
C3785 VPWR.n1479 VGND 0.03813f
C3786 VPWR.n1480 VGND 0.01773f
C3787 VPWR.t1 VGND 0.17855f
C3788 VPWR.t2286 VGND 0.49459f
C3789 VPWR.n1481 VGND 0.07007f
C3790 VPWR.t2 VGND 0.30886f
C3791 VPWR.t202 VGND 0.3123f
C3792 VPWR.t203 VGND 0.31102f
C3793 VPWR.n1482 VGND 0.01822f
C3794 VPWR.t1031 VGND 0.1383f
C3795 VPWR.t369 VGND 0.03275f
C3796 VPWR.t1032 VGND 0.0399f
C3797 VPWR.n1483 VGND 0.04007f
C3798 VPWR.t371 VGND 0.17348f
C3799 VPWR.t370 VGND 0.1722f
C3800 VPWR.n1484 VGND 0.08081f
C3801 VPWR.n1485 VGND 0.04208f
C3802 VPWR.n1486 VGND 0.01201f
C3803 VPWR.t1034 VGND 0.0399f
C3804 VPWR.t1036 VGND 0.0399f
C3805 VPWR.t1038 VGND 0.0399f
C3806 VPWR.t655 VGND 0.03652f
C3807 VPWR.t662 VGND 0.0399f
C3808 VPWR.t1046 VGND 0.06229f
C3809 VPWR.t1044 VGND 0.05344f
C3810 VPWR.t664 VGND 0.0399f
C3811 VPWR.n1487 VGND 0.04248f
C3812 VPWR.t666 VGND 2.67628f
C3813 VPWR.t402 VGND 0.07967f
C3814 VPWR.t670 VGND 0.05822f
C3815 VPWR.t668 VGND 0.0445f
C3816 VPWR.t157 VGND 0.08208f
C3817 VPWR.t156 VGND 0.03275f
C3818 VPWR.n1489 VGND 0.04998f
C3819 VPWR.t158 VGND 0.24197f
C3820 VPWR.t403 VGND 0.77088f
C3821 VPWR.n1491 VGND 0.08774f
C3822 VPWR.t159 VGND 0.54225f
C3823 VPWR.n1492 VGND 0.1481f
C3824 VPWR.t404 VGND 0.8202f
C3825 VPWR.n1493 VGND 0.14813f
C3826 VPWR.n1494 VGND 0.12005f
C3827 VPWR.n1495 VGND 0.01207f
C3828 VPWR.t1599 VGND 0.03704f
C3829 VPWR.n1496 VGND 0.04074f
C3830 VPWR.t141 VGND 0.03275f
C3831 VPWR.n1497 VGND 0.0513f
C3832 VPWR.n1498 VGND 0.01415f
C3833 VPWR.t1600 VGND 0.03652f
C3834 VPWR.n1499 VGND 0.04074f
C3835 VPWR.t140 VGND 0.03147f
C3836 VPWR.n1500 VGND 0.08081f
C3837 VPWR.n1501 VGND 0.04208f
C3838 VPWR.n1502 VGND 0.0114f
C3839 VPWR.t162 VGND 0.03275f
C3840 VPWR.t1135 VGND 0.03649f
C3841 VPWR.t518 VGND 0.03679f
C3842 VPWR.n1503 VGND 0.09371f
C3843 VPWR.t409 VGND 3.09353f
C3844 VPWR.t512 VGND 0.0399f
C3845 VPWR.t510 VGND 0.0399f
C3846 VPWR.t504 VGND 0.05344f
C3847 VPWR.t503 VGND 0.06229f
C3848 VPWR.t218 VGND 1.06896f
C3849 VPWR.t488 VGND 0.04f
C3850 VPWR.t217 VGND 0.03276f
C3851 VPWR.t487 VGND 0.06094f
C3852 VPWR.n1506 VGND 0.04827f
C3853 VPWR.n1507 VGND 0.04431f
C3854 VPWR.t216 VGND 0.03275f
C3855 VPWR.t930 VGND 0.03652f
C3856 VPWR.t304 VGND 0.07838f
C3857 VPWR.t419 VGND 0.03147f
C3858 VPWR.t931 VGND 0.23254f
C3859 VPWR.t554 VGND 0.12768f
C3860 VPWR.t933 VGND 0.0399f
C3861 VPWR.t1224 VGND 0.08968f
C3862 VPWR.t210 VGND 0.03276f
C3863 VPWR.t935 VGND 0.0399f
C3864 VPWR.t937 VGND 0.0399f
C3865 VPWR.t211 VGND 0.03517f
C3866 VPWR.t213 VGND 0.03275f
C3867 VPWR.t214 VGND 0.03276f
C3868 VPWR.t939 VGND 0.0399f
C3869 VPWR.t941 VGND 0.0399f
C3870 VPWR.t215 VGND 0.03517f
C3871 VPWR.t945 VGND 0.05822f
C3872 VPWR.t943 VGND 0.0445f
C3873 VPWR.t220 VGND 1.06654f
C3874 VPWR.t490 VGND 0.0399f
C3875 VPWR.n1509 VGND 0.04079f
C3876 VPWR.t221 VGND 0.03275f
C3877 VPWR.t492 VGND 0.0399f
C3878 VPWR.t494 VGND 0.0399f
C3879 VPWR.t222 VGND 0.03147f
C3880 VPWR.t898 VGND 0.03652f
C3881 VPWR.t496 VGND 0.0399f
C3882 VPWR.n1511 VGND 0.03709f
C3883 VPWR.n1512 VGND 0.04726f
C3884 VPWR.n1513 VGND 0.01125f
C3885 VPWR.t899 VGND 0.0399f
C3886 VPWR.t498 VGND 0.42518f
C3887 VPWR.n1514 VGND 0.03755f
C3888 VPWR.n1515 VGND 0.03893f
C3889 VPWR.t901 VGND 0.0399f
C3890 VPWR.n1516 VGND 0.04027f
C3891 VPWR.n1517 VGND 0.01606f
C3892 VPWR.t502 VGND 0.06229f
C3893 VPWR.t500 VGND 0.05344f
C3894 VPWR.n1518 VGND 0.03054f
C3895 VPWR.n1519 VGND 0.01354f
C3896 VPWR.t903 VGND 0.0399f
C3897 VPWR.n1520 VGND 0.04825f
C3898 VPWR.t905 VGND 0.0399f
C3899 VPWR.t506 VGND 0.0399f
C3900 VPWR.n1521 VGND 0.03332f
C3901 VPWR.t907 VGND 0.0399f
C3902 VPWR.n1522 VGND 0.04248f
C3903 VPWR.n1523 VGND 0.0169f
C3904 VPWR.t909 VGND 0.0399f
C3905 VPWR.n1524 VGND 0.03332f
C3906 VPWR.n1525 VGND 0.0169f
C3907 VPWR.t508 VGND 0.0399f
C3908 VPWR.n1526 VGND 0.04248f
C3909 VPWR.t913 VGND 0.06229f
C3910 VPWR.t911 VGND 0.05344f
C3911 VPWR.t138 VGND 3.18976f
C3912 VPWR.t514 VGND 2.68438f
C3913 VPWR.t139 VGND 0.12657f
C3914 VPWR.n1528 VGND 0.04612f
C3915 VPWR.t516 VGND 0.0399f
C3916 VPWR.n1529 VGND 0.04077f
C3917 VPWR.n1530 VGND 0.01446f
C3918 VPWR.n1531 VGND 0.01853f
C3919 VPWR.n1532 VGND 0.69968f
C3920 VPWR.n1533 VGND 0.70671f
C3921 VPWR.t1001 VGND 1.57164f
C3922 VPWR.n1534 VGND 0.58956f
C3923 VPWR.n1535 VGND 0.80122f
C3924 VPWR.n1536 VGND 0.83909f
C3925 VPWR.t329 VGND 0.62235f
C3926 VPWR.t1839 VGND 0.0399f
C3927 VPWR.t486 VGND 0.03275f
C3928 VPWR.t231 VGND 0.36939f
C3929 VPWR.t1841 VGND 0.0399f
C3930 VPWR.t1843 VGND 0.04002f
C3931 VPWR.t232 VGND 0.36811f
C3932 VPWR.n1537 VGND 0.04522f
C3933 VPWR.t844 VGND 2.4067f
C3934 VPWR.n1538 VGND 0.6648f
C3935 VPWR.t767 VGND 3.4386f
C3936 VPWR.t178 VGND 0.905f
C3937 VPWR.n1539 VGND 0.80398f
C3938 VPWR.t480 VGND 2.35773f
C3939 VPWR.n1540 VGND 0.57916f
C3940 VPWR.n1541 VGND 0.42251f
C3941 VPWR.t239 VGND 0.03276f
C3942 VPWR.t255 VGND 0.03275f
C3943 VPWR.t398 VGND 0.12529f
C3944 VPWR.n1542 VGND 0.08081f
C3945 VPWR.n1543 VGND 0.04925f
C3946 VPWR.t256 VGND 0.03147f
C3947 VPWR.n1545 VGND 0.08081f
C3948 VPWR.n1546 VGND 0.04209f
C3949 VPWR.t1055 VGND 0.03652f
C3950 VPWR.n1548 VGND 0.04797f
C3951 VPWR.n1549 VGND 0.01613f
C3952 VPWR.t1056 VGND 0.0399f
C3953 VPWR.n1550 VGND 0.04051f
C3954 VPWR.t1150 VGND 0.03652f
C3955 VPWR.n1552 VGND 0.04074f
C3956 VPWR.n1553 VGND 0.01222f
C3957 VPWR.t1058 VGND 0.0399f
C3958 VPWR.n1554 VGND 0.03332f
C3959 VPWR.t1153 VGND 0.0399f
C3960 VPWR.t1060 VGND 1.86073f
C3961 VPWR.t1155 VGND 0.0399f
C3962 VPWR.t1062 VGND 0.0399f
C3963 VPWR.t1157 VGND 0.0399f
C3964 VPWR.t1159 VGND 0.0399f
C3965 VPWR.t1064 VGND 0.0399f
C3966 VPWR.t1066 VGND 0.0399f
C3967 VPWR.n1556 VGND 0.01338f
C3968 VPWR.t295 VGND 0.03275f
C3969 VPWR.t128 VGND 0.03147f
C3970 VPWR.t294 VGND 0.17911f
C3971 VPWR.t129 VGND 0.03275f
C3972 VPWR.t291 VGND 0.18153f
C3973 VPWR.t1087 VGND 0.04729f
C3974 VPWR.t1085 VGND 0.05084f
C3975 VPWR.t292 VGND 0.03276f
C3976 VPWR.t1083 VGND 0.0399f
C3977 VPWR.n1557 VGND 0.04597f
C3978 VPWR.t961 VGND 0.06229f
C3979 VPWR.t959 VGND 0.05344f
C3980 VPWR.n1559 VGND 0.03054f
C3981 VPWR.n1560 VGND 0.01334f
C3982 VPWR.t1081 VGND 0.0399f
C3983 VPWR.n1561 VGND 0.04248f
C3984 VPWR.t957 VGND 0.0399f
C3985 VPWR.t1079 VGND 0.0399f
C3986 VPWR.t955 VGND 0.0399f
C3987 VPWR.t1077 VGND 0.0399f
C3988 VPWR.n1562 VGND 0.01203f
C3989 VPWR.t1075 VGND 0.0399f
C3990 VPWR.t953 VGND 0.0399f
C3991 VPWR.n1563 VGND 0.03582f
C3992 VPWR.n1564 VGND 0.03976f
C3993 VPWR.n1565 VGND 0.01265f
C3994 VPWR.t1073 VGND 0.0399f
C3995 VPWR.t951 VGND 0.0399f
C3996 VPWR.n1566 VGND 0.03623f
C3997 VPWR.n1567 VGND 0.03878f
C3998 VPWR.n1568 VGND 0.01297f
C3999 VPWR.t1072 VGND 0.03652f
C4000 VPWR.t949 VGND 0.0399f
C4001 VPWR.n1569 VGND 0.03689f
C4002 VPWR.n1570 VGND 0.04527f
C4003 VPWR.n1571 VGND 0.01308f
C4004 VPWR.t947 VGND 0.0399f
C4005 VPWR.n1572 VGND 0.04805f
C4006 VPWR.t946 VGND 0.03652f
C4007 VPWR.t248 VGND 0.07966f
C4008 VPWR.t427 VGND 0.03275f
C4009 VPWR.t247 VGND 0.08208f
C4010 VPWR.t425 VGND 1.70922f
C4011 VPWR.n1573 VGND 0.13783f
C4012 VPWR.t443 VGND 0.03276f
C4013 VPWR.t424 VGND 1.70681f
C4014 VPWR.t442 VGND 0.2204f
C4015 VPWR.t421 VGND 0.0816f
C4016 VPWR.n1574 VGND 0.13783f
C4017 VPWR.n1575 VGND 0.06637f
C4018 VPWR.t175 VGND 0.07967f
C4019 VPWR.t420 VGND 0.0792f
C4020 VPWR.t164 VGND 0.12658f
C4021 VPWR.t897 VGND 0.04169f
C4022 VPWR.t165 VGND 0.44334f
C4023 VPWR.t895 VGND 0.0507f
C4024 VPWR.t440 VGND 0.34711f
C4025 VPWR.t893 VGND 0.0399f
C4026 VPWR.t891 VGND 0.0399f
C4027 VPWR.t1778 VGND 0.39487f
C4028 VPWR.t889 VGND 0.0399f
C4029 VPWR.t887 VGND 0.0399f
C4030 VPWR.t439 VGND 0.07966f
C4031 VPWR.t885 VGND 0.04f
C4032 VPWR.t413 VGND 0.1123f
C4033 VPWR.t883 VGND 0.0399f
C4034 VPWR.t412 VGND 0.06298f
C4035 VPWR.t866 VGND 0.03652f
C4036 VPWR.t411 VGND 1.10035f
C4037 VPWR.t365 VGND 1.48613f
C4038 VPWR.n1576 VGND 0.13783f
C4039 VPWR.t337 VGND 2.06554f
C4040 VPWR.n1577 VGND 0.0559f
C4041 VPWR.t331 VGND 2.20491f
C4042 VPWR.t364 VGND 0.41613f
C4043 VPWR.n1578 VGND 0.0497f
C4044 VPWR.t330 VGND 0.16971f
C4045 VPWR.t843 VGND 0.03577f
C4046 VPWR.n1580 VGND 0.03968f
C4047 VPWR.n1581 VGND 0.04553f
C4048 VPWR.t841 VGND 0.03992f
C4049 VPWR.t737 VGND 0.04169f
C4050 VPWR.n1582 VGND 0.01626f
C4051 VPWR.t735 VGND 0.0399f
C4052 VPWR.t840 VGND 0.03655f
C4053 VPWR.n1583 VGND 0.0796f
C4054 VPWR.n1584 VGND 0.01587f
C4055 VPWR.t733 VGND 0.0399f
C4056 VPWR.n1585 VGND 0.04011f
C4057 VPWR.t753 VGND 0.06229f
C4058 VPWR.t751 VGND 0.05344f
C4059 VPWR.n1587 VGND 0.03054f
C4060 VPWR.n1588 VGND 0.01334f
C4061 VPWR.t731 VGND 0.0399f
C4062 VPWR.n1589 VGND 0.04248f
C4063 VPWR.t749 VGND 0.0399f
C4064 VPWR.t729 VGND 0.0399f
C4065 VPWR.t747 VGND 0.0399f
C4066 VPWR.t727 VGND 0.0399f
C4067 VPWR.n1590 VGND 0.01203f
C4068 VPWR.t725 VGND 0.0399f
C4069 VPWR.t745 VGND 0.0399f
C4070 VPWR.n1591 VGND 0.03582f
C4071 VPWR.t723 VGND 0.09366f
C4072 VPWR.t743 VGND 0.0399f
C4073 VPWR.t722 VGND 0.03652f
C4074 VPWR.t741 VGND 0.0399f
C4075 VPWR.t739 VGND 0.0399f
C4076 VPWR.t280 VGND 1.66194f
C4077 VPWR.t738 VGND 0.03652f
C4078 VPWR.t278 VGND 1.75817f
C4079 VPWR.t282 VGND 0.07984f
C4080 VPWR.t277 VGND 0.12676f
C4081 VPWR.t245 VGND 0.76091f
C4082 VPWR.t1167 VGND 0.04169f
C4083 VPWR.t244 VGND 0.71159f
C4084 VPWR.t1165 VGND 0.0399f
C4085 VPWR.n1592 VGND 0.03332f
C4086 VPWR.t1070 VGND 0.04169f
C4087 VPWR.n1593 VGND 0.04075f
C4088 VPWR.t1163 VGND 0.0399f
C4089 VPWR.n1595 VGND 0.03343f
C4090 VPWR.t1068 VGND 0.0399f
C4091 VPWR.n1597 VGND 0.04471f
C4092 VPWR.t1161 VGND 0.0399f
C4093 VPWR.t397 VGND 0.12657f
C4094 VPWR.t254 VGND 0.03275f
C4095 VPWR.t396 VGND 0.03275f
C4096 VPWR.t253 VGND 0.03517f
C4097 VPWR.t394 VGND 0.03517f
C4098 VPWR.n1598 VGND 0.13783f
C4099 VPWR.t260 VGND 0.03276f
C4100 VPWR.t393 VGND 0.03276f
C4101 VPWR.t259 VGND 0.03275f
C4102 VPWR.t392 VGND 0.03275f
C4103 VPWR.t243 VGND 0.03517f
C4104 VPWR.t390 VGND 0.03517f
C4105 VPWR.n1599 VGND 0.13783f
C4106 VPWR.t242 VGND 0.03276f
C4107 VPWR.t389 VGND 0.03276f
C4108 VPWR.t241 VGND 0.03275f
C4109 VPWR.t388 VGND 0.2204f
C4110 VPWR.t238 VGND 0.03517f
C4111 VPWR.t385 VGND 0.22281f
C4112 VPWR.t406 VGND 0.03147f
C4113 VPWR.n1600 VGND 0.08877f
C4114 VPWR.t283 VGND 2.01301f
C4115 VPWR.n1601 VGND 0.01379f
C4116 VPWR.n1602 VGND 0.01344f
C4117 VPWR.t1632 VGND 0.03652f
C4118 VPWR.t1232 VGND 0.05596f
C4119 VPWR.n1604 VGND 0.04071f
C4120 VPWR.n1605 VGND 0.04863f
C4121 VPWR.t1230 VGND 0.0399f
C4122 VPWR.n1607 VGND 0.04183f
C4123 VPWR.n1608 VGND 0.01354f
C4124 VPWR.n1609 VGND 0.01606f
C4125 VPWR.t681 VGND 0.63736f
C4126 VPWR.t1226 VGND 0.0399f
C4127 VPWR.n1610 VGND 0.03893f
C4128 VPWR.n1611 VGND 0.03755f
C4129 VPWR.n1612 VGND 0.01125f
C4130 VPWR.t679 VGND 0.05414f
C4131 VPWR.t1225 VGND 0.03652f
C4132 VPWR.n1613 VGND 0.04726f
C4133 VPWR.n1614 VGND 0.03709f
C4134 VPWR.t377 VGND 0.03275f
C4135 VPWR.n1616 VGND 0.01207f
C4136 VPWR.t7 VGND 0.03276f
C4137 VPWR.n1617 VGND 0.05643f
C4138 VPWR.t6 VGND 0.07966f
C4139 VPWR.n1619 VGND 0.05919f
C4140 VPWR.n1620 VGND 0.01544f
C4141 VPWR.t695 VGND 0.0399f
C4142 VPWR.t627 VGND 0.0399f
C4143 VPWR.n1621 VGND 0.07214f
C4144 VPWR.n1622 VGND 0.01584f
C4145 VPWR.t693 VGND 0.0399f
C4146 VPWR.t625 VGND 0.0399f
C4147 VPWR.n1623 VGND 0.07177f
C4148 VPWR.n1624 VGND 0.01606f
C4149 VPWR.t690 VGND 0.03652f
C4150 VPWR.t622 VGND 0.03853f
C4151 VPWR.n1625 VGND 0.09298f
C4152 VPWR.t691 VGND 0.0399f
C4153 VPWR.t623 VGND 0.0399f
C4154 VPWR.n1626 VGND 0.07559f
C4155 VPWR.n1627 VGND 0.0122f
C4156 VPWR.t697 VGND 0.0399f
C4157 VPWR.t629 VGND 2.96092f
C4158 VPWR.n1628 VGND 0.07942f
C4159 VPWR.t699 VGND 0.0399f
C4160 VPWR.t631 VGND 0.0399f
C4161 VPWR.n1630 VGND 0.07936f
C4162 VPWR.n1631 VGND 0.01552f
C4163 VPWR.t701 VGND 0.0399f
C4164 VPWR.t633 VGND 0.0399f
C4165 VPWR.n1632 VGND 0.07206f
C4166 VPWR.n1633 VGND 0.01585f
C4167 VPWR.t703 VGND 0.0399f
C4168 VPWR.t635 VGND 0.0399f
C4169 VPWR.n1634 VGND 0.07197f
C4170 VPWR.n1635 VGND 0.01774f
C4171 VPWR.t705 VGND 0.04169f
C4172 VPWR.t637 VGND 0.04169f
C4173 VPWR.n1636 VGND 0.08665f
C4174 VPWR.t366 VGND 1.42022f
C4175 VPWR.n1637 VGND 0.05236f
C4176 VPWR.t5 VGND 1.46954f
C4177 VPWR.t520 VGND 0.2771f
C4178 VPWR.t8 VGND 0.0816f
C4179 VPWR.n1639 VGND 0.1481f
C4180 VPWR.t654 VGND 0.03669f
C4181 VPWR.n1640 VGND 0.11959f
C4182 VPWR.t373 VGND 0.07919f
C4183 VPWR.t671 VGND 0.0399f
C4184 VPWR.n1642 VGND 0.04077f
C4185 VPWR.n1643 VGND 0.04438f
C4186 VPWR.t673 VGND 0.0399f
C4187 VPWR.t374 VGND 0.03276f
C4188 VPWR.n1645 VGND 0.04675f
C4189 VPWR.n1646 VGND 0.04118f
C4190 VPWR.t375 VGND 0.03517f
C4191 VPWR.t675 VGND 0.04f
C4192 VPWR.t677 VGND 0.0399f
C4193 VPWR.t685 VGND 0.06229f
C4194 VPWR.t683 VGND 0.05344f
C4195 VPWR.n1647 VGND 0.03054f
C4196 VPWR.t1228 VGND 0.0399f
C4197 VPWR.n1648 VGND 0.04027f
C4198 VPWR.t1234 VGND 0.0399f
C4199 VPWR.t1633 VGND 0.85413f
C4200 VPWR.t1236 VGND 0.06838f
C4201 VPWR.n1650 VGND 0.03332f
C4202 VPWR.t1635 VGND 0.07201f
C4203 VPWR.n1651 VGND 0.04018f
C4204 VPWR.t1238 VGND 0.44701f
C4205 VPWR.n1653 VGND 0.03332f
C4206 VPWR.t1637 VGND 0.04067f
C4207 VPWR.n1654 VGND 0.04074f
C4208 VPWR.t1240 VGND 0.04169f
C4209 VPWR.n1656 VGND 0.04075f
C4210 VPWR.t1639 VGND 0.03652f
C4211 VPWR.n1657 VGND 0.04085f
C4212 VPWR.t405 VGND 0.03275f
C4213 VPWR.t1627 VGND 0.34124f
C4214 VPWR.t299 VGND 0.87465f
C4215 VPWR.t929 VGND 0.04169f
C4216 VPWR.n1660 VGND 0.04671f
C4217 VPWR.n1661 VGND 0.04697f
C4218 VPWR.t923 VGND 0.0399f
C4219 VPWR.t1252 VGND 0.0399f
C4220 VPWR.t1250 VGND 0.0399f
C4221 VPWR.t296 VGND 0.03147f
C4222 VPWR.n1662 VGND 0.08877f
C4223 VPWR.t1241 VGND 0.03673f
C4224 VPWR.t1242 VGND 0.0399f
C4225 VPWR.t914 VGND 0.03652f
C4226 VPWR.t1244 VGND 0.0399f
C4227 VPWR.t915 VGND 0.0399f
C4228 VPWR.t1246 VGND 0.0399f
C4229 VPWR.t917 VGND 0.0399f
C4230 VPWR.t1248 VGND 0.0399f
C4231 VPWR.t919 VGND 0.0399f
C4232 VPWR.t921 VGND 0.0399f
C4233 VPWR.t1256 VGND 0.04211f
C4234 VPWR.t927 VGND 0.0401f
C4235 VPWR.t1254 VGND 0.82148f
C4236 VPWR.t925 VGND 0.0399f
C4237 VPWR.t204 VGND 0.03276f
C4238 VPWR.t287 VGND 0.9704f
C4239 VPWR.t288 VGND 0.1261f
C4240 VPWR.t205 VGND 0.03517f
C4241 VPWR.n1663 VGND 0.13783f
C4242 VPWR.n1664 VGND 0.06654f
C4243 VPWR.n1665 VGND 0.04988f
C4244 VPWR.t289 VGND 0.03275f
C4245 VPWR.t207 VGND 0.03275f
C4246 VPWR.n1666 VGND 0.05038f
C4247 VPWR.t290 VGND 0.03147f
C4248 VPWR.n1668 VGND 0.01577f
C4249 VPWR.n1669 VGND 0.42251f
C4250 VPWR.t445 VGND 0.18327f
C4251 VPWR.t305 VGND 0.1833f
C4252 VPWR.n1670 VGND 0.12005f
C4253 VPWR.n1672 VGND 0.47594f
.ends
