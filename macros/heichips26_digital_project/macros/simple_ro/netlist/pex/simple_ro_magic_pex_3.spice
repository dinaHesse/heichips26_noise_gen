* PEX produced on Thu Aug  6 17:22:24 CEST 2026 using scripts/sak-pex.sh with m=3 and s=1 (extresist threshold=10000 mOhm, minres=1000 mOhm, mindelay=1 ps)
* NGSPICE file created from simple_ro_pex.ext - technology: ihp-sg13cmos5l

.subckt simple_ro_pex VPWR VGND enable osc
X0 VPWR VGND.t564 VPWR VPWR sg13_lv_pmos ad=0.34p pd=2.68u as=1.34658n ps=5.23481m w=1u l=1u
X1 VPWR VGND.t713 VPWR VPWR sg13_lv_pmos ad=0.19p pd=1.38u as=0 ps=0 w=1u l=1u
X2 VGND.t713 VPWR VGND.t713 VGND.t728 sg13_lv_nmos ad=0.1428p pd=1.52u as=0 ps=0 w=0.42u l=1u
X3 VGND.t314 VPWR VGND.t314 VGND.t318 sg13_lv_nmos ad=0.1428p pd=1.52u as=0 ps=0 w=0.42u l=1u
X4 VGND.t398 VPWR VGND.t398 VGND.t439 sg13_lv_nmos ad=79.8f pd=0.8u as=0 ps=0 w=0.42u l=1u
X5 VGND.t462 VPWR VGND.t462 VGND.t506 sg13_lv_nmos ad=0.1428p pd=1.52u as=0 ps=0 w=0.42u l=1u
X6 VPWR VGND.t826 VPWR VPWR sg13_lv_pmos ad=0.34p pd=2.68u as=0 ps=0 w=1u l=1u
X7 sg13cmos5l_and2_1_0.B sg13cmos5l_inv_1_1.Y VGND.t30 VGND.t32 sg13_lv_nmos ad=0.1406p pd=1.12u as=0.1406p ps=1.12u w=0.74u l=0.13u
X8 VPWR VGND.t531 VPWR VPWR sg13_lv_pmos ad=0.34p pd=2.68u as=0 ps=0 w=1u l=1u
X9 VGND.t622 VPWR VGND.t622 VGND.t625 sg13_lv_nmos ad=79.8f pd=0.8u as=0 ps=0 w=0.42u l=1u
X10 VGND.t143 VPWR VGND.t143 VGND.t142 sg13_lv_nmos ad=0.1428p pd=1.52u as=0 ps=0 w=0.42u l=1u
X11 VPWR VGND.t713 VPWR VPWR sg13_lv_pmos ad=0.19p pd=1.38u as=0 ps=0 w=1u l=1u
X12 VPWR VGND.t312 VPWR VPWR sg13_lv_pmos ad=0.19p pd=1.38u as=0 ps=0 w=1u l=1u
X13 VPWR VGND.t104 VPWR VPWR sg13_lv_pmos ad=0.19p pd=1.38u as=0 ps=0 w=1u l=1u
X14 VGND.t713 VPWR VGND.t713 VGND.t744 sg13_lv_nmos ad=0.1428p pd=1.52u as=0 ps=0 w=0.42u l=1u
X15 VPWR VGND.t28 VPWR VPWR sg13_lv_pmos ad=0.34p pd=2.68u as=0 ps=0 w=1u l=1u
X16 VPWR VGND.t314 VPWR VPWR sg13_lv_pmos ad=0.34p pd=2.68u as=0 ps=0 w=1u l=1u
X17 VPWR VGND.t574 VPWR VPWR sg13_lv_pmos ad=0.34p pd=2.68u as=0 ps=0 w=1u l=1u
X18 VGND.t64 sg13cmos5l_and2_1_0.X sg13cmos5l_inv_1_3.A VGND.t66 sg13_lv_nmos ad=0.2516p pd=2.16u as=0.1406p ps=1.12u w=0.74u l=0.13u
X19 VPWR VGND.t622 VPWR VPWR sg13_lv_pmos ad=0.19p pd=1.38u as=0 ps=0 w=1u l=1u
X20 VPWR VGND.t713 VPWR VPWR sg13_lv_pmos ad=0.34p pd=2.68u as=0 ps=0 w=1u l=1u
X21 VPWR VGND.t198 VPWR VPWR sg13_lv_pmos ad=0.34p pd=2.68u as=0 ps=0 w=1u l=1u
X22 VGND.t314 VPWR VGND.t314 VGND.t355 sg13_lv_nmos ad=0.1428p pd=1.52u as=0 ps=0 w=0.42u l=1u
X23 VGND.t393 VPWR VGND.t393 VGND.t431 sg13_lv_nmos ad=79.8f pd=0.8u as=0 ps=0 w=0.42u l=1u
X24 VPWR VGND.t802 VPWR VPWR sg13_lv_pmos ad=0.34p pd=2.68u as=0 ps=0 w=1u l=1u
X25 VPWR VGND.t713 VPWR VPWR sg13_lv_pmos ad=0.19p pd=1.38u as=0 ps=0 w=1u l=1u
X26 VPWR VGND.t474 VPWR VPWR sg13_lv_pmos ad=0.34p pd=2.68u as=0 ps=0 w=1u l=1u
X27 VGND.t104 VPWR VGND.t112 VGND.t111 sg13_lv_nmos ad=79.8f pd=0.8u as=0 ps=0 w=0.42u l=1u
X28 VPWR VGND.t622 VPWR VPWR sg13_lv_pmos ad=0.19p pd=1.38u as=0 ps=0 w=1u l=1u
X29 VPWR VGND.t713 VPWR VPWR sg13_lv_pmos ad=0.19p pd=1.38u as=0 ps=0 w=1u l=1u
X30 VGND.t375 VPWR VGND.t375 VGND.t376 sg13_lv_nmos ad=79.8f pd=0.8u as=0 ps=0 w=0.42u l=1u
X31 VPWR a_8108_14442# osc VPWR sg13_lv_pmos ad=0.2114p pd=1.54u as=0.42p ps=2.99u w=1.12u l=0.13u
X32 VGND.t449 VPWR VGND.t449 VGND.t495 sg13_lv_nmos ad=79.8f pd=0.8u as=0 ps=0 w=0.42u l=1u
X33 VGND.t488 VPWR VGND.t488 VGND.t491 sg13_lv_nmos ad=0.1428p pd=1.52u as=0 ps=0 w=0.42u l=1u
X34 VPWR VGND.t713 VPWR VPWR sg13_lv_pmos ad=0.19p pd=1.38u as=0 ps=0 w=1u l=1u
X35 VGND.t713 VPWR VGND.t713 VGND.t722 sg13_lv_nmos ad=0.1428p pd=1.52u as=0 ps=0 w=0.42u l=1u
X36 VPWR VGND.t713 VPWR VPWR sg13_lv_pmos ad=0.34p pd=2.68u as=0 ps=0 w=1u l=1u
X37 VPWR VGND.t104 VPWR VPWR sg13_lv_pmos ad=0.34p pd=2.68u as=0 ps=0 w=1u l=1u
X38 VPWR VGND.t622 VPWR VPWR sg13_lv_pmos ad=0.19p pd=1.38u as=0 ps=0 w=1u l=1u
X39 VGND.t793 VPWR VGND.t793 VGND.t792 sg13_lv_nmos ad=0.1428p pd=1.52u as=0 ps=0 w=0.42u l=1u
X40 VGND.t793 VPWR VGND.t793 VGND.t824 sg13_lv_nmos ad=0.1428p pd=1.52u as=0 ps=0 w=0.42u l=1u
X41 VGND.t484 VPWR VGND.t484 VGND.t483 sg13_lv_nmos ad=0.1428p pd=1.52u as=0 ps=0 w=0.42u l=1u
X42 VPWR VGND.t713 VPWR VPWR sg13_lv_pmos ad=0.34p pd=2.68u as=0 ps=0 w=1u l=1u
X43 VPWR VGND.t713 VPWR VPWR sg13_lv_pmos ad=0.19p pd=1.38u as=0 ps=0 w=1u l=1u
X44 VGND.t229 VPWR VGND.t229 VGND.t230 sg13_lv_nmos ad=0.1428p pd=1.52u as=0 ps=0 w=0.42u l=1u
X45 VGND.t713 VPWR VGND.t713 VGND.t730 sg13_lv_nmos ad=0.1428p pd=1.52u as=0 ps=0 w=0.42u l=1u
X46 VGND.t960 VPWR VGND.t962 VGND.t961 sg13_lv_nmos ad=79.8f pd=0.8u as=0 ps=0 w=0.42u l=1u
X47 VGND.t398 VPWR VGND.t398 VGND.t441 sg13_lv_nmos ad=79.8f pd=0.8u as=0 ps=0 w=0.42u l=1u
X48 VGND.t381 VPWR VGND.t381 VGND.t382 sg13_lv_nmos ad=0.1428p pd=1.52u as=0 ps=0 w=0.42u l=1u
X49 VGND.t793 VPWR VGND.t793 VGND.t823 sg13_lv_nmos ad=79.8f pd=0.8u as=0 ps=0 w=0.42u l=1u
X50 VGND.t1 sg13cmos5l_and2_1_0.X sg13cmos5l_inv_1_3.A VGND.t61 sg13_lv_nmos ad=0.1406p pd=1.12u as=0.1406p ps=1.12u w=0.74u l=0.13u
X51 VGND.t239 VPWR VGND.t239 VGND.t198 sg13_lv_nmos ad=79.8f pd=0.8u as=0 ps=0 w=0.42u l=1u
X52 VGND.t454 VPWR VGND.t454 VGND.t500 sg13_lv_nmos ad=0.1428p pd=1.52u as=0 ps=0 w=0.42u l=1u
X53 VPWR VGND.t793 VPWR VPWR sg13_lv_pmos ad=0.34p pd=2.68u as=0 ps=0 w=1u l=1u
X54 VGND.t324 VPWR VGND.t324 VGND.t325 sg13_lv_nmos ad=79.8f pd=0.8u as=0 ps=0 w=0.42u l=1u
X55 VGND.t713 VPWR VGND.t713 VGND.t746 sg13_lv_nmos ad=0.1428p pd=1.52u as=0 ps=0 w=0.42u l=1u
X56 sg13cmos5l_inv_1_3.A sg13cmos5l_and2_1_0.X VGND.t3 VGND.t58 sg13_lv_nmos ad=0.1406p pd=1.12u as=0.1406p ps=1.12u w=0.74u l=0.13u
X57 VPWR VGND.t531 VPWR VPWR sg13_lv_pmos ad=0.34p pd=2.68u as=0 ps=0 w=1u l=1u
X58 VGND.t198 VPWR VGND.t198 VGND.t213 sg13_lv_nmos ad=79.8f pd=0.8u as=0 ps=0 w=0.42u l=1u
X59 VPWR VGND.t64 VPWR VPWR sg13_lv_pmos ad=0.34p pd=2.68u as=0 ps=0 w=1u l=1u
X60 VGND.t41 sg13cmos5l_inv_1_1.Y sg13cmos5l_and2_1_0.B VGND.t45 sg13_lv_nmos ad=0.1406p pd=1.12u as=0.1406p ps=1.12u w=0.74u l=0.13u
X61 VGND.t30 VPWR VGND.t293 VGND.t294 sg13_lv_nmos ad=0.1428p pd=1.52u as=0 ps=0 w=0.42u l=1u
X62 VGND.t198 VPWR VGND.t198 VGND.t227 sg13_lv_nmos ad=0.1428p pd=1.52u as=0 ps=0 w=0.42u l=1u
X63 VPWR VGND.t713 VPWR VPWR sg13_lv_pmos ad=0.34p pd=2.68u as=0 ps=0 w=1u l=1u
X64 VPWR VGND.t30 VPWR VPWR sg13_lv_pmos ad=0.19p pd=1.38u as=0 ps=0 w=1u l=1u
X65 VPWR VGND.t121 VPWR VPWR sg13_lv_pmos ad=0.34p pd=2.68u as=0 ps=0 w=1u l=1u
X66 VPWR VGND.t793 VPWR VPWR sg13_lv_pmos ad=0.34p pd=2.68u as=0 ps=0 w=1u l=1u
X67 VPWR VGND.t287 VPWR VPWR sg13_lv_pmos ad=0.19p pd=1.38u as=0 ps=0 w=1u l=1u
X68 VPWR VGND.t713 VPWR VPWR sg13_lv_pmos ad=0.19p pd=1.38u as=0 ps=0 w=1u l=1u
X69 sg13cmos5l_buf_1_0.X a_808_8468# VGND.t8 VGND.t7 sg13_lv_nmos ad=0.2886p pd=2.26u as=0.14875p ps=1.16u w=0.74u l=0.13u
X70 VGND.t198 VPWR VGND.t198 VGND.t199 sg13_lv_nmos ad=0.1428p pd=1.52u as=0 ps=0 w=0.42u l=1u
X71 VGND.t393 VPWR VGND.t393 VGND.t430 sg13_lv_nmos ad=0.1428p pd=1.52u as=0 ps=0 w=0.42u l=1u
X72 VPWR VGND.t143 VPWR VPWR sg13_lv_pmos ad=0.19p pd=1.38u as=0 ps=0 w=1u l=1u
X73 VGND.t474 VPWR VGND.t474 VGND.t518 sg13_lv_nmos ad=0.1428p pd=1.52u as=0 ps=0 w=0.42u l=1u
X74 VGND.t198 VPWR VGND.t198 VGND.t211 sg13_lv_nmos ad=79.8f pd=0.8u as=0 ps=0 w=0.42u l=1u
X75 VGND.t314 VPWR VGND.t322 VGND.t360 sg13_lv_nmos ad=79.8f pd=0.8u as=0 ps=0 w=0.42u l=1u
X76 VGND.t713 VPWR VGND.t713 VGND.t724 sg13_lv_nmos ad=0.1428p pd=1.52u as=0 ps=0 w=0.42u l=1u
X77 VGND.t398 VPWR VGND.t398 VGND.t435 sg13_lv_nmos ad=79.8f pd=0.8u as=0 ps=0 w=0.42u l=1u
X78 VPWR VGND.t329 VPWR VPWR sg13_lv_pmos ad=0.34p pd=2.68u as=0 ps=0 w=1u l=1u
X79 VGND.t813 VPWR VGND.t793 VGND.t817 sg13_lv_nmos ad=79.8f pd=0.8u as=0 ps=0 w=0.42u l=1u
X80 VGND.t622 VPWR VGND.t622 VGND.t622 sg13_lv_nmos ad=79.8f pd=0.8u as=0 ps=0 w=0.42u l=1u
X81 VPWR VGND.t569 VPWR VPWR sg13_lv_pmos ad=0.34p pd=2.68u as=0 ps=0 w=1u l=1u
X82 sg13cmos5l_inv_16_2.Y sg13cmos5l_inv_16_2.A VGND.t15 VGND.t26 sg13_lv_nmos ad=0.1406p pd=1.12u as=0.1406p ps=1.12u w=0.74u l=0.13u
X83 VGND.t454 VPWR VGND.t454 VGND.t455 sg13_lv_nmos ad=79.8f pd=0.8u as=0 ps=0 w=0.42u l=1u
X84 VPWR VGND.t892 VPWR VPWR sg13_lv_pmos ad=0.19p pd=1.38u as=0 ps=0 w=1u l=1u
X85 VPWR VGND.t198 VPWR VPWR sg13_lv_pmos ad=0.34p pd=2.68u as=0 ps=0 w=1u l=1u
X86 VPWR VGND.t793 VPWR VPWR sg13_lv_pmos ad=0.34p pd=2.68u as=0 ps=0 w=1u l=1u
X87 VGND.t15 sg13cmos5l_inv_16_2.A sg13cmos5l_inv_16_2.Y VGND.t23 sg13_lv_nmos ad=0.1406p pd=1.12u as=0.1406p ps=1.12u w=0.74u l=0.13u
X88 VPWR VGND.t713 VPWR VPWR sg13_lv_pmos ad=0.34p pd=2.68u as=0 ps=0 w=1u l=1u
X89 VPWR VGND.t713 VPWR VPWR sg13_lv_pmos ad=0.19p pd=1.38u as=0 ps=0 w=1u l=1u
X90 VPWR VGND.t314 VPWR VPWR sg13_lv_pmos ad=0.19p pd=1.38u as=0 ps=0 w=1u l=1u
X91 VPWR VGND.t622 VPWR VPWR sg13_lv_pmos ad=0.19p pd=1.38u as=0 ps=0 w=1u l=1u
X92 VGND.t407 VPWR VGND.t407 VGND.t443 sg13_lv_nmos ad=79.8f pd=0.8u as=0 ps=0 w=0.42u l=1u
X93 VGND.t381 VPWR VGND.t381 VGND.t384 sg13_lv_nmos ad=0.1428p pd=1.52u as=0 ps=0 w=0.42u l=1u
X94 VGND.t112 VPWR VGND.t112 VGND.t113 sg13_lv_nmos ad=0.1428p pd=1.52u as=0 ps=0 w=0.42u l=1u
X95 VPWR VGND.t713 VPWR VPWR sg13_lv_pmos ad=0.34p pd=2.68u as=0 ps=0 w=1u l=1u
X96 sg13cmos5l_inv_16_2.Y sg13cmos5l_inv_16_2.A VGND.t15 VGND.t20 sg13_lv_nmos ad=0.1406p pd=1.12u as=0.1406p ps=1.12u w=0.74u l=0.13u
X97 VGND.t622 VPWR VGND.t622 VGND.t641 sg13_lv_nmos ad=79.8f pd=0.8u as=0 ps=0 w=0.42u l=1u
X98 VGND.t104 VPWR VGND.t104 VGND.t177 sg13_lv_nmos ad=0.1428p pd=1.52u as=0 ps=0 w=0.42u l=1u
X99 VPWR VGND.t793 VPWR VPWR sg13_lv_pmos ad=0.34p pd=2.68u as=0 ps=0 w=1u l=1u
X100 VPWR VGND.t203 VPWR VPWR sg13_lv_pmos ad=0.19p pd=1.38u as=0 ps=0 w=1u l=1u
X101 VPWR VGND.t713 VPWR VPWR sg13_lv_pmos ad=0.19p pd=1.38u as=0 ps=0 w=1u l=1u
X102 VPWR sg13cmos5l_inv_16_2.A sg13cmos5l_inv_16_2.Y VPWR sg13_lv_pmos ad=0.3808p pd=2.92u as=0.2128p ps=1.5u w=1.12u l=0.13u
X103 VGND.t3 sg13cmos5l_inv_1_3.Y sg13cmos5l_inv_1_0.A VGND.t75 sg13_lv_nmos ad=0.1406p pd=1.12u as=0.1406p ps=1.12u w=0.74u l=0.13u
X104 VGND.t713 VPWR VGND.t713 VGND.t748 sg13_lv_nmos ad=0.1428p pd=1.52u as=0 ps=0 w=0.42u l=1u
X105 sg13cmos5l_and2_1_0.B sg13cmos5l_inv_1_1.Y VPWR VPWR sg13_lv_pmos ad=0.2128p pd=1.5u as=0.2128p ps=1.5u w=1.12u l=0.13u
X106 VPWR VGND.t713 VPWR VPWR sg13_lv_pmos ad=0.34p pd=2.68u as=0 ps=0 w=1u l=1u
X107 VGND.t713 VPWR VGND.t713 VGND.t742 sg13_lv_nmos ad=0.1428p pd=1.52u as=0 ps=0 w=0.42u l=1u
X108 sg13cmos5l_inv_16_2.Y sg13cmos5l_inv_16_2.A VPWR VPWR sg13_lv_pmos ad=0.2128p pd=1.5u as=0.2128p ps=1.5u w=1.12u l=0.13u
X109 sg13cmos5l_inv_1_0.A sg13cmos5l_inv_1_3.Y VGND.t3 VGND.t72 sg13_lv_nmos ad=0.1406p pd=1.12u as=0.1406p ps=1.12u w=0.74u l=0.13u
X110 sg13cmos5l_inv_1_1.Y sg13cmos5l_inv_16_4.Y VPWR VPWR sg13_lv_pmos ad=0.3808p pd=2.92u as=0.3808p ps=2.92u w=1.12u l=0.13u
X111 VPWR VGND.t41 VPWR VPWR sg13_lv_pmos ad=0.34p pd=2.68u as=0 ps=0 w=1u l=1u
X112 VGND.t531 VPWR VGND.t531 VGND.t534 sg13_lv_nmos ad=79.8f pd=0.8u as=0 ps=0 w=0.42u l=1u
X113 VPWR VGND.t398 VPWR VPWR sg13_lv_pmos ad=0.19p pd=1.38u as=0 ps=0 w=1u l=1u
X114 VGND.t393 VPWR VGND.t393 VGND.t432 sg13_lv_nmos ad=0.1428p pd=1.52u as=0 ps=0 w=0.42u l=1u
X115 VPWR VGND.t713 VPWR VPWR sg13_lv_pmos ad=0.34p pd=2.68u as=0 ps=0 w=1u l=1u
X116 VGND.t474 VPWR VGND.t474 VGND.t520 sg13_lv_nmos ad=0.1428p pd=1.52u as=0 ps=0 w=0.42u l=1u
X117 VPWR VGND.t713 VPWR VPWR sg13_lv_pmos ad=0.19p pd=1.38u as=0 ps=0 w=1u l=1u
X118 VGND.t398 VPWR VGND.t398 VGND.t437 sg13_lv_nmos ad=79.8f pd=0.8u as=0 ps=0 w=0.42u l=1u
X119 VPWR VGND.t287 VPWR VPWR sg13_lv_pmos ad=0.19p pd=1.38u as=0 ps=0 w=1u l=1u
X120 VGND.t793 VPWR VGND.t793 VGND.t819 sg13_lv_nmos ad=79.8f pd=0.8u as=0 ps=0 w=0.42u l=1u
X121 VGND.t10 VPWR VGND.t10 VGND.t457 sg13_lv_nmos ad=79.8f pd=0.8u as=0 ps=0 w=0.42u l=1u
X122 VPWR VGND.t793 VPWR VPWR sg13_lv_pmos ad=0.19p pd=1.38u as=0 ps=0 w=1u l=1u
X123 VPWR VGND.t137 VPWR VPWR sg13_lv_pmos ad=0.19p pd=1.38u as=0 ps=0 w=1u l=1u
X124 VGND.t398 VPWR VGND.t398 VGND.t400 sg13_lv_nmos ad=79.8f pd=0.8u as=0 ps=0 w=0.42u l=1u
X125 sg13cmos5l_inv_1_3.A sg13cmos5l_and2_1_0.X VPWR VPWR sg13_lv_pmos ad=0.2128p pd=1.5u as=0.2128p ps=1.5u w=1.12u l=0.13u
X126 VPWR VGND.t329 VPWR VPWR sg13_lv_pmos ad=0.19p pd=1.38u as=0 ps=0 w=1u l=1u
X127 VGND.t64 VPWR VGND.t64 VGND.t426 sg13_lv_nmos ad=0.1428p pd=1.52u as=0 ps=0 w=0.42u l=1u
X128 VGND.t239 VPWR VGND.t239 VGND.t240 sg13_lv_nmos ad=0.1428p pd=1.52u as=0 ps=0 w=0.42u l=1u
X129 VPWR VGND.t713 VPWR VPWR sg13_lv_pmos ad=0.34p pd=2.68u as=0 ps=0 w=1u l=1u
X130 VGND.t836 VPWR VGND.t836 VGND.t838 sg13_lv_nmos ad=79.8f pd=0.8u as=0 ps=0 w=0.42u l=1u
X131 VPWR VGND.t104 VPWR VPWR sg13_lv_pmos ad=0.34p pd=2.68u as=0 ps=0 w=1u l=1u
X132 VGND.t945 VPWR VGND.t944 VGND.t943 sg13_lv_nmos ad=0.1428p pd=1.52u as=0 ps=0 w=0.42u l=1u
X133 VPWR VGND.t622 VPWR VPWR sg13_lv_pmos ad=0.19p pd=1.38u as=0 ps=0 w=1u l=1u
X134 VPWR VGND.t713 VPWR VPWR sg13_lv_pmos ad=0.34p pd=2.68u as=0 ps=0 w=1u l=1u
X135 VPWR VGND.t104 VPWR VPWR sg13_lv_pmos ad=0.34p pd=2.68u as=0 ps=0 w=1u l=1u
X136 VGND.t407 VPWR VGND.t407 VGND.t442 sg13_lv_nmos ad=0.1428p pd=1.52u as=0 ps=0 w=0.42u l=1u
X137 VGND.t30 VPWR VGND.t30 VGND.t295 sg13_lv_nmos ad=79.8f pd=0.8u as=0 ps=0 w=0.42u l=1u
X138 VPWR VGND.t713 VPWR VPWR sg13_lv_pmos ad=0.19p pd=1.38u as=0 ps=0 w=1u l=1u
X139 VGND.t198 VPWR VGND.t198 VGND.t222 sg13_lv_nmos ad=79.8f pd=0.8u as=0 ps=0 w=0.42u l=1u
X140 VGND.t713 VPWR VGND.t713 VGND.t736 sg13_lv_nmos ad=0.1428p pd=1.52u as=0 ps=0 w=0.42u l=1u
X141 sg13cmos5l_inv_1_3.A sg13cmos5l_and2_1_0.X VPWR VPWR sg13_lv_pmos ad=0.2128p pd=1.5u as=0.3808p ps=2.92u w=1.12u l=0.13u
X142 VPWR VGND.t375 VPWR VPWR sg13_lv_pmos ad=0.19p pd=1.38u as=0 ps=0 w=1u l=1u
X143 VGND.t41 VPWR VGND.t41 VGND.t302 sg13_lv_nmos ad=0.1428p pd=1.52u as=0 ps=0 w=0.42u l=1u
X144 VPWR VGND.t293 VPWR VPWR sg13_lv_pmos ad=0.19p pd=1.38u as=0 ps=0 w=1u l=1u
X145 VGND.t104 VPWR VGND.t104 VGND.t103 sg13_lv_nmos ad=0.1428p pd=1.52u as=0 ps=0 w=0.42u l=1u
X146 VGND.t826 VPWR VGND.t831 VGND.t830 sg13_lv_nmos ad=79.8f pd=0.8u as=0 ps=0 w=0.42u l=1u
X147 VGND.t104 VPWR VGND.t104 VGND.t182 sg13_lv_nmos ad=79.8f pd=0.8u as=0 ps=0 w=0.42u l=1u
X148 VPWR VGND.t324 VPWR VPWR sg13_lv_pmos ad=0.34p pd=2.68u as=0 ps=0 w=1u l=1u
X149 VPWR VGND.t121 VPWR VPWR sg13_lv_pmos ad=0.19p pd=1.38u as=0 ps=0 w=1u l=1u
X150 VPWR VGND.t713 VPWR VPWR sg13_lv_pmos ad=0.34p pd=2.68u as=0 ps=0 w=1u l=1u
X151 VPWR sg13cmos5l_inv_1_1.Y sg13cmos5l_and2_1_0.B VPWR sg13_lv_pmos ad=0.2128p pd=1.5u as=0.2128p ps=1.5u w=1.12u l=0.13u
X152 VGND.t940 VPWR VGND.t939 VGND.t938 sg13_lv_nmos ad=0.1428p pd=1.52u as=0 ps=0 w=0.42u l=1u
X153 VPWR VGND.t622 VPWR VPWR sg13_lv_pmos ad=0.19p pd=1.38u as=0 ps=0 w=1u l=1u
X154 VPWR VGND.t41 VPWR VPWR sg13_lv_pmos ad=0.19p pd=1.38u as=0 ps=0 w=1u l=1u
X155 VGND.t198 VPWR VGND.t198 VGND.t208 sg13_lv_nmos ad=0.1428p pd=1.52u as=0 ps=0 w=0.42u l=1u
X156 VPWR sg13cmos5l_inv_16_4.A sg13cmos5l_inv_16_4.Y VPWR sg13_lv_pmos ad=0.2128p pd=1.5u as=0.2128p ps=1.5u w=1.12u l=0.13u
X157 VPWR VGND.t10 VPWR VPWR sg13_lv_pmos ad=0.34p pd=2.68u as=0 ps=0 w=1u l=1u
X158 VGND.t329 VPWR VGND.t329 VGND.t368 sg13_lv_nmos ad=79.8f pd=0.8u as=0 ps=0 w=0.42u l=1u
X159 VPWR VGND.t449 VPWR VPWR sg13_lv_pmos ad=0.19p pd=1.38u as=0 ps=0 w=1u l=1u
X160 VPWR VGND.t713 VPWR VPWR sg13_lv_pmos ad=0.34p pd=2.68u as=0 ps=0 w=1u l=1u
X161 VPWR VGND.t531 VPWR VPWR sg13_lv_pmos ad=0.19p pd=1.38u as=0 ps=0 w=1u l=1u
X162 VGND.t375 VPWR VGND.t375 VGND.t379 sg13_lv_nmos ad=0.1428p pd=1.52u as=0 ps=0 w=0.42u l=1u
X163 VPWR VGND.t41 VPWR VPWR sg13_lv_pmos ad=0.19p pd=1.38u as=0 ps=0 w=1u l=1u
X164 VGND.t793 VPWR VGND.t793 VGND.t821 sg13_lv_nmos ad=79.8f pd=0.8u as=0 ps=0 w=0.42u l=1u
X165 VGND.t449 VPWR VGND.t449 VGND.t498 sg13_lv_nmos ad=0.1428p pd=1.52u as=0 ps=0 w=0.42u l=1u
X166 VPWR VGND.t793 VPWR VPWR sg13_lv_pmos ad=0.19p pd=1.38u as=0 ps=0 w=1u l=1u
X167 VPWR VGND.t622 VPWR VPWR sg13_lv_pmos ad=0.34p pd=2.68u as=0 ps=0 w=1u l=1u
X168 VGND.t64 VPWR VGND.t64 VGND.t428 sg13_lv_nmos ad=0.1428p pd=1.52u as=0 ps=0 w=0.42u l=1u
X169 VPWR VGND.t713 VPWR VPWR sg13_lv_pmos ad=0.34p pd=2.68u as=0 ps=0 w=1u l=1u
X170 VGND.t104 VPWR VGND.t104 VGND.t105 sg13_lv_nmos ad=79.8f pd=0.8u as=0 ps=0 w=0.42u l=1u
X171 VGND.t531 VPWR VGND.t531 VGND.t534 sg13_lv_nmos ad=79.8f pd=0.8u as=0 ps=0 w=0.42u l=1u
X172 VPWR VGND.t836 VPWR VPWR sg13_lv_pmos ad=0.19p pd=1.38u as=0 ps=0 w=1u l=1u
X173 VGND.t121 VPWR VGND.t121 VGND.t122 sg13_lv_nmos ad=0.1428p pd=1.52u as=0 ps=0 w=0.42u l=1u
X174 VGND.t449 VPWR VGND.t449 VGND.t452 sg13_lv_nmos ad=79.8f pd=0.8u as=0 ps=0 w=0.42u l=1u
X175 VPWR VGND.t713 VPWR VPWR sg13_lv_pmos ad=0.34p pd=2.68u as=0 ps=0 w=1u l=1u
X176 VGND.t407 VPWR VGND.t407 VGND.t444 sg13_lv_nmos ad=0.1428p pd=1.52u as=0 ps=0 w=0.42u l=1u
X177 VPWR VGND.t474 VPWR VPWR sg13_lv_pmos ad=0.19p pd=1.38u as=0 ps=0 w=1u l=1u
X178 VGND.t831 VPWR VGND.t831 VGND.t833 sg13_lv_nmos ad=79.8f pd=0.8u as=0 ps=0 w=0.42u l=1u
X179 VPWR VGND.t831 VPWR VPWR sg13_lv_pmos ad=0.19p pd=1.38u as=0 ps=0 w=1u l=1u
X180 VGND.t15 sg13cmos5l_inv_16_4.A sg13cmos5l_inv_16_4.Y VGND.t97 sg13_lv_nmos ad=0.1406p pd=1.12u as=0.1406p ps=1.12u w=0.74u l=0.13u
X181 VPWR VGND.t813 VPWR VPWR sg13_lv_pmos ad=0.19p pd=1.38u as=0 ps=0 w=1u l=1u
X182 VPWR VGND.t141 VPWR VPWR sg13_lv_pmos ad=0.19p pd=1.38u as=0 ps=0 w=1u l=1u
X183 a_8108_14442# sg13cmos5l_and2_1_0.X VGND.t5 VGND.t50 sg13_lv_nmos ad=0.187p pd=1.78u as=0.14875p ps=1.16u w=0.55u l=0.13u
X184 VPWR VGND.t793 VPWR VPWR sg13_lv_pmos ad=0.34p pd=2.68u as=0 ps=0 w=1u l=1u
X185 VGND.t622 VPWR VGND.t622 VGND.t624 sg13_lv_nmos ad=0.1428p pd=1.52u as=0 ps=0 w=0.42u l=1u
X186 VPWR VGND.t329 VPWR VPWR sg13_lv_pmos ad=0.19p pd=1.38u as=0 ps=0 w=1u l=1u
X187 VPWR VGND.t713 VPWR VPWR sg13_lv_pmos ad=0.34p pd=2.68u as=0 ps=0 w=1u l=1u
X188 VGND.t793 VPWR VGND.t793 VGND.t808 sg13_lv_nmos ad=79.8f pd=0.8u as=0 ps=0 w=0.42u l=1u
X189 VGND.t324 VPWR VGND.t324 VGND.t326 sg13_lv_nmos ad=0.1428p pd=1.52u as=0 ps=0 w=0.42u l=1u
X190 VGND.t203 VPWR VGND.t198 VGND.t207 sg13_lv_nmos ad=79.8f pd=0.8u as=0 ps=0 w=0.42u l=1u
X191 VPWR VGND.t793 VPWR VPWR sg13_lv_pmos ad=0.19p pd=1.38u as=0 ps=0 w=1u l=1u
X192 VPWR VGND.t622 VPWR VPWR sg13_lv_pmos ad=0.19p pd=1.38u as=0 ps=0 w=1u l=1u
X193 VPWR VGND.t150 VPWR VPWR sg13_lv_pmos ad=0.19p pd=1.38u as=0 ps=0 w=1u l=1u
X194 VPWR VGND.t234 VPWR VPWR sg13_lv_pmos ad=0.19p pd=1.38u as=0 ps=0 w=1u l=1u
X195 VGND.t793 VPWR VGND.t793 VGND.t820 sg13_lv_nmos ad=0.1428p pd=1.52u as=0 ps=0 w=0.42u l=1u
X196 VGND.t198 VPWR VGND.t198 VGND.t226 sg13_lv_nmos ad=79.8f pd=0.8u as=0 ps=0 w=0.42u l=1u
X197 VPWR VGND.t381 VPWR VPWR sg13_lv_pmos ad=0.34p pd=2.68u as=0 ps=0 w=1u l=1u
X198 sg13cmos5l_inv_1_0.A sg13cmos5l_inv_1_3.Y VGND.t3 VGND.t84 sg13_lv_nmos ad=0.1406p pd=1.12u as=0.1406p ps=1.12u w=0.74u l=0.13u
X199 VPWR VGND.t314 VPWR VPWR sg13_lv_pmos ad=0.34p pd=2.68u as=0 ps=0 w=1u l=1u
X200 VGND.t793 VPWR VGND.t826 VGND.t825 sg13_lv_nmos ad=79.8f pd=0.8u as=0 ps=0 w=0.42u l=1u
X201 VGND.t41 VPWR VGND.t306 VGND.t305 sg13_lv_nmos ad=79.8f pd=0.8u as=0 ps=0 w=0.42u l=1u
X202 VPWR VGND.t147 VPWR VPWR sg13_lv_pmos ad=0.34p pd=2.68u as=0 ps=0 w=1u l=1u
X203 VPWR VGND.t713 VPWR VPWR sg13_lv_pmos ad=0.34p pd=2.68u as=0 ps=0 w=1u l=1u
X204 VPWR VGND.t234 VPWR VPWR sg13_lv_pmos ad=0.34p pd=2.68u as=0 ps=0 w=1u l=1u
X205 VGND.t12 sg13cmos5l_inv_16_4.A sg13cmos5l_inv_16_4.Y VGND.t93 sg13_lv_nmos ad=0.1406p pd=1.12u as=0.1406p ps=1.12u w=0.74u l=0.13u
X206 VGND.t412 VPWR VGND.t412 VGND.t446 sg13_lv_nmos ad=0.1428p pd=1.52u as=0 ps=0 w=0.42u l=1u
X207 VPWR sg13cmos5l_inv_1_3.Y sg13cmos5l_inv_1_0.A VPWR sg13_lv_pmos ad=0.2128p pd=1.5u as=0.2128p ps=1.5u w=1.12u l=0.13u
X208 VPWR VGND.t41 VPWR VPWR sg13_lv_pmos ad=0.19p pd=1.38u as=0 ps=0 w=1u l=1u
X209 VGND.t831 VPWR VGND.t836 VGND.t835 sg13_lv_nmos ad=79.8f pd=0.8u as=0 ps=0 w=0.42u l=1u
X210 VPWR VGND.t831 VPWR VPWR sg13_lv_pmos ad=0.19p pd=1.38u as=0 ps=0 w=1u l=1u
X211 sg13cmos5l_inv_16_4.Y sg13cmos5l_inv_16_4.A VGND.t10 VGND.t90 sg13_lv_nmos ad=0.1406p pd=1.12u as=0.1406p ps=1.12u w=0.74u l=0.13u
X212 VPWR VGND.t329 VPWR VPWR sg13_lv_pmos ad=0.34p pd=2.68u as=0 ps=0 w=1u l=1u
X213 VPWR VGND.t713 VPWR VPWR sg13_lv_pmos ad=0.34p pd=2.68u as=0 ps=0 w=1u l=1u
X214 VGND.t137 VPWR VGND.t137 VGND.t138 sg13_lv_nmos ad=79.8f pd=0.8u as=0 ps=0 w=0.42u l=1u
X215 VPWR VGND.t198 VPWR VPWR sg13_lv_pmos ad=0.19p pd=1.38u as=0 ps=0 w=1u l=1u
X216 VPWR VGND.t104 VPWR VPWR sg13_lv_pmos ad=0.19p pd=1.38u as=0 ps=0 w=1u l=1u
X217 sg13cmos5l_inv_1_0.A sg13cmos5l_inv_1_3.Y VPWR VPWR sg13_lv_pmos ad=0.2128p pd=1.5u as=0.2128p ps=1.5u w=1.12u l=0.13u
X218 VPWR VGND.t793 VPWR VPWR sg13_lv_pmos ad=0.19p pd=1.38u as=0 ps=0 w=1u l=1u
X219 VPWR VGND.t622 VPWR VPWR sg13_lv_pmos ad=0.34p pd=2.68u as=0 ps=0 w=1u l=1u
X220 VPWR VGND.t314 VPWR VPWR sg13_lv_pmos ad=0.19p pd=1.38u as=0 ps=0 w=1u l=1u
X221 VGND.t308 VPWR VGND.t308 VGND.t351 sg13_lv_nmos ad=0.1428p pd=1.52u as=0 ps=0 w=0.42u l=1u
X222 VPWR VGND.t713 VPWR VPWR sg13_lv_pmos ad=0.34p pd=2.68u as=0 ps=0 w=1u l=1u
X223 VPWR VGND.t112 VPWR VPWR sg13_lv_pmos ad=0.34p pd=2.68u as=0 ps=0 w=1u l=1u
X224 VPWR VGND.t203 VPWR VPWR sg13_lv_pmos ad=0.34p pd=2.68u as=0 ps=0 w=1u l=1u
X225 VPWR sg13cmos5l_and2_1_0.X sg13cmos5l_inv_1_3.A VPWR sg13_lv_pmos ad=0.2128p pd=1.5u as=0.2128p ps=1.5u w=1.12u l=0.13u
X226 VPWR VGND.t793 VPWR VPWR sg13_lv_pmos ad=0.19p pd=1.38u as=0 ps=0 w=1u l=1u
X227 VGND.t895 VPWR VGND.t894 VGND.t893 sg13_lv_nmos ad=0.1428p pd=1.52u as=0 ps=0 w=0.42u l=1u
X228 VPWR VGND.t449 VPWR VPWR sg13_lv_pmos ad=0.34p pd=2.68u as=0 ps=0 w=1u l=1u
X229 VGND.t793 VPWR VGND.t793 VGND.t822 sg13_lv_nmos ad=0.1428p pd=1.52u as=0 ps=0 w=0.42u l=1u
X230 VGND.t329 VPWR VGND.t329 VGND.t287 sg13_lv_nmos ad=0.1428p pd=1.52u as=0 ps=0 w=0.42u l=1u
X231 VGND.t836 VPWR VGND.t836 VGND.t793 sg13_lv_nmos ad=79.8f pd=0.8u as=0 ps=0 w=0.42u l=1u
X232 VPWR VGND.t793 VPWR VPWR sg13_lv_pmos ad=0.34p pd=2.68u as=0 ps=0 w=1u l=1u
X233 VPWR VGND.t468 VPWR VPWR sg13_lv_pmos ad=0.19p pd=1.38u as=0 ps=0 w=1u l=1u
X234 VGND.t488 VPWR VGND.t488 VGND.t493 sg13_lv_nmos ad=0.1428p pd=1.52u as=0 ps=0 w=0.42u l=1u
X235 VGND.t826 VPWR VGND.t826 VGND.t828 sg13_lv_nmos ad=79.8f pd=0.8u as=0 ps=0 w=0.42u l=1u
X236 VPWR VGND.t531 VPWR VPWR sg13_lv_pmos ad=0.19p pd=1.38u as=0 ps=0 w=1u l=1u
X237 VPWR VGND.t826 VPWR VPWR sg13_lv_pmos ad=0.19p pd=1.38u as=0 ps=0 w=1u l=1u
X238 VGND.t398 VPWR VGND.t398 VGND.t403 sg13_lv_nmos ad=0.1428p pd=1.52u as=0 ps=0 w=0.42u l=1u
X239 VGND.t375 VPWR VGND.t375 VGND.t374 sg13_lv_nmos ad=0.1428p pd=1.52u as=0 ps=0 w=0.42u l=1u
X240 VPWR VGND.t287 VPWR VPWR sg13_lv_pmos ad=0.34p pd=2.68u as=0 ps=0 w=1u l=1u
X241 VGND.t398 VPWR VGND.t398 VGND.t434 sg13_lv_nmos ad=0.1428p pd=1.52u as=0 ps=0 w=0.42u l=1u
X242 VGND.t813 VPWR VGND.t813 VGND.t816 sg13_lv_nmos ad=0.1428p pd=1.52u as=0 ps=0 w=0.42u l=1u
X243 VGND.t449 VPWR VGND.t8 VGND.t494 sg13_lv_nmos ad=0.1428p pd=1.52u as=0 ps=0 w=0.42u l=1u
X244 VGND.t454 VPWR VGND.t454 VGND.t453 sg13_lv_nmos ad=0.1428p pd=1.52u as=0 ps=0 w=0.42u l=1u
X245 sg13cmos5l_inv_1_0.A sg13cmos5l_inv_1_3.Y VPWR VPWR sg13_lv_pmos ad=0.2128p pd=1.5u as=0.2128p ps=1.5u w=1.12u l=0.13u
X246 VPWR VGND.t574 VPWR VPWR sg13_lv_pmos ad=0.19p pd=1.38u as=0 ps=0 w=1u l=1u
X247 sg13cmos5l_inv_16_4.Y sg13cmos5l_inv_16_4.A VPWR VPWR sg13_lv_pmos ad=0.2128p pd=1.5u as=0.2128p ps=1.5u w=1.12u l=0.13u
X248 VGND.t813 VPWR VGND.t813 VGND.t815 sg13_lv_nmos ad=79.8f pd=0.8u as=0 ps=0 w=0.42u l=1u
X249 VPWR VGND.t713 VPWR VPWR sg13_lv_pmos ad=0.19p pd=1.38u as=0 ps=0 w=1u l=1u
X250 VGND.t474 VPWR VGND.t474 VGND.t515 sg13_lv_nmos ad=79.8f pd=0.8u as=0 ps=0 w=0.42u l=1u
X251 VPWR VGND.t802 VPWR VPWR sg13_lv_pmos ad=0.19p pd=1.38u as=0 ps=0 w=1u l=1u
X252 VGND.t965 VPWR VGND.t964 VGND.t963 sg13_lv_nmos ad=0.1428p pd=1.52u as=0 ps=0 w=0.42u l=1u
X253 VGND.t831 VPWR VGND.t831 VGND.t834 sg13_lv_nmos ad=0.1428p pd=1.52u as=0 ps=0 w=0.42u l=1u
X254 VPWR VGND.t793 VPWR VPWR sg13_lv_pmos ad=0.19p pd=1.38u as=0 ps=0 w=1u l=1u
X255 VGND.t287 VPWR VGND.t287 VGND.t290 sg13_lv_nmos ad=79.8f pd=0.8u as=0 ps=0 w=0.42u l=1u
X256 VPWR VGND.t622 VPWR VPWR sg13_lv_pmos ad=0.34p pd=2.68u as=0 ps=0 w=1u l=1u
X257 VGND.t707 VPWR VGND.t707 VGND.t710 sg13_lv_nmos ad=79.8f pd=0.8u as=0 ps=0 w=0.42u l=1u
X258 VGND.t287 VPWR VGND.t287 VGND.t288 sg13_lv_nmos ad=79.8f pd=0.8u as=0 ps=0 w=0.42u l=1u
X259 VPWR VGND.t713 VPWR VPWR sg13_lv_pmos ad=0.34p pd=2.68u as=0 ps=0 w=1u l=1u
X260 VPWR VGND.t551 VPWR VPWR sg13_lv_pmos ad=0.19p pd=1.38u as=0 ps=0 w=1u l=1u
X261 VGND.t329 VPWR VGND.t329 VGND.t335 sg13_lv_nmos ad=0.1428p pd=1.52u as=0 ps=0 w=0.42u l=1u
X262 VPWR VGND.t836 VPWR VPWR sg13_lv_pmos ad=0.19p pd=1.38u as=0 ps=0 w=1u l=1u
X263 VPWR VGND.t393 VPWR VPWR sg13_lv_pmos ad=0.34p pd=2.68u as=0 ps=0 w=1u l=1u
X264 sg13cmos5l_buf_1_0.X a_808_8468# VPWR VPWR sg13_lv_pmos ad=0.42p pd=2.99u as=0.2114p ps=1.54u w=1.12u l=0.13u
X265 VPWR VGND.t104 VPWR VPWR sg13_lv_pmos ad=0.34p pd=2.68u as=0 ps=0 w=1u l=1u
X266 VPWR VGND.t28 VPWR VPWR sg13_lv_pmos ad=0.19p pd=1.38u as=0 ps=0 w=1u l=1u
X267 VPWR VGND.t488 VPWR VPWR sg13_lv_pmos ad=0.19p pd=1.38u as=0 ps=0 w=1u l=1u
X268 VGND.t137 VPWR VGND.t104 VGND.t183 sg13_lv_nmos ad=0.1428p pd=1.52u as=0 ps=0 w=0.42u l=1u
X269 VGND.t793 VPWR VGND.t793 VGND.t809 sg13_lv_nmos ad=0.1428p pd=1.52u as=0 ps=0 w=0.42u l=1u
X270 VGND.t622 VPWR VGND.t622 VGND.t656 sg13_lv_nmos ad=0.1428p pd=1.52u as=0 ps=0 w=0.42u l=1u
X271 VPWR VGND.t793 VPWR VPWR sg13_lv_pmos ad=0.34p pd=2.68u as=0 ps=0 w=1u l=1u
X272 VPWR VGND.t112 VPWR VPWR sg13_lv_pmos ad=0.19p pd=1.38u as=0 ps=0 w=1u l=1u
X273 VPWR VGND.t472 VPWR VPWR sg13_lv_pmos ad=0.19p pd=1.38u as=0 ps=0 w=1u l=1u
X274 VPWR VGND.t196 VPWR VPWR sg13_lv_pmos ad=0.34p pd=2.68u as=0 ps=0 w=1u l=1u
X275 VPWR VGND.t826 VPWR VPWR sg13_lv_pmos ad=0.19p pd=1.38u as=0 ps=0 w=1u l=1u
X276 VGND.t531 VPWR VGND.t531 VGND.t533 sg13_lv_nmos ad=0.1428p pd=1.52u as=0 ps=0 w=0.42u l=1u
X277 VGND.t314 VPWR VGND.t314 VGND.t317 sg13_lv_nmos ad=79.8f pd=0.8u as=0 ps=0 w=0.42u l=1u
X278 VGND.t198 VPWR VGND.t198 VGND.t201 sg13_lv_nmos ad=0.1428p pd=1.52u as=0 ps=0 w=0.42u l=1u
X279 VPWR VGND.t831 VPWR VPWR sg13_lv_pmos ad=0.19p pd=1.38u as=0 ps=0 w=1u l=1u
X280 VGND.t462 VPWR VGND.t466 VGND.t509 sg13_lv_nmos ad=79.8f pd=0.8u as=0 ps=0 w=0.42u l=1u
X281 VPWR VGND.t198 VPWR VPWR sg13_lv_pmos ad=0.34p pd=2.68u as=0 ps=0 w=1u l=1u
X282 VGND.t329 VPWR VGND.t329 VGND.t369 sg13_lv_nmos ad=0.1428p pd=1.52u as=0 ps=0 w=0.42u l=1u
X283 VGND.t198 VPWR VGND.t198 VGND.t221 sg13_lv_nmos ad=0.1428p pd=1.52u as=0 ps=0 w=0.42u l=1u
X284 VGND.t137 VPWR VGND.t141 VGND.t140 sg13_lv_nmos ad=79.8f pd=0.8u as=0 ps=0 w=0.42u l=1u
X285 VPWR VGND.t813 VPWR VPWR sg13_lv_pmos ad=0.19p pd=1.38u as=0 ps=0 w=1u l=1u
X286 VGND.t104 VPWR VGND.t121 VGND.t120 sg13_lv_nmos ad=79.8f pd=0.8u as=0 ps=0 w=0.42u l=1u
X287 VGND.t793 VPWR VGND.t793 VGND.t818 sg13_lv_nmos ad=0.1428p pd=1.52u as=0 ps=0 w=0.42u l=1u
X288 VGND.t10 VPWR VGND.t10 VGND.t456 sg13_lv_nmos ad=0.1428p pd=1.52u as=0 ps=0 w=0.42u l=1u
X289 VPWR VGND.t813 VPWR VPWR sg13_lv_pmos ad=0.34p pd=2.68u as=0 ps=0 w=1u l=1u
X290 VPWR VGND.t462 VPWR VPWR sg13_lv_pmos ad=0.19p pd=1.38u as=0 ps=0 w=1u l=1u
X291 VPWR sg13cmos5l_inv_16_4.A sg13cmos5l_inv_16_4.Y VPWR sg13_lv_pmos ad=0.2128p pd=1.5u as=0.2128p ps=1.5u w=1.12u l=0.13u
X292 VGND.t930 VPWR VGND.t932 VGND.t931 sg13_lv_nmos ad=79.8f pd=0.8u as=0 ps=0 w=0.42u l=1u
X293 VGND.t147 VPWR VGND.t150 VGND.t149 sg13_lv_nmos ad=79.8f pd=0.8u as=0 ps=0 w=0.42u l=1u
X294 VGND.t314 VPWR VGND.t314 VGND.t354 sg13_lv_nmos ad=79.8f pd=0.8u as=0 ps=0 w=0.42u l=1u
X295 VGND.t836 VPWR VGND.t836 VGND.t837 sg13_lv_nmos ad=0.1428p pd=1.52u as=0 ps=0 w=0.42u l=1u
X296 VGND.t104 VPWR VGND.t104 VGND.t106 sg13_lv_nmos ad=0.1428p pd=1.52u as=0 ps=0 w=0.42u l=1u
X297 VPWR VGND.t831 VPWR VPWR sg13_lv_pmos ad=0.34p pd=2.68u as=0 ps=0 w=1u l=1u
X298 VPWR VGND.t793 VPWR VPWR sg13_lv_pmos ad=0.19p pd=1.38u as=0 ps=0 w=1u l=1u
X299 VPWR VGND.t484 VPWR VPWR sg13_lv_pmos ad=0.19p pd=1.38u as=0 ps=0 w=1u l=1u
X300 VPWR VGND.t198 VPWR VPWR sg13_lv_pmos ad=0.34p pd=2.68u as=0 ps=0 w=1u l=1u
X301 VGND.t324 VPWR VGND.t287 VGND.t327 sg13_lv_nmos ad=79.8f pd=0.8u as=0 ps=0 w=0.42u l=1u
X302 sg13cmos5l_inv_16_4.Y sg13cmos5l_inv_16_4.A VGND.t15 VGND.t100 sg13_lv_nmos ad=0.1406p pd=1.12u as=0.1406p ps=1.12u w=0.74u l=0.13u
X303 VGND.t793 VPWR VGND.t793 VGND.t811 sg13_lv_nmos ad=0.1428p pd=1.52u as=0 ps=0 w=0.42u l=1u
X304 VGND.t449 VPWR VGND.t449 VGND.t448 sg13_lv_nmos ad=0.1428p pd=1.52u as=0 ps=0 w=0.42u l=1u
X305 VPWR VGND.t793 VPWR VPWR sg13_lv_pmos ad=0.34p pd=2.68u as=0 ps=0 w=1u l=1u
X306 VGND.t329 VPWR VGND.t329 VGND.t334 sg13_lv_nmos ad=79.8f pd=0.8u as=0 ps=0 w=0.42u l=1u
X307 VPWR VGND.t574 VPWR VPWR sg13_lv_pmos ad=0.19p pd=1.38u as=0 ps=0 w=1u l=1u
X308 VGND.t234 VPWR VGND.t234 VGND.t237 sg13_lv_nmos ad=0.1428p pd=1.52u as=0 ps=0 w=0.42u l=1u
X309 VGND.t34 sg13cmos5l_inv_1_1.Y sg13cmos5l_and2_1_0.B VGND.t38 sg13_lv_nmos ad=0.1406p pd=1.12u as=0.1406p ps=1.12u w=0.74u l=0.13u
X310 VPWR VGND.t104 VPWR VPWR sg13_lv_pmos ad=0.19p pd=1.38u as=0 ps=0 w=1u l=1u
X311 VPWR VGND.t831 VPWR VPWR sg13_lv_pmos ad=0.19p pd=1.38u as=0 ps=0 w=1u l=1u
X312 VGND.t468 VPWR VGND.t468 VGND.t511 sg13_lv_nmos ad=79.8f pd=0.8u as=0 ps=0 w=0.42u l=1u
X313 VGND.t234 VPWR VGND.t234 VGND.t235 sg13_lv_nmos ad=0.1428p pd=1.52u as=0 ps=0 w=0.42u l=1u
X314 VGND.t713 VPWR VGND.t713 VGND.t713 sg13_lv_nmos ad=79.8f pd=0.8u as=0 ps=0 w=0.42u l=1u
X315 VPWR VGND.t622 VPWR VPWR sg13_lv_pmos ad=0.34p pd=2.68u as=0 ps=0 w=1u l=1u
X316 VPWR VGND.t229 VPWR VPWR sg13_lv_pmos ad=0.19p pd=1.38u as=0 ps=0 w=1u l=1u
X317 VGND.t287 VPWR VGND.t293 VGND.t292 sg13_lv_nmos ad=79.8f pd=0.8u as=0 ps=0 w=0.42u l=1u
X318 VGND.t488 VPWR VGND.t488 VGND.t527 sg13_lv_nmos ad=79.8f pd=0.8u as=0 ps=0 w=0.42u l=1u
X319 VGND.t216 VPWR VGND.t198 VGND.t220 sg13_lv_nmos ad=79.8f pd=0.8u as=0 ps=0 w=0.42u l=1u
X320 VPWR VGND.t287 VPWR VPWR sg13_lv_pmos ad=0.34p pd=2.68u as=0 ps=0 w=1u l=1u
X321 VGND.t836 VPWR VGND.t836 VGND.t839 sg13_lv_nmos ad=0.1428p pd=1.52u as=0 ps=0 w=0.42u l=1u
X322 VGND.t216 VPWR VGND.t216 VGND.t218 sg13_lv_nmos ad=79.8f pd=0.8u as=0 ps=0 w=0.42u l=1u
X323 VGND.t531 VPWR VGND.t531 VGND.t533 sg13_lv_nmos ad=0.1428p pd=1.52u as=0 ps=0 w=0.42u l=1u
X324 VPWR VGND.t836 VPWR VPWR sg13_lv_pmos ad=0.34p pd=2.68u as=0 ps=0 w=1u l=1u
X325 VPWR VGND.t793 VPWR VPWR sg13_lv_pmos ad=0.19p pd=1.38u as=0 ps=0 w=1u l=1u
X326 VGND.t34 VPWR VGND.t41 VGND.t299 sg13_lv_nmos ad=79.8f pd=0.8u as=0 ps=0 w=0.42u l=1u
X327 VPWR VGND.t488 VPWR VPWR sg13_lv_pmos ad=0.19p pd=1.38u as=0 ps=0 w=1u l=1u
X328 VGND.t935 VPWR VGND.t937 VGND.t936 sg13_lv_nmos ad=79.8f pd=0.8u as=0 ps=0 w=0.42u l=1u
X329 VGND.t3 sg13cmos5l_and2_1_0.X sg13cmos5l_inv_1_3.A VGND.t53 sg13_lv_nmos ad=0.1406p pd=1.12u as=0.1406p ps=1.12u w=0.74u l=0.13u
X330 VPWR VGND.t137 VPWR VPWR sg13_lv_pmos ad=0.34p pd=2.68u as=0 ps=0 w=1u l=1u
X331 VGND.t203 VPWR VGND.t203 VGND.t206 sg13_lv_nmos ad=0.1428p pd=1.52u as=0 ps=0 w=0.42u l=1u
X332 VPWR VGND.t793 VPWR VPWR sg13_lv_pmos ad=0.34p pd=2.68u as=0 ps=0 w=1u l=1u
X333 VGND.t474 VPWR VGND.t482 VGND.t521 sg13_lv_nmos ad=79.8f pd=0.8u as=0 ps=0 w=0.42u l=1u
X334 VGND.t713 VPWR VGND.t713 VGND.t727 sg13_lv_nmos ad=79.8f pd=0.8u as=0 ps=0 w=0.42u l=1u
X335 VPWR VGND.t826 VPWR VPWR sg13_lv_pmos ad=0.19p pd=1.38u as=0 ps=0 w=1u l=1u
X336 VPWR VGND.t30 VPWR VPWR sg13_lv_pmos ad=0.19p pd=1.38u as=0 ps=0 w=1u l=1u
X337 sg13cmos5l_inv_1_3.A sg13cmos5l_and2_1_0.X VGND.t3 VGND.t49 sg13_lv_nmos ad=0.1406p pd=1.12u as=0.2516p ps=2.16u w=0.74u l=0.13u
X338 VGND.t147 VPWR VGND.t147 VGND.t191 sg13_lv_nmos ad=0.1428p pd=1.52u as=0 ps=0 w=0.42u l=1u
X339 VPWR VGND.t454 VPWR VPWR sg13_lv_pmos ad=0.19p pd=1.38u as=0 ps=0 w=1u l=1u
X340 VPWR VGND.t198 VPWR VPWR sg13_lv_pmos ad=0.19p pd=1.38u as=0 ps=0 w=1u l=1u
X341 sg13cmos5l_and2_1_0.B sg13cmos5l_inv_1_1.Y VGND.t41 VGND.t42 sg13_lv_nmos ad=0.1406p pd=1.12u as=0.1406p ps=1.12u w=0.74u l=0.13u
X342 VPWR VGND.t121 VPWR VPWR sg13_lv_pmos ad=0.19p pd=1.38u as=0 ps=0 w=1u l=1u
X343 VPWR VGND.t793 VPWR VPWR sg13_lv_pmos ad=0.34p pd=2.68u as=0 ps=0 w=1u l=1u
X344 VPWR VGND.t713 VPWR VPWR sg13_lv_pmos ad=0.19p pd=1.38u as=0 ps=0 w=1u l=1u
X345 VGND.t468 VPWR VGND.t472 VGND.t513 sg13_lv_nmos ad=79.8f pd=0.8u as=0 ps=0 w=0.42u l=1u
X346 VGND.t104 VPWR VGND.t112 VGND.t111 sg13_lv_nmos ad=79.8f pd=0.8u as=0 ps=0 w=0.42u l=1u
X347 VPWR VGND.t713 VPWR VPWR sg13_lv_pmos ad=0.19p pd=1.38u as=0 ps=0 w=1u l=1u
X348 VGND.t104 VPWR VGND.t104 VGND.t176 sg13_lv_nmos ad=79.8f pd=0.8u as=0 ps=0 w=0.42u l=1u
X349 VPWR VGND.t826 VPWR VPWR sg13_lv_pmos ad=0.34p pd=2.68u as=0 ps=0 w=1u l=1u
X350 VPWR VGND.t802 VPWR VPWR sg13_lv_pmos ad=0.19p pd=1.38u as=0 ps=0 w=1u l=1u
X351 VPWR VGND.t314 VPWR VPWR sg13_lv_pmos ad=0.34p pd=2.68u as=0 ps=0 w=1u l=1u
X352 VPWR VGND.t104 VPWR VPWR sg13_lv_pmos ad=0.34p pd=2.68u as=0 ps=0 w=1u l=1u
X353 VPWR VGND.t198 VPWR VPWR sg13_lv_pmos ad=0.34p pd=2.68u as=0 ps=0 w=1u l=1u
X354 VPWR VGND.t407 VPWR VPWR sg13_lv_pmos ad=0.19p pd=1.38u as=0 ps=0 w=1u l=1u
X355 sg13cmos5l_inv_16_2.Y sg13cmos5l_inv_16_2.A VGND.t15 VGND.t18 sg13_lv_nmos ad=0.1406p pd=1.12u as=0.1406p ps=1.12u w=0.74u l=0.13u
X356 VGND.t985 VPWR VGND.t984 VGND.t983 sg13_lv_nmos ad=0.1428p pd=1.52u as=0 ps=0 w=0.42u l=1u
X357 VPWR VGND.t713 VPWR VPWR sg13_lv_pmos ad=0.19p pd=1.38u as=0 ps=0 w=1u l=1u
X358 VPWR VGND.t462 VPWR VPWR sg13_lv_pmos ad=0.34p pd=2.68u as=0 ps=0 w=1u l=1u
X359 VGND.t104 VPWR VGND.t104 VGND.t128 sg13_lv_nmos ad=0.1428p pd=1.52u as=0 ps=0 w=0.42u l=1u
X360 VGND.t15 sg13cmos5l_inv_16_2.A sg13cmos5l_inv_16_2.Y VGND.t14 sg13_lv_nmos ad=0.1406p pd=1.12u as=0.1406p ps=1.12u w=0.74u l=0.13u
X361 VGND.t112 VPWR VGND.t112 VGND.t115 sg13_lv_nmos ad=0.1428p pd=1.52u as=0 ps=0 w=0.42u l=1u
X362 VGND.t793 VPWR VGND.t793 VGND.t824 sg13_lv_nmos ad=0.1428p pd=1.52u as=0 ps=0 w=0.42u l=1u
X363 VPWR VGND.t836 VPWR VPWR sg13_lv_pmos ad=0.34p pd=2.68u as=0 ps=0 w=1u l=1u
X364 sg13cmos5l_inv_1_0.A sg13cmos5l_inv_1_3.Y VGND.t3 VGND.t70 sg13_lv_nmos ad=0.1406p pd=1.12u as=0.2516p ps=2.16u w=0.74u l=0.13u
X365 VPWR VGND.t793 VPWR VPWR sg13_lv_pmos ad=0.34p pd=2.68u as=0 ps=0 w=1u l=1u
X366 VGND.t622 VPWR VGND.t622 VGND.t637 sg13_lv_nmos ad=79.8f pd=0.8u as=0 ps=0 w=0.42u l=1u
X367 VGND.t484 VPWR VGND.t484 VGND.t523 sg13_lv_nmos ad=79.8f pd=0.8u as=0 ps=0 w=0.42u l=1u
X368 VGND.t329 VPWR VGND.t329 VGND.t336 sg13_lv_nmos ad=79.8f pd=0.8u as=0 ps=0 w=0.42u l=1u
X369 VPWR VGND.t826 VPWR VPWR sg13_lv_pmos ad=0.19p pd=1.38u as=0 ps=0 w=1u l=1u
X370 VPWR VGND.t622 VPWR VPWR sg13_lv_pmos ad=0.19p pd=1.38u as=0 ps=0 w=1u l=1u
X371 VPWR VGND.t3 VPWR VPWR sg13_lv_pmos ad=0.34p pd=2.68u as=0 ps=0 w=1u l=1u
X372 VPWR sg13cmos5l_inv_16_4.A sg13cmos5l_inv_16_4.Y VPWR sg13_lv_pmos ad=0.2128p pd=1.5u as=0.2128p ps=1.5u w=1.12u l=0.13u
X373 VPWR VGND.t531 VPWR VPWR sg13_lv_pmos ad=0.34p pd=2.68u as=0 ps=0 w=1u l=1u
X374 VGND.t196 VPWR VGND.t196 VGND.t195 sg13_lv_nmos ad=0.1428p pd=1.52u as=0 ps=0 w=0.42u l=1u
X375 VGND.t915 VPWR VGND.t914 VGND.t913 sg13_lv_nmos ad=0.1428p pd=1.52u as=0 ps=0 w=0.42u l=1u
X376 VGND.t234 VPWR VGND.t239 VGND.t238 sg13_lv_nmos ad=79.8f pd=0.8u as=0 ps=0 w=0.42u l=1u
X377 VPWR VGND.t104 VPWR VPWR sg13_lv_pmos ad=0.19p pd=1.38u as=0 ps=0 w=1u l=1u
X378 VPWR VGND.t813 VPWR VPWR sg13_lv_pmos ad=0.34p pd=2.68u as=0 ps=0 w=1u l=1u
X379 VGND.t314 VPWR VGND.t314 VGND.t320 sg13_lv_nmos ad=0.1428p pd=1.52u as=0 ps=0 w=0.42u l=1u
X380 VPWR VGND.t462 VPWR VPWR sg13_lv_pmos ad=0.34p pd=2.68u as=0 ps=0 w=1u l=1u
X381 VGND.t198 VPWR VGND.t198 VGND.t210 sg13_lv_nmos ad=0.1428p pd=1.52u as=0 ps=0 w=0.42u l=1u
X382 a_8108_14442# sg13cmos5l_and2_1_0.X VPWR VPWR sg13_lv_pmos ad=0.2856p pd=2.36u as=0.2114p ps=1.54u w=0.84u l=0.13u
X383 sg13cmos5l_and2_1_0.X a_3885_9540# VGND.t3 VGND.t2 sg13_lv_nmos ad=0.2516p pd=2.16u as=0.1331p ps=1.12u w=0.74u l=0.13u
X384 VPWR VGND.t375 VPWR VPWR sg13_lv_pmos ad=0.19p pd=1.38u as=0 ps=0 w=1u l=1u
X385 VPWR sg13cmos5l_inv_1_1.Y sg13cmos5l_and2_1_0.B VPWR sg13_lv_pmos ad=0.2128p pd=1.5u as=0.2128p ps=1.5u w=1.12u l=0.13u
X386 VGND.t287 VPWR VGND.t287 VGND.t289 sg13_lv_nmos ad=0.1428p pd=1.52u as=0 ps=0 w=0.42u l=1u
X387 VGND.t468 VPWR VGND.t468 VGND.t512 sg13_lv_nmos ad=0.1428p pd=1.52u as=0 ps=0 w=0.42u l=1u
X388 VGND.t216 VPWR VGND.t216 VGND.t217 sg13_lv_nmos ad=0.1428p pd=1.52u as=0 ps=0 w=0.42u l=1u
X389 VPWR VGND.t831 VPWR VPWR sg13_lv_pmos ad=0.34p pd=2.68u as=0 ps=0 w=1u l=1u
X390 VPWR VGND.t239 VPWR VPWR sg13_lv_pmos ad=0.19p pd=1.38u as=0 ps=0 w=1u l=1u
X391 VGND.t955 VPWR VGND.t957 VGND.t956 sg13_lv_nmos ad=79.8f pd=0.8u as=0 ps=0 w=0.42u l=1u
X392 VGND.t41 VPWR VGND.t41 VGND.t301 sg13_lv_nmos ad=79.8f pd=0.8u as=0 ps=0 w=0.42u l=1u
X393 VGND.t622 VPWR VGND.t622 VGND.t631 sg13_lv_nmos ad=79.8f pd=0.8u as=0 ps=0 w=0.42u l=1u
X394 VGND.t474 VPWR VGND.t474 VGND.t517 sg13_lv_nmos ad=79.8f pd=0.8u as=0 ps=0 w=0.42u l=1u
X395 VPWR VGND.t141 VPWR VPWR sg13_lv_pmos ad=0.34p pd=2.68u as=0 ps=0 w=1u l=1u
X396 VPWR VGND.t322 VPWR VPWR sg13_lv_pmos ad=0.19p pd=1.38u as=0 ps=0 w=1u l=1u
X397 VPWR VGND.t468 VPWR VPWR sg13_lv_pmos ad=0.34p pd=2.68u as=0 ps=0 w=1u l=1u
X398 VPWR sg13cmos5l_and2_1_0.X sg13cmos5l_inv_1_3.A VPWR sg13_lv_pmos ad=0.2128p pd=1.5u as=0.2128p ps=1.5u w=1.12u l=0.13u
X399 VPWR VGND.t793 VPWR VPWR sg13_lv_pmos ad=0.34p pd=2.68u as=0 ps=0 w=1u l=1u
X400 VPWR VGND.t449 VPWR VPWR sg13_lv_pmos ad=0.19p pd=1.38u as=0 ps=0 w=1u l=1u
X401 VGND.t324 VPWR VGND.t324 VGND.t363 sg13_lv_nmos ad=0.1428p pd=1.52u as=0 ps=0 w=0.42u l=1u
X402 VGND.t198 VPWR VGND.t198 VGND.t214 sg13_lv_nmos ad=0.1428p pd=1.52u as=0 ps=0 w=0.42u l=1u
X403 VGND.t104 VPWR VGND.t104 VGND.t133 sg13_lv_nmos ad=79.8f pd=0.8u as=0 ps=0 w=0.42u l=1u
X404 VPWR VGND.t713 VPWR VPWR sg13_lv_pmos ad=0.19p pd=1.38u as=0 ps=0 w=1u l=1u
X405 VGND.t622 VPWR VGND.t622 VGND.t639 sg13_lv_nmos ad=79.8f pd=0.8u as=0 ps=0 w=0.42u l=1u
X406 VGND.t488 VPWR VGND.t488 VGND.t525 sg13_lv_nmos ad=79.8f pd=0.8u as=0 ps=0 w=0.42u l=1u
X407 VGND.t112 VPWR VGND.t112 VGND.t114 sg13_lv_nmos ad=79.8f pd=0.8u as=0 ps=0 w=0.42u l=1u
X408 VPWR VGND.t126 VPWR VPWR sg13_lv_pmos ad=0.19p pd=1.38u as=0 ps=0 w=1u l=1u
X409 VPWR VGND.t793 VPWR VPWR sg13_lv_pmos ad=0.34p pd=2.68u as=0 ps=0 w=1u l=1u
X410 VPWR VGND.t488 VPWR VPWR sg13_lv_pmos ad=0.34p pd=2.68u as=0 ps=0 w=1u l=1u
X411 sg13cmos5l_inv_16_2.Y sg13cmos5l_inv_16_2.A VPWR VPWR sg13_lv_pmos ad=0.2128p pd=1.5u as=0.4368p ps=3.02u w=1.12u l=0.13u
X412 VPWR sg13cmos5l_and2_1_0.X sg13cmos5l_inv_1_3.A VPWR sg13_lv_pmos ad=0.2128p pd=1.5u as=0.2128p ps=1.5u w=1.12u l=0.13u
X413 VGND.t41 VPWR VGND.t306 VGND.t348 sg13_lv_nmos ad=79.8f pd=0.8u as=0 ps=0 w=0.42u l=1u
X414 VPWR VGND.t454 VPWR VPWR sg13_lv_pmos ad=0.34p pd=2.68u as=0 ps=0 w=1u l=1u
X415 sg13cmos5l_and2_1_0.B sg13cmos5l_inv_1_1.Y VPWR VPWR sg13_lv_pmos ad=0.2128p pd=1.5u as=0.2128p ps=1.5u w=1.12u l=0.13u
X416 VGND.t831 VPWR VGND.t831 VGND.t832 sg13_lv_nmos ad=0.1428p pd=1.52u as=0 ps=0 w=0.42u l=1u
X417 VGND.t622 VPWR VGND.t622 VGND.t625 sg13_lv_nmos ad=79.8f pd=0.8u as=0 ps=0 w=0.42u l=1u
X418 VGND.t707 VPWR VGND.t707 VGND.t709 sg13_lv_nmos ad=0.1428p pd=1.52u as=0 ps=0 w=0.42u l=1u
X419 VGND.t412 VPWR VGND.t412 VGND.t447 sg13_lv_nmos ad=79.8f pd=0.8u as=0 ps=0 w=0.42u l=1u
X420 VGND.t474 VPWR VGND.t474 VGND.t514 sg13_lv_nmos ad=0.1428p pd=1.52u as=0 ps=0 w=0.42u l=1u
X421 VPWR VGND.t836 VPWR VPWR sg13_lv_pmos ad=0.34p pd=2.68u as=0 ps=0 w=1u l=1u
X422 VGND.t885 VPWR VGND.t887 VGND.t886 sg13_lv_nmos ad=79.8f pd=0.8u as=0 ps=0 w=0.42u l=1u
X423 VPWR VGND.t922 VPWR VPWR sg13_lv_pmos ad=0.19p pd=1.38u as=0 ps=0 w=1u l=1u
X424 VPWR VGND.t150 VPWR VPWR sg13_lv_pmos ad=0.19p pd=1.38u as=0 ps=0 w=1u l=1u
X425 sg13cmos5l_inv_1_3.A sg13cmos5l_and2_1_0.X VGND.t1 VGND.t62 sg13_lv_nmos ad=0.1406p pd=1.12u as=0.1406p ps=1.12u w=0.74u l=0.13u
X426 VGND.t622 VPWR VGND.t622 VGND.t633 sg13_lv_nmos ad=79.8f pd=0.8u as=0 ps=0 w=0.42u l=1u
X427 VGND.t474 VPWR VGND.t474 VGND.t519 sg13_lv_nmos ad=79.8f pd=0.8u as=0 ps=0 w=0.42u l=1u
X428 VPWR VGND.t569 VPWR VPWR sg13_lv_pmos ad=0.34p pd=2.68u as=0 ps=0 w=1u l=1u
X429 VGND.t64 VPWR VGND.t393 VGND.t392 sg13_lv_nmos ad=79.8f pd=0.8u as=0 ps=0 w=0.42u l=1u
X430 VPWR VGND.t398 VPWR VPWR sg13_lv_pmos ad=0.34p pd=2.68u as=0 ps=0 w=1u l=1u
X431 VGND.t3 sg13cmos5l_and2_1_0.X sg13cmos5l_inv_1_3.A VGND.t59 sg13_lv_nmos ad=0.1406p pd=1.12u as=0.1406p ps=1.12u w=0.74u l=0.13u
X432 VGND.t462 VPWR VGND.t462 VGND.t508 sg13_lv_nmos ad=0.1428p pd=1.52u as=0 ps=0 w=0.42u l=1u
X433 VPWR VGND.t104 VPWR VPWR sg13_lv_pmos ad=0.34p pd=2.68u as=0 ps=0 w=1u l=1u
X434 VPWR VGND.t474 VPWR VPWR sg13_lv_pmos ad=0.34p pd=2.68u as=0 ps=0 w=1u l=1u
X435 VGND.t64 VPWR VGND.t64 VGND.t425 sg13_lv_nmos ad=79.8f pd=0.8u as=0 ps=0 w=0.42u l=1u
X436 VPWR VGND.t329 VPWR VPWR sg13_lv_pmos ad=0.34p pd=2.68u as=0 ps=0 w=1u l=1u
X437 VPWR VGND.t793 VPWR VPWR sg13_lv_pmos ad=0.34p pd=2.68u as=0 ps=0 w=1u l=1u
X438 VGND.t622 VPWR VGND.t622 VGND.t627 sg13_lv_nmos ad=79.8f pd=0.8u as=0 ps=0 w=0.42u l=1u
X439 VPWR VGND.t488 VPWR VPWR sg13_lv_pmos ad=0.34p pd=2.68u as=0 ps=0 w=1u l=1u
X440 VPWR VGND.t713 VPWR VPWR sg13_lv_pmos ad=0.19p pd=1.38u as=0 ps=0 w=1u l=1u
X441 VPWR VGND.t229 VPWR VPWR sg13_lv_pmos ad=0.34p pd=2.68u as=0 ps=0 w=1u l=1u
X442 VGND.t488 VPWR VGND.t484 VGND.t524 sg13_lv_nmos ad=0.1428p pd=1.52u as=0 ps=0 w=0.42u l=1u
X443 VGND.t885 VPWR VGND.t884 VGND.t883 sg13_lv_nmos ad=0.1428p pd=1.52u as=0 ps=0 w=0.42u l=1u
X444 VPWR VGND.t826 VPWR VPWR sg13_lv_pmos ad=0.34p pd=2.68u as=0 ps=0 w=1u l=1u
X445 VPWR VGND.t907 VPWR VPWR sg13_lv_pmos ad=0.19p pd=1.38u as=0 ps=0 w=1u l=1u
X446 VPWR VGND.t381 VPWR VPWR sg13_lv_pmos ad=0.19p pd=1.38u as=0 ps=0 w=1u l=1u
X447 VPWR VGND.t312 VPWR VPWR sg13_lv_pmos ad=0.19p pd=1.38u as=0 ps=0 w=1u l=1u
X448 VGND.t28 sg13cmos5l_inv_16_2.A sg13cmos5l_inv_16_2.Y VGND.t27 sg13_lv_nmos ad=0.2516p pd=2.16u as=0.1406p ps=1.12u w=0.74u l=0.13u
X449 VGND.t216 VPWR VGND.t216 VGND.t219 sg13_lv_nmos ad=0.1428p pd=1.52u as=0 ps=0 w=0.42u l=1u
X450 VPWR VGND.t484 VPWR VPWR sg13_lv_pmos ad=0.34p pd=2.68u as=0 ps=0 w=1u l=1u
X451 VGND.t531 VPWR VGND.t531 VGND.t548 sg13_lv_nmos ad=79.8f pd=0.8u as=0 ps=0 w=0.42u l=1u
X452 VPWR VGND.t198 VPWR VPWR sg13_lv_pmos ad=0.19p pd=1.38u as=0 ps=0 w=1u l=1u
X453 VPWR VGND.t234 VPWR VPWR sg13_lv_pmos ad=0.19p pd=1.38u as=0 ps=0 w=1u l=1u
X454 VPWR VGND.t713 VPWR VPWR sg13_lv_pmos ad=0.19p pd=1.38u as=0 ps=0 w=1u l=1u
X455 sg13cmos5l_inv_16_2.Y sg13cmos5l_inv_16_2.A VGND.t15 VGND.t24 sg13_lv_nmos ad=0.1406p pd=1.12u as=0.1406p ps=1.12u w=0.74u l=0.13u
X456 VGND.t198 VPWR VGND.t198 VGND.t225 sg13_lv_nmos ad=0.1428p pd=1.52u as=0 ps=0 w=0.42u l=1u
X457 VPWR VGND.t836 VPWR VPWR sg13_lv_pmos ad=0.34p pd=2.68u as=0 ps=0 w=1u l=1u
X458 VGND.t15 VPWR VGND.t15 VGND.t502 sg13_lv_nmos ad=0.1428p pd=1.52u as=0 ps=0 w=0.42u l=1u
X459 VPWR VGND.t30 VPWR VPWR sg13_lv_pmos ad=0.34p pd=2.68u as=0 ps=0 w=1u l=1u
X460 VGND.t3 sg13cmos5l_inv_1_3.Y sg13cmos5l_inv_1_0.A VGND.t79 sg13_lv_nmos ad=0.1406p pd=1.12u as=0.1406p ps=1.12u w=0.74u l=0.13u
X461 VPWR VGND.t329 VPWR VPWR sg13_lv_pmos ad=0.19p pd=1.38u as=0 ps=0 w=1u l=1u
X462 VGND.t329 VPWR VGND.t329 VGND.t365 sg13_lv_nmos ad=0.1428p pd=1.52u as=0 ps=0 w=0.42u l=1u
X463 VPWR VGND.t121 VPWR VPWR sg13_lv_pmos ad=0.34p pd=2.68u as=0 ps=0 w=1u l=1u
X464 sg13cmos5l_inv_16_4.Y sg13cmos5l_inv_16_4.A VGND.t10 VGND.t88 sg13_lv_nmos ad=0.1406p pd=1.12u as=0.1406p ps=1.12u w=0.74u l=0.13u
X465 VGND.t890 VPWR VGND.t892 VGND.t891 sg13_lv_nmos ad=79.8f pd=0.8u as=0 ps=0 w=0.42u l=1u
X466 VPWR VGND.t622 VPWR VPWR sg13_lv_pmos ad=0.19p pd=1.38u as=0 ps=0 w=1u l=1u
X467 sg13cmos5l_inv_1_0.A sg13cmos5l_inv_1_3.Y VGND.t3 VGND.t76 sg13_lv_nmos ad=0.1406p pd=1.12u as=0.1406p ps=1.12u w=0.74u l=0.13u
X468 VPWR VGND.t713 VPWR VPWR sg13_lv_pmos ad=0.34p pd=2.68u as=0 ps=0 w=1u l=1u
X469 VGND.t468 VPWR VGND.t468 VGND.t510 sg13_lv_nmos ad=0.1428p pd=1.52u as=0 ps=0 w=0.42u l=1u
X470 VGND.t104 VPWR VGND.t104 VGND.t105 sg13_lv_nmos ad=79.8f pd=0.8u as=0 ps=0 w=0.42u l=1u
X471 VGND.t329 VPWR VGND.t329 VGND.t371 sg13_lv_nmos ad=0.1428p pd=1.52u as=0 ps=0 w=0.42u l=1u
X472 VPWR VGND.t308 VPWR VPWR sg13_lv_pmos ad=0.34p pd=2.68u as=0 ps=0 w=1u l=1u
X473 VGND.t622 VPWR VGND.t622 VGND.t629 sg13_lv_nmos ad=79.8f pd=0.8u as=0 ps=0 w=0.42u l=1u
X474 VGND.t308 VPWR VGND.t308 VGND.t350 sg13_lv_nmos ad=79.8f pd=0.8u as=0 ps=0 w=0.42u l=1u
X475 VGND.t540 VPWR VGND.t531 VGND.t542 sg13_lv_nmos ad=79.8f pd=0.8u as=0 ps=0 w=0.42u l=1u
X476 VPWR VGND.t449 VPWR VPWR sg13_lv_pmos ad=0.34p pd=2.68u as=0 ps=0 w=1u l=1u
X477 VPWR VGND.t474 VPWR VPWR sg13_lv_pmos ad=0.34p pd=2.68u as=0 ps=0 w=1u l=1u
X478 VPWR sg13cmos5l_inv_16_2.A sg13cmos5l_inv_16_2.Y VPWR sg13_lv_pmos ad=0.2128p pd=1.5u as=0.2128p ps=1.5u w=1.12u l=0.13u
X479 VGND.t3 sg13cmos5l_inv_1_3.Y sg13cmos5l_inv_1_0.A VGND.t73 sg13_lv_nmos ad=0.1406p pd=1.12u as=0.1406p ps=1.12u w=0.74u l=0.13u
X480 VPWR VGND.t398 VPWR VPWR sg13_lv_pmos ad=0.19p pd=1.38u as=0 ps=0 w=1u l=1u
X481 VGND.t935 VPWR VGND.t934 VGND.t933 sg13_lv_nmos ad=0.1428p pd=1.52u as=0 ps=0 w=0.42u l=1u
X482 VGND.t64 VPWR VGND.t64 VGND.t388 sg13_lv_nmos ad=79.8f pd=0.8u as=0 ps=0 w=0.42u l=1u
X483 VGND.t622 VPWR VGND.t622 VGND.t640 sg13_lv_nmos ad=0.1428p pd=1.52u as=0 ps=0 w=0.42u l=1u
X484 VGND.t488 VPWR VGND.t488 VGND.t526 sg13_lv_nmos ad=0.1428p pd=1.52u as=0 ps=0 w=0.42u l=1u
X485 VPWR VGND.t454 VPWR VPWR sg13_lv_pmos ad=0.19p pd=1.38u as=0 ps=0 w=1u l=1u
X486 VGND.t314 VPWR VGND.t314 VGND.t356 sg13_lv_nmos ad=79.8f pd=0.8u as=0 ps=0 w=0.42u l=1u
X487 VGND.t10 VPWR VGND.t10 VGND.t458 sg13_lv_nmos ad=0.1428p pd=1.52u as=0 ps=0 w=0.42u l=1u
X488 VGND.t104 VPWR VGND.t104 VGND.t108 sg13_lv_nmos ad=0.1428p pd=1.52u as=0 ps=0 w=0.42u l=1u
X489 VPWR VGND.t793 VPWR VPWR sg13_lv_pmos ad=0.19p pd=1.38u as=0 ps=0 w=1u l=1u
X490 VPWR VGND.t912 VPWR VPWR sg13_lv_pmos ad=0.19p pd=1.38u as=0 ps=0 w=1u l=1u
X491 VGND.t531 VPWR VGND.t551 VGND.t550 sg13_lv_nmos ad=79.8f pd=0.8u as=0 ps=0 w=0.42u l=1u
X492 VGND.t398 VPWR VGND.t407 VGND.t406 sg13_lv_nmos ad=79.8f pd=0.8u as=0 ps=0 w=0.42u l=1u
X493 VGND.t34 sg13cmos5l_inv_1_1.Y sg13cmos5l_and2_1_0.B VGND.t33 sg13_lv_nmos ad=0.1406p pd=1.12u as=0.1406p ps=1.12u w=0.74u l=0.13u
X494 VGND.t622 VPWR VGND.t622 VGND.t634 sg13_lv_nmos ad=0.1428p pd=1.52u as=0 ps=0 w=0.42u l=1u
X495 VPWR VGND.t121 VPWR VPWR sg13_lv_pmos ad=0.19p pd=1.38u as=0 ps=0 w=1u l=1u
X496 VPWR VGND.t793 VPWR VPWR sg13_lv_pmos ad=0.34p pd=2.68u as=0 ps=0 w=1u l=1u
X497 VGND.t28 VPWR VGND.t28 VGND.t504 sg13_lv_nmos ad=0.1428p pd=1.52u as=0 ps=0 w=0.42u l=1u
X498 VPWR VGND.t393 VPWR VPWR sg13_lv_pmos ad=0.34p pd=2.68u as=0 ps=0 w=1u l=1u
X499 VPWR VGND.t897 VPWR VPWR sg13_lv_pmos ad=0.19p pd=1.38u as=0 ps=0 w=1u l=1u
X500 VGND.t622 VPWR VGND.t622 VGND.t623 sg13_lv_nmos ad=79.8f pd=0.8u as=0 ps=0 w=0.42u l=1u
X501 VPWR VGND.t713 VPWR VPWR sg13_lv_pmos ad=0.19p pd=1.38u as=0 ps=0 w=1u l=1u
X502 VGND.t229 VPWR VGND.t229 VGND.t231 sg13_lv_nmos ad=79.8f pd=0.8u as=0 ps=0 w=0.42u l=1u
X503 VGND.t713 VPWR VGND.t713 VGND.t742 sg13_lv_nmos ad=0.1428p pd=1.52u as=0 ps=0 w=0.42u l=1u
X504 VPWR VGND.t287 VPWR VPWR sg13_lv_pmos ad=0.34p pd=2.68u as=0 ps=0 w=1u l=1u
X505 VGND.t531 VPWR VGND.t531 VGND.t548 sg13_lv_nmos ad=79.8f pd=0.8u as=0 ps=0 w=0.42u l=1u
X506 VPWR sg13cmos5l_inv_16_2.A sg13cmos5l_inv_16_2.Y VPWR sg13_lv_pmos ad=0.2128p pd=1.5u as=0.2128p ps=1.5u w=1.12u l=0.13u
X507 VGND.t314 VPWR VGND.t314 VGND.t319 sg13_lv_nmos ad=79.8f pd=0.8u as=0 ps=0 w=0.42u l=1u
X508 VGND.t203 VPWR VGND.t203 VGND.t204 sg13_lv_nmos ad=0.1428p pd=1.52u as=0 ps=0 w=0.42u l=1u
X509 VPWR VGND.t143 VPWR VPWR sg13_lv_pmos ad=0.34p pd=2.68u as=0 ps=0 w=1u l=1u
X510 sg13cmos5l_inv_1_3.A sg13cmos5l_and2_1_0.X VPWR VPWR sg13_lv_pmos ad=0.2128p pd=1.5u as=0.2128p ps=1.5u w=1.12u l=0.13u
X511 VGND.t531 VPWR VGND.t531 VGND.t544 sg13_lv_nmos ad=79.8f pd=0.8u as=0 ps=0 w=0.42u l=1u
X512 VPWR VGND.t449 VPWR VPWR sg13_lv_pmos ad=0.34p pd=2.68u as=0 ps=0 w=1u l=1u
X513 VPWR VGND.t239 VPWR VPWR sg13_lv_pmos ad=0.34p pd=2.68u as=0 ps=0 w=1u l=1u
X514 VGND.t622 VPWR VGND.t622 VGND.t628 sg13_lv_nmos ad=0.1428p pd=1.52u as=0 ps=0 w=0.42u l=1u
X515 VGND.t488 VPWR VGND.t488 VGND.t528 sg13_lv_nmos ad=0.1428p pd=1.52u as=0 ps=0 w=0.42u l=1u
X516 VPWR VGND.t10 VPWR VPWR sg13_lv_pmos ad=0.19p pd=1.38u as=0 ps=0 w=1u l=1u
X517 VGND.t150 VPWR VGND.t150 VGND.t152 sg13_lv_nmos ad=79.8f pd=0.8u as=0 ps=0 w=0.42u l=1u
X518 VGND.t531 VPWR VGND.t537 VGND.t536 sg13_lv_nmos ad=79.8f pd=0.8u as=0 ps=0 w=0.42u l=1u
X519 VGND.t407 VPWR VGND.t407 VGND.t409 sg13_lv_nmos ad=79.8f pd=0.8u as=0 ps=0 w=0.42u l=1u
X520 VPWR VGND.t198 VPWR VPWR sg13_lv_pmos ad=0.19p pd=1.38u as=0 ps=0 w=1u l=1u
X521 VGND.t143 VPWR VGND.t141 VGND.t187 sg13_lv_nmos ad=0.1428p pd=1.52u as=0 ps=0 w=0.42u l=1u
X522 VPWR VGND.t713 VPWR VPWR sg13_lv_pmos ad=0.34p pd=2.68u as=0 ps=0 w=1u l=1u
X523 VGND.t104 VPWR VGND.t104 VGND.t134 sg13_lv_nmos ad=0.1428p pd=1.52u as=0 ps=0 w=0.42u l=1u
X524 VGND.t540 VPWR VGND.t531 VGND.t542 sg13_lv_nmos ad=79.8f pd=0.8u as=0 ps=0 w=0.42u l=1u
X525 VPWR VGND.t126 VPWR VPWR sg13_lv_pmos ad=0.34p pd=2.68u as=0 ps=0 w=1u l=1u
X526 VPWR VGND.t41 VPWR VPWR sg13_lv_pmos ad=0.34p pd=2.68u as=0 ps=0 w=1u l=1u
X527 sg13cmos5l_and2_1_0.B sg13cmos5l_inv_1_1.Y VGND.t41 VGND.t46 sg13_lv_nmos ad=0.1406p pd=1.12u as=0.1406p ps=1.12u w=0.74u l=0.13u
X528 VPWR VGND.t198 VPWR VPWR sg13_lv_pmos ad=0.34p pd=2.68u as=0 ps=0 w=1u l=1u
X529 VGND.t980 VPWR VGND.t982 VGND.t981 sg13_lv_nmos ad=79.8f pd=0.8u as=0 ps=0 w=0.42u l=1u
X530 VPWR VGND.t198 VPWR VPWR sg13_lv_pmos ad=0.34p pd=2.68u as=0 ps=0 w=1u l=1u
X531 VGND.t121 VPWR VGND.t126 VGND.t125 sg13_lv_nmos ad=79.8f pd=0.8u as=0 ps=0 w=0.42u l=1u
X532 VPWR VGND.t104 VPWR VPWR sg13_lv_pmos ad=0.34p pd=2.68u as=0 ps=0 w=1u l=1u
X533 VGND.t622 VPWR VGND.t622 VGND.t652 sg13_lv_nmos ad=0.1428p pd=1.52u as=0 ps=0 w=0.42u l=1u
X534 VPWR VGND.t929 VPWR VPWR sg13_lv_pmos ad=0.34p pd=2.68u as=0 ps=0 w=1u l=1u
X535 VPWR VGND.t308 VPWR VPWR sg13_lv_pmos ad=0.34p pd=2.68u as=0 ps=0 w=1u l=1u
X536 VGND.t308 VPWR VGND.t308 VGND.t349 sg13_lv_nmos ad=0.1428p pd=1.52u as=0 ps=0 w=0.42u l=1u
X537 VGND.t955 VPWR VGND.t954 VGND.t953 sg13_lv_nmos ad=0.1428p pd=1.52u as=0 ps=0 w=0.42u l=1u
X538 VGND.t836 VPWR VGND.t836 VGND.t793 sg13_lv_nmos ad=79.8f pd=0.8u as=0 ps=0 w=0.42u l=1u
X539 VGND.t531 VPWR VGND.t551 VGND.t550 sg13_lv_nmos ad=79.8f pd=0.8u as=0 ps=0 w=0.42u l=1u
X540 VGND.t398 VPWR VGND.t398 VGND.t402 sg13_lv_nmos ad=79.8f pd=0.8u as=0 ps=0 w=0.42u l=1u
X541 VPWR VGND.t143 VPWR VPWR sg13_lv_pmos ad=0.19p pd=1.38u as=0 ps=0 w=1u l=1u
X542 VGND.t975 VPWR VGND.t977 VGND.t976 sg13_lv_nmos ad=79.8f pd=0.8u as=0 ps=0 w=0.42u l=1u
X543 VPWR VGND.t381 VPWR VPWR sg13_lv_pmos ad=0.19p pd=1.38u as=0 ps=0 w=1u l=1u
X544 VGND.t622 VPWR VGND.t622 VGND.t630 sg13_lv_nmos ad=0.1428p pd=1.52u as=0 ps=0 w=0.42u l=1u
X545 VGND.t474 VPWR VGND.t474 VGND.t516 sg13_lv_nmos ad=0.1428p pd=1.52u as=0 ps=0 w=0.42u l=1u
X546 VGND.t813 VPWR VGND.t813 VGND.t815 sg13_lv_nmos ad=79.8f pd=0.8u as=0 ps=0 w=0.42u l=1u
X547 VGND.t64 VPWR VGND.t64 VGND.t389 sg13_lv_nmos ad=0.1428p pd=1.52u as=0 ps=0 w=0.42u l=1u
X548 VPWR VGND.t887 VPWR VPWR sg13_lv_pmos ad=0.19p pd=1.38u as=0 ps=0 w=1u l=1u
X549 VGND.t537 VPWR VGND.t540 VGND.t539 sg13_lv_nmos ad=79.8f pd=0.8u as=0 ps=0 w=0.42u l=1u
X550 VGND.t234 VPWR VGND.t234 VGND.t236 sg13_lv_nmos ad=79.8f pd=0.8u as=0 ps=0 w=0.42u l=1u
X551 VPWR VGND.t914 VPWR VPWR sg13_lv_pmos ad=0.34p pd=2.68u as=0 ps=0 w=1u l=1u
X552 VGND.t531 VPWR VGND.t531 VGND.t544 sg13_lv_nmos ad=79.8f pd=0.8u as=0 ps=0 w=0.42u l=1u
X553 VGND.t551 VPWR VGND.t551 VGND.t552 sg13_lv_nmos ad=0.1428p pd=1.52u as=0 ps=0 w=0.42u l=1u
X554 VGND.t3 sg13cmos5l_inv_1_3.Y sg13cmos5l_inv_1_0.A VGND.t85 sg13_lv_nmos ad=0.2516p pd=2.16u as=0.1406p ps=1.12u w=0.74u l=0.13u
X555 VPWR sg13cmos5l_inv_1_1.Y sg13cmos5l_and2_1_0.B VPWR sg13_lv_pmos ad=0.2128p pd=1.5u as=0.2128p ps=1.5u w=1.12u l=0.13u
X556 VPWR VGND.t713 VPWR VPWR sg13_lv_pmos ad=0.34p pd=2.68u as=0 ps=0 w=1u l=1u
X557 VGND.t793 VPWR VGND.t793 VGND.t796 sg13_lv_nmos ad=79.8f pd=0.8u as=0 ps=0 w=0.42u l=1u
X558 VGND.t910 VPWR VGND.t912 VGND.t911 sg13_lv_nmos ad=79.8f pd=0.8u as=0 ps=0 w=0.42u l=1u
X559 VGND.t622 VPWR VGND.t622 VGND.t654 sg13_lv_nmos ad=0.1428p pd=1.52u as=0 ps=0 w=0.42u l=1u
X560 VPWR VGND.t287 VPWR VPWR sg13_lv_pmos ad=0.19p pd=1.38u as=0 ps=0 w=1u l=1u
X561 VPWR VGND.t899 VPWR VPWR sg13_lv_pmos ad=0.34p pd=2.68u as=0 ps=0 w=1u l=1u
X562 sg13cmos5l_inv_16_4.Y sg13cmos5l_inv_16_4.A VGND.t12 VGND.t94 sg13_lv_nmos ad=0.1406p pd=1.12u as=0.1406p ps=1.12u w=0.74u l=0.13u
X563 sg13cmos5l_inv_1_0.A sg13cmos5l_inv_1_3.Y VGND.t3 VGND.t82 sg13_lv_nmos ad=0.1406p pd=1.12u as=0.1406p ps=1.12u w=0.74u l=0.13u
X564 VPWR VGND.t112 VPWR VPWR sg13_lv_pmos ad=0.34p pd=2.68u as=0 ps=0 w=1u l=1u
X565 VGND.t198 VPWR VGND.t198 VGND.t212 sg13_lv_nmos ad=0.1428p pd=1.52u as=0 ps=0 w=0.42u l=1u
X566 VPWR VGND.t531 VPWR VPWR sg13_lv_pmos ad=0.19p pd=1.38u as=0 ps=0 w=1u l=1u
X567 VGND.t531 VPWR VGND.t537 VGND.t536 sg13_lv_nmos ad=79.8f pd=0.8u as=0 ps=0 w=0.42u l=1u
X568 VPWR VGND.t449 VPWR VPWR sg13_lv_pmos ad=0.19p pd=1.38u as=0 ps=0 w=1u l=1u
X569 VPWR VGND.t836 VPWR VPWR sg13_lv_pmos ad=0.19p pd=1.38u as=0 ps=0 w=1u l=1u
X570 VGND.t531 VPWR VGND.t531 VGND.t545 sg13_lv_nmos ad=0.1428p pd=1.52u as=0 ps=0 w=0.42u l=1u
X571 VPWR VGND.t198 VPWR VPWR sg13_lv_pmos ad=0.19p pd=1.38u as=0 ps=0 w=1u l=1u
X572 VPWR VGND.t137 VPWR VPWR sg13_lv_pmos ad=0.19p pd=1.38u as=0 ps=0 w=1u l=1u
X573 VPWR VGND.t229 VPWR VPWR sg13_lv_pmos ad=0.19p pd=1.38u as=0 ps=0 w=1u l=1u
X574 VGND.t10 sg13cmos5l_inv_16_4.A sg13cmos5l_inv_16_4.Y VGND.t91 sg13_lv_nmos ad=0.1406p pd=1.12u as=0.1406p ps=1.12u w=0.74u l=0.13u
X575 VGND.t203 VPWR VGND.t203 VGND.t205 sg13_lv_nmos ad=79.8f pd=0.8u as=0 ps=0 w=0.42u l=1u
X576 VGND.t622 VPWR VGND.t622 VGND.t624 sg13_lv_nmos ad=0.1428p pd=1.52u as=0 ps=0 w=0.42u l=1u
X577 VGND.t287 VPWR VGND.t287 VGND.t291 sg13_lv_nmos ad=0.1428p pd=1.52u as=0 ps=0 w=0.42u l=1u
X578 VPWR VGND.t793 VPWR VPWR sg13_lv_pmos ad=0.19p pd=1.38u as=0 ps=0 w=1u l=1u
X579 VPWR VGND.t104 VPWR VPWR sg13_lv_pmos ad=0.34p pd=2.68u as=0 ps=0 w=1u l=1u
X580 VGND.t960 VPWR VGND.t959 VGND.t958 sg13_lv_nmos ad=0.1428p pd=1.52u as=0 ps=0 w=0.42u l=1u
X581 VPWR VGND.t531 VPWR VPWR sg13_lv_pmos ad=0.19p pd=1.38u as=0 ps=0 w=1u l=1u
X582 VGND.t531 VPWR VGND.t531 VGND.t532 sg13_lv_nmos ad=79.8f pd=0.8u as=0 ps=0 w=0.42u l=1u
X583 VGND.t8 enable a_808_8468# VGND.t102 sg13_lv_nmos ad=0.14875p pd=1.16u as=0.187p ps=1.78u w=0.55u l=0.13u
X584 VPWR VGND.t287 VPWR VPWR sg13_lv_pmos ad=0.34p pd=2.68u as=0 ps=0 w=1u l=1u
X585 VGND.t314 VPWR VGND.t314 VGND.t313 sg13_lv_nmos ad=0.1428p pd=1.52u as=0 ps=0 w=0.42u l=1u
X586 VGND.t104 VPWR VGND.t121 VGND.t120 sg13_lv_nmos ad=79.8f pd=0.8u as=0 ps=0 w=0.42u l=1u
X587 VGND.t622 VPWR VGND.t622 VGND.t632 sg13_lv_nmos ad=0.1428p pd=1.52u as=0 ps=0 w=0.42u l=1u
X588 VGND.t143 VPWR VGND.t143 VGND.t190 sg13_lv_nmos ad=79.8f pd=0.8u as=0 ps=0 w=0.42u l=1u
X589 VGND.t3 sg13cmos5l_inv_1_0.A sg13cmos5l_inv_16_2.A VGND.t68 sg13_lv_nmos ad=0.2516p pd=2.16u as=0.2516p ps=2.16u w=0.74u l=0.13u
X590 VPWR sg13cmos5l_inv_16_2.Y sg13cmos5l_inv_16_4.A VPWR sg13_lv_pmos ad=0.3808p pd=2.92u as=0.3808p ps=2.92u w=1.12u l=0.13u
X591 VPWR VGND.t104 VPWR VPWR sg13_lv_pmos ad=0.34p pd=2.68u as=0 ps=0 w=1u l=1u
X592 VPWR sg13cmos5l_and2_1_0.X sg13cmos5l_inv_1_3.A VPWR sg13_lv_pmos ad=0.2128p pd=1.5u as=0.2128p ps=1.5u w=1.12u l=0.13u
X593 VPWR VGND.t64 VPWR VPWR sg13_lv_pmos ad=0.34p pd=2.68u as=0 ps=0 w=1u l=1u
X594 VGND.t104 VPWR VGND.t104 VGND.t117 sg13_lv_nmos ad=0.1428p pd=1.52u as=0 ps=0 w=0.42u l=1u
X595 VPWR VGND.t813 VPWR VPWR sg13_lv_pmos ad=0.19p pd=1.38u as=0 ps=0 w=1u l=1u
X596 VGND.t64 VPWR VGND.t64 VGND.t391 sg13_lv_nmos ad=0.1428p pd=1.52u as=0 ps=0 w=0.42u l=1u
X597 sg13cmos5l_and2_1_0.B sg13cmos5l_inv_1_1.Y VGND.t30 VGND.t29 sg13_lv_nmos ad=0.1406p pd=1.12u as=0.2516p ps=2.16u w=0.74u l=0.13u
X598 VPWR VGND.t959 VPWR VPWR sg13_lv_pmos ad=0.34p pd=2.68u as=0 ps=0 w=1u l=1u
X599 VGND.t393 VPWR VGND.t398 VGND.t397 sg13_lv_nmos ad=79.8f pd=0.8u as=0 ps=0 w=0.42u l=1u
X600 VGND.t104 VPWR VGND.t104 VGND.t106 sg13_lv_nmos ad=0.1428p pd=1.52u as=0 ps=0 w=0.42u l=1u
X601 VGND.t143 VPWR VGND.t143 VGND.t145 sg13_lv_nmos ad=0.1428p pd=1.52u as=0 ps=0 w=0.42u l=1u
X602 VGND.t121 VPWR VGND.t121 VGND.t124 sg13_lv_nmos ad=0.1428p pd=1.52u as=0 ps=0 w=0.42u l=1u
X603 VPWR VGND.t531 VPWR VPWR sg13_lv_pmos ad=0.19p pd=1.38u as=0 ps=0 w=1u l=1u
X604 VPWR VGND.t8 VPWR VPWR sg13_lv_pmos ad=0.34p pd=2.68u as=0 ps=0 w=1u l=1u
X605 VPWR VGND.t198 VPWR VPWR sg13_lv_pmos ad=0.19p pd=1.38u as=0 ps=0 w=1u l=1u
X606 VGND.t713 VPWR VGND.t713 VGND.t723 sg13_lv_nmos ad=79.8f pd=0.8u as=0 ps=0 w=0.42u l=1u
X607 VGND.t537 VPWR VGND.t537 VGND.t538 sg13_lv_nmos ad=0.1428p pd=1.52u as=0 ps=0 w=0.42u l=1u
X608 VGND.t407 VPWR VGND.t407 VGND.t410 sg13_lv_nmos ad=0.1428p pd=1.52u as=0 ps=0 w=0.42u l=1u
X609 VGND.t126 VPWR VGND.t126 VGND.t127 sg13_lv_nmos ad=0.1428p pd=1.52u as=0 ps=0 w=0.42u l=1u
X610 VGND.t398 VPWR VGND.t398 VGND.t440 sg13_lv_nmos ad=0.1428p pd=1.52u as=0 ps=0 w=0.42u l=1u
X611 VGND.t314 VPWR VGND.t314 VGND.t357 sg13_lv_nmos ad=0.1428p pd=1.52u as=0 ps=0 w=0.42u l=1u
X612 VPWR VGND.t904 VPWR VPWR sg13_lv_pmos ad=0.34p pd=2.68u as=0 ps=0 w=1u l=1u
X613 sg13cmos5l_and2_1_0.B sg13cmos5l_inv_1_1.Y VPWR VPWR sg13_lv_pmos ad=0.2128p pd=1.5u as=0.2128p ps=1.5u w=1.12u l=0.13u
X614 VPWR VGND.t375 VPWR VPWR sg13_lv_pmos ad=0.19p pd=1.38u as=0 ps=0 w=1u l=1u
X615 VGND.t622 VPWR VGND.t622 VGND.t626 sg13_lv_nmos ad=0.1428p pd=1.52u as=0 ps=0 w=0.42u l=1u
X616 VGND.t537 VPWR VGND.t540 VGND.t539 sg13_lv_nmos ad=79.8f pd=0.8u as=0 ps=0 w=0.42u l=1u
X617 VPWR sg13cmos5l_inv_1_3.Y sg13cmos5l_inv_1_0.A VPWR sg13_lv_pmos ad=0.2128p pd=1.5u as=0.2128p ps=1.5u w=1.12u l=0.13u
X618 VPWR sg13cmos5l_inv_16_4.A sg13cmos5l_inv_16_4.Y VPWR sg13_lv_pmos ad=0.2128p pd=1.5u as=0.2128p ps=1.5u w=1.12u l=0.13u
X619 VGND.t551 VPWR VGND.t551 VGND.t552 sg13_lv_nmos ad=0.1428p pd=1.52u as=0 ps=0 w=0.42u l=1u
X620 VPWR VGND.t112 VPWR VPWR sg13_lv_pmos ad=0.19p pd=1.38u as=0 ps=0 w=1u l=1u
X621 VGND.t329 VPWR VGND.t329 VGND.t331 sg13_lv_nmos ad=0.1428p pd=1.52u as=0 ps=0 w=0.42u l=1u
X622 VGND.t890 VPWR VGND.t889 VGND.t888 sg13_lv_nmos ad=0.1428p pd=1.52u as=0 ps=0 w=0.42u l=1u
X623 sg13cmos5l_inv_1_0.A sg13cmos5l_inv_1_3.Y VPWR VPWR sg13_lv_pmos ad=0.2128p pd=1.5u as=0.2128p ps=1.5u w=1.12u l=0.13u
X624 VGND.t564 VPWR VGND.t564 VGND.t565 sg13_lv_nmos ad=0.1428p pd=1.52u as=0 ps=0 w=0.42u l=1u
X625 VGND.t41 sg13cmos5l_inv_1_1.Y sg13cmos5l_and2_1_0.B VGND.t47 sg13_lv_nmos ad=0.2516p pd=2.16u as=0.1406p ps=1.12u w=0.74u l=0.13u
X626 VGND.t713 VPWR VGND.t713 VGND.t717 sg13_lv_nmos ad=79.8f pd=0.8u as=0 ps=0 w=0.42u l=1u
X627 VPWR VGND.t713 VPWR VPWR sg13_lv_pmos ad=0.34p pd=2.68u as=0 ps=0 w=1u l=1u
X628 VPWR sg13cmos5l_and2_1_0.B a_3885_9540# VPWR sg13_lv_pmos ad=0.1918p pd=1.5u as=0.1596p ps=1.22u w=0.84u l=0.13u
X629 VPWR sg13cmos5l_inv_1_0.A sg13cmos5l_inv_16_2.A VPWR sg13_lv_pmos ad=0.3808p pd=2.92u as=0.3808p ps=2.92u w=1.12u l=0.13u
X630 VGND.t229 VPWR VGND.t229 VGND.t232 sg13_lv_nmos ad=0.1428p pd=1.52u as=0 ps=0 w=0.42u l=1u
X631 VPWR VGND.t381 VPWR VPWR sg13_lv_pmos ad=0.34p pd=2.68u as=0 ps=0 w=1u l=1u
X632 VGND.t393 VPWR VGND.t393 VGND.t394 sg13_lv_nmos ad=0.1428p pd=1.52u as=0 ps=0 w=0.42u l=1u
X633 VGND.t531 VPWR VGND.t531 VGND.t545 sg13_lv_nmos ad=0.1428p pd=1.52u as=0 ps=0 w=0.42u l=1u
X634 VGND.t308 VPWR VGND.t312 VGND.t311 sg13_lv_nmos ad=79.8f pd=0.8u as=0 ps=0 w=0.42u l=1u
X635 VPWR VGND.t137 VPWR VPWR sg13_lv_pmos ad=0.34p pd=2.68u as=0 ps=0 w=1u l=1u
X636 VPWR VGND.t466 VPWR VPWR sg13_lv_pmos ad=0.19p pd=1.38u as=0 ps=0 w=1u l=1u
X637 VPWR VGND.t889 VPWR VPWR sg13_lv_pmos ad=0.34p pd=2.68u as=0 ps=0 w=1u l=1u
X638 sg13cmos5l_inv_1_1.Y sg13cmos5l_inv_16_4.Y VGND.t3 VGND.t67 sg13_lv_nmos ad=0.2516p pd=2.16u as=0.2516p ps=2.16u w=0.74u l=0.13u
X639 VPWR VGND.t531 VPWR VPWR sg13_lv_pmos ad=0.19p pd=1.38u as=0 ps=0 w=1u l=1u
X640 VGND.t531 VPWR VGND.t531 VGND.t532 sg13_lv_nmos ad=79.8f pd=0.8u as=0 ps=0 w=0.42u l=1u
X641 VGND.t713 VPWR VGND.t713 VGND.t725 sg13_lv_nmos ad=79.8f pd=0.8u as=0 ps=0 w=0.42u l=1u
X642 VPWR VGND.t836 VPWR VPWR sg13_lv_pmos ad=0.19p pd=1.38u as=0 ps=0 w=1u l=1u
X643 VGND.t540 VPWR VGND.t540 VGND.t541 sg13_lv_nmos ad=0.1428p pd=1.52u as=0 ps=0 w=0.42u l=1u
X644 VGND.t198 VPWR VGND.t216 VGND.t215 sg13_lv_nmos ad=79.8f pd=0.8u as=0 ps=0 w=0.42u l=1u
X645 VPWR VGND.t229 VPWR VPWR sg13_lv_pmos ad=0.34p pd=2.68u as=0 ps=0 w=1u l=1u
X646 a_3979_9540# sg13cmos5l_buf_1_0.X a_3885_9540# VGND.t6 sg13_lv_nmos ad=0.1216p pd=1.02u as=0.2176p ps=1.96u w=0.64u l=0.13u
X647 VGND.t30 VPWR VGND.t30 VGND.t296 sg13_lv_nmos ad=0.1428p pd=1.52u as=0 ps=0 w=0.42u l=1u
X648 VGND.t198 VPWR VGND.t198 VGND.t223 sg13_lv_nmos ad=0.1428p pd=1.52u as=0 ps=0 w=0.42u l=1u
X649 VPWR VGND.t454 VPWR VPWR sg13_lv_pmos ad=0.34p pd=2.68u as=0 ps=0 w=1u l=1u
X650 VPWR VGND.t104 VPWR VPWR sg13_lv_pmos ad=0.19p pd=1.38u as=0 ps=0 w=1u l=1u
X651 VPWR sg13cmos5l_inv_16_4.A sg13cmos5l_inv_16_4.Y VPWR sg13_lv_pmos ad=0.2128p pd=1.5u as=0.2128p ps=1.5u w=1.12u l=0.13u
X652 VPWR VGND.t381 VPWR VPWR sg13_lv_pmos ad=0.19p pd=1.38u as=0 ps=0 w=1u l=1u
X653 VPWR VGND.t909 VPWR VPWR sg13_lv_pmos ad=0.34p pd=2.68u as=0 ps=0 w=1u l=1u
X654 VPWR VGND.t537 VPWR VPWR sg13_lv_pmos ad=0.19p pd=1.38u as=0 ps=0 w=1u l=1u
X655 VPWR VGND.t398 VPWR VPWR sg13_lv_pmos ad=0.34p pd=2.68u as=0 ps=0 w=1u l=1u
X656 VGND.t398 VPWR VGND.t398 VGND.t405 sg13_lv_nmos ad=0.1428p pd=1.52u as=0 ps=0 w=0.42u l=1u
X657 VPWR VGND.t216 VPWR VPWR sg13_lv_pmos ad=0.19p pd=1.38u as=0 ps=0 w=1u l=1u
X658 sg13cmos5l_inv_16_4.Y sg13cmos5l_inv_16_4.A VPWR VPWR sg13_lv_pmos ad=0.2128p pd=1.5u as=0.2128p ps=1.5u w=1.12u l=0.13u
X659 VPWR VGND.t239 VPWR VPWR sg13_lv_pmos ad=0.19p pd=1.38u as=0 ps=0 w=1u l=1u
X660 VGND.t324 VPWR VGND.t324 VGND.t362 sg13_lv_nmos ad=79.8f pd=0.8u as=0 ps=0 w=0.42u l=1u
X661 VGND.t64 VPWR VGND.t64 VGND.t387 sg13_lv_nmos ad=0.1428p pd=1.52u as=0 ps=0 w=0.42u l=1u
X662 VPWR VGND.t104 VPWR VPWR sg13_lv_pmos ad=0.34p pd=2.68u as=0 ps=0 w=1u l=1u
X663 VGND.t537 VPWR VGND.t537 VGND.t538 sg13_lv_nmos ad=0.1428p pd=1.52u as=0 ps=0 w=0.42u l=1u
X664 VGND.t707 VPWR VGND.t707 VGND.t710 sg13_lv_nmos ad=79.8f pd=0.8u as=0 ps=0 w=0.42u l=1u
X665 VGND.t564 VPWR VGND.t564 VGND.t567 sg13_lv_nmos ad=0.1428p pd=1.52u as=0 ps=0 w=0.42u l=1u
X666 VGND.t462 VPWR VGND.t462 VGND.t461 sg13_lv_nmos ad=0.1428p pd=1.52u as=0 ps=0 w=0.42u l=1u
X667 VPWR VGND.t198 VPWR VPWR sg13_lv_pmos ad=0.34p pd=2.68u as=0 ps=0 w=1u l=1u
X668 VGND.t713 VPWR VGND.t713 VGND.t719 sg13_lv_nmos ad=79.8f pd=0.8u as=0 ps=0 w=0.42u l=1u
X669 VGND.t126 VPWR VGND.t126 VGND.t173 sg13_lv_nmos ad=0.1428p pd=1.52u as=0 ps=0 w=0.42u l=1u
X670 VPWR VGND.t468 VPWR VPWR sg13_lv_pmos ad=0.19p pd=1.38u as=0 ps=0 w=1u l=1u
X671 VGND.t112 VPWR VGND.t112 VGND.t115 sg13_lv_nmos ad=0.1428p pd=1.52u as=0 ps=0 w=0.42u l=1u
X672 VGND.t104 VPWR VGND.t104 VGND.t179 sg13_lv_nmos ad=0.1428p pd=1.52u as=0 ps=0 w=0.42u l=1u
X673 VPWR VGND.t894 VPWR VPWR sg13_lv_pmos ad=0.34p pd=2.68u as=0 ps=0 w=1u l=1u
X674 VGND.t15 sg13cmos5l_inv_16_4.A sg13cmos5l_inv_16_4.Y VGND.t101 sg13_lv_nmos ad=0.2516p pd=2.16u as=0.1406p ps=1.12u w=0.74u l=0.13u
X675 sg13cmos5l_and2_1_0.B sg13cmos5l_inv_1_1.Y VPWR VPWR sg13_lv_pmos ad=0.2128p pd=1.5u as=0.3808p ps=2.92u w=1.12u l=0.13u
X676 VPWR VGND.t407 VPWR VPWR sg13_lv_pmos ad=0.34p pd=2.68u as=0 ps=0 w=1u l=1u
X677 VGND.t707 VPWR VGND.t713 VGND.t712 sg13_lv_nmos ad=79.8f pd=0.8u as=0 ps=0 w=0.42u l=1u
X678 VGND.t531 VPWR VGND.t531 VGND.t543 sg13_lv_nmos ad=0.1428p pd=1.52u as=0 ps=0 w=0.42u l=1u
X679 VGND.t398 VPWR VGND.t398 VGND.t399 sg13_lv_nmos ad=0.1428p pd=1.52u as=0 ps=0 w=0.42u l=1u
X680 VGND.t564 VPWR VGND.t564 VGND.t565 sg13_lv_nmos ad=0.1428p pd=1.52u as=0 ps=0 w=0.42u l=1u
X681 VPWR VGND.t836 VPWR VPWR sg13_lv_pmos ad=0.19p pd=1.38u as=0 ps=0 w=1u l=1u
X682 VPWR VGND.t488 VPWR VPWR sg13_lv_pmos ad=0.19p pd=1.38u as=0 ps=0 w=1u l=1u
X683 VPWR VGND.t10 VPWR VPWR sg13_lv_pmos ad=0.34p pd=2.68u as=0 ps=0 w=1u l=1u
X684 VPWR VGND.t707 VPWR VPWR sg13_lv_pmos ad=0.19p pd=1.38u as=0 ps=0 w=1u l=1u
X685 VPWR VGND.t393 VPWR VPWR sg13_lv_pmos ad=0.19p pd=1.38u as=0 ps=0 w=1u l=1u
X686 VGND.t287 VPWR VGND.t287 VGND.t286 sg13_lv_nmos ad=0.1428p pd=1.52u as=0 ps=0 w=0.42u l=1u
X687 VGND.t198 VPWR VGND.t229 VGND.t228 sg13_lv_nmos ad=79.8f pd=0.8u as=0 ps=0 w=0.42u l=1u
X688 VGND.t980 VPWR VGND.t979 VGND.t978 sg13_lv_nmos ad=0.1428p pd=1.52u as=0 ps=0 w=0.42u l=1u
X689 VPWR VGND.t482 VPWR VPWR sg13_lv_pmos ad=0.19p pd=1.38u as=0 ps=0 w=1u l=1u
X690 VPWR VGND.t121 VPWR VPWR sg13_lv_pmos ad=0.19p pd=1.38u as=0 ps=0 w=1u l=1u
X691 VPWR VGND.t375 VPWR VPWR sg13_lv_pmos ad=0.34p pd=2.68u as=0 ps=0 w=1u l=1u
X692 VPWR VGND.t551 VPWR VPWR sg13_lv_pmos ad=0.34p pd=2.68u as=0 ps=0 w=1u l=1u
X693 VPWR VGND.t329 VPWR VPWR sg13_lv_pmos ad=0.19p pd=1.38u as=0 ps=0 w=1u l=1u
X694 VGND.t540 VPWR VGND.t540 VGND.t541 sg13_lv_nmos ad=0.1428p pd=1.52u as=0 ps=0 w=0.42u l=1u
X695 VPWR VGND.t813 VPWR VPWR sg13_lv_pmos ad=0.19p pd=1.38u as=0 ps=0 w=1u l=1u
X696 VPWR VGND.t28 VPWR VPWR sg13_lv_pmos ad=0.19p pd=1.38u as=0 ps=0 w=1u l=1u
X697 VGND.t198 VPWR VGND.t198 VGND.t200 sg13_lv_nmos ad=79.8f pd=0.8u as=0 ps=0 w=0.42u l=1u
X698 sg13cmos5l_inv_1_3.A sg13cmos5l_and2_1_0.X VPWR VPWR sg13_lv_pmos ad=0.2128p pd=1.5u as=0.2128p ps=1.5u w=1.12u l=0.13u
X699 sg13cmos5l_inv_1_3.A sg13cmos5l_and2_1_0.X VGND.t3 VGND.t54 sg13_lv_nmos ad=0.1406p pd=1.12u as=0.1406p ps=1.12u w=0.74u l=0.13u
X700 VGND.t531 VPWR VGND.t531 VGND.t535 sg13_lv_nmos ad=0.1428p pd=1.52u as=0 ps=0 w=0.42u l=1u
X701 VGND.t239 VPWR VGND.t239 VGND.t242 sg13_lv_nmos ad=0.1428p pd=1.52u as=0 ps=0 w=0.42u l=1u
X702 VPWR VGND.t104 VPWR VPWR sg13_lv_pmos ad=0.34p pd=2.68u as=0 ps=0 w=1u l=1u
X703 VPWR sg13cmos5l_inv_1_1.Y sg13cmos5l_and2_1_0.B VPWR sg13_lv_pmos ad=0.4368p pd=3.02u as=0.2128p ps=1.5u w=1.12u l=0.13u
X704 VGND.t622 VPWR VGND.t622 VGND.t621 sg13_lv_nmos ad=0.1428p pd=1.52u as=0 ps=0 w=0.42u l=1u
X705 VPWR VGND.t449 VPWR VPWR sg13_lv_pmos ad=0.34p pd=2.68u as=0 ps=0 w=1u l=1u
X706 VPWR VGND.t234 VPWR VPWR sg13_lv_pmos ad=0.34p pd=2.68u as=0 ps=0 w=1u l=1u
X707 VPWR VGND.t472 VPWR VPWR sg13_lv_pmos ad=0.19p pd=1.38u as=0 ps=0 w=1u l=1u
X708 VPWR VGND.t793 VPWR VPWR sg13_lv_pmos ad=0.34p pd=2.68u as=0 ps=0 w=1u l=1u
X709 VGND.t196 VPWR VGND.t198 VGND.t197 sg13_lv_nmos ad=79.8f pd=0.8u as=0 ps=0 w=0.42u l=1u
X710 VPWR VGND.t229 VPWR VPWR sg13_lv_pmos ad=0.34p pd=2.68u as=0 ps=0 w=1u l=1u
X711 VGND.t622 VPWR VGND.t622 VGND.t649 sg13_lv_nmos ad=79.8f pd=0.8u as=0 ps=0 w=0.42u l=1u
X712 VPWR VGND.t531 VPWR VPWR sg13_lv_pmos ad=0.19p pd=1.38u as=0 ps=0 w=1u l=1u
X713 VGND.t713 VPWR VGND.t713 VGND.t715 sg13_lv_nmos ad=79.8f pd=0.8u as=0 ps=0 w=0.42u l=1u
X714 VGND.t198 VPWR VGND.t198 VGND.t224 sg13_lv_nmos ad=79.8f pd=0.8u as=0 ps=0 w=0.42u l=1u
X715 VGND.t398 VPWR VGND.t398 VGND.t401 sg13_lv_nmos ad=0.1428p pd=1.52u as=0 ps=0 w=0.42u l=1u
X716 VGND.t564 VPWR VGND.t564 VGND.t567 sg13_lv_nmos ad=0.1428p pd=1.52u as=0 ps=0 w=0.42u l=1u
X717 VGND.t41 VPWR VGND.t41 VGND.t304 sg13_lv_nmos ad=0.1428p pd=1.52u as=0 ps=0 w=0.42u l=1u
X718 VGND.t112 VPWR VGND.t112 VGND.t114 sg13_lv_nmos ad=79.8f pd=0.8u as=0 ps=0 w=0.42u l=1u
X719 sg13cmos5l_inv_1_0.A sg13cmos5l_inv_1_3.Y VPWR VPWR sg13_lv_pmos ad=0.2128p pd=1.5u as=0.2128p ps=1.5u w=1.12u l=0.13u
X720 VPWR VGND.t622 VPWR VPWR sg13_lv_pmos ad=0.19p pd=1.38u as=0 ps=0 w=1u l=1u
X721 VPWR VGND.t216 VPWR VPWR sg13_lv_pmos ad=0.19p pd=1.38u as=0 ps=0 w=1u l=1u
X722 VPWR VGND.t531 VPWR VPWR sg13_lv_pmos ad=0.34p pd=2.68u as=0 ps=0 w=1u l=1u
X723 VGND.t137 VPWR VGND.t137 VGND.t184 sg13_lv_nmos ad=79.8f pd=0.8u as=0 ps=0 w=0.42u l=1u
X724 VGND.t713 VPWR VGND.t713 VGND.t726 sg13_lv_nmos ad=0.1428p pd=1.52u as=0 ps=0 w=0.42u l=1u
X725 VPWR VGND.t324 VPWR VPWR sg13_lv_pmos ad=0.34p pd=2.68u as=0 ps=0 w=1u l=1u
X726 VGND.t314 VPWR VGND.t314 VGND.t358 sg13_lv_nmos ad=79.8f pd=0.8u as=0 ps=0 w=0.42u l=1u
X727 VPWR VGND.t198 VPWR VPWR sg13_lv_pmos ad=0.19p pd=1.38u as=0 ps=0 w=1u l=1u
X728 VGND.t104 VPWR VGND.t104 VGND.t110 sg13_lv_nmos ad=0.1428p pd=1.52u as=0 ps=0 w=0.42u l=1u
X729 VGND.t910 VPWR VGND.t909 VGND.t908 sg13_lv_nmos ad=0.1428p pd=1.52u as=0 ps=0 w=0.42u l=1u
X730 VPWR VGND.t484 VPWR VPWR sg13_lv_pmos ad=0.19p pd=1.38u as=0 ps=0 w=1u l=1u
X731 VPWR VGND.t5 VPWR VPWR sg13_lv_pmos ad=0.34p pd=2.68u as=0 ps=0 w=1u l=1u
X732 VPWR VGND.t375 VPWR VPWR sg13_lv_pmos ad=0.34p pd=2.68u as=0 ps=0 w=1u l=1u
X733 VGND.t831 VPWR VGND.t831 VGND.t832 sg13_lv_nmos ad=0.1428p pd=1.52u as=0 ps=0 w=0.42u l=1u
X734 VPWR VGND.t537 VPWR VPWR sg13_lv_pmos ad=0.34p pd=2.68u as=0 ps=0 w=1u l=1u
X735 VPWR VGND.t306 VPWR VPWR sg13_lv_pmos ad=0.19p pd=1.38u as=0 ps=0 w=1u l=1u
X736 VGND.t531 VPWR VGND.t531 VGND.t543 sg13_lv_nmos ad=0.1428p pd=1.52u as=0 ps=0 w=0.42u l=1u
X737 VGND.t41 VPWR VGND.t41 VGND.t345 sg13_lv_nmos ad=0.1428p pd=1.52u as=0 ps=0 w=0.42u l=1u
X738 VGND.t713 VPWR VGND.t713 VGND.t720 sg13_lv_nmos ad=0.1428p pd=1.52u as=0 ps=0 w=0.42u l=1u
X739 VGND.t793 VPWR VGND.t793 VGND.t795 sg13_lv_nmos ad=0.1428p pd=1.52u as=0 ps=0 w=0.42u l=1u
X740 VGND.t622 VPWR VGND.t622 VGND.t643 sg13_lv_nmos ad=79.8f pd=0.8u as=0 ps=0 w=0.42u l=1u
X741 VGND.t488 VPWR VGND.t488 VGND.t529 sg13_lv_nmos ad=79.8f pd=0.8u as=0 ps=0 w=0.42u l=1u
X742 VGND.t3 sg13cmos5l_inv_1_3.Y sg13cmos5l_inv_1_0.A VGND.t71 sg13_lv_nmos ad=0.1406p pd=1.12u as=0.1406p ps=1.12u w=0.74u l=0.13u
X743 VGND.t707 VPWR VGND.t707 VGND.t708 sg13_lv_nmos ad=79.8f pd=0.8u as=0 ps=0 w=0.42u l=1u
X744 VGND.t229 VPWR VGND.t234 VGND.t233 sg13_lv_nmos ad=79.8f pd=0.8u as=0 ps=0 w=0.42u l=1u
X745 VPWR VGND.t836 VPWR VPWR sg13_lv_pmos ad=0.19p pd=1.38u as=0 ps=0 w=1u l=1u
X746 VPWR VGND.t412 VPWR VPWR sg13_lv_pmos ad=0.34p pd=2.68u as=0 ps=0 w=1u l=1u
X747 VPWR VGND.t622 VPWR VPWR sg13_lv_pmos ad=0.19p pd=1.38u as=0 ps=0 w=1u l=1u
X748 sg13cmos5l_inv_16_4.Y sg13cmos5l_inv_16_4.A VPWR VPWR sg13_lv_pmos ad=0.2128p pd=1.5u as=0.2128p ps=1.5u w=1.12u l=0.13u
X749 VGND.t239 VPWR VGND.t239 VGND.t241 sg13_lv_nmos ad=79.8f pd=0.8u as=0 ps=0 w=0.42u l=1u
X750 VPWR VGND.t468 VPWR VPWR sg13_lv_pmos ad=0.34p pd=2.68u as=0 ps=0 w=1u l=1u
X751 VPWR VGND.t564 VPWR VPWR sg13_lv_pmos ad=0.34p pd=2.68u as=0 ps=0 w=1u l=1u
X752 VPWR VGND.t393 VPWR VPWR sg13_lv_pmos ad=0.19p pd=1.38u as=0 ps=0 w=1u l=1u
X753 VGND.t462 VPWR VGND.t462 VGND.t507 sg13_lv_nmos ad=79.8f pd=0.8u as=0 ps=0 w=0.42u l=1u
X754 VPWR VGND.t474 VPWR VPWR sg13_lv_pmos ad=0.19p pd=1.38u as=0 ps=0 w=1u l=1u
X755 VGND.t531 VPWR VGND.t531 VGND.t535 sg13_lv_nmos ad=0.1428p pd=1.52u as=0 ps=0 w=0.42u l=1u
X756 VGND.t713 VPWR VGND.t713 VGND.t714 sg13_lv_nmos ad=0.1428p pd=1.52u as=0 ps=0 w=0.42u l=1u
X757 VPWR VGND.t126 VPWR VPWR sg13_lv_pmos ad=0.19p pd=1.38u as=0 ps=0 w=1u l=1u
X758 VGND.t198 VPWR VGND.t203 VGND.t202 sg13_lv_nmos ad=79.8f pd=0.8u as=0 ps=0 w=0.42u l=1u
X759 sg13cmos5l_inv_16_2.Y sg13cmos5l_inv_16_2.A VGND.t10 VGND.t9 sg13_lv_nmos ad=0.1406p pd=1.12u as=0.2516p ps=2.16u w=0.74u l=0.13u
X760 VPWR VGND.t884 VPWR VPWR sg13_lv_pmos ad=0.34p pd=2.68u as=0 ps=0 w=1u l=1u
X761 VGND.t375 VPWR VGND.t375 VGND.t378 sg13_lv_nmos ad=79.8f pd=0.8u as=0 ps=0 w=0.42u l=1u
X762 VGND.t622 VPWR VGND.t622 VGND.t637 sg13_lv_nmos ad=79.8f pd=0.8u as=0 ps=0 w=0.42u l=1u
X763 VPWR VGND.t540 VPWR VPWR sg13_lv_pmos ad=0.34p pd=2.68u as=0 ps=0 w=1u l=1u
X764 VPWR VGND.t831 VPWR VPWR sg13_lv_pmos ad=0.34p pd=2.68u as=0 ps=0 w=1u l=1u
X765 VGND.t198 VPWR VGND.t198 VGND.t209 sg13_lv_nmos ad=79.8f pd=0.8u as=0 ps=0 w=0.42u l=1u
X766 VPWR VGND.t10 VPWR VPWR sg13_lv_pmos ad=0.19p pd=1.38u as=0 ps=0 w=1u l=1u
X767 VPWR VGND.t64 VPWR VPWR sg13_lv_pmos ad=0.34p pd=2.68u as=0 ps=0 w=1u l=1u
X768 sg13cmos5l_inv_16_2.Y sg13cmos5l_inv_16_2.A VPWR VPWR sg13_lv_pmos ad=0.2128p pd=1.5u as=0.2128p ps=1.5u w=1.12u l=0.13u
X769 VGND.t622 VPWR VGND.t622 VGND.t645 sg13_lv_nmos ad=79.8f pd=0.8u as=0 ps=0 w=0.42u l=1u
X770 VPWR VGND.t381 VPWR VPWR sg13_lv_pmos ad=0.34p pd=2.68u as=0 ps=0 w=1u l=1u
X771 VPWR VGND.t104 VPWR VPWR sg13_lv_pmos ad=0.19p pd=1.38u as=0 ps=0 w=1u l=1u
X772 VPWR VGND.t314 VPWR VPWR sg13_lv_pmos ad=0.34p pd=2.68u as=0 ps=0 w=1u l=1u
X773 VGND.t713 VPWR VGND.t713 VGND.t738 sg13_lv_nmos ad=0.1428p pd=1.52u as=0 ps=0 w=0.42u l=1u
X774 VPWR VGND.t622 VPWR VPWR sg13_lv_pmos ad=0.19p pd=1.38u as=0 ps=0 w=1u l=1u
X775 VPWR sg13cmos5l_inv_16_2.A sg13cmos5l_inv_16_2.Y VPWR sg13_lv_pmos ad=0.2128p pd=1.5u as=0.2128p ps=1.5u w=1.12u l=0.13u
X776 sg13cmos5l_and2_1_0.B sg13cmos5l_inv_1_1.Y VGND.t34 VGND.t39 sg13_lv_nmos ad=0.1406p pd=1.12u as=0.1406p ps=1.12u w=0.74u l=0.13u
X777 VPWR VGND.t216 VPWR VPWR sg13_lv_pmos ad=0.34p pd=2.68u as=0 ps=0 w=1u l=1u
X778 VPWR VGND.t150 VPWR VPWR sg13_lv_pmos ad=0.34p pd=2.68u as=0 ps=0 w=1u l=1u
X779 VGND.t622 VPWR VGND.t622 VGND.t661 sg13_lv_nmos ad=79.8f pd=0.8u as=0 ps=0 w=0.42u l=1u
X780 VPWR VGND.t239 VPWR VPWR sg13_lv_pmos ad=0.34p pd=2.68u as=0 ps=0 w=1u l=1u
X781 VPWR VGND.t329 VPWR VPWR sg13_lv_pmos ad=0.34p pd=2.68u as=0 ps=0 w=1u l=1u
X782 VPWR VGND.t707 VPWR VPWR sg13_lv_pmos ad=0.19p pd=1.38u as=0 ps=0 w=1u l=1u
X783 VPWR VGND.t474 VPWR VPWR sg13_lv_pmos ad=0.34p pd=2.68u as=0 ps=0 w=1u l=1u
X784 VPWR enable a_808_8468# VPWR sg13_lv_pmos ad=0.2114p pd=1.54u as=0.2856p ps=2.36u w=0.84u l=0.13u
X785 VPWR VGND.t622 VPWR VPWR sg13_lv_pmos ad=0.19p pd=1.38u as=0 ps=0 w=1u l=1u
X786 VPWR VGND.t474 VPWR VPWR sg13_lv_pmos ad=0.19p pd=1.38u as=0 ps=0 w=1u l=1u
X787 VPWR VGND.t329 VPWR VPWR sg13_lv_pmos ad=0.34p pd=2.68u as=0 ps=0 w=1u l=1u
X788 VGND.t622 VPWR VGND.t622 VGND.t631 sg13_lv_nmos ad=79.8f pd=0.8u as=0 ps=0 w=0.42u l=1u
X789 VPWR VGND.t531 VPWR VPWR sg13_lv_pmos ad=0.34p pd=2.68u as=0 ps=0 w=1u l=1u
X790 VGND.t531 VPWR VGND.t531 VGND.t530 sg13_lv_nmos ad=0.1428p pd=1.52u as=0 ps=0 w=0.42u l=1u
X791 VGND.t713 VPWR VGND.t713 VGND.t716 sg13_lv_nmos ad=0.1428p pd=1.52u as=0 ps=0 w=0.42u l=1u
X792 VGND.t104 VPWR VGND.t104 VGND.t119 sg13_lv_nmos ad=0.1428p pd=1.52u as=0 ps=0 w=0.42u l=1u
X793 VPWR VGND.t104 VPWR VPWR sg13_lv_pmos ad=0.19p pd=1.38u as=0 ps=0 w=1u l=1u
X794 VPWR VGND.t198 VPWR VPWR sg13_lv_pmos ad=0.19p pd=1.38u as=0 ps=0 w=1u l=1u
X795 VPWR VGND.t308 VPWR VPWR sg13_lv_pmos ad=0.19p pd=1.38u as=0 ps=0 w=1u l=1u
X796 sg13cmos5l_and2_1_0.B sg13cmos5l_inv_1_1.Y VGND.t34 VGND.t35 sg13_lv_nmos ad=0.1406p pd=1.12u as=0.1406p ps=1.12u w=0.74u l=0.13u
X797 VGND.t622 VPWR VGND.t622 VGND.t655 sg13_lv_nmos ad=79.8f pd=0.8u as=0 ps=0 w=0.42u l=1u
X798 VPWR VGND.t937 VPWR VPWR sg13_lv_pmos ad=0.19p pd=1.38u as=0 ps=0 w=1u l=1u
X799 VPWR VGND.t462 VPWR VPWR sg13_lv_pmos ad=0.34p pd=2.68u as=0 ps=0 w=1u l=1u
X800 VGND.t104 VPWR VGND.t104 VGND.t108 sg13_lv_nmos ad=0.1428p pd=1.52u as=0 ps=0 w=0.42u l=1u
X801 VGND.t531 VPWR VGND.t531 VGND.t561 sg13_lv_nmos ad=79.8f pd=0.8u as=0 ps=0 w=0.42u l=1u
X802 VGND.t64 sg13cmos5l_and2_1_0.X sg13cmos5l_inv_1_3.A VGND.t63 sg13_lv_nmos ad=0.1406p pd=1.12u as=0.1406p ps=1.12u w=0.74u l=0.13u
X803 VPWR VGND.t314 VPWR VPWR sg13_lv_pmos ad=0.19p pd=1.38u as=0 ps=0 w=1u l=1u
X804 VGND.t314 VPWR VGND.t314 VGND.t353 sg13_lv_nmos ad=0.1428p pd=1.52u as=0 ps=0 w=0.42u l=1u
X805 VGND.t622 VPWR VGND.t622 VGND.t639 sg13_lv_nmos ad=79.8f pd=0.8u as=0 ps=0 w=0.42u l=1u
X806 VPWR VGND.t531 VPWR VPWR sg13_lv_pmos ad=0.34p pd=2.68u as=0 ps=0 w=1u l=1u
X807 VPWR VGND.t198 VPWR VPWR sg13_lv_pmos ad=0.34p pd=2.68u as=0 ps=0 w=1u l=1u
X808 VPWR VGND.t484 VPWR VPWR sg13_lv_pmos ad=0.34p pd=2.68u as=0 ps=0 w=1u l=1u
X809 sg13cmos5l_inv_1_3.A sg13cmos5l_and2_1_0.X VGND.t3 VGND.t60 sg13_lv_nmos ad=0.1406p pd=1.12u as=0.1406p ps=1.12u w=0.74u l=0.13u
X810 VPWR VGND.t793 VPWR VPWR sg13_lv_pmos ad=0.34p pd=2.68u as=0 ps=0 w=1u l=1u
X811 VGND.t622 VPWR VGND.t622 VGND.t647 sg13_lv_nmos ad=79.8f pd=0.8u as=0 ps=0 w=0.42u l=1u
X812 VGND.t239 VPWR VGND.t239 VGND.t198 sg13_lv_nmos ad=79.8f pd=0.8u as=0 ps=0 w=0.42u l=1u
X813 VGND.t41 sg13cmos5l_inv_1_1.Y sg13cmos5l_and2_1_0.B VGND.t43 sg13_lv_nmos ad=0.1406p pd=1.12u as=0.1406p ps=1.12u w=0.74u l=0.13u
X814 VGND.t3 VPWR VGND.t3 VGND.t386 sg13_lv_nmos ad=0.1428p pd=1.52u as=0 ps=0 w=0.42u l=1u
X815 VGND.t713 VPWR VGND.t713 VGND.t740 sg13_lv_nmos ad=0.1428p pd=1.52u as=0 ps=0 w=0.42u l=1u
X816 VPWR VGND.t622 VPWR VPWR sg13_lv_pmos ad=0.19p pd=1.38u as=0 ps=0 w=1u l=1u
X817 VGND.t229 VPWR VGND.t229 VGND.t230 sg13_lv_nmos ad=0.1428p pd=1.52u as=0 ps=0 w=0.42u l=1u
X818 VPWR VGND.t137 VPWR VPWR sg13_lv_pmos ad=0.19p pd=1.38u as=0 ps=0 w=1u l=1u
X819 VPWR VGND.t375 VPWR VPWR sg13_lv_pmos ad=0.34p pd=2.68u as=0 ps=0 w=1u l=1u
X820 VPWR VGND.t375 VPWR VPWR sg13_lv_pmos ad=0.34p pd=2.68u as=0 ps=0 w=1u l=1u
X821 VGND.t30 VPWR VGND.t293 VGND.t294 sg13_lv_nmos ad=0.1428p pd=1.52u as=0 ps=0 w=0.42u l=1u
X822 VPWR VGND.t322 VPWR VPWR sg13_lv_pmos ad=0.19p pd=1.38u as=0 ps=0 w=1u l=1u
X823 VPWR VGND.t121 VPWR VPWR sg13_lv_pmos ad=0.34p pd=2.68u as=0 ps=0 w=1u l=1u
X824 VGND.t198 VPWR VGND.t198 VGND.t227 sg13_lv_nmos ad=0.1428p pd=1.52u as=0 ps=0 w=0.42u l=1u
X825 VGND.t707 VPWR VGND.t707 VGND.t709 sg13_lv_nmos ad=0.1428p pd=1.52u as=0 ps=0 w=0.42u l=1u
X826 VGND.t551 VPWR VGND.t531 VGND.t555 sg13_lv_nmos ad=79.8f pd=0.8u as=0 ps=0 w=0.42u l=1u
X827 VPWR VGND.t15 VPWR VPWR sg13_lv_pmos ad=0.34p pd=2.68u as=0 ps=0 w=1u l=1u
X828 VPWR VGND.t150 VPWR VPWR sg13_lv_pmos ad=0.19p pd=1.38u as=0 ps=0 w=1u l=1u
X829 VGND.t622 VPWR VGND.t622 VGND.t633 sg13_lv_nmos ad=79.8f pd=0.8u as=0 ps=0 w=0.42u l=1u
X830 VPWR VGND.t531 VPWR VPWR sg13_lv_pmos ad=0.34p pd=2.68u as=0 ps=0 w=1u l=1u
X831 VGND.t198 VPWR VGND.t198 VGND.t213 sg13_lv_nmos ad=79.8f pd=0.8u as=0 ps=0 w=0.42u l=1u
X832 VGND.t950 VPWR VGND.t952 VGND.t951 sg13_lv_nmos ad=79.8f pd=0.8u as=0 ps=0 w=0.42u l=1u
X833 VGND.t713 VPWR VGND.t713 VGND.t718 sg13_lv_nmos ad=0.1428p pd=1.52u as=0 ps=0 w=0.42u l=1u
X834 VGND.t622 VPWR VGND.t622 VGND.t657 sg13_lv_nmos ad=79.8f pd=0.8u as=0 ps=0 w=0.42u l=1u
X835 VPWR VGND.t622 VPWR VPWR sg13_lv_pmos ad=0.34p pd=2.68u as=0 ps=0 w=1u l=1u
X836 VPWR VGND.t942 VPWR VPWR sg13_lv_pmos ad=0.19p pd=1.38u as=0 ps=0 w=1u l=1u
X837 VGND.t15 sg13cmos5l_inv_16_2.A sg13cmos5l_inv_16_2.Y VGND.t25 sg13_lv_nmos ad=0.1406p pd=1.12u as=0.1406p ps=1.12u w=0.74u l=0.13u
X838 VGND.t198 VPWR VGND.t198 VGND.t211 sg13_lv_nmos ad=79.8f pd=0.8u as=0 ps=0 w=0.42u l=1u
X839 sg13cmos5l_inv_1_0.A sg13cmos5l_inv_1_3.Y VGND.t3 VGND.t80 sg13_lv_nmos ad=0.1406p pd=1.12u as=0.1406p ps=1.12u w=0.74u l=0.13u
X840 sg13cmos5l_inv_1_3.A sg13cmos5l_and2_1_0.X VGND.t3 VGND.t56 sg13_lv_nmos ad=0.1406p pd=1.12u as=0.1406p ps=1.12u w=0.74u l=0.13u
X841 VGND.t198 VPWR VGND.t198 VGND.t199 sg13_lv_nmos ad=0.1428p pd=1.52u as=0 ps=0 w=0.42u l=1u
X842 VGND.t622 VPWR VGND.t622 VGND.t627 sg13_lv_nmos ad=79.8f pd=0.8u as=0 ps=0 w=0.42u l=1u
X843 VPWR VGND.t104 VPWR VPWR sg13_lv_pmos ad=0.19p pd=1.38u as=0 ps=0 w=1u l=1u
X844 VPWR VGND.t982 VPWR VPWR sg13_lv_pmos ad=0.19p pd=1.38u as=0 ps=0 w=1u l=1u
X845 VPWR VGND.t622 VPWR VPWR sg13_lv_pmos ad=0.19p pd=1.38u as=0 ps=0 w=1u l=1u
X846 VPWR VGND.t287 VPWR VPWR sg13_lv_pmos ad=0.19p pd=1.38u as=0 ps=0 w=1u l=1u
X847 VPWR VGND.t488 VPWR VPWR sg13_lv_pmos ad=0.34p pd=2.68u as=0 ps=0 w=1u l=1u
X848 VGND.t3 sg13cmos5l_inv_1_3.Y sg13cmos5l_inv_1_0.A VGND.t77 sg13_lv_nmos ad=0.1406p pd=1.12u as=0.1406p ps=1.12u w=0.74u l=0.13u
X849 VPWR VGND.t104 VPWR VPWR sg13_lv_pmos ad=0.34p pd=2.68u as=0 ps=0 w=1u l=1u
X850 VGND.t531 VPWR VGND.t531 VGND.t530 sg13_lv_nmos ad=0.1428p pd=1.52u as=0 ps=0 w=0.42u l=1u
X851 VPWR VGND.t216 VPWR VPWR sg13_lv_pmos ad=0.34p pd=2.68u as=0 ps=0 w=1u l=1u
X852 VGND.t137 VPWR VGND.t137 VGND.t185 sg13_lv_nmos ad=0.1428p pd=1.52u as=0 ps=0 w=0.42u l=1u
X853 VGND.t622 VPWR VGND.t622 VGND.t635 sg13_lv_nmos ad=79.8f pd=0.8u as=0 ps=0 w=0.42u l=1u
X854 VPWR VGND.t198 VPWR VPWR sg13_lv_pmos ad=0.19p pd=1.38u as=0 ps=0 w=1u l=1u
X855 VPWR VGND.t104 VPWR VPWR sg13_lv_pmos ad=0.19p pd=1.38u as=0 ps=0 w=1u l=1u
X856 sg13cmos5l_inv_16_4.Y sg13cmos5l_inv_16_4.A VGND.t10 VGND.t86 sg13_lv_nmos ad=0.1406p pd=1.12u as=0.2516p ps=2.16u w=0.74u l=0.13u
X857 VPWR VGND.t64 VPWR VPWR sg13_lv_pmos ad=0.19p pd=1.38u as=0 ps=0 w=1u l=1u
X858 VGND.t121 VPWR VGND.t126 VGND.t125 sg13_lv_nmos ad=79.8f pd=0.8u as=0 ps=0 w=0.42u l=1u
X859 VGND.t622 VPWR VGND.t622 VGND.t646 sg13_lv_nmos ad=0.1428p pd=1.52u as=0 ps=0 w=0.42u l=1u
X860 VPWR VGND.t622 VPWR VPWR sg13_lv_pmos ad=0.19p pd=1.38u as=0 ps=0 w=1u l=1u
X861 VGND.t531 VPWR VGND.t531 VGND.t561 sg13_lv_nmos ad=79.8f pd=0.8u as=0 ps=0 w=0.42u l=1u
X862 VGND.t393 VPWR VGND.t393 VGND.t395 sg13_lv_nmos ad=79.8f pd=0.8u as=0 ps=0 w=0.42u l=1u
X863 VPWR VGND.t967 VPWR VPWR sg13_lv_pmos ad=0.19p pd=1.38u as=0 ps=0 w=1u l=1u
X864 VPWR VGND.t198 VPWR VPWR sg13_lv_pmos ad=0.34p pd=2.68u as=0 ps=0 w=1u l=1u
X865 VGND.t707 VPWR VGND.t707 VGND.t711 sg13_lv_nmos ad=0.1428p pd=1.52u as=0 ps=0 w=0.42u l=1u
X866 VGND.t622 VPWR VGND.t622 VGND.t651 sg13_lv_nmos ad=79.8f pd=0.8u as=0 ps=0 w=0.42u l=1u
X867 VPWR VGND.t622 VPWR VPWR sg13_lv_pmos ad=0.34p pd=2.68u as=0 ps=0 w=1u l=1u
X868 VPWR VGND.t927 VPWR VPWR sg13_lv_pmos ad=0.19p pd=1.38u as=0 ps=0 w=1u l=1u
X869 VGND.t121 VPWR VGND.t121 VGND.t123 sg13_lv_nmos ad=79.8f pd=0.8u as=0 ps=0 w=0.42u l=1u
X870 VGND.t531 VPWR VGND.t531 VGND.t557 sg13_lv_nmos ad=79.8f pd=0.8u as=0 ps=0 w=0.42u l=1u
X871 VPWR VGND.t28 VPWR VPWR sg13_lv_pmos ad=0.34p pd=2.68u as=0 ps=0 w=1u l=1u
X872 sg13cmos5l_and2_1_0.B sg13cmos5l_inv_1_1.Y VPWR VPWR sg13_lv_pmos ad=0.2128p pd=1.5u as=0.2128p ps=1.5u w=1.12u l=0.13u
X873 VGND.t412 VPWR VGND.t412 VGND.t414 sg13_lv_nmos ad=79.8f pd=0.8u as=0 ps=0 w=0.42u l=1u
X874 VGND.t15 sg13cmos5l_inv_16_2.A sg13cmos5l_inv_16_2.Y VGND.t21 sg13_lv_nmos ad=0.1406p pd=1.12u as=0.1406p ps=1.12u w=0.74u l=0.13u
X875 VPWR VGND.t398 VPWR VPWR sg13_lv_pmos ad=0.34p pd=2.68u as=0 ps=0 w=1u l=1u
X876 VPWR VGND.t831 VPWR VPWR sg13_lv_pmos ad=0.34p pd=2.68u as=0 ps=0 w=1u l=1u
X877 VGND.t622 VPWR VGND.t622 VGND.t659 sg13_lv_nmos ad=79.8f pd=0.8u as=0 ps=0 w=0.42u l=1u
X878 VPWR VGND.t947 VPWR VPWR sg13_lv_pmos ad=0.19p pd=1.38u as=0 ps=0 w=1u l=1u
X879 VPWR VGND.t622 VPWR VPWR sg13_lv_pmos ad=0.34p pd=2.68u as=0 ps=0 w=1u l=1u
X880 VGND.t574 VPWR VGND.t574 VGND.t576 sg13_lv_nmos ad=79.8f pd=0.8u as=0 ps=0 w=0.42u l=1u
X881 VPWR VGND.t474 VPWR VPWR sg13_lv_pmos ad=0.34p pd=2.68u as=0 ps=0 w=1u l=1u
X882 sg13cmos5l_inv_1_3.A sg13cmos5l_and2_1_0.X VPWR VPWR sg13_lv_pmos ad=0.2128p pd=1.5u as=0.2128p ps=1.5u w=1.12u l=0.13u
X883 sg13cmos5l_and2_1_0.B sg13cmos5l_inv_1_1.Y VPWR VPWR sg13_lv_pmos ad=0.2128p pd=1.5u as=0.2128p ps=1.5u w=1.12u l=0.13u
X884 VGND.t329 VPWR VGND.t329 VGND.t330 sg13_lv_nmos ad=79.8f pd=0.8u as=0 ps=0 w=0.42u l=1u
X885 VGND.t622 VPWR VGND.t622 VGND.t629 sg13_lv_nmos ad=79.8f pd=0.8u as=0 ps=0 w=0.42u l=1u
X886 VGND.t551 VPWR VGND.t531 VGND.t555 sg13_lv_nmos ad=79.8f pd=0.8u as=0 ps=0 w=0.42u l=1u
X887 VPWR VGND.t622 VPWR VPWR sg13_lv_pmos ad=0.19p pd=1.38u as=0 ps=0 w=1u l=1u
X888 VPWR VGND.t64 VPWR VPWR sg13_lv_pmos ad=0.19p pd=1.38u as=0 ps=0 w=1u l=1u
X889 sg13cmos5l_inv_16_2.Y sg13cmos5l_inv_16_2.A VPWR VPWR sg13_lv_pmos ad=0.2128p pd=1.5u as=0.2128p ps=1.5u w=1.12u l=0.13u
X890 VGND.t564 VPWR VGND.t569 VGND.t568 sg13_lv_nmos ad=79.8f pd=0.8u as=0 ps=0 w=0.42u l=1u
X891 VPWR VGND.t488 VPWR VPWR sg13_lv_pmos ad=0.34p pd=2.68u as=0 ps=0 w=1u l=1u
X892 VGND.t622 VPWR VGND.t622 VGND.t640 sg13_lv_nmos ad=0.1428p pd=1.52u as=0 ps=0 w=0.42u l=1u
X893 sg13cmos5l_inv_1_3.A sg13cmos5l_and2_1_0.X VPWR VPWR sg13_lv_pmos ad=0.2128p pd=1.5u as=0.2128p ps=1.5u w=1.12u l=0.13u
X894 sg13cmos5l_inv_1_0.A sg13cmos5l_inv_1_3.Y VPWR VPWR sg13_lv_pmos ad=0.2128p pd=1.5u as=0.3808p ps=2.92u w=1.12u l=0.13u
X895 VGND.t34 sg13cmos5l_inv_1_1.Y sg13cmos5l_and2_1_0.B VGND.t36 sg13_lv_nmos ad=0.1406p pd=1.12u as=0.1406p ps=1.12u w=0.74u l=0.13u
X896 VGND.t793 VPWR VGND.t793 VGND.t796 sg13_lv_nmos ad=79.8f pd=0.8u as=0 ps=0 w=0.42u l=1u
X897 VPWR sg13cmos5l_inv_16_2.A sg13cmos5l_inv_16_2.Y VPWR sg13_lv_pmos ad=0.2128p pd=1.5u as=0.2128p ps=1.5u w=1.12u l=0.13u
X898 VPWR VGND.t64 VPWR VPWR sg13_lv_pmos ad=0.19p pd=1.38u as=0 ps=0 w=1u l=1u
X899 VGND.t622 VPWR VGND.t622 VGND.t648 sg13_lv_nmos ad=0.1428p pd=1.52u as=0 ps=0 w=0.42u l=1u
X900 VGND.t239 VPWR VGND.t239 VGND.t240 sg13_lv_nmos ad=0.1428p pd=1.52u as=0 ps=0 w=0.42u l=1u
X901 VPWR VGND.t972 VPWR VPWR sg13_lv_pmos ad=0.19p pd=1.38u as=0 ps=0 w=1u l=1u
X902 VPWR VGND.t622 VPWR VPWR sg13_lv_pmos ad=0.19p pd=1.38u as=0 ps=0 w=1u l=1u
X903 VPWR VGND.t622 VPWR VPWR sg13_lv_pmos ad=0.34p pd=2.68u as=0 ps=0 w=1u l=1u
X904 VGND.t970 VPWR VGND.t972 VGND.t971 sg13_lv_nmos ad=79.8f pd=0.8u as=0 ps=0 w=0.42u l=1u
X905 VPWR sg13cmos5l_inv_1_1.Y sg13cmos5l_and2_1_0.B VPWR sg13_lv_pmos ad=0.2128p pd=1.5u as=0.2128p ps=1.5u w=1.12u l=0.13u
X906 VPWR VGND.t150 VPWR VPWR sg13_lv_pmos ad=0.19p pd=1.38u as=0 ps=0 w=1u l=1u
X907 VGND.t324 VPWR VGND.t287 VGND.t364 sg13_lv_nmos ad=79.8f pd=0.8u as=0 ps=0 w=0.42u l=1u
X908 VGND.t622 VPWR VGND.t622 VGND.t653 sg13_lv_nmos ad=79.8f pd=0.8u as=0 ps=0 w=0.42u l=1u
X909 VPWR VGND.t329 VPWR VPWR sg13_lv_pmos ad=0.19p pd=1.38u as=0 ps=0 w=1u l=1u
X910 VGND.t622 VPWR VGND.t622 VGND.t634 sg13_lv_nmos ad=0.1428p pd=1.52u as=0 ps=0 w=0.42u l=1u
X911 VGND.t531 VPWR VGND.t531 VGND.t559 sg13_lv_nmos ad=79.8f pd=0.8u as=0 ps=0 w=0.42u l=1u
X912 VPWR VGND.t407 VPWR VPWR sg13_lv_pmos ad=0.19p pd=1.38u as=0 ps=0 w=1u l=1u
X913 VPWR VGND.t229 VPWR VPWR sg13_lv_pmos ad=0.19p pd=1.38u as=0 ps=0 w=1u l=1u
X914 VGND.t30 VPWR VGND.t30 VGND.t295 sg13_lv_nmos ad=79.8f pd=0.8u as=0 ps=0 w=0.42u l=1u
X915 VGND.t329 VPWR VGND.t329 VGND.t370 sg13_lv_nmos ad=79.8f pd=0.8u as=0 ps=0 w=0.42u l=1u
X916 VGND.t198 VPWR VGND.t198 VGND.t222 sg13_lv_nmos ad=79.8f pd=0.8u as=0 ps=0 w=0.42u l=1u
X917 VGND.t622 VPWR VGND.t622 VGND.t642 sg13_lv_nmos ad=0.1428p pd=1.52u as=0 ps=0 w=0.42u l=1u
X918 VPWR VGND.t203 VPWR VPWR sg13_lv_pmos ad=0.34p pd=2.68u as=0 ps=0 w=1u l=1u
X919 VPWR VGND.t104 VPWR VPWR sg13_lv_pmos ad=0.34p pd=2.68u as=0 ps=0 w=1u l=1u
X920 VGND.t622 VPWR VGND.t622 VGND.t623 sg13_lv_nmos ad=79.8f pd=0.8u as=0 ps=0 w=0.42u l=1u
X921 VPWR VGND.t375 VPWR VPWR sg13_lv_pmos ad=0.34p pd=2.68u as=0 ps=0 w=1u l=1u
X922 VPWR VGND.t287 VPWR VPWR sg13_lv_pmos ad=0.34p pd=2.68u as=0 ps=0 w=1u l=1u
X923 VPWR VGND.t917 VPWR VPWR sg13_lv_pmos ad=0.19p pd=1.38u as=0 ps=0 w=1u l=1u
X924 VPWR VGND.t622 VPWR VPWR sg13_lv_pmos ad=0.34p pd=2.68u as=0 ps=0 w=1u l=1u
X925 VGND.t104 VPWR VGND.t104 VGND.t117 sg13_lv_nmos ad=0.1428p pd=1.52u as=0 ps=0 w=0.42u l=1u
X926 VPWR VGND.t398 VPWR VPWR sg13_lv_pmos ad=0.19p pd=1.38u as=0 ps=0 w=1u l=1u
X927 VPWR VGND.t198 VPWR VPWR sg13_lv_pmos ad=0.34p pd=2.68u as=0 ps=0 w=1u l=1u
X928 VPWR VGND.t229 VPWR VPWR sg13_lv_pmos ad=0.34p pd=2.68u as=0 ps=0 w=1u l=1u
X929 VGND.t622 VPWR VGND.t622 VGND.t658 sg13_lv_nmos ad=0.1428p pd=1.52u as=0 ps=0 w=0.42u l=1u
X930 VPWR VGND.t314 VPWR VPWR sg13_lv_pmos ad=0.34p pd=2.68u as=0 ps=0 w=1u l=1u
X931 VPWR VGND.t944 VPWR VPWR sg13_lv_pmos ad=0.34p pd=2.68u as=0 ps=0 w=1u l=1u
X932 VGND.t198 VPWR VGND.t198 VGND.t208 sg13_lv_nmos ad=0.1428p pd=1.52u as=0 ps=0 w=0.42u l=1u
X933 VGND.t905 VPWR VGND.t907 VGND.t906 sg13_lv_nmos ad=79.8f pd=0.8u as=0 ps=0 w=0.42u l=1u
X934 VGND.t104 VPWR VGND.t104 VGND.t107 sg13_lv_nmos ad=79.8f pd=0.8u as=0 ps=0 w=0.42u l=1u
X935 VPWR VGND.t104 VPWR VPWR sg13_lv_pmos ad=0.19p pd=1.38u as=0 ps=0 w=1u l=1u
X936 VGND.t64 VPWR VGND.t64 VGND.t390 sg13_lv_nmos ad=79.8f pd=0.8u as=0 ps=0 w=0.42u l=1u
X937 VGND.t531 VPWR VGND.t531 VGND.t557 sg13_lv_nmos ad=79.8f pd=0.8u as=0 ps=0 w=0.42u l=1u
X938 VPWR VGND.t957 VPWR VPWR sg13_lv_pmos ad=0.19p pd=1.38u as=0 ps=0 w=1u l=1u
X939 sg13cmos5l_inv_16_4.Y sg13cmos5l_inv_16_4.A VPWR VPWR sg13_lv_pmos ad=0.2128p pd=1.5u as=0.2128p ps=1.5u w=1.12u l=0.13u
X940 VGND.t121 VPWR VGND.t121 VGND.t124 sg13_lv_nmos ad=0.1428p pd=1.52u as=0 ps=0 w=0.42u l=1u
X941 VGND.t5 a_8108_14442# osc VGND.t4 sg13_lv_nmos ad=0.14875p pd=1.16u as=0.2886p ps=2.26u w=0.74u l=0.13u
X942 VGND.t569 VPWR VGND.t569 VGND.t571 sg13_lv_nmos ad=79.8f pd=0.8u as=0 ps=0 w=0.42u l=1u
X943 VPWR VGND.t474 VPWR VPWR sg13_lv_pmos ad=0.34p pd=2.68u as=0 ps=0 w=1u l=1u
X944 VPWR VGND.t531 VPWR VPWR sg13_lv_pmos ad=0.34p pd=2.68u as=0 ps=0 w=1u l=1u
X945 VGND.t150 VPWR VGND.t150 VGND.t193 sg13_lv_nmos ad=0.1428p pd=1.52u as=0 ps=0 w=0.42u l=1u
X946 VGND.t793 VPWR VGND.t793 VGND.t810 sg13_lv_nmos ad=79.8f pd=0.8u as=0 ps=0 w=0.42u l=1u
X947 VGND.t622 VPWR VGND.t622 VGND.t628 sg13_lv_nmos ad=0.1428p pd=1.52u as=0 ps=0 w=0.42u l=1u
X948 VGND.t462 VPWR VGND.t466 VGND.t465 sg13_lv_nmos ad=79.8f pd=0.8u as=0 ps=0 w=0.42u l=1u
X949 VPWR VGND.t216 VPWR VPWR sg13_lv_pmos ad=0.19p pd=1.38u as=0 ps=0 w=1u l=1u
X950 VGND.t574 VPWR VGND.t574 VGND.t576 sg13_lv_nmos ad=79.8f pd=0.8u as=0 ps=0 w=0.42u l=1u
X951 VPWR VGND.t793 VPWR VPWR sg13_lv_pmos ad=0.19p pd=1.38u as=0 ps=0 w=1u l=1u
X952 VPWR VGND.t393 VPWR VPWR sg13_lv_pmos ad=0.19p pd=1.38u as=0 ps=0 w=1u l=1u
X953 VGND.t622 VPWR VGND.t622 VGND.t636 sg13_lv_nmos ad=0.1428p pd=1.52u as=0 ps=0 w=0.42u l=1u
X954 VGND.t484 VPWR VGND.t484 VGND.t522 sg13_lv_nmos ad=0.1428p pd=1.52u as=0 ps=0 w=0.42u l=1u
X955 VGND.t900 VPWR VGND.t902 VGND.t901 sg13_lv_nmos ad=79.8f pd=0.8u as=0 ps=0 w=0.42u l=1u
X956 VGND.t104 VPWR VGND.t104 VGND.t178 sg13_lv_nmos ad=79.8f pd=0.8u as=0 ps=0 w=0.42u l=1u
X957 VPWR VGND.t902 VPWR VPWR sg13_lv_pmos ad=0.19p pd=1.38u as=0 ps=0 w=1u l=1u
X958 VPWR VGND.t622 VPWR VPWR sg13_lv_pmos ad=0.34p pd=2.68u as=0 ps=0 w=1u l=1u
X959 VGND.t375 VPWR VGND.t375 VGND.t377 sg13_lv_nmos ad=0.1428p pd=1.52u as=0 ps=0 w=0.42u l=1u
X960 VGND.t393 VPWR VGND.t393 VGND.t396 sg13_lv_nmos ad=0.1428p pd=1.52u as=0 ps=0 w=0.42u l=1u
X961 VPWR VGND.t314 VPWR VPWR sg13_lv_pmos ad=0.34p pd=2.68u as=0 ps=0 w=1u l=1u
X962 VPWR VGND.t198 VPWR VPWR sg13_lv_pmos ad=0.34p pd=2.68u as=0 ps=0 w=1u l=1u
X963 VPWR VGND.t622 VPWR VPWR sg13_lv_pmos ad=0.34p pd=2.68u as=0 ps=0 w=1u l=1u
X964 VPWR VGND.t407 VPWR VPWR sg13_lv_pmos ad=0.19p pd=1.38u as=0 ps=0 w=1u l=1u
X965 VGND.t531 VPWR VGND.t531 VGND.t546 sg13_lv_nmos ad=79.8f pd=0.8u as=0 ps=0 w=0.42u l=1u
X966 VPWR VGND.t531 VPWR VPWR sg13_lv_pmos ad=0.19p pd=1.38u as=0 ps=0 w=1u l=1u
X967 VGND.t564 VPWR VGND.t569 VGND.t568 sg13_lv_nmos ad=79.8f pd=0.8u as=0 ps=0 w=0.42u l=1u
X968 VGND.t622 VPWR VGND.t622 VGND.t644 sg13_lv_nmos ad=0.1428p pd=1.52u as=0 ps=0 w=0.42u l=1u
X969 VGND.t531 VPWR VGND.t531 VGND.t558 sg13_lv_nmos ad=0.1428p pd=1.52u as=0 ps=0 w=0.42u l=1u
X970 VGND.t622 VPWR VGND.t622 VGND.t652 sg13_lv_nmos ad=0.1428p pd=1.52u as=0 ps=0 w=0.42u l=1u
X971 VPWR VGND.t104 VPWR VPWR sg13_lv_pmos ad=0.34p pd=2.68u as=0 ps=0 w=1u l=1u
X972 VGND.t104 VPWR VGND.t104 VGND.t130 sg13_lv_nmos ad=0.1428p pd=1.52u as=0 ps=0 w=0.42u l=1u
X973 VPWR VGND.t622 VPWR VPWR sg13_lv_pmos ad=0.34p pd=2.68u as=0 ps=0 w=1u l=1u
X974 VGND.t531 VPWR VGND.t564 VGND.t563 sg13_lv_nmos ad=79.8f pd=0.8u as=0 ps=0 w=0.42u l=1u
X975 VGND.t802 VPWR VGND.t793 VGND.t804 sg13_lv_nmos ad=79.8f pd=0.8u as=0 ps=0 w=0.42u l=1u
X976 VGND.t707 VPWR VGND.t707 VGND.t706 sg13_lv_nmos ad=0.1428p pd=1.52u as=0 ps=0 w=0.42u l=1u
X977 VPWR VGND.t398 VPWR VPWR sg13_lv_pmos ad=0.19p pd=1.38u as=0 ps=0 w=1u l=1u
X978 VGND.t407 VPWR VGND.t412 VGND.t411 sg13_lv_nmos ad=79.8f pd=0.8u as=0 ps=0 w=0.42u l=1u
X979 VGND.t622 VPWR VGND.t622 VGND.t660 sg13_lv_nmos ad=0.1428p pd=1.52u as=0 ps=0 w=0.42u l=1u
X980 VPWR VGND.t949 VPWR VPWR sg13_lv_pmos ad=0.34p pd=2.68u as=0 ps=0 w=1u l=1u
X981 VPWR VGND.t104 VPWR VPWR sg13_lv_pmos ad=0.34p pd=2.68u as=0 ps=0 w=1u l=1u
X982 VPWR VGND.t324 VPWR VPWR sg13_lv_pmos ad=0.34p pd=2.68u as=0 ps=0 w=1u l=1u
X983 VPWR VGND.t531 VPWR VPWR sg13_lv_pmos ad=0.19p pd=1.38u as=0 ps=0 w=1u l=1u
X984 VGND.t531 VPWR VGND.t531 VGND.t559 sg13_lv_nmos ad=79.8f pd=0.8u as=0 ps=0 w=0.42u l=1u
X985 VGND.t198 VPWR VGND.t198 VGND.t226 sg13_lv_nmos ad=79.8f pd=0.8u as=0 ps=0 w=0.42u l=1u
X986 VGND.t713 VPWR VGND.t713 VGND.t735 sg13_lv_nmos ad=79.8f pd=0.8u as=0 ps=0 w=0.42u l=1u
X987 VPWR VGND.t962 VPWR VPWR sg13_lv_pmos ad=0.19p pd=1.38u as=0 ps=0 w=1u l=1u
X988 VGND.t15 sg13cmos5l_inv_16_4.A sg13cmos5l_inv_16_4.Y VGND.t95 sg13_lv_nmos ad=0.1406p pd=1.12u as=0.1406p ps=1.12u w=0.74u l=0.13u
X989 VPWR VGND.t622 VPWR VPWR sg13_lv_pmos ad=0.19p pd=1.38u as=0 ps=0 w=1u l=1u
X990 VGND.t3 sg13cmos5l_inv_1_3.Y sg13cmos5l_inv_1_0.A VGND.t83 sg13_lv_nmos ad=0.1406p pd=1.12u as=0.1406p ps=1.12u w=0.74u l=0.13u
X991 VGND.t569 VPWR VGND.t574 VGND.t573 sg13_lv_nmos ad=79.8f pd=0.8u as=0 ps=0 w=0.42u l=1u
X992 VGND.t203 VPWR VGND.t198 VGND.t207 sg13_lv_nmos ad=79.8f pd=0.8u as=0 ps=0 w=0.42u l=1u
X993 VGND.t137 VPWR VGND.t137 VGND.t186 sg13_lv_nmos ad=79.8f pd=0.8u as=0 ps=0 w=0.42u l=1u
X994 VGND.t793 VPWR VGND.t813 VGND.t812 sg13_lv_nmos ad=79.8f pd=0.8u as=0 ps=0 w=0.42u l=1u
X995 VGND.t622 VPWR VGND.t622 VGND.t630 sg13_lv_nmos ad=0.1428p pd=1.52u as=0 ps=0 w=0.42u l=1u
X996 VPWR VGND.t622 VPWR VPWR sg13_lv_pmos ad=0.34p pd=2.68u as=0 ps=0 w=1u l=1u
X997 VGND.t468 VPWR VGND.t468 VGND.t469 sg13_lv_nmos ad=79.8f pd=0.8u as=0 ps=0 w=0.42u l=1u
X998 VPWR VGND.t531 VPWR VPWR sg13_lv_pmos ad=0.19p pd=1.38u as=0 ps=0 w=1u l=1u
X999 sg13cmos5l_inv_16_4.Y sg13cmos5l_inv_16_4.A VGND.t10 VGND.t92 sg13_lv_nmos ad=0.1406p pd=1.12u as=0.1406p ps=1.12u w=0.74u l=0.13u
X1000 VPWR VGND.t934 VPWR VPWR sg13_lv_pmos ad=0.34p pd=2.68u as=0 ps=0 w=1u l=1u
X1001 VGND.t314 VPWR VGND.t314 VGND.t316 sg13_lv_nmos ad=0.1428p pd=1.52u as=0 ps=0 w=0.42u l=1u
X1002 VGND.t3 sg13cmos5l_inv_16_2.Y sg13cmos5l_inv_16_4.A VGND.t69 sg13_lv_nmos ad=0.2516p pd=2.16u as=0.2516p ps=2.16u w=0.74u l=0.13u
X1003 VPWR VGND.t41 VPWR VPWR sg13_lv_pmos ad=0.19p pd=1.38u as=0 ps=0 w=1u l=1u
X1004 VPWR VGND.t198 VPWR VPWR sg13_lv_pmos ad=0.19p pd=1.38u as=0 ps=0 w=1u l=1u
X1005 VGND.t622 VPWR VGND.t622 VGND.t638 sg13_lv_nmos ad=0.1428p pd=1.52u as=0 ps=0 w=0.42u l=1u
X1006 VGND.t147 VPWR VGND.t150 VGND.t192 sg13_lv_nmos ad=79.8f pd=0.8u as=0 ps=0 w=0.42u l=1u
X1007 VPWR sg13cmos5l_inv_1_1.Y sg13cmos5l_and2_1_0.B VPWR sg13_lv_pmos ad=0.2128p pd=1.5u as=0.2128p ps=1.5u w=1.12u l=0.13u
X1008 VGND.t329 VPWR VGND.t329 VGND.t372 sg13_lv_nmos ad=79.8f pd=0.8u as=0 ps=0 w=0.42u l=1u
X1009 VGND.t488 VPWR VGND.t488 VGND.t490 sg13_lv_nmos ad=79.8f pd=0.8u as=0 ps=0 w=0.42u l=1u
X1010 VPWR VGND.t393 VPWR VPWR sg13_lv_pmos ad=0.34p pd=2.68u as=0 ps=0 w=1u l=1u
X1011 VPWR VGND.t622 VPWR VPWR sg13_lv_pmos ad=0.34p pd=2.68u as=0 ps=0 w=1u l=1u
X1012 VPWR VGND.t974 VPWR VPWR sg13_lv_pmos ad=0.34p pd=2.68u as=0 ps=0 w=1u l=1u
X1013 VPWR VGND.t622 VPWR VPWR sg13_lv_pmos ad=0.34p pd=2.68u as=0 ps=0 w=1u l=1u
X1014 VPWR VGND.t398 VPWR VPWR sg13_lv_pmos ad=0.19p pd=1.38u as=0 ps=0 w=1u l=1u
X1015 VGND.t398 VPWR VGND.t398 VGND.t404 sg13_lv_nmos ad=79.8f pd=0.8u as=0 ps=0 w=0.42u l=1u
X1016 VGND.t569 VPWR VGND.t569 VGND.t571 sg13_lv_nmos ad=79.8f pd=0.8u as=0 ps=0 w=0.42u l=1u
X1017 VPWR VGND.t198 VPWR VPWR sg13_lv_pmos ad=0.34p pd=2.68u as=0 ps=0 w=1u l=1u
X1018 VPWR VGND.t234 VPWR VPWR sg13_lv_pmos ad=0.34p pd=2.68u as=0 ps=0 w=1u l=1u
X1019 VPWR sg13cmos5l_and2_1_0.X sg13cmos5l_inv_1_3.A VPWR sg13_lv_pmos ad=0.2128p pd=1.5u as=0.2128p ps=1.5u w=1.12u l=0.13u
X1020 VPWR VGND.t324 VPWR VPWR sg13_lv_pmos ad=0.19p pd=1.38u as=0 ps=0 w=1u l=1u
X1021 VGND.t531 VPWR VGND.t531 VGND.t560 sg13_lv_nmos ad=0.1428p pd=1.52u as=0 ps=0 w=0.42u l=1u
X1022 VGND.t314 VPWR VGND.t314 VGND.t359 sg13_lv_nmos ad=0.1428p pd=1.52u as=0 ps=0 w=0.42u l=1u
X1023 VGND.t713 VPWR VGND.t713 VGND.t729 sg13_lv_nmos ad=79.8f pd=0.8u as=0 ps=0 w=0.42u l=1u
X1024 VGND.t622 VPWR VGND.t622 VGND.t654 sg13_lv_nmos ad=0.1428p pd=1.52u as=0 ps=0 w=0.42u l=1u
X1025 VGND.t104 VPWR VGND.t104 VGND.t109 sg13_lv_nmos ad=79.8f pd=0.8u as=0 ps=0 w=0.42u l=1u
X1026 VGND.t474 VPWR VGND.t482 VGND.t481 sg13_lv_nmos ad=79.8f pd=0.8u as=0 ps=0 w=0.42u l=1u
X1027 VGND.t564 VPWR VGND.t564 VGND.t566 sg13_lv_nmos ad=79.8f pd=0.8u as=0 ps=0 w=0.42u l=1u
X1028 VGND.t793 VPWR VGND.t793 VGND.t806 sg13_lv_nmos ad=79.8f pd=0.8u as=0 ps=0 w=0.42u l=1u
X1029 VGND.t970 VPWR VGND.t969 VGND.t968 sg13_lv_nmos ad=0.1428p pd=1.52u as=0 ps=0 w=0.42u l=1u
X1030 VGND.t28 VPWR VGND.t28 VGND.t460 sg13_lv_nmos ad=79.8f pd=0.8u as=0 ps=0 w=0.42u l=1u
X1031 VGND.t622 VPWR VGND.t622 VGND.t662 sg13_lv_nmos ad=0.1428p pd=1.52u as=0 ps=0 w=0.42u l=1u
X1032 VPWR VGND.t919 VPWR VPWR sg13_lv_pmos ad=0.34p pd=2.68u as=0 ps=0 w=1u l=1u
X1033 VPWR sg13cmos5l_inv_1_3.Y sg13cmos5l_inv_1_0.A VPWR sg13_lv_pmos ad=0.2128p pd=1.5u as=0.2128p ps=1.5u w=1.12u l=0.13u
X1034 VGND.t112 VPWR VGND.t104 VGND.t116 sg13_lv_nmos ad=79.8f pd=0.8u as=0 ps=0 w=0.42u l=1u
X1035 VPWR VGND.t216 VPWR VPWR sg13_lv_pmos ad=0.19p pd=1.38u as=0 ps=0 w=1u l=1u
X1036 VPWR VGND.t381 VPWR VPWR sg13_lv_pmos ad=0.19p pd=1.38u as=0 ps=0 w=1u l=1u
X1037 VPWR VGND.t531 VPWR VPWR sg13_lv_pmos ad=0.19p pd=1.38u as=0 ps=0 w=1u l=1u
X1038 VGND.t531 VPWR VGND.t531 VGND.t546 sg13_lv_nmos ad=79.8f pd=0.8u as=0 ps=0 w=0.42u l=1u
X1039 VGND.t551 VPWR VGND.t551 VGND.t554 sg13_lv_nmos ad=0.1428p pd=1.52u as=0 ps=0 w=0.42u l=1u
X1040 VPWR sg13cmos5l_and2_1_0.X sg13cmos5l_inv_1_3.A VPWR sg13_lv_pmos ad=0.2128p pd=1.5u as=0.2128p ps=1.5u w=1.12u l=0.13u
X1041 VPWR VGND.t622 VPWR VPWR sg13_lv_pmos ad=0.34p pd=2.68u as=0 ps=0 w=1u l=1u
X1042 sg13cmos5l_inv_1_0.A sg13cmos5l_inv_1_3.Y VPWR VPWR sg13_lv_pmos ad=0.2128p pd=1.5u as=0.2128p ps=1.5u w=1.12u l=0.13u
X1043 VGND.t622 VPWR VGND.t622 VGND.t632 sg13_lv_nmos ad=0.1428p pd=1.52u as=0 ps=0 w=0.42u l=1u
X1044 VGND.t531 VPWR VGND.t531 VGND.t558 sg13_lv_nmos ad=0.1428p pd=1.52u as=0 ps=0 w=0.42u l=1u
X1045 VGND.t793 VPWR VGND.t799 VGND.t798 sg13_lv_nmos ad=79.8f pd=0.8u as=0 ps=0 w=0.42u l=1u
X1046 VPWR VGND.t531 VPWR VPWR sg13_lv_pmos ad=0.19p pd=1.38u as=0 ps=0 w=1u l=1u
X1047 VPWR VGND.t574 VPWR VPWR sg13_lv_pmos ad=0.19p pd=1.38u as=0 ps=0 w=1u l=1u
X1048 VGND.t531 VPWR VGND.t564 VGND.t563 sg13_lv_nmos ad=79.8f pd=0.8u as=0 ps=0 w=0.42u l=1u
X1049 VGND.t569 VPWR VGND.t569 VGND.t572 sg13_lv_nmos ad=0.1428p pd=1.52u as=0 ps=0 w=0.42u l=1u
X1050 VPWR sg13cmos5l_inv_1_3.Y sg13cmos5l_inv_1_0.A VPWR sg13_lv_pmos ad=0.2128p pd=1.5u as=0.2128p ps=1.5u w=1.12u l=0.13u
X1051 VPWR VGND.t393 VPWR VPWR sg13_lv_pmos ad=0.34p pd=2.68u as=0 ps=0 w=1u l=1u
X1052 VGND.t314 VPWR VGND.t322 VGND.t321 sg13_lv_nmos ad=79.8f pd=0.8u as=0 ps=0 w=0.42u l=1u
X1053 sg13cmos5l_and2_1_0.X a_3885_9540# VPWR VPWR sg13_lv_pmos ad=0.3808p pd=2.92u as=0.1918p ps=1.5u w=1.12u l=0.13u
X1054 VGND.t713 VPWR VGND.t713 VGND.t723 sg13_lv_nmos ad=79.8f pd=0.8u as=0 ps=0 w=0.42u l=1u
X1055 VPWR VGND.t979 VPWR VPWR sg13_lv_pmos ad=0.34p pd=2.68u as=0 ps=0 w=1u l=1u
X1056 VPWR VGND.t622 VPWR VPWR sg13_lv_pmos ad=0.34p pd=2.68u as=0 ps=0 w=1u l=1u
X1057 VPWR VGND.t537 VPWR VPWR sg13_lv_pmos ad=0.19p pd=1.38u as=0 ps=0 w=1u l=1u
X1058 VPWR VGND.t474 VPWR VPWR sg13_lv_pmos ad=0.19p pd=1.38u as=0 ps=0 w=1u l=1u
X1059 VPWR VGND.t398 VPWR VPWR sg13_lv_pmos ad=0.19p pd=1.38u as=0 ps=0 w=1u l=1u
X1060 VPWR VGND.t64 VPWR VPWR sg13_lv_pmos ad=0.34p pd=2.68u as=0 ps=0 w=1u l=1u
X1061 VPWR VGND.t569 VPWR VPWR sg13_lv_pmos ad=0.19p pd=1.38u as=0 ps=0 w=1u l=1u
X1062 VGND.t569 VPWR VGND.t574 VGND.t573 sg13_lv_nmos ad=79.8f pd=0.8u as=0 ps=0 w=0.42u l=1u
X1063 VPWR VGND.t551 VPWR VPWR sg13_lv_pmos ad=0.19p pd=1.38u as=0 ps=0 w=1u l=1u
X1064 VGND.t287 VPWR VGND.t287 VGND.t290 sg13_lv_nmos ad=79.8f pd=0.8u as=0 ps=0 w=0.42u l=1u
X1065 VGND.t713 VPWR VGND.t713 VGND.t731 sg13_lv_nmos ad=79.8f pd=0.8u as=0 ps=0 w=0.42u l=1u
X1066 VGND.t531 VPWR VGND.t531 VGND.t547 sg13_lv_nmos ad=0.1428p pd=1.52u as=0 ps=0 w=0.42u l=1u
X1067 VPWR VGND.t104 VPWR VPWR sg13_lv_pmos ad=0.34p pd=2.68u as=0 ps=0 w=1u l=1u
X1068 sg13cmos5l_inv_1_3.Y sg13cmos5l_inv_1_3.A VGND.t1 VGND.t0 sg13_lv_nmos ad=0.2516p pd=2.16u as=0.2516p ps=2.16u w=0.74u l=0.13u
X1069 VPWR VGND.t64 VPWR VPWR sg13_lv_pmos ad=0.34p pd=2.68u as=0 ps=0 w=1u l=1u
X1070 VGND.t622 VPWR VGND.t622 VGND.t626 sg13_lv_nmos ad=0.1428p pd=1.52u as=0 ps=0 w=0.42u l=1u
X1071 VGND.t622 VPWR VGND.t622 VGND.t650 sg13_lv_nmos ad=0.1428p pd=1.52u as=0 ps=0 w=0.42u l=1u
X1072 VPWR VGND.t924 VPWR VPWR sg13_lv_pmos ad=0.34p pd=2.68u as=0 ps=0 w=1u l=1u
X1073 VGND.t713 VPWR VGND.t713 VGND.t747 sg13_lv_nmos ad=79.8f pd=0.8u as=0 ps=0 w=0.42u l=1u
X1074 VPWR VGND.t329 VPWR VPWR sg13_lv_pmos ad=0.34p pd=2.68u as=0 ps=0 w=1u l=1u
X1075 sg13cmos5l_inv_16_4.Y sg13cmos5l_inv_16_4.A VPWR VPWR sg13_lv_pmos ad=0.2128p pd=1.5u as=0.2128p ps=1.5u w=1.12u l=0.13u
X1076 VPWR VGND.t531 VPWR VPWR sg13_lv_pmos ad=0.19p pd=1.38u as=0 ps=0 w=1u l=1u
X1077 VPWR VGND.t793 VPWR VPWR sg13_lv_pmos ad=0.19p pd=1.38u as=0 ps=0 w=1u l=1u
X1078 VGND.t531 VPWR VGND.t531 VGND.t556 sg13_lv_nmos ad=0.1428p pd=1.52u as=0 ps=0 w=0.42u l=1u
X1079 VPWR VGND.t407 VPWR VPWR sg13_lv_pmos ad=0.34p pd=2.68u as=0 ps=0 w=1u l=1u
X1080 VGND.t412 VPWR VGND.t412 VGND.t413 sg13_lv_nmos ad=0.1428p pd=1.52u as=0 ps=0 w=0.42u l=1u
X1081 VGND.t287 VPWR VGND.t287 VGND.t288 sg13_lv_nmos ad=79.8f pd=0.8u as=0 ps=0 w=0.42u l=1u
X1082 VGND.t150 VPWR VGND.t150 VGND.t194 sg13_lv_nmos ad=79.8f pd=0.8u as=0 ps=0 w=0.42u l=1u
X1083 VGND.t975 VPWR VGND.t974 VGND.t973 sg13_lv_nmos ad=0.1428p pd=1.52u as=0 ps=0 w=0.42u l=1u
X1084 VGND.t531 VPWR VGND.t531 VGND.t560 sg13_lv_nmos ad=0.1428p pd=1.52u as=0 ps=0 w=0.42u l=1u
X1085 VPWR sg13cmos5l_inv_16_4.A sg13cmos5l_inv_16_4.Y VPWR sg13_lv_pmos ad=0.2128p pd=1.5u as=0.2128p ps=1.5u w=1.12u l=0.13u
X1086 VGND.t799 VPWR VGND.t802 VGND.t801 sg13_lv_nmos ad=79.8f pd=0.8u as=0 ps=0 w=0.42u l=1u
X1087 VGND.t143 VPWR VGND.t143 VGND.t144 sg13_lv_nmos ad=79.8f pd=0.8u as=0 ps=0 w=0.42u l=1u
X1088 VGND.t713 VPWR VGND.t713 VGND.t717 sg13_lv_nmos ad=79.8f pd=0.8u as=0 ps=0 w=0.42u l=1u
X1089 VPWR VGND.t964 VPWR VPWR sg13_lv_pmos ad=0.34p pd=2.68u as=0 ps=0 w=1u l=1u
X1090 VPWR VGND.t622 VPWR VPWR sg13_lv_pmos ad=0.34p pd=2.68u as=0 ps=0 w=1u l=1u
X1091 VPWR VGND.t713 VPWR VPWR sg13_lv_pmos ad=0.19p pd=1.38u as=0 ps=0 w=1u l=1u
X1092 VPWR VGND.t314 VPWR VPWR sg13_lv_pmos ad=0.19p pd=1.38u as=0 ps=0 w=1u l=1u
X1093 VGND.t564 VPWR VGND.t564 VGND.t566 sg13_lv_nmos ad=79.8f pd=0.8u as=0 ps=0 w=0.42u l=1u
X1094 VGND.t713 VPWR VGND.t713 VGND.t741 sg13_lv_nmos ad=79.8f pd=0.8u as=0 ps=0 w=0.42u l=1u
X1095 VGND.t574 VPWR VGND.t574 VGND.t575 sg13_lv_nmos ad=0.1428p pd=1.52u as=0 ps=0 w=0.42u l=1u
X1096 VGND.t198 VPWR VGND.t198 VGND.t221 sg13_lv_nmos ad=0.1428p pd=1.52u as=0 ps=0 w=0.42u l=1u
X1097 VGND.t813 VPWR VGND.t813 VGND.t814 sg13_lv_nmos ad=0.1428p pd=1.52u as=0 ps=0 w=0.42u l=1u
X1098 VGND.t104 VPWR VGND.t104 VGND.t110 sg13_lv_nmos ad=0.1428p pd=1.52u as=0 ps=0 w=0.42u l=1u
X1099 VGND.t468 VPWR VGND.t468 VGND.t470 sg13_lv_nmos ad=0.1428p pd=1.52u as=0 ps=0 w=0.42u l=1u
X1100 VGND.t198 VPWR VGND.t198 VGND.t201 sg13_lv_nmos ad=0.1428p pd=1.52u as=0 ps=0 w=0.42u l=1u
X1101 VGND.t104 VPWR VGND.t104 VGND.t181 sg13_lv_nmos ad=0.1428p pd=1.52u as=0 ps=0 w=0.42u l=1u
X1102 VPWR VGND.t314 VPWR VPWR sg13_lv_pmos ad=0.19p pd=1.38u as=0 ps=0 w=1u l=1u
X1103 VPWR VGND.t112 VPWR VPWR sg13_lv_pmos ad=0.19p pd=1.38u as=0 ps=0 w=1u l=1u
X1104 VGND.t474 VPWR VGND.t474 VGND.t477 sg13_lv_nmos ad=79.8f pd=0.8u as=0 ps=0 w=0.42u l=1u
X1105 VGND.t551 VPWR VGND.t551 VGND.t554 sg13_lv_nmos ad=0.1428p pd=1.52u as=0 ps=0 w=0.42u l=1u
X1106 VGND.t713 VPWR VGND.t713 VGND.t725 sg13_lv_nmos ad=79.8f pd=0.8u as=0 ps=0 w=0.42u l=1u
X1107 VPWR VGND.t984 VPWR VPWR sg13_lv_pmos ad=0.34p pd=2.68u as=0 ps=0 w=1u l=1u
X1108 VPWR VGND.t622 VPWR VPWR sg13_lv_pmos ad=0.34p pd=2.68u as=0 ps=0 w=1u l=1u
X1109 VPWR VGND.t34 VPWR VPWR sg13_lv_pmos ad=0.34p pd=2.68u as=0 ps=0 w=1u l=1u
X1110 VPWR VGND.t569 VPWR VPWR sg13_lv_pmos ad=0.19p pd=1.38u as=0 ps=0 w=1u l=1u
X1111 VPWR VGND.t198 VPWR VPWR sg13_lv_pmos ad=0.34p pd=2.68u as=0 ps=0 w=1u l=1u
X1112 VGND.t793 VPWR VGND.t793 VGND.t807 sg13_lv_nmos ad=0.1428p pd=1.52u as=0 ps=0 w=0.42u l=1u
X1113 VPWR VGND.t551 VPWR VPWR sg13_lv_pmos ad=0.34p pd=2.68u as=0 ps=0 w=1u l=1u
X1114 VGND.t104 VPWR VGND.t104 VGND.t118 sg13_lv_nmos ad=79.8f pd=0.8u as=0 ps=0 w=0.42u l=1u
X1115 VGND.t713 VPWR VGND.t713 VGND.t733 sg13_lv_nmos ad=79.8f pd=0.8u as=0 ps=0 w=0.42u l=1u
X1116 VGND.t531 VPWR VGND.t531 VGND.t549 sg13_lv_nmos ad=0.1428p pd=1.52u as=0 ps=0 w=0.42u l=1u
X1117 VPWR VGND.t216 VPWR VPWR sg13_lv_pmos ad=0.34p pd=2.68u as=0 ps=0 w=1u l=1u
X1118 VGND.t793 VPWR VGND.t793 VGND.t795 sg13_lv_nmos ad=0.1428p pd=1.52u as=0 ps=0 w=0.42u l=1u
X1119 VGND.t569 VPWR VGND.t569 VGND.t572 sg13_lv_nmos ad=0.1428p pd=1.52u as=0 ps=0 w=0.42u l=1u
X1120 VPWR VGND.t41 VPWR VPWR sg13_lv_pmos ad=0.34p pd=2.68u as=0 ps=0 w=1u l=1u
X1121 sg13cmos5l_inv_1_3.Y sg13cmos5l_inv_1_3.A VPWR VPWR sg13_lv_pmos ad=0.3808p pd=2.92u as=0.3808p ps=2.92u w=1.12u l=0.13u
X1122 VGND.t793 VPWR VGND.t793 VGND.t794 sg13_lv_nmos ad=79.8f pd=0.8u as=0 ps=0 w=0.42u l=1u
X1123 VPWR VGND.t713 VPWR VPWR sg13_lv_pmos ad=0.19p pd=1.38u as=0 ps=0 w=1u l=1u
X1124 VPWR VGND.t622 VPWR VPWR sg13_lv_pmos ad=0.34p pd=2.68u as=0 ps=0 w=1u l=1u
X1125 VPWR VGND.t398 VPWR VPWR sg13_lv_pmos ad=0.19p pd=1.38u as=0 ps=0 w=1u l=1u
X1126 VPWR VGND.t531 VPWR VPWR sg13_lv_pmos ad=0.19p pd=1.38u as=0 ps=0 w=1u l=1u
X1127 VPWR VGND.t407 VPWR VPWR sg13_lv_pmos ad=0.34p pd=2.68u as=0 ps=0 w=1u l=1u
X1128 VPWR VGND.t104 VPWR VPWR sg13_lv_pmos ad=0.19p pd=1.38u as=0 ps=0 w=1u l=1u
X1129 VGND.t905 VPWR VGND.t904 VGND.t903 sg13_lv_nmos ad=0.1428p pd=1.52u as=0 ps=0 w=0.42u l=1u
X1130 VPWR VGND.t531 VPWR VPWR sg13_lv_pmos ad=0.34p pd=2.68u as=0 ps=0 w=1u l=1u
X1131 VGND.t531 VPWR VGND.t531 VGND.t547 sg13_lv_nmos ad=0.1428p pd=1.52u as=0 ps=0 w=0.42u l=1u
X1132 VGND.t234 VPWR VGND.t234 VGND.t237 sg13_lv_nmos ad=0.1428p pd=1.52u as=0 ps=0 w=0.42u l=1u
X1133 VGND.t713 VPWR VGND.t713 VGND.t719 sg13_lv_nmos ad=79.8f pd=0.8u as=0 ps=0 w=0.42u l=1u
X1134 VPWR VGND.t622 VPWR VPWR sg13_lv_pmos ad=0.34p pd=2.68u as=0 ps=0 w=1u l=1u
X1135 VPWR VGND.t531 VPWR VPWR sg13_lv_pmos ad=0.19p pd=1.38u as=0 ps=0 w=1u l=1u
X1136 VPWR VGND.t564 VPWR VPWR sg13_lv_pmos ad=0.19p pd=1.38u as=0 ps=0 w=1u l=1u
X1137 VGND.t713 VPWR VGND.t713 VGND.t743 sg13_lv_nmos ad=79.8f pd=0.8u as=0 ps=0 w=0.42u l=1u
X1138 VGND.t574 VPWR VGND.t574 VGND.t577 sg13_lv_nmos ad=0.1428p pd=1.52u as=0 ps=0 w=0.42u l=1u
X1139 VGND.t799 VPWR VGND.t799 VGND.t800 sg13_lv_nmos ad=0.1428p pd=1.52u as=0 ps=0 w=0.42u l=1u
X1140 VGND.t30 sg13cmos5l_inv_1_1.Y sg13cmos5l_and2_1_0.B VGND.t31 sg13_lv_nmos ad=0.1406p pd=1.12u as=0.1406p ps=1.12u w=0.74u l=0.13u
X1141 VGND.t474 VPWR VGND.t474 VGND.t473 sg13_lv_nmos ad=0.1428p pd=1.52u as=0 ps=0 w=0.42u l=1u
X1142 VPWR VGND.t531 VPWR VPWR sg13_lv_pmos ad=0.34p pd=2.68u as=0 ps=0 w=1u l=1u
X1143 VGND.t925 VPWR VGND.t927 VGND.t926 sg13_lv_nmos ad=79.8f pd=0.8u as=0 ps=0 w=0.42u l=1u
X1144 VGND.t3 sg13cmos5l_and2_1_0.X sg13cmos5l_inv_1_3.A VGND.t55 sg13_lv_nmos ad=0.1406p pd=1.12u as=0.1406p ps=1.12u w=0.74u l=0.13u
X1145 VGND.t287 VPWR VGND.t293 VGND.t292 sg13_lv_nmos ad=79.8f pd=0.8u as=0 ps=0 w=0.42u l=1u
X1146 VGND.t474 VPWR VGND.t474 VGND.t479 sg13_lv_nmos ad=79.8f pd=0.8u as=0 ps=0 w=0.42u l=1u
X1147 VGND.t531 VPWR VGND.t531 VGND.t556 sg13_lv_nmos ad=0.1428p pd=1.52u as=0 ps=0 w=0.42u l=1u
X1148 VGND.t216 VPWR VGND.t198 VGND.t220 sg13_lv_nmos ad=79.8f pd=0.8u as=0 ps=0 w=0.42u l=1u
X1149 sg13cmos5l_inv_16_4.Y sg13cmos5l_inv_16_4.A VGND.t15 VGND.t98 sg13_lv_nmos ad=0.1406p pd=1.12u as=0.1406p ps=1.12u w=0.74u l=0.13u
X1150 VGND.t707 VPWR VGND.t713 VGND.t712 sg13_lv_nmos ad=79.8f pd=0.8u as=0 ps=0 w=0.42u l=1u
X1151 VPWR VGND.t954 VPWR VPWR sg13_lv_pmos ad=0.34p pd=2.68u as=0 ps=0 w=1u l=1u
X1152 VGND.t375 VPWR VGND.t375 VGND.t378 sg13_lv_nmos ad=79.8f pd=0.8u as=0 ps=0 w=0.42u l=1u
X1153 VGND.t234 VPWR VGND.t234 VGND.t235 sg13_lv_nmos ad=0.1428p pd=1.52u as=0 ps=0 w=0.42u l=1u
X1154 VGND.t449 VPWR VGND.t449 VGND.t497 sg13_lv_nmos ad=79.8f pd=0.8u as=0 ps=0 w=0.42u l=1u
X1155 VPWR VGND.t104 VPWR VPWR sg13_lv_pmos ad=0.34p pd=2.68u as=0 ps=0 w=1u l=1u
X1156 VPWR VGND.t540 VPWR VPWR sg13_lv_pmos ad=0.19p pd=1.38u as=0 ps=0 w=1u l=1u
X1157 VGND.t713 VPWR VGND.t713 VGND.t721 sg13_lv_nmos ad=79.8f pd=0.8u as=0 ps=0 w=0.42u l=1u
X1158 VPWR VGND.t537 VPWR VPWR sg13_lv_pmos ad=0.34p pd=2.68u as=0 ps=0 w=1u l=1u
X1159 VPWR VGND.t398 VPWR VPWR sg13_lv_pmos ad=0.34p pd=2.68u as=0 ps=0 w=1u l=1u
X1160 VGND.t574 VPWR VGND.t574 VGND.t575 sg13_lv_nmos ad=0.1428p pd=1.52u as=0 ps=0 w=0.42u l=1u
X1161 VGND.t407 VPWR VGND.t407 VGND.t408 sg13_lv_nmos ad=0.1428p pd=1.52u as=0 ps=0 w=0.42u l=1u
X1162 VPWR VGND.t34 VPWR VPWR sg13_lv_pmos ad=0.19p pd=1.38u as=0 ps=0 w=1u l=1u
X1163 VGND.t203 VPWR VGND.t203 VGND.t206 sg13_lv_nmos ad=0.1428p pd=1.52u as=0 ps=0 w=0.42u l=1u
X1164 VPWR VGND.t622 VPWR VPWR sg13_lv_pmos ad=0.19p pd=1.38u as=0 ps=0 w=1u l=1u
X1165 VGND.t713 VPWR VGND.t713 VGND.t732 sg13_lv_nmos ad=0.1428p pd=1.52u as=0 ps=0 w=0.42u l=1u
X1166 VGND.t216 VPWR VGND.t216 VGND.t218 sg13_lv_nmos ad=79.8f pd=0.8u as=0 ps=0 w=0.42u l=1u
X1167 VPWR sg13cmos5l_inv_1_3.Y sg13cmos5l_inv_1_0.A VPWR sg13_lv_pmos ad=0.4368p pd=3.02u as=0.2128p ps=1.5u w=1.12u l=0.13u
X1168 VGND.t329 VPWR VGND.t329 VGND.t366 sg13_lv_nmos ad=79.8f pd=0.8u as=0 ps=0 w=0.42u l=1u
X1169 VGND.t826 VPWR VGND.t826 VGND.t827 sg13_lv_nmos ad=0.1428p pd=1.52u as=0 ps=0 w=0.42u l=1u
X1170 VPWR VGND.t198 VPWR VPWR sg13_lv_pmos ad=0.19p pd=1.38u as=0 ps=0 w=1u l=1u
X1171 VPWR VGND.t713 VPWR VPWR sg13_lv_pmos ad=0.19p pd=1.38u as=0 ps=0 w=1u l=1u
X1172 VGND.t484 VPWR VGND.t484 VGND.t486 sg13_lv_nmos ad=0.1428p pd=1.52u as=0 ps=0 w=0.42u l=1u
X1173 VGND.t713 VPWR VGND.t713 VGND.t737 sg13_lv_nmos ad=79.8f pd=0.8u as=0 ps=0 w=0.42u l=1u
X1174 VPWR VGND.t412 VPWR VPWR sg13_lv_pmos ad=0.34p pd=2.68u as=0 ps=0 w=1u l=1u
X1175 VPWR VGND.t239 VPWR VPWR sg13_lv_pmos ad=0.34p pd=2.68u as=0 ps=0 w=1u l=1u
X1176 sg13cmos5l_inv_1_0.A sg13cmos5l_inv_1_3.Y VPWR VPWR sg13_lv_pmos ad=0.2128p pd=1.5u as=0.2128p ps=1.5u w=1.12u l=0.13u
X1177 VPWR VGND.t488 VPWR VPWR sg13_lv_pmos ad=0.19p pd=1.38u as=0 ps=0 w=1u l=1u
X1178 VPWR VGND.t531 VPWR VPWR sg13_lv_pmos ad=0.34p pd=2.68u as=0 ps=0 w=1u l=1u
X1179 VGND.t531 VPWR VGND.t531 VGND.t549 sg13_lv_nmos ad=0.1428p pd=1.52u as=0 ps=0 w=0.42u l=1u
X1180 VGND.t381 VPWR VGND.t381 VGND.t423 sg13_lv_nmos ad=0.1428p pd=1.52u as=0 ps=0 w=0.42u l=1u
X1181 VGND.t3 sg13cmos5l_and2_1_0.X sg13cmos5l_inv_1_3.A VGND.t51 sg13_lv_nmos ad=0.1406p pd=1.12u as=0.1406p ps=1.12u w=0.74u l=0.13u
X1182 VPWR VGND.t713 VPWR VPWR sg13_lv_pmos ad=0.19p pd=1.38u as=0 ps=0 w=1u l=1u
X1183 VPWR VGND.t564 VPWR VPWR sg13_lv_pmos ad=0.19p pd=1.38u as=0 ps=0 w=1u l=1u
X1184 VGND.t713 VPWR VGND.t713 VGND.t745 sg13_lv_nmos ad=79.8f pd=0.8u as=0 ps=0 w=0.42u l=1u
X1185 VGND.t531 VPWR VGND.t531 VGND.t562 sg13_lv_nmos ad=0.1428p pd=1.52u as=0 ps=0 w=0.42u l=1u
X1186 VPWR VGND.t564 VPWR VPWR sg13_lv_pmos ad=0.34p pd=2.68u as=0 ps=0 w=1u l=1u
X1187 VGND.t104 VPWR VGND.t104 VGND.t119 sg13_lv_nmos ad=0.1428p pd=1.52u as=0 ps=0 w=0.42u l=1u
X1188 VGND.t622 VPWR VGND.t622 VGND.t621 sg13_lv_nmos ad=0.1428p pd=1.52u as=0 ps=0 w=0.42u l=1u
X1189 VGND.t802 VPWR VGND.t802 VGND.t803 sg13_lv_nmos ad=0.1428p pd=1.52u as=0 ps=0 w=0.42u l=1u
X1190 VPWR VGND.t198 VPWR VPWR sg13_lv_pmos ad=0.19p pd=1.38u as=0 ps=0 w=1u l=1u
X1191 VGND.t137 VPWR VGND.t137 VGND.t136 sg13_lv_nmos ad=0.1428p pd=1.52u as=0 ps=0 w=0.42u l=1u
X1192 VPWR VGND.t216 VPWR VPWR sg13_lv_pmos ad=0.34p pd=2.68u as=0 ps=0 w=1u l=1u
X1193 VGND.t622 VPWR VGND.t622 VGND.t649 sg13_lv_nmos ad=79.8f pd=0.8u as=0 ps=0 w=0.42u l=1u
X1194 VPWR VGND.t551 VPWR VPWR sg13_lv_pmos ad=0.34p pd=2.68u as=0 ps=0 w=1u l=1u
X1195 VGND.t713 VPWR VGND.t713 VGND.t715 sg13_lv_nmos ad=79.8f pd=0.8u as=0 ps=0 w=0.42u l=1u
X1196 VPWR VGND.t462 VPWR VPWR sg13_lv_pmos ad=0.19p pd=1.38u as=0 ps=0 w=1u l=1u
X1197 VGND.t474 VPWR VGND.t474 VGND.t478 sg13_lv_nmos ad=0.1428p pd=1.52u as=0 ps=0 w=0.42u l=1u
X1198 VPWR sg13cmos5l_inv_16_4.A sg13cmos5l_inv_16_4.Y VPWR sg13_lv_pmos ad=0.4368p pd=3.02u as=0.2128p ps=1.5u w=1.12u l=0.13u
X1199 VGND.t713 VPWR VGND.t713 VGND.t726 sg13_lv_nmos ad=0.1428p pd=1.52u as=0 ps=0 w=0.42u l=1u
X1200 VPWR VGND.t198 VPWR VPWR sg13_lv_pmos ad=0.34p pd=2.68u as=0 ps=0 w=1u l=1u
X1201 VPWR VGND.t314 VPWR VPWR sg13_lv_pmos ad=0.34p pd=2.68u as=0 ps=0 w=1u l=1u
X1202 VPWR VGND.t540 VPWR VPWR sg13_lv_pmos ad=0.34p pd=2.68u as=0 ps=0 w=1u l=1u
X1203 VPWR VGND.t569 VPWR VPWR sg13_lv_pmos ad=0.34p pd=2.68u as=0 ps=0 w=1u l=1u
X1204 VGND.t574 VPWR VGND.t574 VGND.t577 sg13_lv_nmos ad=0.1428p pd=1.52u as=0 ps=0 w=0.42u l=1u
X1205 VPWR VGND.t398 VPWR VPWR sg13_lv_pmos ad=0.19p pd=1.38u as=0 ps=0 w=1u l=1u
X1206 VPWR VGND.t622 VPWR VPWR sg13_lv_pmos ad=0.19p pd=1.38u as=0 ps=0 w=1u l=1u
X1207 VGND.t713 VPWR VGND.t713 VGND.t734 sg13_lv_nmos ad=0.1428p pd=1.52u as=0 ps=0 w=0.42u l=1u
X1208 VGND.t826 VPWR VGND.t826 VGND.t829 sg13_lv_nmos ad=0.1428p pd=1.52u as=0 ps=0 w=0.42u l=1u
X1209 sg13cmos5l_inv_16_2.Y sg13cmos5l_inv_16_2.A VGND.t15 VGND.t16 sg13_lv_nmos ad=0.1406p pd=1.12u as=0.1406p ps=1.12u w=0.74u l=0.13u
X1210 VGND.t488 VPWR VGND.t488 VGND.t489 sg13_lv_nmos ad=0.1428p pd=1.52u as=0 ps=0 w=0.42u l=1u
X1211 VGND.t713 VPWR VGND.t713 VGND.t739 sg13_lv_nmos ad=79.8f pd=0.8u as=0 ps=0 w=0.42u l=1u
X1212 VPWR VGND.t412 VPWR VPWR sg13_lv_pmos ad=0.19p pd=1.38u as=0 ps=0 w=1u l=1u
X1213 VPWR VGND.t104 VPWR VPWR sg13_lv_pmos ad=0.19p pd=1.38u as=0 ps=0 w=1u l=1u
X1214 VPWR VGND.t713 VPWR VPWR sg13_lv_pmos ad=0.19p pd=1.38u as=0 ps=0 w=1u l=1u
X1215 VGND.t324 VPWR VGND.t324 VGND.t323 sg13_lv_nmos ad=0.1428p pd=1.52u as=0 ps=0 w=0.42u l=1u
X1216 VGND.t196 VPWR VGND.t196 VGND.t195 sg13_lv_nmos ad=0.1428p pd=1.52u as=0 ps=0 w=0.42u l=1u
X1217 VGND.t713 VPWR VGND.t713 VGND.t720 sg13_lv_nmos ad=0.1428p pd=1.52u as=0 ps=0 w=0.42u l=1u
X1218 VPWR VGND.t147 VPWR VPWR sg13_lv_pmos ad=0.19p pd=1.38u as=0 ps=0 w=1u l=1u
X1219 VPWR VGND.t622 VPWR VPWR sg13_lv_pmos ad=0.19p pd=1.38u as=0 ps=0 w=1u l=1u
X1220 VPWR VGND.t398 VPWR VPWR sg13_lv_pmos ad=0.34p pd=2.68u as=0 ps=0 w=1u l=1u
X1221 VPWR VGND.t234 VPWR VPWR sg13_lv_pmos ad=0.19p pd=1.38u as=0 ps=0 w=1u l=1u
X1222 VGND.t12 sg13cmos5l_inv_16_2.A sg13cmos5l_inv_16_2.Y VGND.t11 sg13_lv_nmos ad=0.1406p pd=1.12u as=0.1406p ps=1.12u w=0.74u l=0.13u
X1223 VGND.t622 VPWR VGND.t622 VGND.t643 sg13_lv_nmos ad=79.8f pd=0.8u as=0 ps=0 w=0.42u l=1u
X1224 VPWR VGND.t531 VPWR VPWR sg13_lv_pmos ad=0.34p pd=2.68u as=0 ps=0 w=1u l=1u
X1225 VGND.t713 VPWR VGND.t713 VGND.t728 sg13_lv_nmos ad=0.1428p pd=1.52u as=0 ps=0 w=0.42u l=1u
X1226 VPWR VGND.t293 VPWR VPWR sg13_lv_pmos ad=0.34p pd=2.68u as=0 ps=0 w=1u l=1u
X1227 VGND.t707 VPWR VGND.t707 VGND.t708 sg13_lv_nmos ad=79.8f pd=0.8u as=0 ps=0 w=0.42u l=1u
X1228 VPWR VGND.t239 VPWR VPWR sg13_lv_pmos ad=0.19p pd=1.38u as=0 ps=0 w=1u l=1u
X1229 VGND.t41 VPWR VGND.t41 VGND.t303 sg13_lv_nmos ad=79.8f pd=0.8u as=0 ps=0 w=0.42u l=1u
X1230 VGND.t234 VPWR VGND.t239 VGND.t238 sg13_lv_nmos ad=79.8f pd=0.8u as=0 ps=0 w=0.42u l=1u
X1231 VGND.t793 VPWR VGND.t793 VGND.t805 sg13_lv_nmos ad=0.1428p pd=1.52u as=0 ps=0 w=0.42u l=1u
X1232 VPWR VGND.t622 VPWR VPWR sg13_lv_pmos ad=0.19p pd=1.38u as=0 ps=0 w=1u l=1u
X1233 VGND.t28 VPWR VGND.t28 VGND.t459 sg13_lv_nmos ad=0.1428p pd=1.52u as=0 ps=0 w=0.42u l=1u
X1234 VPWR VGND.t143 VPWR VPWR sg13_lv_pmos ad=0.34p pd=2.68u as=0 ps=0 w=1u l=1u
X1235 VPWR VGND.t713 VPWR VPWR sg13_lv_pmos ad=0.34p pd=2.68u as=0 ps=0 w=1u l=1u
X1236 VPWR VGND.t531 VPWR VPWR sg13_lv_pmos ad=0.34p pd=2.68u as=0 ps=0 w=1u l=1u
X1237 VGND.t198 VPWR VGND.t198 VGND.t210 sg13_lv_nmos ad=0.1428p pd=1.52u as=0 ps=0 w=0.42u l=1u
X1238 VPWR sg13cmos5l_inv_16_2.A sg13cmos5l_inv_16_2.Y VPWR sg13_lv_pmos ad=0.2128p pd=1.5u as=0.2128p ps=1.5u w=1.12u l=0.13u
X1239 VPWR VGND.t324 VPWR VPWR sg13_lv_pmos ad=0.34p pd=2.68u as=0 ps=0 w=1u l=1u
X1240 VGND.t713 VPWR VGND.t713 VGND.t744 sg13_lv_nmos ad=0.1428p pd=1.52u as=0 ps=0 w=0.42u l=1u
X1241 VPWR VGND.t622 VPWR VPWR sg13_lv_pmos ad=0.19p pd=1.38u as=0 ps=0 w=1u l=1u
X1242 VPWR sg13cmos5l_inv_1_1.Y sg13cmos5l_and2_1_0.B VPWR sg13_lv_pmos ad=0.2128p pd=1.5u as=0.2128p ps=1.5u w=1.12u l=0.13u
X1243 VGND.t287 VPWR VGND.t287 VGND.t289 sg13_lv_nmos ad=0.1428p pd=1.52u as=0 ps=0 w=0.42u l=1u
X1244 VGND.t474 VPWR VGND.t474 VGND.t480 sg13_lv_nmos ad=0.1428p pd=1.52u as=0 ps=0 w=0.42u l=1u
X1245 VGND.t216 VPWR VGND.t216 VGND.t217 sg13_lv_nmos ad=0.1428p pd=1.52u as=0 ps=0 w=0.42u l=1u
X1246 sg13cmos5l_inv_16_2.Y sg13cmos5l_inv_16_2.A VPWR VPWR sg13_lv_pmos ad=0.2128p pd=1.5u as=0.2128p ps=1.5u w=1.12u l=0.13u
X1247 VPWR VGND.t713 VPWR VPWR sg13_lv_pmos ad=0.19p pd=1.38u as=0 ps=0 w=1u l=1u
X1248 VPWR VGND.t203 VPWR VPWR sg13_lv_pmos ad=0.19p pd=1.38u as=0 ps=0 w=1u l=1u
X1249 VGND.t104 VPWR VGND.t104 VGND.t135 sg13_lv_nmos ad=79.8f pd=0.8u as=0 ps=0 w=0.42u l=1u
X1250 VPWR VGND.t5 VPWR VPWR sg13_lv_pmos ad=0.19p pd=1.38u as=0 ps=0 w=1u l=1u
X1251 VPWR VGND.t622 VPWR VPWR sg13_lv_pmos ad=0.34p pd=2.68u as=0 ps=0 w=1u l=1u
X1252 VGND.t713 VPWR VGND.t713 VGND.t714 sg13_lv_nmos ad=0.1428p pd=1.52u as=0 ps=0 w=0.42u l=1u
X1253 VPWR VGND.t375 VPWR VPWR sg13_lv_pmos ad=0.19p pd=1.38u as=0 ps=0 w=1u l=1u
X1254 VPWR VGND.t531 VPWR VPWR sg13_lv_pmos ad=0.34p pd=2.68u as=0 ps=0 w=1u l=1u
X1255 VPWR VGND.t306 VPWR VPWR sg13_lv_pmos ad=0.19p pd=1.38u as=0 ps=0 w=1u l=1u
X1256 VPWR VGND.t574 VPWR VPWR sg13_lv_pmos ad=0.34p pd=2.68u as=0 ps=0 w=1u l=1u
X1257 VGND.t531 VPWR VGND.t531 VGND.t562 sg13_lv_nmos ad=0.1428p pd=1.52u as=0 ps=0 w=0.42u l=1u
X1258 VGND.t198 VPWR VGND.t198 VGND.t214 sg13_lv_nmos ad=0.1428p pd=1.52u as=0 ps=0 w=0.42u l=1u
X1259 VPWR VGND.t622 VPWR VPWR sg13_lv_pmos ad=0.19p pd=1.38u as=0 ps=0 w=1u l=1u
X1260 VPWR VGND.t488 VPWR VPWR sg13_lv_pmos ad=0.19p pd=1.38u as=0 ps=0 w=1u l=1u
X1261 VPWR VGND.t198 VPWR VPWR sg13_lv_pmos ad=0.19p pd=1.38u as=0 ps=0 w=1u l=1u
X1262 VGND.t713 VPWR VGND.t713 VGND.t722 sg13_lv_nmos ad=0.1428p pd=1.52u as=0 ps=0 w=0.42u l=1u
X1263 VPWR VGND.t229 VPWR VPWR sg13_lv_pmos ad=0.19p pd=1.38u as=0 ps=0 w=1u l=1u
X1264 VGND.t104 VPWR VGND.t104 VGND.t180 sg13_lv_nmos ad=79.8f pd=0.8u as=0 ps=0 w=0.42u l=1u
X1265 VGND.t925 VPWR VGND.t924 VGND.t923 sg13_lv_nmos ad=0.1428p pd=1.52u as=0 ps=0 w=0.42u l=1u
X1266 VPWR VGND.t707 VPWR VPWR sg13_lv_pmos ad=0.19p pd=1.38u as=0 ps=0 w=1u l=1u
X1267 VPWR VGND.t952 VPWR VPWR sg13_lv_pmos ad=0.19p pd=1.38u as=0 ps=0 w=1u l=1u
X1268 VPWR VGND.t112 VPWR VPWR sg13_lv_pmos ad=0.34p pd=2.68u as=0 ps=0 w=1u l=1u
X1269 VPWR VGND.t203 VPWR VPWR sg13_lv_pmos ad=0.34p pd=2.68u as=0 ps=0 w=1u l=1u
X1270 VGND.t793 VPWR VGND.t793 VGND.t797 sg13_lv_nmos ad=0.1428p pd=1.52u as=0 ps=0 w=0.42u l=1u
X1271 VPWR VGND.t287 VPWR VPWR sg13_lv_pmos ad=0.34p pd=2.68u as=0 ps=0 w=1u l=1u
X1272 VGND.t121 VPWR VGND.t121 VGND.t123 sg13_lv_nmos ad=79.8f pd=0.8u as=0 ps=0 w=0.42u l=1u
X1273 VPWR VGND.t713 VPWR VPWR sg13_lv_pmos ad=0.34p pd=2.68u as=0 ps=0 w=1u l=1u
X1274 VPWR sg13cmos5l_and2_1_0.X sg13cmos5l_inv_1_3.A VPWR sg13_lv_pmos ad=0.2128p pd=1.5u as=0.2128p ps=1.5u w=1.12u l=0.13u
X1275 VGND.t622 VPWR VGND.t622 VGND.t645 sg13_lv_nmos ad=79.8f pd=0.8u as=0 ps=0 w=0.42u l=1u
X1276 VPWR VGND.t531 VPWR VPWR sg13_lv_pmos ad=0.34p pd=2.68u as=0 ps=0 w=1u l=1u
X1277 VGND.t713 VPWR VGND.t713 VGND.t730 sg13_lv_nmos ad=0.1428p pd=1.52u as=0 ps=0 w=0.42u l=1u
X1278 sg13cmos5l_inv_1_3.A sg13cmos5l_and2_1_0.X VGND.t64 VGND.t65 sg13_lv_nmos ad=0.1406p pd=1.12u as=0.1406p ps=1.12u w=0.74u l=0.13u
X1279 VPWR VGND.t198 VPWR VPWR sg13_lv_pmos ad=0.34p pd=2.68u as=0 ps=0 w=1u l=1u
X1280 VGND.t104 VPWR VGND.t104 VGND.t132 sg13_lv_nmos ad=0.1428p pd=1.52u as=0 ps=0 w=0.42u l=1u
X1281 VGND.t713 VPWR VGND.t713 VGND.t738 sg13_lv_nmos ad=0.1428p pd=1.52u as=0 ps=0 w=0.42u l=1u
X1282 VGND.t945 VPWR VGND.t947 VGND.t946 sg13_lv_nmos ad=79.8f pd=0.8u as=0 ps=0 w=0.42u l=1u
X1283 VPWR VGND.t622 VPWR VPWR sg13_lv_pmos ad=0.19p pd=1.38u as=0 ps=0 w=1u l=1u
X1284 VPWR VGND.t531 VPWR VPWR sg13_lv_pmos ad=0.34p pd=2.68u as=0 ps=0 w=1u l=1u
X1285 VPWR VGND.t713 VPWR VPWR sg13_lv_pmos ad=0.34p pd=2.68u as=0 ps=0 w=1u l=1u
X1286 VGND.t622 VPWR VGND.t622 VGND.t661 sg13_lv_nmos ad=79.8f pd=0.8u as=0 ps=0 w=0.42u l=1u
X1287 VPWR VGND.t564 VPWR VPWR sg13_lv_pmos ad=0.34p pd=2.68u as=0 ps=0 w=1u l=1u
X1288 VGND.t713 VPWR VGND.t713 VGND.t746 sg13_lv_nmos ad=0.1428p pd=1.52u as=0 ps=0 w=0.42u l=1u
X1289 VGND.t375 VPWR VGND.t381 VGND.t380 sg13_lv_nmos ad=79.8f pd=0.8u as=0 ps=0 w=0.42u l=1u
X1290 VPWR VGND.t398 VPWR VPWR sg13_lv_pmos ad=0.34p pd=2.68u as=0 ps=0 w=1u l=1u
X1291 VPWR VGND.t622 VPWR VPWR sg13_lv_pmos ad=0.19p pd=1.38u as=0 ps=0 w=1u l=1u
X1292 VPWR VGND.t713 VPWR VPWR sg13_lv_pmos ad=0.19p pd=1.38u as=0 ps=0 w=1u l=1u
X1293 VGND.t713 VPWR VGND.t713 VGND.t716 sg13_lv_nmos ad=0.1428p pd=1.52u as=0 ps=0 w=0.42u l=1u
X1294 VPWR VGND.t104 VPWR VPWR sg13_lv_pmos ad=0.19p pd=1.38u as=0 ps=0 w=1u l=1u
X1295 VPWR VGND.t574 VPWR VPWR sg13_lv_pmos ad=0.34p pd=2.68u as=0 ps=0 w=1u l=1u
X1296 VGND.t622 VPWR VGND.t622 VGND.t655 sg13_lv_nmos ad=79.8f pd=0.8u as=0 ps=0 w=0.42u l=1u
X1297 VPWR VGND.t622 VPWR VPWR sg13_lv_pmos ad=0.19p pd=1.38u as=0 ps=0 w=1u l=1u
X1298 VGND.t713 VPWR VGND.t713 VGND.t724 sg13_lv_nmos ad=0.1428p pd=1.52u as=0 ps=0 w=0.42u l=1u
X1299 VGND.t622 VPWR VGND.t622 VGND.t622 sg13_lv_nmos ad=79.8f pd=0.8u as=0 ps=0 w=0.42u l=1u
X1300 VPWR VGND.t104 VPWR VPWR sg13_lv_pmos ad=0.19p pd=1.38u as=0 ps=0 w=1u l=1u
X1301 VPWR VGND.t622 VPWR VPWR sg13_lv_pmos ad=0.34p pd=2.68u as=0 ps=0 w=1u l=1u
X1302 VGND.t474 VPWR VGND.t474 VGND.t476 sg13_lv_nmos ad=0.1428p pd=1.52u as=0 ps=0 w=0.42u l=1u
X1303 VGND.t329 VPWR VGND.t329 VGND.t333 sg13_lv_nmos ad=0.1428p pd=1.52u as=0 ps=0 w=0.42u l=1u
X1304 VPWR VGND.t713 VPWR VPWR sg13_lv_pmos ad=0.34p pd=2.68u as=0 ps=0 w=1u l=1u
X1305 VPWR VGND.t713 VPWR VPWR sg13_lv_pmos ad=0.19p pd=1.38u as=0 ps=0 w=1u l=1u
X1306 VPWR VGND.t239 VPWR VPWR sg13_lv_pmos ad=0.19p pd=1.38u as=0 ps=0 w=1u l=1u
X1307 VPWR VGND.t622 VPWR VPWR sg13_lv_pmos ad=0.19p pd=1.38u as=0 ps=0 w=1u l=1u
X1308 VGND.t622 VPWR VGND.t622 VGND.t647 sg13_lv_nmos ad=79.8f pd=0.8u as=0 ps=0 w=0.42u l=1u
X1309 VGND.t3 sg13cmos5l_and2_1_0.X sg13cmos5l_inv_1_3.A VGND.t57 sg13_lv_nmos ad=0.1406p pd=1.12u as=0.1406p ps=1.12u w=0.74u l=0.13u
X1310 VGND.t930 VPWR VGND.t929 VGND.t928 sg13_lv_nmos ad=0.1428p pd=1.52u as=0 ps=0 w=0.42u l=1u
X1311 VGND.t3 sg13cmos5l_inv_1_3.Y sg13cmos5l_inv_1_0.A VGND.t81 sg13_lv_nmos ad=0.1406p pd=1.12u as=0.1406p ps=1.12u w=0.74u l=0.13u
X1312 VPWR VGND.t329 VPWR VPWR sg13_lv_pmos ad=0.34p pd=2.68u as=0 ps=0 w=1u l=1u
X1313 VPWR VGND.t104 VPWR VPWR sg13_lv_pmos ad=0.34p pd=2.68u as=0 ps=0 w=1u l=1u
X1314 VGND.t314 VPWR VGND.t314 VGND.t315 sg13_lv_nmos ad=79.8f pd=0.8u as=0 ps=0 w=0.42u l=1u
X1315 VGND.t713 VPWR VGND.t713 VGND.t740 sg13_lv_nmos ad=0.1428p pd=1.52u as=0 ps=0 w=0.42u l=1u
X1316 VPWR VGND.t198 VPWR VPWR sg13_lv_pmos ad=0.34p pd=2.68u as=0 ps=0 w=1u l=1u
X1317 VGND.t622 VPWR VGND.t622 VGND.t641 sg13_lv_nmos ad=79.8f pd=0.8u as=0 ps=0 w=0.42u l=1u
X1318 sg13cmos5l_inv_1_0.A sg13cmos5l_inv_1_3.Y VGND.t3 VGND.t78 sg13_lv_nmos ad=0.1406p pd=1.12u as=0.1406p ps=1.12u w=0.74u l=0.13u
X1319 VPWR VGND.t329 VPWR VPWR sg13_lv_pmos ad=0.19p pd=1.38u as=0 ps=0 w=1u l=1u
X1320 VGND.t329 VPWR VGND.t329 VGND.t367 sg13_lv_nmos ad=0.1428p pd=1.52u as=0 ps=0 w=0.42u l=1u
X1321 VGND.t216 VPWR VGND.t216 VGND.t219 sg13_lv_nmos ad=0.1428p pd=1.52u as=0 ps=0 w=0.42u l=1u
X1322 VPWR VGND.t713 VPWR VPWR sg13_lv_pmos ad=0.34p pd=2.68u as=0 ps=0 w=1u l=1u
X1323 VGND.t713 VPWR VGND.t713 VGND.t748 sg13_lv_nmos ad=0.1428p pd=1.52u as=0 ps=0 w=0.42u l=1u
X1324 VPWR VGND.t622 VPWR VPWR sg13_lv_pmos ad=0.19p pd=1.38u as=0 ps=0 w=1u l=1u
X1325 VPWR VGND.t393 VPWR VPWR sg13_lv_pmos ad=0.19p pd=1.38u as=0 ps=0 w=1u l=1u
X1326 VGND.t381 VPWR VGND.t381 VGND.t383 sg13_lv_nmos ad=79.8f pd=0.8u as=0 ps=0 w=0.42u l=1u
X1327 VPWR VGND.t308 VPWR VPWR sg13_lv_pmos ad=0.19p pd=1.38u as=0 ps=0 w=1u l=1u
X1328 VPWR VGND.t622 VPWR VPWR sg13_lv_pmos ad=0.19p pd=1.38u as=0 ps=0 w=1u l=1u
X1329 VGND.t34 VPWR VGND.t34 VGND.t298 sg13_lv_nmos ad=0.1428p pd=1.52u as=0 ps=0 w=0.42u l=1u
X1330 VGND.t104 VPWR VGND.t104 VGND.t107 sg13_lv_nmos ad=79.8f pd=0.8u as=0 ps=0 w=0.42u l=1u
X1331 VGND.t10 sg13cmos5l_inv_16_4.A sg13cmos5l_inv_16_4.Y VGND.t87 sg13_lv_nmos ad=0.1406p pd=1.12u as=0.1406p ps=1.12u w=0.74u l=0.13u
X1332 VGND.t198 VPWR VGND.t198 VGND.t225 sg13_lv_nmos ad=0.1428p pd=1.52u as=0 ps=0 w=0.42u l=1u
X1333 VGND.t965 VPWR VGND.t967 VGND.t966 sg13_lv_nmos ad=79.8f pd=0.8u as=0 ps=0 w=0.42u l=1u
X1334 VGND.t64 VPWR VGND.t64 VGND.t424 sg13_lv_nmos ad=0.1428p pd=1.52u as=0 ps=0 w=0.42u l=1u
X1335 VPWR VGND.t198 VPWR VPWR sg13_lv_pmos ad=0.19p pd=1.38u as=0 ps=0 w=1u l=1u
X1336 VGND.t143 VPWR VGND.t147 VGND.t146 sg13_lv_nmos ad=79.8f pd=0.8u as=0 ps=0 w=0.42u l=1u
X1337 VPWR VGND.t198 VPWR VPWR sg13_lv_pmos ad=0.19p pd=1.38u as=0 ps=0 w=1u l=1u
X1338 VGND.t308 VPWR VGND.t312 VGND.t352 sg13_lv_nmos ad=79.8f pd=0.8u as=0 ps=0 w=0.42u l=1u
X1339 VGND.t713 VPWR VGND.t713 VGND.t718 sg13_lv_nmos ad=0.1428p pd=1.52u as=0 ps=0 w=0.42u l=1u
X1340 VPWR VGND.t468 VPWR VPWR sg13_lv_pmos ad=0.34p pd=2.68u as=0 ps=0 w=1u l=1u
X1341 VGND.t793 VPWR VGND.t793 VGND.t810 sg13_lv_nmos ad=79.8f pd=0.8u as=0 ps=0 w=0.42u l=1u
X1342 VPWR VGND.t531 VPWR VPWR sg13_lv_pmos ad=0.34p pd=2.68u as=0 ps=0 w=1u l=1u
X1343 VGND.t622 VPWR VGND.t622 VGND.t657 sg13_lv_nmos ad=79.8f pd=0.8u as=0 ps=0 w=0.42u l=1u
X1344 VPWR VGND.t622 VPWR VPWR sg13_lv_pmos ad=0.19p pd=1.38u as=0 ps=0 w=1u l=1u
X1345 sg13cmos5l_inv_16_2.Y sg13cmos5l_inv_16_2.A VGND.t15 VGND.t22 sg13_lv_nmos ad=0.1406p pd=1.12u as=0.1406p ps=1.12u w=0.74u l=0.13u
X1346 VPWR VGND.t121 VPWR VPWR sg13_lv_pmos ad=0.34p pd=2.68u as=0 ps=0 w=1u l=1u
X1347 VPWR VGND.t622 VPWR VPWR sg13_lv_pmos ad=0.34p pd=2.68u as=0 ps=0 w=1u l=1u
X1348 VPWR VGND.t198 VPWR VPWR sg13_lv_pmos ad=0.34p pd=2.68u as=0 ps=0 w=1u l=1u
X1349 VPWR VGND.t622 VPWR VPWR sg13_lv_pmos ad=0.19p pd=1.38u as=0 ps=0 w=1u l=1u
X1350 VGND.t15 sg13cmos5l_inv_16_2.A sg13cmos5l_inv_16_2.Y VGND.t19 sg13_lv_nmos ad=0.1406p pd=1.12u as=0.1406p ps=1.12u w=0.74u l=0.13u
X1351 VGND.t375 VPWR VGND.t375 VGND.t377 sg13_lv_nmos ad=0.1428p pd=1.52u as=0 ps=0 w=0.42u l=1u
X1352 VPWR VGND.t707 VPWR VPWR sg13_lv_pmos ad=0.34p pd=2.68u as=0 ps=0 w=1u l=1u
X1353 VGND.t449 VPWR VGND.t449 VGND.t496 sg13_lv_nmos ad=0.1428p pd=1.52u as=0 ps=0 w=0.42u l=1u
X1354 VPWR VGND.t622 VPWR VPWR sg13_lv_pmos ad=0.19p pd=1.38u as=0 ps=0 w=1u l=1u
X1355 VPWR VGND.t713 VPWR VPWR sg13_lv_pmos ad=0.34p pd=2.68u as=0 ps=0 w=1u l=1u
X1356 VGND.t622 VPWR VGND.t622 VGND.t635 sg13_lv_nmos ad=79.8f pd=0.8u as=0 ps=0 w=0.42u l=1u
X1357 sg13cmos5l_inv_16_2.Y sg13cmos5l_inv_16_2.A VPWR VPWR sg13_lv_pmos ad=0.2128p pd=1.5u as=0.2128p ps=1.5u w=1.12u l=0.13u
X1358 sg13cmos5l_inv_1_0.A sg13cmos5l_inv_1_3.Y VGND.t3 VGND.t74 sg13_lv_nmos ad=0.1406p pd=1.12u as=0.1406p ps=1.12u w=0.74u l=0.13u
X1359 VGND.t375 VPWR VGND.t375 VGND.t376 sg13_lv_nmos ad=79.8f pd=0.8u as=0 ps=0 w=0.42u l=1u
X1360 VGND.t104 VPWR VGND.t5 VGND.t175 sg13_lv_nmos ad=0.1428p pd=1.52u as=0 ps=0 w=0.42u l=1u
X1361 VPWR VGND.t622 VPWR VPWR sg13_lv_pmos ad=0.19p pd=1.38u as=0 ps=0 w=1u l=1u
X1362 VPWR VGND.t622 VPWR VPWR sg13_lv_pmos ad=0.34p pd=2.68u as=0 ps=0 w=1u l=1u
X1363 VGND.t622 VPWR VGND.t622 VGND.t646 sg13_lv_nmos ad=0.1428p pd=1.52u as=0 ps=0 w=0.42u l=1u
X1364 VPWR VGND.t381 VPWR VPWR sg13_lv_pmos ad=0.34p pd=2.68u as=0 ps=0 w=1u l=1u
X1365 VPWR sg13cmos5l_inv_16_2.A sg13cmos5l_inv_16_2.Y VPWR sg13_lv_pmos ad=0.2128p pd=1.5u as=0.2128p ps=1.5u w=1.12u l=0.13u
X1366 VGND.t707 VPWR VGND.t707 VGND.t711 sg13_lv_nmos ad=0.1428p pd=1.52u as=0 ps=0 w=0.42u l=1u
X1367 VGND.t41 sg13cmos5l_inv_1_1.Y sg13cmos5l_and2_1_0.B VGND.t40 sg13_lv_nmos ad=0.1406p pd=1.12u as=0.1406p ps=1.12u w=0.74u l=0.13u
X1368 VGND.t802 VPWR VGND.t793 VGND.t804 sg13_lv_nmos ad=79.8f pd=0.8u as=0 ps=0 w=0.42u l=1u
X1369 VPWR VGND.t713 VPWR VPWR sg13_lv_pmos ad=0.34p pd=2.68u as=0 ps=0 w=1u l=1u
X1370 VGND.t622 VPWR VGND.t622 VGND.t651 sg13_lv_nmos ad=79.8f pd=0.8u as=0 ps=0 w=0.42u l=1u
X1371 VGND.t713 VPWR VGND.t713 VGND.t736 sg13_lv_nmos ad=0.1428p pd=1.52u as=0 ps=0 w=0.42u l=1u
X1372 VGND.t793 VPWR VGND.t793 VGND.t792 sg13_lv_nmos ad=0.1428p pd=1.52u as=0 ps=0 w=0.42u l=1u
X1373 VPWR sg13cmos5l_inv_1_3.Y sg13cmos5l_inv_1_0.A VPWR sg13_lv_pmos ad=0.2128p pd=1.5u as=0.2128p ps=1.5u w=1.12u l=0.13u
X1374 VPWR VGND.t987 VPWR VPWR sg13_lv_pmos ad=0.19p pd=1.38u as=0 ps=0 w=1u l=1u
X1375 VPWR VGND.t622 VPWR VPWR sg13_lv_pmos ad=0.19p pd=1.38u as=0 ps=0 w=1u l=1u
X1376 VPWR VGND.t622 VPWR VPWR sg13_lv_pmos ad=0.34p pd=2.68u as=0 ps=0 w=1u l=1u
X1377 VPWR VGND.t147 VPWR VPWR sg13_lv_pmos ad=0.34p pd=2.68u as=0 ps=0 w=1u l=1u
X1378 sg13cmos5l_inv_16_2.Y sg13cmos5l_inv_16_2.A VPWR VPWR sg13_lv_pmos ad=0.2128p pd=1.5u as=0.2128p ps=1.5u w=1.12u l=0.13u
X1379 VGND.t895 VPWR VGND.t897 VGND.t896 sg13_lv_nmos ad=79.8f pd=0.8u as=0 ps=0 w=0.42u l=1u
X1380 a_3885_9540# sg13cmos5l_buf_1_0.X VPWR VPWR sg13_lv_pmos ad=0.1596p pd=1.22u as=0.2856p ps=2.36u w=0.84u l=0.13u
X1381 VGND.t381 VPWR VGND.t381 VGND.t382 sg13_lv_nmos ad=0.1428p pd=1.52u as=0 ps=0 w=0.42u l=1u
X1382 VGND.t793 VPWR VGND.t793 VGND.t823 sg13_lv_nmos ad=79.8f pd=0.8u as=0 ps=0 w=0.42u l=1u
X1383 VPWR VGND.t707 VPWR VPWR sg13_lv_pmos ad=0.19p pd=1.38u as=0 ps=0 w=1u l=1u
X1384 VPWR VGND.t104 VPWR VPWR sg13_lv_pmos ad=0.19p pd=1.38u as=0 ps=0 w=1u l=1u
X1385 VGND.t793 VPWR VGND.t813 VGND.t812 sg13_lv_nmos ad=79.8f pd=0.8u as=0 ps=0 w=0.42u l=1u
X1386 VGND.t622 VPWR VGND.t622 VGND.t659 sg13_lv_nmos ad=79.8f pd=0.8u as=0 ps=0 w=0.42u l=1u
X1387 VGND.t449 VPWR VGND.t449 VGND.t450 sg13_lv_nmos ad=79.8f pd=0.8u as=0 ps=0 w=0.42u l=1u
X1388 VGND.t30 VPWR VGND.t34 VGND.t297 sg13_lv_nmos ad=79.8f pd=0.8u as=0 ps=0 w=0.42u l=1u
X1389 VPWR VGND.t793 VPWR VPWR sg13_lv_pmos ad=0.19p pd=1.38u as=0 ps=0 w=1u l=1u
X1390 VGND.t229 VPWR VGND.t229 VGND.t231 sg13_lv_nmos ad=79.8f pd=0.8u as=0 ps=0 w=0.42u l=1u
X1391 VPWR VGND.t713 VPWR VPWR sg13_lv_pmos ad=0.34p pd=2.68u as=0 ps=0 w=1u l=1u
X1392 VPWR VGND.t104 VPWR VPWR sg13_lv_pmos ad=0.19p pd=1.38u as=0 ps=0 w=1u l=1u
X1393 VPWR VGND.t531 VPWR VPWR sg13_lv_pmos ad=0.34p pd=2.68u as=0 ps=0 w=1u l=1u
X1394 VGND.t203 VPWR VGND.t203 VGND.t204 sg13_lv_nmos ad=0.1428p pd=1.52u as=0 ps=0 w=0.42u l=1u
X1395 VPWR VGND.t622 VPWR VPWR sg13_lv_pmos ad=0.34p pd=2.68u as=0 ps=0 w=1u l=1u
X1396 VPWR VGND.t932 VPWR VPWR sg13_lv_pmos ad=0.19p pd=1.38u as=0 ps=0 w=1u l=1u
X1397 VPWR VGND.t707 VPWR VPWR sg13_lv_pmos ad=0.34p pd=2.68u as=0 ps=0 w=1u l=1u
X1398 VGND.t143 VPWR VGND.t143 VGND.t189 sg13_lv_nmos ad=0.1428p pd=1.52u as=0 ps=0 w=0.42u l=1u
X1399 VPWR VGND.t622 VPWR VPWR sg13_lv_pmos ad=0.19p pd=1.38u as=0 ps=0 w=1u l=1u
X1400 VPWR VGND.t329 VPWR VPWR sg13_lv_pmos ad=0.19p pd=1.38u as=0 ps=0 w=1u l=1u
X1401 VPWR VGND.t713 VPWR VPWR sg13_lv_pmos ad=0.34p pd=2.68u as=0 ps=0 w=1u l=1u
X1402 VGND.t398 VPWR VGND.t398 VGND.t436 sg13_lv_nmos ad=0.1428p pd=1.52u as=0 ps=0 w=0.42u l=1u
X1403 sg13cmos5l_and2_1_0.B sg13cmos5l_inv_1_1.Y VGND.t41 VGND.t44 sg13_lv_nmos ad=0.1406p pd=1.12u as=0.1406p ps=1.12u w=0.74u l=0.13u
X1404 VPWR VGND.t308 VPWR VPWR sg13_lv_pmos ad=0.34p pd=2.68u as=0 ps=0 w=1u l=1u
X1405 VGND.t574 VPWR VGND.t574 VGND.t531 sg13_lv_nmos ad=79.8f pd=0.8u as=0 ps=0 w=0.42u l=1u
X1406 VPWR VGND.t484 VPWR VPWR sg13_lv_pmos ad=0.34p pd=2.68u as=0 ps=0 w=1u l=1u
X1407 VGND.t622 VPWR VGND.t622 VGND.t648 sg13_lv_nmos ad=0.1428p pd=1.52u as=0 ps=0 w=0.42u l=1u
X1408 VGND.t104 VPWR VGND.t104 VGND.t109 sg13_lv_nmos ad=79.8f pd=0.8u as=0 ps=0 w=0.42u l=1u
X1409 VGND.t813 VPWR VGND.t793 VGND.t817 sg13_lv_nmos ad=79.8f pd=0.8u as=0 ps=0 w=0.42u l=1u
X1410 VGND.t474 VPWR VGND.t474 VGND.t475 sg13_lv_nmos ad=79.8f pd=0.8u as=0 ps=0 w=0.42u l=1u
X1411 VGND.t126 VPWR VGND.t5 VGND.t174 sg13_lv_nmos ad=79.8f pd=0.8u as=0 ps=0 w=0.42u l=1u
X1412 VGND.t793 VPWR VGND.t793 VGND.t806 sg13_lv_nmos ad=79.8f pd=0.8u as=0 ps=0 w=0.42u l=1u
X1413 VGND.t622 VPWR VGND.t622 VGND.t653 sg13_lv_nmos ad=79.8f pd=0.8u as=0 ps=0 w=0.42u l=1u
X1414 VPWR VGND.t104 VPWR VPWR sg13_lv_pmos ad=0.34p pd=2.68u as=0 ps=0 w=1u l=1u
X1415 VPWR VGND.t793 VPWR VPWR sg13_lv_pmos ad=0.19p pd=1.38u as=0 ps=0 w=1u l=1u
X1416 sg13cmos5l_inv_16_4.Y sg13cmos5l_inv_16_4.A VPWR VPWR sg13_lv_pmos ad=0.2128p pd=1.5u as=0.3808p ps=2.92u w=1.12u l=0.13u
X1417 VGND.t112 VPWR VGND.t104 VGND.t116 sg13_lv_nmos ad=79.8f pd=0.8u as=0 ps=0 w=0.42u l=1u
X1418 VPWR VGND.t622 VPWR VPWR sg13_lv_pmos ad=0.19p pd=1.38u as=0 ps=0 w=1u l=1u
X1419 VPWR VGND.t622 VPWR VPWR sg13_lv_pmos ad=0.34p pd=2.68u as=0 ps=0 w=1u l=1u
X1420 VGND.t622 VPWR VGND.t622 VGND.t642 sg13_lv_nmos ad=0.1428p pd=1.52u as=0 ps=0 w=0.42u l=1u
X1421 VPWR VGND.t622 VPWR VPWR sg13_lv_pmos ad=0.34p pd=2.68u as=0 ps=0 w=1u l=1u
X1422 VGND.t112 VPWR VGND.t112 VGND.t113 sg13_lv_nmos ad=0.1428p pd=1.52u as=0 ps=0 w=0.42u l=1u
X1423 VPWR VGND.t713 VPWR VPWR sg13_lv_pmos ad=0.34p pd=2.68u as=0 ps=0 w=1u l=1u
X1424 VGND.t551 VPWR VGND.t551 VGND.t553 sg13_lv_nmos ad=79.8f pd=0.8u as=0 ps=0 w=0.42u l=1u
X1425 VPWR VGND.t531 VPWR VPWR sg13_lv_pmos ad=0.19p pd=1.38u as=0 ps=0 w=1u l=1u
X1426 VGND.t793 VPWR VGND.t799 VGND.t798 sg13_lv_nmos ad=79.8f pd=0.8u as=0 ps=0 w=0.42u l=1u
X1427 VPWR VGND.t622 VPWR VPWR sg13_lv_pmos ad=0.19p pd=1.38u as=0 ps=0 w=1u l=1u
X1428 VGND.t622 VPWR VGND.t622 VGND.t658 sg13_lv_nmos ad=0.1428p pd=1.52u as=0 ps=0 w=0.42u l=1u
X1429 VPWR VGND.t198 VPWR VPWR sg13_lv_pmos ad=0.34p pd=2.68u as=0 ps=0 w=1u l=1u
X1430 VPWR VGND.t622 VPWR VPWR sg13_lv_pmos ad=0.34p pd=2.68u as=0 ps=0 w=1u l=1u
X1431 VGND.t41 VPWR VGND.t41 VGND.t347 sg13_lv_nmos ad=0.1428p pd=1.52u as=0 ps=0 w=0.42u l=1u
X1432 VGND.t950 VPWR VGND.t949 VGND.t948 sg13_lv_nmos ad=0.1428p pd=1.52u as=0 ps=0 w=0.42u l=1u
X1433 VPWR VGND.t412 VPWR VPWR sg13_lv_pmos ad=0.19p pd=1.38u as=0 ps=0 w=1u l=1u
X1434 VPWR VGND.t713 VPWR VPWR sg13_lv_pmos ad=0.34p pd=2.68u as=0 ps=0 w=1u l=1u
X1435 VPWR VGND.t531 VPWR VPWR sg13_lv_pmos ad=0.19p pd=1.38u as=0 ps=0 w=1u l=1u
X1436 VGND.t234 VPWR VGND.t234 VGND.t236 sg13_lv_nmos ad=79.8f pd=0.8u as=0 ps=0 w=0.42u l=1u
X1437 VPWR VGND.t977 VPWR VPWR sg13_lv_pmos ad=0.19p pd=1.38u as=0 ps=0 w=1u l=1u
X1438 VPWR VGND.t622 VPWR VPWR sg13_lv_pmos ad=0.19p pd=1.38u as=0 ps=0 w=1u l=1u
X1439 VPWR VGND.t622 VPWR VPWR sg13_lv_pmos ad=0.34p pd=2.68u as=0 ps=0 w=1u l=1u
X1440 VGND.t398 VPWR VGND.t398 VGND.t438 sg13_lv_nmos ad=0.1428p pd=1.52u as=0 ps=0 w=0.42u l=1u
X1441 VPWR VGND.t466 VPWR VPWR sg13_lv_pmos ad=0.19p pd=1.38u as=0 ps=0 w=1u l=1u
X1442 sg13cmos5l_inv_16_4.Y sg13cmos5l_inv_16_4.A VGND.t15 VGND.t96 sg13_lv_nmos ad=0.1406p pd=1.12u as=0.1406p ps=1.12u w=0.74u l=0.13u
X1443 VGND.t793 VPWR VGND.t793 VGND.t819 sg13_lv_nmos ad=79.8f pd=0.8u as=0 ps=0 w=0.42u l=1u
X1444 VGND.t622 VPWR VGND.t622 VGND.t636 sg13_lv_nmos ad=0.1428p pd=1.52u as=0 ps=0 w=0.42u l=1u
X1445 VPWR VGND.t287 VPWR VPWR sg13_lv_pmos ad=0.19p pd=1.38u as=0 ps=0 w=1u l=1u
X1446 VPWR VGND.t793 VPWR VPWR sg13_lv_pmos ad=0.19p pd=1.38u as=0 ps=0 w=1u l=1u
X1447 VGND.t985 VPWR VGND.t987 VGND.t986 sg13_lv_nmos ad=79.8f pd=0.8u as=0 ps=0 w=0.42u l=1u
X1448 VPWR VGND.t64 VPWR VPWR sg13_lv_pmos ad=0.19p pd=1.38u as=0 ps=0 w=1u l=1u
X1449 VPWR VGND.t622 VPWR VPWR sg13_lv_pmos ad=0.34p pd=2.68u as=0 ps=0 w=1u l=1u
X1450 VPWR sg13cmos5l_inv_1_1.Y sg13cmos5l_and2_1_0.B VPWR sg13_lv_pmos ad=0.2128p pd=1.5u as=0.2128p ps=1.5u w=1.12u l=0.13u
X1451 VGND.t836 VPWR VGND.t836 VGND.t838 sg13_lv_nmos ad=79.8f pd=0.8u as=0 ps=0 w=0.42u l=1u
X1452 VGND.t622 VPWR VGND.t622 VGND.t644 sg13_lv_nmos ad=0.1428p pd=1.52u as=0 ps=0 w=0.42u l=1u
X1453 VPWR VGND.t622 VPWR VPWR sg13_lv_pmos ad=0.34p pd=2.68u as=0 ps=0 w=1u l=1u
X1454 VPWR VGND.t531 VPWR VPWR sg13_lv_pmos ad=0.19p pd=1.38u as=0 ps=0 w=1u l=1u
X1455 VGND.t799 VPWR VGND.t802 VGND.t801 sg13_lv_nmos ad=79.8f pd=0.8u as=0 ps=0 w=0.42u l=1u
X1456 VGND.t574 VPWR VGND.t574 VGND.t531 sg13_lv_nmos ad=79.8f pd=0.8u as=0 ps=0 w=0.42u l=1u
X1457 VPWR VGND.t799 VPWR VPWR sg13_lv_pmos ad=0.19p pd=1.38u as=0 ps=0 w=1u l=1u
X1458 VGND.t203 VPWR VGND.t203 VGND.t205 sg13_lv_nmos ad=79.8f pd=0.8u as=0 ps=0 w=0.42u l=1u
X1459 VPWR VGND.t622 VPWR VPWR sg13_lv_pmos ad=0.19p pd=1.38u as=0 ps=0 w=1u l=1u
X1460 VPWR VGND.t707 VPWR VPWR sg13_lv_pmos ad=0.34p pd=2.68u as=0 ps=0 w=1u l=1u
X1461 VPWR sg13cmos5l_and2_1_0.X sg13cmos5l_inv_1_3.A VPWR sg13_lv_pmos ad=0.4368p pd=3.02u as=0.2128p ps=1.5u w=1.12u l=0.13u
X1462 VGND.t707 VPWR VGND.t707 VGND.t706 sg13_lv_nmos ad=0.1428p pd=1.52u as=0 ps=0 w=0.42u l=1u
X1463 VPWR VGND.t287 VPWR VPWR sg13_lv_pmos ad=0.19p pd=1.38u as=0 ps=0 w=1u l=1u
X1464 VGND.t198 VPWR VGND.t198 VGND.t212 sg13_lv_nmos ad=0.1428p pd=1.52u as=0 ps=0 w=0.42u l=1u
X1465 VGND.t324 VPWR VGND.t324 VGND.t361 sg13_lv_nmos ad=0.1428p pd=1.52u as=0 ps=0 w=0.42u l=1u
X1466 VGND.t813 VPWR VGND.t813 VGND.t814 sg13_lv_nmos ad=0.1428p pd=1.52u as=0 ps=0 w=0.42u l=1u
X1467 VGND.t826 VPWR VGND.t831 VGND.t830 sg13_lv_nmos ad=79.8f pd=0.8u as=0 ps=0 w=0.42u l=1u
X1468 VGND.t622 VPWR VGND.t622 VGND.t660 sg13_lv_nmos ad=0.1428p pd=1.52u as=0 ps=0 w=0.42u l=1u
X1469 VGND.t449 VPWR VGND.t449 VGND.t451 sg13_lv_nmos ad=0.1428p pd=1.52u as=0 ps=0 w=0.42u l=1u
X1470 VGND.t104 VPWR VGND.t104 VGND.t103 sg13_lv_nmos ad=0.1428p pd=1.52u as=0 ps=0 w=0.42u l=1u
X1471 VPWR VGND.t574 VPWR VPWR sg13_lv_pmos ad=0.19p pd=1.38u as=0 ps=0 w=1u l=1u
X1472 VPWR VGND.t622 VPWR VPWR sg13_lv_pmos ad=0.34p pd=2.68u as=0 ps=0 w=1u l=1u
X1473 VPWR VGND.t308 VPWR VPWR sg13_lv_pmos ad=0.34p pd=2.68u as=0 ps=0 w=1u l=1u
X1474 VGND.t713 VPWR VGND.t713 VGND.t735 sg13_lv_nmos ad=79.8f pd=0.8u as=0 ps=0 w=0.42u l=1u
X1475 VGND.t287 VPWR VGND.t287 VGND.t291 sg13_lv_nmos ad=0.1428p pd=1.52u as=0 ps=0 w=0.42u l=1u
X1476 VPWR VGND.t203 VPWR VPWR sg13_lv_pmos ad=0.19p pd=1.38u as=0 ps=0 w=1u l=1u
X1477 VGND.t147 VPWR VGND.t147 VGND.t148 sg13_lv_nmos ad=0.1428p pd=1.52u as=0 ps=0 w=0.42u l=1u
X1478 VPWR VGND.t713 VPWR VPWR sg13_lv_pmos ad=0.34p pd=2.68u as=0 ps=0 w=1u l=1u
X1479 VGND.t41 VPWR VGND.t41 VGND.t346 sg13_lv_nmos ad=79.8f pd=0.8u as=0 ps=0 w=0.42u l=1u
X1480 VPWR VGND.t198 VPWR VPWR sg13_lv_pmos ad=0.19p pd=1.38u as=0 ps=0 w=1u l=1u
X1481 VGND.t551 VPWR VGND.t551 VGND.t553 sg13_lv_nmos ad=79.8f pd=0.8u as=0 ps=0 w=0.42u l=1u
X1482 sg13cmos5l_inv_1_0.A sg13cmos5l_inv_1_3.Y VPWR VPWR sg13_lv_pmos ad=0.2128p pd=1.5u as=0.2128p ps=1.5u w=1.12u l=0.13u
X1483 VPWR VGND.t314 VPWR VPWR sg13_lv_pmos ad=0.34p pd=2.68u as=0 ps=0 w=1u l=1u
X1484 VGND.t793 VPWR VGND.t793 VGND.t807 sg13_lv_nmos ad=0.1428p pd=1.52u as=0 ps=0 w=0.42u l=1u
X1485 sg13cmos5l_and2_1_0.B sg13cmos5l_inv_1_1.Y VGND.t34 VGND.t37 sg13_lv_nmos ad=0.1406p pd=1.12u as=0.1406p ps=1.12u w=0.74u l=0.13u
X1486 VPWR VGND.t622 VPWR VPWR sg13_lv_pmos ad=0.34p pd=2.68u as=0 ps=0 w=1u l=1u
X1487 VPWR VGND.t569 VPWR VPWR sg13_lv_pmos ad=0.19p pd=1.38u as=0 ps=0 w=1u l=1u
X1488 VGND.t10 sg13cmos5l_inv_16_4.A sg13cmos5l_inv_16_4.Y VGND.t89 sg13_lv_nmos ad=0.1406p pd=1.12u as=0.1406p ps=1.12u w=0.74u l=0.13u
X1489 VGND.t104 VPWR VGND.t104 VGND.t118 sg13_lv_nmos ad=79.8f pd=0.8u as=0 ps=0 w=0.42u l=1u
X1490 VGND.t375 VPWR VGND.t375 VGND.t379 sg13_lv_nmos ad=0.1428p pd=1.52u as=0 ps=0 w=0.42u l=1u
X1491 VGND.t793 VPWR VGND.t793 VGND.t821 sg13_lv_nmos ad=79.8f pd=0.8u as=0 ps=0 w=0.42u l=1u
X1492 VGND.t622 VPWR VGND.t622 VGND.t638 sg13_lv_nmos ad=0.1428p pd=1.52u as=0 ps=0 w=0.42u l=1u
X1493 VPWR VGND.t239 VPWR VPWR sg13_lv_pmos ad=0.34p pd=2.68u as=0 ps=0 w=1u l=1u
X1494 sg13cmos5l_and2_1_0.B sg13cmos5l_inv_1_1.Y VPWR VPWR sg13_lv_pmos ad=0.2128p pd=1.5u as=0.2128p ps=1.5u w=1.12u l=0.13u
X1495 VPWR VGND.t551 VPWR VPWR sg13_lv_pmos ad=0.19p pd=1.38u as=0 ps=0 w=1u l=1u
X1496 VPWR sg13cmos5l_inv_1_3.Y sg13cmos5l_inv_1_0.A VPWR sg13_lv_pmos ad=0.2128p pd=1.5u as=0.2128p ps=1.5u w=1.12u l=0.13u
X1497 VGND.t793 VPWR VGND.t793 VGND.t794 sg13_lv_nmos ad=79.8f pd=0.8u as=0 ps=0 w=0.42u l=1u
X1498 VGND.t915 VPWR VGND.t917 VGND.t916 sg13_lv_nmos ad=79.8f pd=0.8u as=0 ps=0 w=0.42u l=1u
X1499 VPWR VGND.t412 VPWR VPWR sg13_lv_pmos ad=0.19p pd=1.38u as=0 ps=0 w=1u l=1u
X1500 VGND.t104 VPWR VGND.t104 VGND.t129 sg13_lv_nmos ad=79.8f pd=0.8u as=0 ps=0 w=0.42u l=1u
X1501 VPWR VGND.t793 VPWR VPWR sg13_lv_pmos ad=0.19p pd=1.38u as=0 ps=0 w=1u l=1u
X1502 VPWR VGND.t622 VPWR VPWR sg13_lv_pmos ad=0.34p pd=2.68u as=0 ps=0 w=1u l=1u
X1503 VPWR VGND.t488 VPWR VPWR sg13_lv_pmos ad=0.19p pd=1.38u as=0 ps=0 w=1u l=1u
X1504 VPWR VGND.t707 VPWR VPWR sg13_lv_pmos ad=0.34p pd=2.68u as=0 ps=0 w=1u l=1u
X1505 VPWR VGND.t198 VPWR VPWR sg13_lv_pmos ad=0.19p pd=1.38u as=0 ps=0 w=1u l=1u
X1506 VGND.t121 VPWR VGND.t121 VGND.t122 sg13_lv_nmos ad=0.1428p pd=1.52u as=0 ps=0 w=0.42u l=1u
X1507 VGND.t713 VPWR VGND.t713 VGND.t729 sg13_lv_nmos ad=79.8f pd=0.8u as=0 ps=0 w=0.42u l=1u
X1508 VPWR VGND.t622 VPWR VPWR sg13_lv_pmos ad=0.34p pd=2.68u as=0 ps=0 w=1u l=1u
X1509 VPWR VGND.t531 VPWR VPWR sg13_lv_pmos ad=0.19p pd=1.38u as=0 ps=0 w=1u l=1u
X1510 VPWR VGND.t407 VPWR VPWR sg13_lv_pmos ad=0.19p pd=1.38u as=0 ps=0 w=1u l=1u
X1511 VPWR VGND.t398 VPWR VPWR sg13_lv_pmos ad=0.34p pd=2.68u as=0 ps=0 w=1u l=1u
X1512 VPWR VGND.t707 VPWR VPWR sg13_lv_pmos ad=0.34p pd=2.68u as=0 ps=0 w=1u l=1u
X1513 VGND.t799 VPWR VGND.t799 VGND.t800 sg13_lv_nmos ad=0.1428p pd=1.52u as=0 ps=0 w=0.42u l=1u
X1514 VGND.t831 VPWR VGND.t831 VGND.t833 sg13_lv_nmos ad=79.8f pd=0.8u as=0 ps=0 w=0.42u l=1u
X1515 VGND.t622 VPWR VGND.t622 VGND.t662 sg13_lv_nmos ad=0.1428p pd=1.52u as=0 ps=0 w=0.42u l=1u
X1516 VPWR VGND.t813 VPWR VPWR sg13_lv_pmos ad=0.34p pd=2.68u as=0 ps=0 w=1u l=1u
X1517 VGND.t488 VPWR VGND.t488 VGND.t492 sg13_lv_nmos ad=79.8f pd=0.8u as=0 ps=0 w=0.42u l=1u
X1518 VPWR VGND.t28 VPWR VPWR sg13_lv_pmos ad=0.19p pd=1.38u as=0 ps=0 w=1u l=1u
X1519 VPWR VGND.t137 VPWR VPWR sg13_lv_pmos ad=0.34p pd=2.68u as=0 ps=0 w=1u l=1u
X1520 VGND.t468 VPWR VGND.t472 VGND.t471 sg13_lv_nmos ad=79.8f pd=0.8u as=0 ps=0 w=0.42u l=1u
X1521 VGND.t622 VPWR VGND.t622 VGND.t656 sg13_lv_nmos ad=0.1428p pd=1.52u as=0 ps=0 w=0.42u l=1u
X1522 VPWR VGND.t939 VPWR VPWR sg13_lv_pmos ad=0.34p pd=2.68u as=0 ps=0 w=1u l=1u
X1523 VPWR VGND.t112 VPWR VPWR sg13_lv_pmos ad=0.19p pd=1.38u as=0 ps=0 w=1u l=1u
X1524 VPWR VGND.t793 VPWR VPWR sg13_lv_pmos ad=0.19p pd=1.38u as=0 ps=0 w=1u l=1u
X1525 VPWR VGND.t293 VPWR VPWR sg13_lv_pmos ad=0.19p pd=1.38u as=0 ps=0 w=1u l=1u
X1526 VGND.t329 VPWR VGND.t329 VGND.t328 sg13_lv_nmos ad=0.1428p pd=1.52u as=0 ps=0 w=0.42u l=1u
X1527 VPWR VGND.t482 VPWR VPWR sg13_lv_pmos ad=0.19p pd=1.38u as=0 ps=0 w=1u l=1u
X1528 VPWR sg13cmos5l_inv_16_4.A sg13cmos5l_inv_16_4.Y VPWR sg13_lv_pmos ad=0.2128p pd=1.5u as=0.2128p ps=1.5u w=1.12u l=0.13u
X1529 VPWR VGND.t622 VPWR VPWR sg13_lv_pmos ad=0.34p pd=2.68u as=0 ps=0 w=1u l=1u
X1530 VPWR VGND.t569 VPWR VPWR sg13_lv_pmos ad=0.19p pd=1.38u as=0 ps=0 w=1u l=1u
X1531 VGND.t229 VPWR VGND.t229 VGND.t232 sg13_lv_nmos ad=0.1428p pd=1.52u as=0 ps=0 w=0.42u l=1u
X1532 VGND.t793 VPWR VGND.t793 VGND.t808 sg13_lv_nmos ad=79.8f pd=0.8u as=0 ps=0 w=0.42u l=1u
X1533 VGND.t900 VPWR VGND.t899 VGND.t898 sg13_lv_nmos ad=0.1428p pd=1.52u as=0 ps=0 w=0.42u l=1u
X1534 VPWR VGND.t234 VPWR VPWR sg13_lv_pmos ad=0.19p pd=1.38u as=0 ps=0 w=1u l=1u
X1535 VPWR VGND.t143 VPWR VPWR sg13_lv_pmos ad=0.19p pd=1.38u as=0 ps=0 w=1u l=1u
X1536 VGND.t462 VPWR VGND.t462 VGND.t463 sg13_lv_nmos ad=79.8f pd=0.8u as=0 ps=0 w=0.42u l=1u
X1537 VPWR VGND.t3 VPWR VPWR sg13_lv_pmos ad=0.19p pd=1.38u as=0 ps=0 w=1u l=1u
X1538 VPWR VGND.t713 VPWR VPWR sg13_lv_pmos ad=0.19p pd=1.38u as=0 ps=0 w=1u l=1u
X1539 VPWR VGND.t324 VPWR VPWR sg13_lv_pmos ad=0.19p pd=1.38u as=0 ps=0 w=1u l=1u
X1540 sg13cmos5l_inv_16_4.Y sg13cmos5l_inv_16_4.A VPWR VPWR sg13_lv_pmos ad=0.2128p pd=1.5u as=0.2128p ps=1.5u w=1.12u l=0.13u
X1541 VGND.t198 VPWR VGND.t198 VGND.t223 sg13_lv_nmos ad=0.1428p pd=1.52u as=0 ps=0 w=0.42u l=1u
X1542 VPWR VGND.t793 VPWR VPWR sg13_lv_pmos ad=0.19p pd=1.38u as=0 ps=0 w=1u l=1u
X1543 VGND.t826 VPWR VGND.t826 VGND.t827 sg13_lv_nmos ad=0.1428p pd=1.52u as=0 ps=0 w=0.42u l=1u
X1544 VGND.t793 VPWR VGND.t793 VGND.t820 sg13_lv_nmos ad=0.1428p pd=1.52u as=0 ps=0 w=0.42u l=1u
X1545 VGND.t308 VPWR VGND.t308 VGND.t309 sg13_lv_nmos ad=79.8f pd=0.8u as=0 ps=0 w=0.42u l=1u
X1546 VPWR VGND.t293 VPWR VPWR sg13_lv_pmos ad=0.34p pd=2.68u as=0 ps=0 w=1u l=1u
X1547 VPWR VGND.t239 VPWR VPWR sg13_lv_pmos ad=0.19p pd=1.38u as=0 ps=0 w=1u l=1u
X1548 VPWR VGND.t793 VPWR VPWR sg13_lv_pmos ad=0.34p pd=2.68u as=0 ps=0 w=1u l=1u
X1549 VGND.t793 VPWR VGND.t826 VGND.t825 sg13_lv_nmos ad=79.8f pd=0.8u as=0 ps=0 w=0.42u l=1u
X1550 VPWR VGND.t329 VPWR VPWR sg13_lv_pmos ad=0.19p pd=1.38u as=0 ps=0 w=1u l=1u
X1551 VGND.t198 VPWR VGND.t216 VGND.t215 sg13_lv_nmos ad=79.8f pd=0.8u as=0 ps=0 w=0.42u l=1u
X1552 VGND.t484 VPWR VGND.t484 VGND.t485 sg13_lv_nmos ad=79.8f pd=0.8u as=0 ps=0 w=0.42u l=1u
X1553 VGND.t713 VPWR VGND.t713 VGND.t731 sg13_lv_nmos ad=79.8f pd=0.8u as=0 ps=0 w=0.42u l=1u
X1554 VGND.t920 VPWR VGND.t922 VGND.t921 sg13_lv_nmos ad=79.8f pd=0.8u as=0 ps=0 w=0.42u l=1u
X1555 VPWR VGND.t622 VPWR VPWR sg13_lv_pmos ad=0.34p pd=2.68u as=0 ps=0 w=1u l=1u
X1556 VPWR VGND.t41 VPWR VPWR sg13_lv_pmos ad=0.34p pd=2.68u as=0 ps=0 w=1u l=1u
X1557 VPWR VGND.t531 VPWR VPWR sg13_lv_pmos ad=0.19p pd=1.38u as=0 ps=0 w=1u l=1u
X1558 VPWR VGND.t574 VPWR VPWR sg13_lv_pmos ad=0.19p pd=1.38u as=0 ps=0 w=1u l=1u
X1559 VPWR VGND.t488 VPWR VPWR sg13_lv_pmos ad=0.34p pd=2.68u as=0 ps=0 w=1u l=1u
X1560 VPWR VGND.t531 VPWR VPWR sg13_lv_pmos ad=0.34p pd=2.68u as=0 ps=0 w=1u l=1u
X1561 VGND.t150 VPWR VGND.t150 VGND.t151 sg13_lv_nmos ad=0.1428p pd=1.52u as=0 ps=0 w=0.42u l=1u
X1562 VGND.t802 VPWR VGND.t802 VGND.t803 sg13_lv_nmos ad=0.1428p pd=1.52u as=0 ps=0 w=0.42u l=1u
X1563 VGND.t831 VPWR VGND.t836 VGND.t835 sg13_lv_nmos ad=79.8f pd=0.8u as=0 ps=0 w=0.42u l=1u
X1564 VGND.t622 VPWR VGND.t622 VGND.t650 sg13_lv_nmos ad=0.1428p pd=1.52u as=0 ps=0 w=0.42u l=1u
X1565 VGND.t713 VPWR VGND.t713 VGND.t747 sg13_lv_nmos ad=79.8f pd=0.8u as=0 ps=0 w=0.42u l=1u
X1566 VPWR VGND.t799 VPWR VPWR sg13_lv_pmos ad=0.34p pd=2.68u as=0 ps=0 w=1u l=1u
X1567 VPWR VGND.t622 VPWR VPWR sg13_lv_pmos ad=0.34p pd=2.68u as=0 ps=0 w=1u l=1u
X1568 VPWR VGND.t564 VPWR VPWR sg13_lv_pmos ad=0.19p pd=1.38u as=0 ps=0 w=1u l=1u
X1569 VPWR VGND.t203 VPWR VPWR sg13_lv_pmos ad=0.19p pd=1.38u as=0 ps=0 w=1u l=1u
X1570 VPWR VGND.t126 VPWR VPWR sg13_lv_pmos ad=0.34p pd=2.68u as=0 ps=0 w=1u l=1u
X1571 VGND.t15 VPWR VGND.t28 VGND.t503 sg13_lv_nmos ad=79.8f pd=0.8u as=0 ps=0 w=0.42u l=1u
X1572 VPWR VGND.t551 VPWR VPWR sg13_lv_pmos ad=0.19p pd=1.38u as=0 ps=0 w=1u l=1u
X1573 VPWR VGND.t198 VPWR VPWR sg13_lv_pmos ad=0.19p pd=1.38u as=0 ps=0 w=1u l=1u
X1574 VPWR VGND.t793 VPWR VPWR sg13_lv_pmos ad=0.19p pd=1.38u as=0 ps=0 w=1u l=1u
X1575 VGND.t104 VPWR VGND.t104 VGND.t131 sg13_lv_nmos ad=79.8f pd=0.8u as=0 ps=0 w=0.42u l=1u
X1576 VGND.t713 VPWR VGND.t713 VGND.t741 sg13_lv_nmos ad=79.8f pd=0.8u as=0 ps=0 w=0.42u l=1u
X1577 VPWR VGND.t622 VPWR VPWR sg13_lv_pmos ad=0.34p pd=2.68u as=0 ps=0 w=1u l=1u
X1578 VPWR VGND.t540 VPWR VPWR sg13_lv_pmos ad=0.19p pd=1.38u as=0 ps=0 w=1u l=1u
X1579 sg13cmos5l_and2_1_0.B sg13cmos5l_inv_1_1.Y VPWR VPWR sg13_lv_pmos ad=0.2128p pd=1.5u as=0.2128p ps=1.5u w=1.12u l=0.13u
X1580 VPWR VGND.t713 VPWR VPWR sg13_lv_pmos ad=0.19p pd=1.38u as=0 ps=0 w=1u l=1u
X1581 VPWR VGND.t468 VPWR VPWR sg13_lv_pmos ad=0.34p pd=2.68u as=0 ps=0 w=1u l=1u
X1582 VGND.t713 VPWR VGND.t713 VGND.t713 sg13_lv_nmos ad=79.8f pd=0.8u as=0 ps=0 w=0.42u l=1u
X1583 VGND.t826 VPWR VGND.t826 VGND.t829 sg13_lv_nmos ad=0.1428p pd=1.52u as=0 ps=0 w=0.42u l=1u
X1584 VGND.t793 VPWR VGND.t793 VGND.t822 sg13_lv_nmos ad=0.1428p pd=1.52u as=0 ps=0 w=0.42u l=1u
X1585 VPWR VGND.t826 VPWR VPWR sg13_lv_pmos ad=0.34p pd=2.68u as=0 ps=0 w=1u l=1u
X1586 VPWR VGND.t799 VPWR VPWR sg13_lv_pmos ad=0.19p pd=1.38u as=0 ps=0 w=1u l=1u
X1587 VPWR VGND.t449 VPWR VPWR sg13_lv_pmos ad=0.19p pd=1.38u as=0 ps=0 w=1u l=1u
X1588 VPWR VGND.t474 VPWR VPWR sg13_lv_pmos ad=0.19p pd=1.38u as=0 ps=0 w=1u l=1u
X1589 VGND.t826 VPWR VGND.t826 VGND.t828 sg13_lv_nmos ad=79.8f pd=0.8u as=0 ps=0 w=0.42u l=1u
X1590 VGND.t484 VPWR VGND.t488 VGND.t487 sg13_lv_nmos ad=79.8f pd=0.8u as=0 ps=0 w=0.42u l=1u
X1591 VPWR VGND.t64 VPWR VPWR sg13_lv_pmos ad=0.34p pd=2.68u as=0 ps=0 w=1u l=1u
X1592 VGND.t287 VPWR VGND.t287 VGND.t286 sg13_lv_nmos ad=0.1428p pd=1.52u as=0 ps=0 w=0.42u l=1u
X1593 VGND.t198 VPWR VGND.t229 VGND.t228 sg13_lv_nmos ad=79.8f pd=0.8u as=0 ps=0 w=0.42u l=1u
X1594 VPWR VGND.t713 VPWR VPWR sg13_lv_pmos ad=0.19p pd=1.38u as=0 ps=0 w=1u l=1u
X1595 sg13cmos5l_inv_1_3.A sg13cmos5l_and2_1_0.X VPWR VPWR sg13_lv_pmos ad=0.2128p pd=1.5u as=0.2128p ps=1.5u w=1.12u l=0.13u
X1596 VGND.t713 VPWR VGND.t713 VGND.t733 sg13_lv_nmos ad=79.8f pd=0.8u as=0 ps=0 w=0.42u l=1u
X1597 VPWR VGND.t969 VPWR VPWR sg13_lv_pmos ad=0.34p pd=2.68u as=0 ps=0 w=1u l=1u
X1598 VPWR VGND.t407 VPWR VPWR sg13_lv_pmos ad=0.34p pd=2.68u as=0 ps=0 w=1u l=1u
X1599 VGND.t381 VPWR VGND.t3 VGND.t385 sg13_lv_nmos ad=79.8f pd=0.8u as=0 ps=0 w=0.42u l=1u
X1600 VPWR VGND.t143 VPWR VPWR sg13_lv_pmos ad=0.34p pd=2.68u as=0 ps=0 w=1u l=1u
X1601 VGND.t15 sg13cmos5l_inv_16_4.A sg13cmos5l_inv_16_4.Y VGND.t99 sg13_lv_nmos ad=0.1406p pd=1.12u as=0.1406p ps=1.12u w=0.74u l=0.13u
X1602 VGND.t375 VPWR VGND.t375 VGND.t374 sg13_lv_nmos ad=0.1428p pd=1.52u as=0 ps=0 w=0.42u l=1u
X1603 VGND.t813 VPWR VGND.t813 VGND.t816 sg13_lv_nmos ad=0.1428p pd=1.52u as=0 ps=0 w=0.42u l=1u
X1604 VPWR VGND.t531 VPWR VPWR sg13_lv_pmos ad=0.34p pd=2.68u as=0 ps=0 w=1u l=1u
X1605 VGND.t713 VPWR VGND.t713 VGND.t727 sg13_lv_nmos ad=79.8f pd=0.8u as=0 ps=0 w=0.42u l=1u
X1606 VGND.t793 VPWR VGND.t793 VGND.t805 sg13_lv_nmos ad=0.1428p pd=1.52u as=0 ps=0 w=0.42u l=1u
X1607 VPWR VGND.t802 VPWR VPWR sg13_lv_pmos ad=0.34p pd=2.68u as=0 ps=0 w=1u l=1u
X1608 VGND.t329 VPWR VGND.t329 VGND.t332 sg13_lv_nmos ad=79.8f pd=0.8u as=0 ps=0 w=0.42u l=1u
X1609 VPWR VGND.t622 VPWR VPWR sg13_lv_pmos ad=0.19p pd=1.38u as=0 ps=0 w=1u l=1u
X1610 VPWR VGND.t564 VPWR VPWR sg13_lv_pmos ad=0.19p pd=1.38u as=0 ps=0 w=1u l=1u
X1611 VGND.t393 VPWR VGND.t393 VGND.t433 sg13_lv_nmos ad=79.8f pd=0.8u as=0 ps=0 w=0.42u l=1u
X1612 VPWR VGND.t713 VPWR VPWR sg13_lv_pmos ad=0.19p pd=1.38u as=0 ps=0 w=1u l=1u
X1613 VPWR VGND.t64 VPWR VPWR sg13_lv_pmos ad=0.19p pd=1.38u as=0 ps=0 w=1u l=1u
X1614 VPWR VGND.t329 VPWR VPWR sg13_lv_pmos ad=0.34p pd=2.68u as=0 ps=0 w=1u l=1u
X1615 VPWR VGND.t150 VPWR VPWR sg13_lv_pmos ad=0.34p pd=2.68u as=0 ps=0 w=1u l=1u
X1616 sg13cmos5l_inv_1_3.A sg13cmos5l_and2_1_0.X VPWR VPWR sg13_lv_pmos ad=0.2128p pd=1.5u as=0.2128p ps=1.5u w=1.12u l=0.13u
X1617 VPWR VGND.t234 VPWR VPWR sg13_lv_pmos ad=0.34p pd=2.68u as=0 ps=0 w=1u l=1u
X1618 VGND.t41 VPWR VGND.t41 VGND.t300 sg13_lv_nmos ad=0.1428p pd=1.52u as=0 ps=0 w=0.42u l=1u
X1619 VGND.t831 VPWR VGND.t831 VGND.t834 sg13_lv_nmos ad=0.1428p pd=1.52u as=0 ps=0 w=0.42u l=1u
X1620 VPWR VGND.t713 VPWR VPWR sg13_lv_pmos ad=0.19p pd=1.38u as=0 ps=0 w=1u l=1u
X1621 VGND.t28 VPWR VGND.t28 VGND.t505 sg13_lv_nmos ad=79.8f pd=0.8u as=0 ps=0 w=0.42u l=1u
X1622 VPWR VGND.t462 VPWR VPWR sg13_lv_pmos ad=0.34p pd=2.68u as=0 ps=0 w=1u l=1u
X1623 VGND.t198 VPWR VGND.t198 VGND.t200 sg13_lv_nmos ad=79.8f pd=0.8u as=0 ps=0 w=0.42u l=1u
X1624 VPWR VGND.t314 VPWR VPWR sg13_lv_pmos ad=0.19p pd=1.38u as=0 ps=0 w=1u l=1u
X1625 VPWR VGND.t551 VPWR VPWR sg13_lv_pmos ad=0.34p pd=2.68u as=0 ps=0 w=1u l=1u
X1626 VGND.t308 VPWR VGND.t308 VGND.t307 sg13_lv_nmos ad=0.1428p pd=1.52u as=0 ps=0 w=0.42u l=1u
X1627 VGND.t196 VPWR VGND.t198 VGND.t197 sg13_lv_nmos ad=79.8f pd=0.8u as=0 ps=0 w=0.42u l=1u
X1628 VGND.t713 VPWR VGND.t713 VGND.t743 sg13_lv_nmos ad=79.8f pd=0.8u as=0 ps=0 w=0.42u l=1u
X1629 VPWR VGND.t622 VPWR VPWR sg13_lv_pmos ad=0.34p pd=2.68u as=0 ps=0 w=1u l=1u
X1630 VGND.t239 VPWR VGND.t239 VGND.t242 sg13_lv_nmos ad=0.1428p pd=1.52u as=0 ps=0 w=0.42u l=1u
X1631 VPWR VGND.t104 VPWR VPWR sg13_lv_pmos ad=0.19p pd=1.38u as=0 ps=0 w=1u l=1u
X1632 VPWR VGND.t707 VPWR VPWR sg13_lv_pmos ad=0.34p pd=2.68u as=0 ps=0 w=1u l=1u
X1633 VPWR VGND.t198 VPWR VPWR sg13_lv_pmos ad=0.19p pd=1.38u as=0 ps=0 w=1u l=1u
X1634 VPWR sg13cmos5l_inv_1_3.Y sg13cmos5l_inv_1_0.A VPWR sg13_lv_pmos ad=0.2128p pd=1.5u as=0.2128p ps=1.5u w=1.12u l=0.13u
X1635 VPWR VGND.t239 VPWR VPWR sg13_lv_pmos ad=0.19p pd=1.38u as=0 ps=0 w=1u l=1u
X1636 VPWR VGND.t713 VPWR VPWR sg13_lv_pmos ad=0.19p pd=1.38u as=0 ps=0 w=1u l=1u
X1637 VPWR VGND.t574 VPWR VPWR sg13_lv_pmos ad=0.19p pd=1.38u as=0 ps=0 w=1u l=1u
X1638 VPWR VGND.t474 VPWR VPWR sg13_lv_pmos ad=0.34p pd=2.68u as=0 ps=0 w=1u l=1u
X1639 VGND.t569 VPWR VGND.t569 VGND.t570 sg13_lv_nmos ad=0.1428p pd=1.52u as=0 ps=0 w=0.42u l=1u
X1640 VPWR VGND.t569 VPWR VPWR sg13_lv_pmos ad=0.34p pd=2.68u as=0 ps=0 w=1u l=1u
X1641 VPWR VGND.t41 VPWR VPWR sg13_lv_pmos ad=0.34p pd=2.68u as=0 ps=0 w=1u l=1u
X1642 VGND.t793 VPWR VGND.t793 VGND.t809 sg13_lv_nmos ad=0.1428p pd=1.52u as=0 ps=0 w=0.42u l=1u
X1643 sg13cmos5l_inv_1_3.A sg13cmos5l_and2_1_0.X VGND.t3 VGND.t52 sg13_lv_nmos ad=0.1406p pd=1.12u as=0.1406p ps=1.12u w=0.74u l=0.13u
X1644 VGND.t462 VPWR VGND.t462 VGND.t464 sg13_lv_nmos ad=0.1428p pd=1.52u as=0 ps=0 w=0.42u l=1u
X1645 VPWR VGND.t474 VPWR VPWR sg13_lv_pmos ad=0.19p pd=1.38u as=0 ps=0 w=1u l=1u
X1646 VGND.t198 VPWR VGND.t198 VGND.t224 sg13_lv_nmos ad=79.8f pd=0.8u as=0 ps=0 w=0.42u l=1u
X1647 VGND.t793 VPWR VGND.t793 VGND.t797 sg13_lv_nmos ad=0.1428p pd=1.52u as=0 ps=0 w=0.42u l=1u
X1648 VPWR VGND.t203 VPWR VPWR sg13_lv_pmos ad=0.34p pd=2.68u as=0 ps=0 w=1u l=1u
X1649 VGND.t137 VPWR VGND.t137 VGND.t139 sg13_lv_nmos ad=0.1428p pd=1.52u as=0 ps=0 w=0.42u l=1u
X1650 VPWR VGND.t793 VPWR VPWR sg13_lv_pmos ad=0.34p pd=2.68u as=0 ps=0 w=1u l=1u
X1651 VPWR VGND.t198 VPWR VPWR sg13_lv_pmos ad=0.34p pd=2.68u as=0 ps=0 w=1u l=1u
X1652 VPWR VGND.t104 VPWR VPWR sg13_lv_pmos ad=0.34p pd=2.68u as=0 ps=0 w=1u l=1u
X1653 VGND.t64 VPWR VGND.t64 VGND.t427 sg13_lv_nmos ad=79.8f pd=0.8u as=0 ps=0 w=0.42u l=1u
X1654 VPWR VGND.t375 VPWR VPWR sg13_lv_pmos ad=0.34p pd=2.68u as=0 ps=0 w=1u l=1u
X1655 VPWR VGND.t813 VPWR VPWR sg13_lv_pmos ad=0.34p pd=2.68u as=0 ps=0 w=1u l=1u
X1656 VGND.t713 VPWR VGND.t713 VGND.t721 sg13_lv_nmos ad=79.8f pd=0.8u as=0 ps=0 w=0.42u l=1u
X1657 VGND.t793 VPWR VGND.t793 VGND.t818 sg13_lv_nmos ad=0.1428p pd=1.52u as=0 ps=0 w=0.42u l=1u
X1658 VGND.t713 VPWR VGND.t713 VGND.t732 sg13_lv_nmos ad=0.1428p pd=1.52u as=0 ps=0 w=0.42u l=1u
X1659 VPWR VGND.t531 VPWR VPWR sg13_lv_pmos ad=0.34p pd=2.68u as=0 ps=0 w=1u l=1u
X1660 VPWR VGND.t198 VPWR VPWR sg13_lv_pmos ad=0.19p pd=1.38u as=0 ps=0 w=1u l=1u
X1661 VPWR VGND.t793 VPWR VPWR sg13_lv_pmos ad=0.34p pd=2.68u as=0 ps=0 w=1u l=1u
X1662 VGND.t713 VPWR VGND.t713 VGND.t737 sg13_lv_nmos ad=79.8f pd=0.8u as=0 ps=0 w=0.42u l=1u
X1663 VPWR VGND.t713 VPWR VPWR sg13_lv_pmos ad=0.19p pd=1.38u as=0 ps=0 w=1u l=1u
X1664 VPWR VGND.t484 VPWR VPWR sg13_lv_pmos ad=0.34p pd=2.68u as=0 ps=0 w=1u l=1u
X1665 VGND.t836 VPWR VGND.t836 VGND.t837 sg13_lv_nmos ad=0.1428p pd=1.52u as=0 ps=0 w=0.42u l=1u
X1666 VGND.t375 VPWR VGND.t381 VGND.t380 sg13_lv_nmos ad=79.8f pd=0.8u as=0 ps=0 w=0.42u l=1u
X1667 VGND.t449 VPWR VGND.t454 VGND.t499 sg13_lv_nmos ad=79.8f pd=0.8u as=0 ps=0 w=0.42u l=1u
X1668 VPWR VGND.t713 VPWR VPWR sg13_lv_pmos ad=0.19p pd=1.38u as=0 ps=0 w=1u l=1u
X1669 VGND.t15 sg13cmos5l_inv_16_2.A sg13cmos5l_inv_16_2.Y VGND.t17 sg13_lv_nmos ad=0.1406p pd=1.12u as=0.1406p ps=1.12u w=0.74u l=0.13u
X1670 VGND.t920 VPWR VGND.t919 VGND.t918 sg13_lv_nmos ad=0.1428p pd=1.52u as=0 ps=0 w=0.42u l=1u
X1671 VPWR VGND.t793 VPWR VPWR sg13_lv_pmos ad=0.19p pd=1.38u as=0 ps=0 w=1u l=1u
X1672 VPWR VGND.t398 VPWR VPWR sg13_lv_pmos ad=0.34p pd=2.68u as=0 ps=0 w=1u l=1u
X1673 VGND.t713 VPWR VGND.t713 VGND.t745 sg13_lv_nmos ad=79.8f pd=0.8u as=0 ps=0 w=0.42u l=1u
X1674 VGND.t229 VPWR VGND.t234 VGND.t233 sg13_lv_nmos ad=79.8f pd=0.8u as=0 ps=0 w=0.42u l=1u
X1675 VPWR VGND.t793 VPWR VPWR sg13_lv_pmos ad=0.34p pd=2.68u as=0 ps=0 w=1u l=1u
X1676 sg13cmos5l_inv_16_2.Y sg13cmos5l_inv_16_2.A VGND.t12 VGND.t13 sg13_lv_nmos ad=0.1406p pd=1.12u as=0.1406p ps=1.12u w=0.74u l=0.13u
X1677 VPWR VGND.t713 VPWR VPWR sg13_lv_pmos ad=0.19p pd=1.38u as=0 ps=0 w=1u l=1u
X1678 VPWR VGND.t574 VPWR VPWR sg13_lv_pmos ad=0.34p pd=2.68u as=0 ps=0 w=1u l=1u
X1679 VGND.t239 VPWR VGND.t239 VGND.t241 sg13_lv_nmos ad=79.8f pd=0.8u as=0 ps=0 w=0.42u l=1u
X1680 VGND.t793 VPWR VGND.t793 VGND.t811 sg13_lv_nmos ad=0.1428p pd=1.52u as=0 ps=0 w=0.42u l=1u
X1681 VGND.t940 VPWR VGND.t942 VGND.t941 sg13_lv_nmos ad=79.8f pd=0.8u as=0 ps=0 w=0.42u l=1u
X1682 VGND.t468 VPWR VGND.t468 VGND.t467 sg13_lv_nmos ad=0.1428p pd=1.52u as=0 ps=0 w=0.42u l=1u
X1683 VPWR VGND.t713 VPWR VPWR sg13_lv_pmos ad=0.34p pd=2.68u as=0 ps=0 w=1u l=1u
X1684 VPWR VGND.t793 VPWR VPWR sg13_lv_pmos ad=0.34p pd=2.68u as=0 ps=0 w=1u l=1u
X1685 VGND.t64 VPWR VGND.t64 VGND.t429 sg13_lv_nmos ad=79.8f pd=0.8u as=0 ps=0 w=0.42u l=1u
X1686 VPWR VGND.t799 VPWR VPWR sg13_lv_pmos ad=0.34p pd=2.68u as=0 ps=0 w=1u l=1u
X1687 VPWR VGND.t713 VPWR VPWR sg13_lv_pmos ad=0.19p pd=1.38u as=0 ps=0 w=1u l=1u
X1688 VPWR VGND.t474 VPWR VPWR sg13_lv_pmos ad=0.34p pd=2.68u as=0 ps=0 w=1u l=1u
X1689 sg13cmos5l_inv_16_2.Y sg13cmos5l_inv_16_2.A VPWR VPWR sg13_lv_pmos ad=0.2128p pd=1.5u as=0.2128p ps=1.5u w=1.12u l=0.13u
X1690 VPWR VGND.t112 VPWR VPWR sg13_lv_pmos ad=0.34p pd=2.68u as=0 ps=0 w=1u l=1u
X1691 sg13cmos5l_inv_16_4.Y sg13cmos5l_inv_16_4.A VPWR VPWR sg13_lv_pmos ad=0.2128p pd=1.5u as=0.2128p ps=1.5u w=1.12u l=0.13u
X1692 VPWR VGND.t196 VPWR VPWR sg13_lv_pmos ad=0.34p pd=2.68u as=0 ps=0 w=1u l=1u
X1693 VPWR VGND.t104 VPWR VPWR sg13_lv_pmos ad=0.19p pd=1.38u as=0 ps=0 w=1u l=1u
X1694 VGND.t713 VPWR VGND.t713 VGND.t734 sg13_lv_nmos ad=0.1428p pd=1.52u as=0 ps=0 w=0.42u l=1u
X1695 VPWR VGND.t531 VPWR VPWR sg13_lv_pmos ad=0.34p pd=2.68u as=0 ps=0 w=1u l=1u
X1696 VGND.t198 VPWR VGND.t203 VGND.t202 sg13_lv_nmos ad=79.8f pd=0.8u as=0 ps=0 w=0.42u l=1u
X1697 VPWR sg13cmos5l_inv_16_2.A sg13cmos5l_inv_16_2.Y VPWR sg13_lv_pmos ad=0.2128p pd=1.5u as=0.2128p ps=1.5u w=1.12u l=0.13u
X1698 VGND.t407 VPWR VGND.t407 VGND.t445 sg13_lv_nmos ad=79.8f pd=0.8u as=0 ps=0 w=0.42u l=1u
X1699 VGND.t569 VPWR VGND.t569 VGND.t570 sg13_lv_nmos ad=0.1428p pd=1.52u as=0 ps=0 w=0.42u l=1u
X1700 VGND.t713 VPWR VGND.t713 VGND.t739 sg13_lv_nmos ad=79.8f pd=0.8u as=0 ps=0 w=0.42u l=1u
X1701 VGND.t308 VPWR VGND.t308 VGND.t310 sg13_lv_nmos ad=0.1428p pd=1.52u as=0 ps=0 w=0.42u l=1u
X1702 VGND.t836 VPWR VGND.t836 VGND.t839 sg13_lv_nmos ad=0.1428p pd=1.52u as=0 ps=0 w=0.42u l=1u
X1703 VGND.t3 sg13cmos5l_and2_1_0.B a_3979_9540# VGND.t48 sg13_lv_nmos ad=0.1331p pd=1.12u as=0.1216p ps=1.02u w=0.64u l=0.13u
X1704 VGND.t381 VPWR VGND.t381 VGND.t383 sg13_lv_nmos ad=79.8f pd=0.8u as=0 ps=0 w=0.42u l=1u
X1705 VGND.t198 VPWR VGND.t198 VGND.t209 sg13_lv_nmos ad=79.8f pd=0.8u as=0 ps=0 w=0.42u l=1u
X1706 VGND.t143 VPWR VGND.t143 VGND.t188 sg13_lv_nmos ad=79.8f pd=0.8u as=0 ps=0 w=0.42u l=1u
X1707 VPWR VGND.t713 VPWR VPWR sg13_lv_pmos ad=0.19p pd=1.38u as=0 ps=0 w=1u l=1u
X1708 VGND.t454 VPWR VGND.t10 VGND.t501 sg13_lv_nmos ad=79.8f pd=0.8u as=0 ps=0 w=0.42u l=1u
X1709 VPWR VGND.t329 VPWR VPWR sg13_lv_pmos ad=0.34p pd=2.68u as=0 ps=0 w=1u l=1u
R0 VGND.n329 VGND.n52 6300
R1 VGND.n52 VGND.n115 6300
R2 VGND.n115 VGND.n22 6300
R3 VGND.n22 VGND.n327 6300
R4 VGND.n327 VGND.n1 6300
R5 VGND.n1 VGND.n326 6300
R6 VGND.n326 VGND.n325 6300
R7 VGND.n90 VGND.t976 183.806
R8 VGND.n90 VGND.t886 183.804
R9 VGND.t891 VGND.n90 183.805
R10 VGND.n90 VGND.t896 183.806
R11 VGND.n90 VGND.t923 182.042
R12 VGND.t938 VGND.n90 182.042
R13 VGND.n90 VGND.t966 183.805
R14 VGND.n329 VGND.n90 6413.31
R15 VGND.t70 VGND.n3 418.56
R16 VGND.n327 VGND.n146 411.43
R17 VGND.t883 VGND.n90 181.875
R18 VGND.n90 VGND.t898 182.042
R19 VGND.t913 VGND.n90 182.042
R20 VGND.n276 VGND.t86 402.858
R21 VGND.t67 VGND.t68 402.858
R22 VGND.t87 VGND.n270 394.286
R23 VGND.t26 VGND.n260 394.286
R24 VGND.n188 VGND.t71 394.286
R25 VGND.n310 VGND.t31 394.286
R26 VGND.n90 VGND.t921 183.805
R27 VGND.n90 VGND.t946 183.805
R28 VGND.n90 VGND.t961 183.805
R29 VGND.n90 VGND.t971 183.805
R30 VGND.t2 VGND.n186 385.714
R31 VGND.t66 VGND.n176 377.144
R32 VGND.t47 VGND.n303 377.144
R33 VGND.n153 VGND.t4 372.858
R34 VGND.t72 VGND.n185 368.572
R35 VGND.n187 VGND.t48 360
R36 VGND.n197 VGND.t65 351.43
R37 VGND.n316 VGND.t46 351.43
R38 VGND.t89 VGND.n269 342.858
R39 VGND.t24 VGND.n261 342.858
R40 VGND.n189 VGND.t73 342.858
R41 VGND.n311 VGND.t33 342.858
R42 VGND.t906 VGND.n90 183.806
R43 VGND.t916 VGND.n90 183.806
R44 VGND.t936 VGND.n90 183.806
R45 VGND.t951 VGND.n90 183.806
R46 VGND.t986 VGND.n90 183.806
R47 VGND.t63 VGND.n177 325.714
R48 VGND.n90 VGND.t983 182.042
R49 VGND.n90 VGND.t978 182.042
R50 VGND.t968 VGND.n90 182.042
R51 VGND.n90 VGND.t963 182.042
R52 VGND.t958 VGND.n90 182.042
R53 VGND.n90 VGND.t953 182.042
R54 VGND.t948 VGND.n90 182.042
R55 VGND.n90 VGND.t943 182.042
R56 VGND.n90 VGND.t941 183.806
R57 VGND.n90 VGND.t933 182.042
R58 VGND.t928 VGND.n90 182.042
R59 VGND.t926 VGND.n90 183.806
R60 VGND.t918 VGND.n90 182.042
R61 VGND.t908 VGND.n90 182.042
R62 VGND.n90 VGND.t903 182.042
R63 VGND.n90 VGND.t901 183.805
R64 VGND.n90 VGND.t893 182.042
R65 VGND.t888 VGND.n90 182.042
R66 VGND.n90 VGND.t973 182.042
R67 VGND.n278 VGND.t90 317.144
R68 VGND.n284 VGND.t23 317.144
R69 VGND.t74 VGND.n184 317.144
R70 VGND.t35 VGND.n308 317.144
R71 VGND.t102 VGND.n146 312.858
R72 VGND.t50 VGND.n152 312.858
R73 VGND.n196 VGND.t62 300
R74 VGND.n315 VGND.t44 300
R75 VGND.t91 VGND.n268 291.43
R76 VGND.t22 VGND.n262 291.43
R77 VGND.n312 VGND.t36 291.43
R78 VGND.t49 VGND.t75 282.858
R79 VGND.t61 VGND.n178 274.286
R80 VGND.t43 VGND.n305 274.286
R81 VGND.n279 VGND.t92 265.714
R82 VGND.n283 VGND.t21 265.714
R83 VGND.t76 VGND.n183 265.714
R84 VGND.t793 VGND.t797 109.001
R85 VGND.t800 VGND.t793 109.001
R86 VGND.t814 VGND.t793 109.001
R87 VGND.t793 VGND.t820 108.999
R88 VGND.t793 VGND.t834 108.999
R89 VGND.t837 VGND.t793 109.001
R90 VGND.t713 VGND.t724 108.999
R91 VGND.t730 VGND.t713 109.001
R92 VGND.t713 VGND.t736 108.999
R93 VGND.t713 VGND.t748 108.999
R94 VGND.t632 VGND.t622 109.001
R95 VGND.t636 VGND.t622 109.001
R96 VGND.t622 VGND.t642 108.999
R97 VGND.t622 VGND.t650 108.999
R98 VGND.t622 VGND.t658 108.999
R99 VGND.t622 VGND.t662 108.999
R100 VGND.t531 VGND.t535 109.001
R101 VGND.t547 VGND.t531 109.001
R102 VGND.t531 VGND.t554 108.999
R103 VGND.t531 VGND.t567 108.999
R104 VGND.t377 VGND.n5 109.001
R105 VGND.t382 VGND.n5 109.001
R106 VGND.t296 VGND.t287 252.065
R107 VGND.t204 VGND.t198 109.001
R108 VGND.t198 VGND.t214 108.999
R109 VGND.t217 VGND.t198 109.001
R110 VGND.t221 VGND.t198 109.001
R111 VGND.t198 VGND.t227 108.999
R112 VGND.t198 VGND.t237 108.999
R113 VGND.t104 VGND.t106 109.001
R114 VGND.t104 VGND.t115 108.999
R115 VGND.t104 VGND.t119 108.999
R116 VGND.t104 VGND.t124 108.999
R117 VGND.n232 VGND.t459 252.041
R118 VGND.t461 VGND.n221 252.041
R119 VGND.n234 VGND.t464 252.041
R120 VGND.t467 VGND.n219 252.041
R121 VGND.n236 VGND.t470 252.041
R122 VGND.t473 VGND.n217 252.041
R123 VGND.n238 VGND.t476 252.041
R124 VGND.t478 VGND.n215 252.041
R125 VGND.n240 VGND.t480 252.041
R126 VGND.t483 VGND.n213 252.041
R127 VGND.n242 VGND.t486 252.041
R128 VGND.t489 VGND.n211 252.041
R129 VGND.n244 VGND.t491 252.041
R130 VGND.n97 VGND.t287 9.63482
R131 VGND.n95 VGND.t347 99.5774
R132 VGND.n99 VGND.t287 9.63482
R133 VGND.n92 VGND.t351 99.5774
R134 VGND.n102 VGND.t287 9.63482
R135 VGND.t287 VGND.n88 9.63482
R136 VGND.n104 VGND.t287 9.63482
R137 VGND.n85 VGND.t359 99.5774
R138 VGND.t361 VGND.n107 99.5774
R139 VGND.t287 VGND.n80 9.63482
R140 VGND.n112 VGND.t287 9.63482
R141 VGND.t287 VGND.n77 9.63482
R142 VGND.t369 VGND.n114 99.5774
R143 VGND.t287 VGND.n74 9.63482
R144 VGND.n329 VGND.t793 427.5
R145 VGND.t713 VGND.t706 108.722
R146 VGND.t622 VGND.n115 427.5
R147 VGND.t530 VGND.t531 108.722
R148 VGND.t374 VGND.n5 108.722
R149 VGND.t286 VGND.n117 108.722
R150 VGND.t195 VGND.n116 108.722
R151 VGND.t104 VGND.t103 108.722
R152 VGND.t128 VGND.n36 251.417
R153 VGND.n38 VGND.t177 251.417
R154 VGND.n39 VGND.t130 251.417
R155 VGND.t179 VGND.n34 251.417
R156 VGND.t132 VGND.n33 251.417
R157 VGND.n41 VGND.t181 251.417
R158 VGND.n42 VGND.t134 251.417
R159 VGND.t183 VGND.n31 251.417
R160 VGND.t136 VGND.n30 251.417
R161 VGND.n44 VGND.t185 251.417
R162 VGND.n45 VGND.t139 251.417
R163 VGND.t187 VGND.n28 251.417
R164 VGND.t142 VGND.n27 251.417
R165 VGND.n47 VGND.t189 251.417
R166 VGND.n48 VGND.t145 251.417
R167 VGND.t191 VGND.n25 251.417
R168 VGND.t148 VGND.n24 251.417
R169 VGND.n50 VGND.t193 251.417
R170 VGND.n51 VGND.t151 251.417
R171 VGND.n195 VGND.t60 248.571
R172 VGND.n314 VGND.t42 248.571
R173 VGND.t796 VGND.t793 109.992
R174 VGND.t793 VGND.t804 109.992
R175 VGND.t806 VGND.t793 109.992
R176 VGND.t793 VGND.t808 109.992
R177 VGND.t810 VGND.t793 109.992
R178 VGND.t823 VGND.t793 109.992
R179 VGND.t793 VGND.t825 109.993
R180 VGND.t828 VGND.t793 109.992
R181 VGND.t833 VGND.t793 109.992
R182 VGND.t713 VGND.t717 109.992
R183 VGND.t723 VGND.t713 109.992
R184 VGND.t727 VGND.t713 109.992
R185 VGND.t735 VGND.t713 109.992
R186 VGND.t739 VGND.t713 109.992
R187 VGND.t713 VGND.t741 109.993
R188 VGND.t743 VGND.t713 109.992
R189 VGND.t713 VGND.t745 109.993
R190 VGND.t747 VGND.t713 109.992
R191 VGND.t622 VGND.t623 109.986
R192 VGND.t622 VGND.t627 109.992
R193 VGND.t622 VGND.t639 109.993
R194 VGND.t641 VGND.t622 109.992
R195 VGND.t645 VGND.t622 109.992
R196 VGND.t649 VGND.t622 109.992
R197 VGND.t661 VGND.t622 109.992
R198 VGND.t531 VGND.t532 109.986
R199 VGND.t534 VGND.t531 109.992
R200 VGND.t531 VGND.t542 109.992
R201 VGND.t531 VGND.t546 109.992
R202 VGND.t553 VGND.t531 109.992
R203 VGND.t557 VGND.t531 109.992
R204 VGND.t531 VGND.t559 109.993
R205 VGND.t531 VGND.t563 109.993
R206 VGND.t566 VGND.t531 109.992
R207 VGND.t571 VGND.t531 109.992
R208 VGND.t531 VGND.t573 109.993
R209 VGND.t576 VGND.t531 109.992
R210 VGND.n5 VGND.t376 109.986
R211 VGND.t287 VGND.t288 109.986
R212 VGND.t290 VGND.t287 109.992
R213 VGND.t198 VGND.t202 109.992
R214 VGND.t198 VGND.t207 109.992
R215 VGND.t209 VGND.t198 109.992
R216 VGND.t198 VGND.t211 109.992
R217 VGND.t213 VGND.t198 109.992
R218 VGND.t198 VGND.t224 109.993
R219 VGND.t226 VGND.t198 109.992
R220 VGND.t231 VGND.t198 109.992
R221 VGND.t198 VGND.t233 109.993
R222 VGND.t236 VGND.t198 109.992
R223 VGND.t109 VGND.t104 109.992
R224 VGND.t104 VGND.t111 109.992
R225 VGND.t118 VGND.t104 109.992
R226 VGND.t123 VGND.t104 109.992
R227 VGND.t529 VGND.t493 243.483
R228 VGND.n118 VGND.t336 100.885
R229 VGND.n244 VGND.t527 243.47
R230 VGND.t525 VGND.n211 243.47
R231 VGND.n242 VGND.t523 243.47
R232 VGND.t521 VGND.n213 243.47
R233 VGND.n240 VGND.t519 243.47
R234 VGND.t517 VGND.n215 243.47
R235 VGND.n238 VGND.t515 243.47
R236 VGND.t513 VGND.n217 243.47
R237 VGND.n236 VGND.t511 243.47
R238 VGND.t509 VGND.n219 243.47
R239 VGND.n234 VGND.t507 243.47
R240 VGND.t505 VGND.n221 243.47
R241 VGND.n232 VGND.t503 243.47
R242 VGND.t287 VGND.n75 9.30721
R243 VGND.t332 VGND.n113 100.883
R244 VGND.n78 VGND.t330 100.883
R245 VGND.n111 VGND.t287 9.30721
R246 VGND.t287 VGND.n79 9.30721
R247 VGND.t321 VGND.n106 100.883
R248 VGND.n84 VGND.t319 100.883
R249 VGND.t317 VGND.n105 100.883
R250 VGND.t287 VGND.n87 9.30721
R251 VGND.n101 VGND.t287 9.30721
R252 VGND.t287 VGND.n91 9.30721
R253 VGND.t305 VGND.n100 100.883
R254 VGND.n94 VGND.t303 100.883
R255 VGND.n96 VGND.t287 9.30721
R256 VGND.t152 VGND.t194 243.139
R257 VGND.t176 VGND.n37 242.846
R258 VGND.t129 VGND.n38 242.846
R259 VGND.n35 VGND.t178 242.846
R260 VGND.n34 VGND.t131 242.846
R261 VGND.t180 VGND.n40 242.846
R262 VGND.t133 VGND.n41 242.846
R263 VGND.n32 VGND.t182 242.846
R264 VGND.n31 VGND.t135 242.846
R265 VGND.t184 VGND.n43 242.846
R266 VGND.t138 VGND.n44 242.846
R267 VGND.n29 VGND.t186 242.846
R268 VGND.n28 VGND.t140 242.846
R269 VGND.t188 VGND.n46 242.846
R270 VGND.t144 VGND.n47 242.846
R271 VGND.n26 VGND.t190 242.846
R272 VGND.n25 VGND.t146 242.846
R273 VGND.t192 VGND.n49 242.846
R274 VGND.t149 VGND.n50 242.846
R275 VGND.t93 VGND.n267 240
R276 VGND.t20 VGND.n263 240
R277 VGND.n191 VGND.t77 240
R278 VGND.n313 VGND.t38 240
R279 VGND.t494 VGND.n273 235.714
R280 VGND.t448 VGND.n272 235.714
R281 VGND.n274 VGND.t451 235.714
R282 VGND.t453 VGND.n271 235.714
R283 VGND.n275 VGND.t456 235.714
R284 VGND.n285 VGND.t502 235.714
R285 VGND.t504 VGND.n259 235.714
R286 VGND.n287 VGND.t506 235.714
R287 VGND.t508 VGND.n257 235.714
R288 VGND.n289 VGND.t510 235.714
R289 VGND.t512 VGND.n255 235.714
R290 VGND.n291 VGND.t514 235.714
R291 VGND.t516 VGND.n253 235.714
R292 VGND.n293 VGND.t518 235.714
R293 VGND.t520 VGND.n251 235.714
R294 VGND.n295 VGND.t522 235.714
R295 VGND.t524 VGND.n249 235.714
R296 VGND.n297 VGND.t526 235.714
R297 VGND.t528 VGND.n247 235.714
R298 VGND.n83 VGND.t424 101.781
R299 VGND.t426 VGND.n71 105.683
R300 VGND.t390 VGND.n86 106.677
R301 VGND.n68 VGND.t392 106.677
R302 VGND.n93 VGND.t432 105.684
R303 VGND.t434 VGND.n66 105.683
R304 VGND.t400 VGND.n98 106.677
R305 VGND.n103 VGND.t440 105.684
R306 VGND.t442 VGND.n57 105.683
R307 VGND.n110 VGND.t444 105.684
R308 VGND.t300 VGND.n304 235.714
R309 VGND.n97 VGND.t302 242.431
R310 VGND.t304 VGND.n95 242.431
R311 VGND.n99 VGND.t307 242.431
R312 VGND.t310 VGND.n92 242.431
R313 VGND.n102 VGND.t313 242.431
R314 VGND.t316 VGND.n88 242.431
R315 VGND.n104 VGND.t318 242.431
R316 VGND.t320 VGND.n85 242.431
R317 VGND.n107 VGND.t323 242.431
R318 VGND.t326 VGND.n80 242.431
R319 VGND.n112 VGND.t328 242.431
R320 VGND.t331 VGND.n77 242.431
R321 VGND.n114 VGND.t333 242.431
R322 VGND.t335 VGND.n74 242.431
R323 VGND.t175 VGND.n152 235.714
R324 VGND.t495 VGND.n272 227.143
R325 VGND.n274 VGND.t497 227.143
R326 VGND.t499 VGND.n271 227.143
R327 VGND.n275 VGND.t501 227.143
R328 VGND.n276 VGND.t457 227.143
R329 VGND.n286 VGND.t460 227.143
R330 VGND.t463 VGND.n258 227.143
R331 VGND.n288 VGND.t465 227.143
R332 VGND.t469 VGND.n256 227.143
R333 VGND.n290 VGND.t471 227.143
R334 VGND.t475 VGND.n254 227.143
R335 VGND.n292 VGND.t477 227.143
R336 VGND.t479 VGND.n252 227.143
R337 VGND.n294 VGND.t481 227.143
R338 VGND.t485 VGND.n250 227.143
R339 VGND.n296 VGND.t487 227.143
R340 VGND.t490 VGND.n248 227.143
R341 VGND.n298 VGND.t492 227.143
R342 VGND.t402 VGND.n59 106.677
R343 VGND.t411 VGND.n53 106.677
R344 VGND.t297 VGND.n309 227.143
R345 VGND.t350 VGND.n91 234.188
R346 VGND.n101 VGND.t352 234.188
R347 VGND.t354 VGND.n87 234.188
R348 VGND.t362 VGND.n79 234.188
R349 VGND.n111 VGND.t364 234.188
R350 VGND.t370 VGND.n75 234.188
R351 VGND.n108 VGND.t174 109.7
R352 VGND.t59 VGND.n179 222.857
R353 VGND.n5 VGND.n76 96.0268
R354 VGND.n109 VGND.t104 96.0268
R355 VGND.t386 VGND.n2 110.704
R356 VGND.t2 VGND.n2 41.7419
R357 VGND.n280 VGND.t94 214.286
R358 VGND.n282 VGND.t19 214.286
R359 VGND.t78 VGND.n182 214.286
R360 VGND.t39 VGND.n306 214.286
R361 VGND.n277 VGND.t458 205.714
R362 VGND.t794 VGND.t793 109.986
R363 VGND.t812 VGND.t793 109.993
R364 VGND.t817 VGND.t793 109.993
R365 VGND.t830 VGND.t793 109.993
R366 VGND.t835 VGND.t793 109.993
R367 VGND.t708 VGND.t713 109.986
R368 VGND.t729 VGND.t713 109.993
R369 VGND.t733 VGND.t713 109.993
R370 VGND.t643 VGND.t622 109.993
R371 VGND.t647 VGND.t622 109.993
R372 VGND.t655 VGND.t622 109.993
R373 VGND.t659 VGND.t622 109.993
R374 VGND.t550 VGND.t531 109.993
R375 VGND.n227 VGND.t495 200.613
R376 VGND.n228 VGND.t450 200.613
R377 VGND.t497 VGND.n226 200.613
R378 VGND.t452 VGND.n225 200.613
R379 VGND.n229 VGND.t499 200.613
R380 VGND.n230 VGND.t455 200.613
R381 VGND.t501 VGND.n224 200.613
R382 VGND.t457 VGND.n223 200.613
R383 VGND.t380 VGND.n5 109.993
R384 VGND.t385 VGND.n5 200.613
R385 VGND.n73 VGND.n5 86.7547
R386 VGND.n71 VGND.t388 106.677
R387 VGND.n72 VGND.t427 23.2336
R388 VGND.n86 VGND.n5 3.31705
R389 VGND.t429 VGND.n70 23.2336
R390 VGND.n5 VGND.n69 86.7547
R391 VGND.t395 VGND.n93 106.677
R392 VGND.n67 VGND.n5 86.7547
R393 VGND.n66 VGND.t397 106.677
R394 VGND.n5 VGND.n65 86.7547
R395 VGND.n98 VGND.n5 3.31705
R396 VGND.t437 VGND.n64 23.2336
R397 VGND.n5 VGND.n59 3.31704
R398 VGND.n60 VGND.t439 23.2336
R399 VGND.t404 VGND.n103 106.677
R400 VGND.n58 VGND.n5 86.7547
R401 VGND.n57 VGND.t406 106.677
R402 VGND.n5 VGND.n56 86.7547
R403 VGND.t409 VGND.n110 106.677
R404 VGND.n55 VGND.n5 86.7547
R405 VGND.n5 VGND.n53 3.31704
R406 VGND.n54 VGND.t447 23.233
R407 VGND.t414 VGND.n5 109.987
R408 VGND.t197 VGND.t198 109.986
R409 VGND.t215 VGND.t198 109.993
R410 VGND.t220 VGND.t198 109.993
R411 VGND.t228 VGND.t198 109.993
R412 VGND.t104 VGND.t105 109.986
R413 VGND.t116 VGND.t104 109.993
R414 VGND.t125 VGND.t104 109.993
R415 VGND.n108 VGND.t104 0.294308
R416 VGND.t460 VGND.n233 199.989
R417 VGND.n220 VGND.t463 199.989
R418 VGND.t465 VGND.n235 199.989
R419 VGND.n218 VGND.t469 199.989
R420 VGND.t471 VGND.n237 199.989
R421 VGND.n216 VGND.t475 199.989
R422 VGND.t477 VGND.n239 199.989
R423 VGND.n214 VGND.t479 199.989
R424 VGND.t481 VGND.n241 199.989
R425 VGND.n212 VGND.t485 199.989
R426 VGND.t487 VGND.n243 199.989
R427 VGND.n210 VGND.t490 199.989
R428 VGND.t492 VGND.n245 199.989
R429 VGND.n14 VGND.t346 199.989
R430 VGND.t348 VGND.n12 199.989
R431 VGND.n15 VGND.t350 199.989
R432 VGND.t352 VGND.n11 199.989
R433 VGND.n16 VGND.t354 199.989
R434 VGND.t356 VGND.n10 199.989
R435 VGND.n17 VGND.t358 199.989
R436 VGND.t360 VGND.n9 199.989
R437 VGND.n18 VGND.t362 199.989
R438 VGND.t364 VGND.n8 199.989
R439 VGND.n19 VGND.t366 199.989
R440 VGND.t368 VGND.n7 199.989
R441 VGND.n20 VGND.t370 199.989
R442 VGND.t372 VGND.n6 199.989
R443 VGND.n37 VGND.t129 199.989
R444 VGND.t131 VGND.n35 199.989
R445 VGND.n40 VGND.t133 199.989
R446 VGND.t135 VGND.n32 199.989
R447 VGND.n43 VGND.t138 199.989
R448 VGND.t140 VGND.n29 199.989
R449 VGND.n46 VGND.t144 199.989
R450 VGND.t146 VGND.n26 199.989
R451 VGND.n49 VGND.t149 199.989
R452 VGND.n194 VGND.t58 197.143
R453 VGND.n313 VGND.t39 197.143
R454 VGND.t839 VGND.t793 108.999
R455 VGND.t577 VGND.t531 108.999
R456 VGND.t242 VGND.t198 108.999
R457 VGND.t838 VGND.t793 109.992
R458 VGND.t793 VGND.t832 109.001
R459 VGND.t829 VGND.t793 108.999
R460 VGND.t793 VGND.t827 109.001
R461 VGND.t824 VGND.t793 108.999
R462 VGND.t793 VGND.t822 109.001
R463 VGND.t793 VGND.t821 109.993
R464 VGND.t793 VGND.t818 109.001
R465 VGND.t816 VGND.t793 108.999
R466 VGND.t815 VGND.t793 109.992
R467 VGND.t811 VGND.t793 108.999
R468 VGND.t793 VGND.t809 109.001
R469 VGND.t807 VGND.t793 109.001
R470 VGND.t793 VGND.t805 109.001
R471 VGND.t803 VGND.t793 109.001
R472 VGND.t801 VGND.t793 109.992
R473 VGND.t793 VGND.t798 109.992
R474 VGND.t793 VGND.t795 109.001
R475 VGND.t792 VGND.t793 108.722
R476 VGND.t713 VGND.t746 109.001
R477 VGND.t744 VGND.t713 108.999
R478 VGND.t713 VGND.t742 109.001
R479 VGND.t740 VGND.t713 108.999
R480 VGND.t713 VGND.t738 109.001
R481 VGND.t713 VGND.t737 109.993
R482 VGND.t713 VGND.t734 109.001
R483 VGND.t732 VGND.t713 108.999
R484 VGND.t731 VGND.t713 109.992
R485 VGND.t728 VGND.t713 108.999
R486 VGND.t713 VGND.t726 109.001
R487 VGND.t713 VGND.t725 109.993
R488 VGND.t713 VGND.t722 109.001
R489 VGND.t720 VGND.t713 109.001
R490 VGND.t713 VGND.t718 109.001
R491 VGND.t716 VGND.t713 109.001
R492 VGND.t713 VGND.t714 109.001
R493 VGND.t711 VGND.t713 109.001
R494 VGND.t713 VGND.t709 109.001
R495 VGND.t622 VGND.t660 109.001
R496 VGND.t622 VGND.t656 109.001
R497 VGND.t654 VGND.t622 108.999
R498 VGND.t622 VGND.t652 109.001
R499 VGND.t622 VGND.t651 109.993
R500 VGND.t622 VGND.t648 109.001
R501 VGND.t646 VGND.t622 108.999
R502 VGND.t622 VGND.t644 109.001
R503 VGND.t622 VGND.t640 109.001
R504 VGND.t638 VGND.t622 108.999
R505 VGND.t637 VGND.t622 109.992
R506 VGND.t634 VGND.t622 109.001
R507 VGND.t633 VGND.t622 109.992
R508 VGND.t630 VGND.t622 109.001
R509 VGND.t622 VGND.t628 109.001
R510 VGND.t626 VGND.t622 109.001
R511 VGND.t622 VGND.t624 109.001
R512 VGND.t622 VGND.t621 108.722
R513 VGND.t531 VGND.t575 109.001
R514 VGND.t572 VGND.t531 108.999
R515 VGND.t531 VGND.t570 109.001
R516 VGND.t531 VGND.t568 109.993
R517 VGND.t531 VGND.t565 109.001
R518 VGND.t562 VGND.t531 108.999
R519 VGND.t531 VGND.t560 109.001
R520 VGND.t558 VGND.t531 108.999
R521 VGND.t531 VGND.t556 109.001
R522 VGND.t531 VGND.t555 109.993
R523 VGND.t531 VGND.t552 109.001
R524 VGND.t549 VGND.t531 108.999
R525 VGND.t548 VGND.t531 109.992
R526 VGND.t545 VGND.t531 109.001
R527 VGND.t531 VGND.t543 109.001
R528 VGND.t541 VGND.t531 109.001
R529 VGND.t531 VGND.t538 109.001
R530 VGND.t531 VGND.t536 109.992
R531 VGND.t531 VGND.t533 109.001
R532 VGND.t456 VGND.n223 192.042
R533 VGND.t500 VGND.n224 192.042
R534 VGND.n230 VGND.t453 192.042
R535 VGND.n229 VGND.t498 192.042
R536 VGND.t451 VGND.n225 192.042
R537 VGND.t496 VGND.n226 192.042
R538 VGND.n228 VGND.t448 192.042
R539 VGND.n54 VGND.n5 86.7577
R540 VGND.n53 VGND.t446 105.683
R541 VGND.n55 VGND.t410 22.2411
R542 VGND.n110 VGND.n5 3.31705
R543 VGND.t408 VGND.n56 22.2411
R544 VGND.n5 VGND.n57 3.31704
R545 VGND.n58 VGND.t405 22.2411
R546 VGND.n103 VGND.n5 3.31705
R547 VGND.n60 VGND.n5 86.7547
R548 VGND.n59 VGND.t438 105.683
R549 VGND.n5 VGND.n64 86.7547
R550 VGND.t436 VGND.n98 105.684
R551 VGND.t399 VGND.n65 22.2411
R552 VGND.n5 VGND.n66 3.31704
R553 VGND.n67 VGND.t396 22.2411
R554 VGND.n93 VGND.n5 3.31705
R555 VGND.t394 VGND.n69 22.2411
R556 VGND.n68 VGND.t430 105.683
R557 VGND.n5 VGND.n70 86.7547
R558 VGND.t428 VGND.n86 105.684
R559 VGND.n72 VGND.n5 86.7547
R560 VGND.n5 VGND.n71 3.31704
R561 VGND.n73 VGND.t387 22.2411
R562 VGND.n83 VGND.n5 7.34144
R563 VGND.t384 VGND.n76 12.9737
R564 VGND.t383 VGND.n5 109.992
R565 VGND.t379 VGND.n5 108.999
R566 VGND.t378 VGND.n5 109.992
R567 VGND.t287 VGND.t294 109.001
R568 VGND.t291 VGND.t287 109.001
R569 VGND.t287 VGND.t289 109.001
R570 VGND.t198 VGND.t240 109.001
R571 VGND.t198 VGND.t238 109.993
R572 VGND.t198 VGND.t235 109.001
R573 VGND.t232 VGND.t198 108.999
R574 VGND.t198 VGND.t230 109.001
R575 VGND.t198 VGND.t225 109.001
R576 VGND.t223 VGND.t198 108.999
R577 VGND.t222 VGND.t198 109.992
R578 VGND.t219 VGND.t198 108.999
R579 VGND.t218 VGND.t198 109.992
R580 VGND.t198 VGND.t212 109.001
R581 VGND.t210 VGND.t198 109.001
R582 VGND.t198 VGND.t208 109.001
R583 VGND.t206 VGND.t198 109.001
R584 VGND.t205 VGND.t198 109.992
R585 VGND.t201 VGND.t198 109.001
R586 VGND.t198 VGND.t199 109.001
R587 VGND.n109 VGND.t173 12.9737
R588 VGND.t104 VGND.t122 109.001
R589 VGND.t104 VGND.t120 109.993
R590 VGND.t104 VGND.t117 109.001
R591 VGND.t104 VGND.t113 109.001
R592 VGND.t110 VGND.t104 109.001
R593 VGND.t104 VGND.t108 109.001
R594 VGND.t104 VGND.t107 109.992
R595 VGND.n233 VGND.t504 191.417
R596 VGND.t506 VGND.n220 191.417
R597 VGND.n235 VGND.t508 191.417
R598 VGND.t510 VGND.n218 191.417
R599 VGND.n237 VGND.t512 191.417
R600 VGND.t514 VGND.n216 191.417
R601 VGND.n239 VGND.t516 191.417
R602 VGND.t518 VGND.n214 191.417
R603 VGND.n241 VGND.t520 191.417
R604 VGND.t522 VGND.n212 191.417
R605 VGND.n243 VGND.t524 191.417
R606 VGND.t526 VGND.n210 191.417
R607 VGND.n245 VGND.t528 191.417
R608 VGND.t302 VGND.n14 191.417
R609 VGND.n12 VGND.t304 191.417
R610 VGND.t307 VGND.n15 191.417
R611 VGND.n11 VGND.t310 191.417
R612 VGND.t313 VGND.n16 191.417
R613 VGND.n10 VGND.t316 191.417
R614 VGND.t318 VGND.n17 191.417
R615 VGND.n9 VGND.t320 191.417
R616 VGND.t323 VGND.n18 191.417
R617 VGND.n8 VGND.t326 191.417
R618 VGND.t328 VGND.n19 191.417
R619 VGND.n7 VGND.t331 191.417
R620 VGND.t333 VGND.n20 191.417
R621 VGND.n6 VGND.t335 191.417
R622 VGND.n36 VGND.t175 191.417
R623 VGND.t177 VGND.n39 191.417
R624 VGND.n33 VGND.t179 191.417
R625 VGND.t181 VGND.n42 191.417
R626 VGND.n30 VGND.t183 191.417
R627 VGND.t185 VGND.n45 191.417
R628 VGND.n27 VGND.t187 191.417
R629 VGND.t189 VGND.n48 191.417
R630 VGND.n24 VGND.t191 191.417
R631 VGND.t193 VGND.n51 191.417
R632 VGND.t95 VGND.n266 188.571
R633 VGND.t18 VGND.n264 188.571
R634 VGND.n192 VGND.t79 188.571
R635 VGND.n314 VGND.t40 188.571
R636 VGND.n286 VGND.t505 184.286
R637 VGND.t507 VGND.n258 184.286
R638 VGND.n288 VGND.t509 184.286
R639 VGND.t511 VGND.n256 184.286
R640 VGND.n290 VGND.t513 184.286
R641 VGND.t515 VGND.n254 184.286
R642 VGND.n292 VGND.t517 184.286
R643 VGND.t519 VGND.n252 184.286
R644 VGND.n294 VGND.t521 184.286
R645 VGND.t523 VGND.n250 184.286
R646 VGND.n296 VGND.t525 184.286
R647 VGND.t527 VGND.n248 184.286
R648 VGND.n298 VGND.t529 184.286
R649 VGND.t299 VGND.n306 184.286
R650 VGND.n96 VGND.t301 100.883
R651 VGND.n94 VGND.t346 234.188
R652 VGND.t348 VGND.n100 234.188
R653 VGND.t309 VGND.n91 100.883
R654 VGND.n101 VGND.t311 100.883
R655 VGND.t315 VGND.n87 100.883
R656 VGND.t356 VGND.n105 234.188
R657 VGND.n84 VGND.t358 234.188
R658 VGND.t360 VGND.n106 234.188
R659 VGND.t325 VGND.n79 100.883
R660 VGND.n111 VGND.t327 100.883
R661 VGND.n78 VGND.t366 234.188
R662 VGND.t368 VGND.n113 234.188
R663 VGND.t334 VGND.n75 100.883
R664 VGND.n118 VGND.t372 234.188
R665 VGND.n154 VGND.t176 184.286
R666 VGND.t178 VGND.n151 184.286
R667 VGND.n155 VGND.t180 184.286
R668 VGND.t182 VGND.n150 184.286
R669 VGND.n156 VGND.t184 184.286
R670 VGND.t186 VGND.n149 184.286
R671 VGND.n157 VGND.t188 184.286
R672 VGND.t190 VGND.n148 184.286
R673 VGND.n324 VGND.t192 184.286
R674 VGND.t194 VGND.n147 184.286
R675 VGND.t503 VGND.t27 175.714
R676 VGND.t459 VGND.n259 175.714
R677 VGND.n287 VGND.t461 175.714
R678 VGND.t464 VGND.n257 175.714
R679 VGND.n289 VGND.t467 175.714
R680 VGND.t470 VGND.n255 175.714
R681 VGND.n291 VGND.t473 175.714
R682 VGND.t476 VGND.n253 175.714
R683 VGND.n293 VGND.t478 175.714
R684 VGND.t480 VGND.n251 175.714
R685 VGND.n295 VGND.t483 175.714
R686 VGND.t486 VGND.n249 175.714
R687 VGND.n297 VGND.t489 175.714
R688 VGND.t491 VGND.n247 175.714
R689 VGND.t298 VGND.n307 175.714
R690 VGND.n97 VGND.t345 99.5774
R691 VGND.n99 VGND.t349 99.5774
R692 VGND.n102 VGND.t353 99.5774
R693 VGND.t355 VGND.n88 99.5774
R694 VGND.n104 VGND.t357 99.5774
R695 VGND.t363 VGND.n80 99.5774
R696 VGND.n112 VGND.t365 99.5774
R697 VGND.t367 VGND.n77 99.5774
R698 VGND.t371 VGND.n74 99.5774
R699 VGND.n154 VGND.t128 175.714
R700 VGND.t130 VGND.n151 175.714
R701 VGND.n155 VGND.t132 175.714
R702 VGND.t134 VGND.n150 175.714
R703 VGND.n156 VGND.t136 175.714
R704 VGND.t139 VGND.n149 175.714
R705 VGND.n157 VGND.t142 175.714
R706 VGND.t145 VGND.n148 175.714
R707 VGND.n324 VGND.t148 175.714
R708 VGND.t151 VGND.n147 175.714
R709 VGND.t57 VGND.n180 171.429
R710 VGND.t38 VGND.n307 171.429
R711 VGND.t29 VGND.t296 167.143
R712 VGND.t458 VGND.t88 162.857
R713 VGND.n281 VGND.t96 162.857
R714 VGND.n281 VGND.t17 162.857
R715 VGND.t80 VGND.n181 162.857
R716 VGND.t60 VGND.n178 162.857
R717 VGND.t42 VGND.n305 162.857
R718 VGND.t77 VGND.t51 154.286
R719 VGND.t52 VGND.t78 154.286
R720 VGND.t79 VGND.t53 154.286
R721 VGND.t54 VGND.t80 154.286
R722 VGND.t81 VGND.t55 154.286
R723 VGND.t56 VGND.t82 154.286
R724 VGND.t83 VGND.t57 154.286
R725 VGND.t58 VGND.t84 154.286
R726 VGND.t85 VGND.t59 154.286
R727 VGND.t6 VGND.t385 150
R728 VGND.n190 VGND.t76 145.714
R729 VGND.n193 VGND.t56 145.714
R730 VGND.n312 VGND.t37 145.714
R731 VGND.t32 VGND.t297 141.429
R732 VGND.t7 VGND.t494 137.143
R733 VGND.t16 VGND.n266 137.143
R734 VGND.t97 VGND.n264 137.143
R735 VGND.n193 VGND.t81 137.143
R736 VGND.n196 VGND.t61 137.143
R737 VGND.n315 VGND.t43 137.143
R738 VGND.t502 VGND.t25 132.857
R739 VGND.n278 VGND.t91 120.001
R740 VGND.n284 VGND.t22 120.001
R741 VGND.t75 VGND.n184 120.001
R742 VGND.t55 VGND.n181 120.001
R743 VGND.t36 VGND.n308 120.001
R744 VGND.t92 VGND.t9 111.43
R745 VGND.t11 VGND.t93 111.43
R746 VGND.t94 VGND.t13 111.43
R747 VGND.n280 VGND.t14 111.43
R748 VGND.t14 VGND.t95 111.43
R749 VGND.t96 VGND.t16 111.43
R750 VGND.t17 VGND.t97 111.43
R751 VGND.t98 VGND.t18 111.43
R752 VGND.n282 VGND.t98 111.43
R753 VGND.t19 VGND.t99 111.43
R754 VGND.t100 VGND.t20 111.43
R755 VGND.t21 VGND.t101 111.43
R756 VGND.t82 VGND.n180 111.43
R757 VGND.t44 VGND.n304 111.43
R758 VGND.t62 VGND.t0 107.144
R759 VGND.n273 VGND.t102 98.5719
R760 VGND.n153 VGND.t50 98.5719
R761 VGND.t90 VGND.n269 94.2862
R762 VGND.t23 VGND.n261 94.2862
R763 VGND.n189 VGND.t74 94.2862
R764 VGND.n192 VGND.t54 94.2862
R765 VGND.n311 VGND.t35 94.2862
R766 VGND.t37 VGND.t298 90.0005
R767 VGND.t45 VGND.t300 90.0005
R768 VGND.t13 VGND.n267 85.7148
R769 VGND.t99 VGND.n263 85.7148
R770 VGND.n194 VGND.t83 85.7148
R771 VGND.n197 VGND.t63 85.7148
R772 VGND.n316 VGND.t45 85.7148
R773 VGND.n187 VGND.t6 77.1434
R774 VGND.n277 VGND.t89 68.5719
R775 VGND.n285 VGND.t24 68.5719
R776 VGND.t53 VGND.n182 68.5719
R777 VGND.t33 VGND.n309 68.5719
R778 VGND.t73 VGND.t69 64.2862
R779 VGND.n279 VGND.t11 60.0005
R780 VGND.n283 VGND.t100 60.0005
R781 VGND.t84 VGND.n179 60.0005
R782 VGND.t65 VGND.n176 60.0005
R783 VGND.t46 VGND.n303 60.0005
R784 VGND.n227 VGND.t7 54.8988
R785 VGND.t450 VGND.t496 51.4291
R786 VGND.t498 VGND.t452 51.4291
R787 VGND.t455 VGND.t500 51.4291
R788 VGND.t48 VGND.n186 51.4291
R789 VGND.n73 VGND.t425 23.2336
R790 VGND.n72 VGND.t389 22.2411
R791 VGND.t391 VGND.n70 22.2411
R792 VGND.t431 VGND.n69 23.2336
R793 VGND.n67 VGND.t433 23.2336
R794 VGND.t435 VGND.n65 23.2336
R795 VGND.t401 VGND.n64 22.2411
R796 VGND.n60 VGND.t403 22.2411
R797 VGND.n58 VGND.t441 23.2336
R798 VGND.t443 VGND.n56 23.2336
R799 VGND.n55 VGND.t445 23.2336
R800 VGND.n54 VGND.t413 22.2419
R801 VGND.t88 VGND.n270 42.8576
R802 VGND.t25 VGND.n260 42.8576
R803 VGND.n188 VGND.t72 42.8576
R804 VGND.n191 VGND.t52 42.8576
R805 VGND.n310 VGND.t32 42.8576
R806 VGND.t40 VGND.t299 38.5719
R807 VGND.n108 VGND.t4 54.6304
R808 VGND.t9 VGND.n268 34.2862
R809 VGND.t101 VGND.n262 34.2862
R810 VGND.n195 VGND.t85 34.2862
R811 VGND.n83 VGND.t66 43.2965
R812 VGND.n96 VGND.t47 41.3307
R813 VGND.n222 VGND.t87 32.8462
R814 VGND.n231 VGND.t26 32.8462
R815 VGND.t71 VGND.n4 32.8462
R816 VGND.t31 VGND.n13 32.8462
R817 VGND.t423 VGND.n76 15.0018
R818 VGND.n109 VGND.t127 15.0018
R819 VGND.t86 VGND.n222 24.2748
R820 VGND.t27 VGND.n231 24.2748
R821 VGND.n4 VGND.t70 24.2748
R822 VGND.n13 VGND.t29 24.2748
R823 VGND.t68 VGND.n5 20.6121
R824 VGND.n3 VGND.t67 19.9891
R825 VGND.t51 VGND.n183 17.1434
R826 VGND.n246 VGND.n298 17.0005
R827 VGND.n246 VGND.n247 17.0005
R828 VGND.n246 VGND.n248 17.0005
R829 VGND.n246 VGND.n297 17.0005
R830 VGND.n246 VGND.n296 17.0005
R831 VGND.n246 VGND.n249 17.0005
R832 VGND.n246 VGND.n250 17.0005
R833 VGND.n246 VGND.n295 17.0005
R834 VGND.n246 VGND.n294 17.0005
R835 VGND.n246 VGND.n251 17.0005
R836 VGND.n246 VGND.n252 17.0005
R837 VGND.n246 VGND.n293 17.0005
R838 VGND.n246 VGND.n292 17.0005
R839 VGND.n246 VGND.n253 17.0005
R840 VGND.n246 VGND.n254 17.0005
R841 VGND.n246 VGND.n291 17.0005
R842 VGND.n246 VGND.n290 17.0005
R843 VGND.n246 VGND.n255 17.0005
R844 VGND.n246 VGND.n256 17.0005
R845 VGND.n246 VGND.n289 17.0005
R846 VGND.n246 VGND.n288 17.0005
R847 VGND.n246 VGND.n257 17.0005
R848 VGND.n246 VGND.n258 17.0005
R849 VGND.n246 VGND.n287 17.0005
R850 VGND.n246 VGND.n286 17.0005
R851 VGND.n246 VGND.n259 17.0005
R852 VGND.n246 VGND.n260 17.0005
R853 VGND.n246 VGND.n285 17.0005
R854 VGND.n246 VGND.n261 17.0005
R855 VGND.n246 VGND.n284 17.0005
R856 VGND.n246 VGND.n262 17.0005
R857 VGND.n246 VGND.n283 17.0005
R858 VGND.n246 VGND.n263 17.0005
R859 VGND.n246 VGND.n282 17.0005
R860 VGND.n246 VGND.n264 17.0005
R861 VGND.n246 VGND.n281 17.0005
R862 VGND.n246 VGND.n266 17.0005
R863 VGND.n246 VGND.n280 17.0005
R864 VGND.n246 VGND.n267 17.0005
R865 VGND.n246 VGND.n279 17.0005
R866 VGND.n246 VGND.n268 17.0005
R867 VGND.n246 VGND.n278 17.0005
R868 VGND.n246 VGND.n269 17.0005
R869 VGND.n246 VGND.n277 17.0005
R870 VGND.n246 VGND.n270 17.0005
R871 VGND.n246 VGND.n276 17.0005
R872 VGND.n246 VGND.n275 17.0005
R873 VGND.n246 VGND.n271 17.0005
R874 VGND.n246 VGND.n274 17.0005
R875 VGND.n246 VGND.n272 17.0005
R876 VGND.n246 VGND.n273 17.0005
R877 VGND.n246 VGND.n146 17.0005
R878 VGND.n5 VGND.n68 3.31704
R879 VGND.n5 VGND.n176 17.0005
R880 VGND.n5 VGND.n197 17.0005
R881 VGND.n5 VGND.n177 17.0005
R882 VGND.n5 VGND.n196 17.0005
R883 VGND.n5 VGND.n178 17.0005
R884 VGND.n5 VGND.n195 17.0005
R885 VGND.n5 VGND.n179 17.0005
R886 VGND.n5 VGND.n194 17.0005
R887 VGND.n5 VGND.n180 17.0005
R888 VGND.n5 VGND.n193 17.0005
R889 VGND.n5 VGND.n181 17.0005
R890 VGND.n5 VGND.n192 17.0005
R891 VGND.n5 VGND.n182 17.0005
R892 VGND.n5 VGND.n191 17.0005
R893 VGND.n5 VGND.n183 17.0005
R894 VGND.n5 VGND.n190 17.0005
R895 VGND.n5 VGND.n184 17.0005
R896 VGND.n5 VGND.n189 17.0005
R897 VGND.n5 VGND.n185 17.0005
R898 VGND.n5 VGND.n188 17.0005
R899 VGND.n5 VGND.n186 17.0005
R900 VGND.n5 VGND.n187 17.0005
R901 VGND.t287 VGND.n118 9.30743
R902 VGND.t287 VGND.n114 9.63482
R903 VGND.t287 VGND.n113 9.30721
R904 VGND.t287 VGND.n78 9.30721
R905 VGND.t287 VGND.n107 9.63482
R906 VGND.t287 VGND.n106 9.30721
R907 VGND.t287 VGND.n85 9.63482
R908 VGND.t287 VGND.n84 9.30721
R909 VGND.t287 VGND.n105 9.30721
R910 VGND.t287 VGND.n92 9.63482
R911 VGND.t287 VGND.n100 9.30721
R912 VGND.t287 VGND.n95 9.63482
R913 VGND.t287 VGND.n94 9.30721
R914 VGND.t287 VGND.n303 17.0005
R915 VGND.t287 VGND.n316 17.0005
R916 VGND.t287 VGND.n304 17.0005
R917 VGND.t287 VGND.n315 17.0005
R918 VGND.t287 VGND.n305 17.0005
R919 VGND.t287 VGND.n314 17.0005
R920 VGND.t287 VGND.n306 17.0005
R921 VGND.t287 VGND.n313 17.0005
R922 VGND.t287 VGND.n307 17.0005
R923 VGND.t287 VGND.n312 17.0005
R924 VGND.t287 VGND.n308 17.0005
R925 VGND.t287 VGND.n311 17.0005
R926 VGND.t287 VGND.n309 17.0005
R927 VGND.t287 VGND.n310 17.0005
R928 VGND.t104 VGND.n147 17.0005
R929 VGND.t104 VGND.n324 17.0005
R930 VGND.t104 VGND.n148 17.0005
R931 VGND.t104 VGND.n157 17.0005
R932 VGND.t104 VGND.n149 17.0005
R933 VGND.t104 VGND.n156 17.0005
R934 VGND.t104 VGND.n150 17.0005
R935 VGND.t104 VGND.n155 17.0005
R936 VGND.t104 VGND.n151 17.0005
R937 VGND.t104 VGND.n154 17.0005
R938 VGND.t104 VGND.n152 17.0005
R939 VGND.t104 VGND.n153 17.0005
R940 VGND.n333 VGND.n141 9.0005
R941 VGND.n205 VGND.n141 9.0005
R942 VGND.n163 VGND.n161 9.0005
R943 VGND.n167 VGND.n166 9.0005
R944 VGND.n322 VGND.n321 9.0005
R945 VGND.n323 VGND.n322 9.0005
R946 VGND.n202 VGND.n200 9.0005
R947 VGND.n204 VGND.n198 9.0005
R948 VGND.n190 VGND.t49 8.57193
R949 VGND.n119 VGND.t412 0.777974
R950 VGND.t984 VGND.n140 0.130189
R951 VGND.t982 VGND.n90 8.501
R952 VGND.n139 VGND.t979 0.130189
R953 VGND.n138 VGND.t974 0.130189
R954 VGND.t972 VGND.n90 8.501
R955 VGND.n137 VGND.t969 0.130189
R956 VGND.t967 VGND.n90 8.501
R957 VGND.n136 VGND.t964 0.130189
R958 VGND.t962 VGND.n90 8.501
R959 VGND.n135 VGND.t959 0.130189
R960 VGND.t957 VGND.n90 8.501
R961 VGND.n134 VGND.t954 0.130189
R962 VGND.t952 VGND.n90 8.501
R963 VGND.n133 VGND.t949 0.130189
R964 VGND.t947 VGND.n90 8.501
R965 VGND.n132 VGND.t944 0.130189
R966 VGND.t942 VGND.n90 8.501
R967 VGND.n131 VGND.t939 0.130189
R968 VGND.t937 VGND.n90 8.501
R969 VGND.n130 VGND.t934 0.130189
R970 VGND.t932 VGND.n90 8.501
R971 VGND.n129 VGND.t929 0.130189
R972 VGND.t927 VGND.n90 8.501
R973 VGND.n128 VGND.t924 0.130189
R974 VGND.t922 VGND.n90 8.501
R975 VGND.n127 VGND.t919 0.130189
R976 VGND.t917 VGND.n90 8.501
R977 VGND.n126 VGND.t914 0.130189
R978 VGND.t912 VGND.n90 8.501
R979 VGND.n125 VGND.t909 0.130189
R980 VGND.t907 VGND.n90 8.501
R981 VGND.n124 VGND.t904 0.130189
R982 VGND.t902 VGND.n90 8.501
R983 VGND.n123 VGND.t899 0.130189
R984 VGND.t897 VGND.n90 8.501
R985 VGND.n122 VGND.t894 0.130189
R986 VGND.t892 VGND.n90 8.501
R987 VGND.n121 VGND.t889 0.130189
R988 VGND.t887 VGND.n90 8.501
R989 VGND.n90 VGND.n120 3.33079
R990 VGND.n90 VGND.t977 8.5005
R991 VGND.n140 VGND.n90 3.33079
R992 VGND.n139 VGND.n90 3.33079
R993 VGND.n90 VGND.n137 3.33079
R994 VGND.n136 VGND.n90 3.33079
R995 VGND.n90 VGND.n135 3.33079
R996 VGND.n134 VGND.n90 3.33079
R997 VGND.n90 VGND.n133 3.33079
R998 VGND.n132 VGND.n90 3.33079
R999 VGND.n90 VGND.n131 3.33079
R1000 VGND.n130 VGND.n90 3.33079
R1001 VGND.n90 VGND.n129 3.33079
R1002 VGND.n128 VGND.n90 3.33079
R1003 VGND.n90 VGND.n127 3.33079
R1004 VGND.n126 VGND.n90 3.33079
R1005 VGND.n90 VGND.n125 3.33079
R1006 VGND.n124 VGND.n90 3.33079
R1007 VGND.n90 VGND.n123 3.33079
R1008 VGND.n122 VGND.n90 3.33079
R1009 VGND.n90 VGND.n121 3.33079
R1010 VGND.t885 VGND.n120 0.0863258
R1011 VGND.n330 VGND.n145 5.16578
R1012 VGND.n166 VGND.t112 4.61666
R1013 VGND.t143 VGND.n323 4.61666
R1014 VGND.t203 VGND.n318 4.5005
R1015 VGND.n317 VGND.t30 4.5005
R1016 VGND.n301 VGND.t381 4.5005
R1017 VGND.t10 VGND.n170 4.5005
R1018 VGND.t540 VGND.n207 4.5005
R1019 VGND.n206 VGND.t622 4.5005
R1020 VGND.n332 VGND.t713 4.5005
R1021 VGND.t802 VGND.n143 4.5005
R1022 VGND.t902 VGND.n328 4.5005
R1023 VGND.n319 VGND.t234 4.5005
R1024 VGND.t329 VGND.n162 4.5005
R1025 VGND.t407 VGND.n300 4.5005
R1026 VGND.n299 VGND.t488 4.5005
R1027 VGND.n208 VGND.t569 4.5005
R1028 VGND.t713 VGND.n331 4.5005
R1029 VGND.n330 VGND.t831 4.5005
R1030 VGND.n169 VGND.n168 4.49573
R1031 VGND.n201 VGND.n144 4.49573
R1032 VGND.n336 VGND.n335 4.49046
R1033 VGND.n334 VGND.n141 4.49046
R1034 VGND.n336 VGND.n142 4.49046
R1035 VGND.n167 VGND.n164 4.49046
R1036 VGND.n165 VGND.n161 4.49046
R1037 VGND.n320 VGND.n159 4.49046
R1038 VGND.n322 VGND.n160 4.49046
R1039 VGND.n159 VGND.n158 4.49046
R1040 VGND.n199 VGND.n198 4.49046
R1041 VGND.n203 VGND.n202 4.49046
R1042 VGND.t69 VGND.n185 4.28621
R1043 VGND.t0 VGND.n177 4.28621
R1044 VGND.t987 VGND.n90 3.46301
R1045 VGND.n246 VGND.n265 3.30688
R1046 VGND.n322 VGND.n161 2.17938
R1047 VGND.n198 VGND.n141 2.17938
R1048 VGND.t531 VGND.n62 0.554952
R1049 VGND.n63 VGND.t239 0.00980952
R1050 VGND.t793 VGND.n61 0.554952
R1051 VGND.t104 VGND.t5 1.01949
R1052 VGND.t34 VGND.t41 1.10279
R1053 VGND.n89 VGND.t121 0.241661
R1054 VGND.t531 VGND.t551 0.393869
R1055 VGND.t198 VGND.t216 0.393869
R1056 VGND.t64 VGND.t1 1.05128
R1057 VGND.t449 VGND.t454 1.04852
R1058 VGND.n174 VGND.t398 1.0417
R1059 VGND.n175 VGND.t393 1.03988
R1060 VGND.t3 VGND.t1 1.03865
R1061 VGND.t12 VGND.t15 1.0217
R1062 VGND.t28 VGND.t462 1.01902
R1063 VGND.t3 VGND.n171 1.01865
R1064 VGND.t314 VGND.t312 1.01575
R1065 VGND.t474 VGND.t472 1.01575
R1066 VGND.t312 VGND.t308 1.01531
R1067 VGND.t472 VGND.t468 1.01531
R1068 VGND.t314 VGND.t322 1.01469
R1069 VGND.t474 VGND.t482 1.01469
R1070 VGND.t306 VGND.t308 1.01465
R1071 VGND.t322 VGND.n21 0.241681
R1072 VGND.t466 VGND.t468 1.01465
R1073 VGND.t482 VGND.t484 1.01465
R1074 VGND.n174 VGND.t393 0.981234
R1075 VGND.n302 VGND.t287 0.979464
R1076 VGND.n81 VGND.t531 0.389609
R1077 VGND.t802 VGND.n82 0.139849
R1078 VGND.t141 VGND.t143 0.954956
R1079 VGND.t398 VGND.n173 0.943051
R1080 VGND.t407 VGND.n119 0.920723
R1081 VGND.n21 VGND.t324 0.370406
R1082 VGND.t64 VGND.n175 0.91777
R1083 VGND.n173 VGND.t407 0.913349
R1084 VGND.t8 VGND.t449 0.905709
R1085 VGND.n209 VGND.n246 0.898516
R1086 VGND.t569 VGND.n62 0.00832401
R1087 VGND.t793 VGND.t813 0.393869
R1088 VGND.n171 VGND.t381 0.870122
R1089 VGND.t793 VGND.n82 0.389609
R1090 VGND.t41 VGND.t306 0.834398
R1091 VGND.t462 VGND.t466 0.834398
R1092 VGND.t30 VGND.t34 0.801813
R1093 VGND.t381 VGND.n172 0.791318
R1094 VGND.t198 VGND.t203 0.364351
R1095 VGND.t10 VGND.t12 0.770172
R1096 VGND.t137 VGND.n23 0.381852
R1097 VGND.t147 VGND.t143 0.760497
R1098 VGND.t5 VGND.t126 0.741292
R1099 VGND.n5 VGND.n119 0.610079
R1100 VGND.n5 VGND.n173 0.727791
R1101 VGND.t196 VGND.t198 0.708889
R1102 VGND.t375 VGND.n172 0.708781
R1103 VGND.t15 VGND.t28 0.707084
R1104 VGND.t104 VGND.n89 0.331155
R1105 VGND.n246 VGND.t28 0.680312
R1106 VGND.t198 VGND.t229 0.343103
R1107 VGND.n328 VGND.n143 0.66578
R1108 VGND.n332 VGND.n143 0.66578
R1109 VGND.n207 VGND.n206 0.66578
R1110 VGND.n207 VGND.n170 0.66578
R1111 VGND.n301 VGND.n170 0.66578
R1112 VGND.n317 VGND.n301 0.66578
R1113 VGND.n318 VGND.n317 0.66578
R1114 VGND.n331 VGND.n330 0.66578
R1115 VGND.n208 VGND.n0 0.66578
R1116 VGND.n299 VGND.n208 0.66578
R1117 VGND.n300 VGND.n299 0.66578
R1118 VGND.n300 VGND.n162 0.66578
R1119 VGND.n319 VGND.n162 0.66578
R1120 VGND.n5 VGND.n175 0.663193
R1121 VGND.t104 VGND.t147 0.654504
R1122 VGND.t713 VGND.n52 427.5
R1123 VGND.t531 VGND.n22 427.5
R1124 VGND.n246 VGND.n245 0.649813
R1125 VGND.n246 VGND.n210 0.649813
R1126 VGND.n246 VGND.n243 0.649813
R1127 VGND.n246 VGND.n212 0.649813
R1128 VGND.n246 VGND.n241 0.649813
R1129 VGND.n246 VGND.n214 0.649813
R1130 VGND.n246 VGND.n239 0.649813
R1131 VGND.n246 VGND.n216 0.649813
R1132 VGND.n246 VGND.n237 0.649813
R1133 VGND.n246 VGND.n218 0.649813
R1134 VGND.n246 VGND.n235 0.649813
R1135 VGND.n246 VGND.n220 0.649813
R1136 VGND.n246 VGND.n233 0.649813
R1137 VGND.n246 VGND.n231 0.649813
R1138 VGND.n246 VGND.n222 0.649813
R1139 VGND.n5 VGND.n4 0.649813
R1140 VGND.n5 VGND.n3 0.649813
R1141 VGND.n5 VGND.n1 427.5
R1142 VGND.t287 VGND.n6 0.649813
R1143 VGND.t287 VGND.n20 0.649813
R1144 VGND.t287 VGND.n7 0.649813
R1145 VGND.t287 VGND.n19 0.649813
R1146 VGND.t287 VGND.n8 0.649813
R1147 VGND.t287 VGND.n18 0.649813
R1148 VGND.t287 VGND.n9 0.649813
R1149 VGND.t287 VGND.n17 0.649813
R1150 VGND.t287 VGND.n10 0.649813
R1151 VGND.t287 VGND.n16 0.649813
R1152 VGND.t287 VGND.n11 0.649813
R1153 VGND.t287 VGND.n15 0.649813
R1154 VGND.t287 VGND.n12 0.649813
R1155 VGND.t287 VGND.n14 0.649813
R1156 VGND.t287 VGND.n13 0.649813
R1157 VGND.n117 VGND.n326 427.5
R1158 VGND.n116 VGND.n325 427.5
R1159 VGND.t104 VGND.n51 0.649813
R1160 VGND.t104 VGND.n50 0.649813
R1161 VGND.t104 VGND.n49 0.649813
R1162 VGND.t104 VGND.n24 0.649813
R1163 VGND.t104 VGND.n25 0.649813
R1164 VGND.t104 VGND.n26 0.649813
R1165 VGND.t104 VGND.n48 0.649813
R1166 VGND.t104 VGND.n47 0.649813
R1167 VGND.t104 VGND.n46 0.649813
R1168 VGND.t104 VGND.n27 0.649813
R1169 VGND.t104 VGND.n28 0.649813
R1170 VGND.t104 VGND.n29 0.649813
R1171 VGND.t104 VGND.n45 0.649813
R1172 VGND.t104 VGND.n44 0.649813
R1173 VGND.t104 VGND.n43 0.649813
R1174 VGND.t104 VGND.n30 0.649813
R1175 VGND.t104 VGND.n31 0.649813
R1176 VGND.t104 VGND.n32 0.649813
R1177 VGND.t104 VGND.n42 0.649813
R1178 VGND.t104 VGND.n41 0.649813
R1179 VGND.t104 VGND.n40 0.649813
R1180 VGND.t104 VGND.n33 0.649813
R1181 VGND.t104 VGND.n34 0.649813
R1182 VGND.t104 VGND.n35 0.649813
R1183 VGND.t104 VGND.n39 0.649813
R1184 VGND.t104 VGND.n38 0.649813
R1185 VGND.t104 VGND.n37 0.649813
R1186 VGND.t104 VGND.n36 0.649813
R1187 VGND.n325 VGND.t104 6727.5
R1188 VGND.n246 VGND.t12 0.64464
R1189 VGND.n246 VGND.t482 0.604578
R1190 VGND.n246 VGND.t466 0.604578
R1191 VGND.t287 VGND.n21 0.221036
R1192 VGND.t287 VGND.t306 0.604578
R1193 VGND.t150 VGND.t147 0.593799
R1194 VGND VGND.n336 0.56194
R1195 VGND.n206 VGND.n205 0.52498
R1196 VGND.n0 VGND.n204 0.52498
R1197 VGND.n209 VGND.t484 0.521804
R1198 VGND.t126 VGND.n89 0.154985
R1199 VGND.t287 VGND.t329 0.502953
R1200 VGND.n5 VGND.n171 0.488547
R1201 VGND.n23 VGND.t141 0.146771
R1202 VGND.n246 VGND.t449 0.464129
R1203 VGND.n5 VGND.t1 0.462083
R1204 VGND.t287 VGND.t34 0.440434
R1205 VGND.n246 VGND.t472 0.423217
R1206 VGND.t287 VGND.t312 0.423217
R1207 VGND.t104 VGND.t112 0.423056
R1208 VGND.n318 VGND.n169 0.4229
R1209 VGND.n321 VGND.n319 0.4229
R1210 VGND.t831 VGND.n61 0.00832401
R1211 VGND.n63 VGND.t198 0.554952
R1212 VGND.n5 VGND.n174 0.387972
R1213 VGND.n5 VGND.n172 0.357895
R1214 VGND.t104 VGND.t152 0.356985
R1215 VGND.t30 VGND.n302 0.347617
R1216 VGND.t10 VGND.n265 0.308308
R1217 VGND.n81 VGND.t540 0.139849
R1218 VGND.t454 VGND.n265 0.295799
R1219 VGND.t985 VGND.t987 0.226736
R1220 VGND.t980 VGND.t982 0.226736
R1221 VGND.t885 VGND.t887 0.226736
R1222 VGND.t892 VGND.t890 0.226736
R1223 VGND.t895 VGND.t897 0.226736
R1224 VGND.t902 VGND.t900 0.226736
R1225 VGND.t905 VGND.t907 0.226736
R1226 VGND.t912 VGND.t910 0.226736
R1227 VGND.t915 VGND.t917 0.226736
R1228 VGND.t922 VGND.t920 0.226736
R1229 VGND.t925 VGND.t927 0.226736
R1230 VGND.t932 VGND.t930 0.226736
R1231 VGND.t935 VGND.t937 0.226736
R1232 VGND.t942 VGND.t940 0.226736
R1233 VGND.t945 VGND.t947 0.226736
R1234 VGND.t952 VGND.t950 0.226736
R1235 VGND.t955 VGND.t957 0.226736
R1236 VGND.t962 VGND.t960 0.226736
R1237 VGND.t965 VGND.t967 0.226736
R1238 VGND.t972 VGND.t970 0.226736
R1239 VGND.t884 VGND.n120 0.130189
R1240 VGND.n122 VGND.t895 0.0863258
R1241 VGND.n124 VGND.t905 0.0863258
R1242 VGND.n126 VGND.t915 0.0863258
R1243 VGND.n128 VGND.t925 0.0863258
R1244 VGND.n130 VGND.t935 0.0863258
R1245 VGND.n132 VGND.t945 0.0863258
R1246 VGND.n134 VGND.t955 0.0863258
R1247 VGND.n136 VGND.t965 0.0863258
R1248 VGND.n138 VGND.t975 0.0863258
R1249 VGND.n139 VGND.t980 0.0863258
R1250 VGND.n140 VGND.t985 0.0863258
R1251 VGND.t970 VGND.n137 0.0863258
R1252 VGND.t960 VGND.n135 0.0863258
R1253 VGND.t950 VGND.n133 0.0863258
R1254 VGND.t940 VGND.n131 0.0863258
R1255 VGND.t930 VGND.n129 0.0863258
R1256 VGND.t920 VGND.n127 0.0863258
R1257 VGND.t910 VGND.n125 0.0863258
R1258 VGND.t900 VGND.n123 0.0863258
R1259 VGND.t890 VGND.n121 0.0863258
R1260 VGND.t975 VGND.n145 0.210486
R1261 VGND.t488 VGND.n209 0.128569
R1262 VGND.t982 VGND.t984 0.0855
R1263 VGND.t979 VGND.t977 0.0855
R1264 VGND.t887 VGND.t889 0.0855
R1265 VGND.t894 VGND.t892 0.0855
R1266 VGND.t897 VGND.t899 0.0855
R1267 VGND.t904 VGND.t902 0.0855
R1268 VGND.t907 VGND.t909 0.0855
R1269 VGND.t914 VGND.t912 0.0855
R1270 VGND.t917 VGND.t919 0.0855
R1271 VGND.t924 VGND.t922 0.0855
R1272 VGND.t927 VGND.t929 0.0855
R1273 VGND.t934 VGND.t932 0.0855
R1274 VGND.t937 VGND.t939 0.0855
R1275 VGND.t944 VGND.t942 0.0855
R1276 VGND.t947 VGND.t949 0.0855
R1277 VGND.t954 VGND.t952 0.0855
R1278 VGND.t957 VGND.t959 0.0855
R1279 VGND.t964 VGND.t962 0.0855
R1280 VGND.t967 VGND.t969 0.0855
R1281 VGND.t974 VGND.t972 0.0855
R1282 VGND.n82 VGND.t799 0.171378
R1283 VGND.n81 VGND.t537 0.171378
R1284 VGND.n335 VGND.n334 0.0436411
R1285 VGND.n165 VGND.n164 0.0436411
R1286 VGND.n334 VGND.n142 0.0436411
R1287 VGND.n203 VGND.n199 0.0436411
R1288 VGND.n320 VGND.n160 0.0436411
R1289 VGND.n160 VGND.n158 0.0436411
R1290 VGND.n169 VGND.n163 0.04274
R1291 VGND.n200 VGND.n144 0.04274
R1292 VGND.t793 VGND.t819 109.992
R1293 VGND.t713 VGND.t721 109.992
R1294 VGND.t713 VGND.t719 109.992
R1295 VGND.t713 VGND.t715 109.992
R1296 VGND.t713 VGND.t712 109.992
R1297 VGND.t713 VGND.t710 109.992
R1298 VGND.t622 VGND.t657 109.992
R1299 VGND.t622 VGND.t653 109.992
R1300 VGND.t622 VGND.t635 109.992
R1301 VGND.t622 VGND.t631 109.992
R1302 VGND.t622 VGND.t629 109.992
R1303 VGND.t622 VGND.t625 109.992
R1304 VGND.t531 VGND.t561 109.992
R1305 VGND.t531 VGND.t544 109.992
R1306 VGND.t531 VGND.t539 109.992
R1307 VGND.n246 VGND.n244 0.0258175
R1308 VGND.n246 VGND.n211 0.0258175
R1309 VGND.n246 VGND.n242 0.0258175
R1310 VGND.n246 VGND.n213 0.0258175
R1311 VGND.n246 VGND.n240 0.0258175
R1312 VGND.n246 VGND.n215 0.0258175
R1313 VGND.n246 VGND.n238 0.0258175
R1314 VGND.n246 VGND.n217 0.0258175
R1315 VGND.n246 VGND.n236 0.0258175
R1316 VGND.n246 VGND.n219 0.0258175
R1317 VGND.n246 VGND.n234 0.0258175
R1318 VGND.n246 VGND.n221 0.0258175
R1319 VGND.n246 VGND.n232 0.0258175
R1320 VGND.n246 VGND.n223 0.0258175
R1321 VGND.n246 VGND.n224 0.0258175
R1322 VGND.n246 VGND.n230 0.0258175
R1323 VGND.n246 VGND.n229 0.0258175
R1324 VGND.n246 VGND.n225 0.0258175
R1325 VGND.n246 VGND.n226 0.0258175
R1326 VGND.n246 VGND.n228 0.0258175
R1327 VGND.n246 VGND.n227 0.0258175
R1328 VGND.t287 VGND.t295 109.992
R1329 VGND.t287 VGND.t292 109.992
R1330 VGND.t198 VGND.t241 109.992
R1331 VGND.t198 VGND.t200 109.992
R1332 VGND.t104 VGND.t114 109.992
R1333 VGND.n205 VGND.n142 0.0220706
R1334 VGND.n335 VGND.n333 0.0220706
R1335 VGND.n164 VGND.n163 0.0220706
R1336 VGND.n166 VGND.n165 0.0220706
R1337 VGND.n321 VGND.n320 0.0220706
R1338 VGND.n323 VGND.n158 0.0220706
R1339 VGND.n200 VGND.n199 0.0220706
R1340 VGND.n204 VGND.n203 0.0220706
R1341 VGND.n322 VGND.n159 0.02162
R1342 VGND.n336 VGND.n141 0.02162
R1343 VGND.n328 VGND 0.01986
R1344 VGND.t977 VGND.n145 0.01675
R1345 VGND.n61 VGND.t836 0.00980952
R1346 VGND.n62 VGND.t574 0.00980952
R1347 VGND.t234 VGND.n63 0.00832401
R1348 VGND.n302 VGND.t293 0.0159033
R1349 VGND.n333 VGND.n332 0.01458
R1350 VGND.n331 VGND.n144 0.01458
R1351 VGND.n246 VGND.t493 0.0136588
R1352 VGND.n168 VGND.n161 0.0115476
R1353 VGND.n168 VGND.n167 0.0115476
R1354 VGND.n202 VGND.n201 0.0115476
R1355 VGND.n201 VGND.n198 0.0115476
R1356 VGND.t981 VGND.n90 183.805
R1357 VGND.t956 VGND.n90 183.805
R1358 VGND.n90 VGND.t931 183.805
R1359 VGND.n90 VGND.t911 183.805
R1360 VGND.t622 VGND.n0 4.93817
R1361 VGND.n138 VGND.n90 3.63334
R1362 VGND.n5 VGND.n2 1.3009
R1363 VGND.t713 VGND.t707 1.28001
R1364 VGND.t793 VGND.t826 1.19263
R1365 VGND.t564 VGND.t531 1.19263
R1366 VGND.t287 VGND.n117 1.14998
R1367 VGND.t198 VGND.n116 1.14807
R1368 VGND.t104 VGND.n23 1.06234
C0 a_14920_6254# VPWR 0.13817f
C1 a_14920_5538# a_14920_4742# 0.01095f
C2 VPWR a_4352_9278# 0.08129f
C3 a_14920_13098# a_14920_13814# 0.01275f
C4 a_14920_13098# a_14920_12302# 0.01095f
C5 a_4840_10074# VPWR 0.13533f
C6 sg13cmos5l_and2_1_0.X sg13cmos5l_inv_1_0.A 0.09883f
C7 a_14920_4742# VPWR 0.13817f
C8 sg13cmos5l_inv_16_2.A a_4352_9278# 0.01466f
C9 sg13cmos5l_inv_16_2.A VPWR 1.57764f
C10 a_7904_14610# osc 0.01144f
C11 a_14920_2514# a_14920_3230# 0.01275f
C12 sg13cmos5l_inv_1_3.Y VPWR 1.56822f
C13 sg13cmos5l_inv_1_1.Y sg13cmos5l_and2_1_0.B 1.10138f
C14 a_4840_10074# sg13cmos5l_inv_1_3.Y 0.01159f
C15 a_15104_12302# VPWR 0.05878f
C16 a_14920_13098# a_15104_13098# 0.11523f
C17 sg13cmos5l_and2_1_0.X osc 0.01095f
C18 sg13cmos5l_inv_1_3.Y sg13cmos5l_inv_16_2.A 0.09565f
C19 a_14920_7766# VPWR 0.15318f
C20 sg13cmos5l_inv_16_4.A sg13cmos5l_inv_16_4.Y 1.07161f
C21 sg13cmos5l_buf_1_0.X enable 0.01113f
C22 a_14920_3230# VPWR 0.14232f
C23 sg13cmos5l_inv_1_3.A sg13cmos5l_inv_16_4.A 0.01775f
C24 a_4352_9278# sg13cmos5l_inv_1_0.A 0.03508f
C25 a_808_8468# VPWR 0.26433f
C26 a_3885_9540# sg13cmos5l_and2_1_0.X 0.12944f
C27 sg13cmos5l_and2_1_0.B sg13cmos5l_and2_1_0.X 0.07478f
C28 sg13cmos5l_inv_16_2.Y sg13cmos5l_inv_16_4.Y 0.04738f
C29 sg13cmos5l_inv_1_1.Y sg13cmos5l_inv_16_4.Y 0.0991f
C30 VPWR sg13cmos5l_inv_1_0.A 2.83048f
C31 sg13cmos5l_inv_1_3.A sg13cmos5l_inv_16_2.Y 0.04921f
C32 a_14920_4026# VPWR 0.13817f
C33 a_14920_12302# a_14920_11586# 0.01275f
C34 a_15104_11586# VPWR 0.05787f
C35 a_7904_14610# a_8108_14442# 0.03376f
C36 a_14920_7050# a_14920_6254# 0.01095f
C37 a_14920_4026# a_14920_4742# 0.01275f
C38 a_15104_14610# VPWR 0.07712f
C39 a_14920_7050# VPWR 0.13817f
C40 a_8108_14442# sg13cmos5l_and2_1_0.X 0.33093f
C41 sg13cmos5l_inv_16_2.A sg13cmos5l_inv_1_0.A 0.12139f
C42 a_14920_2514# a_15104_2514# 0.11523f
C43 a_14920_9278# a_15104_9278# 0.11523f
C44 sg13cmos5l_inv_16_4.Y sg13cmos5l_and2_1_0.X 0.21097f
C45 sg13cmos5l_inv_1_3.Y sg13cmos5l_inv_1_0.A 0.93024f
C46 VPWR osc 0.31435f
C47 sg13cmos5l_inv_1_3.A sg13cmos5l_and2_1_0.X 1.13454f
C48 a_3885_9540# a_4352_9278# 0.02877f
C49 VPWR sg13cmos5l_and2_1_0.B 2.98307f
C50 a_14920_13098# VPWR 0.14331f
C51 a_3885_9540# VPWR 0.5169f
C52 a_15104_2514# VPWR 0.06093f
C53 a_14920_4026# a_14920_3230# 0.01095f
C54 sg13cmos5l_buf_1_0.X VPWR 1.08796f
C55 a_14920_7050# a_14920_7766# 0.01275f
C56 VPWR a_8108_14442# 0.33905f
C57 VPWR a_14920_9278# 0.15163f
C58 VPWR sg13cmos5l_inv_16_4.Y 3.0991f
C59 a_3496_7766# sg13cmos5l_inv_16_4.A 0.03325f
C60 a_4840_10074# sg13cmos5l_inv_16_4.Y 0.03558f
C61 sg13cmos5l_inv_1_3.A VPWR 2.84107f
C62 a_15104_13814# a_14920_13814# 0.11523f
C63 a_15104_4742# VPWR 0.05657f
C64 sg13cmos5l_inv_16_2.Y sg13cmos5l_inv_16_4.A 1.40538f
C65 sg13cmos5l_inv_1_1.Y sg13cmos5l_inv_16_4.A 0.07408f
C66 sg13cmos5l_inv_1_1.Y a_3488_10790# 0.03446f
C67 a_15104_3230# VPWR 0.05775f
C68 sg13cmos5l_inv_16_2.A sg13cmos5l_inv_16_4.Y 0.32675f
C69 a_14920_1718# a_15104_1718# 0.11523f
C70 sg13cmos5l_inv_1_1.Y sg13cmos5l_inv_16_2.Y 0.0144f
C71 a_14920_4742# a_15104_4742# 0.11523f
C72 a_14920_6254# a_15104_6254# 0.11523f
C73 a_15104_1718# VPWR 0.05731f
C74 sg13cmos5l_inv_1_3.A sg13cmos5l_inv_1_3.Y 0.21711f
C75 a_15104_6254# VPWR 0.05657f
C76 a_14920_11586# VPWR 0.15532f
C77 a_808_8468# sg13cmos5l_buf_1_0.X 0.29561f
C78 a_14920_5538# a_15104_5538# 0.11523f
C79 a_15104_1002# a_14920_1002# 0.11523f
C80 sg13cmos5l_inv_16_4.A sg13cmos5l_and2_1_0.X 0.03266f
C81 sg13cmos5l_inv_16_2.Y sg13cmos5l_and2_1_0.X 0.0982f
C82 sg13cmos5l_inv_1_1.Y sg13cmos5l_and2_1_0.X 0.01142f
C83 a_15104_5538# VPWR 0.05657f
C84 sg13cmos5l_inv_16_4.Y sg13cmos5l_inv_1_0.A 0.03217f
C85 a_15104_1002# VPWR 0.05685f
C86 a_15104_3230# a_14920_3230# 0.11523f
C87 a_14920_13814# VPWR 0.14639f
C88 a_15104_7050# VPWR 0.05657f
C89 a_14920_12302# VPWR 0.14581f
C90 a_3885_9540# sg13cmos5l_and2_1_0.B 0.31594f
C91 a_8108_14442# osc 0.29036f
C92 sg13cmos5l_buf_1_0.X sg13cmos5l_and2_1_0.B 0.3308f
C93 sg13cmos5l_buf_1_0.X a_3885_9540# 0.16238f
C94 a_3496_7766# VPWR 0.17144f
C95 sg13cmos5l_inv_16_4.A VPWR 1.54609f
C96 a_3488_10790# VPWR 0.0931f
C97 a_14920_11586# a_15104_11586# 0.11523f
C98 a_15104_4026# VPWR 0.05657f
C99 a_4840_10074# sg13cmos5l_inv_16_4.A 0.01986f
C100 sg13cmos5l_inv_16_2.Y VPWR 2.94397f
C101 sg13cmos5l_inv_1_1.Y VPWR 1.76621f
C102 a_4840_10074# sg13cmos5l_inv_16_2.Y 0.03631f
C103 a_4840_10074# sg13cmos5l_inv_1_1.Y 0.03332f
C104 sg13cmos5l_and2_1_0.B sg13cmos5l_inv_16_4.Y 0.14059f
C105 a_15104_13098# VPWR 0.05803f
C106 a_14920_12302# a_15104_12302# 0.11523f
C107 a_3885_9540# sg13cmos5l_inv_16_4.Y 0.01117f
C108 sg13cmos5l_inv_16_2.A sg13cmos5l_inv_16_4.A 0.22812f
C109 sg13cmos5l_buf_1_0.X sg13cmos5l_inv_16_4.Y 0.10124f
C110 a_15104_13814# VPWR 0.05657f
C111 VPWR enable 0.16478f
C112 a_7904_14610# VPWR 0.11992f
C113 sg13cmos5l_inv_16_2.A sg13cmos5l_inv_16_2.Y 0.94006f
C114 sg13cmos5l_inv_1_3.Y sg13cmos5l_inv_16_4.A 0.01961f
C115 a_15104_7766# VPWR 0.05714f
C116 sg13cmos5l_and2_1_0.X a_4352_9278# 0.01853f
C117 sg13cmos5l_inv_1_3.Y sg13cmos5l_inv_16_2.Y 0.05844f
C118 sg13cmos5l_inv_1_3.Y sg13cmos5l_inv_1_1.Y 0.0116f
C119 VPWR sg13cmos5l_and2_1_0.X 3.1246f
C120 VPWR a_15104_9278# 0.0582f
C121 a_14920_2514# a_14920_1718# 0.01095f
C122 sg13cmos5l_inv_16_2.A sg13cmos5l_and2_1_0.X 0.13337f
C123 a_14920_7050# a_15104_7050# 0.11523f
C124 a_14920_2514# VPWR 0.15189f
C125 sg13cmos5l_inv_16_4.A sg13cmos5l_inv_1_0.A 0.09967f
C126 sg13cmos5l_inv_1_3.Y sg13cmos5l_and2_1_0.X 0.16677f
C127 a_14920_1718# a_14920_1002# 0.01275f
C128 a_14920_4026# a_15104_4026# 0.11523f
C129 a_14920_6254# a_14920_5538# 0.01275f
C130 sg13cmos5l_inv_16_2.Y sg13cmos5l_inv_1_0.A 0.08795f
C131 sg13cmos5l_inv_1_1.Y sg13cmos5l_inv_1_0.A 0.01416f
C132 a_14920_1002# VPWR 0.13916f
C133 a_15104_7766# a_14920_7766# 0.11523f
C134 a_14920_5538# VPWR 0.13817f
C135 a_14920_1718# VPWR 0.14076f
C136 a_808_8468# enable 0.33302f
C137 osc VGND 0.68254f
C138 a_15104_1002# VGND 0.07556f ; **FLOATING
C139 a_14920_1002# VGND 0.12355f ; **FLOATING
C140 a_15104_1718# VGND 0.07452f ; **FLOATING
C141 a_14920_1718# VGND 0.11992f ; **FLOATING
C142 a_15104_2514# VGND 0.07452f ; **FLOATING
C143 a_14920_2514# VGND 0.11992f ; **FLOATING
C144 a_15104_3230# VGND 0.07583f ; **FLOATING
C145 a_14920_3230# VGND 0.12448f ; **FLOATING
C146 a_15104_4026# VGND 0.07756f ; **FLOATING
C147 a_14920_4026# VGND 0.12999f ; **FLOATING
C148 a_15104_4742# VGND 0.07521f ; **FLOATING
C149 a_14920_4742# VGND 0.12232f ; **FLOATING
C150 a_15104_5538# VGND 0.07471f ; **FLOATING
C151 a_14920_5538# VGND 0.12056f ; **FLOATING
C152 a_15104_6254# VGND 0.07452f ; **FLOATING
C153 a_14920_6254# VGND 0.11992f ; **FLOATING
C154 a_15104_7050# VGND 0.07452f ; **FLOATING
C155 a_14920_7050# VGND 0.11992f ; **FLOATING
C156 a_15104_7766# VGND 0.075f ; **FLOATING
C157 a_14920_7766# VGND 0.11852f ; **FLOATING
C158 a_3496_7766# VGND 0.14676f ; **FLOATING
C159 a_808_8468# VGND 0.35836f
C160 a_15104_9278# VGND 0.07588f ; **FLOATING
C161 a_14920_9278# VGND 0.1355f ; **FLOATING
C162 a_4352_9278# VGND 0.04331f ; **FLOATING
C163 sg13cmos5l_inv_1_0.A VGND 1.1727f
C164 a_3979_9540# VGND 1.08754f
C165 sg13cmos5l_inv_1_3.A VGND 0.73196f
C166 a_4840_10074# VGND 0.08231f ; **FLOATING
C167 sg13cmos5l_inv_16_4.Y VGND 0.19534f
C168 a_3488_10790# VGND 0.09222f ; **FLOATING
C169 a_15104_11586# VGND 0.07537f ; **FLOATING
C170 a_14920_11586# VGND 0.11852f ; **FLOATING
C171 a_15104_12302# VGND 0.07452f ; **FLOATING
C172 a_14920_12302# VGND 0.11992f ; **FLOATING
C173 a_15104_13098# VGND 0.07553f ; **FLOATING
C174 a_14920_13098# VGND 0.12344f ; **FLOATING
C175 a_15104_13814# VGND 0.07928f ; **FLOATING
C176 a_14920_13814# VGND 0.13626f ; **FLOATING
C177 a_15104_14610# VGND 0.12405f ; **FLOATING
C178 a_7904_14610# VGND 0.06148f ; **FLOATING
C179 VGND.t836 VGND 0.35111f
C180 VGND.t121 VGND 1.1727f
C181 VGND.t229 VGND 0.30666p
C182 VGND.t216 VGND 1.6245f
C183 VGND.t64 VGND 5.45717f
C184 VGND.t1 VGND 2.3454f
C185 VGND.t3 VGND 0.21667f
C186 VGND.t28 VGND 0.17556f
C187 VGND.t15 VGND 0.17556f
C188 VGND.t10 VGND 0.37924f
C189 VGND.t454 VGND 0.37924f
C190 VGND.t30 VGND 5.92374f
C191 VGND.t905 VGND 0.68927f
C192 VGND.t904 VGND 0.68927f
C193 VGND.t940 VGND 0.35321f
C194 VGND.t985 VGND 0.30566p
.ends
