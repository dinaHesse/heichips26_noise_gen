* PEX produced on Thu Oct  1 10:20:54 PM CEST 2026 using scripts/sak-pex.sh with m=3 and s=1 (extresist threshold=10000 mOhm, minres=1000 mOhm, mindelay=1 ps)
* NGSPICE file created from g_glitch_pex.ext - technology: ihp-sg13cmos5l

.subckt g_glitch_pex VPWR VGND osc en[0] en[1] en[2] en[3] en[4] en[5] en[6]
+ en[7]
X0 VPWR.t559 sg13cmos5l_inv_1_1.A sg13cmos5l_inv_2_2.A VPWR.t18 sg13_lv_pmos ad=0.3808p pd=2.92u as=0.3808p ps=2.92u w=1.12u l=0.13u
X1 a_27599_2002# a_27564_1898# sg13cmos5l_xnor2_1_1.B VGND.t809 sg13_lv_nmos ad=0.1406p pd=1.12u as=0.2516p ps=2.16u w=0.74u l=0.13u
X2 sg13cmos5l_inv_16_29.Y sg13cmos5l_inv_16_29.A VGND.t384 VGND.t486 sg13_lv_nmos ad=0.1406p pd=1.12u as=0.1406p ps=1.12u w=0.74u l=0.13u
X3 VGND.t269 VPWR.t538 VGND.t269 VGND.t354 sg13_lv_nmos ad=79.8f pd=0.8u as=0 ps=0 w=0.42u l=1u
X4 VGND.t1 sg13cmos5l_inv_16_6.A sg13cmos5l_inv_16_8.A VGND.t2 sg13_lv_nmos ad=0.1406p pd=1.12u as=0.1406p ps=1.12u w=0.74u l=0.13u
X5 VGND.t66 VPWR.t58 VGND.t66 VGND.t328 sg13_lv_nmos ad=79.8f pd=0.8u as=0 ps=0 w=0.42u l=1u
X6 VPWR.t366 sg13cmos5l_inv_16_10.A sg13cmos5l_inv_16_10.Y VPWR.t0 sg13_lv_pmos ad=0.2128p pd=1.5u as=0.2128p ps=1.5u w=1.12u l=0.13u
X7 VGND.t390 sg13cmos5l_inv_16_21.A sg13cmos5l_inv_16_21.Y VGND.t700 sg13_lv_nmos ad=0.1406p pd=1.12u as=0.1406p ps=1.12u w=0.74u l=0.13u
X8 VPWR.t104 sg13cmos5l_inv_4_0.Y sg13cmos5l_inv_16_0.A VPWR.t18 sg13_lv_pmos ad=0.2128p pd=1.5u as=0.2128p ps=1.5u w=1.12u l=0.13u
X9 VGND.t32 sg13cmos5l_inv_16_23.Y sg13cmos5l_inv_16_25.Y VGND.t507 sg13_lv_nmos ad=0.1406p pd=1.12u as=0.1406p ps=1.12u w=0.74u l=0.13u
X10 sg13cmos5l_inv_8_1.A sg13cmos5l_inv_2_3.Y VGND.t66 VGND.t159 sg13_lv_nmos ad=0.1406p pd=1.12u as=0.1406p ps=1.12u w=0.74u l=0.13u
X11 sg13cmos5l_inv_16_1.A sg13cmos5l_inv_16_14.A VPWR.t226 VPWR.t20 sg13_lv_pmos ad=0.2128p pd=1.5u as=0.3808p ps=2.92u w=1.12u l=0.13u
X12 VGND.t133 sg13cmos5l_inv_16_29.Y sg13cmos5l_inv_16_4.Y VGND.t148 sg13_lv_nmos ad=0.2516p pd=2.16u as=0.1406p ps=1.12u w=0.74u l=0.13u
X13 a_24910_3411# a_25025_3410# VPWR.t481 VPWR.t20 sg13_lv_pmos ad=0.34p pd=2.68u as=0.2254p ps=1.53u w=1u l=0.5u
X14 sg13cmos5l_inv_16_27.A sg13cmos5l_inv_16_24.A VGND.t786 VGND.t788 sg13_lv_nmos ad=0.1406p pd=1.12u as=0.1406p ps=1.12u w=0.74u l=0.13u
X15 sg13cmos5l_xnor2_1_1.Y sg13cmos5l_xnor2_1_1.B a_27123_1632# VPWR.t0 sg13_lv_pmos ad=0.2408p pd=1.55u as=0.1428p ps=1.375u w=1.12u l=0.13u
X16 sg13cmos5l_inv_16_0.A sg13cmos5l_inv_4_0.Y VPWR.t104 VPWR.t18 sg13_lv_pmos ad=0.2128p pd=1.5u as=0.3808p ps=2.92u w=1.12u l=0.13u
X17 sg13cmos5l_inv_16_25.Y sg13cmos5l_inv_16_23.Y VGND.t32 VGND.t504 sg13_lv_nmos ad=0.1406p pd=1.12u as=0.1406p ps=1.12u w=0.74u l=0.13u
X18 sg13cmos5l_inv_16_4.Y sg13cmos5l_inv_16_29.Y VGND.t133 VGND.t145 sg13_lv_nmos ad=0.1406p pd=1.12u as=0.1406p ps=1.12u w=0.74u l=0.13u
X19 VPWR.t126 sg13cmos5l_inv_16_29.Y sg13cmos5l_inv_16_4.Y VPWR.t20 sg13_lv_pmos ad=0.2128p pd=1.5u as=0.2128p ps=1.5u w=1.12u l=0.13u
X20 VPWR.t46 sg13cmos5l_inv_16_20.A sg13cmos5l_inv_16_30.A VPWR.t0 sg13_lv_pmos ad=0.2128p pd=1.5u as=0.2128p ps=1.5u w=1.12u l=0.13u
X21 VGND.t404 sg13cmos5l_dlygate4sd3_1_4.X a_28020_1980# VGND.t462 sg13_lv_nmos ad=0.2272p pd=1.99u as=78.39999f ps=0.885u w=0.64u l=0.13u
X22 VPWR.t17 VGND.t446 VPWR.t17 VPWR.t0 sg13_lv_pmos ad=0.19p pd=1.38u as=0 ps=0 w=1u l=1u
X23 VGND.t390 sg13cmos5l_inv_16_21.A sg13cmos5l_inv_16_21.Y VGND.t696 sg13_lv_nmos ad=0.1406p pd=1.12u as=0.1406p ps=1.12u w=0.74u l=0.13u
X24 a_27029_2386# sg13cmos5l_xnor2_1_1.Y VGND.t267 VGND.t266 sg13_lv_nmos ad=0.1406p pd=1.12u as=0.1898p ps=1.36u w=0.74u l=0.13u
X25 VGND.t397 sg13cmos5l_inv_16_23.A sg13cmos5l_inv_16_23.Y VGND.t654 sg13_lv_nmos ad=0.1406p pd=1.12u as=0.1406p ps=1.12u w=0.74u l=0.13u
X26 VGND.t393 VPWR.t346 VGND.t392 VGND.t391 sg13_lv_nmos ad=0.1428p pd=1.52u as=0 ps=0 w=0.42u l=1u
X27 VPWR.t118 VGND.t381 VPWR.t117 VPWR.t20 sg13_lv_pmos ad=0.19p pd=1.38u as=0 ps=0 w=1u l=1u
X28 sg13cmos5l_inv_16_4.Y sg13cmos5l_inv_16_29.Y VPWR.t122 VPWR.t20 sg13_lv_pmos ad=0.2128p pd=1.5u as=0.2128p ps=1.5u w=1.12u l=0.13u
X29 VGND.t172 sg13cmos5l_inv_16_13.A sg13cmos5l_inv_16_9.A VGND.t180 sg13_lv_nmos ad=0.1406p pd=1.12u as=0.1406p ps=1.12u w=0.74u l=0.13u
X30 VPWR.t96 sg13cmos5l_inv_16_0.A sg13cmos5l_inv_16_2.A VPWR.t0 sg13_lv_pmos ad=0.2128p pd=1.5u as=0.2128p ps=1.5u w=1.12u l=0.13u
X31 sg13cmos5l_inv_16_11.Y sg13cmos5l_inv_16_9.Y VGND.t172 VGND.t173 sg13_lv_nmos ad=0.1406p pd=1.12u as=0.1406p ps=1.12u w=0.74u l=0.13u
X32 VGND.t121 sg13cmos5l_inv_2_7.Y sg13cmos5l_inv_4_6.Y VGND.t125 sg13_lv_nmos ad=0.1406p pd=1.12u as=0.1406p ps=1.12u w=0.74u l=0.13u
X33 VPWR.t396 sg13cmos5l_inv_16_22.A sg13cmos5l_inv_16_21.A VPWR.t0 sg13_lv_pmos ad=0.4368p pd=3.02u as=0.2128p ps=1.5u w=1.12u l=0.13u
X34 VGND.t361 sg13cmos5l_inv_16_7.A sg13cmos5l_inv_16_10.A VGND.t517 sg13_lv_nmos ad=0.1406p pd=1.12u as=0.1406p ps=1.12u w=0.74u l=0.13u
X35 VPWR.t58 VGND.t66 VPWR.t58 VPWR.t18 sg13_lv_pmos ad=0.19p pd=1.38u as=0 ps=0 w=1u l=1u
X36 sg13cmos5l_inv_16_7.A sg13cmos5l_inv_16_8.A VGND.t568 VGND.t582 sg13_lv_nmos ad=0.1406p pd=1.12u as=0.1406p ps=1.12u w=0.74u l=0.13u
X37 sg13cmos5l_inv_16_9.Y sg13cmos5l_inv_16_9.A VPWR.t164 VPWR.t20 sg13_lv_pmos ad=0.2128p pd=1.5u as=0.2128p ps=1.5u w=1.12u l=0.13u
X38 sg13cmos5l_inv_16_16.A sg13cmos5l_inv_16_2.A VGND.t231 VGND.t289 sg13_lv_nmos ad=0.1406p pd=1.12u as=0.1406p ps=1.12u w=0.74u l=0.13u
X39 VPWR.t17 VGND.t449 VPWR.t17 VPWR.t0 sg13_lv_pmos ad=0.34p pd=2.68u as=0 ps=0 w=1u l=1u
X40 VGND.t121 sg13cmos5l_inv_1_7.A sg13cmos5l_inv_4_8.A VGND.t463 sg13_lv_nmos ad=0.2516p pd=2.16u as=0.2516p ps=2.16u w=0.74u l=0.13u
X41 sg13cmos5l_inv_16_9.A sg13cmos5l_inv_16_13.A VGND.t172 VGND.t177 sg13_lv_nmos ad=0.1406p pd=1.12u as=0.1406p ps=1.12u w=0.74u l=0.13u
X42 sg13cmos5l_inv_16_2.A sg13cmos5l_inv_16_0.A VPWR.t96 VPWR.t0 sg13_lv_pmos ad=0.2128p pd=1.5u as=0.3808p ps=2.92u w=1.12u l=0.13u
X43 VPWR.t307 sg13cmos5l_dlygate4sd3_1_0.A a_25248_2697# VPWR.t20 sg13_lv_pmos ad=0.2891p pd=1.695u as=0.1596p ps=1.22u w=0.84u l=0.13u
X44 a_5257_3940# sg13cmos5l_and2_1_7.A VGND.t535 VGND.t623 sg13_lv_nmos ad=0.1216p pd=1.02u as=0.1331p ps=1.12u w=0.64u l=0.13u
X45 VGND.t82 VPWR.t303 VGND.t82 VGND.t388 sg13_lv_nmos ad=0.1428p pd=1.52u as=0 ps=0 w=0.42u l=1u
X46 VPWR.t46 sg13cmos5l_inv_16_30.A sg13cmos5l_inv_16_5.A VPWR.t0 sg13_lv_pmos ad=0.2128p pd=1.5u as=0.2128p ps=1.5u w=1.12u l=0.13u
X47 VPWR.t366 sg13cmos5l_inv_16_7.A sg13cmos5l_inv_16_10.A VPWR.t0 sg13_lv_pmos ad=0.2128p pd=1.5u as=0.2128p ps=1.5u w=1.12u l=0.13u
X48 VPWR.t234 sg13cmos5l_inv_16_1.A sg13cmos5l_inv_16_1.Y VPWR.t20 sg13_lv_pmos ad=0.2128p pd=1.5u as=0.2128p ps=1.5u w=1.12u l=0.13u
X49 VGND.t41 sg13cmos5l_inv_16_16.A sg13cmos5l_inv_16_18.A VGND.t106 sg13_lv_nmos ad=0.1406p pd=1.12u as=0.1406p ps=1.12u w=0.74u l=0.13u
X50 VPWR.t162 sg13cmos5l_inv_16_9.A sg13cmos5l_inv_16_9.Y VPWR.t20 sg13_lv_pmos ad=0.2128p pd=1.5u as=0.2128p ps=1.5u w=1.12u l=0.13u
X51 sg13cmos5l_inv_16_29.Y sg13cmos5l_inv_16_29.A VPWR.t42 VPWR.t0 sg13_lv_pmos ad=0.2128p pd=1.5u as=0.2128p ps=1.5u w=1.12u l=0.13u
X52 sg13cmos5l_inv_16_9.Y sg13cmos5l_inv_16_9.A VGND.t361 VGND.t530 sg13_lv_nmos ad=0.1406p pd=1.12u as=0.1406p ps=1.12u w=0.74u l=0.13u
X53 a_24236_3108# en[6] VPWR.t105 VPWR.t20 sg13_lv_pmos ad=0.2856p pd=2.36u as=0.2114p ps=1.54u w=0.84u l=0.13u
X54 VGND.t361 VPWR.t36 VGND.t363 VGND.t362 sg13_lv_nmos ad=79.8f pd=0.8u as=0 ps=0 w=0.42u l=1u
X55 VGND.t269 VPWR.t569 VGND.t269 VGND.t356 sg13_lv_nmos ad=79.8f pd=0.8u as=0 ps=0 w=0.42u l=1u
X56 VPWR.t115 sg13cmos5l_xnor2_1_3.B a_25112_1673# VPWR.t0 sg13_lv_pmos ad=0.1523p pd=1.38u as=0.1428p ps=1.52u w=0.42u l=0.13u
X57 sg13cmos5l_inv_16_5.A sg13cmos5l_inv_16_30.A VPWR.t46 VPWR.t0 sg13_lv_pmos ad=0.2128p pd=1.5u as=0.2128p ps=1.5u w=1.12u l=0.13u
X58 VGND.t133 sg13cmos5l_inv_16_5.Y sg13cmos5l_inv_16_3.Y VGND.t148 sg13_lv_nmos ad=0.2516p pd=2.16u as=0.1406p ps=1.12u w=0.74u l=0.13u
X59 sg13cmos5l_inv_16_10.A sg13cmos5l_inv_16_7.A VPWR.t366 VPWR.t0 sg13_lv_pmos ad=0.2128p pd=1.5u as=0.2128p ps=1.5u w=1.12u l=0.13u
X60 sg13cmos5l_inv_16_1.Y sg13cmos5l_inv_16_1.A VPWR.t230 VPWR.t20 sg13_lv_pmos ad=0.2128p pd=1.5u as=0.2128p ps=1.5u w=1.12u l=0.13u
X61 VGND.t361 sg13cmos5l_inv_16_9.A sg13cmos5l_inv_16_9.Y VGND.t527 sg13_lv_nmos ad=0.1406p pd=1.12u as=0.1406p ps=1.12u w=0.74u l=0.13u
X62 VGND.t131 sg13cmos5l_inv_1_2.A sg13cmos5l_inv_2_3.A VGND.t130 sg13_lv_nmos ad=0.2516p pd=2.16u as=0.2516p ps=2.16u w=0.74u l=0.13u
X63 VGND.t82 sg13cmos5l_inv_16_20.A sg13cmos5l_inv_16_30.A VGND.t92 sg13_lv_nmos ad=0.1406p pd=1.12u as=0.1406p ps=1.12u w=0.74u l=0.13u
X64 VPWR.t46 sg13cmos5l_inv_16_30.A sg13cmos5l_inv_16_5.A VPWR.t0 sg13_lv_pmos ad=0.2128p pd=1.5u as=0.2128p ps=1.5u w=1.12u l=0.13u
X65 sg13cmos5l_inv_16_3.Y sg13cmos5l_inv_16_5.Y VGND.t133 VGND.t145 sg13_lv_nmos ad=0.1406p pd=1.12u as=0.1406p ps=1.12u w=0.74u l=0.13u
X66 VGND.t231 sg13cmos5l_inv_16_18.A sg13cmos5l_inv_16_18.Y VGND.t230 sg13_lv_nmos ad=0.1406p pd=1.12u as=0.1406p ps=1.12u w=0.74u l=0.13u
X67 sg13cmos5l_inv_16_26.A sg13cmos5l_inv_8_6.A VGND.t73 VGND.t74 sg13_lv_nmos ad=0.1406p pd=1.12u as=0.1406p ps=1.12u w=0.74u l=0.13u
X68 VGND.t131 VPWR.t489 VGND.t131 VGND.t344 sg13_lv_nmos ad=0.1428p pd=1.52u as=0 ps=0 w=0.42u l=1u
X69 VGND.t404 VPWR.t24 VGND.t404 VGND.t423 sg13_lv_nmos ad=0.1428p pd=1.52u as=0 ps=0 w=0.42u l=1u
X70 a_27029_2002# sg13cmos5l_xnor2_1_1.B VGND.t267 VGND.t266 sg13_lv_nmos ad=0.1406p pd=1.12u as=0.1898p ps=1.36u w=0.74u l=0.13u
X71 sg13cmos5l_inv_16_30.A sg13cmos5l_inv_16_20.A VGND.t82 VGND.t89 sg13_lv_nmos ad=0.1406p pd=1.12u as=0.1406p ps=1.12u w=0.74u l=0.13u
X72 VGND.t150 sg13cmos5l_inv_16_8.A sg13cmos5l_inv_16_7.A VGND.t583 sg13_lv_nmos ad=0.2516p pd=2.16u as=0.1406p ps=1.12u w=0.74u l=0.13u
X73 VGND.t69 sg13cmos5l_inv_8_6.A sg13cmos5l_inv_16_26.A VGND.t70 sg13_lv_nmos ad=0.1406p pd=1.12u as=0.1406p ps=1.12u w=0.74u l=0.13u
X74 VGND.t20 sg13cmos5l_inv_4_1.Y sg13cmos5l_inv_16_12.A VGND.t540 sg13_lv_nmos ad=0.1406p pd=1.12u as=0.1406p ps=1.12u w=0.74u l=0.13u
X75 VPWR.t346 VGND.t392 VPWR.t345 VPWR.t20 sg13_lv_pmos ad=0.34p pd=2.68u as=0 ps=0 w=1u l=1u
X76 sg13cmos5l_inv_16_9.A sg13cmos5l_inv_16_13.A VGND.t172 VGND.t173 sg13_lv_nmos ad=0.1406p pd=1.12u as=0.1406p ps=1.12u w=0.74u l=0.13u
X77 sg13cmos5l_inv_16_7.A sg13cmos5l_inv_16_8.A VGND.t568 VGND.t578 sg13_lv_nmos ad=0.1406p pd=1.12u as=0.1406p ps=1.12u w=0.74u l=0.13u
X78 VGND.t384 sg13cmos5l_inv_16_31.A sg13cmos5l_inv_16_29.A VGND.t633 sg13_lv_nmos ad=0.1406p pd=1.12u as=0.1406p ps=1.12u w=0.74u l=0.13u
X79 a_14240_4097# sg13cmos5l_and2_1_2.B VPWR.t58 VPWR.t18 sg13_lv_pmos ad=0.1596p pd=1.22u as=0.1918p ps=1.5u w=0.84u l=0.13u
X80 a_24236_3108# en[6] VGND.t119 VGND.t862 sg13_lv_nmos ad=0.187p pd=1.78u as=0.14875p ps=1.16u w=0.55u l=0.13u
X81 VGND.t780 sg13cmos5l_inv_16_15.A sg13cmos5l_inv_16_14.A VGND.t929 sg13_lv_nmos ad=0.2516p pd=2.16u as=0.1406p ps=1.12u w=0.74u l=0.13u
X82 VGND.t121 sg13cmos5l_inv_4_8.A sg13cmos5l_xnor2_1_6.A VGND.t650 sg13_lv_nmos ad=0.1406p pd=1.12u as=0.1406p ps=1.12u w=0.74u l=0.13u
X83 sg13cmos5l_inv_16_29.Y sg13cmos5l_inv_16_29.A VPWR.t41 VPWR.t0 sg13_lv_pmos ad=0.2128p pd=1.5u as=0.2128p ps=1.5u w=1.12u l=0.13u
X84 sg13cmos5l_inv_16_12.A sg13cmos5l_inv_4_1.Y VGND.t535 VGND.t537 sg13_lv_nmos ad=0.1406p pd=1.12u as=0.1406p ps=1.12u w=0.74u l=0.13u
X85 VPWR.t586 sg13cmos5l_inv_16_21.A sg13cmos5l_inv_16_21.Y VPWR.t0 sg13_lv_pmos ad=0.2128p pd=1.5u as=0.2128p ps=1.5u w=1.12u l=0.13u
X86 VGND.t69 sg13cmos5l_inv_16_26.A sg13cmos5l_inv_16_31.A VGND.t767 sg13_lv_nmos ad=0.1406p pd=1.12u as=0.1406p ps=1.12u w=0.74u l=0.13u
X87 sg13cmos5l_inv_16_14.A sg13cmos5l_inv_16_15.A VGND.t325 VGND.t926 sg13_lv_nmos ad=0.1406p pd=1.12u as=0.1406p ps=1.12u w=0.74u l=0.13u
X88 sg13cmos5l_inv_16_10.A sg13cmos5l_inv_16_7.A VGND.t361 VGND.t530 sg13_lv_nmos ad=0.1406p pd=1.12u as=0.1406p ps=1.12u w=0.74u l=0.13u
X89 VGND.t32 sg13cmos5l_inv_16_23.Y sg13cmos5l_inv_16_25.Y VGND.t501 sg13_lv_nmos ad=0.1406p pd=1.12u as=0.1406p ps=1.12u w=0.74u l=0.13u
X90 sg13cmos5l_inv_16_18.A sg13cmos5l_inv_16_16.A VGND.t41 VGND.t99 sg13_lv_nmos ad=0.1406p pd=1.12u as=0.2516p ps=2.16u w=0.74u l=0.13u
X91 VPWR.t303 VGND.t82 VPWR.t727 VPWR.t20 sg13_lv_pmos ad=0.34p pd=2.68u as=0 ps=0 w=1u l=1u
X92 VPWR.t41 sg13cmos5l_inv_16_29.A sg13cmos5l_inv_16_29.Y VPWR.t0 sg13_lv_pmos ad=0.2128p pd=1.5u as=0.2128p ps=1.5u w=1.12u l=0.13u
X93 sg13cmos5l_inv_8_7.A sg13cmos5l_inv_4_7.A VPWR.t569 VPWR.t20 sg13_lv_pmos ad=0.2128p pd=1.5u as=0.2128p ps=1.5u w=1.12u l=0.13u
X94 sg13cmos5l_inv_16_8.A sg13cmos5l_inv_16_6.A VPWR.t1 VPWR.t0 sg13_lv_pmos ad=0.2128p pd=1.5u as=0.3808p ps=2.92u w=1.12u l=0.13u
X95 sg13cmos5l_inv_16_21.A sg13cmos5l_inv_16_22.A VGND.t712 VGND.t724 sg13_lv_nmos ad=0.1406p pd=1.12u as=0.1406p ps=1.12u w=0.74u l=0.13u
X96 sg13cmos5l_inv_16_21.Y sg13cmos5l_inv_16_21.A VPWR.t78 VPWR.t0 sg13_lv_pmos ad=0.2128p pd=1.5u as=0.2128p ps=1.5u w=1.12u l=0.13u
X97 a_26991_3108# sg13cmos5l_xnor2_1_5.Y VPWR.t657 VPWR.t20 sg13_lv_pmos ad=0.1596p pd=1.22u as=0.203p ps=1.5u w=0.84u l=0.13u
X98 sg13cmos5l_inv_16_25.Y sg13cmos5l_inv_16_23.Y VGND.t32 VGND.t498 sg13_lv_nmos ad=0.1406p pd=1.12u as=0.1406p ps=1.12u w=0.74u l=0.13u
X99 VGND.t361 sg13cmos5l_inv_16_7.A sg13cmos5l_inv_16_10.A VGND.t527 sg13_lv_nmos ad=0.1406p pd=1.12u as=0.1406p ps=1.12u w=0.74u l=0.13u
X100 VGND.t69 sg13cmos5l_inv_4_5.A sg13cmos5l_inv_8_6.A VGND.t238 sg13_lv_nmos ad=0.1406p pd=1.12u as=0.1406p ps=1.12u w=0.74u l=0.13u
X101 sg13cmos5l_inv_16_15.A sg13cmos5l_inv_8_1.A VGND.t325 VGND.t778 sg13_lv_nmos ad=0.1406p pd=1.12u as=0.1406p ps=1.12u w=0.74u l=0.13u
X102 VGND.t269 sg13cmos5l_inv_16_27.A sg13cmos5l_inv_16_23.A VGND.t278 sg13_lv_nmos ad=0.1406p pd=1.12u as=0.1406p ps=1.12u w=0.74u l=0.13u
X103 VGND.t312 sg13cmos5l_inv_16_12.A sg13cmos5l_inv_16_13.A VGND.t890 sg13_lv_nmos ad=0.1406p pd=1.12u as=0.1406p ps=1.12u w=0.74u l=0.13u
X104 sg13cmos5l_inv_16_30.A sg13cmos5l_inv_16_20.A VGND.t82 VGND.t85 sg13_lv_nmos ad=0.1406p pd=1.12u as=0.1406p ps=1.12u w=0.74u l=0.13u
X105 VGND.t190 sg13cmos5l_inv_16_23.A sg13cmos5l_inv_16_23.Y VGND.t668 sg13_lv_nmos ad=0.2516p pd=2.16u as=0.1406p ps=1.12u w=0.74u l=0.13u
X106 VPWR.t41 VGND.t379 VPWR.t596 VPWR.t0 sg13_lv_pmos ad=0.19p pd=1.38u as=0 ps=0 w=1u l=1u
X107 VGND.t235 sg13cmos5l_inv_16_1.Y sg13cmos5l_inv_16_17.Y VGND.t829 sg13_lv_nmos ad=0.1406p pd=1.12u as=0.1406p ps=1.12u w=0.74u l=0.13u
X108 a_26259_2680# sg13cmos5l_xnor2_1_6.Y VPWR.t23 VPWR.t20 sg13_lv_pmos ad=0.1428p pd=1.375u as=0.2891p ps=1.695u w=1.12u l=0.13u
X109 sg13cmos5l_inv_16_6.A sg13cmos5l_inv_4_2.Y VGND.t7 VGND.t33 sg13_lv_nmos ad=0.1406p pd=1.12u as=0.2516p ps=2.16u w=0.74u l=0.13u
X110 VPWR.t530 sg13cmos5l_inv_16_23.A sg13cmos5l_inv_16_23.Y VPWR.t20 sg13_lv_pmos ad=0.2128p pd=1.5u as=0.2128p ps=1.5u w=1.12u l=0.13u
X111 VPWR.t396 sg13cmos5l_inv_16_22.A sg13cmos5l_inv_16_21.A VPWR.t0 sg13_lv_pmos ad=0.2128p pd=1.5u as=0.2128p ps=1.5u w=1.12u l=0.13u
X112 sg13cmos5l_inv_16_17.Y sg13cmos5l_inv_16_1.Y VGND.t235 VGND.t826 sg13_lv_nmos ad=0.1406p pd=1.12u as=0.2516p ps=2.16u w=0.74u l=0.13u
X113 VPWR.t158 sg13cmos5l_inv_16_9.A sg13cmos5l_inv_16_9.Y VPWR.t20 sg13_lv_pmos ad=0.2128p pd=1.5u as=0.2128p ps=1.5u w=1.12u l=0.13u
X114 VPWR.t260 sg13cmos5l_xnor2_1_1.Y a_26880_2697# VPWR.t20 sg13_lv_pmos ad=0.2891p pd=1.695u as=0.1596p ps=1.22u w=0.84u l=0.13u
X115 VGND.t172 sg13cmos5l_inv_16_9.Y sg13cmos5l_inv_16_11.Y VGND.t186 sg13_lv_nmos ad=0.2516p pd=2.16u as=0.1406p ps=1.12u w=0.74u l=0.13u
X116 VGND.t69 sg13cmos5l_inv_16_26.A sg13cmos5l_inv_16_31.A VGND.t763 sg13_lv_nmos ad=0.1406p pd=1.12u as=0.1406p ps=1.12u w=0.74u l=0.13u
X117 sg13cmos5l_inv_16_10.A sg13cmos5l_inv_16_7.A VPWR.t366 VPWR.t0 sg13_lv_pmos ad=0.2128p pd=1.5u as=0.3808p ps=2.92u w=1.12u l=0.13u
X118 VGND.t269 VPWR.t532 VGND.t269 VGND.t352 sg13_lv_nmos ad=79.8f pd=0.8u as=0 ps=0 w=0.42u l=1u
X119 sg13cmos5l_inv_16_21.A sg13cmos5l_inv_16_22.A VPWR.t396 VPWR.t0 sg13_lv_pmos ad=0.2128p pd=1.5u as=0.2128p ps=1.5u w=1.12u l=0.13u
X120 VGND.t417 sg13cmos5l_inv_16_29.A sg13cmos5l_inv_16_29.Y VGND.t495 sg13_lv_nmos ad=0.2516p pd=2.16u as=0.1406p ps=1.12u w=0.74u l=0.13u
X121 sg13cmos5l_inv_16_8.A sg13cmos5l_inv_16_6.A VGND.t7 VGND.t12 sg13_lv_nmos ad=0.1406p pd=1.12u as=0.1406p ps=1.12u w=0.74u l=0.13u
X122 sg13cmos5l_inv_16_14.A sg13cmos5l_inv_16_15.A VPWR.t126 VPWR.t20 sg13_lv_pmos ad=0.2128p pd=1.5u as=0.2128p ps=1.5u w=1.12u l=0.13u
X123 VPWR.t36 VGND.t426 VPWR.t36 VPWR.t0 sg13_lv_pmos ad=0.34p pd=2.68u as=0 ps=0 w=1u l=1u
X124 sg13cmos5l_inv_16_31.A sg13cmos5l_inv_16_26.A VGND.t69 VGND.t760 sg13_lv_nmos ad=0.1406p pd=1.12u as=0.1406p ps=1.12u w=0.74u l=0.13u
X125 VGND.t235 sg13cmos5l_inv_2_2.A sg13cmos5l_inv_4_1.A VGND.t236 sg13_lv_nmos ad=0.2516p pd=2.16u as=0.1406p ps=1.12u w=0.74u l=0.13u
X126 VPWR.t396 sg13cmos5l_inv_16_22.A sg13cmos5l_inv_16_21.A VPWR.t0 sg13_lv_pmos ad=0.2128p pd=1.5u as=0.2128p ps=1.5u w=1.12u l=0.13u
X127 sg13cmos5l_inv_16_18.A sg13cmos5l_inv_16_16.A VPWR.t87 VPWR.t0 sg13_lv_pmos ad=0.2128p pd=1.5u as=0.2128p ps=1.5u w=1.12u l=0.13u
X128 VPWR.t134 sg13cmos5l_inv_16_29.Y sg13cmos5l_inv_16_4.Y VPWR.t20 sg13_lv_pmos ad=0.4368p pd=3.02u as=0.2128p ps=1.5u w=1.12u l=0.13u
X129 VGND.t119 sg13cmos5l_inv_16_24.A sg13cmos5l_inv_16_27.A VGND.t797 sg13_lv_nmos ad=0.1406p pd=1.12u as=0.1406p ps=1.12u w=0.74u l=0.13u
X130 VPWR.t104 sg13cmos5l_inv_4_0.Y sg13cmos5l_inv_16_0.A VPWR.t18 sg13_lv_pmos ad=0.3808p pd=2.92u as=0.2184p ps=1.51u w=1.12u l=0.13u
X131 VGND.t7 sg13cmos5l_inv_16_6.A sg13cmos5l_inv_16_8.A VGND.t9 sg13_lv_nmos ad=0.1406p pd=1.12u as=0.1406p ps=1.12u w=0.74u l=0.13u
X132 VGND.t269 sg13cmos5l_inv_16_27.A sg13cmos5l_inv_16_23.A VGND.t274 sg13_lv_nmos ad=0.1406p pd=1.12u as=0.1406p ps=1.12u w=0.74u l=0.13u
X133 sg13cmos5l_inv_16_5.Y sg13cmos5l_inv_16_5.A VGND.t303 VGND.t866 sg13_lv_nmos ad=0.1406p pd=1.12u as=0.1406p ps=1.12u w=0.74u l=0.13u
X134 VGND.t392 sg13cmos5l_inv_16_21.A sg13cmos5l_inv_16_21.Y VGND.t707 sg13_lv_nmos ad=0.1406p pd=1.12u as=0.1406p ps=1.12u w=0.74u l=0.13u
X135 VGND.t133 VPWR.t617 VGND.t133 VGND.t377 sg13_lv_nmos ad=0.1428p pd=1.52u as=0 ps=0 w=0.42u l=1u
X136 VGND.t312 sg13cmos5l_inv_16_12.A sg13cmos5l_inv_16_13.A VGND.t886 sg13_lv_nmos ad=0.1406p pd=1.12u as=0.1406p ps=1.12u w=0.74u l=0.13u
X137 VGND.t190 sg13cmos5l_inv_16_23.A sg13cmos5l_inv_16_23.Y VGND.t664 sg13_lv_nmos ad=0.1406p pd=1.12u as=0.1406p ps=1.12u w=0.74u l=0.13u
X138 a_5803_3940# sg13cmos5l_and2_1_7.A a_5709_3940# VGND.t624 sg13_lv_nmos ad=0.1216p pd=1.02u as=0.2176p ps=1.96u w=0.64u l=0.13u
X139 VPWR.t87 sg13cmos5l_inv_16_16.A sg13cmos5l_inv_16_18.A VPWR.t0 sg13_lv_pmos ad=0.2128p pd=1.5u as=0.2128p ps=1.5u w=1.12u l=0.13u
X140 sg13cmos5l_inv_16_4.Y sg13cmos5l_inv_16_29.Y VPWR.t132 VPWR.t20 sg13_lv_pmos ad=0.2128p pd=1.5u as=0.2128p ps=1.5u w=1.12u l=0.13u
X141 sg13cmos5l_inv_16_1.A sg13cmos5l_inv_16_14.A VPWR.t232 VPWR.t20 sg13_lv_pmos ad=0.2128p pd=1.5u as=0.2128p ps=1.5u w=1.12u l=0.13u
X142 sg13cmos5l_inv_16_27.A sg13cmos5l_inv_16_24.A VGND.t119 VGND.t794 sg13_lv_nmos ad=0.1406p pd=1.12u as=0.1406p ps=1.12u w=0.74u l=0.13u
X143 VPWR.t510 sg13cmos5l_inv_16_26.A sg13cmos5l_inv_16_31.A VPWR.t20 sg13_lv_pmos ad=0.2128p pd=1.5u as=0.2128p ps=1.5u w=1.12u l=0.13u
X144 VPWR.t23 sg13cmos5l_xnor2_1_3.Y a_26016_2697# VPWR.t20 sg13_lv_pmos ad=0.2891p pd=1.695u as=0.1596p ps=1.22u w=0.84u l=0.13u
X145 a_23648_3403# sg13cmos5l_and2_1_7.B VPWR.t21 VPWR.t20 sg13_lv_pmos ad=0.1596p pd=1.22u as=0.1918p ps=1.5u w=0.84u l=0.13u
X146 VGND.t231 sg13cmos5l_inv_16_2.A sg13cmos5l_inv_16_16.A VGND.t290 sg13_lv_nmos ad=0.1406p pd=1.12u as=0.1406p ps=1.12u w=0.74u l=0.13u
X147 sg13cmos5l_inv_16_14.A sg13cmos5l_inv_16_15.A VPWR.t124 VPWR.t20 sg13_lv_pmos ad=0.2128p pd=1.5u as=0.2128p ps=1.5u w=1.12u l=0.13u
X148 sg13cmos5l_inv_16_23.A sg13cmos5l_inv_16_27.A VGND.t269 VGND.t271 sg13_lv_nmos ad=0.1406p pd=1.12u as=0.1406p ps=1.12u w=0.74u l=0.13u
X149 sg13cmos5l_inv_16_30.A sg13cmos5l_inv_16_20.A VPWR.t78 VPWR.t0 sg13_lv_pmos ad=0.2128p pd=1.5u as=0.2128p ps=1.5u w=1.12u l=0.13u
X150 VPWR.t313 sg13cmos5l_inv_16_5.Y sg13cmos5l_inv_16_3.Y VPWR.t0 sg13_lv_pmos ad=0.2128p pd=1.5u as=0.2128p ps=1.5u w=1.12u l=0.13u
X151 sg13cmos5l_inv_16_23.Y sg13cmos5l_inv_16_23.A VGND.t190 VGND.t661 sg13_lv_nmos ad=0.1406p pd=1.12u as=0.1406p ps=1.12u w=0.74u l=0.13u
X152 VPWR.t356 sg13cmos5l_inv_16_23.A sg13cmos5l_inv_16_23.Y VPWR.t20 sg13_lv_pmos ad=0.2128p pd=1.5u as=0.2128p ps=1.5u w=1.12u l=0.13u
X153 VPWR.t625 sg13cmos5l_inv_16_14.A sg13cmos5l_inv_16_1.A VPWR.t20 sg13_lv_pmos ad=0.2128p pd=1.5u as=0.2128p ps=1.5u w=1.12u l=0.13u
X154 VGND.t119 sg13cmos5l_inv_16_24.A sg13cmos5l_inv_16_27.A VGND.t791 sg13_lv_nmos ad=0.1406p pd=1.12u as=0.1406p ps=1.12u w=0.74u l=0.13u
X155 sg13cmos5l_inv_16_13.A sg13cmos5l_inv_16_12.A VPWR.t730 VPWR.t20 sg13_lv_pmos ad=0.2128p pd=1.5u as=0.2128p ps=1.5u w=1.12u l=0.13u
X156 VPWR.t46 sg13cmos5l_inv_16_20.A sg13cmos5l_inv_16_30.A VPWR.t0 sg13_lv_pmos ad=0.2128p pd=1.5u as=0.2128p ps=1.5u w=1.12u l=0.13u
X157 sg13cmos5l_inv_4_2.A sg13cmos5l_inv_2_1.A VGND.t7 VGND.t308 sg13_lv_nmos ad=0.1406p pd=1.12u as=0.2516p ps=2.16u w=0.74u l=0.13u
X158 VGND.t172 sg13cmos5l_inv_16_13.A sg13cmos5l_inv_16_9.A VGND.t186 sg13_lv_nmos ad=0.2516p pd=2.16u as=0.1406p ps=1.12u w=0.74u l=0.13u
X159 VPWR.t14 sg13cmos5l_inv_4_2.Y sg13cmos5l_inv_16_6.A VPWR.t0 sg13_lv_pmos ad=0.2128p pd=1.5u as=0.2128p ps=1.5u w=1.12u l=0.13u
X160 sg13cmos5l_inv_16_9.Y sg13cmos5l_inv_16_9.A VPWR.t170 VPWR.t20 sg13_lv_pmos ad=0.2128p pd=1.5u as=0.2128p ps=1.5u w=1.12u l=0.13u
X161 sg13cmos5l_inv_16_2.A sg13cmos5l_inv_16_0.A VGND.t249 VGND.t615 sg13_lv_nmos ad=0.1406p pd=1.12u as=0.1406p ps=1.12u w=0.74u l=0.13u
X162 VPWR.t36 sg13cmos5l_inv_16_7.A sg13cmos5l_inv_16_10.A VPWR.t0 sg13_lv_pmos ad=0.2128p pd=1.5u as=0.2128p ps=1.5u w=1.12u l=0.13u
X163 VPWR.t1 VGND.t365 VPWR.t36 VPWR.t0 sg13_lv_pmos ad=0.34p pd=2.68u as=0 ps=0 w=1u l=1u
X164 sg13cmos5l_inv_16_5.Y sg13cmos5l_inv_16_5.A VPWR.t313 VPWR.t0 sg13_lv_pmos ad=0.2128p pd=1.5u as=0.3808p ps=2.92u w=1.12u l=0.13u
X165 VGND.t45 sg13cmos5l_inv_16_30.A sg13cmos5l_inv_16_5.A VGND.t50 sg13_lv_nmos ad=0.1406p pd=1.12u as=0.1406p ps=1.12u w=0.74u l=0.13u
X166 VGND.t41 sg13cmos5l_inv_16_16.A sg13cmos5l_inv_16_18.A VGND.t112 sg13_lv_nmos ad=0.1406p pd=1.12u as=0.1406p ps=1.12u w=0.74u l=0.13u
X167 VPWR.t168 sg13cmos5l_inv_16_9.A sg13cmos5l_inv_16_9.Y VPWR.t20 sg13_lv_pmos ad=0.2128p pd=1.5u as=0.2128p ps=1.5u w=1.12u l=0.13u
X168 VGND.t249 sg13cmos5l_inv_16_0.A sg13cmos5l_inv_16_2.A VGND.t612 sg13_lv_nmos ad=0.1406p pd=1.12u as=0.1406p ps=1.12u w=0.74u l=0.13u
X169 sg13cmos5l_inv_16_5.A sg13cmos5l_inv_16_30.A VGND.t45 VGND.t44 sg13_lv_nmos ad=0.1406p pd=1.12u as=0.2516p ps=2.16u w=0.74u l=0.13u
X170 VGND.t381 VPWR.t117 VGND.t379 VGND.t380 sg13_lv_nmos ad=0.1428p pd=1.52u as=0 ps=0 w=0.42u l=1u
X171 VGND.t568 sg13cmos5l_inv_16_8.A sg13cmos5l_inv_16_7.A VGND.t579 sg13_lv_nmos ad=0.1406p pd=1.12u as=0.1406p ps=1.12u w=0.74u l=0.13u
X172 VGND.t188 a_27686_874# a_27798_938# VGND.t304 sg13_lv_nmos ad=0.1426p pd=1.16u as=0.1428p ps=1.52u w=0.42u l=0.5u
X173 VPWR.t849 VGND.t133 VPWR.t617 VPWR.t20 sg13_lv_pmos ad=0.34p pd=2.68u as=0 ps=0 w=1u l=1u
X174 VPWR.t118 sg13cmos5l_inv_2_3.A sg13cmos5l_inv_2_3.Y VPWR.t20 sg13_lv_pmos ad=0.3864p pd=2.93u as=0.2128p ps=1.5u w=1.12u l=0.13u
X175 sg13cmos5l_inv_16_25.Y sg13cmos5l_inv_16_23.Y VPWR.t352 VPWR.t20 sg13_lv_pmos ad=0.2128p pd=1.5u as=0.2128p ps=1.5u w=1.12u l=0.13u
X176 sg13cmos5l_inv_4_0.Y sg13cmos5l_inv_4_0.A VGND.t303 VGND.t512 sg13_lv_nmos ad=0.1406p pd=1.12u as=0.2516p ps=2.16u w=0.74u l=0.13u
X177 VPWR.t419 sg13cmos5l_inv_16_31.A sg13cmos5l_inv_16_29.A VPWR.t20 sg13_lv_pmos ad=0.2128p pd=1.5u as=0.2128p ps=1.5u w=1.12u l=0.13u
X178 sg13cmos5l_inv_16_1.A sg13cmos5l_inv_16_14.A VGND.t324 VGND.t746 sg13_lv_nmos ad=0.1406p pd=1.12u as=0.1406p ps=1.12u w=0.74u l=0.13u
X179 VGND.t307 VPWR.t427 VGND.t312 VGND.t311 sg13_lv_nmos ad=79.8f pd=0.8u as=0 ps=0 w=0.42u l=1u
X180 sg13cmos5l_inv_16_29.A sg13cmos5l_inv_16_31.A VGND.t80 VGND.t642 sg13_lv_nmos ad=0.1406p pd=1.12u as=0.1406p ps=1.12u w=0.74u l=0.13u
X181 VPWR.t182 sg13cmos5l_inv_16_9.Y sg13cmos5l_inv_16_11.Y VPWR.t18 sg13_lv_pmos ad=0.2128p pd=1.5u as=0.2128p ps=1.5u w=1.12u l=0.13u
X182 VGND.t269 VPWR.t538 VGND.t269 VGND.t353 sg13_lv_nmos ad=0.1428p pd=1.52u as=0 ps=0 w=0.42u l=1u
X183 a_19753_3940# sg13cmos5l_and2_1_5.B VGND.t32 VGND.t710 sg13_lv_nmos ad=0.1216p pd=1.02u as=0.1331p ps=1.12u w=0.64u l=0.13u
X184 VGND.t66 VPWR.t58 VGND.t66 VGND.t327 sg13_lv_nmos ad=0.1428p pd=1.52u as=0 ps=0 w=0.42u l=1u
X185 VGND.t417 sg13cmos5l_inv_16_31.A sg13cmos5l_inv_16_29.A VGND.t639 sg13_lv_nmos ad=0.1406p pd=1.12u as=0.1406p ps=1.12u w=0.74u l=0.13u
X186 a_6284_3858# en[1] VGND.t235 VGND.t560 sg13_lv_nmos ad=0.187p pd=1.78u as=0.14875p ps=1.16u w=0.55u l=0.13u
X187 sg13cmos5l_inv_16_5.A sg13cmos5l_inv_16_30.A VGND.t45 VGND.t51 sg13_lv_nmos ad=0.1406p pd=1.12u as=0.1406p ps=1.12u w=0.74u l=0.13u
X188 VGND.t7 sg13cmos5l_inv_4_1.A sg13cmos5l_inv_4_1.Y VGND.t824 sg13_lv_nmos ad=0.2516p pd=2.16u as=0.1406p ps=1.12u w=0.74u l=0.13u
X189 sg13cmos5l_inv_16_9.A sg13cmos5l_inv_16_13.A VPWR.t164 VPWR.t20 sg13_lv_pmos ad=0.2128p pd=1.5u as=0.2128p ps=1.5u w=1.12u l=0.13u
X190 sg13cmos5l_inv_16_24.A sg13cmos5l_inv_4_6.Y VPWR.t106 VPWR.t18 sg13_lv_pmos ad=0.2128p pd=1.5u as=0.2128p ps=1.5u w=1.12u l=0.13u
X191 VGND.t41 sg13cmos5l_inv_16_16.A sg13cmos5l_inv_16_18.A VGND.t108 sg13_lv_nmos ad=0.1406p pd=1.12u as=0.1406p ps=1.12u w=0.74u l=0.13u
X192 sg13cmos5l_inv_16_11.Y sg13cmos5l_inv_16_9.Y VPWR.t182 VPWR.t18 sg13_lv_pmos ad=0.2128p pd=1.5u as=0.2128p ps=1.5u w=1.12u l=0.13u
X193 sg13cmos5l_inv_16_29.Y sg13cmos5l_inv_16_29.A VPWR.t46 VPWR.t0 sg13_lv_pmos ad=0.2128p pd=1.5u as=0.2128p ps=1.5u w=1.12u l=0.13u
X194 VPWR.t1 sg13cmos5l_inv_16_6.A sg13cmos5l_inv_16_8.A VPWR.t0 sg13_lv_pmos ad=0.2128p pd=1.5u as=0.2128p ps=1.5u w=1.12u l=0.13u
X195 VGND.t45 sg13cmos5l_inv_16_30.A sg13cmos5l_inv_16_5.A VGND.t46 sg13_lv_nmos ad=0.1406p pd=1.12u as=0.1406p ps=1.12u w=0.74u l=0.13u
X196 VPWR.t396 sg13cmos5l_inv_16_21.A sg13cmos5l_inv_16_21.Y VPWR.t0 sg13_lv_pmos ad=0.4368p pd=3.02u as=0.2128p ps=1.5u w=1.12u l=0.13u
X197 sg13cmos5l_inv_16_30.A sg13cmos5l_inv_16_20.A VGND.t82 VGND.t95 sg13_lv_nmos ad=0.1406p pd=1.12u as=0.1406p ps=1.12u w=0.74u l=0.13u
X198 sg13cmos5l_inv_16_29.A sg13cmos5l_inv_16_31.A VGND.t384 VGND.t636 sg13_lv_nmos ad=0.1406p pd=1.12u as=0.1406p ps=1.12u w=0.74u l=0.13u
X199 VPWR.t162 sg13cmos5l_inv_16_13.A sg13cmos5l_inv_16_9.A VPWR.t20 sg13_lv_pmos ad=0.2128p pd=1.5u as=0.2128p ps=1.5u w=1.12u l=0.13u
X200 sg13cmos5l_inv_16_16.A sg13cmos5l_inv_16_2.A VPWR.t96 VPWR.t0 sg13_lv_pmos ad=0.2128p pd=1.5u as=0.2128p ps=1.5u w=1.12u l=0.13u
X201 VGND.t421 VPWR.t17 VGND.t24 VGND.t422 sg13_lv_nmos ad=79.8f pd=0.8u as=0 ps=0 w=0.42u l=1u
X202 sg13cmos5l_inv_16_8.A sg13cmos5l_inv_16_6.A VPWR.t1 VPWR.t0 sg13_lv_pmos ad=0.2128p pd=1.5u as=0.2128p ps=1.5u w=1.12u l=0.13u
X203 sg13cmos5l_inv_16_20.A sg13cmos5l_inv_8_4.A VGND.t62 VGND.t898 sg13_lv_nmos ad=0.1443p pd=1.13u as=0.2516p ps=2.16u w=0.74u l=0.13u
X204 sg13cmos5l_inv_8_1.A sg13cmos5l_inv_2_3.Y VPWR.t58 VPWR.t18 sg13_lv_pmos ad=0.2128p pd=1.5u as=0.2128p ps=1.5u w=1.12u l=0.13u
X205 sg13cmos5l_inv_16_21.Y sg13cmos5l_inv_16_21.A VPWR.t396 VPWR.t0 sg13_lv_pmos ad=0.2128p pd=1.5u as=0.2128p ps=1.5u w=1.12u l=0.13u
X206 VPWR.t487 VGND.t131 VPWR.t485 VPWR.t20 sg13_lv_pmos ad=0.19p pd=1.38u as=0 ps=0 w=1u l=1u
X207 VPWR.t538 sg13cmos5l_inv_16_23.A sg13cmos5l_inv_16_23.Y VPWR.t20 sg13_lv_pmos ad=0.4368p pd=3.02u as=0.2128p ps=1.5u w=1.12u l=0.13u
X208 VGND.t69 sg13cmos5l_inv_1_4.A sg13cmos5l_inv_1_4.Y VGND.t97 sg13_lv_nmos ad=0.2516p pd=2.16u as=0.2516p ps=2.16u w=0.74u l=0.13u
X209 sg13cmos5l_inv_16_27.A sg13cmos5l_inv_16_24.A VPWR.t685 VPWR.t18 sg13_lv_pmos ad=0.2128p pd=1.5u as=0.2128p ps=1.5u w=1.12u l=0.13u
X210 sg13cmos5l_inv_4_2.Y sg13cmos5l_inv_4_2.A VPWR.t14 VPWR.t0 sg13_lv_pmos ad=0.2128p pd=1.5u as=0.3808p ps=2.92u w=1.12u l=0.13u
X211 VGND.t384 VPWR.t144 VGND.t384 VGND.t383 sg13_lv_nmos ad=0.1428p pd=1.52u as=0 ps=0 w=0.42u l=1u
X212 sg13cmos5l_inv_16_4.Y sg13cmos5l_inv_16_29.Y VGND.t133 VGND.t132 sg13_lv_nmos ad=0.1406p pd=1.12u as=0.2516p ps=2.16u w=0.74u l=0.13u
X213 sg13cmos5l_inv_16_17.Y sg13cmos5l_inv_16_1.Y VGND.t235 VGND.t838 sg13_lv_nmos ad=0.1406p pd=1.12u as=0.1406p ps=1.12u w=0.74u l=0.13u
X214 VPWR.t117 VGND.t379 VPWR.t489 VPWR.t20 sg13_lv_pmos ad=0.34p pd=2.68u as=0 ps=0 w=1u l=1u
X215 VPWR.t19 a_5120_4097# sg13cmos5l_inv_1_1.A VPWR.t18 sg13_lv_pmos ad=0.1918p pd=1.5u as=0.3808p ps=2.92u w=1.12u l=0.13u
X216 VPWR.t1 sg13cmos5l_inv_16_6.A sg13cmos5l_inv_16_8.A VPWR.t0 sg13_lv_pmos ad=0.2128p pd=1.5u as=0.2128p ps=1.5u w=1.12u l=0.13u
X217 VGND.t119 a_24910_3411# sg13cmos5l_dlygate4sd3_1_0.A VGND.t622 sg13_lv_nmos ad=0.1426p pd=1.16u as=0.2516p ps=2.16u w=0.74u l=0.13u
X218 VGND.t235 sg13cmos5l_inv_16_1.Y sg13cmos5l_inv_16_17.Y VGND.t835 sg13_lv_nmos ad=0.1406p pd=1.12u as=0.1406p ps=1.12u w=0.74u l=0.13u
X219 VPWR.t58 VGND.t66 VPWR.t58 VPWR.t18 sg13_lv_pmos ad=0.34p pd=2.68u as=0 ps=0 w=1u l=1u
X220 a_28652_3858# en[7] VPWR.t816 VPWR.t18 sg13_lv_pmos ad=0.2856p pd=2.36u as=0.2114p ps=1.54u w=0.84u l=0.13u
X221 VPWR.t23 a_26016_2697# sg13cmos5l_xnor2_1_4.Y VPWR.t20 sg13_lv_pmos ad=0.3808p pd=2.92u as=0.2408p ps=1.55u w=1.12u l=0.13u
X222 sg13cmos5l_inv_16_31.A sg13cmos5l_inv_16_26.A VGND.t69 VGND.t770 sg13_lv_nmos ad=0.1406p pd=1.12u as=0.1406p ps=1.12u w=0.74u l=0.13u
X223 sg13cmos5l_xnor2_1_6.Y a_25248_2697# a_25397_2386# VGND.t561 sg13_lv_nmos ad=0.2516p pd=2.16u as=0.1406p ps=1.12u w=0.74u l=0.13u
X224 VPWR.t61 sg13cmos5l_inv_8_6.A sg13cmos5l_inv_16_26.A VPWR.t20 sg13_lv_pmos ad=0.2128p pd=1.5u as=0.2128p ps=1.5u w=1.12u l=0.13u
X225 VGND.t303 sg13cmos5l_inv_16_5.A sg13cmos5l_inv_16_5.Y VGND.t867 sg13_lv_nmos ad=0.1406p pd=1.12u as=0.1406p ps=1.12u w=0.74u l=0.13u
X226 sg13cmos5l_inv_16_6.A sg13cmos5l_inv_4_2.Y VGND.t7 VGND.t39 sg13_lv_nmos ad=0.1443p pd=1.13u as=0.1406p ps=1.12u w=0.74u l=0.13u
X227 VGND.t121 sg13cmos5l_inv_4_8.A sg13cmos5l_xnor2_1_6.A VGND.t652 sg13_lv_nmos ad=0.2516p pd=2.16u as=0.1406p ps=1.12u w=0.74u l=0.13u
X228 VPWR.t307 a_25306_3108# a_25025_3410# VPWR.t20 sg13_lv_pmos ad=0.1523p pd=1.38u as=0.34p ps=2.68u w=1u l=0.5u
X229 VGND.t535 a_5120_4097# sg13cmos5l_inv_1_1.A VGND.t934 sg13_lv_nmos ad=0.1331p pd=1.12u as=0.2516p ps=2.16u w=0.74u l=0.13u
X230 sg13cmos5l_inv_16_11.Y sg13cmos5l_inv_16_9.Y VPWR.t182 VPWR.t18 sg13_lv_pmos ad=0.2128p pd=1.5u as=0.2128p ps=1.5u w=1.12u l=0.13u
X231 VPWR.t106 sg13cmos5l_inv_2_7.Y sg13cmos5l_inv_4_6.Y VPWR.t18 sg13_lv_pmos ad=0.2128p pd=1.5u as=0.2128p ps=1.5u w=1.12u l=0.13u
X232 sg13cmos5l_inv_16_18.Y sg13cmos5l_inv_16_18.A VPWR.t87 VPWR.t0 sg13_lv_pmos ad=0.2128p pd=1.5u as=0.2128p ps=1.5u w=1.12u l=0.13u
X233 VGND.t535 sg13cmos5l_inv_16_12.A sg13cmos5l_inv_16_13.A VGND.t896 sg13_lv_nmos ad=0.2516p pd=2.16u as=0.1406p ps=1.12u w=0.74u l=0.13u
X234 sg13cmos5l_inv_16_17.Y sg13cmos5l_inv_16_1.Y VPWR.t253 VPWR.t20 sg13_lv_pmos ad=0.2128p pd=1.5u as=0.2128p ps=1.5u w=1.12u l=0.13u
X235 sg13cmos5l_inv_16_0.A sg13cmos5l_inv_4_0.Y VGND.t324 VGND.t817 sg13_lv_nmos ad=0.1406p pd=1.12u as=0.1406p ps=1.12u w=0.74u l=0.13u
X236 sg13cmos5l_inv_16_16.A sg13cmos5l_inv_16_2.A VGND.t231 VGND.t291 sg13_lv_nmos ad=0.1406p pd=1.12u as=0.1406p ps=1.12u w=0.74u l=0.13u
X237 VPWR.t96 sg13cmos5l_inv_16_16.A sg13cmos5l_inv_16_18.A VPWR.t0 sg13_lv_pmos ad=0.4368p pd=3.02u as=0.2128p ps=1.5u w=1.12u l=0.13u
X238 sg13cmos5l_inv_16_26.A sg13cmos5l_inv_8_6.A VPWR.t60 VPWR.t20 sg13_lv_pmos ad=0.2128p pd=1.5u as=0.3808p ps=2.92u w=1.12u l=0.13u
X239 VPWR.t19 sg13cmos5l_buf_1_1.X a_5120_4097# VPWR.t18 sg13_lv_pmos ad=0.2856p pd=2.36u as=0.1596p ps=1.22u w=0.84u l=0.13u
X240 sg13cmos5l_inv_16_14.A sg13cmos5l_inv_16_15.A VPWR.t132 VPWR.t20 sg13_lv_pmos ad=0.2128p pd=1.5u as=0.2128p ps=1.5u w=1.12u l=0.13u
X241 VPWR.t14 sg13cmos5l_inv_16_18.A sg13cmos5l_inv_16_18.Y VPWR.t0 sg13_lv_pmos ad=0.2128p pd=1.5u as=0.2128p ps=1.5u w=1.12u l=0.13u
X242 VPWR.t313 sg13cmos5l_inv_16_0.A sg13cmos5l_inv_16_2.A VPWR.t0 sg13_lv_pmos ad=0.2128p pd=1.5u as=0.2128p ps=1.5u w=1.12u l=0.13u
X243 sg13cmos5l_xnor2_1_6.A sg13cmos5l_inv_4_8.A VPWR.t516 VPWR.t20 sg13_lv_pmos ad=0.2128p pd=1.5u as=0.3808p ps=2.92u w=1.12u l=0.13u
X244 VPWR.t536 sg13cmos5l_inv_16_23.A sg13cmos5l_inv_16_23.Y VPWR.t20 sg13_lv_pmos ad=0.2128p pd=1.5u as=0.2128p ps=1.5u w=1.12u l=0.13u
X245 VGND.t324 sg13cmos5l_inv_4_0.Y sg13cmos5l_inv_16_0.A VGND.t814 sg13_lv_nmos ad=0.1406p pd=1.12u as=0.1406p ps=1.12u w=0.74u l=0.13u
X246 VPWR.t389 sg13cmos5l_inv_4_1.Y sg13cmos5l_inv_16_12.A VPWR.t20 sg13_lv_pmos ad=0.2128p pd=1.5u as=0.2128p ps=1.5u w=1.12u l=0.13u
X247 a_24819_1168# sg13cmos5l_xnor2_1_3.A VPWR.t17 VPWR.t0 sg13_lv_pmos ad=0.1428p pd=1.375u as=0.2891p ps=1.695u w=1.12u l=0.13u
X248 VGND.t27 sg13cmos5l_xnor2_1_3.B a_25112_1673# VGND.t163 sg13_lv_nmos ad=79.8f pd=0.8u as=0.1428p ps=1.52u w=0.42u l=0.13u
X249 sg13cmos5l_inv_16_18.A sg13cmos5l_inv_16_16.A VPWR.t96 VPWR.t0 sg13_lv_pmos ad=0.2128p pd=1.5u as=0.2128p ps=1.5u w=1.12u l=0.13u
X250 sg13cmos5l_inv_16_13.A sg13cmos5l_inv_16_12.A VPWR.t522 VPWR.t20 sg13_lv_pmos ad=0.2128p pd=1.5u as=0.2128p ps=1.5u w=1.12u l=0.13u
X251 sg13cmos5l_inv_16_31.A sg13cmos5l_inv_16_26.A VPWR.t667 VPWR.t20 sg13_lv_pmos ad=0.2128p pd=1.5u as=0.2128p ps=1.5u w=1.12u l=0.13u
X252 VPWR.t1 sg13cmos5l_inv_16_8.A sg13cmos5l_inv_16_7.A VPWR.t0 sg13_lv_pmos ad=0.2128p pd=1.5u as=0.2128p ps=1.5u w=1.12u l=0.13u
X253 VGND.t7 sg13cmos5l_inv_16_6.A sg13cmos5l_inv_16_8.A VGND.t15 sg13_lv_nmos ad=0.1406p pd=1.12u as=0.1406p ps=1.12u w=0.74u l=0.13u
X254 VGND.t397 VPWR.t352 VGND.t397 VGND.t396 sg13_lv_nmos ad=0.1428p pd=1.52u as=0 ps=0 w=0.42u l=1u
X255 sg13cmos5l_inv_16_2.A sg13cmos5l_inv_16_0.A VPWR.t96 VPWR.t0 sg13_lv_pmos ad=0.2128p pd=1.5u as=0.2128p ps=1.5u w=1.12u l=0.13u
X256 sg13cmos5l_inv_16_25.Y sg13cmos5l_inv_16_23.Y VPWR.t348 VPWR.t20 sg13_lv_pmos ad=0.2128p pd=1.5u as=0.2128p ps=1.5u w=1.12u l=0.13u
X257 VGND.t269 sg13cmos5l_inv_16_27.A sg13cmos5l_inv_16_23.A VGND.t280 sg13_lv_nmos ad=0.1406p pd=1.12u as=0.1406p ps=1.12u w=0.74u l=0.13u
X258 sg13cmos5l_inv_16_3.Y sg13cmos5l_inv_16_5.Y VGND.t133 VGND.t132 sg13_lv_nmos ad=0.1406p pd=1.12u as=0.2516p ps=2.16u w=0.74u l=0.13u
X259 sg13cmos5l_inv_16_23.Y sg13cmos5l_inv_16_23.A VPWR.t532 VPWR.t20 sg13_lv_pmos ad=0.2128p pd=1.5u as=0.2128p ps=1.5u w=1.12u l=0.13u
X260 sg13cmos5l_inv_16_1.Y sg13cmos5l_inv_16_1.A VGND.t41 VGND.t245 sg13_lv_nmos ad=0.1406p pd=1.12u as=0.1406p ps=1.12u w=0.74u l=0.13u
X261 sg13cmos5l_inv_16_10.Y sg13cmos5l_inv_16_10.A VGND.t426 VGND.t669 sg13_lv_nmos ad=0.1406p pd=1.12u as=0.2516p ps=2.16u w=0.74u l=0.13u
X262 a_26880_1671# sg13cmos5l_xnor2_1_1.B a_26843_1980# VGND.t265 sg13_lv_nmos ad=0.2176p pd=1.96u as=78.39999f ps=0.885u w=0.64u l=0.13u
X263 sg13cmos5l_inv_16_27.A sg13cmos5l_inv_16_24.A VGND.t119 VGND.t800 sg13_lv_nmos ad=0.1406p pd=1.12u as=0.1406p ps=1.12u w=0.74u l=0.13u
X264 VPWR.t346 sg13cmos5l_inv_16_23.Y sg13cmos5l_inv_16_25.Y VPWR.t20 sg13_lv_pmos ad=0.2128p pd=1.5u as=0.2128p ps=1.5u w=1.12u l=0.13u
X265 VGND.t32 VPWR.t156 VGND.t32 VGND.t333 sg13_lv_nmos ad=79.8f pd=0.8u as=0 ps=0 w=0.42u l=1u
X266 sg13cmos5l_inv_4_2.A sg13cmos5l_inv_2_1.A VPWR.t300 VPWR.t20 sg13_lv_pmos ad=0.2128p pd=1.5u as=0.3864p ps=2.93u w=1.12u l=0.13u
X267 VPWR.t58 a_14732_3858# sg13cmos5l_and2_1_2.B VPWR.t18 sg13_lv_pmos ad=0.2114p pd=1.54u as=0.42p ps=2.99u w=1.12u l=0.13u
X268 VGND.t64 sg13cmos5l_dlygate4sd3_1_4.X a_27416_874# VGND.t461 sg13_lv_nmos ad=79.8f pd=0.8u as=0.1428p ps=1.52u w=0.42u l=0.13u
X269 sg13cmos5l_inv_16_13.A sg13cmos5l_inv_16_12.A VPWR.t794 VPWR.t20 sg13_lv_pmos ad=0.2128p pd=1.5u as=0.2128p ps=1.5u w=1.12u l=0.13u
X270 sg13cmos5l_inv_16_17.Y sg13cmos5l_inv_16_1.Y VPWR.t249 VPWR.t20 sg13_lv_pmos ad=0.2128p pd=1.5u as=0.2128p ps=1.5u w=1.12u l=0.13u
X271 VGND.t27 a_24518_1632# a_24630_1656# VGND.t67 sg13_lv_nmos ad=0.1426p pd=1.16u as=0.1428p ps=1.52u w=0.42u l=0.5u
X272 VPWR.t78 sg13cmos5l_inv_16_20.A sg13cmos5l_inv_16_30.A VPWR.t0 sg13_lv_pmos ad=0.2128p pd=1.5u as=0.2128p ps=1.5u w=1.12u l=0.13u
X273 sg13cmos5l_inv_16_5.Y sg13cmos5l_inv_16_5.A VPWR.t313 VPWR.t0 sg13_lv_pmos ad=0.2128p pd=1.5u as=0.2128p ps=1.5u w=1.12u l=0.13u
X274 VPWR.t158 sg13cmos5l_inv_16_13.A sg13cmos5l_inv_16_9.A VPWR.t20 sg13_lv_pmos ad=0.2128p pd=1.5u as=0.2128p ps=1.5u w=1.12u l=0.13u
X275 sg13cmos5l_inv_16_7.A sg13cmos5l_inv_16_8.A VGND.t568 VGND.t580 sg13_lv_nmos ad=0.1406p pd=1.12u as=0.1406p ps=1.12u w=0.74u l=0.13u
X276 VPWR.t14 sg13cmos5l_inv_4_2.Y sg13cmos5l_inv_16_6.A VPWR.t0 sg13_lv_pmos ad=0.3808p pd=2.92u as=0.2184p ps=1.51u w=1.12u l=0.13u
X277 sg13cmos5l_xnor2_1_2.B a_27798_938# VGND.t188 VGND.t187 sg13_lv_nmos ad=0.2516p pd=2.16u as=0.1426p ps=1.16u w=0.74u l=0.13u
X278 sg13cmos5l_inv_16_14.A sg13cmos5l_inv_16_15.A VGND.t324 VGND.t817 sg13_lv_nmos ad=0.1406p pd=1.12u as=0.2516p ps=2.16u w=0.74u l=0.13u
X279 VGND.t119 VPWR.t120 VGND.t339 VGND.t338 sg13_lv_nmos ad=79.8f pd=0.8u as=0 ps=0 w=0.42u l=1u
X280 sg13cmos5l_inv_16_22.A sg13cmos5l_inv_16_19.A VGND.t551 VGND.t552 sg13_lv_nmos ad=0.1406p pd=1.12u as=0.1406p ps=1.12u w=0.74u l=0.13u
X281 a_25382_1632# a_25112_1673# VPWR.t115 VPWR.t0 sg13_lv_pmos ad=0.34p pd=2.68u as=0.1523p ps=1.38u w=1u l=0.5u
X282 VGND.t303 sg13cmos5l_inv_4_0.A sg13cmos5l_inv_4_0.Y VGND.t513 sg13_lv_nmos ad=0.1406p pd=1.12u as=0.1406p ps=1.12u w=0.74u l=0.13u
X283 sg13cmos5l_inv_16_20.A sg13cmos5l_inv_8_4.A VPWR.t78 VPWR.t0 sg13_lv_pmos ad=0.2184p pd=1.51u as=0.3808p ps=2.92u w=1.12u l=0.13u
X284 VPWR.t596 VGND.t133 VPWR.t596 VPWR.t0 sg13_lv_pmos ad=0.34p pd=2.68u as=0 ps=0 w=1u l=1u
X285 VGND.t397 sg13cmos5l_inv_16_19.A sg13cmos5l_inv_16_22.A VGND.t548 sg13_lv_nmos ad=0.1406p pd=1.12u as=0.1406p ps=1.12u w=0.74u l=0.13u
X286 VPWR.t119 sg13cmos5l_inv_1_2.A sg13cmos5l_inv_2_3.A VPWR.t18 sg13_lv_pmos ad=0.3808p pd=2.92u as=0.3808p ps=2.92u w=1.12u l=0.13u
X287 VPWR.t156 VGND.t32 VPWR.t156 VPWR.t18 sg13_lv_pmos ad=0.19p pd=1.38u as=0 ps=0 w=1u l=1u
X288 sg13cmos5l_inv_16_5.Y sg13cmos5l_inv_16_5.A VPWR.t313 VPWR.t0 sg13_lv_pmos ad=0.2128p pd=1.5u as=0.2128p ps=1.5u w=1.12u l=0.13u
X289 VPWR.t35 VGND.t307 VPWR.t34 VPWR.t20 sg13_lv_pmos ad=0.19p pd=1.38u as=0 ps=0 w=1u l=1u
X290 VPWR.t512 sg13cmos5l_inv_16_26.A sg13cmos5l_inv_16_31.A VPWR.t20 sg13_lv_pmos ad=0.2128p pd=1.5u as=0.2128p ps=1.5u w=1.12u l=0.13u
X291 sg13cmos5l_inv_4_1.A sg13cmos5l_inv_2_2.A VPWR.t215 VPWR.t20 sg13_lv_pmos ad=0.2128p pd=1.5u as=0.3808p ps=2.92u w=1.12u l=0.13u
X292 VPWR.t218 sg13cmos5l_inv_4_5.A sg13cmos5l_inv_8_6.A VPWR.t18 sg13_lv_pmos ad=0.2128p pd=1.5u as=0.2128p ps=1.5u w=1.12u l=0.13u
X293 a_25248_2697# sg13cmos5l_dlygate4sd3_1_0.A a_25211_2428# VGND.t620 sg13_lv_nmos ad=0.2176p pd=1.96u as=78.39999f ps=0.885u w=0.64u l=0.13u
X294 sg13cmos5l_inv_16_15.A sg13cmos5l_inv_8_1.A VPWR.t678 VPWR.t18 sg13_lv_pmos ad=0.2128p pd=1.5u as=0.2128p ps=1.5u w=1.12u l=0.13u
X295 sg13cmos5l_and2_1_7.A a_26991_3108# VPWR.t260 VPWR.t20 sg13_lv_pmos ad=0.2128p pd=1.5u as=0.3808p ps=2.92u w=1.12u l=0.13u
X296 sg13cmos5l_inv_16_22.A sg13cmos5l_inv_16_19.A VGND.t397 VGND.t545 sg13_lv_nmos ad=0.1406p pd=1.12u as=0.1406p ps=1.12u w=0.74u l=0.13u
X297 VPWR.t25 sg13cmos5l_inv_16_27.A sg13cmos5l_inv_16_23.A VPWR.t18 sg13_lv_pmos ad=0.2128p pd=1.5u as=0.2128p ps=1.5u w=1.12u l=0.13u
X298 VPWR.t313 sg13cmos5l_inv_16_5.A sg13cmos5l_inv_16_5.Y VPWR.t0 sg13_lv_pmos ad=0.2128p pd=1.5u as=0.2128p ps=1.5u w=1.12u l=0.13u
X299 VGND.t45 sg13cmos5l_inv_16_30.A sg13cmos5l_inv_16_5.A VGND.t52 sg13_lv_nmos ad=0.1406p pd=1.12u as=0.1406p ps=1.12u w=0.74u l=0.13u
X300 sg13cmos5l_inv_16_29.A sg13cmos5l_inv_16_31.A VPWR.t508 VPWR.t20 sg13_lv_pmos ad=0.2128p pd=1.5u as=0.2128p ps=1.5u w=1.12u l=0.13u
X301 sg13cmos5l_inv_16_5.A sg13cmos5l_inv_16_30.A VGND.t45 VGND.t47 sg13_lv_nmos ad=0.1406p pd=1.12u as=0.1406p ps=1.12u w=0.74u l=0.13u
X302 VGND.t121 sg13cmos5l_inv_4_6.Y sg13cmos5l_inv_16_24.A VGND.t686 sg13_lv_nmos ad=0.1406p pd=1.12u as=0.1443p ps=1.13u w=0.74u l=0.13u
X303 a_14377_3940# sg13cmos5l_and2_1_2.B VGND.t66 VGND.t811 sg13_lv_nmos ad=0.1216p pd=1.02u as=0.1331p ps=1.12u w=0.64u l=0.13u
X304 VPWR.t366 sg13cmos5l_inv_16_10.A sg13cmos5l_inv_16_10.Y VPWR.t0 sg13_lv_pmos ad=0.2128p pd=1.5u as=0.2128p ps=1.5u w=1.12u l=0.13u
X305 VGND.t269 VPWR.t532 VGND.t269 VGND.t351 sg13_lv_nmos ad=0.1428p pd=1.52u as=0 ps=0 w=0.42u l=1u
X306 VPWR.t193 en[0] a_2920_3932# VPWR.t18 sg13_lv_pmos ad=0.2114p pd=1.54u as=0.2856p ps=2.36u w=0.84u l=0.13u
X307 VPWR.t422 sg13cmos5l_inv_16_31.A sg13cmos5l_inv_16_29.A VPWR.t20 sg13_lv_pmos ad=0.2128p pd=1.5u as=0.2128p ps=1.5u w=1.12u l=0.13u
X308 sg13cmos5l_inv_16_16.A sg13cmos5l_inv_16_2.A VPWR.t96 VPWR.t0 sg13_lv_pmos ad=0.2128p pd=1.5u as=0.2128p ps=1.5u w=1.12u l=0.13u
X309 VGND.t381 sg13cmos5l_inv_16_29.A sg13cmos5l_inv_16_29.Y VGND.t481 sg13_lv_nmos ad=0.1406p pd=1.12u as=0.1406p ps=1.12u w=0.74u l=0.13u
X310 VPWR.t14 sg13cmos5l_inv_4_2.Y sg13cmos5l_inv_16_6.A VPWR.t0 sg13_lv_pmos ad=0.2128p pd=1.5u as=0.2128p ps=1.5u w=1.12u l=0.13u
X311 VPWR.t391 sg13cmos5l_inv_4_1.A sg13cmos5l_inv_4_1.Y VPWR.t20 sg13_lv_pmos ad=0.3808p pd=2.92u as=0.2128p ps=1.5u w=1.12u l=0.13u
X312 a_9932_3858# en[2] VPWR.t104 VPWR.t18 sg13_lv_pmos ad=0.2856p pd=2.36u as=0.2114p ps=1.54u w=0.84u l=0.13u
X313 sg13cmos5l_inv_16_10.Y sg13cmos5l_inv_16_10.A VPWR.t366 VPWR.t0 sg13_lv_pmos ad=0.2128p pd=1.5u as=0.2128p ps=1.5u w=1.12u l=0.13u
X314 VPWR.t193 sg13cmos5l_inv_16_9.Y sg13cmos5l_inv_16_11.Y VPWR.t18 sg13_lv_pmos ad=0.4368p pd=3.02u as=0.2128p ps=1.5u w=1.12u l=0.13u
X315 sg13cmos5l_inv_16_24.A sg13cmos5l_inv_4_6.Y VGND.t359 VGND.t685 sg13_lv_nmos ad=0.1443p pd=1.13u as=0.2516p ps=2.16u w=0.74u l=0.13u
X316 sg13cmos5l_inv_16_29.A sg13cmos5l_inv_16_31.A VPWR.t421 VPWR.t20 sg13_lv_pmos ad=0.2128p pd=1.5u as=0.2128p ps=1.5u w=1.12u l=0.13u
X317 sg13cmos5l_inv_16_4.Y sg13cmos5l_inv_16_29.Y VGND.t133 VGND.t143 sg13_lv_nmos ad=0.1406p pd=1.12u as=0.1406p ps=1.12u w=0.74u l=0.13u
X318 VGND.t82 sg13cmos5l_inv_16_31.A sg13cmos5l_inv_16_29.A VGND.t645 sg13_lv_nmos ad=0.1406p pd=1.12u as=0.1406p ps=1.12u w=0.74u l=0.13u
X319 sg13cmos5l_inv_16_9.A sg13cmos5l_inv_16_13.A VPWR.t170 VPWR.t20 sg13_lv_pmos ad=0.2128p pd=1.5u as=0.2128p ps=1.5u w=1.12u l=0.13u
X320 sg13cmos5l_xnor2_1_4.Y sg13cmos5l_xnor2_1_3.Y a_26259_2680# VPWR.t20 sg13_lv_pmos ad=0.2408p pd=1.55u as=0.1428p ps=1.375u w=1.12u l=0.13u
X321 VPWR.t348 VGND.t395 VPWR.t346 VPWR.t20 sg13_lv_pmos ad=0.19p pd=1.38u as=0 ps=0 w=1u l=1u
X322 VGND.t390 sg13cmos5l_inv_16_21.A sg13cmos5l_inv_16_21.Y VGND.t694 sg13_lv_nmos ad=0.1406p pd=1.12u as=0.1406p ps=1.12u w=0.74u l=0.13u
X323 VGND.t172 VPWR.t34 VGND.t172 VGND.t340 sg13_lv_nmos ad=0.1428p pd=1.52u as=0 ps=0 w=0.42u l=1u
X324 VPWR.t120 sg13cmos5l_inv_16_24.A sg13cmos5l_inv_16_27.A VPWR.t18 sg13_lv_pmos ad=0.2128p pd=1.5u as=0.2128p ps=1.5u w=1.12u l=0.13u
X325 sg13cmos5l_inv_16_4.Y sg13cmos5l_inv_16_29.Y VPWR.t121 VPWR.t20 sg13_lv_pmos ad=0.2128p pd=1.5u as=0.3808p ps=2.92u w=1.12u l=0.13u
X326 VPWR.t168 sg13cmos5l_inv_16_13.A sg13cmos5l_inv_16_9.A VPWR.t20 sg13_lv_pmos ad=0.2128p pd=1.5u as=0.2128p ps=1.5u w=1.12u l=0.13u
X327 VPWR.t25 sg13cmos5l_inv_16_27.A sg13cmos5l_inv_16_23.A VPWR.t18 sg13_lv_pmos ad=0.2128p pd=1.5u as=0.2128p ps=1.5u w=1.12u l=0.13u
X328 sg13cmos5l_inv_16_5.Y sg13cmos5l_inv_16_5.A VGND.t303 VGND.t868 sg13_lv_nmos ad=0.1406p pd=1.12u as=0.1406p ps=1.12u w=0.74u l=0.13u
X329 sg13cmos5l_inv_16_8.A sg13cmos5l_inv_16_6.A VPWR.t1 VPWR.t0 sg13_lv_pmos ad=0.2128p pd=1.5u as=0.2128p ps=1.5u w=1.12u l=0.13u
X330 VPWR.t19 sg13cmos5l_and2_1_1.B a_5709_3940# VPWR.t18 sg13_lv_pmos ad=0.1918p pd=1.5u as=0.1596p ps=1.22u w=0.84u l=0.13u
X331 VPWR.t17 a_24518_1632# a_24630_1656# VPWR.t0 sg13_lv_pmos ad=0.2254p pd=1.53u as=0.34p ps=2.68u w=1u l=0.5u
X332 sg13cmos5l_inv_16_27.A sg13cmos5l_inv_16_24.A VPWR.t685 VPWR.t18 sg13_lv_pmos ad=0.2128p pd=1.5u as=0.2128p ps=1.5u w=1.12u l=0.13u
X333 VPWR.t17 sg13cmos5l_xnor2_1_3.A a_24248_1673# VPWR.t0 sg13_lv_pmos ad=0.1523p pd=1.38u as=0.1428p ps=1.52u w=0.42u l=0.13u
X334 VGND.t27 sg13cmos5l_xnor2_1_6.A a_25397_2386# VGND.t457 sg13_lv_nmos ad=0.1898p pd=1.36u as=0.2516p ps=2.16u w=0.74u l=0.13u
X335 sg13cmos5l_inv_16_4.Y sg13cmos5l_inv_16_29.Y VGND.t133 VGND.t139 sg13_lv_nmos ad=0.1406p pd=1.12u as=0.1406p ps=1.12u w=0.74u l=0.13u
X336 VGND.t62 VPWR.t46 VGND.t62 VGND.t437 sg13_lv_nmos ad=79.8f pd=0.8u as=0 ps=0 w=0.42u l=1u
X337 sg13cmos5l_inv_16_23.A sg13cmos5l_inv_16_27.A VPWR.t25 VPWR.t18 sg13_lv_pmos ad=0.2128p pd=1.5u as=0.2128p ps=1.5u w=1.12u l=0.13u
X338 sg13cmos5l_inv_16_18.Y sg13cmos5l_inv_16_18.A VPWR.t87 VPWR.t0 sg13_lv_pmos ad=0.2128p pd=1.5u as=0.2128p ps=1.5u w=1.12u l=0.13u
X339 VGND.t231 sg13cmos5l_inv_16_2.A sg13cmos5l_inv_16_16.A VGND.t292 sg13_lv_nmos ad=0.1406p pd=1.12u as=0.1406p ps=1.12u w=0.74u l=0.13u
X340 sg13cmos5l_inv_16_28.A sg13cmos5l_inv_8_7.A VGND.t196 VGND.t197 sg13_lv_nmos ad=0.1406p pd=1.12u as=0.1406p ps=1.12u w=0.74u l=0.13u
X341 VGND.t712 sg13cmos5l_inv_16_22.A sg13cmos5l_inv_16_21.A VGND.t725 sg13_lv_nmos ad=0.1406p pd=1.12u as=0.1406p ps=1.12u w=0.74u l=0.13u
X342 VPWR.t685 sg13cmos5l_inv_16_24.A sg13cmos5l_inv_16_27.A VPWR.t18 sg13_lv_pmos ad=0.2128p pd=1.5u as=0.2128p ps=1.5u w=1.12u l=0.13u
X343 VGND.t133 sg13cmos5l_inv_16_29.Y sg13cmos5l_inv_16_4.Y VGND.t136 sg13_lv_nmos ad=0.1406p pd=1.12u as=0.1406p ps=1.12u w=0.74u l=0.13u
X344 sg13cmos5l_inv_16_10.Y sg13cmos5l_inv_16_10.A VPWR.t366 VPWR.t0 sg13_lv_pmos ad=0.2128p pd=1.5u as=0.2128p ps=1.5u w=1.12u l=0.13u
X345 VPWR.t65 sg13cmos5l_inv_8_6.A sg13cmos5l_inv_16_26.A VPWR.t20 sg13_lv_pmos ad=0.3808p pd=2.92u as=0.2184p ps=1.51u w=1.12u l=0.13u
X346 VPWR.t224 sg13cmos5l_inv_16_1.Y sg13cmos5l_inv_16_17.Y VPWR.t20 sg13_lv_pmos ad=0.4368p pd=3.02u as=0.2128p ps=1.5u w=1.12u l=0.13u
X347 VGND.t190 sg13cmos5l_inv_8_7.A sg13cmos5l_inv_16_28.A VGND.t193 sg13_lv_nmos ad=0.1406p pd=1.12u as=0.1406p ps=1.12u w=0.74u l=0.13u
X348 VPWR.t144 VGND.t66 VPWR.t146 VPWR.t20 sg13_lv_pmos ad=0.19p pd=1.38u as=0 ps=0 w=1u l=1u
X349 VGND.t361 sg13cmos5l_inv_16_9.A sg13cmos5l_inv_16_9.Y VGND.t525 sg13_lv_nmos ad=0.1406p pd=1.12u as=0.1406p ps=1.12u w=0.74u l=0.13u
X350 VPWR.t96 sg13cmos5l_inv_16_2.A sg13cmos5l_inv_16_16.A VPWR.t0 sg13_lv_pmos ad=0.2128p pd=1.5u as=0.2128p ps=1.5u w=1.12u l=0.13u
X351 VGND.t399 VPWR.t198 VGND.t199 VGND.t398 sg13_lv_nmos ad=0.1428p pd=1.52u as=0 ps=0 w=0.42u l=1u
X352 VPWR.t480 sg13cmos5l_inv_16_14.A sg13cmos5l_inv_16_1.A VPWR.t20 sg13_lv_pmos ad=0.2128p pd=1.5u as=0.2128p ps=1.5u w=1.12u l=0.13u
X353 VPWR.t68 en[4] a_16264_3932# VPWR.t18 sg13_lv_pmos ad=0.2114p pd=1.54u as=0.2856p ps=2.36u w=0.84u l=0.13u
X354 VGND.t426 sg13cmos5l_inv_16_10.A sg13cmos5l_inv_16_10.Y VGND.t670 sg13_lv_nmos ad=0.1406p pd=1.12u as=0.1406p ps=1.12u w=0.74u l=0.13u
X355 sg13cmos5l_inv_16_18.Y sg13cmos5l_inv_16_18.A VPWR.t87 VPWR.t0 sg13_lv_pmos ad=0.2128p pd=1.5u as=0.2128p ps=1.5u w=1.12u l=0.13u
X356 VPWR.t42 sg13cmos5l_inv_16_30.A sg13cmos5l_inv_16_5.A VPWR.t0 sg13_lv_pmos ad=0.2128p pd=1.5u as=0.2128p ps=1.5u w=1.12u l=0.13u
X357 VPWR.t174 sg13cmos5l_inv_16_28.A sg13cmos5l_inv_16_19.A VPWR.t0 sg13_lv_pmos ad=0.2128p pd=1.5u as=0.2128p ps=1.5u w=1.12u l=0.13u
X358 sg13cmos5l_inv_16_3.Y sg13cmos5l_inv_16_5.Y VGND.t133 VGND.t143 sg13_lv_nmos ad=0.1406p pd=1.12u as=0.1406p ps=1.12u w=0.74u l=0.13u
X359 VPWR.t17 sg13cmos5l_xnor2_1_3.B a_24576_1185# VPWR.t0 sg13_lv_pmos ad=0.2891p pd=1.695u as=0.1596p ps=1.22u w=0.84u l=0.13u
X360 sg13cmos5l_inv_16_1.Y sg13cmos5l_inv_16_1.A VGND.t249 VGND.t256 sg13_lv_nmos ad=0.1406p pd=1.12u as=0.1406p ps=1.12u w=0.74u l=0.13u
X361 sg13cmos5l_inv_16_9.Y sg13cmos5l_inv_16_9.A VGND.t361 VGND.t522 sg13_lv_nmos ad=0.1406p pd=1.12u as=0.1406p ps=1.12u w=0.74u l=0.13u
X362 sg13cmos5l_inv_16_26.A sg13cmos5l_inv_8_6.A VPWR.t65 VPWR.t20 sg13_lv_pmos ad=0.2184p pd=1.51u as=0.2128p ps=1.5u w=1.12u l=0.13u
X363 VGND.t303 sg13cmos5l_inv_16_5.A sg13cmos5l_inv_16_5.Y VGND.t869 sg13_lv_nmos ad=0.1406p pd=1.12u as=0.1406p ps=1.12u w=0.74u l=0.13u
X364 a_27686_874# a_27416_874# VGND.t64 VGND.t261 sg13_lv_nmos ad=0.1428p pd=1.52u as=79.8f ps=0.8u w=0.42u l=0.5u
X365 sg13cmos5l_inv_16_19.A sg13cmos5l_inv_16_28.A VGND.t585 VGND.t587 sg13_lv_nmos ad=0.1406p pd=1.12u as=0.1406p ps=1.12u w=0.74u l=0.13u
X366 sg13cmos5l_inv_16_5.A sg13cmos5l_inv_16_30.A VPWR.t41 VPWR.t0 sg13_lv_pmos ad=0.2128p pd=1.5u as=0.3808p ps=2.92u w=1.12u l=0.13u
X367 sg13cmos5l_inv_16_1.Y sg13cmos5l_inv_16_1.A VPWR.t224 VPWR.t20 sg13_lv_pmos ad=0.2128p pd=1.5u as=0.2128p ps=1.5u w=1.12u l=0.13u
X368 sg13cmos5l_inv_16_5.Y sg13cmos5l_inv_16_5.A VGND.t303 VGND.t864 sg13_lv_nmos ad=0.1406p pd=1.12u as=0.2516p ps=2.16u w=0.74u l=0.13u
X369 VPWR.t17 a_24576_1185# sg13cmos5l_xnor2_1_3.Y VPWR.t0 sg13_lv_pmos ad=0.3808p pd=2.92u as=0.2408p ps=1.55u w=1.12u l=0.13u
X370 a_26880_2697# sg13cmos5l_xnor2_1_1.Y a_26843_2428# VGND.t265 sg13_lv_nmos ad=0.2176p pd=1.96u as=78.39999f ps=0.885u w=0.64u l=0.13u
X371 VPWR.t24 sg13cmos5l_dlygate4sd3_1_3.X a_26112_1671# VPWR.t0 sg13_lv_pmos ad=0.2891p pd=1.695u as=0.1596p ps=1.22u w=0.84u l=0.13u
X372 sg13cmos5l_inv_16_22.A sg13cmos5l_inv_16_19.A VPWR.t396 VPWR.t0 sg13_lv_pmos ad=0.2128p pd=1.5u as=0.2128p ps=1.5u w=1.12u l=0.13u
X373 sg13cmos5l_inv_16_2.A sg13cmos5l_inv_16_0.A VGND.t249 VGND.t609 sg13_lv_nmos ad=0.1406p pd=1.12u as=0.1406p ps=1.12u w=0.74u l=0.13u
X374 VPWR.t1 sg13cmos5l_inv_16_8.A sg13cmos5l_inv_16_7.A VPWR.t0 sg13_lv_pmos ad=0.2128p pd=1.5u as=0.2128p ps=1.5u w=1.12u l=0.13u
X375 sg13cmos5l_inv_16_21.A sg13cmos5l_inv_16_22.A VGND.t712 VGND.t726 sg13_lv_nmos ad=0.1406p pd=1.12u as=0.1406p ps=1.12u w=0.74u l=0.13u
X376 sg13cmos5l_inv_16_3.Y sg13cmos5l_inv_16_5.Y VGND.t133 VGND.t139 sg13_lv_nmos ad=0.1406p pd=1.12u as=0.1406p ps=1.12u w=0.74u l=0.13u
X377 VPWR.t396 sg13cmos5l_inv_16_19.A sg13cmos5l_inv_16_22.A VPWR.t0 sg13_lv_pmos ad=0.2128p pd=1.5u as=0.2128p ps=1.5u w=1.12u l=0.13u
X378 VGND.t249 sg13cmos5l_inv_16_0.A sg13cmos5l_inv_16_2.A VGND.t606 sg13_lv_nmos ad=0.1406p pd=1.12u as=0.1406p ps=1.12u w=0.74u l=0.13u
X379 sg13cmos5l_inv_16_14.A sg13cmos5l_inv_16_15.A VGND.t325 VGND.t924 sg13_lv_nmos ad=0.1406p pd=1.12u as=0.1406p ps=1.12u w=0.74u l=0.13u
X380 VPWR.t41 sg13cmos5l_inv_16_29.A sg13cmos5l_inv_16_29.Y VPWR.t0 sg13_lv_pmos ad=0.2128p pd=1.5u as=0.2128p ps=1.5u w=1.12u l=0.13u
X381 VGND.t133 sg13cmos5l_inv_16_5.Y sg13cmos5l_inv_16_3.Y VGND.t136 sg13_lv_nmos ad=0.1406p pd=1.12u as=0.1406p ps=1.12u w=0.74u l=0.13u
X382 sg13cmos5l_inv_4_0.Y sg13cmos5l_inv_4_0.A VGND.t303 VGND.t514 sg13_lv_nmos ad=0.1406p pd=1.12u as=0.1406p ps=1.12u w=0.74u l=0.13u
X383 VGND.t361 sg13cmos5l_inv_16_7.A sg13cmos5l_inv_16_10.A VGND.t525 sg13_lv_nmos ad=0.1406p pd=1.12u as=0.1406p ps=1.12u w=0.74u l=0.13u
X384 VPWR.t156 sg13cmos5l_and2_1_7.A a_19616_4097# VPWR.t18 sg13_lv_pmos ad=0.2856p pd=2.36u as=0.1596p ps=1.22u w=0.84u l=0.13u
X385 sg13cmos5l_inv_16_29.Y sg13cmos5l_inv_16_29.A VPWR.t41 VPWR.t0 sg13_lv_pmos ad=0.2128p pd=1.5u as=0.3808p ps=2.92u w=1.12u l=0.13u
X386 sg13cmos5l_inv_16_9.Y sg13cmos5l_inv_16_9.A VGND.t361 VGND.t518 sg13_lv_nmos ad=0.1406p pd=1.12u as=0.1406p ps=1.12u w=0.74u l=0.13u
X387 sg13cmos5l_inv_16_1.A sg13cmos5l_inv_16_14.A VGND.t117 VGND.t740 sg13_lv_nmos ad=0.1406p pd=1.12u as=0.1406p ps=1.12u w=0.74u l=0.13u
X388 VPWR.t24 VGND.t407 VPWR.t24 VPWR.t0 sg13_lv_pmos ad=0.19p pd=1.38u as=0 ps=0 w=1u l=1u
X389 VPWR.t303 sg13cmos5l_inv_16_26.A sg13cmos5l_inv_16_31.A VPWR.t20 sg13_lv_pmos ad=0.2128p pd=1.5u as=0.2128p ps=1.5u w=1.12u l=0.13u
X390 VGND.t421 VPWR.t17 VGND.t22 VGND.t420 sg13_lv_nmos ad=0.1428p pd=1.52u as=0 ps=0 w=0.42u l=1u
X391 VGND.t585 sg13cmos5l_inv_16_28.A sg13cmos5l_inv_16_19.A VGND.t588 sg13_lv_nmos ad=0.1406p pd=1.12u as=0.1406p ps=1.12u w=0.74u l=0.13u
X392 sg13cmos5l_inv_16_19.A sg13cmos5l_inv_16_28.A VPWR.t174 VPWR.t0 sg13_lv_pmos ad=0.2128p pd=1.5u as=0.2128p ps=1.5u w=1.12u l=0.13u
X393 sg13cmos5l_inv_16_5.A sg13cmos5l_inv_16_30.A VGND.t45 VGND.t53 sg13_lv_nmos ad=0.1406p pd=1.12u as=0.1406p ps=1.12u w=0.74u l=0.13u
X394 sg13cmos5l_inv_16_10.A sg13cmos5l_inv_16_7.A VGND.t361 VGND.t522 sg13_lv_nmos ad=0.1406p pd=1.12u as=0.1406p ps=1.12u w=0.74u l=0.13u
X395 VGND.t249 sg13cmos5l_inv_16_1.A sg13cmos5l_inv_16_1.Y VGND.t248 sg13_lv_nmos ad=0.1406p pd=1.12u as=0.1406p ps=1.12u w=0.74u l=0.13u
X396 sg13cmos5l_inv_16_14.A sg13cmos5l_inv_16_15.A VGND.t324 VGND.t920 sg13_lv_nmos ad=0.1406p pd=1.12u as=0.1406p ps=1.12u w=0.74u l=0.13u
X397 VGND.t199 sg13cmos5l_inv_4_7.A sg13cmos5l_inv_8_7.A VGND.t845 sg13_lv_nmos ad=0.2516p pd=2.16u as=0.1406p ps=1.12u w=0.74u l=0.13u
X398 VPWR.t313 sg13cmos5l_inv_16_5.A sg13cmos5l_inv_16_5.Y VPWR.t0 sg13_lv_pmos ad=0.2128p pd=1.5u as=0.2128p ps=1.5u w=1.12u l=0.13u
X399 sg13cmos5l_inv_16_22.A sg13cmos5l_inv_16_19.A VGND.t190 VGND.t558 sg13_lv_nmos ad=0.1406p pd=1.12u as=0.1406p ps=1.12u w=0.74u l=0.13u
X400 VGND.t45 sg13cmos5l_inv_16_30.A sg13cmos5l_inv_16_5.A VGND.t48 sg13_lv_nmos ad=0.1406p pd=1.12u as=0.1406p ps=1.12u w=0.74u l=0.13u
X401 sg13cmos5l_inv_16_21.Y sg13cmos5l_inv_16_21.A VPWR.t78 VPWR.t0 sg13_lv_pmos ad=0.2128p pd=1.5u as=0.3808p ps=2.92u w=1.12u l=0.13u
X402 VGND.t361 VPWR.t34 VGND.t363 VGND.t362 sg13_lv_nmos ad=79.8f pd=0.8u as=0 ps=0 w=0.42u l=1u
X403 VPWR.t1 sg13cmos5l_inv_16_8.A sg13cmos5l_inv_16_7.A VPWR.t0 sg13_lv_pmos ad=0.2128p pd=1.5u as=0.2128p ps=1.5u w=1.12u l=0.13u
X404 sg13cmos5l_inv_4_0.Y sg13cmos5l_inv_4_0.A VPWR.t313 VPWR.t0 sg13_lv_pmos ad=0.2128p pd=1.5u as=0.2128p ps=1.5u w=1.12u l=0.13u
X405 a_26261_2002# sg13cmos5l_dlygate4sd3_1_3.X VGND.t27 VGND.t260 sg13_lv_nmos ad=0.1406p pd=1.12u as=0.1898p ps=1.36u w=0.74u l=0.13u
X406 sg13cmos5l_inv_8_7.A sg13cmos5l_inv_4_7.A VGND.t190 VGND.t842 sg13_lv_nmos ad=0.1406p pd=1.12u as=0.2516p ps=2.16u w=0.74u l=0.13u
X407 VGND.t190 sg13cmos5l_inv_16_19.A sg13cmos5l_inv_16_22.A VGND.t555 sg13_lv_nmos ad=0.1406p pd=1.12u as=0.1406p ps=1.12u w=0.74u l=0.13u
X408 sg13cmos5l_buf_1_1.X a_2920_3932# VGND.t307 VGND.t631 sg13_lv_nmos ad=0.2886p pd=2.26u as=0.14875p ps=1.16u w=0.74u l=0.13u
X409 VGND.t384 sg13cmos5l_inv_16_29.A sg13cmos5l_inv_16_29.Y VGND.t493 sg13_lv_nmos ad=0.1406p pd=1.12u as=0.1406p ps=1.12u w=0.74u l=0.13u
X410 sg13cmos5l_inv_16_11.Y sg13cmos5l_inv_16_9.Y VGND.t172 VGND.t181 sg13_lv_nmos ad=0.1406p pd=1.12u as=0.1406p ps=1.12u w=0.74u l=0.13u
X411 sg13cmos5l_inv_16_31.A sg13cmos5l_inv_16_26.A VGND.t69 VGND.t758 sg13_lv_nmos ad=0.1406p pd=1.12u as=0.1406p ps=1.12u w=0.74u l=0.13u
X412 VPWR.t396 sg13cmos5l_inv_16_22.A sg13cmos5l_inv_16_21.A VPWR.t0 sg13_lv_pmos ad=0.2128p pd=1.5u as=0.2128p ps=1.5u w=1.12u l=0.13u
X413 VPWR.t174 sg13cmos5l_inv_8_7.A sg13cmos5l_inv_16_28.A VPWR.t0 sg13_lv_pmos ad=0.2128p pd=1.5u as=0.2128p ps=1.5u w=1.12u l=0.13u
X414 VPWR.t313 sg13cmos5l_inv_16_5.Y sg13cmos5l_inv_16_3.Y VPWR.t0 sg13_lv_pmos ad=0.2128p pd=1.5u as=0.2128p ps=1.5u w=1.12u l=0.13u
X415 sg13cmos5l_inv_16_29.Y sg13cmos5l_inv_16_29.A VGND.t384 VGND.t490 sg13_lv_nmos ad=0.1406p pd=1.12u as=0.1406p ps=1.12u w=0.74u l=0.13u
X416 VGND.t121 sg13cmos5l_inv_4_6.Y sg13cmos5l_inv_16_24.A VGND.t692 sg13_lv_nmos ad=0.2516p pd=2.16u as=0.1406p ps=1.12u w=0.74u l=0.13u
X417 VPWR.t36 sg13cmos5l_inv_16_10.A sg13cmos5l_inv_16_10.Y VPWR.t0 sg13_lv_pmos ad=0.4368p pd=3.02u as=0.2128p ps=1.5u w=1.12u l=0.13u
X418 VPWR.t657 a_26991_3108# sg13cmos5l_and2_1_7.A VPWR.t20 sg13_lv_pmos ad=0.203p pd=1.5u as=0.2128p ps=1.5u w=1.12u l=0.13u
X419 VGND.t705 sg13cmos5l_inv_16_21.A sg13cmos5l_inv_16_21.Y VGND.t704 sg13_lv_nmos ad=0.1406p pd=1.12u as=0.1406p ps=1.12u w=0.74u l=0.13u
X420 VGND.t32 sg13cmos5l_inv_16_23.Y sg13cmos5l_inv_16_25.Y VGND.t511 sg13_lv_nmos ad=0.2516p pd=2.16u as=0.1406p ps=1.12u w=0.74u l=0.13u
X421 sg13cmos5l_inv_16_28.A sg13cmos5l_inv_8_7.A VPWR.t174 VPWR.t0 sg13_lv_pmos ad=0.2128p pd=1.5u as=0.2128p ps=1.5u w=1.12u l=0.13u
X422 sg13cmos5l_inv_16_10.A sg13cmos5l_inv_16_7.A VGND.t361 VGND.t518 sg13_lv_nmos ad=0.1406p pd=1.12u as=0.1406p ps=1.12u w=0.74u l=0.13u
X423 sg13cmos5l_inv_16_4.Y sg13cmos5l_inv_16_29.Y VPWR.t130 VPWR.t20 sg13_lv_pmos ad=0.2128p pd=1.5u as=0.2128p ps=1.5u w=1.12u l=0.13u
X424 a_28652_3858# en[7] VGND.t156 VGND.t910 sg13_lv_nmos ad=0.187p pd=1.78u as=0.14875p ps=1.16u w=0.55u l=0.13u
X425 VGND.t29 sg13cmos5l_xnor2_1_2.B a_27599_2002# VGND.t28 sg13_lv_nmos ad=0.1898p pd=1.36u as=0.1406p ps=1.12u w=0.74u l=0.13u
X426 VPWR.t512 sg13cmos5l_inv_16_31.A sg13cmos5l_inv_16_29.A VPWR.t20 sg13_lv_pmos ad=0.2128p pd=1.5u as=0.2128p ps=1.5u w=1.12u l=0.13u
X427 VGND.t384 sg13cmos5l_inv_16_29.A sg13cmos5l_inv_16_29.Y VGND.t487 sg13_lv_nmos ad=0.1406p pd=1.12u as=0.1406p ps=1.12u w=0.74u l=0.13u
X428 sg13cmos5l_inv_16_24.A sg13cmos5l_inv_4_6.Y VGND.t121 VGND.t689 sg13_lv_nmos ad=0.1406p pd=1.12u as=0.1406p ps=1.12u w=0.74u l=0.13u
X429 VGND.t117 sg13cmos5l_inv_16_14.A sg13cmos5l_inv_16_1.A VGND.t733 sg13_lv_nmos ad=0.1406p pd=1.12u as=0.1406p ps=1.12u w=0.74u l=0.13u
X430 sg13cmos5l_inv_16_23.A sg13cmos5l_inv_16_27.A VGND.t269 VGND.t268 sg13_lv_nmos ad=0.1406p pd=1.12u as=0.2516p ps=2.16u w=0.74u l=0.13u
X431 sg13cmos5l_inv_16_21.Y sg13cmos5l_inv_16_21.A VGND.t390 VGND.t701 sg13_lv_nmos ad=0.1406p pd=1.12u as=0.1406p ps=1.12u w=0.74u l=0.13u
X432 sg13cmos5l_inv_16_13.A sg13cmos5l_inv_16_12.A VGND.t307 VGND.t881 sg13_lv_nmos ad=0.1406p pd=1.12u as=0.2516p ps=2.16u w=0.74u l=0.13u
X433 sg13cmos5l_inv_16_0.A sg13cmos5l_inv_4_0.Y VPWR.t104 VPWR.t18 sg13_lv_pmos ad=0.2128p pd=1.5u as=0.2128p ps=1.5u w=1.12u l=0.13u
X434 sg13cmos5l_inv_16_23.Y sg13cmos5l_inv_16_23.A VGND.t190 VGND.t659 sg13_lv_nmos ad=0.1406p pd=1.12u as=0.1406p ps=1.12u w=0.74u l=0.13u
X435 sg13cmos5l_inv_16_25.Y sg13cmos5l_inv_16_23.Y VGND.t32 VGND.t508 sg13_lv_nmos ad=0.1406p pd=1.12u as=0.1406p ps=1.12u w=0.74u l=0.13u
X436 VGND.t66 sg13cmos5l_inv_2_3.Y sg13cmos5l_inv_8_1.A VGND.t160 sg13_lv_nmos ad=0.2516p pd=2.16u as=0.1406p ps=1.12u w=0.74u l=0.13u
X437 VPWR.t419 VGND.t66 VPWR.t146 VPWR.t20 sg13_lv_pmos ad=0.34p pd=2.68u as=0 ps=0 w=1u l=1u
X438 VGND.t786 sg13cmos5l_inv_16_24.A sg13cmos5l_inv_16_27.A VGND.t789 sg13_lv_nmos ad=0.1406p pd=1.12u as=0.1406p ps=1.12u w=0.74u l=0.13u
X439 VPWR.t68 sg13cmos5l_inv_1_4.A sg13cmos5l_inv_1_4.Y VPWR.t18 sg13_lv_pmos ad=0.3808p pd=2.92u as=0.3808p ps=2.92u w=1.12u l=0.13u
X440 VPWR.t104 sg13cmos5l_inv_4_0.Y sg13cmos5l_inv_16_0.A VPWR.t18 sg13_lv_pmos ad=0.2128p pd=1.5u as=0.2128p ps=1.5u w=1.12u l=0.13u
X441 VGND.t366 VPWR.t729 VGND.t1 VGND.t367 sg13_lv_nmos ad=79.8f pd=0.8u as=0 ps=0 w=0.42u l=1u
X442 VPWR.t35 VGND.t363 VPWR.t34 VPWR.t20 sg13_lv_pmos ad=0.19p pd=1.38u as=0 ps=0 w=1u l=1u
X443 a_25491_2680# sg13cmos5l_xnor2_1_6.A VPWR.t307 VPWR.t20 sg13_lv_pmos ad=0.1428p pd=1.375u as=0.2891p ps=1.695u w=1.12u l=0.13u
X444 VGND.t133 sg13cmos5l_inv_16_29.Y sg13cmos5l_inv_16_4.Y VGND.t146 sg13_lv_nmos ad=0.1406p pd=1.12u as=0.1406p ps=1.12u w=0.74u l=0.13u
X445 sg13cmos5l_inv_16_4.Y sg13cmos5l_inv_16_29.Y VPWR.t126 VPWR.t20 sg13_lv_pmos ad=0.2128p pd=1.5u as=0.2128p ps=1.5u w=1.12u l=0.13u
X446 sg13cmos5l_inv_16_27.A sg13cmos5l_inv_16_24.A VGND.t786 VGND.t785 sg13_lv_nmos ad=0.1406p pd=1.12u as=0.2516p ps=2.16u w=0.74u l=0.13u
X447 VPWR.t96 sg13cmos5l_inv_16_0.A sg13cmos5l_inv_16_2.A VPWR.t0 sg13_lv_pmos ad=0.2128p pd=1.5u as=0.2128p ps=1.5u w=1.12u l=0.13u
X448 VGND.t269 VPWR.t262 VGND.t269 VGND.t335 sg13_lv_nmos ad=0.1428p pd=1.52u as=0 ps=0 w=0.42u l=1u
X449 VPWR.t262 sg13cmos5l_inv_16_27.A sg13cmos5l_inv_16_23.A VPWR.t18 sg13_lv_pmos ad=0.2128p pd=1.5u as=0.2128p ps=1.5u w=1.12u l=0.13u
X450 a_26843_1980# sg13cmos5l_xnor2_1_0.Y VGND.t27 VGND.t566 sg13_lv_nmos ad=78.39999f pd=0.885u as=0.2272p ps=1.99u w=0.64u l=0.13u
X451 VPWR.t313 sg13cmos5l_inv_16_5.Y sg13cmos5l_inv_16_3.Y VPWR.t0 sg13_lv_pmos ad=0.2128p pd=1.5u as=0.2128p ps=1.5u w=1.12u l=0.13u
X452 sg13cmos5l_xnor2_1_5.Y a_26880_2697# a_27029_2386# VGND.t755 sg13_lv_nmos ad=0.2516p pd=2.16u as=0.1406p ps=1.12u w=0.74u l=0.13u
X453 sg13cmos5l_inv_16_23.Y sg13cmos5l_inv_16_23.A VGND.t397 VGND.t655 sg13_lv_nmos ad=0.1406p pd=1.12u as=0.1406p ps=1.12u w=0.74u l=0.13u
X454 VPWR.t124 sg13cmos5l_inv_16_29.Y sg13cmos5l_inv_16_4.Y VPWR.t20 sg13_lv_pmos ad=0.2128p pd=1.5u as=0.2128p ps=1.5u w=1.12u l=0.13u
X455 sg13cmos5l_inv_16_27.A sg13cmos5l_inv_16_24.A VPWR.t120 VPWR.t18 sg13_lv_pmos ad=0.2128p pd=1.5u as=0.2128p ps=1.5u w=1.12u l=0.13u
X456 sg13cmos5l_inv_16_9.A sg13cmos5l_inv_16_13.A VGND.t172 VGND.t181 sg13_lv_nmos ad=0.1406p pd=1.12u as=0.1406p ps=1.12u w=0.74u l=0.13u
X457 sg13cmos5l_inv_16_2.A sg13cmos5l_inv_16_0.A VPWR.t96 VPWR.t0 sg13_lv_pmos ad=0.2128p pd=1.5u as=0.2128p ps=1.5u w=1.12u l=0.13u
X458 VGND.t172 sg13cmos5l_inv_16_9.Y sg13cmos5l_inv_16_11.Y VGND.t174 sg13_lv_nmos ad=0.1406p pd=1.12u as=0.1406p ps=1.12u w=0.74u l=0.13u
X459 sg13cmos5l_xnor2_1_3.Y sg13cmos5l_xnor2_1_3.B a_24819_1168# VPWR.t0 sg13_lv_pmos ad=0.2408p pd=1.55u as=0.1428p ps=1.375u w=1.12u l=0.13u
X460 sg13cmos5l_inv_4_6.Y sg13cmos5l_inv_2_7.Y VGND.t121 VGND.t126 sg13_lv_nmos ad=0.1406p pd=1.12u as=0.1406p ps=1.12u w=0.74u l=0.13u
X461 sg13cmos5l_inv_16_5.Y sg13cmos5l_inv_16_5.A VGND.t303 VGND.t870 sg13_lv_nmos ad=0.1406p pd=1.12u as=0.1406p ps=1.12u w=0.74u l=0.13u
X462 sg13cmos5l_inv_16_3.Y sg13cmos5l_inv_16_5.Y VPWR.t313 VPWR.t0 sg13_lv_pmos ad=0.2128p pd=1.5u as=0.2128p ps=1.5u w=1.12u l=0.13u
X463 VPWR.t166 sg13cmos5l_inv_16_9.A sg13cmos5l_inv_16_9.Y VPWR.t20 sg13_lv_pmos ad=0.2128p pd=1.5u as=0.2128p ps=1.5u w=1.12u l=0.13u
X464 VGND.t384 VPWR.t144 VGND.t384 VGND.t385 sg13_lv_nmos ad=79.8f pd=0.8u as=0 ps=0 w=0.42u l=1u
X465 VGND.t303 sg13cmos5l_inv_16_5.A sg13cmos5l_inv_16_5.Y VGND.t865 sg13_lv_nmos ad=0.1406p pd=1.12u as=0.1406p ps=1.12u w=0.74u l=0.13u
X466 VPWR.t96 sg13cmos5l_inv_16_0.A sg13cmos5l_inv_16_2.A VPWR.t0 sg13_lv_pmos ad=0.2128p pd=1.5u as=0.2128p ps=1.5u w=1.12u l=0.13u
X467 sg13cmos5l_inv_16_21.Y sg13cmos5l_inv_16_21.A VGND.t390 VGND.t697 sg13_lv_nmos ad=0.1406p pd=1.12u as=0.1406p ps=1.12u w=0.74u l=0.13u
X468 a_5120_4097# sg13cmos5l_buf_1_1.X a_5257_3940# VGND.t262 sg13_lv_nmos ad=0.2176p pd=1.96u as=0.1216p ps=1.02u w=0.64u l=0.13u
X469 sg13cmos5l_inv_4_4.A sg13cmos5l_inv_2_5.A VGND.t390 VGND.t562 sg13_lv_nmos ad=0.1406p pd=1.12u as=0.2516p ps=2.16u w=0.74u l=0.13u
X470 sg13cmos5l_inv_16_10.A sg13cmos5l_inv_16_7.A VPWR.t366 VPWR.t0 sg13_lv_pmos ad=0.2128p pd=1.5u as=0.2128p ps=1.5u w=1.12u l=0.13u
X471 sg13cmos5l_inv_16_1.Y sg13cmos5l_inv_16_1.A VPWR.t234 VPWR.t20 sg13_lv_pmos ad=0.2128p pd=1.5u as=0.2128p ps=1.5u w=1.12u l=0.13u
X472 sg13cmos5l_inv_16_5.A sg13cmos5l_inv_16_30.A VPWR.t46 VPWR.t0 sg13_lv_pmos ad=0.2128p pd=1.5u as=0.2128p ps=1.5u w=1.12u l=0.13u
X473 VPWR.t396 sg13cmos5l_inv_16_22.A sg13cmos5l_inv_16_21.A VPWR.t0 sg13_lv_pmos ad=0.2128p pd=1.5u as=0.2128p ps=1.5u w=1.12u l=0.13u
X474 sg13cmos5l_inv_16_9.Y sg13cmos5l_inv_16_9.A VPWR.t162 VPWR.t20 sg13_lv_pmos ad=0.2128p pd=1.5u as=0.2128p ps=1.5u w=1.12u l=0.13u
X475 VGND.t712 sg13cmos5l_inv_16_22.A sg13cmos5l_inv_16_21.A VGND.t727 sg13_lv_nmos ad=0.2516p pd=2.16u as=0.1406p ps=1.12u w=0.74u l=0.13u
X476 VGND.t361 sg13cmos5l_inv_16_9.A sg13cmos5l_inv_16_9.Y VGND.t531 sg13_lv_nmos ad=0.2516p pd=2.16u as=0.1406p ps=1.12u w=0.74u l=0.13u
X477 VPWR.t19 a_6284_3858# sg13cmos5l_and2_1_1.B VPWR.t18 sg13_lv_pmos ad=0.2114p pd=1.54u as=0.42p ps=2.99u w=1.12u l=0.13u
X478 VPWR.t366 sg13cmos5l_inv_16_7.A sg13cmos5l_inv_16_10.A VPWR.t0 sg13_lv_pmos ad=0.2128p pd=1.5u as=0.2128p ps=1.5u w=1.12u l=0.13u
X479 VPWR.t46 sg13cmos5l_inv_16_30.A sg13cmos5l_inv_16_5.A VPWR.t0 sg13_lv_pmos ad=0.2128p pd=1.5u as=0.2128p ps=1.5u w=1.12u l=0.13u
X480 VPWR.t58 a_14240_4097# sg13cmos5l_inv_1_2.A VPWR.t18 sg13_lv_pmos ad=0.1918p pd=1.5u as=0.3808p ps=2.92u w=1.12u l=0.13u
X481 VPWR.t262 VGND.t269 VPWR.t262 VPWR.t18 sg13_lv_pmos ad=0.34p pd=2.68u as=0 ps=0 w=1u l=1u
X482 VPWR.t174 sg13cmos5l_inv_16_19.A sg13cmos5l_inv_16_22.A VPWR.t0 sg13_lv_pmos ad=0.2128p pd=1.5u as=0.2128p ps=1.5u w=1.12u l=0.13u
X483 VGND.t231 sg13cmos5l_inv_16_2.A sg13cmos5l_inv_16_16.A VGND.t294 sg13_lv_nmos ad=0.1406p pd=1.12u as=0.1406p ps=1.12u w=0.74u l=0.13u
X484 VGND.t303 sg13cmos5l_inv_4_0.A sg13cmos5l_inv_4_0.Y VGND.t515 sg13_lv_nmos ad=0.2516p pd=2.16u as=0.1406p ps=1.12u w=0.74u l=0.13u
X485 VGND.t133 sg13cmos5l_inv_16_5.Y sg13cmos5l_inv_16_3.Y VGND.t146 sg13_lv_nmos ad=0.1406p pd=1.12u as=0.1406p ps=1.12u w=0.74u l=0.13u
X486 sg13cmos5l_xnor2_1_1.Y a_26880_1671# a_27029_2002# VGND.t755 sg13_lv_nmos ad=0.2516p pd=2.16u as=0.1406p ps=1.12u w=0.74u l=0.13u
X487 VGND.t66 a_14240_4097# sg13cmos5l_inv_1_2.A VGND.t808 sg13_lv_nmos ad=0.1331p pd=1.12u as=0.2516p ps=2.16u w=0.74u l=0.13u
X488 sg13cmos5l_inv_16_19.A sg13cmos5l_inv_16_28.A VGND.t585 VGND.t589 sg13_lv_nmos ad=0.1406p pd=1.12u as=0.1406p ps=1.12u w=0.74u l=0.13u
X489 VGND.t45 sg13cmos5l_inv_16_30.A sg13cmos5l_inv_16_5.A VGND.t54 sg13_lv_nmos ad=0.1406p pd=1.12u as=0.1406p ps=1.12u w=0.74u l=0.13u
X490 VGND.t172 sg13cmos5l_inv_16_13.A sg13cmos5l_inv_16_9.A VGND.t174 sg13_lv_nmos ad=0.1406p pd=1.12u as=0.1406p ps=1.12u w=0.74u l=0.13u
X491 sg13cmos5l_inv_16_29.A sg13cmos5l_inv_16_31.A VGND.t384 VGND.t634 sg13_lv_nmos ad=0.1406p pd=1.12u as=0.1406p ps=1.12u w=0.74u l=0.13u
X492 VPWR.t58 sg13cmos5l_and2_1_7.A a_14240_4097# VPWR.t18 sg13_lv_pmos ad=0.2856p pd=2.36u as=0.1596p ps=1.22u w=0.84u l=0.13u
X493 VGND.t366 VPWR.t1 VGND.t365 VGND.t412 sg13_lv_nmos ad=0.1428p pd=1.52u as=0 ps=0 w=0.42u l=1u
X494 VPWR.t106 sg13cmos5l_inv_4_6.Y sg13cmos5l_inv_16_24.A VPWR.t18 sg13_lv_pmos ad=0.2128p pd=1.5u as=0.2184p ps=1.51u w=1.12u l=0.13u
X495 sg13cmos5l_inv_16_5.A sg13cmos5l_inv_16_30.A VGND.t45 VGND.t49 sg13_lv_nmos ad=0.1406p pd=1.12u as=0.1406p ps=1.12u w=0.74u l=0.13u
X496 sg13cmos5l_xnor2_1_6.A sg13cmos5l_inv_4_8.A VGND.t121 VGND.t651 sg13_lv_nmos ad=0.1406p pd=1.12u as=0.1406p ps=1.12u w=0.74u l=0.13u
X497 VPWR.t42 sg13cmos5l_inv_16_29.A sg13cmos5l_inv_16_29.Y VPWR.t0 sg13_lv_pmos ad=0.2128p pd=1.5u as=0.2128p ps=1.5u w=1.12u l=0.13u
X498 sg13cmos5l_inv_16_18.A sg13cmos5l_inv_16_16.A VGND.t41 VGND.t103 sg13_lv_nmos ad=0.1406p pd=1.12u as=0.1406p ps=1.12u w=0.74u l=0.13u
X499 sg13cmos5l_inv_16_9.Y sg13cmos5l_inv_16_9.A VPWR.t158 VPWR.t20 sg13_lv_pmos ad=0.2128p pd=1.5u as=0.2128p ps=1.5u w=1.12u l=0.13u
X500 VGND.t20 sg13cmos5l_inv_4_1.Y sg13cmos5l_inv_16_12.A VGND.t538 sg13_lv_nmos ad=0.1406p pd=1.12u as=0.1406p ps=1.12u w=0.74u l=0.13u
X501 VGND.t123 VPWR.t116 VGND.t123 VGND.t450 sg13_lv_nmos ad=0.1428p pd=1.52u as=0 ps=0 w=0.42u l=1u
X502 VPWR.t146 VGND.t384 VPWR.t144 VPWR.t20 sg13_lv_pmos ad=0.19p pd=1.38u as=0 ps=0 w=1u l=1u
X503 sg13cmos5l_inv_16_21.Y sg13cmos5l_inv_16_21.A VPWR.t586 VPWR.t0 sg13_lv_pmos ad=0.2128p pd=1.5u as=0.2128p ps=1.5u w=1.12u l=0.13u
X504 VPWR.t446 sg13cmos5l_inv_16_8.A sg13cmos5l_inv_16_7.A VPWR.t0 sg13_lv_pmos ad=0.4368p pd=3.02u as=0.2128p ps=1.5u w=1.12u l=0.13u
X505 VPWR.t174 sg13cmos5l_inv_16_28.A sg13cmos5l_inv_16_19.A VPWR.t0 sg13_lv_pmos ad=0.2128p pd=1.5u as=0.2128p ps=1.5u w=1.12u l=0.13u
X506 VGND.t361 sg13cmos5l_inv_16_7.A sg13cmos5l_inv_16_10.A VGND.t531 sg13_lv_nmos ad=0.2516p pd=2.16u as=0.1406p ps=1.12u w=0.74u l=0.13u
X507 VPWR.t226 sg13cmos5l_inv_16_1.A sg13cmos5l_inv_16_1.Y VPWR.t20 sg13_lv_pmos ad=0.2128p pd=1.5u as=0.2128p ps=1.5u w=1.12u l=0.13u
X508 sg13cmos5l_inv_16_25.Y sg13cmos5l_inv_16_23.Y VGND.t32 VGND.t502 sg13_lv_nmos ad=0.1406p pd=1.12u as=0.1406p ps=1.12u w=0.74u l=0.13u
X509 VGND.t307 en[0] a_2920_3932# VGND.t306 sg13_lv_nmos ad=0.14875p pd=1.16u as=0.187p ps=1.78u w=0.55u l=0.13u
X510 sg13cmos5l_inv_16_29.Y sg13cmos5l_inv_16_29.A VPWR.t41 VPWR.t0 sg13_lv_pmos ad=0.2128p pd=1.5u as=0.2128p ps=1.5u w=1.12u l=0.13u
X511 VGND.t41 sg13cmos5l_inv_16_16.A sg13cmos5l_inv_16_18.A VGND.t100 sg13_lv_nmos ad=0.1406p pd=1.12u as=0.1406p ps=1.12u w=0.74u l=0.13u
X512 VPWR.t1 sg13cmos5l_inv_16_6.A sg13cmos5l_inv_16_8.A VPWR.t0 sg13_lv_pmos ad=0.2128p pd=1.5u as=0.2128p ps=1.5u w=1.12u l=0.13u
X513 VPWR.t569 sg13cmos5l_inv_4_7.A sg13cmos5l_inv_8_7.A VPWR.t20 sg13_lv_pmos ad=0.3808p pd=2.92u as=0.2128p ps=1.5u w=1.12u l=0.13u
X514 VPWR.t586 sg13cmos5l_inv_16_21.A sg13cmos5l_inv_16_21.Y VPWR.t0 sg13_lv_pmos ad=0.2128p pd=1.5u as=0.2128p ps=1.5u w=1.12u l=0.13u
X515 sg13cmos5l_inv_16_24.A sg13cmos5l_inv_4_6.Y VPWR.t106 VPWR.t18 sg13_lv_pmos ad=0.2184p pd=1.51u as=0.3808p ps=2.92u w=1.12u l=0.13u
X516 a_9932_3858# en[2] VGND.t117 VGND.t128 sg13_lv_nmos ad=0.187p pd=1.78u as=0.14875p ps=1.16u w=0.55u l=0.13u
X517 VGND.t32 sg13cmos5l_inv_16_23.Y sg13cmos5l_inv_16_25.Y VGND.t499 sg13_lv_nmos ad=0.1406p pd=1.12u as=0.1406p ps=1.12u w=0.74u l=0.13u
X518 VGND.t235 sg13cmos5l_inv_16_1.Y sg13cmos5l_inv_16_17.Y VGND.t833 sg13_lv_nmos ad=0.1406p pd=1.12u as=0.1406p ps=1.12u w=0.74u l=0.13u
X519 sg13cmos5l_inv_8_6.A sg13cmos5l_inv_4_5.A VGND.t69 VGND.t239 sg13_lv_nmos ad=0.1406p pd=1.12u as=0.1406p ps=1.12u w=0.74u l=0.13u
X520 sg13cmos5l_inv_8_7.A sg13cmos5l_inv_4_7.A VPWR.t538 VPWR.t20 sg13_lv_pmos ad=0.2128p pd=1.5u as=0.3808p ps=2.92u w=1.12u l=0.13u
X521 VPWR.t481 a_24730_2350# a_24449_2572# VPWR.t20 sg13_lv_pmos ad=0.1523p pd=1.38u as=0.34p ps=2.68u w=1u l=0.5u
X522 a_28020_1980# sg13cmos5l_xnor2_1_2.B a_27564_1898# VGND.t30 sg13_lv_nmos ad=78.39999f pd=0.885u as=0.2176p ps=1.96u w=0.64u l=0.13u
X523 a_28160_4097# sg13cmos5l_and2_1_6.B VPWR.t106 VPWR.t18 sg13_lv_pmos ad=0.1596p pd=1.22u as=0.1918p ps=1.5u w=0.84u l=0.13u
X524 VGND.t82 sg13cmos5l_inv_16_20.A sg13cmos5l_inv_16_30.A VGND.t86 sg13_lv_nmos ad=0.1406p pd=1.12u as=0.1406p ps=1.12u w=0.74u l=0.13u
X525 VPWR.t24 sg13cmos5l_dlygate4sd3_1_4.X a_27564_1898# VPWR.t0 sg13_lv_pmos ad=0.4536p pd=2.76u as=0.1596p ps=1.22u w=0.84u l=0.13u
X526 sg13cmos5l_inv_16_17.Y sg13cmos5l_inv_16_1.Y VGND.t235 VGND.t830 sg13_lv_nmos ad=0.1406p pd=1.12u as=0.1406p ps=1.12u w=0.74u l=0.13u
X527 VPWR.t516 sg13cmos5l_xnor2_1_5.Y a_26991_3108# VPWR.t20 sg13_lv_pmos ad=0.2856p pd=2.36u as=0.1596p ps=1.22u w=0.84u l=0.13u
X528 sg13cmos5l_xnor2_1_3.B a_24630_1656# VPWR.t17 VPWR.t0 sg13_lv_pmos ad=0.4256p pd=3u as=0.2254p ps=1.53u w=1.12u l=0.13u
X529 VGND.t24 sg13cmos5l_xnor2_1_3.A a_24248_1673# VGND.t774 sg13_lv_nmos ad=79.8f pd=0.8u as=0.1428p ps=1.52u w=0.42u l=0.13u
X530 VPWR.t78 sg13cmos5l_inv_16_21.A sg13cmos5l_inv_16_21.Y VPWR.t0 sg13_lv_pmos ad=0.2128p pd=1.5u as=0.2128p ps=1.5u w=1.12u l=0.13u
X531 sg13cmos5l_inv_16_30.A sg13cmos5l_inv_16_20.A VGND.t82 VGND.t83 sg13_lv_nmos ad=0.1406p pd=1.12u as=0.1406p ps=1.12u w=0.74u l=0.13u
X532 sg13cmos5l_inv_16_21.A sg13cmos5l_inv_16_22.A VPWR.t396 VPWR.t0 sg13_lv_pmos ad=0.2128p pd=1.5u as=0.2128p ps=1.5u w=1.12u l=0.13u
X533 VGND.t7 sg13cmos5l_inv_4_2.Y sg13cmos5l_inv_16_6.A VGND.t34 sg13_lv_nmos ad=0.1406p pd=1.12u as=0.1406p ps=1.12u w=0.74u l=0.13u
X534 VGND.t235 sg13cmos5l_inv_16_1.Y sg13cmos5l_inv_16_17.Y VGND.t827 sg13_lv_nmos ad=0.1406p pd=1.12u as=0.1406p ps=1.12u w=0.74u l=0.13u
X535 VGND.t119 a_25306_3108# a_25025_3410# VGND.t803 sg13_lv_nmos ad=79.8f pd=0.8u as=0.1428p ps=1.52u w=0.42u l=0.5u
X536 VPWR.t104 a_9932_3858# sg13cmos5l_and2_1_3.B VPWR.t18 sg13_lv_pmos ad=0.2114p pd=1.54u as=0.42p ps=2.99u w=1.12u l=0.13u
X537 VPWR.t386 VGND.t331 VPWR.t386 VPWR.t20 sg13_lv_pmos ad=0.34p pd=2.68u as=0 ps=0 w=1u l=1u
X538 sg13cmos5l_inv_16_13.A sg13cmos5l_inv_16_12.A VGND.t312 VGND.t891 sg13_lv_nmos ad=0.1406p pd=1.12u as=0.1406p ps=1.12u w=0.74u l=0.13u
X539 sg13cmos5l_inv_16_31.A sg13cmos5l_inv_16_26.A VGND.t69 VGND.t764 sg13_lv_nmos ad=0.1406p pd=1.12u as=0.1406p ps=1.12u w=0.74u l=0.13u
X540 VPWR.t156 VGND.t32 VPWR.t649 VPWR.t18 sg13_lv_pmos ad=0.34p pd=2.68u as=0 ps=0 w=1u l=1u
X541 VPWR.t366 sg13cmos5l_inv_16_7.A sg13cmos5l_inv_16_10.A VPWR.t0 sg13_lv_pmos ad=0.2128p pd=1.5u as=0.2128p ps=1.5u w=1.12u l=0.13u
X542 sg13cmos5l_inv_16_18.Y sg13cmos5l_inv_16_18.A VGND.t231 VGND.t232 sg13_lv_nmos ad=0.1406p pd=1.12u as=0.1406p ps=1.12u w=0.74u l=0.13u
X543 VPWR.t396 sg13cmos5l_inv_16_22.A sg13cmos5l_inv_16_21.A VPWR.t0 sg13_lv_pmos ad=0.2128p pd=1.5u as=0.2128p ps=1.5u w=1.12u l=0.13u
X544 VGND.t7 sg13cmos5l_inv_16_6.A sg13cmos5l_inv_16_8.A VGND.t13 sg13_lv_nmos ad=0.1406p pd=1.12u as=0.1406p ps=1.12u w=0.74u l=0.13u
X545 VPWR.t128 sg13cmos5l_inv_16_15.A sg13cmos5l_inv_16_14.A VPWR.t20 sg13_lv_pmos ad=0.2128p pd=1.5u as=0.2128p ps=1.5u w=1.12u l=0.13u
X546 VGND.t64 a_26822_874# a_26934_938# VGND.t456 sg13_lv_nmos ad=0.1426p pd=1.16u as=0.1428p ps=1.52u w=0.42u l=0.5u
X547 sg13cmos5l_inv_16_23.Y sg13cmos5l_inv_16_23.A VPWR.t530 VPWR.t20 sg13_lv_pmos ad=0.2128p pd=1.5u as=0.2128p ps=1.5u w=1.12u l=0.13u
X548 VPWR.t144 VGND.t66 VPWR.t143 VPWR.t20 sg13_lv_pmos ad=0.34p pd=2.68u as=0 ps=0 w=1u l=1u
X549 VGND.t69 sg13cmos5l_inv_16_26.A sg13cmos5l_inv_16_31.A VGND.t761 sg13_lv_nmos ad=0.1406p pd=1.12u as=0.1406p ps=1.12u w=0.74u l=0.13u
X550 VPWR.t87 sg13cmos5l_inv_16_16.A sg13cmos5l_inv_16_18.A VPWR.t0 sg13_lv_pmos ad=0.2128p pd=1.5u as=0.2128p ps=1.5u w=1.12u l=0.13u
X551 sg13cmos5l_inv_16_1.A sg13cmos5l_inv_16_14.A VPWR.t631 VPWR.t20 sg13_lv_pmos ad=0.2128p pd=1.5u as=0.2128p ps=1.5u w=1.12u l=0.13u
X552 a_9357_3940# sg13cmos5l_and2_1_7.A VPWR.t104 VPWR.t18 sg13_lv_pmos ad=0.1596p pd=1.22u as=0.2856p ps=2.36u w=0.84u l=0.13u
X553 VGND.t339 VPWR.t564 VGND.t359 VGND.t358 sg13_lv_nmos ad=79.8f pd=0.8u as=0 ps=0 w=0.42u l=1u
X554 sg13cmos5l_inv_16_27.A sg13cmos5l_inv_16_24.A VGND.t119 VGND.t798 sg13_lv_nmos ad=0.1406p pd=1.12u as=0.1406p ps=1.12u w=0.74u l=0.13u
X555 sg13cmos5l_inv_16_8.A sg13cmos5l_inv_16_6.A VGND.t7 VGND.t10 sg13_lv_nmos ad=0.1406p pd=1.12u as=0.1406p ps=1.12u w=0.74u l=0.13u
X556 sg13cmos5l_inv_16_23.A sg13cmos5l_inv_16_27.A VGND.t269 VGND.t275 sg13_lv_nmos ad=0.1406p pd=1.12u as=0.1406p ps=1.12u w=0.74u l=0.13u
X557 VPWR.t313 sg13cmos5l_inv_16_5.Y sg13cmos5l_inv_16_3.Y VPWR.t0 sg13_lv_pmos ad=0.4368p pd=3.02u as=0.2128p ps=1.5u w=1.12u l=0.13u
X558 sg13cmos5l_inv_16_23.Y sg13cmos5l_inv_16_23.A VGND.t190 VGND.t665 sg13_lv_nmos ad=0.1406p pd=1.12u as=0.1406p ps=1.12u w=0.74u l=0.13u
X559 sg13cmos5l_inv_16_13.A sg13cmos5l_inv_16_12.A VGND.t312 VGND.t887 sg13_lv_nmos ad=0.1406p pd=1.12u as=0.1406p ps=1.12u w=0.74u l=0.13u
X560 VGND.t69 en[4] a_16264_3932# VGND.t863 sg13_lv_nmos ad=0.14875p pd=1.16u as=0.187p ps=1.78u w=0.55u l=0.13u
X561 VPWR.t134 sg13cmos5l_inv_16_29.Y sg13cmos5l_inv_16_4.Y VPWR.t20 sg13_lv_pmos ad=0.2128p pd=1.5u as=0.2128p ps=1.5u w=1.12u l=0.13u
X562 VPWR.t234 sg13cmos5l_inv_16_14.A sg13cmos5l_inv_16_1.A VPWR.t20 sg13_lv_pmos ad=0.2128p pd=1.5u as=0.2128p ps=1.5u w=1.12u l=0.13u
X563 VGND.t20 sg13cmos5l_and2_1_1.B a_5803_3940# VGND.t129 sg13_lv_nmos ad=0.1331p pd=1.12u as=0.1216p ps=1.02u w=0.64u l=0.13u
X564 VPWR.t36 VGND.t363 VPWR.t36 VPWR.t0 sg13_lv_pmos ad=0.19p pd=1.38u as=0 ps=0 w=1u l=1u
X565 VGND.t872 sg13cmos5l_inv_16_5.A sg13cmos5l_inv_16_5.Y VGND.t871 sg13_lv_nmos ad=0.1406p pd=1.12u as=0.1406p ps=1.12u w=0.74u l=0.13u
X566 VGND.t119 sg13cmos5l_inv_16_24.A sg13cmos5l_inv_16_27.A VGND.t795 sg13_lv_nmos ad=0.1406p pd=1.12u as=0.1406p ps=1.12u w=0.74u l=0.13u
X567 VGND.t269 sg13cmos5l_inv_16_27.A sg13cmos5l_inv_16_23.A VGND.t272 sg13_lv_nmos ad=0.1406p pd=1.12u as=0.1406p ps=1.12u w=0.74u l=0.13u
X568 VPWR.t124 sg13cmos5l_inv_16_15.A sg13cmos5l_inv_16_14.A VPWR.t20 sg13_lv_pmos ad=0.2128p pd=1.5u as=0.2128p ps=1.5u w=1.12u l=0.13u
X569 VPWR.t78 sg13cmos5l_inv_16_20.A sg13cmos5l_inv_16_30.A VPWR.t0 sg13_lv_pmos ad=0.2128p pd=1.5u as=0.2128p ps=1.5u w=1.12u l=0.13u
X570 a_26843_2428# sg13cmos5l_xnor2_1_4.Y VGND.t27 VGND.t566 sg13_lv_nmos ad=78.39999f pd=0.885u as=0.2272p ps=1.99u w=0.64u l=0.13u
X571 a_24518_1632# a_24248_1673# VPWR.t17 VPWR.t0 sg13_lv_pmos ad=0.34p pd=2.68u as=0.1523p ps=1.38u w=1u l=0.5u
X572 sg13cmos5l_inv_16_3.Y sg13cmos5l_inv_16_5.Y VPWR.t313 VPWR.t0 sg13_lv_pmos ad=0.2128p pd=1.5u as=0.2128p ps=1.5u w=1.12u l=0.13u
X573 VGND.t190 sg13cmos5l_inv_16_23.A sg13cmos5l_inv_16_23.Y VGND.t662 sg13_lv_nmos ad=0.1406p pd=1.12u as=0.1406p ps=1.12u w=0.74u l=0.13u
X574 VPWR.t423 a_25248_2697# sg13cmos5l_xnor2_1_6.Y VPWR.t20 sg13_lv_pmos ad=0.3808p pd=2.92u as=0.2408p ps=1.55u w=1.12u l=0.13u
X575 sg13cmos5l_inv_16_23.Y sg13cmos5l_inv_16_23.A VPWR.t356 VPWR.t20 sg13_lv_pmos ad=0.2128p pd=1.5u as=0.2128p ps=1.5u w=1.12u l=0.13u
X576 sg13cmos5l_inv_16_1.A sg13cmos5l_inv_16_14.A VPWR.t625 VPWR.t20 sg13_lv_pmos ad=0.2128p pd=1.5u as=0.2128p ps=1.5u w=1.12u l=0.13u
X577 VPWR.t520 sg13cmos5l_inv_16_12.A sg13cmos5l_inv_16_13.A VPWR.t20 sg13_lv_pmos ad=0.2128p pd=1.5u as=0.2128p ps=1.5u w=1.12u l=0.13u
X578 sg13cmos5l_inv_16_11.Y sg13cmos5l_inv_16_9.Y VGND.t172 VGND.t183 sg13_lv_nmos ad=0.1406p pd=1.12u as=0.1406p ps=1.12u w=0.74u l=0.13u
X579 sg13cmos5l_inv_16_30.A sg13cmos5l_inv_16_20.A VPWR.t46 VPWR.t0 sg13_lv_pmos ad=0.2128p pd=1.5u as=0.2128p ps=1.5u w=1.12u l=0.13u
X580 VGND.t7 sg13cmos5l_inv_2_1.A sg13cmos5l_inv_4_2.A VGND.t309 sg13_lv_nmos ad=0.2516p pd=2.16u as=0.1406p ps=1.12u w=0.74u l=0.13u
X581 VGND.t7 VPWR.t522 VGND.t7 VGND.t370 sg13_lv_nmos ad=0.1428p pd=1.52u as=0 ps=0 w=0.42u l=1u
X582 VGND.t29 VPWR.t516 VGND.t404 VGND.t403 sg13_lv_nmos ad=79.8f pd=0.8u as=0 ps=0 w=0.42u l=1u
X583 VPWR.t24 VGND.t404 VPWR.t24 VPWR.t0 sg13_lv_pmos ad=0.34p pd=2.68u as=0 ps=0 w=1u l=1u
X584 sg13cmos5l_inv_4_4.A sg13cmos5l_inv_2_5.A VPWR.t386 VPWR.t20 sg13_lv_pmos ad=0.2128p pd=1.5u as=0.3864p ps=2.93u w=1.12u l=0.13u
X585 sg13cmos5l_inv_16_16.A sg13cmos5l_inv_16_2.A VGND.t231 VGND.t295 sg13_lv_nmos ad=0.1406p pd=1.12u as=0.1406p ps=1.12u w=0.74u l=0.13u
X586 VPWR.t172 sg13cmos5l_inv_16_9.A sg13cmos5l_inv_16_9.Y VPWR.t20 sg13_lv_pmos ad=0.4368p pd=3.02u as=0.2128p ps=1.5u w=1.12u l=0.13u
X587 sg13cmos5l_inv_16_8.A sg13cmos5l_inv_16_6.A VGND.t1 VGND.t5 sg13_lv_nmos ad=0.1406p pd=1.12u as=0.1406p ps=1.12u w=0.74u l=0.13u
X588 VGND.t249 sg13cmos5l_inv_16_0.A sg13cmos5l_inv_16_2.A VGND.t616 sg13_lv_nmos ad=0.2516p pd=2.16u as=0.1406p ps=1.12u w=0.74u l=0.13u
X589 sg13cmos5l_inv_16_10.A sg13cmos5l_inv_16_7.A VPWR.t36 VPWR.t0 sg13_lv_pmos ad=0.2128p pd=1.5u as=0.2128p ps=1.5u w=1.12u l=0.13u
X590 sg13cmos5l_inv_16_18.A sg13cmos5l_inv_16_16.A VPWR.t87 VPWR.t0 sg13_lv_pmos ad=0.2128p pd=1.5u as=0.3808p ps=2.92u w=1.12u l=0.13u
X591 VGND.t62 sg13cmos5l_inv_16_30.A sg13cmos5l_inv_16_5.A VGND.t61 sg13_lv_nmos ad=0.2516p pd=2.16u as=0.1406p ps=1.12u w=0.74u l=0.13u
X592 VPWR.t313 sg13cmos5l_inv_16_5.A sg13cmos5l_inv_16_5.Y VPWR.t0 sg13_lv_pmos ad=0.2128p pd=1.5u as=0.2128p ps=1.5u w=1.12u l=0.13u
X593 VGND.t585 sg13cmos5l_inv_16_28.A sg13cmos5l_inv_16_19.A VGND.t590 sg13_lv_nmos ad=0.1406p pd=1.12u as=0.1406p ps=1.12u w=0.74u l=0.13u
X594 sg13cmos5l_inv_16_25.Y sg13cmos5l_inv_16_23.Y VPWR.t358 VPWR.t20 sg13_lv_pmos ad=0.2128p pd=1.5u as=0.2128p ps=1.5u w=1.12u l=0.13u
X595 sg13cmos5l_inv_16_5.A sg13cmos5l_inv_16_30.A VGND.t45 VGND.t55 sg13_lv_nmos ad=0.1406p pd=1.12u as=0.1406p ps=1.12u w=0.74u l=0.13u
X596 VGND.t432 VPWR.t41 VGND.t45 VGND.t434 sg13_lv_nmos ad=79.8f pd=0.8u as=0 ps=0 w=0.42u l=1u
X597 VPWR.t46 sg13cmos5l_inv_16_30.A sg13cmos5l_inv_16_5.A VPWR.t0 sg13_lv_pmos ad=0.4368p pd=3.02u as=0.2128p ps=1.5u w=1.12u l=0.13u
X598 sg13cmos5l_inv_16_19.A sg13cmos5l_inv_16_28.A VGND.t585 VGND.t584 sg13_lv_nmos ad=0.1406p pd=1.12u as=0.2516p ps=2.16u w=0.74u l=0.13u
X599 VPWR.t366 sg13cmos5l_inv_16_7.A sg13cmos5l_inv_16_10.A VPWR.t0 sg13_lv_pmos ad=0.2128p pd=1.5u as=0.2128p ps=1.5u w=1.12u l=0.13u
X600 VPWR.t312 sg13cmos5l_inv_1_7.A sg13cmos5l_inv_4_8.A VPWR.t20 sg13_lv_pmos ad=0.3808p pd=2.92u as=0.3808p ps=2.92u w=1.12u l=0.13u
X601 VGND.t339 VPWR.t564 VGND.t119 VGND.t357 sg13_lv_nmos ad=0.1428p pd=1.52u as=0 ps=0 w=0.42u l=1u
X602 VPWR.t356 sg13cmos5l_inv_16_23.Y sg13cmos5l_inv_16_25.Y VPWR.t20 sg13_lv_pmos ad=0.2128p pd=1.5u as=0.2128p ps=1.5u w=1.12u l=0.13u
X603 VPWR.t538 VGND.t269 VPWR.t538 VPWR.t20 sg13_lv_pmos ad=0.19p pd=1.38u as=0 ps=0 w=1u l=1u
X604 sg13cmos5l_inv_16_30.A sg13cmos5l_inv_16_20.A VPWR.t46 VPWR.t0 sg13_lv_pmos ad=0.2128p pd=1.5u as=0.2128p ps=1.5u w=1.12u l=0.13u
X605 sg13cmos5l_inv_16_25.Y sg13cmos5l_inv_16_23.Y VPWR.t352 VPWR.t20 sg13_lv_pmos ad=0.2128p pd=1.5u as=0.2128p ps=1.5u w=1.12u l=0.13u
X606 sg13cmos5l_inv_16_9.A sg13cmos5l_inv_16_13.A VGND.t172 VGND.t183 sg13_lv_nmos ad=0.1406p pd=1.12u as=0.1406p ps=1.12u w=0.74u l=0.13u
X607 a_26822_874# a_26552_874# VPWR.t24 VPWR.t0 sg13_lv_pmos ad=0.34p pd=2.68u as=0.1523p ps=1.38u w=1u l=0.5u
X608 sg13cmos5l_inv_16_29.A sg13cmos5l_inv_16_31.A VPWR.t419 VPWR.t20 sg13_lv_pmos ad=0.2128p pd=1.5u as=0.2128p ps=1.5u w=1.12u l=0.13u
X609 VGND.t80 sg13cmos5l_inv_16_31.A sg13cmos5l_inv_16_29.A VGND.t643 sg13_lv_nmos ad=0.1406p pd=1.12u as=0.1406p ps=1.12u w=0.74u l=0.13u
X610 sg13cmos5l_inv_16_6.A sg13cmos5l_inv_4_2.Y VPWR.t14 VPWR.t0 sg13_lv_pmos ad=0.2128p pd=1.5u as=0.3808p ps=2.92u w=1.12u l=0.13u
X611 sg13cmos5l_inv_16_11.Y sg13cmos5l_inv_16_9.Y VPWR.t182 VPWR.t18 sg13_lv_pmos ad=0.2128p pd=1.5u as=0.2128p ps=1.5u w=1.12u l=0.13u
X612 VGND.t404 VPWR.t312 VGND.t407 VGND.t406 sg13_lv_nmos ad=79.8f pd=0.8u as=0 ps=0 w=0.42u l=1u
X613 a_19616_4097# sg13cmos5l_and2_1_7.A a_19753_3940# VGND.t628 sg13_lv_nmos ad=0.2176p pd=1.96u as=0.1216p ps=1.02u w=0.64u l=0.13u
X614 VPWR.t521 VGND.t7 VPWR.t522 VPWR.t20 sg13_lv_pmos ad=0.34p pd=2.68u as=0 ps=0 w=1u l=1u
X615 VPWR.t868 VGND.t404 VPWR.t516 VPWR.t20 sg13_lv_pmos ad=0.19p pd=1.38u as=0 ps=0 w=1u l=1u
X616 VPWR.t198 VGND.t440 VPWR.t181 VPWR.t0 sg13_lv_pmos ad=0.34p pd=2.68u as=0 ps=0 w=1u l=1u
X617 sg13cmos5l_inv_16_29.A sg13cmos5l_inv_16_31.A VGND.t417 VGND.t640 sg13_lv_nmos ad=0.1406p pd=1.12u as=0.1406p ps=1.12u w=0.74u l=0.13u
X618 VGND.t235 sg13cmos5l_inv_4_1.Y sg13cmos5l_inv_16_12.A VGND.t542 sg13_lv_nmos ad=0.2516p pd=2.16u as=0.1443p ps=1.13u w=0.74u l=0.13u
X619 VPWR.t166 sg13cmos5l_inv_16_13.A sg13cmos5l_inv_16_9.A VPWR.t20 sg13_lv_pmos ad=0.2128p pd=1.5u as=0.2128p ps=1.5u w=1.12u l=0.13u
X620 VPWR.t106 sg13cmos5l_inv_4_6.Y sg13cmos5l_inv_16_24.A VPWR.t18 sg13_lv_pmos ad=0.3808p pd=2.92u as=0.2128p ps=1.5u w=1.12u l=0.13u
X621 VPWR.t46 sg13cmos5l_inv_16_29.A sg13cmos5l_inv_16_29.Y VPWR.t0 sg13_lv_pmos ad=0.4368p pd=3.02u as=0.2128p ps=1.5u w=1.12u l=0.13u
X622 sg13cmos5l_inv_16_18.A sg13cmos5l_inv_16_16.A VGND.t41 VGND.t109 sg13_lv_nmos ad=0.1406p pd=1.12u as=0.1406p ps=1.12u w=0.74u l=0.13u
X623 sg13cmos5l_inv_16_8.A sg13cmos5l_inv_16_6.A VPWR.t1 VPWR.t0 sg13_lv_pmos ad=0.2128p pd=1.5u as=0.2128p ps=1.5u w=1.12u l=0.13u
X624 VGND.t45 sg13cmos5l_inv_16_30.A sg13cmos5l_inv_16_5.A VGND.t56 sg13_lv_nmos ad=0.1406p pd=1.12u as=0.1406p ps=1.12u w=0.74u l=0.13u
X625 VGND.t82 sg13cmos5l_inv_16_20.A sg13cmos5l_inv_16_30.A VGND.t96 sg13_lv_nmos ad=0.2516p pd=2.16u as=0.1406p ps=1.12u w=0.74u l=0.13u
X626 VPWR.t96 sg13cmos5l_inv_16_2.A sg13cmos5l_inv_16_16.A VPWR.t0 sg13_lv_pmos ad=0.2128p pd=1.5u as=0.2128p ps=1.5u w=1.12u l=0.13u
X627 sg13cmos5l_inv_16_9.A sg13cmos5l_inv_16_13.A VPWR.t162 VPWR.t20 sg13_lv_pmos ad=0.2128p pd=1.5u as=0.2128p ps=1.5u w=1.12u l=0.13u
X628 sg13cmos5l_inv_16_24.A sg13cmos5l_inv_4_6.Y VPWR.t106 VPWR.t18 sg13_lv_pmos ad=0.2128p pd=1.5u as=0.2128p ps=1.5u w=1.12u l=0.13u
X629 sg13cmos5l_inv_16_23.A sg13cmos5l_inv_16_27.A VPWR.t25 VPWR.t18 sg13_lv_pmos ad=0.2128p pd=1.5u as=0.3808p ps=2.92u w=1.12u l=0.13u
X630 VPWR.t1 sg13cmos5l_inv_16_6.A sg13cmos5l_inv_16_8.A VPWR.t0 sg13_lv_pmos ad=0.2128p pd=1.5u as=0.2128p ps=1.5u w=1.12u l=0.13u
X631 VPWR.t58 sg13cmos5l_inv_2_3.Y sg13cmos5l_inv_8_1.A VPWR.t18 sg13_lv_pmos ad=0.3808p pd=2.92u as=0.2128p ps=1.5u w=1.12u l=0.13u
X632 VPWR.t396 sg13cmos5l_inv_16_21.A sg13cmos5l_inv_16_21.Y VPWR.t0 sg13_lv_pmos ad=0.2128p pd=1.5u as=0.2128p ps=1.5u w=1.12u l=0.13u
X633 VGND.t390 sg13cmos5l_inv_4_4.A sg13cmos5l_inv_8_4.A VGND.t939 sg13_lv_nmos ad=0.2516p pd=2.16u as=0.1406p ps=1.12u w=0.74u l=0.13u
X634 VPWR.t685 sg13cmos5l_inv_16_24.A sg13cmos5l_inv_16_27.A VPWR.t18 sg13_lv_pmos ad=0.2128p pd=1.5u as=0.2128p ps=1.5u w=1.12u l=0.13u
X635 VGND.t133 sg13cmos5l_inv_16_29.Y sg13cmos5l_inv_16_4.Y VGND.t134 sg13_lv_nmos ad=0.1406p pd=1.12u as=0.1406p ps=1.12u w=0.74u l=0.13u
X636 VGND.t117 sg13cmos5l_inv_16_1.Y sg13cmos5l_inv_16_17.Y VGND.t839 sg13_lv_nmos ad=0.1406p pd=1.12u as=0.1406p ps=1.12u w=0.74u l=0.13u
X637 VGND.t231 sg13cmos5l_inv_16_18.A sg13cmos5l_inv_16_18.Y VGND.t233 sg13_lv_nmos ad=0.2516p pd=2.16u as=0.1406p ps=1.12u w=0.74u l=0.13u
X638 sg13cmos5l_dlygate4sd3_1_4.X a_26934_938# VPWR.t24 VPWR.t0 sg13_lv_pmos ad=0.4256p pd=3u as=0.2254p ps=1.53u w=1.12u l=0.13u
X639 VGND.t190 sg13cmos5l_inv_8_7.A sg13cmos5l_inv_16_28.A VGND.t191 sg13_lv_nmos ad=0.1406p pd=1.12u as=0.1443p ps=1.13u w=0.74u l=0.13u
X640 VGND.t117 sg13cmos5l_inv_16_14.A sg13cmos5l_inv_16_1.A VGND.t743 sg13_lv_nmos ad=0.1406p pd=1.12u as=0.1406p ps=1.12u w=0.74u l=0.13u
X641 sg13cmos5l_inv_8_4.A sg13cmos5l_inv_4_4.A VGND.t390 VGND.t936 sg13_lv_nmos ad=0.1406p pd=1.12u as=0.2516p ps=2.16u w=0.74u l=0.13u
X642 VPWR.t569 VGND.t269 VPWR.t569 VPWR.t20 sg13_lv_pmos ad=0.19p pd=1.38u as=0 ps=0 w=1u l=1u
X643 sg13cmos5l_inv_16_27.A sg13cmos5l_inv_16_24.A VPWR.t685 VPWR.t18 sg13_lv_pmos ad=0.2128p pd=1.5u as=0.3808p ps=2.92u w=1.12u l=0.13u
X644 sg13cmos5l_inv_16_17.Y sg13cmos5l_inv_16_1.Y VGND.t235 VGND.t836 sg13_lv_nmos ad=0.1406p pd=1.12u as=0.1406p ps=1.12u w=0.74u l=0.13u
X645 VGND.t32 sg13cmos5l_inv_1_6.A sg13cmos5l_inv_2_5.A VGND.t43 sg13_lv_nmos ad=0.2516p pd=2.16u as=0.2516p ps=2.16u w=0.74u l=0.13u
X646 VGND.t69 sg13cmos5l_inv_16_26.A sg13cmos5l_inv_16_31.A VGND.t771 sg13_lv_nmos ad=0.2516p pd=2.16u as=0.1406p ps=1.12u w=0.74u l=0.13u
X647 VPWR.t14 sg13cmos5l_inv_4_2.A sg13cmos5l_inv_4_2.Y VPWR.t0 sg13_lv_pmos ad=0.2128p pd=1.5u as=0.2128p ps=1.5u w=1.12u l=0.13u
X648 sg13cmos5l_inv_16_26.A sg13cmos5l_inv_8_6.A VPWR.t61 VPWR.t20 sg13_lv_pmos ad=0.2128p pd=1.5u as=0.2128p ps=1.5u w=1.12u l=0.13u
X649 sg13cmos5l_inv_4_1.Y sg13cmos5l_inv_4_1.A VGND.t7 VGND.t821 sg13_lv_nmos ad=0.1406p pd=1.12u as=0.2516p ps=2.16u w=0.74u l=0.13u
X650 sg13cmos5l_inv_16_28.A sg13cmos5l_inv_8_7.A VGND.t190 VGND.t189 sg13_lv_nmos ad=0.1443p pd=1.13u as=0.2516p ps=2.16u w=0.74u l=0.13u
X651 VPWR.t182 sg13cmos5l_inv_16_9.Y sg13cmos5l_inv_16_11.Y VPWR.t18 sg13_lv_pmos ad=0.2128p pd=1.5u as=0.2128p ps=1.5u w=1.12u l=0.13u
X652 sg13cmos5l_inv_4_6.Y sg13cmos5l_inv_2_7.Y VPWR.t106 VPWR.t18 sg13_lv_pmos ad=0.2128p pd=1.5u as=0.2128p ps=1.5u w=1.12u l=0.13u
X653 VPWR.t87 sg13cmos5l_inv_16_18.A sg13cmos5l_inv_16_18.Y VPWR.t0 sg13_lv_pmos ad=0.2128p pd=1.5u as=0.2128p ps=1.5u w=1.12u l=0.13u
X654 sg13cmos5l_inv_16_5.Y sg13cmos5l_inv_16_5.A VGND.t872 VGND.t873 sg13_lv_nmos ad=0.1406p pd=1.12u as=0.1406p ps=1.12u w=0.74u l=0.13u
X655 VPWR.t242 VGND.t407 VPWR.t312 VPWR.t20 sg13_lv_pmos ad=0.19p pd=1.38u as=0 ps=0 w=1u l=1u
X656 sg13cmos5l_xnor2_1_6.Y sg13cmos5l_dlygate4sd3_1_0.A a_25491_2680# VPWR.t20 sg13_lv_pmos ad=0.2408p pd=1.55u as=0.1428p ps=1.375u w=1.12u l=0.13u
X657 VGND.t324 sg13cmos5l_inv_4_0.Y sg13cmos5l_inv_16_0.A VGND.t818 sg13_lv_nmos ad=0.1406p pd=1.12u as=0.1406p ps=1.12u w=0.74u l=0.13u
X658 VPWR.t17 VGND.t445 VPWR.t17 VPWR.t0 sg13_lv_pmos ad=0.34p pd=2.68u as=0 ps=0 w=1u l=1u
X659 VPWR.t61 sg13cmos5l_inv_8_6.A sg13cmos5l_inv_16_26.A VPWR.t20 sg13_lv_pmos ad=0.2128p pd=1.5u as=0.2128p ps=1.5u w=1.12u l=0.13u
X660 VPWR.t300 sg13cmos5l_inv_4_1.Y sg13cmos5l_inv_16_12.A VPWR.t20 sg13_lv_pmos ad=0.2128p pd=1.5u as=0.2128p ps=1.5u w=1.12u l=0.13u
X661 VPWR.t96 sg13cmos5l_inv_16_2.A sg13cmos5l_inv_16_16.A VPWR.t0 sg13_lv_pmos ad=0.2128p pd=1.5u as=0.2128p ps=1.5u w=1.12u l=0.13u
X662 sg13cmos5l_inv_16_9.A sg13cmos5l_inv_16_13.A VPWR.t158 VPWR.t20 sg13_lv_pmos ad=0.2128p pd=1.5u as=0.2128p ps=1.5u w=1.12u l=0.13u
X663 VPWR.t427 VGND.t312 VPWR.t559 VPWR.t18 sg13_lv_pmos ad=0.19p pd=1.38u as=0 ps=0 w=1u l=1u
X664 VPWR.t134 sg13cmos5l_inv_16_15.A sg13cmos5l_inv_16_14.A VPWR.t20 sg13_lv_pmos ad=0.4368p pd=3.02u as=0.2128p ps=1.5u w=1.12u l=0.13u
X665 sg13cmos5l_inv_16_18.Y sg13cmos5l_inv_16_18.A VPWR.t14 VPWR.t0 sg13_lv_pmos ad=0.2128p pd=1.5u as=0.2128p ps=1.5u w=1.12u l=0.13u
X666 sg13cmos5l_inv_16_2.A sg13cmos5l_inv_16_0.A VPWR.t313 VPWR.t0 sg13_lv_pmos ad=0.2128p pd=1.5u as=0.2128p ps=1.5u w=1.12u l=0.13u
X667 VGND.t269 sg13cmos5l_inv_16_27.A sg13cmos5l_inv_16_23.A VGND.t284 sg13_lv_nmos ad=0.2516p pd=2.16u as=0.1406p ps=1.12u w=0.74u l=0.13u
X668 VGND.t41 VPWR.t216 VGND.t41 VGND.t373 sg13_lv_nmos ad=79.8f pd=0.8u as=0 ps=0 w=0.42u l=1u
X669 VPWR.t516 sg13cmos5l_inv_4_8.A sg13cmos5l_xnor2_1_6.A VPWR.t20 sg13_lv_pmos ad=0.2128p pd=1.5u as=0.2128p ps=1.5u w=1.12u l=0.13u
X670 VGND.t535 sg13cmos5l_inv_16_12.A sg13cmos5l_inv_16_13.A VGND.t894 sg13_lv_nmos ad=0.1406p pd=1.12u as=0.1406p ps=1.12u w=0.74u l=0.13u
X671 sg13cmos5l_inv_16_23.Y sg13cmos5l_inv_16_23.A VPWR.t536 VPWR.t20 sg13_lv_pmos ad=0.2128p pd=1.5u as=0.2128p ps=1.5u w=1.12u l=0.13u
X672 a_25382_1632# a_25112_1673# VGND.t27 VGND.t305 sg13_lv_nmos ad=0.1428p pd=1.52u as=79.8f ps=0.8u w=0.42u l=0.5u
X673 VPWR.t242 VGND.t409 VPWR.t142 VPWR.t20 sg13_lv_pmos ad=0.34p pd=2.68u as=0 ps=0 w=1u l=1u
X674 sg13cmos5l_inv_16_12.A sg13cmos5l_inv_4_1.Y VPWR.t389 VPWR.t20 sg13_lv_pmos ad=0.2128p pd=1.5u as=0.2128p ps=1.5u w=1.12u l=0.13u
X675 VPWR.t96 sg13cmos5l_inv_16_16.A sg13cmos5l_inv_16_18.A VPWR.t0 sg13_lv_pmos ad=0.2128p pd=1.5u as=0.2128p ps=1.5u w=1.12u l=0.13u
X676 VPWR.t669 sg13cmos5l_inv_16_26.A sg13cmos5l_inv_16_31.A VPWR.t20 sg13_lv_pmos ad=0.2128p pd=1.5u as=0.2128p ps=1.5u w=1.12u l=0.13u
X677 VGND.t780 sg13cmos5l_inv_8_1.A sg13cmos5l_inv_16_15.A VGND.t782 sg13_lv_nmos ad=0.1406p pd=1.12u as=0.1406p ps=1.12u w=0.74u l=0.13u
X678 sg13cmos5l_inv_16_14.A sg13cmos5l_inv_16_15.A VPWR.t130 VPWR.t20 sg13_lv_pmos ad=0.2128p pd=1.5u as=0.2128p ps=1.5u w=1.12u l=0.13u
X679 VPWR.t96 sg13cmos5l_inv_16_0.A sg13cmos5l_inv_16_2.A VPWR.t0 sg13_lv_pmos ad=0.2128p pd=1.5u as=0.2128p ps=1.5u w=1.12u l=0.13u
X680 VPWR.t350 sg13cmos5l_inv_16_23.Y sg13cmos5l_inv_16_25.Y VPWR.t20 sg13_lv_pmos ad=0.2128p pd=1.5u as=0.2128p ps=1.5u w=1.12u l=0.13u
X681 sg13cmos5l_inv_16_23.A sg13cmos5l_inv_16_27.A VGND.t269 VGND.t281 sg13_lv_nmos ad=0.1406p pd=1.12u as=0.1406p ps=1.12u w=0.74u l=0.13u
X682 VGND.t133 sg13cmos5l_inv_16_5.Y sg13cmos5l_inv_16_3.Y VGND.t134 sg13_lv_nmos ad=0.1406p pd=1.12u as=0.1406p ps=1.12u w=0.74u l=0.13u
X683 VGND.t312 VPWR.t559 VGND.t312 VGND.t314 sg13_lv_nmos ad=79.8f pd=0.8u as=0 ps=0 w=0.42u l=1u
X684 VPWR.t532 sg13cmos5l_inv_16_23.A sg13cmos5l_inv_16_23.Y VPWR.t20 sg13_lv_pmos ad=0.2128p pd=1.5u as=0.2128p ps=1.5u w=1.12u l=0.13u
X685 VGND.t41 sg13cmos5l_inv_16_1.A sg13cmos5l_inv_16_1.Y VGND.t246 sg13_lv_nmos ad=0.1406p pd=1.12u as=0.1406p ps=1.12u w=0.74u l=0.13u
X686 VGND.t119 sg13cmos5l_inv_16_24.A sg13cmos5l_inv_16_27.A VGND.t801 sg13_lv_nmos ad=0.2516p pd=2.16u as=0.1406p ps=1.12u w=0.74u l=0.13u
X687 VGND.t231 sg13cmos5l_inv_16_2.A sg13cmos5l_inv_16_16.A VGND.t296 sg13_lv_nmos ad=0.1406p pd=1.12u as=0.1406p ps=1.12u w=0.74u l=0.13u
X688 VGND.t361 VPWR.t36 VGND.t361 VGND.t360 sg13_lv_nmos ad=0.1428p pd=1.52u as=0 ps=0 w=0.42u l=1u
X689 VGND.t269 VPWR.t569 VGND.t269 VGND.t355 sg13_lv_nmos ad=0.1428p pd=1.52u as=0 ps=0 w=0.42u l=1u
X690 VPWR.t300 sg13cmos5l_inv_2_1.A sg13cmos5l_inv_4_2.A VPWR.t20 sg13_lv_pmos ad=0.3808p pd=2.92u as=0.2128p ps=1.5u w=1.12u l=0.13u
X691 sg13cmos5l_inv_16_25.Y sg13cmos5l_inv_16_23.Y VPWR.t346 VPWR.t20 sg13_lv_pmos ad=0.2128p pd=1.5u as=0.2128p ps=1.5u w=1.12u l=0.13u
X692 sg13cmos5l_inv_16_8.A sg13cmos5l_inv_16_6.A VGND.t7 VGND.t16 sg13_lv_nmos ad=0.1406p pd=1.12u as=0.1406p ps=1.12u w=0.74u l=0.13u
X693 VPWR.t521 sg13cmos5l_inv_16_12.A sg13cmos5l_inv_16_13.A VPWR.t20 sg13_lv_pmos ad=0.2128p pd=1.5u as=0.2128p ps=1.5u w=1.12u l=0.13u
X694 sg13cmos5l_and2_1_4.B a_16264_3932# VPWR.t68 VPWR.t18 sg13_lv_pmos ad=0.42p pd=2.99u as=0.2114p ps=1.54u w=1.12u l=0.13u
X695 VPWR.t251 sg13cmos5l_inv_16_1.Y sg13cmos5l_inv_16_17.Y VPWR.t20 sg13_lv_pmos ad=0.2128p pd=1.5u as=0.2128p ps=1.5u w=1.12u l=0.13u
X696 sg13cmos5l_inv_16_19.A sg13cmos5l_inv_16_28.A VGND.t585 VGND.t591 sg13_lv_nmos ad=0.1406p pd=1.12u as=0.1406p ps=1.12u w=0.74u l=0.13u
X697 VGND.t585 sg13cmos5l_inv_16_28.A sg13cmos5l_inv_16_19.A VGND.t586 sg13_lv_nmos ad=0.1406p pd=1.12u as=0.1406p ps=1.12u w=0.74u l=0.13u
X698 a_26991_3108# sg13cmos5l_xnor2_1_5.Y VGND.t121 VGND.t913 sg13_lv_nmos ad=0.2516p pd=2.16u as=0.3293p ps=1.63u w=0.74u l=0.13u
X699 sg13cmos5l_inv_16_20.A sg13cmos5l_inv_8_4.A VPWR.t78 VPWR.t0 sg13_lv_pmos ad=0.2128p pd=1.5u as=0.2128p ps=1.5u w=1.12u l=0.13u
X700 VGND.t24 a_24334_2571# sg13cmos5l_xnor2_1_3.A VGND.t264 sg13_lv_nmos ad=0.1426p pd=1.16u as=0.2516p ps=2.16u w=0.74u l=0.13u
X701 sg13cmos5l_inv_16_17.Y sg13cmos5l_inv_16_1.Y VPWR.t248 VPWR.t20 sg13_lv_pmos ad=0.2128p pd=1.5u as=0.3808p ps=2.92u w=1.12u l=0.13u
X702 VGND.t324 sg13cmos5l_inv_16_15.A sg13cmos5l_inv_16_14.A VGND.t818 sg13_lv_nmos ad=0.1406p pd=1.12u as=0.1406p ps=1.12u w=0.74u l=0.13u
X703 a_24539_916# sg13cmos5l_xnor2_1_3.A VGND.t773 VGND.t772 sg13_lv_nmos ad=78.39999f pd=0.885u as=0.2272p ps=1.99u w=0.64u l=0.13u
X704 sg13cmos5l_dlygate4sd3_1_4.X a_26934_938# VGND.t64 VGND.t162 sg13_lv_nmos ad=0.2516p pd=2.16u as=0.1426p ps=1.16u w=0.74u l=0.13u
X705 VGND.t190 sg13cmos5l_inv_16_19.A sg13cmos5l_inv_16_22.A VGND.t553 sg13_lv_nmos ad=0.1406p pd=1.12u as=0.1406p ps=1.12u w=0.74u l=0.13u
X706 VPWR.t96 sg13cmos5l_inv_16_16.A sg13cmos5l_inv_16_18.A VPWR.t0 sg13_lv_pmos ad=0.2128p pd=1.5u as=0.2128p ps=1.5u w=1.12u l=0.13u
X707 VPWR.t144 VGND.t384 VPWR.t143 VPWR.t20 sg13_lv_pmos ad=0.34p pd=2.68u as=0 ps=0 w=1u l=1u
X708 VPWR.t665 sg13cmos5l_inv_16_26.A sg13cmos5l_inv_16_31.A VPWR.t20 sg13_lv_pmos ad=0.2128p pd=1.5u as=0.2128p ps=1.5u w=1.12u l=0.13u
X709 VPWR.t559 VGND.t312 VPWR.t559 VPWR.t18 sg13_lv_pmos ad=0.19p pd=1.38u as=0 ps=0 w=1u l=1u
X710 sg13cmos5l_inv_16_7.A sg13cmos5l_inv_16_8.A VPWR.t1 VPWR.t0 sg13_lv_pmos ad=0.2128p pd=1.5u as=0.3808p ps=2.92u w=1.12u l=0.13u
X711 VGND.t399 VPWR.t568 VGND.t199 VGND.t398 sg13_lv_nmos ad=0.1428p pd=1.52u as=0 ps=0 w=0.42u l=1u
X712 sg13cmos5l_inv_16_30.A sg13cmos5l_inv_16_20.A VPWR.t78 VPWR.t0 sg13_lv_pmos ad=0.2128p pd=1.5u as=0.2128p ps=1.5u w=1.12u l=0.13u
X713 VPWR.t816 a_28652_3858# sg13cmos5l_and2_1_6.B VPWR.t18 sg13_lv_pmos ad=0.2114p pd=1.54u as=0.42p ps=2.99u w=1.12u l=0.13u
X714 VGND.t41 sg13cmos5l_inv_16_1.A sg13cmos5l_inv_16_1.Y VGND.t242 sg13_lv_nmos ad=0.1406p pd=1.12u as=0.1406p ps=1.12u w=0.74u l=0.13u
X715 VPWR.t247 VGND.t41 VPWR.t216 VPWR.t20 sg13_lv_pmos ad=0.19p pd=1.38u as=0 ps=0 w=1u l=1u
X716 a_16736_4097# sg13cmos5l_and2_1_4.B VPWR.t68 VPWR.t18 sg13_lv_pmos ad=0.1596p pd=1.22u as=0.1918p ps=1.5u w=0.84u l=0.13u
X717 sg13cmos5l_inv_16_22.A sg13cmos5l_inv_16_19.A VGND.t397 VGND.t549 sg13_lv_nmos ad=0.1406p pd=1.12u as=0.1406p ps=1.12u w=0.74u l=0.13u
X718 VPWR.t313 sg13cmos5l_inv_16_5.A sg13cmos5l_inv_16_5.Y VPWR.t0 sg13_lv_pmos ad=0.2128p pd=1.5u as=0.2128p ps=1.5u w=1.12u l=0.13u
X719 sg13cmos5l_inv_16_31.A sg13cmos5l_inv_16_26.A VPWR.t512 VPWR.t20 sg13_lv_pmos ad=0.2128p pd=1.5u as=0.2128p ps=1.5u w=1.12u l=0.13u
X720 VGND.t121 a_26991_3108# sg13cmos5l_and2_1_7.A VGND.t907 sg13_lv_nmos ad=0.1406p pd=1.12u as=0.1406p ps=1.12u w=0.74u l=0.13u
X721 VPWR.t854 VGND.t269 VPWR.t532 VPWR.t20 sg13_lv_pmos ad=0.19p pd=1.38u as=0 ps=0 w=1u l=1u
X722 VPWR.t216 sg13cmos5l_inv_2_2.A sg13cmos5l_inv_4_1.A VPWR.t20 sg13_lv_pmos ad=0.3864p pd=2.93u as=0.2128p ps=1.5u w=1.12u l=0.13u
X723 sg13cmos5l_inv_8_6.A sg13cmos5l_inv_4_5.A VPWR.t218 VPWR.t18 sg13_lv_pmos ad=0.2128p pd=1.5u as=0.2128p ps=1.5u w=1.12u l=0.13u
X724 VPWR.t17 VGND.t24 VPWR.t17 VPWR.t0 sg13_lv_pmos ad=0.19p pd=1.38u as=0 ps=0 w=1u l=1u
X725 sg13cmos5l_inv_16_5.Y sg13cmos5l_inv_16_5.A VPWR.t313 VPWR.t0 sg13_lv_pmos ad=0.2128p pd=1.5u as=0.2128p ps=1.5u w=1.12u l=0.13u
X726 VPWR.t24 sg13cmos5l_dlygate4sd3_1_3.X a_26552_874# VPWR.t0 sg13_lv_pmos ad=0.1523p pd=1.38u as=0.1428p ps=1.52u w=0.42u l=0.13u
X727 a_23648_3403# sg13cmos5l_and2_1_7.A a_23785_3492# VGND.t630 sg13_lv_nmos ad=0.2176p pd=1.96u as=0.1216p ps=1.02u w=0.64u l=0.13u
X728 VPWR.t520 sg13cmos5l_inv_16_12.A sg13cmos5l_inv_16_13.A VPWR.t20 sg13_lv_pmos ad=0.2128p pd=1.5u as=0.2128p ps=1.5u w=1.12u l=0.13u
X729 VPWR.t510 sg13cmos5l_inv_16_31.A sg13cmos5l_inv_16_29.A VPWR.t20 sg13_lv_pmos ad=0.2128p pd=1.5u as=0.2128p ps=1.5u w=1.12u l=0.13u
X730 sg13cmos5l_inv_16_5.A sg13cmos5l_inv_16_30.A VGND.t45 VGND.t57 sg13_lv_nmos ad=0.1406p pd=1.12u as=0.1406p ps=1.12u w=0.74u l=0.13u
X731 sg13cmos5l_inv_16_24.A sg13cmos5l_inv_4_6.Y VGND.t121 VGND.t687 sg13_lv_nmos ad=0.1406p pd=1.12u as=0.1406p ps=1.12u w=0.74u l=0.13u
X732 a_14240_4097# sg13cmos5l_and2_1_7.A a_14377_3940# VGND.t626 sg13_lv_nmos ad=0.2176p pd=1.96u as=0.1216p ps=1.02u w=0.64u l=0.13u
X733 sg13cmos5l_inv_16_10.Y sg13cmos5l_inv_16_10.A VPWR.t366 VPWR.t0 sg13_lv_pmos ad=0.2128p pd=1.5u as=0.2128p ps=1.5u w=1.12u l=0.13u
X734 sg13cmos5l_inv_16_29.A sg13cmos5l_inv_16_31.A VPWR.t422 VPWR.t20 sg13_lv_pmos ad=0.2128p pd=1.5u as=0.2128p ps=1.5u w=1.12u l=0.13u
X735 VPWR.t96 sg13cmos5l_inv_16_2.A sg13cmos5l_inv_16_16.A VPWR.t0 sg13_lv_pmos ad=0.4368p pd=3.02u as=0.2128p ps=1.5u w=1.12u l=0.13u
X736 sg13cmos5l_inv_16_29.Y sg13cmos5l_inv_16_29.A VGND.t381 VGND.t482 sg13_lv_nmos ad=0.1406p pd=1.12u as=0.1406p ps=1.12u w=0.74u l=0.13u
X737 sg13cmos5l_inv_16_6.A sg13cmos5l_inv_4_2.Y VPWR.t14 VPWR.t0 sg13_lv_pmos ad=0.2184p pd=1.51u as=0.2128p ps=1.5u w=1.12u l=0.13u
X738 sg13cmos5l_inv_16_29.A sg13cmos5l_inv_16_31.A VGND.t82 VGND.t646 sg13_lv_nmos ad=0.1406p pd=1.12u as=0.1406p ps=1.12u w=0.74u l=0.13u
X739 VPWR.t172 sg13cmos5l_inv_16_13.A sg13cmos5l_inv_16_9.A VPWR.t20 sg13_lv_pmos ad=0.4368p pd=3.02u as=0.2128p ps=1.5u w=1.12u l=0.13u
X740 a_26112_1671# sg13cmos5l_dlygate4sd3_1_3.X a_26075_1980# VGND.t258 sg13_lv_nmos ad=0.2176p pd=1.96u as=78.39999f ps=0.885u w=0.64u l=0.13u
X741 sg13cmos5l_inv_16_21.Y sg13cmos5l_inv_16_21.A VGND.t390 VGND.t695 sg13_lv_nmos ad=0.1406p pd=1.12u as=0.1406p ps=1.12u w=0.74u l=0.13u
X742 a_26880_1671# sg13cmos5l_xnor2_1_0.Y VPWR.t24 VPWR.t0 sg13_lv_pmos ad=0.1596p pd=1.22u as=0.4536p ps=2.76u w=0.84u l=0.13u
X743 a_26165_2386# sg13cmos5l_xnor2_1_3.Y VGND.t27 VGND.t26 sg13_lv_nmos ad=0.1406p pd=1.12u as=0.1898p ps=1.36u w=0.74u l=0.13u
X744 VPWR.t386 sg13cmos5l_inv_4_4.A sg13cmos5l_inv_8_4.A VPWR.t20 sg13_lv_pmos ad=0.3808p pd=2.92u as=0.2128p ps=1.5u w=1.12u l=0.13u
X745 sg13cmos5l_inv_1_3.A a_5709_3940# VPWR.t19 VPWR.t18 sg13_lv_pmos ad=0.3808p pd=2.92u as=0.1918p ps=1.5u w=1.12u l=0.13u
X746 VPWR.t569 VGND.t199 VPWR.t568 VPWR.t20 sg13_lv_pmos ad=0.34p pd=2.68u as=0 ps=0 w=1u l=1u
X747 VPWR.t122 sg13cmos5l_inv_16_29.Y sg13cmos5l_inv_16_4.Y VPWR.t20 sg13_lv_pmos ad=0.2128p pd=1.5u as=0.2128p ps=1.5u w=1.12u l=0.13u
X748 a_28297_3940# sg13cmos5l_and2_1_6.B VGND.t121 VGND.t120 sg13_lv_nmos ad=0.1216p pd=1.02u as=0.1331p ps=1.12u w=0.64u l=0.13u
X749 sg13cmos5l_inv_16_27.A sg13cmos5l_inv_16_24.A VPWR.t120 VPWR.t18 sg13_lv_pmos ad=0.2128p pd=1.5u as=0.2128p ps=1.5u w=1.12u l=0.13u
X750 VGND.t399 VPWR.t198 VGND.t401 VGND.t400 sg13_lv_nmos ad=79.8f pd=0.8u as=0 ps=0 w=0.42u l=1u
X751 sg13cmos5l_inv_16_23.A sg13cmos5l_inv_16_27.A VPWR.t25 VPWR.t18 sg13_lv_pmos ad=0.2128p pd=1.5u as=0.2128p ps=1.5u w=1.12u l=0.13u
X752 VPWR.t14 sg13cmos5l_inv_16_6.A sg13cmos5l_inv_16_8.A VPWR.t0 sg13_lv_pmos ad=0.2128p pd=1.5u as=0.2128p ps=1.5u w=1.12u l=0.13u
X753 VPWR.t120 VGND.t339 VPWR.t120 VPWR.t18 sg13_lv_pmos ad=0.19p pd=1.38u as=0 ps=0 w=1u l=1u
X754 sg13cmos5l_inv_16_3.Y sg13cmos5l_inv_16_5.Y VPWR.t313 VPWR.t0 sg13_lv_pmos ad=0.2128p pd=1.5u as=0.3808p ps=2.92u w=1.12u l=0.13u
X755 a_24334_2571# a_24449_2572# VGND.t24 VGND.t161 sg13_lv_nmos ad=0.1428p pd=1.52u as=0.1426p ps=1.16u w=0.42u l=0.5u
X756 sg13cmos5l_inv_8_4.A sg13cmos5l_inv_4_4.A VPWR.t65 VPWR.t20 sg13_lv_pmos ad=0.2128p pd=1.5u as=0.3808p ps=2.92u w=1.12u l=0.13u
X757 VPWR.t685 sg13cmos5l_inv_16_24.A sg13cmos5l_inv_16_27.A VPWR.t18 sg13_lv_pmos ad=0.2128p pd=1.5u as=0.2128p ps=1.5u w=1.12u l=0.13u
X758 VGND.t872 sg13cmos5l_inv_16_5.A sg13cmos5l_inv_16_5.Y VGND.t874 sg13_lv_nmos ad=0.1406p pd=1.12u as=0.1406p ps=1.12u w=0.74u l=0.13u
X759 VGND.t133 sg13cmos5l_inv_16_29.Y sg13cmos5l_inv_16_4.Y VGND.t140 sg13_lv_nmos ad=0.1406p pd=1.12u as=0.1406p ps=1.12u w=0.74u l=0.13u
X760 VPWR.t41 VGND.t432 VPWR.t596 VPWR.t0 sg13_lv_pmos ad=0.19p pd=1.38u as=0 ps=0 w=1u l=1u
X761 VGND.t29 VPWR.t516 VGND.t267 VGND.t402 sg13_lv_nmos ad=0.1428p pd=1.52u as=0 ps=0 w=0.42u l=1u
X762 VPWR.t25 sg13cmos5l_inv_16_27.A sg13cmos5l_inv_16_23.A VPWR.t18 sg13_lv_pmos ad=0.2128p pd=1.5u as=0.2128p ps=1.5u w=1.12u l=0.13u
X763 VPWR.t87 sg13cmos5l_inv_16_18.A sg13cmos5l_inv_16_18.Y VPWR.t0 sg13_lv_pmos ad=0.4368p pd=3.02u as=0.2128p ps=1.5u w=1.12u l=0.13u
X764 VPWR.t253 VGND.t41 VPWR.t252 VPWR.t20 sg13_lv_pmos ad=0.34p pd=2.68u as=0 ps=0 w=1u l=1u
X765 sg13cmos5l_inv_1_3.A a_5709_3940# VGND.t20 VGND.t19 sg13_lv_nmos ad=0.2516p pd=2.16u as=0.1331p ps=1.12u w=0.74u l=0.13u
X766 VGND.t199 sg13cmos5l_inv_8_7.A sg13cmos5l_inv_16_28.A VGND.t198 sg13_lv_nmos ad=0.2516p pd=2.16u as=0.1406p ps=1.12u w=0.74u l=0.13u
X767 VPWR.t96 sg13cmos5l_inv_16_2.A sg13cmos5l_inv_16_16.A VPWR.t0 sg13_lv_pmos ad=0.2128p pd=1.5u as=0.2128p ps=1.5u w=1.12u l=0.13u
X768 sg13cmos5l_inv_4_1.Y sg13cmos5l_inv_4_1.A VPWR.t388 VPWR.t20 sg13_lv_pmos ad=0.2128p pd=1.5u as=0.3808p ps=2.92u w=1.12u l=0.13u
X769 sg13cmos5l_inv_16_4.Y sg13cmos5l_inv_16_29.Y VGND.t133 VGND.t137 sg13_lv_nmos ad=0.1406p pd=1.12u as=0.1406p ps=1.12u w=0.74u l=0.13u
X770 VPWR.t366 sg13cmos5l_inv_16_10.A sg13cmos5l_inv_16_10.Y VPWR.t0 sg13_lv_pmos ad=0.2128p pd=1.5u as=0.2128p ps=1.5u w=1.12u l=0.13u
X771 VGND.t432 VPWR.t41 VGND.t432 VGND.t433 sg13_lv_nmos ad=0.1428p pd=1.52u as=0 ps=0 w=0.42u l=1u
X772 sg13cmos5l_inv_16_11.Y sg13cmos5l_inv_16_9.Y VPWR.t193 VPWR.t18 sg13_lv_pmos ad=0.2128p pd=1.5u as=0.2128p ps=1.5u w=1.12u l=0.13u
X773 sg13cmos5l_inv_16_28.A sg13cmos5l_inv_8_7.A VGND.t190 VGND.t194 sg13_lv_nmos ad=0.1406p pd=1.12u as=0.1406p ps=1.12u w=0.74u l=0.13u
X774 sg13cmos5l_inv_16_16.A sg13cmos5l_inv_16_2.A VPWR.t96 VPWR.t0 sg13_lv_pmos ad=0.2128p pd=1.5u as=0.2128p ps=1.5u w=1.12u l=0.13u
X775 sg13cmos5l_inv_16_9.Y sg13cmos5l_inv_16_9.A VGND.t361 VGND.t526 sg13_lv_nmos ad=0.1406p pd=1.12u as=0.1406p ps=1.12u w=0.74u l=0.13u
X776 sg13cmos5l_inv_16_1.A sg13cmos5l_inv_16_14.A VPWR.t480 VPWR.t20 sg13_lv_pmos ad=0.2128p pd=1.5u as=0.2128p ps=1.5u w=1.12u l=0.13u
X777 a_9451_3940# sg13cmos5l_and2_1_7.A a_9357_3940# VGND.t625 sg13_lv_nmos ad=0.1216p pd=1.02u as=0.2176p ps=1.96u w=0.64u l=0.13u
X778 sg13cmos5l_inv_16_5.A sg13cmos5l_inv_16_30.A VPWR.t42 VPWR.t0 sg13_lv_pmos ad=0.2128p pd=1.5u as=0.2128p ps=1.5u w=1.12u l=0.13u
X779 VPWR.t87 sg13cmos5l_inv_16_18.A sg13cmos5l_inv_16_18.Y VPWR.t0 sg13_lv_pmos ad=0.2128p pd=1.5u as=0.2128p ps=1.5u w=1.12u l=0.13u
X780 VGND.t249 sg13cmos5l_inv_16_1.A sg13cmos5l_inv_16_1.Y VGND.t257 sg13_lv_nmos ad=0.2516p pd=2.16u as=0.1406p ps=1.12u w=0.74u l=0.13u
X781 sg13cmos5l_inv_16_16.A sg13cmos5l_inv_16_2.A VGND.t231 VGND.t297 sg13_lv_nmos ad=0.1406p pd=1.12u as=0.1406p ps=1.12u w=0.74u l=0.13u
X782 sg13cmos5l_inv_16_22.A sg13cmos5l_inv_16_19.A VPWR.t403 VPWR.t0 sg13_lv_pmos ad=0.2128p pd=1.5u as=0.2128p ps=1.5u w=1.12u l=0.13u
X783 VGND.t32 VPWR.t386 VGND.t331 VGND.t350 sg13_lv_nmos ad=0.1428p pd=1.52u as=0 ps=0 w=0.42u l=1u
X784 sg13cmos5l_inv_16_22.A sg13cmos5l_inv_16_19.A VGND.t397 VGND.t543 sg13_lv_nmos ad=0.1406p pd=1.12u as=0.2516p ps=2.16u w=0.74u l=0.13u
X785 sg13cmos5l_inv_16_19.A sg13cmos5l_inv_16_28.A VGND.t585 VGND.t597 sg13_lv_nmos ad=0.1406p pd=1.12u as=0.1406p ps=1.12u w=0.74u l=0.13u
X786 sg13cmos5l_inv_16_18.Y sg13cmos5l_inv_16_18.A VPWR.t87 VPWR.t0 sg13_lv_pmos ad=0.2128p pd=1.5u as=0.2128p ps=1.5u w=1.12u l=0.13u
X787 VPWR.t226 sg13cmos5l_inv_16_1.A sg13cmos5l_inv_16_1.Y VPWR.t20 sg13_lv_pmos ad=0.2128p pd=1.5u as=0.2128p ps=1.5u w=1.12u l=0.13u
X788 VGND.t585 sg13cmos5l_inv_16_28.A sg13cmos5l_inv_16_19.A VGND.t592 sg13_lv_nmos ad=0.1406p pd=1.12u as=0.1406p ps=1.12u w=0.74u l=0.13u
X789 VPWR.t396 sg13cmos5l_inv_16_19.A sg13cmos5l_inv_16_22.A VPWR.t0 sg13_lv_pmos ad=0.2128p pd=1.5u as=0.2128p ps=1.5u w=1.12u l=0.13u
X790 VGND.t249 sg13cmos5l_inv_16_0.A sg13cmos5l_inv_16_2.A VGND.t610 sg13_lv_nmos ad=0.1406p pd=1.12u as=0.1406p ps=1.12u w=0.74u l=0.13u
X791 VGND.t133 sg13cmos5l_inv_16_5.Y sg13cmos5l_inv_16_3.Y VGND.t140 sg13_lv_nmos ad=0.1406p pd=1.12u as=0.1406p ps=1.12u w=0.74u l=0.13u
X792 sg13cmos5l_inv_16_22.A sg13cmos5l_inv_16_19.A VPWR.t396 VPWR.t0 sg13_lv_pmos ad=0.2128p pd=1.5u as=0.2128p ps=1.5u w=1.12u l=0.13u
X793 VPWR.t41 VGND.t45 VPWR.t41 VPWR.t0 sg13_lv_pmos ad=0.19p pd=1.38u as=0 ps=0 w=1u l=1u
X794 sg13cmos5l_inv_16_2.A sg13cmos5l_inv_16_0.A VGND.t249 VGND.t607 sg13_lv_nmos ad=0.1406p pd=1.12u as=0.1406p ps=1.12u w=0.74u l=0.13u
X795 VGND.t404 VPWR.t312 VGND.t404 VGND.t405 sg13_lv_nmos ad=0.1428p pd=1.52u as=0 ps=0 w=0.42u l=1u
X796 VGND.t325 sg13cmos5l_inv_16_15.A sg13cmos5l_inv_16_14.A VGND.t925 sg13_lv_nmos ad=0.1406p pd=1.12u as=0.1406p ps=1.12u w=0.74u l=0.13u
X797 VPWR.t516 VGND.t267 VPWR.t516 VPWR.t20 sg13_lv_pmos ad=0.34p pd=2.68u as=0 ps=0 w=1u l=1u
X798 VPWR.t854 VGND.t269 VPWR.t538 VPWR.t20 sg13_lv_pmos ad=0.34p pd=2.68u as=0 ps=0 w=1u l=1u
X799 sg13cmos5l_inv_16_17.Y sg13cmos5l_inv_16_1.Y VPWR.t221 VPWR.t20 sg13_lv_pmos ad=0.2128p pd=1.5u as=0.2128p ps=1.5u w=1.12u l=0.13u
X800 sg13cmos5l_inv_16_3.Y sg13cmos5l_inv_16_5.Y VGND.t133 VGND.t137 sg13_lv_nmos ad=0.1406p pd=1.12u as=0.1406p ps=1.12u w=0.74u l=0.13u
X801 sg13cmos5l_inv_16_7.A sg13cmos5l_inv_16_8.A VPWR.t1 VPWR.t0 sg13_lv_pmos ad=0.2128p pd=1.5u as=0.2128p ps=1.5u w=1.12u l=0.13u
X802 sg13cmos5l_inv_2_7.Y sg13cmos5l_inv_1_8.Y VGND.t359 VGND.t532 sg13_lv_nmos ad=0.1406p pd=1.12u as=0.2516p ps=2.16u w=0.74u l=0.13u
X803 VGND.t231 sg13cmos5l_inv_16_2.A sg13cmos5l_inv_16_16.A VGND.t298 sg13_lv_nmos ad=0.1406p pd=1.12u as=0.1406p ps=1.12u w=0.74u l=0.13u
X804 sg13cmos5l_inv_16_19.A sg13cmos5l_inv_16_28.A VPWR.t174 VPWR.t0 sg13_lv_pmos ad=0.2128p pd=1.5u as=0.2128p ps=1.5u w=1.12u l=0.13u
X805 sg13cmos5l_inv_16_10.A sg13cmos5l_inv_16_7.A VGND.t361 VGND.t526 sg13_lv_nmos ad=0.1406p pd=1.12u as=0.1406p ps=1.12u w=0.74u l=0.13u
X806 VGND.t249 sg13cmos5l_inv_16_1.A sg13cmos5l_inv_16_1.Y VGND.t253 sg13_lv_nmos ad=0.1406p pd=1.12u as=0.1406p ps=1.12u w=0.74u l=0.13u
X807 VPWR.t252 sg13cmos5l_inv_16_1.Y sg13cmos5l_inv_16_17.Y VPWR.t20 sg13_lv_pmos ad=0.2128p pd=1.5u as=0.2128p ps=1.5u w=1.12u l=0.13u
X808 VPWR.t41 sg13cmos5l_inv_16_29.A sg13cmos5l_inv_16_29.Y VPWR.t0 sg13_lv_pmos ad=0.2128p pd=1.5u as=0.2128p ps=1.5u w=1.12u l=0.13u
X809 VGND.t361 sg13cmos5l_inv_16_9.A sg13cmos5l_inv_16_9.Y VGND.t519 sg13_lv_nmos ad=0.1406p pd=1.12u as=0.1406p ps=1.12u w=0.74u l=0.13u
X810 VPWR.t156 a_19616_4097# sg13cmos5l_inv_1_6.A VPWR.t18 sg13_lv_pmos ad=0.1918p pd=1.5u as=0.3808p ps=2.92u w=1.12u l=0.13u
X811 sg13cmos5l_inv_16_16.A sg13cmos5l_inv_16_2.A VGND.t231 VGND.t293 sg13_lv_nmos ad=0.1406p pd=1.12u as=0.1406p ps=1.12u w=0.74u l=0.13u
X812 VGND.t117 sg13cmos5l_inv_16_14.A sg13cmos5l_inv_16_1.A VGND.t741 sg13_lv_nmos ad=0.1406p pd=1.12u as=0.1406p ps=1.12u w=0.74u l=0.13u
X813 sg13cmos5l_inv_16_31.A sg13cmos5l_inv_16_26.A VPWR.t303 VPWR.t20 sg13_lv_pmos ad=0.2128p pd=1.5u as=0.2128p ps=1.5u w=1.12u l=0.13u
X814 VGND.t585 sg13cmos5l_inv_16_28.A sg13cmos5l_inv_16_19.A VGND.t598 sg13_lv_nmos ad=0.1406p pd=1.12u as=0.1406p ps=1.12u w=0.74u l=0.13u
X815 VPWR.t174 sg13cmos5l_inv_16_28.A sg13cmos5l_inv_16_19.A VPWR.t0 sg13_lv_pmos ad=0.2128p pd=1.5u as=0.2128p ps=1.5u w=1.12u l=0.13u
X816 VGND.t307 VPWR.t427 VGND.t307 VGND.t310 sg13_lv_nmos ad=0.1428p pd=1.52u as=0 ps=0 w=0.42u l=1u
X817 sg13cmos5l_inv_16_1.Y sg13cmos5l_inv_16_1.A VGND.t249 VGND.t250 sg13_lv_nmos ad=0.1406p pd=1.12u as=0.1406p ps=1.12u w=0.74u l=0.13u
X818 VGND.t325 sg13cmos5l_inv_16_15.A sg13cmos5l_inv_16_14.A VGND.t921 sg13_lv_nmos ad=0.1406p pd=1.12u as=0.1406p ps=1.12u w=0.74u l=0.13u
X819 VPWR.t222 sg13cmos5l_inv_16_1.A sg13cmos5l_inv_16_1.Y VPWR.t20 sg13_lv_pmos ad=0.2128p pd=1.5u as=0.2128p ps=1.5u w=1.12u l=0.13u
X820 VPWR.t519 sg13cmos5l_inv_4_8.A sg13cmos5l_xnor2_1_6.A VPWR.t20 sg13_lv_pmos ad=0.3808p pd=2.92u as=0.2128p ps=1.5u w=1.12u l=0.13u
X821 VGND.t32 a_20588_3858# sg13cmos5l_and2_1_5.B VGND.t31 sg13_lv_nmos ad=0.14875p pd=1.16u as=0.2886p ps=2.26u w=0.74u l=0.13u
X822 VGND.t62 sg13cmos5l_inv_8_4.A sg13cmos5l_inv_16_20.A VGND.t903 sg13_lv_nmos ad=0.1406p pd=1.12u as=0.1406p ps=1.12u w=0.74u l=0.13u
X823 sg13cmos5l_inv_16_19.A sg13cmos5l_inv_16_28.A VGND.t585 VGND.t593 sg13_lv_nmos ad=0.1406p pd=1.12u as=0.1406p ps=1.12u w=0.74u l=0.13u
X824 VGND.t7 VPWR.t522 VGND.t7 VGND.t371 sg13_lv_nmos ad=79.8f pd=0.8u as=0 ps=0 w=0.42u l=1u
X825 sg13cmos5l_inv_16_5.Y sg13cmos5l_inv_16_5.A VPWR.t313 VPWR.t0 sg13_lv_pmos ad=0.2128p pd=1.5u as=0.2128p ps=1.5u w=1.12u l=0.13u
X826 VGND.t190 sg13cmos5l_inv_16_19.A sg13cmos5l_inv_16_22.A VGND.t559 sg13_lv_nmos ad=0.2516p pd=2.16u as=0.1406p ps=1.12u w=0.74u l=0.13u
X827 VGND.t59 sg13cmos5l_inv_16_30.A sg13cmos5l_inv_16_5.A VGND.t58 sg13_lv_nmos ad=0.1406p pd=1.12u as=0.1406p ps=1.12u w=0.74u l=0.13u
X828 VPWR.t524 sg13cmos5l_inv_16_12.A sg13cmos5l_inv_16_13.A VPWR.t20 sg13_lv_pmos ad=0.4368p pd=3.02u as=0.2128p ps=1.5u w=1.12u l=0.13u
X829 VPWR.t78 sg13cmos5l_inv_16_21.A sg13cmos5l_inv_16_21.Y VPWR.t0 sg13_lv_pmos ad=0.2128p pd=1.5u as=0.2128p ps=1.5u w=1.12u l=0.13u
X830 sg13cmos5l_inv_16_7.A sg13cmos5l_inv_16_8.A VPWR.t1 VPWR.t0 sg13_lv_pmos ad=0.2128p pd=1.5u as=0.2128p ps=1.5u w=1.12u l=0.13u
X831 sg13cmos5l_inv_16_30.A sg13cmos5l_inv_16_20.A VGND.t80 VGND.t79 sg13_lv_nmos ad=0.1406p pd=1.12u as=0.2516p ps=2.16u w=0.74u l=0.13u
X832 VPWR.t78 sg13cmos5l_inv_8_4.A sg13cmos5l_inv_16_20.A VPWR.t0 sg13_lv_pmos ad=0.2128p pd=1.5u as=0.2128p ps=1.5u w=1.12u l=0.13u
X833 sg13cmos5l_inv_16_19.A sg13cmos5l_inv_16_28.A VPWR.t174 VPWR.t0 sg13_lv_pmos ad=0.2128p pd=1.5u as=0.2128p ps=1.5u w=1.12u l=0.13u
X834 VGND.t446 VPWR.t17 VGND.t446 VGND.t447 sg13_lv_nmos ad=79.8f pd=0.8u as=0 ps=0 w=0.42u l=1u
X835 VGND.t32 a_19616_4097# sg13cmos5l_inv_1_6.A VGND.t168 sg13_lv_nmos ad=0.1331p pd=1.12u as=0.2516p ps=2.16u w=0.74u l=0.13u
X836 VPWR.t313 sg13cmos5l_inv_4_0.A sg13cmos5l_inv_4_0.Y VPWR.t0 sg13_lv_pmos ad=0.3808p pd=2.92u as=0.2128p ps=1.5u w=1.12u l=0.13u
X837 sg13cmos5l_xnor2_1_0.Y a_26112_1671# a_26261_2002# VGND.t285 sg13_lv_nmos ad=0.2516p pd=2.16u as=0.1406p ps=1.12u w=0.74u l=0.13u
X838 VGND.t196 sg13cmos5l_inv_4_7.A sg13cmos5l_inv_8_7.A VGND.t843 sg13_lv_nmos ad=0.1406p pd=1.12u as=0.1406p ps=1.12u w=0.74u l=0.13u
X839 sg13cmos5l_inv_16_22.A sg13cmos5l_inv_16_19.A VGND.t190 VGND.t556 sg13_lv_nmos ad=0.1406p pd=1.12u as=0.1406p ps=1.12u w=0.74u l=0.13u
X840 sg13cmos5l_inv_16_2.A sg13cmos5l_inv_16_0.A VGND.t249 VGND.t603 sg13_lv_nmos ad=0.1406p pd=1.12u as=0.1406p ps=1.12u w=0.74u l=0.13u
X841 VGND.t32 VPWR.t649 VGND.t32 VGND.t334 sg13_lv_nmos ad=0.1428p pd=1.52u as=0 ps=0 w=0.42u l=1u
X842 sg13cmos5l_inv_16_28.A sg13cmos5l_inv_8_7.A VPWR.t174 VPWR.t0 sg13_lv_pmos ad=0.2128p pd=1.5u as=0.2128p ps=1.5u w=1.12u l=0.13u
X843 sg13cmos5l_inv_16_21.A sg13cmos5l_inv_16_22.A VPWR.t396 VPWR.t0 sg13_lv_pmos ad=0.2128p pd=1.5u as=0.2128p ps=1.5u w=1.12u l=0.13u
X844 VPWR.t312 VGND.t404 VPWR.t519 VPWR.t20 sg13_lv_pmos ad=0.34p pd=2.68u as=0 ps=0 w=1u l=1u
X845 VPWR.t134 VGND.t131 VPWR.t485 VPWR.t20 sg13_lv_pmos ad=0.34p pd=2.68u as=0 ps=0 w=1u l=1u
X846 VGND.t384 sg13cmos5l_inv_16_29.A sg13cmos5l_inv_16_29.Y VGND.t491 sg13_lv_nmos ad=0.1406p pd=1.12u as=0.1406p ps=1.12u w=0.74u l=0.13u
X847 VGND.t117 sg13cmos5l_inv_16_14.A sg13cmos5l_inv_16_1.A VGND.t737 sg13_lv_nmos ad=0.1406p pd=1.12u as=0.1406p ps=1.12u w=0.74u l=0.13u
X848 VPWR.t427 VGND.t307 VPWR.t427 VPWR.t18 sg13_lv_pmos ad=0.34p pd=2.68u as=0 ps=0 w=1u l=1u
X849 sg13cmos5l_inv_16_31.A sg13cmos5l_inv_16_26.A VGND.t66 VGND.t756 sg13_lv_nmos ad=0.1406p pd=1.12u as=0.2516p ps=2.16u w=0.74u l=0.13u
X850 VGND.t269 VPWR.t262 VGND.t167 VGND.t336 sg13_lv_nmos ad=79.8f pd=0.8u as=0 ps=0 w=0.42u l=1u
X851 VPWR.t174 sg13cmos5l_inv_8_7.A sg13cmos5l_inv_16_28.A VPWR.t0 sg13_lv_pmos ad=0.2128p pd=1.5u as=0.2128p ps=1.5u w=1.12u l=0.13u
X852 VGND.t361 sg13cmos5l_inv_16_7.A sg13cmos5l_inv_16_10.A VGND.t519 sg13_lv_nmos ad=0.1406p pd=1.12u as=0.1406p ps=1.12u w=0.74u l=0.13u
X853 VGND.t41 VPWR.t216 VGND.t41 VGND.t372 sg13_lv_nmos ad=0.1428p pd=1.52u as=0 ps=0 w=0.42u l=1u
X854 sg13cmos5l_inv_16_29.A sg13cmos5l_inv_16_31.A VPWR.t512 VPWR.t20 sg13_lv_pmos ad=0.2128p pd=1.5u as=0.2128p ps=1.5u w=1.12u l=0.13u
X855 VGND.t324 sg13cmos5l_inv_16_15.A sg13cmos5l_inv_16_14.A VGND.t917 sg13_lv_nmos ad=0.1406p pd=1.12u as=0.1406p ps=1.12u w=0.74u l=0.13u
X856 a_26016_2697# sg13cmos5l_xnor2_1_6.Y VPWR.t564 VPWR.t20 sg13_lv_pmos ad=0.1596p pd=1.22u as=0.4536p ps=2.76u w=0.84u l=0.13u
X857 sg13cmos5l_inv_16_1.A sg13cmos5l_inv_16_14.A VGND.t117 VGND.t734 sg13_lv_nmos ad=0.1406p pd=1.12u as=0.1406p ps=1.12u w=0.74u l=0.13u
X858 VGND.t312 sg13cmos5l_inv_16_12.A sg13cmos5l_inv_16_13.A VGND.t882 sg13_lv_nmos ad=0.1406p pd=1.12u as=0.1406p ps=1.12u w=0.74u l=0.13u
X859 VPWR.t104 sg13cmos5l_inv_4_0.Y sg13cmos5l_inv_16_0.A VPWR.t18 sg13_lv_pmos ad=0.2128p pd=1.5u as=0.2128p ps=1.5u w=1.12u l=0.13u
X860 sg13cmos5l_inv_16_3.Y sg13cmos5l_inv_16_5.Y VPWR.t313 VPWR.t0 sg13_lv_pmos ad=0.2128p pd=1.5u as=0.2128p ps=1.5u w=1.12u l=0.13u
X861 VGND.t32 sg13cmos5l_inv_16_23.Y sg13cmos5l_inv_16_25.Y VGND.t509 sg13_lv_nmos ad=0.1406p pd=1.12u as=0.1406p ps=1.12u w=0.74u l=0.13u
X862 VGND.t312 VPWR.t559 VGND.t312 VGND.t313 sg13_lv_nmos ad=0.1428p pd=1.52u as=0 ps=0 w=0.42u l=1u
X863 VPWR.t198 VGND.t199 VPWR.t181 VPWR.t0 sg13_lv_pmos ad=0.34p pd=2.68u as=0 ps=0 w=1u l=1u
X864 sg13cmos5l_inv_4_5.A sg13cmos5l_inv_1_4.Y VGND.t69 VGND.t730 sg13_lv_nmos ad=0.1406p pd=1.12u as=0.2516p ps=2.16u w=0.74u l=0.13u
X865 VPWR.t524 VGND.t7 VPWR.t522 VPWR.t20 sg13_lv_pmos ad=0.19p pd=1.38u as=0 ps=0 w=1u l=1u
X866 VPWR.t262 sg13cmos5l_inv_16_27.A sg13cmos5l_inv_16_23.A VPWR.t18 sg13_lv_pmos ad=0.4368p pd=3.02u as=0.2128p ps=1.5u w=1.12u l=0.13u
X867 sg13cmos5l_inv_16_14.A sg13cmos5l_inv_16_15.A VPWR.t121 VPWR.t20 sg13_lv_pmos ad=0.2128p pd=1.5u as=0.3808p ps=2.92u w=1.12u l=0.13u
X868 sg13cmos5l_inv_16_4.Y sg13cmos5l_inv_16_29.Y VGND.t133 VGND.t147 sg13_lv_nmos ad=0.1406p pd=1.12u as=0.1406p ps=1.12u w=0.74u l=0.13u
X869 sg13cmos5l_xnor2_1_3.B a_24630_1656# VGND.t27 VGND.t115 sg13_lv_nmos ad=0.2516p pd=2.16u as=0.1426p ps=1.16u w=0.74u l=0.13u
X870 VPWR.t128 sg13cmos5l_inv_16_29.Y sg13cmos5l_inv_16_4.Y VPWR.t20 sg13_lv_pmos ad=0.2128p pd=1.5u as=0.2128p ps=1.5u w=1.12u l=0.13u
X871 VPWR.t678 sg13cmos5l_inv_8_1.A sg13cmos5l_inv_16_15.A VPWR.t18 sg13_lv_pmos ad=0.2128p pd=1.5u as=0.2128p ps=1.5u w=1.12u l=0.13u
X872 sg13cmos5l_inv_16_2.A sg13cmos5l_inv_16_0.A VPWR.t96 VPWR.t0 sg13_lv_pmos ad=0.2128p pd=1.5u as=0.2128p ps=1.5u w=1.12u l=0.13u
X873 VGND.t172 sg13cmos5l_inv_16_9.Y sg13cmos5l_inv_16_11.Y VGND.t178 sg13_lv_nmos ad=0.1406p pd=1.12u as=0.1406p ps=1.12u w=0.74u l=0.13u
X874 sg13cmos5l_inv_16_23.A sg13cmos5l_inv_16_27.A VPWR.t262 VPWR.t18 sg13_lv_pmos ad=0.2128p pd=1.5u as=0.2128p ps=1.5u w=1.12u l=0.13u
X875 a_24576_1185# sg13cmos5l_xnor2_1_3.B a_24539_916# VGND.t164 sg13_lv_nmos ad=0.2176p pd=1.96u as=78.39999f ps=0.885u w=0.64u l=0.13u
X876 sg13cmos5l_inv_16_3.Y sg13cmos5l_inv_16_5.Y VPWR.t313 VPWR.t0 sg13_lv_pmos ad=0.2128p pd=1.5u as=0.2128p ps=1.5u w=1.12u l=0.13u
X877 VGND.t551 sg13cmos5l_inv_16_23.A sg13cmos5l_inv_16_23.Y VGND.t656 sg13_lv_nmos ad=0.1406p pd=1.12u as=0.1406p ps=1.12u w=0.74u l=0.13u
X878 VPWR.t120 sg13cmos5l_inv_16_24.A sg13cmos5l_inv_16_27.A VPWR.t18 sg13_lv_pmos ad=0.4368p pd=3.02u as=0.2128p ps=1.5u w=1.12u l=0.13u
X879 sg13cmos5l_inv_16_4.Y sg13cmos5l_inv_16_29.Y VPWR.t124 VPWR.t20 sg13_lv_pmos ad=0.2128p pd=1.5u as=0.2128p ps=1.5u w=1.12u l=0.13u
X880 VPWR.t262 VGND.t167 VPWR.t261 VPWR.t18 sg13_lv_pmos ad=0.19p pd=1.38u as=0 ps=0 w=1u l=1u
X881 sg13cmos5l_inv_16_10.Y sg13cmos5l_inv_16_10.A VPWR.t366 VPWR.t0 sg13_lv_pmos ad=0.2128p pd=1.5u as=0.2128p ps=1.5u w=1.12u l=0.13u
X882 VPWR.t96 sg13cmos5l_inv_16_0.A sg13cmos5l_inv_16_2.A VPWR.t0 sg13_lv_pmos ad=0.2128p pd=1.5u as=0.2128p ps=1.5u w=1.12u l=0.13u
X883 sg13cmos5l_inv_16_11.Y sg13cmos5l_inv_16_9.Y VGND.t172 VGND.t175 sg13_lv_nmos ad=0.1406p pd=1.12u as=0.1406p ps=1.12u w=0.74u l=0.13u
X884 VGND.t121 sg13cmos5l_inv_2_7.Y sg13cmos5l_inv_4_6.Y VGND.t127 sg13_lv_nmos ad=0.2516p pd=2.16u as=0.1406p ps=1.12u w=0.74u l=0.13u
X885 sg13cmos5l_inv_4_7.A sg13cmos5l_inv_2_4.A VGND.t22 VGND.t21 sg13_lv_nmos ad=0.1406p pd=1.12u as=0.2516p ps=2.16u w=0.74u l=0.13u
X886 VPWR.t313 sg13cmos5l_inv_16_5.Y sg13cmos5l_inv_16_3.Y VPWR.t0 sg13_lv_pmos ad=0.2128p pd=1.5u as=0.2128p ps=1.5u w=1.12u l=0.13u
X887 sg13cmos5l_inv_16_23.Y sg13cmos5l_inv_16_23.A VGND.t397 VGND.t653 sg13_lv_nmos ad=0.1406p pd=1.12u as=0.2516p ps=2.16u w=0.74u l=0.13u
X888 sg13cmos5l_inv_16_9.Y sg13cmos5l_inv_16_9.A VPWR.t166 VPWR.t20 sg13_lv_pmos ad=0.2128p pd=1.5u as=0.2128p ps=1.5u w=1.12u l=0.13u
X889 VGND.t62 VPWR.t46 VGND.t62 VGND.t436 sg13_lv_nmos ad=0.1428p pd=1.52u as=0 ps=0 w=0.42u l=1u
X890 sg13cmos5l_inv_16_29.Y sg13cmos5l_inv_16_29.A VGND.t384 VGND.t484 sg13_lv_nmos ad=0.1406p pd=1.12u as=0.1406p ps=1.12u w=0.74u l=0.13u
X891 VGND.t390 sg13cmos5l_inv_16_21.A sg13cmos5l_inv_16_21.Y VGND.t698 sg13_lv_nmos ad=0.1406p pd=1.12u as=0.1406p ps=1.12u w=0.74u l=0.13u
X892 sg13cmos5l_inv_2_3.Y sg13cmos5l_inv_2_3.A VGND.t131 VGND.t753 sg13_lv_nmos ad=0.1406p pd=1.12u as=0.2516p ps=2.16u w=0.74u l=0.13u
X893 VPWR.t559 VGND.t312 VPWR.t559 VPWR.t18 sg13_lv_pmos ad=0.34p pd=2.68u as=0 ps=0 w=1u l=1u
X894 VGND.t392 sg13cmos5l_inv_2_5.A sg13cmos5l_inv_4_4.A VGND.t563 sg13_lv_nmos ad=0.2516p pd=2.16u as=0.1406p ps=1.12u w=0.74u l=0.13u
X895 VGND.t32 sg13cmos5l_inv_16_23.Y sg13cmos5l_inv_16_25.Y VGND.t505 sg13_lv_nmos ad=0.1406p pd=1.12u as=0.1406p ps=1.12u w=0.74u l=0.13u
X896 VPWR.t46 sg13cmos5l_inv_16_30.A sg13cmos5l_inv_16_5.A VPWR.t0 sg13_lv_pmos ad=0.2128p pd=1.5u as=0.2128p ps=1.5u w=1.12u l=0.13u
X897 VPWR.t366 sg13cmos5l_inv_16_7.A sg13cmos5l_inv_16_10.A VPWR.t0 sg13_lv_pmos ad=0.2128p pd=1.5u as=0.2128p ps=1.5u w=1.12u l=0.13u
X898 VPWR.t234 sg13cmos5l_inv_16_1.A sg13cmos5l_inv_16_1.Y VPWR.t20 sg13_lv_pmos ad=0.4368p pd=3.02u as=0.2128p ps=1.5u w=1.12u l=0.13u
X899 sg13cmos5l_inv_8_1.A sg13cmos5l_inv_2_3.Y VGND.t131 VGND.t157 sg13_lv_nmos ad=0.1406p pd=1.12u as=0.2516p ps=2.16u w=0.74u l=0.13u
X900 VGND.t41 VPWR.t249 VGND.t41 VGND.t374 sg13_lv_nmos ad=0.1428p pd=1.52u as=0 ps=0 w=0.42u l=1u
X901 sg13cmos5l_inv_16_7.A sg13cmos5l_inv_16_8.A VGND.t568 VGND.t572 sg13_lv_nmos ad=0.1406p pd=1.12u as=0.1406p ps=1.12u w=0.74u l=0.13u
X902 VPWR.t216 VGND.t41 VPWR.t215 VPWR.t20 sg13_lv_pmos ad=0.34p pd=2.68u as=0 ps=0 w=1u l=1u
X903 VPWR.t24 a_26822_874# a_26934_938# VPWR.t0 sg13_lv_pmos ad=0.2254p pd=1.53u as=0.34p ps=2.68u w=1u l=0.5u
X904 VPWR.t532 VGND.t269 VPWR.t530 VPWR.t20 sg13_lv_pmos ad=0.34p pd=2.68u as=0 ps=0 w=1u l=1u
X905 sg13cmos5l_inv_16_5.A sg13cmos5l_inv_16_30.A VPWR.t46 VPWR.t0 sg13_lv_pmos ad=0.2128p pd=1.5u as=0.2128p ps=1.5u w=1.12u l=0.13u
X906 sg13cmos5l_inv_16_10.A sg13cmos5l_inv_16_7.A VPWR.t366 VPWR.t0 sg13_lv_pmos ad=0.2128p pd=1.5u as=0.2128p ps=1.5u w=1.12u l=0.13u
X907 sg13cmos5l_inv_4_2.Y sg13cmos5l_inv_4_2.A VGND.t150 VGND.t149 sg13_lv_nmos ad=0.1406p pd=1.12u as=0.2516p ps=2.16u w=0.74u l=0.13u
X908 VGND.t117 VPWR.t651 VGND.t117 VGND.t322 sg13_lv_nmos ad=79.8f pd=0.8u as=0 ps=0 w=0.42u l=1u
X909 VGND.t872 sg13cmos5l_inv_16_5.A sg13cmos5l_inv_16_5.Y VGND.t876 sg13_lv_nmos ad=0.1406p pd=1.12u as=0.1406p ps=1.12u w=0.74u l=0.13u
X910 VPWR.t17 VGND.t22 VPWR.t17 VPWR.t0 sg13_lv_pmos ad=0.34p pd=2.68u as=0 ps=0 w=1u l=1u
X911 sg13cmos5l_inv_16_22.A sg13cmos5l_inv_16_19.A VPWR.t174 VPWR.t0 sg13_lv_pmos ad=0.2128p pd=1.5u as=0.2128p ps=1.5u w=1.12u l=0.13u
X912 sg13cmos5l_inv_16_3.Y sg13cmos5l_inv_16_5.Y VGND.t133 VGND.t147 sg13_lv_nmos ad=0.1406p pd=1.12u as=0.1406p ps=1.12u w=0.74u l=0.13u
X913 sg13cmos5l_inv_16_16.A sg13cmos5l_inv_16_2.A VGND.t231 VGND.t299 sg13_lv_nmos ad=0.1406p pd=1.12u as=0.1406p ps=1.12u w=0.74u l=0.13u
X914 VPWR.t87 VGND.t41 VPWR.t254 VPWR.t0 sg13_lv_pmos ad=0.34p pd=2.68u as=0 ps=0 w=1u l=1u
X915 VGND.t119 VPWR.t120 VGND.t119 VGND.t337 sg13_lv_nmos ad=0.1428p pd=1.52u as=0 ps=0 w=0.42u l=1u
X916 VPWR.t174 sg13cmos5l_inv_16_19.A sg13cmos5l_inv_16_22.A VPWR.t0 sg13_lv_pmos ad=0.2128p pd=1.5u as=0.2128p ps=1.5u w=1.12u l=0.13u
X917 VGND.t172 sg13cmos5l_inv_16_13.A sg13cmos5l_inv_16_9.A VGND.t178 sg13_lv_nmos ad=0.1406p pd=1.12u as=0.1406p ps=1.12u w=0.74u l=0.13u
X918 sg13cmos5l_inv_16_19.A sg13cmos5l_inv_16_28.A VGND.t585 VGND.t599 sg13_lv_nmos ad=0.1406p pd=1.12u as=0.1406p ps=1.12u w=0.74u l=0.13u
X919 VPWR.t46 sg13cmos5l_inv_16_29.A sg13cmos5l_inv_16_29.Y VPWR.t0 sg13_lv_pmos ad=0.2128p pd=1.5u as=0.2128p ps=1.5u w=1.12u l=0.13u
X920 sg13cmos5l_inv_16_9.A sg13cmos5l_inv_16_13.A VGND.t172 VGND.t175 sg13_lv_nmos ad=0.1406p pd=1.12u as=0.1406p ps=1.12u w=0.74u l=0.13u
X921 sg13cmos5l_inv_16_20.A sg13cmos5l_inv_8_4.A VGND.t62 VGND.t904 sg13_lv_nmos ad=0.1406p pd=1.12u as=0.1406p ps=1.12u w=0.74u l=0.13u
X922 VPWR.t34 VGND.t172 VPWR.t566 VPWR.t20 sg13_lv_pmos ad=0.34p pd=2.68u as=0 ps=0 w=1u l=1u
X923 VGND.t585 sg13cmos5l_inv_16_28.A sg13cmos5l_inv_16_19.A VGND.t594 sg13_lv_nmos ad=0.1406p pd=1.12u as=0.1406p ps=1.12u w=0.74u l=0.13u
X924 VPWR.t232 sg13cmos5l_inv_16_1.A sg13cmos5l_inv_16_1.Y VPWR.t20 sg13_lv_pmos ad=0.2128p pd=1.5u as=0.2128p ps=1.5u w=1.12u l=0.13u
X925 VPWR.t106 a_28160_4097# sg13cmos5l_inv_1_8.A VPWR.t18 sg13_lv_pmos ad=0.1918p pd=1.5u as=0.3808p ps=2.92u w=1.12u l=0.13u
X926 VGND.t568 sg13cmos5l_inv_16_8.A sg13cmos5l_inv_16_7.A VGND.t573 sg13_lv_nmos ad=0.1406p pd=1.12u as=0.1406p ps=1.12u w=0.74u l=0.13u
X927 sg13cmos5l_inv_16_5.A sg13cmos5l_inv_16_30.A VGND.t59 VGND.t60 sg13_lv_nmos ad=0.1406p pd=1.12u as=0.1406p ps=1.12u w=0.74u l=0.13u
X928 sg13cmos5l_inv_16_24.A sg13cmos5l_inv_4_6.Y VPWR.t106 VPWR.t18 sg13_lv_pmos ad=0.2128p pd=1.5u as=0.2128p ps=1.5u w=1.12u l=0.13u
X929 VGND.t41 sg13cmos5l_inv_16_16.A sg13cmos5l_inv_16_18.A VGND.t104 sg13_lv_nmos ad=0.1406p pd=1.12u as=0.1406p ps=1.12u w=0.74u l=0.13u
X930 a_25211_2428# sg13cmos5l_xnor2_1_6.A VGND.t27 VGND.t458 sg13_lv_nmos ad=78.39999f pd=0.885u as=0.2272p ps=1.99u w=0.64u l=0.13u
X931 VGND.t62 sg13cmos5l_inv_8_4.A sg13cmos5l_inv_16_20.A VGND.t899 sg13_lv_nmos ad=0.1406p pd=1.12u as=0.1443p ps=1.13u w=0.74u l=0.13u
X932 sg13cmos5l_inv_16_29.Y sg13cmos5l_inv_16_29.A VPWR.t42 VPWR.t0 sg13_lv_pmos ad=0.2128p pd=1.5u as=0.2128p ps=1.5u w=1.12u l=0.13u
X933 VPWR.t160 sg13cmos5l_inv_16_9.A sg13cmos5l_inv_16_9.Y VPWR.t20 sg13_lv_pmos ad=0.2128p pd=1.5u as=0.2128p ps=1.5u w=1.12u l=0.13u
X934 sg13cmos5l_inv_16_9.Y sg13cmos5l_inv_16_9.A VGND.t361 VGND.t528 sg13_lv_nmos ad=0.1406p pd=1.12u as=0.1406p ps=1.12u w=0.74u l=0.13u
X935 sg13cmos5l_inv_16_12.A sg13cmos5l_inv_4_1.Y VGND.t20 VGND.t539 sg13_lv_nmos ad=0.1406p pd=1.12u as=0.1406p ps=1.12u w=0.74u l=0.13u
X936 VPWR.t396 sg13cmos5l_inv_16_21.A sg13cmos5l_inv_16_21.Y VPWR.t0 sg13_lv_pmos ad=0.2128p pd=1.5u as=0.2128p ps=1.5u w=1.12u l=0.13u
X937 a_28940_3108# osc VPWR.t142 VPWR.t20 sg13_lv_pmos ad=0.2856p pd=2.36u as=0.2114p ps=1.54u w=0.84u l=0.13u
X938 sg13cmos5l_inv_16_7.A sg13cmos5l_inv_16_8.A VGND.t568 VGND.t567 sg13_lv_nmos ad=0.1406p pd=1.12u as=0.2516p ps=2.16u w=0.74u l=0.13u
X939 VGND.t235 VPWR.t19 VGND.t235 VGND.t316 sg13_lv_nmos ad=79.8f pd=0.8u as=0 ps=0 w=0.42u l=1u
X940 VGND.t446 VPWR.t17 VGND.t445 VGND.t444 sg13_lv_nmos ad=0.1428p pd=1.52u as=0 ps=0 w=0.42u l=1u
X941 sg13cmos5l_inv_16_5.A sg13cmos5l_inv_16_30.A VPWR.t46 VPWR.t0 sg13_lv_pmos ad=0.2128p pd=1.5u as=0.2128p ps=1.5u w=1.12u l=0.13u
X942 sg13cmos5l_inv_16_19.A sg13cmos5l_inv_16_28.A VPWR.t174 VPWR.t0 sg13_lv_pmos ad=0.2128p pd=1.5u as=0.2128p ps=1.5u w=1.12u l=0.13u
X943 sg13cmos5l_inv_16_10.A sg13cmos5l_inv_16_7.A VPWR.t366 VPWR.t0 sg13_lv_pmos ad=0.2128p pd=1.5u as=0.2128p ps=1.5u w=1.12u l=0.13u
X944 sg13cmos5l_inv_16_1.Y sg13cmos5l_inv_16_1.A VPWR.t226 VPWR.t20 sg13_lv_pmos ad=0.2128p pd=1.5u as=0.2128p ps=1.5u w=1.12u l=0.13u
X945 VGND.t32 sg13cmos5l_inv_16_23.Y sg13cmos5l_inv_16_25.Y VGND.t503 sg13_lv_nmos ad=0.1406p pd=1.12u as=0.1406p ps=1.12u w=0.74u l=0.13u
X946 VGND.t1 VPWR.t520 VGND.t7 VGND.t369 sg13_lv_nmos ad=79.8f pd=0.8u as=0 ps=0 w=0.42u l=1u
X947 sg13cmos5l_inv_16_18.A sg13cmos5l_inv_16_16.A VGND.t41 VGND.t101 sg13_lv_nmos ad=0.1406p pd=1.12u as=0.1406p ps=1.12u w=0.74u l=0.13u
X948 VGND.t27 sg13cmos5l_dlygate4sd3_1_1.X a_26261_2002# VGND.t806 sg13_lv_nmos ad=0.1898p pd=1.36u as=0.2516p ps=2.16u w=0.74u l=0.13u
X949 VPWR.t41 sg13cmos5l_inv_16_29.A sg13cmos5l_inv_16_29.Y VPWR.t0 sg13_lv_pmos ad=0.2128p pd=1.5u as=0.2128p ps=1.5u w=1.12u l=0.13u
X950 VPWR.t730 VGND.t1 VPWR.t729 VPWR.t20 sg13_lv_pmos ad=0.19p pd=1.38u as=0 ps=0 w=1u l=1u
X951 VGND.t66 VPWR.t419 VGND.t66 VGND.t348 sg13_lv_nmos ad=79.8f pd=0.8u as=0 ps=0 w=0.42u l=1u
X952 VPWR.t249 VGND.t41 VPWR.t248 VPWR.t20 sg13_lv_pmos ad=0.34p pd=2.68u as=0 ps=0 w=1u l=1u
X953 sg13cmos5l_inv_16_21.Y sg13cmos5l_inv_16_21.A VPWR.t586 VPWR.t0 sg13_lv_pmos ad=0.2128p pd=1.5u as=0.2128p ps=1.5u w=1.12u l=0.13u
X954 a_16873_3940# sg13cmos5l_and2_1_4.B VGND.t69 VGND.t78 sg13_lv_nmos ad=0.1216p pd=1.02u as=0.1331p ps=1.12u w=0.64u l=0.13u
X955 VPWR.t1 sg13cmos5l_inv_16_8.A sg13cmos5l_inv_16_7.A VPWR.t0 sg13_lv_pmos ad=0.2128p pd=1.5u as=0.2128p ps=1.5u w=1.12u l=0.13u
X956 VGND.t121 a_28160_4097# sg13cmos5l_inv_1_8.A VGND.t935 sg13_lv_nmos ad=0.1331p pd=1.12u as=0.2516p ps=2.16u w=0.74u l=0.13u
X957 VGND.t82 sg13cmos5l_inv_16_20.A sg13cmos5l_inv_16_30.A VGND.t90 sg13_lv_nmos ad=0.1406p pd=1.12u as=0.1406p ps=1.12u w=0.74u l=0.13u
X958 sg13cmos5l_inv_16_17.Y sg13cmos5l_inv_16_1.Y VGND.t235 VGND.t834 sg13_lv_nmos ad=0.1406p pd=1.12u as=0.1406p ps=1.12u w=0.74u l=0.13u
X959 VPWR.t120 VGND.t119 VPWR.t120 VPWR.t18 sg13_lv_pmos ad=0.34p pd=2.68u as=0 ps=0 w=1u l=1u
X960 VPWR.t569 sg13cmos5l_inv_4_7.A sg13cmos5l_inv_8_7.A VPWR.t20 sg13_lv_pmos ad=0.2128p pd=1.5u as=0.2128p ps=1.5u w=1.12u l=0.13u
X961 sg13cmos5l_inv_16_26.A sg13cmos5l_inv_8_6.A VGND.t69 VGND.t71 sg13_lv_nmos ad=0.1406p pd=1.12u as=0.1406p ps=1.12u w=0.74u l=0.13u
X962 sg13cmos5l_inv_1_0.A a_9357_3940# VPWR.t104 VPWR.t18 sg13_lv_pmos ad=0.3808p pd=2.92u as=0.1918p ps=1.5u w=1.12u l=0.13u
X963 VPWR.t596 VGND.t430 VPWR.t596 VPWR.t0 sg13_lv_pmos ad=0.34p pd=2.68u as=0 ps=0 w=1u l=1u
X964 VPWR.t106 sg13cmos5l_and2_1_7.A a_28160_4097# VPWR.t18 sg13_lv_pmos ad=0.2856p pd=2.36u as=0.1596p ps=1.22u w=0.84u l=0.13u
X965 sg13cmos5l_inv_16_11.Y sg13cmos5l_inv_16_9.Y VGND.t170 VGND.t169 sg13_lv_nmos ad=0.1406p pd=1.12u as=0.2516p ps=2.16u w=0.74u l=0.13u
X966 VGND.t123 sg13cmos5l_xnor2_1_3.A a_24725_874# VGND.t775 sg13_lv_nmos ad=0.1898p pd=1.36u as=0.2516p ps=2.16u w=0.74u l=0.13u
X967 VPWR.t116 VGND.t123 VPWR.t115 VPWR.t0 sg13_lv_pmos ad=0.34p pd=2.68u as=0 ps=0 w=1u l=1u
X968 sg13cmos5l_inv_16_30.A sg13cmos5l_inv_16_20.A VGND.t82 VGND.t87 sg13_lv_nmos ad=0.1406p pd=1.12u as=0.1406p ps=1.12u w=0.74u l=0.13u
X969 VGND.t235 sg13cmos5l_inv_16_1.Y sg13cmos5l_inv_16_17.Y VGND.t831 sg13_lv_nmos ad=0.1406p pd=1.12u as=0.1406p ps=1.12u w=0.74u l=0.13u
X970 a_24518_1632# a_24248_1673# VGND.t24 VGND.t564 sg13_lv_nmos ad=0.1428p pd=1.52u as=79.8f ps=0.8u w=0.42u l=0.5u
X971 VGND.t82 sg13cmos5l_inv_16_20.A sg13cmos5l_inv_16_30.A VGND.t84 sg13_lv_nmos ad=0.1406p pd=1.12u as=0.1406p ps=1.12u w=0.74u l=0.13u
X972 VGND.t780 sg13cmos5l_inv_16_15.A sg13cmos5l_inv_16_14.A VGND.t927 sg13_lv_nmos ad=0.1406p pd=1.12u as=0.1406p ps=1.12u w=0.74u l=0.13u
X973 sg13cmos5l_inv_16_20.A sg13cmos5l_inv_8_4.A VGND.t62 VGND.t900 sg13_lv_nmos ad=0.1406p pd=1.12u as=0.1406p ps=1.12u w=0.74u l=0.13u
X974 sg13cmos5l_inv_16_6.A sg13cmos5l_inv_4_2.Y VGND.t7 VGND.t35 sg13_lv_nmos ad=0.1406p pd=1.12u as=0.1406p ps=1.12u w=0.74u l=0.13u
X975 VPWR.t396 sg13cmos5l_inv_16_22.A sg13cmos5l_inv_16_21.A VPWR.t0 sg13_lv_pmos ad=0.2128p pd=1.5u as=0.2128p ps=1.5u w=1.12u l=0.13u
X976 a_28940_3108# osc VGND.t156 VGND.t825 sg13_lv_nmos ad=0.187p pd=1.78u as=0.14875p ps=1.16u w=0.55u l=0.13u
X977 sg13cmos5l_inv_1_0.A a_9357_3940# VGND.t117 VGND.t116 sg13_lv_nmos ad=0.2516p pd=2.16u as=0.1331p ps=1.12u w=0.74u l=0.13u
X978 sg13cmos5l_inv_16_12.A sg13cmos5l_inv_4_1.Y VGND.t535 VGND.t534 sg13_lv_nmos ad=0.1406p pd=1.12u as=0.2516p ps=2.16u w=0.74u l=0.13u
X979 VPWR.t19 VGND.t235 VPWR.t19 VPWR.t18 sg13_lv_pmos ad=0.19p pd=1.38u as=0 ps=0 w=1u l=1u
X980 VGND.t535 sg13cmos5l_inv_16_12.A sg13cmos5l_inv_16_13.A VGND.t892 sg13_lv_nmos ad=0.1406p pd=1.12u as=0.1406p ps=1.12u w=0.74u l=0.13u
X981 VGND.t69 sg13cmos5l_inv_16_26.A sg13cmos5l_inv_16_31.A VGND.t765 sg13_lv_nmos ad=0.1406p pd=1.12u as=0.1406p ps=1.12u w=0.74u l=0.13u
X982 VPWR.t41 VGND.t45 VPWR.t41 VPWR.t0 sg13_lv_pmos ad=0.34p pd=2.68u as=0 ps=0 w=1u l=1u
X983 sg13cmos5l_inv_16_21.A sg13cmos5l_inv_16_22.A VPWR.t396 VPWR.t0 sg13_lv_pmos ad=0.2128p pd=1.5u as=0.2128p ps=1.5u w=1.12u l=0.13u
X984 sg13cmos5l_inv_16_10.A sg13cmos5l_inv_16_7.A VGND.t361 VGND.t528 sg13_lv_nmos ad=0.1406p pd=1.12u as=0.1406p ps=1.12u w=0.74u l=0.13u
X985 VPWR.t78 VGND.t62 VPWR.t78 VPWR.t0 sg13_lv_pmos ad=0.34p pd=2.68u as=0 ps=0 w=1u l=1u
X986 sg13cmos5l_inv_16_14.A sg13cmos5l_inv_16_15.A VPWR.t128 VPWR.t20 sg13_lv_pmos ad=0.2128p pd=1.5u as=0.2128p ps=1.5u w=1.12u l=0.13u
X987 sg13cmos5l_inv_16_21.Y sg13cmos5l_inv_16_21.A VPWR.t78 VPWR.t0 sg13_lv_pmos ad=0.2128p pd=1.5u as=0.2128p ps=1.5u w=1.12u l=0.13u
X988 sg13cmos5l_inv_16_23.A sg13cmos5l_inv_16_27.A VGND.t269 VGND.t279 sg13_lv_nmos ad=0.1406p pd=1.12u as=0.1406p ps=1.12u w=0.74u l=0.13u
X989 VGND.t64 a_25958_874# a_26070_938# VGND.t263 sg13_lv_nmos ad=0.1426p pd=1.16u as=0.1428p ps=1.52u w=0.42u l=0.5u
X990 sg13cmos5l_inv_16_31.A sg13cmos5l_inv_16_26.A VGND.t69 VGND.t762 sg13_lv_nmos ad=0.1406p pd=1.12u as=0.1406p ps=1.12u w=0.74u l=0.13u
X991 sg13cmos5l_inv_16_25.Y sg13cmos5l_inv_16_23.Y VGND.t32 VGND.t496 sg13_lv_nmos ad=0.1406p pd=1.12u as=0.2516p ps=2.16u w=0.74u l=0.13u
X992 VGND.t119 sg13cmos5l_inv_16_24.A sg13cmos5l_inv_16_27.A VGND.t799 sg13_lv_nmos ad=0.1406p pd=1.12u as=0.1406p ps=1.12u w=0.74u l=0.13u
X993 VPWR.t104 sg13cmos5l_and2_1_3.B a_9357_3940# VPWR.t18 sg13_lv_pmos ad=0.1918p pd=1.5u as=0.1596p ps=1.22u w=0.84u l=0.13u
X994 VPWR.t521 VGND.t7 VPWR.t520 VPWR.t20 sg13_lv_pmos ad=0.19p pd=1.38u as=0 ps=0 w=1u l=1u
X995 VGND.t430 VPWR.t596 VGND.t432 VGND.t431 sg13_lv_nmos ad=79.8f pd=0.8u as=0 ps=0 w=0.42u l=1u
X996 VGND.t269 sg13cmos5l_inv_16_27.A sg13cmos5l_inv_16_23.A VGND.t276 sg13_lv_nmos ad=0.1406p pd=1.12u as=0.1406p ps=1.12u w=0.74u l=0.13u
X997 sg13cmos5l_inv_16_10.Y sg13cmos5l_inv_16_10.A VGND.t426 VGND.t671 sg13_lv_nmos ad=0.1406p pd=1.12u as=0.1406p ps=1.12u w=0.74u l=0.13u
X998 VGND.t312 sg13cmos5l_inv_16_12.A sg13cmos5l_inv_16_13.A VGND.t888 sg13_lv_nmos ad=0.1406p pd=1.12u as=0.1406p ps=1.12u w=0.74u l=0.13u
X999 VGND.t190 sg13cmos5l_inv_16_23.A sg13cmos5l_inv_16_23.Y VGND.t666 sg13_lv_nmos ad=0.1406p pd=1.12u as=0.1406p ps=1.12u w=0.74u l=0.13u
X1000 sg13cmos5l_inv_16_4.Y sg13cmos5l_inv_16_29.Y VPWR.t134 VPWR.t20 sg13_lv_pmos ad=0.2128p pd=1.5u as=0.2128p ps=1.5u w=1.12u l=0.13u
X1001 sg13cmos5l_inv_16_1.A sg13cmos5l_inv_16_14.A VPWR.t234 VPWR.t20 sg13_lv_pmos ad=0.2128p pd=1.5u as=0.2128p ps=1.5u w=1.12u l=0.13u
X1002 sg13cmos5l_inv_16_27.A sg13cmos5l_inv_16_24.A VGND.t119 VGND.t796 sg13_lv_nmos ad=0.1406p pd=1.12u as=0.1406p ps=1.12u w=0.74u l=0.13u
X1003 VPWR.t105 a_24236_3108# sg13cmos5l_and2_1_7.B VPWR.t20 sg13_lv_pmos ad=0.2114p pd=1.54u as=0.42p ps=2.99u w=1.12u l=0.13u
X1004 sg13cmos5l_inv_16_9.A sg13cmos5l_inv_16_13.A VGND.t170 VGND.t169 sg13_lv_nmos ad=0.1406p pd=1.12u as=0.2516p ps=2.16u w=0.74u l=0.13u
X1005 VPWR.t41 VGND.t432 VPWR.t41 VPWR.t0 sg13_lv_pmos ad=0.34p pd=2.68u as=0 ps=0 w=1u l=1u
X1006 sg13cmos5l_inv_16_14.A sg13cmos5l_inv_16_15.A VPWR.t124 VPWR.t20 sg13_lv_pmos ad=0.2128p pd=1.5u as=0.2128p ps=1.5u w=1.12u l=0.13u
X1007 sg13cmos5l_inv_16_23.A sg13cmos5l_inv_16_27.A VGND.t269 VGND.t273 sg13_lv_nmos ad=0.1406p pd=1.12u as=0.1406p ps=1.12u w=0.74u l=0.13u
X1008 VPWR.t313 sg13cmos5l_inv_16_5.Y sg13cmos5l_inv_16_3.Y VPWR.t0 sg13_lv_pmos ad=0.2128p pd=1.5u as=0.2128p ps=1.5u w=1.12u l=0.13u
X1009 sg13cmos5l_inv_16_13.A sg13cmos5l_inv_16_12.A VGND.t312 VGND.t885 sg13_lv_nmos ad=0.1406p pd=1.12u as=0.1406p ps=1.12u w=0.74u l=0.13u
X1010 sg13cmos5l_inv_16_23.Y sg13cmos5l_inv_16_23.A VGND.t190 VGND.t663 sg13_lv_nmos ad=0.1406p pd=1.12u as=0.1406p ps=1.12u w=0.74u l=0.13u
X1011 VPWR.t358 sg13cmos5l_inv_16_23.A sg13cmos5l_inv_16_23.Y VPWR.t20 sg13_lv_pmos ad=0.2128p pd=1.5u as=0.2128p ps=1.5u w=1.12u l=0.13u
X1012 VGND.t267 sg13cmos5l_xnor2_1_4.Y a_27029_2386# VGND.t565 sg13_lv_nmos ad=0.1898p pd=1.36u as=0.2516p ps=2.16u w=0.74u l=0.13u
X1013 VGND.t172 sg13cmos5l_inv_16_9.Y sg13cmos5l_inv_16_11.Y VGND.t184 sg13_lv_nmos ad=0.1406p pd=1.12u as=0.1406p ps=1.12u w=0.74u l=0.13u
X1014 sg13cmos5l_inv_4_7.A sg13cmos5l_inv_2_4.A VPWR.t21 VPWR.t20 sg13_lv_pmos ad=0.2128p pd=1.5u as=0.3808p ps=2.92u w=1.12u l=0.13u
X1015 sg13cmos5l_inv_16_23.Y sg13cmos5l_inv_16_23.A VPWR.t352 VPWR.t20 sg13_lv_pmos ad=0.2128p pd=1.5u as=0.3808p ps=2.92u w=1.12u l=0.13u
X1016 sg13cmos5l_inv_16_21.A sg13cmos5l_inv_16_22.A VPWR.t396 VPWR.t0 sg13_lv_pmos ad=0.2128p pd=1.5u as=0.2128p ps=1.5u w=1.12u l=0.13u
X1017 VPWR.t40 sg13cmos5l_inv_2_5.A sg13cmos5l_inv_4_4.A VPWR.t20 sg13_lv_pmos ad=0.3808p pd=2.92u as=0.2128p ps=1.5u w=1.12u l=0.13u
X1018 sg13cmos5l_inv_16_5.Y sg13cmos5l_inv_16_5.A VGND.t872 VGND.t877 sg13_lv_nmos ad=0.1406p pd=1.12u as=0.1406p ps=1.12u w=0.74u l=0.13u
X1019 sg13cmos5l_inv_16_21.Y sg13cmos5l_inv_16_21.A VGND.t392 VGND.t708 sg13_lv_nmos ad=0.1406p pd=1.12u as=0.1406p ps=1.12u w=0.74u l=0.13u
X1020 sg13cmos5l_inv_16_18.A sg13cmos5l_inv_16_16.A VPWR.t87 VPWR.t0 sg13_lv_pmos ad=0.2128p pd=1.5u as=0.2128p ps=1.5u w=1.12u l=0.13u
X1021 sg13cmos5l_inv_16_31.A sg13cmos5l_inv_16_26.A VPWR.t510 VPWR.t20 sg13_lv_pmos ad=0.2128p pd=1.5u as=0.2128p ps=1.5u w=1.12u l=0.13u
X1022 VGND.t7 sg13cmos5l_inv_16_6.A sg13cmos5l_inv_16_8.A VGND.t6 sg13_lv_nmos ad=0.1406p pd=1.12u as=0.1406p ps=1.12u w=0.74u l=0.13u
X1023 sg13cmos5l_inv_2_7.Y sg13cmos5l_inv_1_8.Y VPWR.t106 VPWR.t18 sg13_lv_pmos ad=0.2128p pd=1.5u as=0.3864p ps=2.93u w=1.12u l=0.13u
X1024 VGND.t231 sg13cmos5l_inv_16_2.A sg13cmos5l_inv_16_16.A VGND.t300 sg13_lv_nmos ad=0.1406p pd=1.12u as=0.1406p ps=1.12u w=0.74u l=0.13u
X1025 VPWR.t497 sg13cmos5l_and2_1_7.A a_23648_3403# VPWR.t20 sg13_lv_pmos ad=0.2856p pd=2.36u as=0.1596p ps=1.22u w=0.84u l=0.13u
X1026 VPWR.t36 sg13cmos5l_inv_16_7.A sg13cmos5l_inv_16_10.A VPWR.t0 sg13_lv_pmos ad=0.4368p pd=3.02u as=0.2128p ps=1.5u w=1.12u l=0.13u
X1027 VGND.t119 a_24236_3108# sg13cmos5l_and2_1_7.B VGND.t118 sg13_lv_nmos ad=0.14875p pd=1.16u as=0.2886p ps=2.26u w=0.74u l=0.13u
X1028 VPWR.t87 sg13cmos5l_inv_16_16.A sg13cmos5l_inv_16_18.A VPWR.t0 sg13_lv_pmos ad=0.2128p pd=1.5u as=0.2128p ps=1.5u w=1.12u l=0.13u
X1029 sg13cmos5l_inv_16_27.A sg13cmos5l_inv_16_24.A VGND.t119 VGND.t792 sg13_lv_nmos ad=0.1406p pd=1.12u as=0.1406p ps=1.12u w=0.74u l=0.13u
X1030 VGND.t585 sg13cmos5l_inv_16_28.A sg13cmos5l_inv_16_19.A VGND.t600 sg13_lv_nmos ad=0.2516p pd=2.16u as=0.1406p ps=1.12u w=0.74u l=0.13u
X1031 VPWR.t358 sg13cmos5l_inv_16_23.Y sg13cmos5l_inv_16_25.Y VPWR.t20 sg13_lv_pmos ad=0.4368p pd=3.02u as=0.2128p ps=1.5u w=1.12u l=0.13u
X1032 sg13cmos5l_inv_16_8.A sg13cmos5l_inv_16_6.A VGND.t1 VGND.t3 sg13_lv_nmos ad=0.1406p pd=1.12u as=0.1406p ps=1.12u w=0.74u l=0.13u
X1033 sg13cmos5l_inv_16_19.A sg13cmos5l_inv_16_28.A VGND.t585 VGND.t595 sg13_lv_nmos ad=0.1406p pd=1.12u as=0.1406p ps=1.12u w=0.74u l=0.13u
X1034 VPWR.t226 sg13cmos5l_inv_16_14.A sg13cmos5l_inv_16_1.A VPWR.t20 sg13_lv_pmos ad=0.2128p pd=1.5u as=0.2128p ps=1.5u w=1.12u l=0.13u
X1035 sg13cmos5l_inv_16_7.A sg13cmos5l_inv_16_8.A VGND.t568 VGND.t574 sg13_lv_nmos ad=0.1406p pd=1.12u as=0.1406p ps=1.12u w=0.74u l=0.13u
X1036 sg13cmos5l_inv_16_13.A sg13cmos5l_inv_16_12.A VPWR.t729 VPWR.t20 sg13_lv_pmos ad=0.2128p pd=1.5u as=0.3808p ps=2.92u w=1.12u l=0.13u
X1037 sg13cmos5l_inv_16_25.Y sg13cmos5l_inv_16_23.Y VPWR.t356 VPWR.t20 sg13_lv_pmos ad=0.2128p pd=1.5u as=0.2128p ps=1.5u w=1.12u l=0.13u
X1038 VPWR.t46 sg13cmos5l_inv_16_20.A sg13cmos5l_inv_16_30.A VPWR.t0 sg13_lv_pmos ad=0.2128p pd=1.5u as=0.2128p ps=1.5u w=1.12u l=0.13u
X1039 VGND.t568 sg13cmos5l_inv_16_8.A sg13cmos5l_inv_16_7.A VGND.t569 sg13_lv_nmos ad=0.1406p pd=1.12u as=0.1406p ps=1.12u w=0.74u l=0.13u
X1040 VGND.t267 sg13cmos5l_xnor2_1_0.Y a_27029_2002# VGND.t565 sg13_lv_nmos ad=0.1898p pd=1.36u as=0.2516p ps=2.16u w=0.74u l=0.13u
X1041 VPWR.t46 VGND.t417 VPWR.t46 VPWR.t0 sg13_lv_pmos ad=0.34p pd=2.68u as=0 ps=0 w=1u l=1u
X1042 VGND.t172 sg13cmos5l_inv_16_13.A sg13cmos5l_inv_16_9.A VGND.t184 sg13_lv_nmos ad=0.1406p pd=1.12u as=0.1406p ps=1.12u w=0.74u l=0.13u
X1043 sg13cmos5l_inv_16_29.A sg13cmos5l_inv_16_31.A VGND.t80 VGND.t644 sg13_lv_nmos ad=0.1406p pd=1.12u as=0.1406p ps=1.12u w=0.74u l=0.13u
X1044 sg13cmos5l_inv_16_30.A sg13cmos5l_inv_16_20.A VPWR.t46 VPWR.t0 sg13_lv_pmos ad=0.2128p pd=1.5u as=0.2128p ps=1.5u w=1.12u l=0.13u
X1045 VGND.t361 VPWR.t34 VGND.t361 VGND.t360 sg13_lv_nmos ad=0.1428p pd=1.52u as=0 ps=0 w=0.42u l=1u
X1046 VPWR.t14 sg13cmos5l_inv_4_2.Y sg13cmos5l_inv_16_6.A VPWR.t0 sg13_lv_pmos ad=0.2128p pd=1.5u as=0.2128p ps=1.5u w=1.12u l=0.13u
X1047 sg13cmos5l_inv_16_18.A sg13cmos5l_inv_16_16.A VGND.t41 VGND.t113 sg13_lv_nmos ad=0.1406p pd=1.12u as=0.1406p ps=1.12u w=0.74u l=0.13u
X1048 sg13cmos5l_inv_16_9.Y sg13cmos5l_inv_16_9.A VPWR.t168 VPWR.t20 sg13_lv_pmos ad=0.2128p pd=1.5u as=0.2128p ps=1.5u w=1.12u l=0.13u
X1049 sg13cmos5l_inv_16_2.A sg13cmos5l_inv_16_0.A VGND.t249 VGND.t613 sg13_lv_nmos ad=0.1406p pd=1.12u as=0.1406p ps=1.12u w=0.74u l=0.13u
X1050 VGND.t80 sg13cmos5l_inv_16_31.A sg13cmos5l_inv_16_29.A VGND.t641 sg13_lv_nmos ad=0.1406p pd=1.12u as=0.1406p ps=1.12u w=0.74u l=0.13u
X1051 sg13cmos5l_inv_16_9.A sg13cmos5l_inv_16_13.A VPWR.t166 VPWR.t20 sg13_lv_pmos ad=0.2128p pd=1.5u as=0.2128p ps=1.5u w=1.12u l=0.13u
X1052 VGND.t41 sg13cmos5l_inv_16_16.A sg13cmos5l_inv_16_18.A VGND.t110 sg13_lv_nmos ad=0.1406p pd=1.12u as=0.1406p ps=1.12u w=0.74u l=0.13u
X1053 VPWR.t1 sg13cmos5l_inv_16_6.A sg13cmos5l_inv_16_8.A VPWR.t0 sg13_lv_pmos ad=0.2128p pd=1.5u as=0.2128p ps=1.5u w=1.12u l=0.13u
X1054 VPWR.t24 VGND.t455 VPWR.t24 VPWR.t0 sg13_lv_pmos ad=0.19p pd=1.38u as=0 ps=0 w=1u l=1u
X1055 VGND.t167 sg13cmos5l_inv_1_5.A sg13cmos5l_inv_2_4.A VGND.t166 sg13_lv_nmos ad=0.2516p pd=2.16u as=0.2516p ps=2.16u w=0.74u l=0.13u
X1056 a_24730_2350# sg13cmos5l_dlygate4sd3_1_0.A VGND.t27 VGND.t619 sg13_lv_nmos ad=0.1428p pd=1.52u as=79.8f ps=0.8u w=0.42u l=0.13u
X1057 sg13cmos5l_inv_16_18.A sg13cmos5l_inv_16_16.A VGND.t41 VGND.t107 sg13_lv_nmos ad=0.1406p pd=1.12u as=0.1406p ps=1.12u w=0.74u l=0.13u
X1058 VGND.t62 sg13cmos5l_inv_8_4.A sg13cmos5l_inv_16_20.A VGND.t901 sg13_lv_nmos ad=0.1406p pd=1.12u as=0.1406p ps=1.12u w=0.74u l=0.13u
X1059 sg13cmos5l_inv_16_8.A sg13cmos5l_inv_16_6.A VPWR.t1 VPWR.t0 sg13_lv_pmos ad=0.2128p pd=1.5u as=0.2128p ps=1.5u w=1.12u l=0.13u
X1060 VGND.t324 sg13cmos5l_inv_16_14.A sg13cmos5l_inv_16_1.A VGND.t747 sg13_lv_nmos ad=0.2516p pd=2.16u as=0.1406p ps=1.12u w=0.74u l=0.13u
X1061 VGND.t712 sg13cmos5l_inv_16_22.A sg13cmos5l_inv_16_21.A VGND.t715 sg13_lv_nmos ad=0.1406p pd=1.12u as=0.1406p ps=1.12u w=0.74u l=0.13u
X1062 sg13cmos5l_inv_16_17.Y sg13cmos5l_inv_16_1.Y VGND.t117 VGND.t840 sg13_lv_nmos ad=0.1406p pd=1.12u as=0.1406p ps=1.12u w=0.74u l=0.13u
X1063 sg13cmos5l_inv_4_5.A sg13cmos5l_inv_1_4.Y VPWR.t218 VPWR.t18 sg13_lv_pmos ad=0.2128p pd=1.5u as=0.3808p ps=2.92u w=1.12u l=0.13u
X1064 sg13cmos5l_inv_16_1.A sg13cmos5l_inv_16_14.A VGND.t117 VGND.t744 sg13_lv_nmos ad=0.1406p pd=1.12u as=0.1406p ps=1.12u w=0.74u l=0.13u
X1065 VGND.t453 VPWR.t24 VGND.t455 VGND.t454 sg13_lv_nmos ad=79.8f pd=0.8u as=0 ps=0 w=0.42u l=1u
X1066 VGND.t64 sg13cmos5l_dlygate4sd3_1_3.X a_26552_874# VGND.t259 sg13_lv_nmos ad=79.8f pd=0.8u as=0.1428p ps=1.52u w=0.42u l=0.13u
X1067 sg13cmos5l_inv_16_16.A sg13cmos5l_inv_16_2.A VPWR.t96 VPWR.t0 sg13_lv_pmos ad=0.2128p pd=1.5u as=0.2128p ps=1.5u w=1.12u l=0.13u
X1068 VGND.t390 sg13cmos5l_inv_4_4.A sg13cmos5l_inv_8_4.A VGND.t937 sg13_lv_nmos ad=0.1406p pd=1.12u as=0.1406p ps=1.12u w=0.74u l=0.13u
X1069 sg13cmos5l_inv_16_18.Y sg13cmos5l_inv_16_18.A VGND.t150 VGND.t216 sg13_lv_nmos ad=0.1406p pd=1.12u as=0.2516p ps=2.16u w=0.74u l=0.13u
X1070 sg13cmos5l_inv_16_30.A sg13cmos5l_inv_16_20.A VGND.t82 VGND.t93 sg13_lv_nmos ad=0.1406p pd=1.12u as=0.1406p ps=1.12u w=0.74u l=0.13u
X1071 VGND.t235 sg13cmos5l_inv_16_1.Y sg13cmos5l_inv_16_17.Y VGND.t837 sg13_lv_nmos ad=0.1406p pd=1.12u as=0.1406p ps=1.12u w=0.74u l=0.13u
X1072 VPWR.t182 sg13cmos5l_inv_16_9.Y sg13cmos5l_inv_16_11.Y VPWR.t18 sg13_lv_pmos ad=0.2128p pd=1.5u as=0.2128p ps=1.5u w=1.12u l=0.13u
X1073 VGND.t73 sg13cmos5l_inv_8_6.A sg13cmos5l_inv_16_26.A VGND.t75 sg13_lv_nmos ad=0.1406p pd=1.12u as=0.1406p ps=1.12u w=0.74u l=0.13u
X1074 sg13cmos5l_inv_4_2.Y sg13cmos5l_inv_4_2.A VPWR.t14 VPWR.t0 sg13_lv_pmos ad=0.2128p pd=1.5u as=0.2128p ps=1.5u w=1.12u l=0.13u
X1075 VGND.t417 sg13cmos5l_inv_16_31.A sg13cmos5l_inv_16_29.A VGND.t637 sg13_lv_nmos ad=0.1406p pd=1.12u as=0.1406p ps=1.12u w=0.74u l=0.13u
X1076 VGND.t7 sg13cmos5l_inv_4_1.A sg13cmos5l_inv_4_1.Y VGND.t822 sg13_lv_nmos ad=0.1406p pd=1.12u as=0.1406p ps=1.12u w=0.74u l=0.13u
X1077 VGND.t366 VPWR.t729 VGND.t365 VGND.t364 sg13_lv_nmos ad=0.1428p pd=1.52u as=0 ps=0 w=0.42u l=1u
X1078 VPWR.t34 VGND.t361 VPWR.t566 VPWR.t20 sg13_lv_pmos ad=0.34p pd=2.68u as=0 ps=0 w=1u l=1u
X1079 VGND.t426 sg13cmos5l_inv_16_10.A sg13cmos5l_inv_16_10.Y VGND.t672 sg13_lv_nmos ad=0.1406p pd=1.12u as=0.1406p ps=1.12u w=0.74u l=0.13u
X1080 sg13cmos5l_inv_16_11.Y sg13cmos5l_inv_16_9.Y VPWR.t182 VPWR.t18 sg13_lv_pmos ad=0.2128p pd=1.5u as=0.2128p ps=1.5u w=1.12u l=0.13u
X1081 sg13cmos5l_inv_16_12.A sg13cmos5l_inv_4_1.Y VGND.t20 VGND.t541 sg13_lv_nmos ad=0.1443p pd=1.13u as=0.1406p ps=1.12u w=0.74u l=0.13u
X1082 VPWR.t106 sg13cmos5l_inv_2_7.Y sg13cmos5l_inv_4_6.Y VPWR.t18 sg13_lv_pmos ad=0.3808p pd=2.92u as=0.2128p ps=1.5u w=1.12u l=0.13u
X1083 sg13cmos5l_inv_16_18.Y sg13cmos5l_inv_16_18.A VPWR.t87 VPWR.t0 sg13_lv_pmos ad=0.2128p pd=1.5u as=0.2128p ps=1.5u w=1.12u l=0.13u
X1084 sg13cmos5l_inv_16_0.A sg13cmos5l_inv_4_0.Y VGND.t324 VGND.t819 sg13_lv_nmos ad=0.1443p pd=1.13u as=0.1406p ps=1.12u w=0.74u l=0.13u
X1085 a_25397_2386# sg13cmos5l_dlygate4sd3_1_0.A VGND.t27 VGND.t621 sg13_lv_nmos ad=0.1406p pd=1.12u as=0.1898p ps=1.36u w=0.74u l=0.13u
X1086 sg13cmos5l_inv_16_16.A sg13cmos5l_inv_16_2.A VPWR.t96 VPWR.t0 sg13_lv_pmos ad=0.2128p pd=1.5u as=0.2128p ps=1.5u w=1.12u l=0.13u
X1087 VPWR.t160 sg13cmos5l_inv_16_13.A sg13cmos5l_inv_16_9.A VPWR.t20 sg13_lv_pmos ad=0.2128p pd=1.5u as=0.2128p ps=1.5u w=1.12u l=0.13u
X1088 sg13cmos5l_inv_16_8.A sg13cmos5l_inv_16_6.A VPWR.t1 VPWR.t0 sg13_lv_pmos ad=0.2128p pd=1.5u as=0.2128p ps=1.5u w=1.12u l=0.13u
X1089 VPWR.t87 sg13cmos5l_inv_16_18.A sg13cmos5l_inv_16_18.Y VPWR.t0 sg13_lv_pmos ad=0.2128p pd=1.5u as=0.2128p ps=1.5u w=1.12u l=0.13u
X1090 sg13cmos5l_inv_16_21.A sg13cmos5l_inv_16_22.A VGND.t712 VGND.t716 sg13_lv_nmos ad=0.1406p pd=1.12u as=0.1406p ps=1.12u w=0.74u l=0.13u
X1091 sg13cmos5l_inv_8_1.A sg13cmos5l_inv_2_3.Y VPWR.t58 VPWR.t18 sg13_lv_pmos ad=0.2128p pd=1.5u as=0.3808p ps=2.92u w=1.12u l=0.13u
X1092 VPWR.t313 sg13cmos5l_inv_16_0.A sg13cmos5l_inv_16_2.A VPWR.t0 sg13_lv_pmos ad=0.4368p pd=3.02u as=0.2128p ps=1.5u w=1.12u l=0.13u
X1093 sg13cmos5l_xnor2_1_6.A sg13cmos5l_inv_4_8.A VPWR.t516 VPWR.t20 sg13_lv_pmos ad=0.2128p pd=1.5u as=0.2128p ps=1.5u w=1.12u l=0.13u
X1094 sg13cmos5l_inv_16_13.A sg13cmos5l_inv_16_12.A VGND.t535 VGND.t895 sg13_lv_nmos ad=0.1406p pd=1.12u as=0.1406p ps=1.12u w=0.74u l=0.13u
X1095 VPWR.t538 sg13cmos5l_inv_16_23.A sg13cmos5l_inv_16_23.Y VPWR.t20 sg13_lv_pmos ad=0.2128p pd=1.5u as=0.2128p ps=1.5u w=1.12u l=0.13u
X1096 sg13cmos5l_dlygate4sd3_1_1.X a_25494_1656# VPWR.t24 VPWR.t0 sg13_lv_pmos ad=0.4256p pd=3u as=0.2254p ps=1.53u w=1.12u l=0.13u
X1097 a_25306_3108# sg13cmos5l_xnor2_1_6.A VPWR.t307 VPWR.t20 sg13_lv_pmos ad=0.1428p pd=1.52u as=0.1523p ps=1.38u w=0.42u l=0.13u
X1098 VPWR.t391 sg13cmos5l_inv_4_1.Y sg13cmos5l_inv_16_12.A VPWR.t20 sg13_lv_pmos ad=0.2128p pd=1.5u as=0.2128p ps=1.5u w=1.12u l=0.13u
X1099 VGND.t45 VPWR.t41 VGND.t45 VGND.t435 sg13_lv_nmos ad=0.1428p pd=1.52u as=0 ps=0 w=0.42u l=1u
X1100 sg13cmos5l_inv_16_15.A sg13cmos5l_inv_8_1.A VGND.t780 VGND.t783 sg13_lv_nmos ad=0.1406p pd=1.12u as=0.1406p ps=1.12u w=0.74u l=0.13u
X1101 sg13cmos5l_inv_16_25.Y sg13cmos5l_inv_16_23.Y VPWR.t350 VPWR.t20 sg13_lv_pmos ad=0.2128p pd=1.5u as=0.2128p ps=1.5u w=1.12u l=0.13u
X1102 VGND.t269 sg13cmos5l_inv_16_27.A sg13cmos5l_inv_16_23.A VGND.t282 sg13_lv_nmos ad=0.1406p pd=1.12u as=0.1406p ps=1.12u w=0.74u l=0.13u
X1103 sg13cmos5l_inv_16_23.Y sg13cmos5l_inv_16_23.A VPWR.t532 VPWR.t20 sg13_lv_pmos ad=0.2128p pd=1.5u as=0.2128p ps=1.5u w=1.12u l=0.13u
X1104 VGND.t872 sg13cmos5l_inv_16_5.A sg13cmos5l_inv_16_5.Y VGND.t878 sg13_lv_nmos ad=0.1406p pd=1.12u as=0.1406p ps=1.12u w=0.74u l=0.13u
X1105 a_27123_2680# sg13cmos5l_xnor2_1_4.Y VPWR.t260 VPWR.t20 sg13_lv_pmos ad=0.1428p pd=1.375u as=0.2891p ps=1.695u w=1.12u l=0.13u
X1106 VGND.t780 sg13cmos5l_inv_8_1.A sg13cmos5l_inv_16_15.A VGND.t779 sg13_lv_nmos ad=0.1406p pd=1.12u as=0.1406p ps=1.12u w=0.74u l=0.13u
X1107 VGND.t399 VPWR.t568 VGND.t401 VGND.t400 sg13_lv_nmos ad=79.8f pd=0.8u as=0 ps=0 w=0.42u l=1u
X1108 VPWR.t348 sg13cmos5l_inv_16_23.Y sg13cmos5l_inv_16_25.Y VPWR.t20 sg13_lv_pmos ad=0.2128p pd=1.5u as=0.2128p ps=1.5u w=1.12u l=0.13u
X1109 sg13cmos5l_inv_16_31.A sg13cmos5l_inv_16_26.A VGND.t69 VGND.t768 sg13_lv_nmos ad=0.1406p pd=1.12u as=0.1406p ps=1.12u w=0.74u l=0.13u
X1110 VPWR.t252 sg13cmos5l_inv_16_1.Y sg13cmos5l_inv_16_17.Y VPWR.t20 sg13_lv_pmos ad=0.2128p pd=1.5u as=0.2128p ps=1.5u w=1.12u l=0.13u
X1111 sg13cmos5l_inv_16_16.A sg13cmos5l_inv_16_2.A VGND.t231 VGND.t301 sg13_lv_nmos ad=0.1406p pd=1.12u as=0.1406p ps=1.12u w=0.74u l=0.13u
X1112 VGND.t121 sg13cmos5l_inv_1_8.A sg13cmos5l_inv_1_8.Y VGND.t802 sg13_lv_nmos ad=0.2516p pd=2.16u as=0.2516p ps=2.16u w=0.74u l=0.13u
X1113 sg13cmos5l_inv_16_6.A sg13cmos5l_inv_4_2.Y VGND.t7 VGND.t37 sg13_lv_nmos ad=0.1406p pd=1.12u as=0.1406p ps=1.12u w=0.74u l=0.13u
X1114 VGND.t7 sg13cmos5l_inv_16_6.A sg13cmos5l_inv_16_8.A VGND.t17 sg13_lv_nmos ad=0.2516p pd=2.16u as=0.1406p ps=1.12u w=0.74u l=0.13u
X1115 sg13cmos5l_inv_16_1.Y sg13cmos5l_inv_16_1.A VGND.t41 VGND.t247 sg13_lv_nmos ad=0.1406p pd=1.12u as=0.1406p ps=1.12u w=0.74u l=0.13u
X1116 sg13cmos5l_inv_16_17.Y sg13cmos5l_inv_16_1.Y VPWR.t251 VPWR.t20 sg13_lv_pmos ad=0.2128p pd=1.5u as=0.2128p ps=1.5u w=1.12u l=0.13u
X1117 sg13cmos5l_inv_2_1.A sg13cmos5l_inv_1_3.A VGND.t235 VGND.t812 sg13_lv_nmos ad=0.2516p pd=2.16u as=0.2516p ps=2.16u w=0.74u l=0.13u
X1118 VGND.t235 VPWR.t19 VGND.t235 VGND.t315 sg13_lv_nmos ad=0.1428p pd=1.52u as=0 ps=0 w=0.42u l=1u
X1119 sg13cmos5l_inv_16_0.A sg13cmos5l_inv_4_0.Y VGND.t324 VGND.t815 sg13_lv_nmos ad=0.1406p pd=1.12u as=0.1406p ps=1.12u w=0.74u l=0.13u
X1120 VGND.t1 VPWR.t520 VGND.t1 VGND.t368 sg13_lv_nmos ad=0.1428p pd=1.52u as=0 ps=0 w=0.42u l=1u
X1121 VPWR.t119 VGND.t131 VPWR.t119 VPWR.t18 sg13_lv_pmos ad=0.34p pd=2.68u as=0 ps=0 w=1u l=1u
X1122 VPWR.t729 VGND.t365 VPWR.t839 VPWR.t20 sg13_lv_pmos ad=0.34p pd=2.68u as=0 ps=0 w=1u l=1u
X1123 VGND.t585 sg13cmos5l_inv_16_28.A sg13cmos5l_inv_16_19.A VGND.t596 sg13_lv_nmos ad=0.1406p pd=1.12u as=0.1406p ps=1.12u w=0.74u l=0.13u
X1124 VPWR.t78 sg13cmos5l_inv_8_4.A sg13cmos5l_inv_16_20.A VPWR.t0 sg13_lv_pmos ad=0.2128p pd=1.5u as=0.2128p ps=1.5u w=1.12u l=0.13u
X1125 sg13cmos5l_inv_16_19.A sg13cmos5l_inv_16_28.A VPWR.t403 VPWR.t0 sg13_lv_pmos ad=0.2128p pd=1.5u as=0.3808p ps=2.92u w=1.12u l=0.13u
X1126 sg13cmos5l_inv_16_14.A sg13cmos5l_inv_16_15.A VGND.t324 VGND.t819 sg13_lv_nmos ad=0.1406p pd=1.12u as=0.1406p ps=1.12u w=0.74u l=0.13u
X1127 VGND.t568 sg13cmos5l_inv_16_8.A sg13cmos5l_inv_16_7.A VGND.t575 sg13_lv_nmos ad=0.1406p pd=1.12u as=0.1406p ps=1.12u w=0.74u l=0.13u
X1128 VPWR.t249 sg13cmos5l_inv_16_1.Y sg13cmos5l_inv_16_17.Y VPWR.t20 sg13_lv_pmos ad=0.2128p pd=1.5u as=0.2128p ps=1.5u w=1.12u l=0.13u
X1129 sg13cmos5l_inv_16_18.A sg13cmos5l_inv_16_16.A VPWR.t96 VPWR.t0 sg13_lv_pmos ad=0.2128p pd=1.5u as=0.2128p ps=1.5u w=1.12u l=0.13u
X1130 sg13cmos5l_inv_16_22.A sg13cmos5l_inv_16_19.A VGND.t190 VGND.t554 sg13_lv_nmos ad=0.1406p pd=1.12u as=0.1406p ps=1.12u w=0.74u l=0.13u
X1131 sg13cmos5l_inv_16_13.A sg13cmos5l_inv_16_12.A VPWR.t521 VPWR.t20 sg13_lv_pmos ad=0.2128p pd=1.5u as=0.2128p ps=1.5u w=1.12u l=0.13u
X1132 sg13cmos5l_inv_4_0.A sg13cmos5l_inv_2_0.A VGND.t249 VGND.t617 sg13_lv_nmos ad=0.1406p pd=1.12u as=0.2516p ps=2.16u w=0.74u l=0.13u
X1133 sg13cmos5l_inv_16_7.A sg13cmos5l_inv_16_8.A VGND.t568 VGND.t570 sg13_lv_nmos ad=0.1406p pd=1.12u as=0.1406p ps=1.12u w=0.74u l=0.13u
X1134 sg13cmos5l_inv_16_31.A sg13cmos5l_inv_16_26.A VPWR.t665 VPWR.t20 sg13_lv_pmos ad=0.2128p pd=1.5u as=0.2128p ps=1.5u w=1.12u l=0.13u
X1135 VPWR.t1 sg13cmos5l_inv_16_8.A sg13cmos5l_inv_16_7.A VPWR.t0 sg13_lv_pmos ad=0.2128p pd=1.5u as=0.2128p ps=1.5u w=1.12u l=0.13u
X1136 VPWR.t78 sg13cmos5l_inv_16_20.A sg13cmos5l_inv_16_30.A VPWR.t0 sg13_lv_pmos ad=0.4368p pd=3.02u as=0.2128p ps=1.5u w=1.12u l=0.13u
X1137 sg13cmos5l_inv_16_1.Y sg13cmos5l_inv_16_1.A VGND.t41 VGND.t243 sg13_lv_nmos ad=0.1406p pd=1.12u as=0.1406p ps=1.12u w=0.74u l=0.13u
X1138 VPWR.t68 sg13cmos5l_and2_1_7.A a_16736_4097# VPWR.t18 sg13_lv_pmos ad=0.2856p pd=2.36u as=0.1596p ps=1.22u w=0.84u l=0.13u
X1139 VGND.t551 sg13cmos5l_inv_16_19.A sg13cmos5l_inv_16_22.A VGND.t550 sg13_lv_nmos ad=0.1406p pd=1.12u as=0.1406p ps=1.12u w=0.74u l=0.13u
X1140 sg13cmos5l_inv_16_5.Y sg13cmos5l_inv_16_5.A VPWR.t313 VPWR.t0 sg13_lv_pmos ad=0.2128p pd=1.5u as=0.2128p ps=1.5u w=1.12u l=0.13u
X1141 VPWR.t663 sg13cmos5l_inv_16_26.A sg13cmos5l_inv_16_31.A VPWR.t20 sg13_lv_pmos ad=0.2128p pd=1.5u as=0.2128p ps=1.5u w=1.12u l=0.13u
X1142 sg13cmos5l_and2_1_7.A a_26991_3108# VGND.t121 VGND.t908 sg13_lv_nmos ad=0.1406p pd=1.12u as=0.1406p ps=1.12u w=0.74u l=0.13u
X1143 VPWR.t422 VGND.t66 VPWR.t422 VPWR.t20 sg13_lv_pmos ad=0.34p pd=2.68u as=0 ps=0 w=1u l=1u
X1144 VGND.t41 VPWR.t249 VGND.t41 VGND.t375 sg13_lv_nmos ad=79.8f pd=0.8u as=0 ps=0 w=0.42u l=1u
X1145 sg13cmos5l_inv_16_11.Y sg13cmos5l_inv_16_9.Y VPWR.t182 VPWR.t18 sg13_lv_pmos ad=0.2128p pd=1.5u as=0.3808p ps=2.92u w=1.12u l=0.13u
X1146 sg13cmos5l_inv_16_13.A sg13cmos5l_inv_16_12.A VPWR.t520 VPWR.t20 sg13_lv_pmos ad=0.2128p pd=1.5u as=0.2128p ps=1.5u w=1.12u l=0.13u
X1147 VPWR.t19 VGND.t235 VPWR.t19 VPWR.t18 sg13_lv_pmos ad=0.34p pd=2.68u as=0 ps=0 w=1u l=1u
X1148 VPWR.t174 sg13cmos5l_inv_8_7.A sg13cmos5l_inv_16_28.A VPWR.t0 sg13_lv_pmos ad=0.2128p pd=1.5u as=0.2184p ps=1.51u w=1.12u l=0.13u
X1149 sg13cmos5l_inv_16_29.A sg13cmos5l_inv_16_31.A VPWR.t510 VPWR.t20 sg13_lv_pmos ad=0.2128p pd=1.5u as=0.2128p ps=1.5u w=1.12u l=0.13u
X1150 VPWR.t23 VGND.t359 VPWR.t564 VPWR.t20 sg13_lv_pmos ad=0.19p pd=1.38u as=0 ps=0 w=1u l=1u
X1151 VPWR.t155 VGND.t401 VPWR.t568 VPWR.t20 sg13_lv_pmos ad=0.19p pd=1.38u as=0 ps=0 w=1u l=1u
X1152 VGND.t430 VPWR.t596 VGND.t430 VGND.t429 sg13_lv_nmos ad=0.1428p pd=1.52u as=0 ps=0 w=0.42u l=1u
X1153 VGND.t121 sg13cmos5l_inv_4_6.Y sg13cmos5l_inv_16_24.A VGND.t688 sg13_lv_nmos ad=0.1406p pd=1.12u as=0.1406p ps=1.12u w=0.74u l=0.13u
X1154 sg13cmos5l_inv_16_1.A sg13cmos5l_inv_16_14.A VGND.t117 VGND.t732 sg13_lv_nmos ad=0.1406p pd=1.12u as=0.2516p ps=2.16u w=0.74u l=0.13u
X1155 VGND.t786 a_23648_3403# sg13cmos5l_inv_1_5.A VGND.t940 sg13_lv_nmos ad=0.1331p pd=1.12u as=0.2516p ps=2.16u w=0.74u l=0.13u
X1156 VGND.t32 VPWR.t156 VGND.t32 VGND.t332 sg13_lv_nmos ad=0.1428p pd=1.52u as=0 ps=0 w=0.42u l=1u
X1157 a_20588_3858# en[5] VPWR.t25 VPWR.t18 sg13_lv_pmos ad=0.2856p pd=2.36u as=0.2114p ps=1.54u w=0.84u l=0.13u
X1158 sg13cmos5l_inv_16_20.A sg13cmos5l_inv_8_4.A VGND.t62 VGND.t902 sg13_lv_nmos ad=0.1406p pd=1.12u as=0.1406p ps=1.12u w=0.74u l=0.13u
X1159 VPWR.t508 sg13cmos5l_inv_16_31.A sg13cmos5l_inv_16_29.A VPWR.t20 sg13_lv_pmos ad=0.2128p pd=1.5u as=0.2128p ps=1.5u w=1.12u l=0.13u
X1160 sg13cmos5l_inv_16_28.A sg13cmos5l_inv_8_7.A VPWR.t174 VPWR.t0 sg13_lv_pmos ad=0.2184p pd=1.51u as=0.3808p ps=2.92u w=1.12u l=0.13u
X1161 VPWR.t520 VGND.t1 VPWR.t520 VPWR.t20 sg13_lv_pmos ad=0.34p pd=2.68u as=0 ps=0 w=1u l=1u
X1162 a_26822_874# a_26552_874# VGND.t64 VGND.t286 sg13_lv_nmos ad=0.1428p pd=1.52u as=79.8f ps=0.8u w=0.42u l=0.5u
X1163 VGND.t397 sg13cmos5l_inv_16_19.A sg13cmos5l_inv_16_22.A VGND.t546 sg13_lv_nmos ad=0.1406p pd=1.12u as=0.1406p ps=1.12u w=0.74u l=0.13u
X1164 sg13cmos5l_inv_16_23.A sg13cmos5l_inv_16_27.A VPWR.t25 VPWR.t18 sg13_lv_pmos ad=0.2128p pd=1.5u as=0.2128p ps=1.5u w=1.12u l=0.13u
X1165 VGND.t150 sg13cmos5l_inv_16_18.A sg13cmos5l_inv_16_18.Y VGND.t217 sg13_lv_nmos ad=0.1406p pd=1.12u as=0.1406p ps=1.12u w=0.74u l=0.13u
X1166 sg13cmos5l_xnor2_1_4.Y a_26016_2697# a_26165_2386# VGND.t931 sg13_lv_nmos ad=0.2516p pd=2.16u as=0.1406p ps=1.12u w=0.74u l=0.13u
X1167 VPWR.t24 sg13cmos5l_xnor2_1_1.B a_26880_1671# VPWR.t0 sg13_lv_pmos ad=0.2891p pd=1.695u as=0.1596p ps=1.22u w=0.84u l=0.13u
X1168 VGND.t66 a_14732_3858# sg13cmos5l_and2_1_2.B VGND.t933 sg13_lv_nmos ad=0.14875p pd=1.16u as=0.2886p ps=2.26u w=0.74u l=0.13u
X1169 VPWR.t120 sg13cmos5l_inv_16_24.A sg13cmos5l_inv_16_27.A VPWR.t18 sg13_lv_pmos ad=0.2128p pd=1.5u as=0.2128p ps=1.5u w=1.12u l=0.13u
X1170 a_28160_4097# sg13cmos5l_and2_1_7.A a_28297_3940# VGND.t629 sg13_lv_nmos ad=0.2176p pd=1.96u as=0.1216p ps=1.02u w=0.64u l=0.13u
X1171 VPWR.t25 sg13cmos5l_inv_16_27.A sg13cmos5l_inv_16_23.A VPWR.t18 sg13_lv_pmos ad=0.2128p pd=1.5u as=0.2128p ps=1.5u w=1.12u l=0.13u
X1172 VPWR.t350 VGND.t397 VPWR.t352 VPWR.t20 sg13_lv_pmos ad=0.34p pd=2.68u as=0 ps=0 w=1u l=1u
X1173 sg13cmos5l_inv_16_10.Y sg13cmos5l_inv_16_10.A VGND.t426 VGND.t673 sg13_lv_nmos ad=0.1406p pd=1.12u as=0.1406p ps=1.12u w=0.74u l=0.13u
X1174 VPWR.t313 sg13cmos5l_inv_16_5.Y sg13cmos5l_inv_16_3.Y VPWR.t0 sg13_lv_pmos ad=0.2128p pd=1.5u as=0.2128p ps=1.5u w=1.12u l=0.13u
X1175 VPWR.t65 sg13cmos5l_inv_4_4.A sg13cmos5l_inv_8_4.A VPWR.t20 sg13_lv_pmos ad=0.2128p pd=1.5u as=0.2128p ps=1.5u w=1.12u l=0.13u
X1176 a_27599_2002# sg13cmos5l_dlygate4sd3_1_4.X VGND.t29 VGND.t460 sg13_lv_nmos ad=0.2516p pd=2.16u as=0.1898p ps=1.36u w=0.74u l=0.13u
X1177 sg13cmos5l_inv_16_27.A sg13cmos5l_inv_16_24.A VPWR.t685 VPWR.t18 sg13_lv_pmos ad=0.2128p pd=1.5u as=0.2128p ps=1.5u w=1.12u l=0.13u
X1178 sg13cmos5l_inv_16_4.Y sg13cmos5l_inv_16_29.Y VGND.t133 VGND.t141 sg13_lv_nmos ad=0.1406p pd=1.12u as=0.1406p ps=1.12u w=0.74u l=0.13u
X1179 VPWR.t366 sg13cmos5l_inv_16_10.A sg13cmos5l_inv_16_10.Y VPWR.t0 sg13_lv_pmos ad=0.2128p pd=1.5u as=0.2128p ps=1.5u w=1.12u l=0.13u
X1180 VPWR.t251 VGND.t41 VPWR.t249 VPWR.t20 sg13_lv_pmos ad=0.19p pd=1.38u as=0 ps=0 w=1u l=1u
X1181 sg13cmos5l_inv_16_23.A sg13cmos5l_inv_16_27.A VPWR.t25 VPWR.t18 sg13_lv_pmos ad=0.2128p pd=1.5u as=0.2128p ps=1.5u w=1.12u l=0.13u
X1182 VPWR.t422 sg13cmos5l_inv_16_31.A sg13cmos5l_inv_16_29.A VPWR.t20 sg13_lv_pmos ad=0.2128p pd=1.5u as=0.2128p ps=1.5u w=1.12u l=0.13u
X1183 VPWR.t244 VGND.t324 VPWR.t243 VPWR.t18 sg13_lv_pmos ad=0.34p pd=2.68u as=0 ps=0 w=1u l=1u
X1184 sg13cmos5l_inv_16_16.A sg13cmos5l_inv_16_2.A VPWR.t96 VPWR.t0 sg13_lv_pmos ad=0.2128p pd=1.5u as=0.2128p ps=1.5u w=1.12u l=0.13u
X1185 VGND.t712 sg13cmos5l_inv_16_22.A sg13cmos5l_inv_16_21.A VGND.t717 sg13_lv_nmos ad=0.1406p pd=1.12u as=0.1406p ps=1.12u w=0.74u l=0.13u
X1186 VPWR.t389 sg13cmos5l_inv_4_1.A sg13cmos5l_inv_4_1.Y VPWR.t20 sg13_lv_pmos ad=0.2128p pd=1.5u as=0.2128p ps=1.5u w=1.12u l=0.13u
X1187 sg13cmos5l_inv_16_10.Y sg13cmos5l_inv_16_10.A VPWR.t366 VPWR.t0 sg13_lv_pmos ad=0.2128p pd=1.5u as=0.2128p ps=1.5u w=1.12u l=0.13u
X1188 sg13cmos5l_inv_16_8.A sg13cmos5l_inv_16_6.A VPWR.t14 VPWR.t0 sg13_lv_pmos ad=0.2128p pd=1.5u as=0.2128p ps=1.5u w=1.12u l=0.13u
X1189 VPWR.t36 VGND.t361 VPWR.t36 VPWR.t0 sg13_lv_pmos ad=0.34p pd=2.68u as=0 ps=0 w=1u l=1u
X1190 VPWR.t193 sg13cmos5l_inv_16_9.Y sg13cmos5l_inv_16_11.Y VPWR.t18 sg13_lv_pmos ad=0.2128p pd=1.5u as=0.2128p ps=1.5u w=1.12u l=0.13u
X1191 sg13cmos5l_inv_16_21.A sg13cmos5l_inv_16_22.A VGND.t712 VGND.t711 sg13_lv_nmos ad=0.1406p pd=1.12u as=0.2516p ps=2.16u w=0.74u l=0.13u
X1192 VPWR.t564 VGND.t119 VPWR.t423 VPWR.t20 sg13_lv_pmos ad=0.34p pd=2.68u as=0 ps=0 w=1u l=1u
X1193 VPWR.t96 sg13cmos5l_inv_16_2.A sg13cmos5l_inv_16_16.A VPWR.t0 sg13_lv_pmos ad=0.2128p pd=1.5u as=0.2128p ps=1.5u w=1.12u l=0.13u
X1194 sg13cmos5l_inv_16_9.A sg13cmos5l_inv_16_13.A VPWR.t168 VPWR.t20 sg13_lv_pmos ad=0.2128p pd=1.5u as=0.2128p ps=1.5u w=1.12u l=0.13u
X1195 sg13cmos5l_inv_16_5.Y sg13cmos5l_inv_16_5.A VGND.t872 VGND.t879 sg13_lv_nmos ad=0.1406p pd=1.12u as=0.1406p ps=1.12u w=0.74u l=0.13u
X1196 VGND.t117 sg13cmos5l_and2_1_3.B a_9451_3940# VGND.t749 sg13_lv_nmos ad=0.1331p pd=1.12u as=0.1216p ps=1.02u w=0.64u l=0.13u
X1197 a_25306_3108# sg13cmos5l_xnor2_1_6.A VGND.t119 VGND.t459 sg13_lv_nmos ad=0.1428p pd=1.52u as=79.8f ps=0.8u w=0.42u l=0.13u
X1198 sg13cmos5l_inv_16_18.Y sg13cmos5l_inv_16_18.A VPWR.t87 VPWR.t0 sg13_lv_pmos ad=0.2128p pd=1.5u as=0.2128p ps=1.5u w=1.12u l=0.13u
X1199 sg13cmos5l_xnor2_1_2.B a_27798_938# VPWR.t24 VPWR.t0 sg13_lv_pmos ad=0.4256p pd=3u as=0.2254p ps=1.53u w=1.12u l=0.13u
X1200 VPWR.t40 sg13cmos5l_inv_1_6.A sg13cmos5l_inv_2_5.A VPWR.t20 sg13_lv_pmos ad=0.3808p pd=2.92u as=0.3808p ps=2.92u w=1.12u l=0.13u
X1201 VPWR.t403 sg13cmos5l_inv_16_19.A sg13cmos5l_inv_16_22.A VPWR.t0 sg13_lv_pmos ad=0.2128p pd=1.5u as=0.2128p ps=1.5u w=1.12u l=0.13u
X1202 VGND.t303 sg13cmos5l_inv_16_2.A sg13cmos5l_inv_16_16.A VGND.t302 sg13_lv_nmos ad=0.2516p pd=2.16u as=0.1406p ps=1.12u w=0.74u l=0.13u
X1203 VGND.t441 VPWR.t198 VGND.t443 VGND.t442 sg13_lv_nmos ad=79.8f pd=0.8u as=0 ps=0 w=0.42u l=1u
X1204 VPWR.t300 sg13cmos5l_inv_4_1.Y sg13cmos5l_inv_16_12.A VPWR.t20 sg13_lv_pmos ad=0.3808p pd=2.92u as=0.2184p ps=1.51u w=1.12u l=0.13u
X1205 sg13cmos5l_inv_16_27.A sg13cmos5l_inv_16_24.A VPWR.t685 VPWR.t18 sg13_lv_pmos ad=0.2128p pd=1.5u as=0.2128p ps=1.5u w=1.12u l=0.13u
X1206 sg13cmos5l_inv_16_22.A sg13cmos5l_inv_16_19.A VPWR.t396 VPWR.t0 sg13_lv_pmos ad=0.2128p pd=1.5u as=0.2128p ps=1.5u w=1.12u l=0.13u
X1207 VPWR.t36 VGND.t427 VPWR.t36 VPWR.t0 sg13_lv_pmos ad=0.19p pd=1.38u as=0 ps=0 w=1u l=1u
X1208 sg13cmos5l_inv_16_3.Y sg13cmos5l_inv_16_5.Y VGND.t133 VGND.t141 sg13_lv_nmos ad=0.1406p pd=1.12u as=0.1406p ps=1.12u w=0.74u l=0.13u
X1209 sg13cmos5l_inv_16_7.A sg13cmos5l_inv_16_8.A VGND.t568 VGND.t576 sg13_lv_nmos ad=0.1406p pd=1.12u as=0.1406p ps=1.12u w=0.74u l=0.13u
X1210 VPWR.t657 a_26880_2697# sg13cmos5l_xnor2_1_5.Y VPWR.t20 sg13_lv_pmos ad=0.3808p pd=2.92u as=0.2408p ps=1.55u w=1.12u l=0.13u
X1211 sg13cmos5l_inv_16_1.Y sg13cmos5l_inv_16_1.A VPWR.t226 VPWR.t20 sg13_lv_pmos ad=0.2128p pd=1.5u as=0.2128p ps=1.5u w=1.12u l=0.13u
X1212 VGND.t568 sg13cmos5l_inv_16_8.A sg13cmos5l_inv_16_7.A VGND.t571 sg13_lv_nmos ad=0.1406p pd=1.12u as=0.1406p ps=1.12u w=0.74u l=0.13u
X1213 VPWR.t222 sg13cmos5l_inv_16_1.Y sg13cmos5l_inv_16_17.Y VPWR.t20 sg13_lv_pmos ad=0.2128p pd=1.5u as=0.2128p ps=1.5u w=1.12u l=0.13u
X1214 sg13cmos5l_buf_1_1.X a_2920_3932# VPWR.t193 VPWR.t18 sg13_lv_pmos ad=0.42p pd=2.99u as=0.2114p ps=1.54u w=1.12u l=0.13u
X1215 VGND.t361 sg13cmos5l_inv_16_9.A sg13cmos5l_inv_16_9.Y VGND.t523 sg13_lv_nmos ad=0.1406p pd=1.12u as=0.1406p ps=1.12u w=0.74u l=0.13u
X1216 VGND.t66 VPWR.t144 VGND.t66 VGND.t345 sg13_lv_nmos ad=0.1428p pd=1.52u as=0 ps=0 w=0.42u l=1u
X1217 VPWR.t1 sg13cmos5l_inv_16_8.A sg13cmos5l_inv_16_7.A VPWR.t0 sg13_lv_pmos ad=0.2128p pd=1.5u as=0.2128p ps=1.5u w=1.12u l=0.13u
X1218 VGND.t430 sg13cmos5l_inv_16_5.A sg13cmos5l_inv_16_5.Y VGND.t880 sg13_lv_nmos ad=0.2516p pd=2.16u as=0.1406p ps=1.12u w=0.74u l=0.13u
X1219 VPWR.t479 sg13cmos5l_inv_16_14.A sg13cmos5l_inv_16_1.A VPWR.t20 sg13_lv_pmos ad=0.2128p pd=1.5u as=0.2128p ps=1.5u w=1.12u l=0.13u
X1220 VGND.t359 sg13cmos5l_inv_1_8.Y sg13cmos5l_inv_2_7.Y VGND.t533 sg13_lv_nmos ad=0.2516p pd=2.16u as=0.1406p ps=1.12u w=0.74u l=0.13u
X1221 VPWR.t42 sg13cmos5l_inv_16_30.A sg13cmos5l_inv_16_5.A VPWR.t0 sg13_lv_pmos ad=0.2128p pd=1.5u as=0.2128p ps=1.5u w=1.12u l=0.13u
X1222 VPWR.t174 sg13cmos5l_inv_16_28.A sg13cmos5l_inv_16_19.A VPWR.t0 sg13_lv_pmos ad=0.2128p pd=1.5u as=0.2128p ps=1.5u w=1.12u l=0.13u
X1223 VPWR.t24 VGND.t452 VPWR.t24 VPWR.t0 sg13_lv_pmos ad=0.34p pd=2.68u as=0 ps=0 w=1u l=1u
X1224 a_26016_2697# sg13cmos5l_xnor2_1_3.Y a_25979_2428# VGND.t25 sg13_lv_nmos ad=0.2176p pd=1.96u as=78.39999f ps=0.885u w=0.64u l=0.13u
X1225 sg13cmos5l_inv_16_1.Y sg13cmos5l_inv_16_1.A VGND.t249 VGND.t254 sg13_lv_nmos ad=0.1406p pd=1.12u as=0.1406p ps=1.12u w=0.74u l=0.13u
X1226 sg13cmos5l_inv_16_17.Y sg13cmos5l_inv_16_1.Y VPWR.t252 VPWR.t20 sg13_lv_pmos ad=0.2128p pd=1.5u as=0.2128p ps=1.5u w=1.12u l=0.13u
X1227 sg13cmos5l_inv_16_29.Y sg13cmos5l_inv_16_29.A VPWR.t41 VPWR.t0 sg13_lv_pmos ad=0.2128p pd=1.5u as=0.2128p ps=1.5u w=1.12u l=0.13u
X1228 sg13cmos5l_inv_16_5.Y sg13cmos5l_inv_16_5.A VGND.t872 VGND.t875 sg13_lv_nmos ad=0.1406p pd=1.12u as=0.1406p ps=1.12u w=0.74u l=0.13u
X1229 sg13cmos5l_inv_16_9.Y sg13cmos5l_inv_16_9.A VGND.t361 VGND.t520 sg13_lv_nmos ad=0.1406p pd=1.12u as=0.1406p ps=1.12u w=0.74u l=0.13u
X1230 sg13cmos5l_inv_4_0.A sg13cmos5l_inv_2_0.A VPWR.t479 VPWR.t20 sg13_lv_pmos ad=0.2128p pd=1.5u as=0.3864p ps=2.93u w=1.12u l=0.13u
X1231 VPWR.t303 sg13cmos5l_inv_16_26.A sg13cmos5l_inv_16_31.A VPWR.t20 sg13_lv_pmos ad=0.4368p pd=3.02u as=0.2128p ps=1.5u w=1.12u l=0.13u
X1232 sg13cmos5l_inv_16_19.A sg13cmos5l_inv_16_28.A VPWR.t174 VPWR.t0 sg13_lv_pmos ad=0.2128p pd=1.5u as=0.2128p ps=1.5u w=1.12u l=0.13u
X1233 a_27564_1898# sg13cmos5l_xnor2_1_2.B VPWR.t24 VPWR.t0 sg13_lv_pmos ad=0.1596p pd=1.22u as=0.2891p ps=1.695u w=0.84u l=0.13u
X1234 VGND.t41 VPWR.t87 VGND.t41 VGND.t413 sg13_lv_nmos ad=0.1428p pd=1.52u as=0 ps=0 w=0.42u l=1u
X1235 VGND.t249 sg13cmos5l_inv_16_1.A sg13cmos5l_inv_16_1.Y VGND.t251 sg13_lv_nmos ad=0.1406p pd=1.12u as=0.1406p ps=1.12u w=0.74u l=0.13u
X1236 sg13cmos5l_inv_16_1.Y sg13cmos5l_inv_16_1.A VPWR.t222 VPWR.t20 sg13_lv_pmos ad=0.2128p pd=1.5u as=0.2128p ps=1.5u w=1.12u l=0.13u
X1237 sg13cmos5l_inv_16_21.Y sg13cmos5l_inv_16_21.A VPWR.t78 VPWR.t0 sg13_lv_pmos ad=0.2128p pd=1.5u as=0.2128p ps=1.5u w=1.12u l=0.13u
X1238 VGND.t82 sg13cmos5l_inv_16_20.A sg13cmos5l_inv_16_30.A VGND.t81 sg13_lv_nmos ad=0.1406p pd=1.12u as=0.1406p ps=1.12u w=0.74u l=0.13u
X1239 VPWR.t1 sg13cmos5l_inv_16_8.A sg13cmos5l_inv_16_7.A VPWR.t0 sg13_lv_pmos ad=0.2128p pd=1.5u as=0.2128p ps=1.5u w=1.12u l=0.13u
X1240 sg13cmos5l_inv_16_20.A sg13cmos5l_inv_8_4.A VPWR.t78 VPWR.t0 sg13_lv_pmos ad=0.2128p pd=1.5u as=0.2128p ps=1.5u w=1.12u l=0.13u
X1241 sg13cmos5l_inv_16_10.Y sg13cmos5l_inv_16_10.A VPWR.t366 VPWR.t0 sg13_lv_pmos ad=0.2128p pd=1.5u as=0.3808p ps=2.92u w=1.12u l=0.13u
X1242 VGND.t249 sg13cmos5l_inv_16_0.A sg13cmos5l_inv_16_2.A VGND.t604 sg13_lv_nmos ad=0.1406p pd=1.12u as=0.1406p ps=1.12u w=0.74u l=0.13u
X1243 a_24730_2350# sg13cmos5l_dlygate4sd3_1_0.A VPWR.t481 VPWR.t20 sg13_lv_pmos ad=0.1428p pd=1.52u as=0.1523p ps=1.38u w=0.42u l=0.13u
X1244 VPWR.t524 sg13cmos5l_inv_16_12.A sg13cmos5l_inv_16_13.A VPWR.t20 sg13_lv_pmos ad=0.2128p pd=1.5u as=0.2128p ps=1.5u w=1.12u l=0.13u
X1245 sg13cmos5l_inv_16_14.A sg13cmos5l_inv_16_15.A VGND.t325 VGND.t922 sg13_lv_nmos ad=0.1406p pd=1.12u as=0.1406p ps=1.12u w=0.74u l=0.13u
X1246 sg13cmos5l_inv_16_7.A sg13cmos5l_inv_16_8.A VPWR.t1 VPWR.t0 sg13_lv_pmos ad=0.2128p pd=1.5u as=0.2128p ps=1.5u w=1.12u l=0.13u
X1247 VPWR.t17 VGND.t401 VPWR.t198 VPWR.t0 sg13_lv_pmos ad=0.19p pd=1.38u as=0 ps=0 w=1u l=1u
X1248 sg13cmos5l_inv_16_2.A sg13cmos5l_inv_16_0.A VGND.t249 VGND.t601 sg13_lv_nmos ad=0.1406p pd=1.12u as=0.2516p ps=2.16u w=0.74u l=0.13u
X1249 VGND.t27 a_24730_2350# a_24449_2572# VGND.t932 sg13_lv_nmos ad=79.8f pd=0.8u as=0.1428p ps=1.52u w=0.42u l=0.5u
X1250 sg13cmos5l_inv_16_18.Y sg13cmos5l_inv_16_18.A VGND.t150 VGND.t218 sg13_lv_nmos ad=0.1406p pd=1.12u as=0.1406p ps=1.12u w=0.74u l=0.13u
X1251 VPWR.t181 sg13cmos5l_inv_8_7.A sg13cmos5l_inv_16_28.A VPWR.t0 sg13_lv_pmos ad=0.3808p pd=2.92u as=0.2128p ps=1.5u w=1.12u l=0.13u
X1252 VGND.t361 sg13cmos5l_inv_16_7.A sg13cmos5l_inv_16_10.A VGND.t523 sg13_lv_nmos ad=0.1406p pd=1.12u as=0.1406p ps=1.12u w=0.74u l=0.13u
X1253 sg13cmos5l_inv_16_29.Y sg13cmos5l_inv_16_29.A VGND.t384 VGND.t492 sg13_lv_nmos ad=0.1406p pd=1.12u as=0.1406p ps=1.12u w=0.74u l=0.13u
X1254 VGND.t62 VPWR.t78 VGND.t62 VGND.t438 sg13_lv_nmos ad=0.1428p pd=1.52u as=0 ps=0 w=0.42u l=1u
X1255 sg13cmos5l_inv_16_1.A sg13cmos5l_inv_16_14.A VGND.t117 VGND.t738 sg13_lv_nmos ad=0.1406p pd=1.12u as=0.1406p ps=1.12u w=0.74u l=0.13u
X1256 VGND.t69 sg13cmos5l_inv_16_26.A sg13cmos5l_inv_16_31.A VGND.t757 sg13_lv_nmos ad=0.1406p pd=1.12u as=0.1406p ps=1.12u w=0.74u l=0.13u
X1257 sg13cmos5l_inv_16_28.A sg13cmos5l_inv_8_7.A VPWR.t174 VPWR.t0 sg13_lv_pmos ad=0.2128p pd=1.5u as=0.2128p ps=1.5u w=1.12u l=0.13u
X1258 sg13cmos5l_inv_16_10.A sg13cmos5l_inv_16_7.A VGND.t361 VGND.t520 sg13_lv_nmos ad=0.1406p pd=1.12u as=0.1406p ps=1.12u w=0.74u l=0.13u
X1259 sg13cmos5l_inv_16_14.A sg13cmos5l_inv_16_15.A VGND.t324 VGND.t918 sg13_lv_nmos ad=0.1406p pd=1.12u as=0.1406p ps=1.12u w=0.74u l=0.13u
X1260 VGND.t426 sg13cmos5l_inv_16_10.A sg13cmos5l_inv_16_10.Y VGND.t674 sg13_lv_nmos ad=0.1406p pd=1.12u as=0.1406p ps=1.12u w=0.74u l=0.13u
X1261 VPWR.t569 VGND.t269 VPWR.t569 VPWR.t20 sg13_lv_pmos ad=0.34p pd=2.68u as=0 ps=0 w=1u l=1u
X1262 VGND.t27 a_25382_1632# a_25494_1656# VGND.t42 sg13_lv_nmos ad=0.1426p pd=1.16u as=0.1428p ps=1.52u w=0.42u l=0.5u
X1263 VPWR.t313 sg13cmos5l_inv_16_5.A sg13cmos5l_inv_16_5.Y VPWR.t0 sg13_lv_pmos ad=0.2128p pd=1.5u as=0.2128p ps=1.5u w=1.12u l=0.13u
X1264 VPWR.t142 a_28940_3108# sg13cmos5l_inv_1_7.A VPWR.t20 sg13_lv_pmos ad=0.2114p pd=1.54u as=0.42p ps=2.99u w=1.12u l=0.13u
X1265 VGND.t117 sg13cmos5l_inv_16_14.A sg13cmos5l_inv_16_1.A VGND.t735 sg13_lv_nmos ad=0.1406p pd=1.12u as=0.1406p ps=1.12u w=0.74u l=0.13u
X1266 sg13cmos5l_inv_16_13.A sg13cmos5l_inv_16_12.A VGND.t312 VGND.t883 sg13_lv_nmos ad=0.1406p pd=1.12u as=0.1406p ps=1.12u w=0.74u l=0.13u
X1267 sg13cmos5l_inv_16_0.A sg13cmos5l_inv_4_0.Y VPWR.t104 VPWR.t18 sg13_lv_pmos ad=0.2184p pd=1.51u as=0.2128p ps=1.5u w=1.12u l=0.13u
X1268 sg13cmos5l_inv_4_0.Y sg13cmos5l_inv_4_0.A VPWR.t96 VPWR.t0 sg13_lv_pmos ad=0.2128p pd=1.5u as=0.3808p ps=2.92u w=1.12u l=0.13u
X1269 VGND.t73 sg13cmos5l_inv_1_4.Y sg13cmos5l_inv_4_5.A VGND.t731 sg13_lv_nmos ad=0.2516p pd=2.16u as=0.1406p ps=1.12u w=0.74u l=0.13u
X1270 sg13cmos5l_inv_16_21.A sg13cmos5l_inv_16_22.A VGND.t712 VGND.t718 sg13_lv_nmos ad=0.1406p pd=1.12u as=0.1406p ps=1.12u w=0.74u l=0.13u
X1271 sg13cmos5l_inv_16_22.A sg13cmos5l_inv_16_19.A VPWR.t396 VPWR.t0 sg13_lv_pmos ad=0.2128p pd=1.5u as=0.3808p ps=2.92u w=1.12u l=0.13u
X1272 VPWR.t122 sg13cmos5l_inv_16_15.A sg13cmos5l_inv_16_14.A VPWR.t20 sg13_lv_pmos ad=0.2128p pd=1.5u as=0.2128p ps=1.5u w=1.12u l=0.13u
X1273 VGND.t712 sg13cmos5l_inv_16_22.A sg13cmos5l_inv_16_21.A VGND.t713 sg13_lv_nmos ad=0.1406p pd=1.12u as=0.1406p ps=1.12u w=0.74u l=0.13u
X1274 sg13cmos5l_inv_16_4.Y sg13cmos5l_inv_16_29.Y VPWR.t128 VPWR.t20 sg13_lv_pmos ad=0.2128p pd=1.5u as=0.2128p ps=1.5u w=1.12u l=0.13u
X1275 VPWR.t96 sg13cmos5l_inv_16_0.A sg13cmos5l_inv_16_2.A VPWR.t0 sg13_lv_pmos ad=0.2128p pd=1.5u as=0.2128p ps=1.5u w=1.12u l=0.13u
X1276 VGND.t82 VPWR.t667 VGND.t82 VGND.t386 sg13_lv_nmos ad=0.1428p pd=1.52u as=0 ps=0 w=0.42u l=1u
X1277 sg13cmos5l_inv_16_15.A sg13cmos5l_inv_8_1.A VPWR.t678 VPWR.t18 sg13_lv_pmos ad=0.2128p pd=1.5u as=0.2128p ps=1.5u w=1.12u l=0.13u
X1278 sg13cmos5l_inv_16_11.Y sg13cmos5l_inv_16_9.Y VGND.t172 VGND.t179 sg13_lv_nmos ad=0.1406p pd=1.12u as=0.1406p ps=1.12u w=0.74u l=0.13u
X1279 VPWR.t262 sg13cmos5l_inv_16_27.A sg13cmos5l_inv_16_23.A VPWR.t18 sg13_lv_pmos ad=0.2128p pd=1.5u as=0.2128p ps=1.5u w=1.12u l=0.13u
X1280 VPWR.t313 sg13cmos5l_inv_16_5.Y sg13cmos5l_inv_16_3.Y VPWR.t0 sg13_lv_pmos ad=0.2128p pd=1.5u as=0.2128p ps=1.5u w=1.12u l=0.13u
X1281 sg13cmos5l_inv_16_23.Y sg13cmos5l_inv_16_23.A VGND.t551 VGND.t657 sg13_lv_nmos ad=0.1406p pd=1.12u as=0.1406p ps=1.12u w=0.74u l=0.13u
X1282 sg13cmos5l_inv_16_29.Y sg13cmos5l_inv_16_29.A VGND.t384 VGND.t488 sg13_lv_nmos ad=0.1406p pd=1.12u as=0.1406p ps=1.12u w=0.74u l=0.13u
X1283 sg13cmos5l_inv_16_9.Y sg13cmos5l_inv_16_9.A VGND.t361 VGND.t516 sg13_lv_nmos ad=0.1406p pd=1.12u as=0.2516p ps=2.16u w=0.74u l=0.13u
X1284 VGND.t121 sg13cmos5l_inv_4_6.Y sg13cmos5l_inv_16_24.A VGND.t690 sg13_lv_nmos ad=0.1406p pd=1.12u as=0.1406p ps=1.12u w=0.74u l=0.13u
X1285 VPWR.t36 sg13cmos5l_inv_16_10.A sg13cmos5l_inv_16_10.Y VPWR.t0 sg13_lv_pmos ad=0.2128p pd=1.5u as=0.2128p ps=1.5u w=1.12u l=0.13u
X1286 sg13cmos5l_inv_16_2.A sg13cmos5l_inv_16_0.A VPWR.t96 VPWR.t0 sg13_lv_pmos ad=0.2128p pd=1.5u as=0.2128p ps=1.5u w=1.12u l=0.13u
X1287 VPWR.t260 a_26991_3108# sg13cmos5l_and2_1_7.A VPWR.t20 sg13_lv_pmos ad=0.2128p pd=1.5u as=0.2128p ps=1.5u w=1.12u l=0.13u
X1288 VPWR.t678 sg13cmos5l_inv_8_1.A sg13cmos5l_inv_16_15.A VPWR.t18 sg13_lv_pmos ad=0.2128p pd=1.5u as=0.2128p ps=1.5u w=1.12u l=0.13u
X1289 VGND.t390 sg13cmos5l_inv_16_21.A sg13cmos5l_inv_16_21.Y VGND.t702 sg13_lv_nmos ad=0.1406p pd=1.12u as=0.1406p ps=1.12u w=0.74u l=0.13u
X1290 VGND.t172 sg13cmos5l_inv_16_9.Y sg13cmos5l_inv_16_11.Y VGND.t176 sg13_lv_nmos ad=0.1406p pd=1.12u as=0.1406p ps=1.12u w=0.74u l=0.13u
X1291 VGND.t24 sg13cmos5l_inv_2_4.A sg13cmos5l_inv_4_7.A VGND.t23 sg13_lv_nmos ad=0.2516p pd=2.16u as=0.1406p ps=1.12u w=0.74u l=0.13u
X1292 VPWR.t24 a_27686_874# a_27798_938# VPWR.t0 sg13_lv_pmos ad=0.2254p pd=1.53u as=0.34p ps=2.68u w=1u l=0.5u
X1293 sg13cmos5l_inv_16_3.Y sg13cmos5l_inv_16_5.Y VPWR.t313 VPWR.t0 sg13_lv_pmos ad=0.2128p pd=1.5u as=0.2128p ps=1.5u w=1.12u l=0.13u
X1294 VGND.t156 a_28940_3108# sg13cmos5l_inv_1_7.A VGND.t155 sg13_lv_nmos ad=0.14875p pd=1.16u as=0.2886p ps=2.26u w=0.74u l=0.13u
X1295 VGND.t384 sg13cmos5l_inv_16_29.A sg13cmos5l_inv_16_29.Y VGND.t485 sg13_lv_nmos ad=0.1406p pd=1.12u as=0.1406p ps=1.12u w=0.74u l=0.13u
X1296 sg13cmos5l_inv_16_8.A sg13cmos5l_inv_16_6.A VGND.t1 VGND.t0 sg13_lv_nmos ad=0.1406p pd=1.12u as=0.2516p ps=2.16u w=0.74u l=0.13u
X1297 sg13cmos5l_inv_16_21.Y sg13cmos5l_inv_16_21.A VGND.t390 VGND.t699 sg13_lv_nmos ad=0.1406p pd=1.12u as=0.1406p ps=1.12u w=0.74u l=0.13u
X1298 VGND.t66 sg13cmos5l_inv_2_3.A sg13cmos5l_inv_2_3.Y VGND.t754 sg13_lv_nmos ad=0.2516p pd=2.16u as=0.1406p ps=1.12u w=0.74u l=0.13u
X1299 sg13cmos5l_inv_16_0.A sg13cmos5l_inv_4_0.Y VPWR.t104 VPWR.t18 sg13_lv_pmos ad=0.2128p pd=1.5u as=0.2128p ps=1.5u w=1.12u l=0.13u
X1300 VGND.t449 VPWR.t17 VGND.t449 VGND.t448 sg13_lv_nmos ad=0.1428p pd=1.52u as=0 ps=0 w=0.42u l=1u
X1301 sg13cmos5l_inv_16_10.A sg13cmos5l_inv_16_7.A VPWR.t366 VPWR.t0 sg13_lv_pmos ad=0.2128p pd=1.5u as=0.2128p ps=1.5u w=1.12u l=0.13u
X1302 sg13cmos5l_inv_16_25.Y sg13cmos5l_inv_16_23.Y VGND.t32 VGND.t506 sg13_lv_nmos ad=0.1406p pd=1.12u as=0.1406p ps=1.12u w=0.74u l=0.13u
X1303 VGND.t66 sg13cmos5l_inv_2_3.Y sg13cmos5l_inv_8_1.A VGND.t158 sg13_lv_nmos ad=0.1406p pd=1.12u as=0.1406p ps=1.12u w=0.74u l=0.13u
X1304 sg13cmos5l_inv_16_5.A sg13cmos5l_inv_16_30.A VPWR.t46 VPWR.t0 sg13_lv_pmos ad=0.2128p pd=1.5u as=0.2128p ps=1.5u w=1.12u l=0.13u
X1305 sg13cmos5l_xnor2_1_5.Y sg13cmos5l_xnor2_1_1.Y a_27123_2680# VPWR.t20 sg13_lv_pmos ad=0.2408p pd=1.55u as=0.1428p ps=1.375u w=1.12u l=0.13u
X1306 VGND.t786 sg13cmos5l_inv_16_24.A sg13cmos5l_inv_16_27.A VGND.t787 sg13_lv_nmos ad=0.1406p pd=1.12u as=0.1406p ps=1.12u w=0.74u l=0.13u
X1307 VGND.t133 VPWR.t596 VGND.t379 VGND.t378 sg13_lv_nmos ad=79.8f pd=0.8u as=0 ps=0 w=0.42u l=1u
X1308 VGND.t568 sg13cmos5l_inv_16_8.A sg13cmos5l_inv_16_7.A VGND.t577 sg13_lv_nmos ad=0.1406p pd=1.12u as=0.1406p ps=1.12u w=0.74u l=0.13u
X1309 VGND.t133 sg13cmos5l_inv_16_29.Y sg13cmos5l_inv_16_4.Y VGND.t144 sg13_lv_nmos ad=0.1406p pd=1.12u as=0.1406p ps=1.12u w=0.74u l=0.13u
X1310 a_25958_874# a_25688_874# VPWR.t24 VPWR.t0 sg13_lv_pmos ad=0.34p pd=2.68u as=0.1523p ps=1.38u w=1u l=0.5u
X1311 VPWR.t174 sg13cmos5l_inv_16_19.A sg13cmos5l_inv_16_22.A VPWR.t0 sg13_lv_pmos ad=0.4368p pd=3.02u as=0.2128p ps=1.5u w=1.12u l=0.13u
X1312 sg13cmos5l_inv_16_30.A sg13cmos5l_inv_16_20.A VPWR.t46 VPWR.t0 sg13_lv_pmos ad=0.2128p pd=1.5u as=0.3808p ps=2.92u w=1.12u l=0.13u
X1313 sg13cmos5l_xnor2_1_3.Y a_24576_1185# a_24725_874# VGND.t18 sg13_lv_nmos ad=0.2516p pd=2.16u as=0.1406p ps=1.12u w=0.74u l=0.13u
X1314 sg13cmos5l_inv_16_9.A sg13cmos5l_inv_16_13.A VGND.t172 VGND.t179 sg13_lv_nmos ad=0.1406p pd=1.12u as=0.1406p ps=1.12u w=0.74u l=0.13u
X1315 sg13cmos5l_inv_16_22.A sg13cmos5l_inv_16_19.A VPWR.t174 VPWR.t0 sg13_lv_pmos ad=0.2128p pd=1.5u as=0.2128p ps=1.5u w=1.12u l=0.13u
X1316 sg13cmos5l_inv_16_2.A sg13cmos5l_inv_16_0.A VPWR.t96 VPWR.t0 sg13_lv_pmos ad=0.2128p pd=1.5u as=0.2128p ps=1.5u w=1.12u l=0.13u
X1317 VPWR.t667 VGND.t82 VPWR.t665 VPWR.t20 sg13_lv_pmos ad=0.34p pd=2.68u as=0 ps=0 w=1u l=1u
X1318 sg13cmos5l_inv_4_6.Y sg13cmos5l_inv_2_7.Y VGND.t121 VGND.t124 sg13_lv_nmos ad=0.1406p pd=1.12u as=0.2516p ps=2.16u w=0.74u l=0.13u
X1319 sg13cmos5l_inv_16_21.A sg13cmos5l_inv_16_22.A VPWR.t396 VPWR.t0 sg13_lv_pmos ad=0.2128p pd=1.5u as=0.2128p ps=1.5u w=1.12u l=0.13u
X1320 VPWR.t24 a_25382_1632# a_25494_1656# VPWR.t0 sg13_lv_pmos ad=0.2254p pd=1.53u as=0.34p ps=2.68u w=1u l=0.5u
X1321 sg13cmos5l_inv_16_10.A sg13cmos5l_inv_16_7.A VGND.t361 VGND.t516 sg13_lv_nmos ad=0.1406p pd=1.12u as=0.2516p ps=2.16u w=0.74u l=0.13u
X1322 VPWR.t164 sg13cmos5l_inv_16_9.A sg13cmos5l_inv_16_9.Y VPWR.t20 sg13_lv_pmos ad=0.2128p pd=1.5u as=0.2128p ps=1.5u w=1.12u l=0.13u
X1323 VGND.t131 VPWR.t485 VGND.t131 VGND.t343 sg13_lv_nmos ad=79.8f pd=0.8u as=0 ps=0 w=0.42u l=1u
X1324 VGND.t172 sg13cmos5l_inv_16_13.A sg13cmos5l_inv_16_9.A VGND.t176 sg13_lv_nmos ad=0.1406p pd=1.12u as=0.1406p ps=1.12u w=0.74u l=0.13u
X1325 a_25248_2697# sg13cmos5l_xnor2_1_6.A VPWR.t306 VPWR.t20 sg13_lv_pmos ad=0.1596p pd=1.22u as=0.4536p ps=2.76u w=0.84u l=0.13u
X1326 sg13cmos5l_inv_16_1.Y sg13cmos5l_inv_16_1.A VPWR.t232 VPWR.t20 sg13_lv_pmos ad=0.2128p pd=1.5u as=0.2128p ps=1.5u w=1.12u l=0.13u
X1327 VPWR.t106 sg13cmos5l_inv_4_6.Y sg13cmos5l_inv_16_24.A VPWR.t18 sg13_lv_pmos ad=0.2128p pd=1.5u as=0.2128p ps=1.5u w=1.12u l=0.13u
X1328 VPWR.t42 sg13cmos5l_inv_16_29.A sg13cmos5l_inv_16_29.Y VPWR.t0 sg13_lv_pmos ad=0.2128p pd=1.5u as=0.2128p ps=1.5u w=1.12u l=0.13u
X1329 sg13cmos5l_inv_16_18.A sg13cmos5l_inv_16_16.A VGND.t41 VGND.t105 sg13_lv_nmos ad=0.1406p pd=1.12u as=0.1406p ps=1.12u w=0.74u l=0.13u
X1330 sg13cmos5l_inv_16_9.Y sg13cmos5l_inv_16_9.A VPWR.t160 VPWR.t20 sg13_lv_pmos ad=0.2128p pd=1.5u as=0.2128p ps=1.5u w=1.12u l=0.13u
X1331 VGND.t361 sg13cmos5l_inv_16_9.A sg13cmos5l_inv_16_9.Y VGND.t529 sg13_lv_nmos ad=0.1406p pd=1.12u as=0.1406p ps=1.12u w=0.74u l=0.13u
X1332 VPWR.t174 sg13cmos5l_inv_16_28.A sg13cmos5l_inv_16_19.A VPWR.t0 sg13_lv_pmos ad=0.4368p pd=3.02u as=0.2128p ps=1.5u w=1.12u l=0.13u
X1333 VPWR.t366 sg13cmos5l_inv_16_7.A sg13cmos5l_inv_16_10.A VPWR.t0 sg13_lv_pmos ad=0.2128p pd=1.5u as=0.2128p ps=1.5u w=1.12u l=0.13u
X1334 VPWR.t230 sg13cmos5l_inv_16_1.A sg13cmos5l_inv_16_1.Y VPWR.t20 sg13_lv_pmos ad=0.2128p pd=1.5u as=0.2128p ps=1.5u w=1.12u l=0.13u
X1335 VPWR.t46 sg13cmos5l_inv_16_30.A sg13cmos5l_inv_16_5.A VPWR.t0 sg13_lv_pmos ad=0.2128p pd=1.5u as=0.2128p ps=1.5u w=1.12u l=0.13u
X1336 sg13cmos5l_inv_2_0.A sg13cmos5l_inv_1_0.A VGND.t249 VGND.t897 sg13_lv_nmos ad=0.2516p pd=2.16u as=0.2516p ps=2.16u w=0.74u l=0.13u
X1337 VGND.t41 sg13cmos5l_inv_16_16.A sg13cmos5l_inv_16_18.A VGND.t102 sg13_lv_nmos ad=0.1406p pd=1.12u as=0.1406p ps=1.12u w=0.74u l=0.13u
X1338 a_20588_3858# en[5] VGND.t32 VGND.t911 sg13_lv_nmos ad=0.187p pd=1.78u as=0.14875p ps=1.16u w=0.55u l=0.13u
X1339 a_16736_4097# sg13cmos5l_and2_1_7.A a_16873_3940# VGND.t627 sg13_lv_nmos ad=0.2176p pd=1.96u as=0.1216p ps=1.02u w=0.64u l=0.13u
X1340 sg13cmos5l_inv_16_7.A sg13cmos5l_inv_16_8.A VPWR.t1 VPWR.t0 sg13_lv_pmos ad=0.2128p pd=1.5u as=0.2128p ps=1.5u w=1.12u l=0.13u
X1341 sg13cmos5l_inv_16_18.Y sg13cmos5l_inv_16_18.A VGND.t224 VGND.t225 sg13_lv_nmos ad=0.1406p pd=1.12u as=0.1406p ps=1.12u w=0.74u l=0.13u
X1342 sg13cmos5l_inv_16_30.A sg13cmos5l_inv_16_20.A VGND.t82 VGND.t91 sg13_lv_nmos ad=0.1406p pd=1.12u as=0.1406p ps=1.12u w=0.74u l=0.13u
X1343 VGND.t417 VPWR.t46 VGND.t80 VGND.t416 sg13_lv_nmos ad=0.1428p pd=1.52u as=0 ps=0 w=0.42u l=1u
X1344 sg13cmos5l_inv_16_19.A sg13cmos5l_inv_16_28.A VPWR.t174 VPWR.t0 sg13_lv_pmos ad=0.2128p pd=1.5u as=0.2128p ps=1.5u w=1.12u l=0.13u
X1345 VGND.t133 sg13cmos5l_inv_16_5.Y sg13cmos5l_inv_16_3.Y VGND.t144 sg13_lv_nmos ad=0.1406p pd=1.12u as=0.1406p ps=1.12u w=0.74u l=0.13u
X1346 VGND.t150 sg13cmos5l_inv_16_18.A sg13cmos5l_inv_16_18.Y VGND.t219 sg13_lv_nmos ad=0.1406p pd=1.12u as=0.1406p ps=1.12u w=0.74u l=0.13u
X1347 VGND.t73 sg13cmos5l_inv_8_6.A sg13cmos5l_inv_16_26.A VGND.t72 sg13_lv_nmos ad=0.1406p pd=1.12u as=0.1406p ps=1.12u w=0.74u l=0.13u
X1348 VGND.t172 sg13cmos5l_inv_16_9.Y sg13cmos5l_inv_16_11.Y VGND.t171 sg13_lv_nmos ad=0.1406p pd=1.12u as=0.1406p ps=1.12u w=0.74u l=0.13u
X1349 VGND.t82 sg13cmos5l_inv_16_20.A sg13cmos5l_inv_16_30.A VGND.t88 sg13_lv_nmos ad=0.1406p pd=1.12u as=0.1406p ps=1.12u w=0.74u l=0.13u
X1350 VGND.t426 sg13cmos5l_inv_16_10.A sg13cmos5l_inv_16_10.Y VGND.t680 sg13_lv_nmos ad=0.1406p pd=1.12u as=0.1406p ps=1.12u w=0.74u l=0.13u
X1351 sg13cmos5l_dlygate4sd3_1_3.X a_26070_938# VPWR.t24 VPWR.t0 sg13_lv_pmos ad=0.4256p pd=3u as=0.2254p ps=1.53u w=1.12u l=0.13u
X1352 sg13cmos5l_inv_16_17.Y sg13cmos5l_inv_16_1.Y VGND.t235 VGND.t832 sg13_lv_nmos ad=0.1406p pd=1.12u as=0.1406p ps=1.12u w=0.74u l=0.13u
X1353 sg13cmos5l_inv_16_26.A sg13cmos5l_inv_8_6.A VGND.t69 VGND.t68 sg13_lv_nmos ad=0.1406p pd=1.12u as=0.2516p ps=2.16u w=0.74u l=0.13u
X1354 a_26075_1980# sg13cmos5l_dlygate4sd3_1_1.X VGND.t27 VGND.t805 sg13_lv_nmos ad=78.39999f pd=0.885u as=0.2272p ps=1.99u w=0.64u l=0.13u
X1355 sg13cmos5l_inv_16_10.Y sg13cmos5l_inv_16_10.A VGND.t426 VGND.t675 sg13_lv_nmos ad=0.1406p pd=1.12u as=0.1406p ps=1.12u w=0.74u l=0.13u
X1356 sg13cmos5l_inv_16_29.A sg13cmos5l_inv_16_31.A VGND.t384 VGND.t632 sg13_lv_nmos ad=0.1406p pd=1.12u as=0.2516p ps=2.16u w=0.74u l=0.13u
X1357 sg13cmos5l_inv_16_14.A sg13cmos5l_inv_16_15.A VGND.t780 VGND.t928 sg13_lv_nmos ad=0.1406p pd=1.12u as=0.1406p ps=1.12u w=0.74u l=0.13u
X1358 VPWR.t651 VGND.t117 VPWR.t651 VPWR.t18 sg13_lv_pmos ad=0.19p pd=1.38u as=0 ps=0 w=1u l=1u
X1359 sg13cmos5l_inv_16_21.A sg13cmos5l_inv_16_22.A VPWR.t396 VPWR.t0 sg13_lv_pmos ad=0.2128p pd=1.5u as=0.2128p ps=1.5u w=1.12u l=0.13u
X1360 VGND.t7 sg13cmos5l_inv_4_2.Y sg13cmos5l_inv_16_6.A VGND.t36 sg13_lv_nmos ad=0.1406p pd=1.12u as=0.1406p ps=1.12u w=0.74u l=0.13u
X1361 sg13cmos5l_xnor2_1_6.A sg13cmos5l_inv_4_8.A VGND.t121 VGND.t649 sg13_lv_nmos ad=0.1406p pd=1.12u as=0.2516p ps=2.16u w=0.74u l=0.13u
X1362 VGND.t150 sg13cmos5l_inv_4_2.A sg13cmos5l_inv_4_2.Y VGND.t151 sg13_lv_nmos ad=0.1406p pd=1.12u as=0.1406p ps=1.12u w=0.74u l=0.13u
X1363 VGND.t441 VPWR.t198 VGND.t440 VGND.t439 sg13_lv_nmos ad=0.1428p pd=1.52u as=0 ps=0 w=0.42u l=1u
X1364 VGND.t535 sg13cmos5l_inv_4_1.Y sg13cmos5l_inv_16_12.A VGND.t536 sg13_lv_nmos ad=0.1406p pd=1.12u as=0.1406p ps=1.12u w=0.74u l=0.13u
X1365 sg13cmos5l_inv_16_13.A sg13cmos5l_inv_16_12.A VGND.t535 VGND.t893 sg13_lv_nmos ad=0.1406p pd=1.12u as=0.1406p ps=1.12u w=0.74u l=0.13u
X1366 VGND.t235 a_6284_3858# sg13cmos5l_and2_1_1.B VGND.t807 sg13_lv_nmos ad=0.14875p pd=1.16u as=0.2886p ps=2.26u w=0.74u l=0.13u
X1367 sg13cmos5l_inv_16_31.A sg13cmos5l_inv_16_26.A VGND.t69 VGND.t766 sg13_lv_nmos ad=0.1406p pd=1.12u as=0.1406p ps=1.12u w=0.74u l=0.13u
X1368 VGND.t66 VPWR.t422 VGND.t66 VGND.t349 sg13_lv_nmos ad=0.1428p pd=1.52u as=0 ps=0 w=0.42u l=1u
X1369 VGND.t712 sg13cmos5l_inv_16_22.A sg13cmos5l_inv_16_21.A VGND.t719 sg13_lv_nmos ad=0.1406p pd=1.12u as=0.1406p ps=1.12u w=0.74u l=0.13u
X1370 sg13cmos5l_inv_16_25.Y sg13cmos5l_inv_16_23.Y VGND.t32 VGND.t500 sg13_lv_nmos ad=0.1406p pd=1.12u as=0.1406p ps=1.12u w=0.74u l=0.13u
X1371 VGND.t361 sg13cmos5l_inv_16_7.A sg13cmos5l_inv_16_10.A VGND.t529 sg13_lv_nmos ad=0.1406p pd=1.12u as=0.1406p ps=1.12u w=0.74u l=0.13u
X1372 sg13cmos5l_inv_16_29.Y sg13cmos5l_inv_16_29.A VPWR.t41 VPWR.t0 sg13_lv_pmos ad=0.2128p pd=1.5u as=0.2128p ps=1.5u w=1.12u l=0.13u
X1373 VGND.t69 sg13cmos5l_inv_4_5.A sg13cmos5l_inv_8_6.A VGND.t240 sg13_lv_nmos ad=0.2516p pd=2.16u as=0.1406p ps=1.12u w=0.74u l=0.13u
X1374 VPWR.t130 sg13cmos5l_inv_16_15.A sg13cmos5l_inv_16_14.A VPWR.t20 sg13_lv_pmos ad=0.2128p pd=1.5u as=0.2128p ps=1.5u w=1.12u l=0.13u
X1375 VGND.t224 sg13cmos5l_inv_16_18.A sg13cmos5l_inv_16_18.Y VGND.t226 sg13_lv_nmos ad=0.1406p pd=1.12u as=0.1406p ps=1.12u w=0.74u l=0.13u
X1376 sg13cmos5l_inv_16_21.A sg13cmos5l_inv_16_22.A VGND.t712 VGND.t714 sg13_lv_nmos ad=0.1406p pd=1.12u as=0.1406p ps=1.12u w=0.74u l=0.13u
X1377 VPWR.t78 sg13cmos5l_inv_16_21.A sg13cmos5l_inv_16_21.Y VPWR.t0 sg13_lv_pmos ad=0.2128p pd=1.5u as=0.2128p ps=1.5u w=1.12u l=0.13u
X1378 VGND.t32 sg13cmos5l_inv_16_23.Y sg13cmos5l_inv_16_25.Y VGND.t497 sg13_lv_nmos ad=0.1406p pd=1.12u as=0.1406p ps=1.12u w=0.74u l=0.13u
X1379 sg13cmos5l_inv_16_18.Y sg13cmos5l_inv_16_18.A VGND.t150 VGND.t220 sg13_lv_nmos ad=0.1406p pd=1.12u as=0.1406p ps=1.12u w=0.74u l=0.13u
X1380 sg13cmos5l_inv_8_6.A sg13cmos5l_inv_4_5.A VGND.t69 VGND.t237 sg13_lv_nmos ad=0.1406p pd=1.12u as=0.2516p ps=2.16u w=0.74u l=0.13u
X1381 VGND.t62 sg13cmos5l_inv_8_4.A sg13cmos5l_inv_16_20.A VGND.t905 sg13_lv_nmos ad=0.2516p pd=2.16u as=0.1406p ps=1.12u w=0.74u l=0.13u
X1382 VGND.t325 sg13cmos5l_inv_8_1.A sg13cmos5l_inv_16_15.A VGND.t777 sg13_lv_nmos ad=0.1406p pd=1.12u as=0.1443p ps=1.13u w=0.74u l=0.13u
X1383 sg13cmos5l_inv_16_23.A sg13cmos5l_inv_16_27.A VGND.t269 VGND.t277 sg13_lv_nmos ad=0.1406p pd=1.12u as=0.1406p ps=1.12u w=0.74u l=0.13u
X1384 sg13cmos5l_inv_16_10.Y sg13cmos5l_inv_16_10.A VGND.t426 VGND.t681 sg13_lv_nmos ad=0.1406p pd=1.12u as=0.1406p ps=1.12u w=0.74u l=0.13u
X1385 sg13cmos5l_inv_16_13.A sg13cmos5l_inv_16_12.A VGND.t312 VGND.t889 sg13_lv_nmos ad=0.1406p pd=1.12u as=0.1406p ps=1.12u w=0.74u l=0.13u
X1386 VPWR.t46 VGND.t62 VPWR.t78 VPWR.t0 sg13_lv_pmos ad=0.19p pd=1.38u as=0 ps=0 w=1u l=1u
X1387 sg13cmos5l_inv_16_23.Y sg13cmos5l_inv_16_23.A VGND.t190 VGND.t667 sg13_lv_nmos ad=0.1406p pd=1.12u as=0.1406p ps=1.12u w=0.74u l=0.13u
X1388 VPWR.t631 sg13cmos5l_inv_16_14.A sg13cmos5l_inv_16_1.A VPWR.t20 sg13_lv_pmos ad=0.2128p pd=1.5u as=0.2128p ps=1.5u w=1.12u l=0.13u
X1389 sg13cmos5l_inv_16_17.Y sg13cmos5l_inv_16_1.Y VGND.t235 VGND.t828 sg13_lv_nmos ad=0.1406p pd=1.12u as=0.1406p ps=1.12u w=0.74u l=0.13u
X1390 VGND.t235 VPWR.t19 VGND.t235 VGND.t318 sg13_lv_nmos ad=79.8f pd=0.8u as=0 ps=0 w=0.42u l=1u
X1391 VGND.t426 sg13cmos5l_inv_16_10.A sg13cmos5l_inv_16_10.Y VGND.t676 sg13_lv_nmos ad=0.1406p pd=1.12u as=0.1406p ps=1.12u w=0.74u l=0.13u
X1392 VGND.t172 sg13cmos5l_inv_16_13.A sg13cmos5l_inv_16_9.A VGND.t171 sg13_lv_nmos ad=0.1406p pd=1.12u as=0.1406p ps=1.12u w=0.74u l=0.13u
X1393 VPWR.t126 sg13cmos5l_inv_16_15.A sg13cmos5l_inv_16_14.A VPWR.t20 sg13_lv_pmos ad=0.2128p pd=1.5u as=0.2128p ps=1.5u w=1.12u l=0.13u
X1394 sg13cmos5l_inv_16_3.Y sg13cmos5l_inv_16_5.Y VPWR.t313 VPWR.t0 sg13_lv_pmos ad=0.2128p pd=1.5u as=0.2128p ps=1.5u w=1.12u l=0.13u
X1395 sg13cmos5l_inv_16_15.A sg13cmos5l_inv_8_1.A VGND.t325 VGND.t776 sg13_lv_nmos ad=0.1443p pd=1.13u as=0.2516p ps=2.16u w=0.74u l=0.13u
X1396 sg13cmos5l_inv_16_23.Y sg13cmos5l_inv_16_23.A VPWR.t358 VPWR.t20 sg13_lv_pmos ad=0.2128p pd=1.5u as=0.2128p ps=1.5u w=1.12u l=0.13u
X1397 sg13cmos5l_inv_16_9.Y sg13cmos5l_inv_16_9.A VPWR.t157 VPWR.t20 sg13_lv_pmos ad=0.2128p pd=1.5u as=0.3808p ps=2.92u w=1.12u l=0.13u
X1398 a_26880_2697# sg13cmos5l_xnor2_1_4.Y VPWR.t615 VPWR.t20 sg13_lv_pmos ad=0.1596p pd=1.22u as=0.4536p ps=2.76u w=0.84u l=0.13u
X1399 sg13cmos5l_inv_16_11.Y sg13cmos5l_inv_16_9.Y VGND.t172 VGND.t185 sg13_lv_nmos ad=0.1406p pd=1.12u as=0.1406p ps=1.12u w=0.74u l=0.13u
X1400 VPWR.t21 sg13cmos5l_inv_2_4.A sg13cmos5l_inv_4_7.A VPWR.t20 sg13_lv_pmos ad=0.3864p pd=2.93u as=0.2128p ps=1.5u w=1.12u l=0.13u
X1401 VGND.t131 VPWR.t119 VGND.t131 VGND.t326 sg13_lv_nmos ad=0.1428p pd=1.52u as=0 ps=0 w=0.42u l=1u
X1402 VGND.t172 VPWR.t34 VGND.t307 VGND.t341 sg13_lv_nmos ad=79.8f pd=0.8u as=0 ps=0 w=0.42u l=1u
X1403 VPWR.t396 sg13cmos5l_inv_16_22.A sg13cmos5l_inv_16_21.A VPWR.t0 sg13_lv_pmos ad=0.2128p pd=1.5u as=0.2128p ps=1.5u w=1.12u l=0.13u
X1404 sg13cmos5l_inv_16_29.Y sg13cmos5l_inv_16_29.A VGND.t384 VGND.t494 sg13_lv_nmos ad=0.1406p pd=1.12u as=0.1406p ps=1.12u w=0.74u l=0.13u
X1405 VGND.t7 sg13cmos5l_inv_16_6.A sg13cmos5l_inv_16_8.A VGND.t11 sg13_lv_nmos ad=0.1406p pd=1.12u as=0.1406p ps=1.12u w=0.74u l=0.13u
X1406 VGND.t172 sg13cmos5l_inv_16_9.Y sg13cmos5l_inv_16_11.Y VGND.t182 sg13_lv_nmos ad=0.1406p pd=1.12u as=0.1406p ps=1.12u w=0.74u l=0.13u
X1407 VGND.t392 sg13cmos5l_inv_16_21.A sg13cmos5l_inv_16_21.Y VGND.t709 sg13_lv_nmos ad=0.2516p pd=2.16u as=0.1406p ps=1.12u w=0.74u l=0.13u
X1408 VGND.t69 sg13cmos5l_inv_16_26.A sg13cmos5l_inv_16_31.A VGND.t759 sg13_lv_nmos ad=0.1406p pd=1.12u as=0.1406p ps=1.12u w=0.74u l=0.13u
X1409 VPWR.t87 sg13cmos5l_inv_16_16.A sg13cmos5l_inv_16_18.A VPWR.t0 sg13_lv_pmos ad=0.2128p pd=1.5u as=0.2128p ps=1.5u w=1.12u l=0.13u
X1410 sg13cmos5l_inv_4_1.A sg13cmos5l_inv_2_2.A VGND.t235 VGND.t234 sg13_lv_nmos ad=0.1406p pd=1.12u as=0.2516p ps=2.16u w=0.74u l=0.13u
X1411 sg13cmos5l_dlygate4sd3_1_1.X a_25494_1656# VGND.t27 VGND.t648 sg13_lv_nmos ad=0.2516p pd=2.16u as=0.1426p ps=1.16u w=0.74u l=0.13u
X1412 sg13cmos5l_inv_16_8.A sg13cmos5l_inv_16_6.A VGND.t7 VGND.t8 sg13_lv_nmos ad=0.1406p pd=1.12u as=0.1406p ps=1.12u w=0.74u l=0.13u
X1413 sg13cmos5l_and2_1_7.A a_26991_3108# VGND.t121 VGND.t906 sg13_lv_nmos ad=0.1406p pd=1.12u as=0.2516p ps=2.16u w=0.74u l=0.13u
X1414 VPWR.t106 sg13cmos5l_inv_1_8.Y sg13cmos5l_inv_2_7.Y VPWR.t18 sg13_lv_pmos ad=0.3808p pd=2.92u as=0.2128p ps=1.5u w=1.12u l=0.13u
X1415 sg13cmos5l_inv_16_21.Y sg13cmos5l_inv_16_21.A VGND.t705 VGND.t706 sg13_lv_nmos ad=0.1406p pd=1.12u as=0.1406p ps=1.12u w=0.74u l=0.13u
X1416 VPWR.t19 VGND.t235 VPWR.t19 VPWR.t18 sg13_lv_pmos ad=0.19p pd=1.38u as=0 ps=0 w=1u l=1u
X1417 sg13cmos5l_inv_16_18.A sg13cmos5l_inv_16_16.A VPWR.t87 VPWR.t0 sg13_lv_pmos ad=0.2128p pd=1.5u as=0.2128p ps=1.5u w=1.12u l=0.13u
X1418 a_26355_1632# sg13cmos5l_dlygate4sd3_1_1.X VPWR.t24 VPWR.t0 sg13_lv_pmos ad=0.1428p pd=1.375u as=0.2891p ps=1.695u w=1.12u l=0.13u
X1419 VPWR.t132 sg13cmos5l_inv_16_29.Y sg13cmos5l_inv_16_4.Y VPWR.t20 sg13_lv_pmos ad=0.2128p pd=1.5u as=0.2128p ps=1.5u w=1.12u l=0.13u
X1420 VPWR.t232 sg13cmos5l_inv_16_14.A sg13cmos5l_inv_16_1.A VPWR.t20 sg13_lv_pmos ad=0.2128p pd=1.5u as=0.2128p ps=1.5u w=1.12u l=0.13u
X1421 VPWR.t24 sg13cmos5l_dlygate4sd3_1_1.X a_25688_874# VPWR.t0 sg13_lv_pmos ad=0.1523p pd=1.38u as=0.1428p ps=1.52u w=0.42u l=0.13u
X1422 VGND.t119 sg13cmos5l_inv_16_24.A sg13cmos5l_inv_16_27.A VGND.t793 sg13_lv_nmos ad=0.1406p pd=1.12u as=0.1406p ps=1.12u w=0.74u l=0.13u
X1423 sg13cmos5l_inv_16_31.A sg13cmos5l_inv_16_26.A VPWR.t508 VPWR.t20 sg13_lv_pmos ad=0.2128p pd=1.5u as=0.3808p ps=2.92u w=1.12u l=0.13u
X1424 VGND.t1 sg13cmos5l_inv_16_6.A sg13cmos5l_inv_16_8.A VGND.t4 sg13_lv_nmos ad=0.1406p pd=1.12u as=0.1406p ps=1.12u w=0.74u l=0.13u
X1425 VPWR.t21 a_23648_3403# sg13cmos5l_inv_1_5.A VPWR.t20 sg13_lv_pmos ad=0.1918p pd=1.5u as=0.3808p ps=2.92u w=1.12u l=0.13u
X1426 VPWR.t124 sg13cmos5l_inv_16_15.A sg13cmos5l_inv_16_14.A VPWR.t20 sg13_lv_pmos ad=0.2128p pd=1.5u as=0.2128p ps=1.5u w=1.12u l=0.13u
X1427 VGND.t269 sg13cmos5l_inv_16_27.A sg13cmos5l_inv_16_23.A VGND.t270 sg13_lv_nmos ad=0.1406p pd=1.12u as=0.1406p ps=1.12u w=0.74u l=0.13u
X1428 VPWR.t78 sg13cmos5l_inv_16_20.A sg13cmos5l_inv_16_30.A VPWR.t0 sg13_lv_pmos ad=0.2128p pd=1.5u as=0.2128p ps=1.5u w=1.12u l=0.13u
X1429 VGND.t190 sg13cmos5l_inv_16_23.A sg13cmos5l_inv_16_23.Y VGND.t660 sg13_lv_nmos ad=0.1406p pd=1.12u as=0.1406p ps=1.12u w=0.74u l=0.13u
X1430 VGND.t117 a_9932_3858# sg13cmos5l_and2_1_3.B VGND.t748 sg13_lv_nmos ad=0.14875p pd=1.16u as=0.2886p ps=2.26u w=0.74u l=0.13u
X1431 sg13cmos5l_inv_16_1.A sg13cmos5l_inv_16_14.A VPWR.t226 VPWR.t20 sg13_lv_pmos ad=0.2128p pd=1.5u as=0.2128p ps=1.5u w=1.12u l=0.13u
X1432 VGND.t235 VPWR.t19 VGND.t117 VGND.t320 sg13_lv_nmos ad=79.8f pd=0.8u as=0 ps=0 w=0.42u l=1u
X1433 VGND.t427 VPWR.t36 VGND.t427 VGND.t428 sg13_lv_nmos ad=79.8f pd=0.8u as=0 ps=0 w=0.42u l=1u
X1434 sg13cmos5l_inv_16_27.A sg13cmos5l_inv_16_24.A VGND.t786 VGND.t790 sg13_lv_nmos ad=0.1406p pd=1.12u as=0.1406p ps=1.12u w=0.74u l=0.13u
X1435 VPWR.t358 sg13cmos5l_inv_16_23.Y sg13cmos5l_inv_16_25.Y VPWR.t20 sg13_lv_pmos ad=0.2128p pd=1.5u as=0.2128p ps=1.5u w=1.12u l=0.13u
X1436 VPWR.t730 sg13cmos5l_inv_16_12.A sg13cmos5l_inv_16_13.A VPWR.t20 sg13_lv_pmos ad=0.2128p pd=1.5u as=0.2128p ps=1.5u w=1.12u l=0.13u
X1437 sg13cmos5l_inv_16_30.A sg13cmos5l_inv_16_20.A VPWR.t46 VPWR.t0 sg13_lv_pmos ad=0.2128p pd=1.5u as=0.2128p ps=1.5u w=1.12u l=0.13u
X1438 sg13cmos5l_inv_16_9.A sg13cmos5l_inv_16_13.A VGND.t172 VGND.t185 sg13_lv_nmos ad=0.1406p pd=1.12u as=0.1406p ps=1.12u w=0.74u l=0.13u
X1439 VPWR.t46 sg13cmos5l_inv_16_20.A sg13cmos5l_inv_16_30.A VPWR.t0 sg13_lv_pmos ad=0.2128p pd=1.5u as=0.2128p ps=1.5u w=1.12u l=0.13u
X1440 sg13cmos5l_inv_16_6.A sg13cmos5l_inv_4_2.Y VPWR.t14 VPWR.t0 sg13_lv_pmos ad=0.2128p pd=1.5u as=0.2128p ps=1.5u w=1.12u l=0.13u
X1441 VGND.t41 sg13cmos5l_inv_16_16.A sg13cmos5l_inv_16_18.A VGND.t114 sg13_lv_nmos ad=0.2516p pd=2.16u as=0.1406p ps=1.12u w=0.74u l=0.13u
X1442 VPWR.t170 sg13cmos5l_inv_16_9.A sg13cmos5l_inv_16_9.Y VPWR.t20 sg13_lv_pmos ad=0.2128p pd=1.5u as=0.2128p ps=1.5u w=1.12u l=0.13u
X1443 VGND.t172 sg13cmos5l_inv_16_13.A sg13cmos5l_inv_16_9.A VGND.t182 sg13_lv_nmos ad=0.1406p pd=1.12u as=0.1406p ps=1.12u w=0.74u l=0.13u
X1444 VGND.t249 sg13cmos5l_inv_16_0.A sg13cmos5l_inv_16_2.A VGND.t614 sg13_lv_nmos ad=0.1406p pd=1.12u as=0.1406p ps=1.12u w=0.74u l=0.13u
X1445 sg13cmos5l_inv_16_10.A sg13cmos5l_inv_16_7.A VPWR.t366 VPWR.t0 sg13_lv_pmos ad=0.2128p pd=1.5u as=0.2128p ps=1.5u w=1.12u l=0.13u
X1446 sg13cmos5l_inv_16_18.A sg13cmos5l_inv_16_16.A VGND.t41 VGND.t111 sg13_lv_nmos ad=0.1406p pd=1.12u as=0.1406p ps=1.12u w=0.74u l=0.13u
X1447 VGND.t409 VPWR.t142 VGND.t409 VGND.t408 sg13_lv_nmos ad=0.1428p pd=1.52u as=0 ps=0 w=0.42u l=1u
X1448 sg13cmos5l_inv_16_2.A sg13cmos5l_inv_16_0.A VGND.t249 VGND.t611 sg13_lv_nmos ad=0.1406p pd=1.12u as=0.1406p ps=1.12u w=0.74u l=0.13u
X1449 VPWR.t19 VGND.t117 VPWR.t651 VPWR.t18 sg13_lv_pmos ad=0.19p pd=1.38u as=0 ps=0 w=1u l=1u
X1450 VGND.t66 VPWR.t144 VGND.t66 VGND.t346 sg13_lv_nmos ad=79.8f pd=0.8u as=0 ps=0 w=0.42u l=1u
X1451 sg13cmos5l_inv_2_3.Y sg13cmos5l_inv_2_3.A VPWR.t117 VPWR.t20 sg13_lv_pmos ad=0.2128p pd=1.5u as=0.3808p ps=2.92u w=1.12u l=0.13u
X1452 sg13cmos5l_inv_4_2.Y sg13cmos5l_inv_4_2.A VGND.t150 VGND.t152 sg13_lv_nmos ad=0.1406p pd=1.12u as=0.1406p ps=1.12u w=0.74u l=0.13u
X1453 VPWR.t352 sg13cmos5l_inv_16_23.Y sg13cmos5l_inv_16_25.Y VPWR.t20 sg13_lv_pmos ad=0.2128p pd=1.5u as=0.2128p ps=1.5u w=1.12u l=0.13u
X1454 VGND.t73 sg13cmos5l_inv_8_6.A sg13cmos5l_inv_16_26.A VGND.t77 sg13_lv_nmos ad=0.2516p pd=2.16u as=0.1443p ps=1.13u w=0.74u l=0.13u
X1455 a_27738_1632# sg13cmos5l_xnor2_1_2.B sg13cmos5l_xnor2_1_1.B VPWR.t0 sg13_lv_pmos ad=0.1428p pd=1.375u as=0.2408p ps=1.55u w=1.12u l=0.13u
X1456 VGND.t117 sg13cmos5l_inv_16_1.Y sg13cmos5l_inv_16_17.Y VGND.t841 sg13_lv_nmos ad=0.2516p pd=2.16u as=0.1406p ps=1.12u w=0.74u l=0.13u
X1457 VPWR.t218 sg13cmos5l_inv_1_4.Y sg13cmos5l_inv_4_5.A VPWR.t18 sg13_lv_pmos ad=0.3864p pd=2.93u as=0.2128p ps=1.5u w=1.12u l=0.13u
X1458 sg13cmos5l_inv_16_21.A sg13cmos5l_inv_16_22.A VGND.t712 VGND.t720 sg13_lv_nmos ad=0.1406p pd=1.12u as=0.1406p ps=1.12u w=0.74u l=0.13u
X1459 VGND.t325 VPWR.t243 VGND.t324 VGND.t323 sg13_lv_nmos ad=0.1428p pd=1.52u as=0 ps=0 w=0.42u l=1u
X1460 sg13cmos5l_inv_16_29.A sg13cmos5l_inv_16_31.A VPWR.t146 VPWR.t20 sg13_lv_pmos ad=0.2128p pd=1.5u as=0.3808p ps=2.92u w=1.12u l=0.13u
X1461 VGND.t324 sg13cmos5l_inv_16_14.A sg13cmos5l_inv_16_1.A VGND.t745 sg13_lv_nmos ad=0.1406p pd=1.12u as=0.1406p ps=1.12u w=0.74u l=0.13u
X1462 sg13cmos5l_inv_8_4.A sg13cmos5l_inv_4_4.A VGND.t390 VGND.t938 sg13_lv_nmos ad=0.1406p pd=1.12u as=0.1406p ps=1.12u w=0.74u l=0.13u
X1463 sg13cmos5l_inv_16_18.Y sg13cmos5l_inv_16_18.A VGND.t224 VGND.t227 sg13_lv_nmos ad=0.1406p pd=1.12u as=0.1406p ps=1.12u w=0.74u l=0.13u
X1464 VGND.t123 sg13cmos5l_dlygate4sd3_1_1.X a_25688_874# VGND.t804 sg13_lv_nmos ad=79.8f pd=0.8u as=0.1428p ps=1.52u w=0.42u l=0.13u
X1465 VGND.t82 sg13cmos5l_inv_16_20.A sg13cmos5l_inv_16_30.A VGND.t94 sg13_lv_nmos ad=0.1406p pd=1.12u as=0.1406p ps=1.12u w=0.74u l=0.13u
X1466 VGND.t235 VPWR.t19 VGND.t235 VGND.t319 sg13_lv_nmos ad=0.1428p pd=1.52u as=0 ps=0 w=0.42u l=1u
X1467 sg13cmos5l_inv_16_11.Y sg13cmos5l_inv_16_9.Y VPWR.t182 VPWR.t18 sg13_lv_pmos ad=0.2128p pd=1.5u as=0.2128p ps=1.5u w=1.12u l=0.13u
X1468 sg13cmos5l_inv_16_26.A sg13cmos5l_inv_8_6.A VGND.t73 VGND.t76 sg13_lv_nmos ad=0.1443p pd=1.13u as=0.1406p ps=1.12u w=0.74u l=0.13u
X1469 VGND.t150 sg13cmos5l_inv_16_18.A sg13cmos5l_inv_16_18.Y VGND.t221 sg13_lv_nmos ad=0.1406p pd=1.12u as=0.1406p ps=1.12u w=0.74u l=0.13u
X1470 VGND.t41 sg13cmos5l_inv_4_2.Y sg13cmos5l_inv_16_6.A VGND.t40 sg13_lv_nmos ad=0.2516p pd=2.16u as=0.1443p ps=1.13u w=0.74u l=0.13u
X1471 VPWR.t14 sg13cmos5l_inv_4_2.A sg13cmos5l_inv_4_2.Y VPWR.t0 sg13_lv_pmos ad=0.3808p pd=2.92u as=0.2128p ps=1.5u w=1.12u l=0.13u
X1472 sg13cmos5l_inv_16_29.A sg13cmos5l_inv_16_31.A VGND.t417 VGND.t638 sg13_lv_nmos ad=0.1406p pd=1.12u as=0.1406p ps=1.12u w=0.74u l=0.13u
X1473 VGND.t535 sg13cmos5l_inv_1_1.A sg13cmos5l_inv_2_2.A VGND.t752 sg13_lv_nmos ad=0.2516p pd=2.16u as=0.2516p ps=2.16u w=0.74u l=0.13u
X1474 sg13cmos5l_inv_2_0.A sg13cmos5l_inv_1_0.A VPWR.t637 VPWR.t20 sg13_lv_pmos ad=0.3808p pd=2.92u as=0.3808p ps=2.92u w=1.12u l=0.13u
X1475 sg13cmos5l_inv_4_1.Y sg13cmos5l_inv_4_1.A VGND.t7 VGND.t823 sg13_lv_nmos ad=0.1406p pd=1.12u as=0.1406p ps=1.12u w=0.74u l=0.13u
X1476 VPWR.t164 sg13cmos5l_inv_16_13.A sg13cmos5l_inv_16_9.A VPWR.t20 sg13_lv_pmos ad=0.2128p pd=1.5u as=0.2128p ps=1.5u w=1.12u l=0.13u
X1477 VPWR.t106 sg13cmos5l_inv_4_6.Y sg13cmos5l_inv_16_24.A VPWR.t18 sg13_lv_pmos ad=0.2128p pd=1.5u as=0.2128p ps=1.5u w=1.12u l=0.13u
X1478 VGND.t426 sg13cmos5l_inv_16_10.A sg13cmos5l_inv_16_10.Y VGND.t682 sg13_lv_nmos ad=0.1406p pd=1.12u as=0.1406p ps=1.12u w=0.74u l=0.13u
X1479 VPWR.t182 sg13cmos5l_inv_16_9.Y sg13cmos5l_inv_16_11.Y VPWR.t18 sg13_lv_pmos ad=0.2128p pd=1.5u as=0.2128p ps=1.5u w=1.12u l=0.13u
X1480 VGND.t133 VPWR.t596 VGND.t133 VGND.t377 sg13_lv_nmos ad=0.1428p pd=1.52u as=0 ps=0 w=0.42u l=1u
X1481 VPWR.t87 sg13cmos5l_inv_16_18.A sg13cmos5l_inv_16_18.Y VPWR.t0 sg13_lv_pmos ad=0.2128p pd=1.5u as=0.2128p ps=1.5u w=1.12u l=0.13u
X1482 sg13cmos5l_inv_16_21.Y sg13cmos5l_inv_16_21.A VPWR.t396 VPWR.t0 sg13_lv_pmos ad=0.2128p pd=1.5u as=0.2128p ps=1.5u w=1.12u l=0.13u
X1483 a_14732_3858# en[3] VPWR.t58 VPWR.t18 sg13_lv_pmos ad=0.2856p pd=2.36u as=0.2114p ps=1.54u w=0.84u l=0.13u
X1484 sg13cmos5l_dlygate4sd3_1_3.X a_26070_938# VGND.t64 VGND.t63 sg13_lv_nmos ad=0.2516p pd=2.16u as=0.1426p ps=1.16u w=0.74u l=0.13u
X1485 sg13cmos5l_inv_16_10.Y sg13cmos5l_inv_16_10.A VGND.t426 VGND.t677 sg13_lv_nmos ad=0.1406p pd=1.12u as=0.1406p ps=1.12u w=0.74u l=0.13u
X1486 VGND.t384 sg13cmos5l_inv_16_31.A sg13cmos5l_inv_16_29.A VGND.t635 sg13_lv_nmos ad=0.1406p pd=1.12u as=0.1406p ps=1.12u w=0.74u l=0.13u
X1487 VPWR.t96 sg13cmos5l_inv_16_2.A sg13cmos5l_inv_16_16.A VPWR.t0 sg13_lv_pmos ad=0.2128p pd=1.5u as=0.2128p ps=1.5u w=1.12u l=0.13u
X1488 sg13cmos5l_inv_16_9.A sg13cmos5l_inv_16_13.A VPWR.t160 VPWR.t20 sg13_lv_pmos ad=0.2128p pd=1.5u as=0.2128p ps=1.5u w=1.12u l=0.13u
X1489 VGND.t73 VPWR.t218 VGND.t331 VGND.t330 sg13_lv_nmos ad=79.8f pd=0.8u as=0 ps=0 w=0.42u l=1u
X1490 VPWR.t1 sg13cmos5l_inv_16_6.A sg13cmos5l_inv_16_8.A VPWR.t0 sg13_lv_pmos ad=0.2128p pd=1.5u as=0.2128p ps=1.5u w=1.12u l=0.13u
X1491 VPWR.t58 sg13cmos5l_inv_2_3.Y sg13cmos5l_inv_8_1.A VPWR.t18 sg13_lv_pmos ad=0.2128p pd=1.5u as=0.2128p ps=1.5u w=1.12u l=0.13u
X1492 sg13cmos5l_inv_16_23.Y sg13cmos5l_inv_16_23.A VPWR.t538 VPWR.t20 sg13_lv_pmos ad=0.2128p pd=1.5u as=0.2128p ps=1.5u w=1.12u l=0.13u
X1493 VPWR.t685 sg13cmos5l_inv_16_24.A sg13cmos5l_inv_16_27.A VPWR.t18 sg13_lv_pmos ad=0.2128p pd=1.5u as=0.2128p ps=1.5u w=1.12u l=0.13u
X1494 sg13cmos5l_inv_16_12.A sg13cmos5l_inv_4_1.Y VPWR.t391 VPWR.t20 sg13_lv_pmos ad=0.2128p pd=1.5u as=0.2128p ps=1.5u w=1.12u l=0.13u
X1495 sg13cmos5l_inv_16_16.A sg13cmos5l_inv_16_2.A VPWR.t96 VPWR.t0 sg13_lv_pmos ad=0.2128p pd=1.5u as=0.3808p ps=2.92u w=1.12u l=0.13u
X1496 VGND.t712 sg13cmos5l_inv_16_22.A sg13cmos5l_inv_16_21.A VGND.t721 sg13_lv_nmos ad=0.1406p pd=1.12u as=0.1406p ps=1.12u w=0.74u l=0.13u
X1497 sg13cmos5l_inv_16_8.A sg13cmos5l_inv_16_6.A VPWR.t1 VPWR.t0 sg13_lv_pmos ad=0.2128p pd=1.5u as=0.2128p ps=1.5u w=1.12u l=0.13u
X1498 VGND.t780 sg13cmos5l_inv_8_1.A sg13cmos5l_inv_16_15.A VGND.t784 sg13_lv_nmos ad=0.2516p pd=2.16u as=0.1406p ps=1.12u w=0.74u l=0.13u
X1499 VPWR.t352 sg13cmos5l_inv_16_23.Y sg13cmos5l_inv_16_25.Y VPWR.t20 sg13_lv_pmos ad=0.2128p pd=1.5u as=0.2128p ps=1.5u w=1.12u l=0.13u
X1500 sg13cmos5l_inv_16_23.A sg13cmos5l_inv_16_27.A VGND.t269 VGND.t283 sg13_lv_nmos ad=0.1406p pd=1.12u as=0.1406p ps=1.12u w=0.74u l=0.13u
X1501 VPWR.t19 VGND.t235 VPWR.t19 VPWR.t18 sg13_lv_pmos ad=0.34p pd=2.68u as=0 ps=0 w=1u l=1u
X1502 VGND.t131 VPWR.t485 VGND.t131 VGND.t342 sg13_lv_nmos ad=0.1428p pd=1.52u as=0 ps=0 w=0.42u l=1u
X1503 sg13cmos5l_inv_16_15.A sg13cmos5l_inv_8_1.A VGND.t780 VGND.t781 sg13_lv_nmos ad=0.1406p pd=1.12u as=0.1406p ps=1.12u w=0.74u l=0.13u
X1504 VGND.t69 sg13cmos5l_inv_16_26.A sg13cmos5l_inv_16_31.A VGND.t769 sg13_lv_nmos ad=0.1406p pd=1.12u as=0.1406p ps=1.12u w=0.74u l=0.13u
X1505 sg13cmos5l_inv_16_17.Y sg13cmos5l_inv_16_1.Y VPWR.t252 VPWR.t20 sg13_lv_pmos ad=0.2128p pd=1.5u as=0.2128p ps=1.5u w=1.12u l=0.13u
X1506 VPWR.t421 VGND.t66 VPWR.t419 VPWR.t20 sg13_lv_pmos ad=0.19p pd=1.38u as=0 ps=0 w=1u l=1u
X1507 sg13cmos5l_inv_16_26.A sg13cmos5l_inv_8_6.A VPWR.t61 VPWR.t20 sg13_lv_pmos ad=0.2128p pd=1.5u as=0.2128p ps=1.5u w=1.12u l=0.13u
X1508 a_27123_1632# sg13cmos5l_xnor2_1_0.Y VPWR.t24 VPWR.t0 sg13_lv_pmos ad=0.1428p pd=1.375u as=0.2891p ps=1.695u w=1.12u l=0.13u
X1509 VGND.t7 sg13cmos5l_inv_4_2.Y sg13cmos5l_inv_16_6.A VGND.t38 sg13_lv_nmos ad=0.1406p pd=1.12u as=0.1406p ps=1.12u w=0.74u l=0.13u
X1510 VGND.t117 VPWR.t651 VGND.t117 VGND.t321 sg13_lv_nmos ad=0.1428p pd=1.52u as=0 ps=0 w=0.42u l=1u
X1511 sg13cmos5l_inv_4_6.Y sg13cmos5l_inv_2_7.Y VPWR.t106 VPWR.t18 sg13_lv_pmos ad=0.2128p pd=1.5u as=0.3808p ps=2.92u w=1.12u l=0.13u
X1512 VPWR.t253 sg13cmos5l_inv_16_1.Y sg13cmos5l_inv_16_17.Y VPWR.t20 sg13_lv_pmos ad=0.2128p pd=1.5u as=0.2128p ps=1.5u w=1.12u l=0.13u
X1513 VGND.t324 sg13cmos5l_inv_4_0.Y sg13cmos5l_inv_16_0.A VGND.t816 sg13_lv_nmos ad=0.1406p pd=1.12u as=0.1406p ps=1.12u w=0.74u l=0.13u
X1514 VPWR.t218 VGND.t331 VPWR.t156 VPWR.t18 sg13_lv_pmos ad=0.19p pd=1.38u as=0 ps=0 w=1u l=1u
X1515 sg13cmos5l_inv_16_18.A sg13cmos5l_inv_16_16.A VPWR.t96 VPWR.t0 sg13_lv_pmos ad=0.2128p pd=1.5u as=0.2128p ps=1.5u w=1.12u l=0.13u
X1516 a_5120_4097# sg13cmos5l_and2_1_7.A VPWR.t19 VPWR.t18 sg13_lv_pmos ad=0.1596p pd=1.22u as=0.1918p ps=1.5u w=0.84u l=0.13u
X1517 VGND.t82 VPWR.t667 VGND.t82 VGND.t387 sg13_lv_nmos ad=79.8f pd=0.8u as=0 ps=0 w=0.42u l=1u
X1518 sg13cmos5l_inv_16_20.A sg13cmos5l_inv_8_4.A VPWR.t78 VPWR.t0 sg13_lv_pmos ad=0.2128p pd=1.5u as=0.2128p ps=1.5u w=1.12u l=0.13u
X1519 VPWR.t174 sg13cmos5l_inv_16_28.A sg13cmos5l_inv_16_19.A VPWR.t0 sg13_lv_pmos ad=0.2128p pd=1.5u as=0.2128p ps=1.5u w=1.12u l=0.13u
X1520 VPWR.t132 sg13cmos5l_inv_16_15.A sg13cmos5l_inv_16_14.A VPWR.t20 sg13_lv_pmos ad=0.2128p pd=1.5u as=0.2128p ps=1.5u w=1.12u l=0.13u
X1521 sg13cmos5l_inv_16_18.Y sg13cmos5l_inv_16_18.A VPWR.t14 VPWR.t0 sg13_lv_pmos ad=0.2128p pd=1.5u as=0.3808p ps=2.92u w=1.12u l=0.13u
X1522 sg13cmos5l_inv_16_2.A sg13cmos5l_inv_16_0.A VPWR.t96 VPWR.t0 sg13_lv_pmos ad=0.2128p pd=1.5u as=0.2128p ps=1.5u w=1.12u l=0.13u
X1523 VPWR.t489 VGND.t131 VPWR.t487 VPWR.t20 sg13_lv_pmos ad=0.34p pd=2.68u as=0 ps=0 w=1u l=1u
X1524 sg13cmos5l_inv_16_0.A sg13cmos5l_inv_4_0.Y VGND.t324 VGND.t813 sg13_lv_nmos ad=0.1406p pd=1.12u as=0.2516p ps=2.16u w=0.74u l=0.13u
X1525 sg13cmos5l_inv_16_12.A sg13cmos5l_inv_4_1.Y VPWR.t388 VPWR.t20 sg13_lv_pmos ad=0.2128p pd=1.5u as=0.3808p ps=2.92u w=1.12u l=0.13u
X1526 VGND.t427 VPWR.t36 VGND.t426 VGND.t425 sg13_lv_nmos ad=0.1428p pd=1.52u as=0 ps=0 w=0.42u l=1u
X1527 VPWR.t96 sg13cmos5l_inv_16_16.A sg13cmos5l_inv_16_18.A VPWR.t0 sg13_lv_pmos ad=0.2128p pd=1.5u as=0.2128p ps=1.5u w=1.12u l=0.13u
X1528 VGND.t249 sg13cmos5l_inv_2_0.A sg13cmos5l_inv_4_0.A VGND.t618 sg13_lv_nmos ad=0.2516p pd=2.16u as=0.1406p ps=1.12u w=0.74u l=0.13u
X1529 VPWR.t522 sg13cmos5l_inv_16_12.A sg13cmos5l_inv_16_13.A VPWR.t20 sg13_lv_pmos ad=0.2128p pd=1.5u as=0.2128p ps=1.5u w=1.12u l=0.13u
X1530 VPWR.t667 sg13cmos5l_inv_16_26.A sg13cmos5l_inv_16_31.A VPWR.t20 sg13_lv_pmos ad=0.2128p pd=1.5u as=0.2128p ps=1.5u w=1.12u l=0.13u
X1531 sg13cmos5l_inv_16_7.A sg13cmos5l_inv_16_8.A VPWR.t1 VPWR.t0 sg13_lv_pmos ad=0.2128p pd=1.5u as=0.2128p ps=1.5u w=1.12u l=0.13u
X1532 VPWR.t78 sg13cmos5l_inv_8_4.A sg13cmos5l_inv_16_20.A VPWR.t0 sg13_lv_pmos ad=0.2128p pd=1.5u as=0.2184p ps=1.51u w=1.12u l=0.13u
X1533 sg13cmos5l_inv_16_8.A sg13cmos5l_inv_16_6.A VGND.t7 VGND.t14 sg13_lv_nmos ad=0.1406p pd=1.12u as=0.1406p ps=1.12u w=0.74u l=0.13u
X1534 VPWR.t532 sg13cmos5l_inv_16_23.A sg13cmos5l_inv_16_23.Y VPWR.t20 sg13_lv_pmos ad=0.2128p pd=1.5u as=0.2128p ps=1.5u w=1.12u l=0.13u
X1535 VGND.t41 sg13cmos5l_inv_16_1.A sg13cmos5l_inv_16_1.Y VGND.t244 sg13_lv_nmos ad=0.1406p pd=1.12u as=0.1406p ps=1.12u w=0.74u l=0.13u
X1536 VPWR.t24 a_26112_1671# sg13cmos5l_xnor2_1_0.Y VPWR.t0 sg13_lv_pmos ad=0.3808p pd=2.92u as=0.2408p ps=1.55u w=1.12u l=0.13u
X1537 VGND.t393 VPWR.t346 VGND.t395 VGND.t394 sg13_lv_nmos ad=79.8f pd=0.8u as=0 ps=0 w=0.42u l=1u
X1538 sg13cmos5l_inv_16_18.A sg13cmos5l_inv_16_16.A VPWR.t87 VPWR.t0 sg13_lv_pmos ad=0.2128p pd=1.5u as=0.2128p ps=1.5u w=1.12u l=0.13u
X1539 VPWR.t68 a_16736_4097# sg13cmos5l_inv_1_4.A VPWR.t18 sg13_lv_pmos ad=0.1918p pd=1.5u as=0.3808p ps=2.92u w=1.12u l=0.13u
X1540 VPWR.t313 sg13cmos5l_inv_16_5.A sg13cmos5l_inv_16_5.Y VPWR.t0 sg13_lv_pmos ad=0.2128p pd=1.5u as=0.2128p ps=1.5u w=1.12u l=0.13u
X1541 sg13cmos5l_inv_16_31.A sg13cmos5l_inv_16_26.A VPWR.t663 VPWR.t20 sg13_lv_pmos ad=0.2128p pd=1.5u as=0.2128p ps=1.5u w=1.12u l=0.13u
X1542 VGND.t121 a_26991_3108# sg13cmos5l_and2_1_7.A VGND.t909 sg13_lv_nmos ad=0.3293p pd=1.63u as=0.1406p ps=1.12u w=0.74u l=0.13u
X1543 VGND.t41 VPWR.t252 VGND.t41 VGND.t376 sg13_lv_nmos ad=0.1428p pd=1.52u as=0 ps=0 w=0.42u l=1u
X1544 sg13cmos5l_inv_16_25.Y sg13cmos5l_inv_16_23.Y VPWR.t345 VPWR.t20 sg13_lv_pmos ad=0.2128p pd=1.5u as=0.3808p ps=2.92u w=1.12u l=0.13u
X1545 sg13cmos5l_inv_16_1.Y sg13cmos5l_inv_16_1.A VGND.t41 VGND.t241 sg13_lv_nmos ad=0.1406p pd=1.12u as=0.2516p ps=2.16u w=0.74u l=0.13u
X1546 VPWR.t651 VGND.t117 VPWR.t651 VPWR.t18 sg13_lv_pmos ad=0.34p pd=2.68u as=0 ps=0 w=1u l=1u
X1547 VGND.t66 VPWR.t419 VGND.t66 VGND.t347 sg13_lv_nmos ad=0.1428p pd=1.52u as=0 ps=0 w=0.42u l=1u
X1548 VPWR.t182 sg13cmos5l_inv_16_9.Y sg13cmos5l_inv_16_11.Y VPWR.t18 sg13_lv_pmos ad=0.2128p pd=1.5u as=0.2128p ps=1.5u w=1.12u l=0.13u
X1549 VPWR.t794 sg13cmos5l_inv_16_12.A sg13cmos5l_inv_16_13.A VPWR.t20 sg13_lv_pmos ad=0.2128p pd=1.5u as=0.2128p ps=1.5u w=1.12u l=0.13u
X1550 sg13cmos5l_inv_16_30.A sg13cmos5l_inv_16_20.A VPWR.t78 VPWR.t0 sg13_lv_pmos ad=0.2128p pd=1.5u as=0.2128p ps=1.5u w=1.12u l=0.13u
X1551 VGND.t69 a_16736_4097# sg13cmos5l_inv_1_4.A VGND.t98 sg13_lv_nmos ad=0.1331p pd=1.12u as=0.2516p ps=2.16u w=0.74u l=0.13u
X1552 sg13cmos5l_inv_16_9.A sg13cmos5l_inv_16_13.A VPWR.t157 VPWR.t20 sg13_lv_pmos ad=0.2128p pd=1.5u as=0.3808p ps=2.92u w=1.12u l=0.13u
X1553 a_23785_3492# sg13cmos5l_and2_1_7.B VGND.t786 VGND.t941 sg13_lv_nmos ad=0.1216p pd=1.02u as=0.1331p ps=1.12u w=0.64u l=0.13u
X1554 sg13cmos5l_inv_16_13.A sg13cmos5l_inv_16_12.A VPWR.t520 VPWR.t20 sg13_lv_pmos ad=0.2128p pd=1.5u as=0.2128p ps=1.5u w=1.12u l=0.13u
X1555 sg13cmos5l_xnor2_1_1.B a_27564_1898# VPWR.t24 VPWR.t0 sg13_lv_pmos ad=0.2408p pd=1.55u as=0.3808p ps=2.92u w=1.12u l=0.13u
X1556 VGND.t150 sg13cmos5l_inv_4_2.A sg13cmos5l_inv_4_2.Y VGND.t153 sg13_lv_nmos ad=0.2516p pd=2.16u as=0.1406p ps=1.12u w=0.74u l=0.13u
X1557 VGND.t82 VPWR.t303 VGND.t390 VGND.t389 sg13_lv_nmos ad=79.8f pd=0.8u as=0 ps=0 w=0.42u l=1u
X1558 VPWR.t727 VGND.t82 VPWR.t667 VPWR.t20 sg13_lv_pmos ad=0.19p pd=1.38u as=0 ps=0 w=1u l=1u
X1559 VPWR.t46 VGND.t62 VPWR.t46 VPWR.t0 sg13_lv_pmos ad=0.34p pd=2.68u as=0 ps=0 w=1u l=1u
X1560 VPWR.t218 sg13cmos5l_inv_4_5.A sg13cmos5l_inv_8_6.A VPWR.t18 sg13_lv_pmos ad=0.3808p pd=2.92u as=0.2128p ps=1.5u w=1.12u l=0.13u
X1561 sg13cmos5l_inv_16_22.A sg13cmos5l_inv_16_19.A VGND.t397 VGND.t547 sg13_lv_nmos ad=0.1406p pd=1.12u as=0.1406p ps=1.12u w=0.74u l=0.13u
X1562 VGND.t235 VPWR.t19 VGND.t235 VGND.t317 sg13_lv_nmos ad=0.1428p pd=1.52u as=0 ps=0 w=0.42u l=1u
X1563 VGND.t224 sg13cmos5l_inv_16_18.A sg13cmos5l_inv_16_18.Y VGND.t228 sg13_lv_nmos ad=0.1406p pd=1.12u as=0.1406p ps=1.12u w=0.74u l=0.13u
X1564 VPWR.t313 sg13cmos5l_inv_16_5.A sg13cmos5l_inv_16_5.Y VPWR.t0 sg13_lv_pmos ad=0.2128p pd=1.5u as=0.2128p ps=1.5u w=1.12u l=0.13u
X1565 a_25958_874# a_25688_874# VGND.t123 VGND.t122 sg13_lv_nmos ad=0.1428p pd=1.52u as=79.8f ps=0.8u w=0.42u l=0.5u
X1566 a_24910_3411# a_25025_3410# VGND.t119 VGND.t810 sg13_lv_nmos ad=0.1428p pd=1.52u as=0.1426p ps=1.16u w=0.42u l=0.5u
X1567 VGND.t404 VPWR.t24 VGND.t407 VGND.t424 sg13_lv_nmos ad=79.8f pd=0.8u as=0 ps=0 w=0.42u l=1u
X1568 sg13cmos5l_inv_8_6.A sg13cmos5l_inv_4_5.A VPWR.t68 VPWR.t18 sg13_lv_pmos ad=0.2128p pd=1.5u as=0.3808p ps=2.92u w=1.12u l=0.13u
X1569 sg13cmos5l_inv_16_18.Y sg13cmos5l_inv_16_18.A VGND.t150 VGND.t222 sg13_lv_nmos ad=0.1406p pd=1.12u as=0.1406p ps=1.12u w=0.74u l=0.13u
X1570 VPWR.t678 sg13cmos5l_inv_8_1.A sg13cmos5l_inv_16_15.A VPWR.t18 sg13_lv_pmos ad=0.2128p pd=1.5u as=0.2184p ps=1.51u w=1.12u l=0.13u
X1571 VGND.t397 sg13cmos5l_inv_16_19.A sg13cmos5l_inv_16_22.A VGND.t544 sg13_lv_nmos ad=0.1406p pd=1.12u as=0.1406p ps=1.12u w=0.74u l=0.13u
X1572 sg13cmos5l_inv_16_23.A sg13cmos5l_inv_16_27.A VPWR.t25 VPWR.t18 sg13_lv_pmos ad=0.2128p pd=1.5u as=0.2128p ps=1.5u w=1.12u l=0.13u
X1573 sg13cmos5l_and2_1_4.B a_16264_3932# VGND.t69 VGND.t154 sg13_lv_nmos ad=0.2886p pd=2.26u as=0.14875p ps=1.16u w=0.74u l=0.13u
X1574 sg13cmos5l_inv_16_5.Y sg13cmos5l_inv_16_5.A VPWR.t313 VPWR.t0 sg13_lv_pmos ad=0.2128p pd=1.5u as=0.2128p ps=1.5u w=1.12u l=0.13u
X1575 sg13cmos5l_inv_16_10.Y sg13cmos5l_inv_16_10.A VGND.t426 VGND.t683 sg13_lv_nmos ad=0.1406p pd=1.12u as=0.1406p ps=1.12u w=0.74u l=0.13u
X1576 a_24334_2571# a_24449_2572# VPWR.t105 VPWR.t20 sg13_lv_pmos ad=0.34p pd=2.68u as=0.2254p ps=1.53u w=1u l=0.5u
X1577 sg13cmos5l_inv_8_4.A sg13cmos5l_inv_4_4.A VPWR.t65 VPWR.t20 sg13_lv_pmos ad=0.2128p pd=1.5u as=0.2128p ps=1.5u w=1.12u l=0.13u
X1578 VGND.t384 sg13cmos5l_inv_16_29.A sg13cmos5l_inv_16_29.Y VGND.t483 sg13_lv_nmos ad=0.1406p pd=1.12u as=0.1406p ps=1.12u w=0.74u l=0.13u
X1579 a_27686_874# a_27416_874# VPWR.t24 VPWR.t0 sg13_lv_pmos ad=0.34p pd=2.68u as=0.1523p ps=1.38u w=1u l=0.5u
X1580 VGND.t133 sg13cmos5l_inv_16_29.Y sg13cmos5l_inv_16_4.Y VGND.t142 sg13_lv_nmos ad=0.1406p pd=1.12u as=0.1406p ps=1.12u w=0.74u l=0.13u
X1581 sg13cmos5l_inv_16_10.Y sg13cmos5l_inv_16_10.A VPWR.t366 VPWR.t0 sg13_lv_pmos ad=0.2128p pd=1.5u as=0.2128p ps=1.5u w=1.12u l=0.13u
X1582 VGND.t426 sg13cmos5l_inv_16_10.A sg13cmos5l_inv_16_10.Y VGND.t678 sg13_lv_nmos ad=0.1406p pd=1.12u as=0.1406p ps=1.12u w=0.74u l=0.13u
X1583 VPWR.t155 sg13cmos5l_inv_1_5.A sg13cmos5l_inv_2_4.A VPWR.t20 sg13_lv_pmos ad=0.3808p pd=2.92u as=0.3808p ps=2.92u w=1.12u l=0.13u
X1584 sg13cmos5l_inv_16_15.A sg13cmos5l_inv_8_1.A VPWR.t243 VPWR.t18 sg13_lv_pmos ad=0.2184p pd=1.51u as=0.3808p ps=2.92u w=1.12u l=0.13u
X1585 sg13cmos5l_inv_16_29.A sg13cmos5l_inv_16_31.A VPWR.t422 VPWR.t20 sg13_lv_pmos ad=0.2128p pd=1.5u as=0.2128p ps=1.5u w=1.12u l=0.13u
X1586 VPWR.t96 sg13cmos5l_inv_16_2.A sg13cmos5l_inv_16_16.A VPWR.t0 sg13_lv_pmos ad=0.2128p pd=1.5u as=0.2128p ps=1.5u w=1.12u l=0.13u
X1587 VGND.t82 sg13cmos5l_inv_16_31.A sg13cmos5l_inv_16_29.A VGND.t647 sg13_lv_nmos ad=0.2516p pd=2.16u as=0.1406p ps=1.12u w=0.74u l=0.13u
X1588 sg13cmos5l_inv_4_1.Y sg13cmos5l_inv_4_1.A VPWR.t389 VPWR.t20 sg13_lv_pmos ad=0.2128p pd=1.5u as=0.2128p ps=1.5u w=1.12u l=0.13u
X1589 sg13cmos5l_inv_16_29.Y sg13cmos5l_inv_16_29.A VGND.t381 VGND.t480 sg13_lv_nmos ad=0.1406p pd=1.12u as=0.2516p ps=2.16u w=0.74u l=0.13u
X1590 sg13cmos5l_inv_16_6.A sg13cmos5l_inv_4_2.Y VPWR.t14 VPWR.t0 sg13_lv_pmos ad=0.2128p pd=1.5u as=0.2128p ps=1.5u w=1.12u l=0.13u
X1591 VPWR.t24 a_25958_874# a_26070_938# VPWR.t0 sg13_lv_pmos ad=0.2254p pd=1.53u as=0.34p ps=2.68u w=1u l=0.5u
X1592 VPWR.t366 sg13cmos5l_inv_16_10.A sg13cmos5l_inv_16_10.Y VPWR.t0 sg13_lv_pmos ad=0.2128p pd=1.5u as=0.2128p ps=1.5u w=1.12u l=0.13u
X1593 VPWR.t14 sg13cmos5l_inv_16_6.A sg13cmos5l_inv_16_8.A VPWR.t0 sg13_lv_pmos ad=0.4368p pd=3.02u as=0.2128p ps=1.5u w=1.12u l=0.13u
X1594 sg13cmos5l_inv_16_11.Y sg13cmos5l_inv_16_9.Y VPWR.t193 VPWR.t18 sg13_lv_pmos ad=0.2128p pd=1.5u as=0.2128p ps=1.5u w=1.12u l=0.13u
X1595 VGND.t453 VPWR.t24 VGND.t452 VGND.t451 sg13_lv_nmos ad=0.1428p pd=1.52u as=0 ps=0 w=0.42u l=1u
X1596 sg13cmos5l_inv_16_21.A sg13cmos5l_inv_16_22.A VGND.t712 VGND.t722 sg13_lv_nmos ad=0.1406p pd=1.12u as=0.1406p ps=1.12u w=0.74u l=0.13u
X1597 VGND.t156 a_28652_3858# sg13cmos5l_and2_1_6.B VGND.t930 sg13_lv_nmos ad=0.14875p pd=1.16u as=0.2886p ps=2.26u w=0.74u l=0.13u
X1598 VPWR.t421 sg13cmos5l_inv_16_31.A sg13cmos5l_inv_16_29.A VPWR.t20 sg13_lv_pmos ad=0.2128p pd=1.5u as=0.2128p ps=1.5u w=1.12u l=0.13u
X1599 sg13cmos5l_inv_16_16.A sg13cmos5l_inv_16_2.A VPWR.t96 VPWR.t0 sg13_lv_pmos ad=0.2128p pd=1.5u as=0.2128p ps=1.5u w=1.12u l=0.13u
X1600 VPWR.t170 sg13cmos5l_inv_16_13.A sg13cmos5l_inv_16_9.A VPWR.t20 sg13_lv_pmos ad=0.2128p pd=1.5u as=0.2128p ps=1.5u w=1.12u l=0.13u
X1601 VPWR.t193 sg13cmos5l_inv_16_9.Y sg13cmos5l_inv_16_11.Y VPWR.t18 sg13_lv_pmos ad=0.2128p pd=1.5u as=0.2128p ps=1.5u w=1.12u l=0.13u
X1602 sg13cmos5l_inv_16_21.Y sg13cmos5l_inv_16_21.A VGND.t390 VGND.t693 sg13_lv_nmos ad=0.1406p pd=1.12u as=0.2516p ps=2.16u w=0.74u l=0.13u
X1603 VPWR.t87 sg13cmos5l_inv_16_18.A sg13cmos5l_inv_16_18.Y VPWR.t0 sg13_lv_pmos ad=0.2128p pd=1.5u as=0.2128p ps=1.5u w=1.12u l=0.13u
X1604 VPWR.t303 VGND.t390 VPWR.t61 VPWR.t20 sg13_lv_pmos ad=0.19p pd=1.38u as=0 ps=0 w=1u l=1u
X1605 VPWR.t156 VGND.t32 VPWR.t156 VPWR.t18 sg13_lv_pmos ad=0.34p pd=2.68u as=0 ps=0 w=1u l=1u
X1606 sg13cmos5l_inv_16_22.A sg13cmos5l_inv_16_19.A VPWR.t403 VPWR.t0 sg13_lv_pmos ad=0.2128p pd=1.5u as=0.2128p ps=1.5u w=1.12u l=0.13u
X1607 a_5709_3940# sg13cmos5l_and2_1_7.A VPWR.t19 VPWR.t18 sg13_lv_pmos ad=0.1596p pd=1.22u as=0.2856p ps=2.36u w=0.84u l=0.13u
X1608 VPWR.t19 VGND.t235 VPWR.t19 VPWR.t18 sg13_lv_pmos ad=0.34p pd=2.68u as=0 ps=0 w=1u l=1u
X1609 sg13cmos5l_inv_16_16.A sg13cmos5l_inv_16_2.A VGND.t231 VGND.t287 sg13_lv_nmos ad=0.1406p pd=1.12u as=0.2516p ps=2.16u w=0.74u l=0.13u
X1610 VPWR.t685 sg13cmos5l_inv_16_24.A sg13cmos5l_inv_16_27.A VPWR.t18 sg13_lv_pmos ad=0.2128p pd=1.5u as=0.2128p ps=1.5u w=1.12u l=0.13u
X1611 VPWR.t25 a_20588_3858# sg13cmos5l_and2_1_5.B VPWR.t18 sg13_lv_pmos ad=0.2114p pd=1.54u as=0.42p ps=2.99u w=1.12u l=0.13u
X1612 VGND.t133 sg13cmos5l_inv_16_29.Y sg13cmos5l_inv_16_4.Y VGND.t138 sg13_lv_nmos ad=0.1406p pd=1.12u as=0.1406p ps=1.12u w=0.74u l=0.13u
X1613 VPWR.t403 sg13cmos5l_inv_16_19.A sg13cmos5l_inv_16_22.A VPWR.t0 sg13_lv_pmos ad=0.2128p pd=1.5u as=0.2128p ps=1.5u w=1.12u l=0.13u
X1614 VPWR.t25 sg13cmos5l_inv_16_27.A sg13cmos5l_inv_16_23.A VPWR.t18 sg13_lv_pmos ad=0.2128p pd=1.5u as=0.2128p ps=1.5u w=1.12u l=0.13u
X1615 VGND.t196 sg13cmos5l_inv_8_7.A sg13cmos5l_inv_16_28.A VGND.t195 sg13_lv_nmos ad=0.1406p pd=1.12u as=0.1406p ps=1.12u w=0.74u l=0.13u
X1616 VGND.t133 sg13cmos5l_inv_16_5.Y sg13cmos5l_inv_16_3.Y VGND.t142 sg13_lv_nmos ad=0.1406p pd=1.12u as=0.1406p ps=1.12u w=0.74u l=0.13u
X1617 sg13cmos5l_inv_16_27.A sg13cmos5l_inv_16_24.A VPWR.t685 VPWR.t18 sg13_lv_pmos ad=0.2128p pd=1.5u as=0.2128p ps=1.5u w=1.12u l=0.13u
X1618 sg13cmos5l_inv_16_4.Y sg13cmos5l_inv_16_29.Y VGND.t133 VGND.t135 sg13_lv_nmos ad=0.1406p pd=1.12u as=0.1406p ps=1.12u w=0.74u l=0.13u
X1619 VPWR.t637 sg13cmos5l_inv_16_14.A sg13cmos5l_inv_16_1.A VPWR.t20 sg13_lv_pmos ad=0.4368p pd=3.02u as=0.2128p ps=1.5u w=1.12u l=0.13u
X1620 sg13cmos5l_xnor2_1_0.Y sg13cmos5l_dlygate4sd3_1_3.X a_26355_1632# VPWR.t0 sg13_lv_pmos ad=0.2408p pd=1.55u as=0.1428p ps=1.375u w=1.12u l=0.13u
X1621 VPWR.t481 a_24910_3411# sg13cmos5l_dlygate4sd3_1_0.A VPWR.t20 sg13_lv_pmos ad=0.2254p pd=1.53u as=0.4256p ps=3u w=1.12u l=0.13u
X1622 sg13cmos5l_inv_16_17.Y sg13cmos5l_inv_16_1.Y VPWR.t222 VPWR.t20 sg13_lv_pmos ad=0.2128p pd=1.5u as=0.2128p ps=1.5u w=1.12u l=0.13u
X1623 sg13cmos5l_inv_16_28.A sg13cmos5l_inv_8_7.A VGND.t190 VGND.t192 sg13_lv_nmos ad=0.1406p pd=1.12u as=0.1406p ps=1.12u w=0.74u l=0.13u
X1624 VPWR.t24 a_26880_1671# sg13cmos5l_xnor2_1_1.Y VPWR.t0 sg13_lv_pmos ad=0.3808p pd=2.92u as=0.2408p ps=1.55u w=1.12u l=0.13u
X1625 sg13cmos5l_inv_16_9.Y sg13cmos5l_inv_16_9.A VGND.t361 VGND.t524 sg13_lv_nmos ad=0.1406p pd=1.12u as=0.1406p ps=1.12u w=0.74u l=0.13u
X1626 VPWR.t105 a_24334_2571# sg13cmos5l_xnor2_1_3.A VPWR.t20 sg13_lv_pmos ad=0.2254p pd=1.53u as=0.4256p ps=3u w=1.12u l=0.13u
X1627 sg13cmos5l_inv_16_1.A sg13cmos5l_inv_16_14.A VPWR.t479 VPWR.t20 sg13_lv_pmos ad=0.2128p pd=1.5u as=0.2128p ps=1.5u w=1.12u l=0.13u
X1628 sg13cmos5l_inv_16_7.A sg13cmos5l_inv_16_8.A VPWR.t1 VPWR.t0 sg13_lv_pmos ad=0.2128p pd=1.5u as=0.2128p ps=1.5u w=1.12u l=0.13u
X1629 VGND.t324 sg13cmos5l_inv_4_0.Y sg13cmos5l_inv_16_0.A VGND.t820 sg13_lv_nmos ad=0.2516p pd=2.16u as=0.1443p ps=1.13u w=0.74u l=0.13u
X1630 sg13cmos5l_inv_16_19.A sg13cmos5l_inv_16_28.A VPWR.t174 VPWR.t0 sg13_lv_pmos ad=0.2128p pd=1.5u as=0.2128p ps=1.5u w=1.12u l=0.13u
X1631 VPWR.t87 sg13cmos5l_inv_16_18.A sg13cmos5l_inv_16_18.Y VPWR.t0 sg13_lv_pmos ad=0.2128p pd=1.5u as=0.2128p ps=1.5u w=1.12u l=0.13u
X1632 sg13cmos5l_inv_16_5.A sg13cmos5l_inv_16_30.A VPWR.t42 VPWR.t0 sg13_lv_pmos ad=0.2128p pd=1.5u as=0.2128p ps=1.5u w=1.12u l=0.13u
X1633 a_24576_1185# sg13cmos5l_xnor2_1_3.A VPWR.t17 VPWR.t0 sg13_lv_pmos ad=0.1596p pd=1.22u as=0.4536p ps=2.76u w=0.84u l=0.13u
X1634 VGND.t249 sg13cmos5l_inv_16_1.A sg13cmos5l_inv_16_1.Y VGND.t255 sg13_lv_nmos ad=0.1406p pd=1.12u as=0.1406p ps=1.12u w=0.74u l=0.13u
X1635 VPWR.t221 sg13cmos5l_inv_16_1.Y sg13cmos5l_inv_16_17.Y VPWR.t20 sg13_lv_pmos ad=0.2128p pd=1.5u as=0.2128p ps=1.5u w=1.12u l=0.13u
X1636 VGND.t361 sg13cmos5l_inv_16_9.A sg13cmos5l_inv_16_9.Y VGND.t521 sg13_lv_nmos ad=0.1406p pd=1.12u as=0.1406p ps=1.12u w=0.74u l=0.13u
X1637 VPWR.t65 sg13cmos5l_inv_8_6.A sg13cmos5l_inv_16_26.A VPWR.t20 sg13_lv_pmos ad=0.2128p pd=1.5u as=0.2128p ps=1.5u w=1.12u l=0.13u
X1638 VPWR.t480 sg13cmos5l_inv_2_0.A sg13cmos5l_inv_4_0.A VPWR.t20 sg13_lv_pmos ad=0.3808p pd=2.92u as=0.2128p ps=1.5u w=1.12u l=0.13u
X1639 VGND.t568 sg13cmos5l_inv_16_8.A sg13cmos5l_inv_16_7.A VGND.t581 sg13_lv_nmos ad=0.1406p pd=1.12u as=0.1406p ps=1.12u w=0.74u l=0.13u
X1640 VGND.t231 sg13cmos5l_inv_16_2.A sg13cmos5l_inv_16_16.A VGND.t288 sg13_lv_nmos ad=0.1406p pd=1.12u as=0.1406p ps=1.12u w=0.74u l=0.13u
X1641 VPWR.t174 sg13cmos5l_inv_16_28.A sg13cmos5l_inv_16_19.A VPWR.t0 sg13_lv_pmos ad=0.2128p pd=1.5u as=0.2128p ps=1.5u w=1.12u l=0.13u
X1642 VPWR.t615 sg13cmos5l_inv_1_8.A sg13cmos5l_inv_1_8.Y VPWR.t20 sg13_lv_pmos ad=0.3808p pd=2.92u as=0.3808p ps=2.92u w=1.12u l=0.13u
X1643 sg13cmos5l_inv_16_1.Y sg13cmos5l_inv_16_1.A VGND.t249 VGND.t252 sg13_lv_nmos ad=0.1406p pd=1.12u as=0.1406p ps=1.12u w=0.74u l=0.13u
X1644 VPWR.t224 sg13cmos5l_inv_16_1.A sg13cmos5l_inv_16_1.Y VPWR.t20 sg13_lv_pmos ad=0.2128p pd=1.5u as=0.2128p ps=1.5u w=1.12u l=0.13u
X1645 a_26112_1671# sg13cmos5l_dlygate4sd3_1_1.X VPWR.t24 VPWR.t0 sg13_lv_pmos ad=0.1596p pd=1.22u as=0.4536p ps=2.76u w=0.84u l=0.13u
X1646 a_24725_874# sg13cmos5l_xnor2_1_3.B VGND.t123 VGND.t165 sg13_lv_nmos ad=0.1406p pd=1.12u as=0.1898p ps=1.36u w=0.74u l=0.13u
X1647 VPWR.t396 sg13cmos5l_inv_16_19.A sg13cmos5l_inv_16_22.A VPWR.t0 sg13_lv_pmos ad=0.2128p pd=1.5u as=0.2128p ps=1.5u w=1.12u l=0.13u
X1648 sg13cmos5l_inv_16_12.A sg13cmos5l_inv_4_1.Y VPWR.t300 VPWR.t20 sg13_lv_pmos ad=0.2184p pd=1.51u as=0.2128p ps=1.5u w=1.12u l=0.13u
X1649 VGND.t249 sg13cmos5l_inv_16_0.A sg13cmos5l_inv_16_2.A VGND.t608 sg13_lv_nmos ad=0.1406p pd=1.12u as=0.1406p ps=1.12u w=0.74u l=0.13u
X1650 VGND.t133 VPWR.t617 VGND.t379 VGND.t378 sg13_lv_nmos ad=79.8f pd=0.8u as=0 ps=0 w=0.42u l=1u
X1651 sg13cmos5l_inv_2_1.A sg13cmos5l_inv_1_3.A VPWR.t216 VPWR.t20 sg13_lv_pmos ad=0.3808p pd=2.92u as=0.3808p ps=2.92u w=1.12u l=0.13u
X1652 sg13cmos5l_inv_16_7.A sg13cmos5l_inv_16_8.A VPWR.t1 VPWR.t0 sg13_lv_pmos ad=0.2128p pd=1.5u as=0.2128p ps=1.5u w=1.12u l=0.13u
X1653 VGND.t133 sg13cmos5l_inv_16_5.Y sg13cmos5l_inv_16_3.Y VGND.t138 sg13_lv_nmos ad=0.1406p pd=1.12u as=0.1406p ps=1.12u w=0.74u l=0.13u
X1654 sg13cmos5l_inv_16_1.Y sg13cmos5l_inv_16_1.A VPWR.t221 VPWR.t20 sg13_lv_pmos ad=0.2128p pd=1.5u as=0.3808p ps=2.92u w=1.12u l=0.13u
X1655 VPWR.t366 sg13cmos5l_inv_16_10.A sg13cmos5l_inv_16_10.Y VPWR.t0 sg13_lv_pmos ad=0.2128p pd=1.5u as=0.2128p ps=1.5u w=1.12u l=0.13u
X1656 sg13cmos5l_inv_16_2.A sg13cmos5l_inv_16_0.A VGND.t249 VGND.t605 sg13_lv_nmos ad=0.1406p pd=1.12u as=0.1406p ps=1.12u w=0.74u l=0.13u
X1657 sg13cmos5l_inv_16_13.A sg13cmos5l_inv_16_12.A VPWR.t524 VPWR.t20 sg13_lv_pmos ad=0.2128p pd=1.5u as=0.2128p ps=1.5u w=1.12u l=0.13u
X1658 VGND.t325 sg13cmos5l_inv_16_15.A sg13cmos5l_inv_16_14.A VGND.t923 sg13_lv_nmos ad=0.1406p pd=1.12u as=0.1406p ps=1.12u w=0.74u l=0.13u
X1659 VPWR.t24 sg13cmos5l_dlygate4sd3_1_4.X a_27738_1632# VPWR.t0 sg13_lv_pmos ad=0.2891p pd=1.695u as=0.1428p ps=1.375u w=1.12u l=0.13u
X1660 sg13cmos5l_inv_16_3.Y sg13cmos5l_inv_16_5.Y VGND.t133 VGND.t135 sg13_lv_nmos ad=0.1406p pd=1.12u as=0.1406p ps=1.12u w=0.74u l=0.13u
X1661 sg13cmos5l_inv_16_1.A sg13cmos5l_inv_16_14.A VGND.t117 VGND.t742 sg13_lv_nmos ad=0.1406p pd=1.12u as=0.1406p ps=1.12u w=0.74u l=0.13u
X1662 VPWR.t78 sg13cmos5l_inv_8_4.A sg13cmos5l_inv_16_20.A VPWR.t0 sg13_lv_pmos ad=0.3808p pd=2.92u as=0.2128p ps=1.5u w=1.12u l=0.13u
X1663 VGND.t249 sg13cmos5l_inv_16_0.A sg13cmos5l_inv_16_2.A VGND.t602 sg13_lv_nmos ad=0.1406p pd=1.12u as=0.1406p ps=1.12u w=0.74u l=0.13u
X1664 sg13cmos5l_inv_16_18.Y sg13cmos5l_inv_16_18.A VGND.t224 VGND.t229 sg13_lv_nmos ad=0.1406p pd=1.12u as=0.1406p ps=1.12u w=0.74u l=0.13u
X1665 sg13cmos5l_inv_16_10.A sg13cmos5l_inv_16_7.A VGND.t361 VGND.t524 sg13_lv_nmos ad=0.1406p pd=1.12u as=0.1406p ps=1.12u w=0.74u l=0.13u
X1666 a_19616_4097# sg13cmos5l_and2_1_5.B VPWR.t156 VPWR.t18 sg13_lv_pmos ad=0.1596p pd=1.22u as=0.1918p ps=1.5u w=0.84u l=0.13u
X1667 VPWR.t313 sg13cmos5l_inv_16_5.A sg13cmos5l_inv_16_5.Y VPWR.t0 sg13_lv_pmos ad=0.4368p pd=3.02u as=0.2128p ps=1.5u w=1.12u l=0.13u
X1668 VGND.t117 sg13cmos5l_inv_16_14.A sg13cmos5l_inv_16_1.A VGND.t739 sg13_lv_nmos ad=0.1406p pd=1.12u as=0.1406p ps=1.12u w=0.74u l=0.13u
X1669 VGND.t224 sg13cmos5l_inv_16_18.A sg13cmos5l_inv_16_18.Y VGND.t223 sg13_lv_nmos ad=0.1406p pd=1.12u as=0.1406p ps=1.12u w=0.74u l=0.13u
X1670 sg13cmos5l_inv_16_31.A sg13cmos5l_inv_16_26.A VPWR.t669 VPWR.t20 sg13_lv_pmos ad=0.2128p pd=1.5u as=0.2128p ps=1.5u w=1.12u l=0.13u
X1671 VGND.t73 VPWR.t218 VGND.t73 VGND.t329 sg13_lv_nmos ad=0.1428p pd=1.52u as=0 ps=0 w=0.42u l=1u
X1672 VPWR.t174 sg13cmos5l_inv_16_28.A sg13cmos5l_inv_16_19.A VPWR.t0 sg13_lv_pmos ad=0.2128p pd=1.5u as=0.2128p ps=1.5u w=1.12u l=0.13u
X1673 VGND.t361 sg13cmos5l_inv_16_7.A sg13cmos5l_inv_16_10.A VGND.t521 sg13_lv_nmos ad=0.1406p pd=1.12u as=0.1406p ps=1.12u w=0.74u l=0.13u
X1674 VGND.t324 sg13cmos5l_inv_16_15.A sg13cmos5l_inv_16_14.A VGND.t919 sg13_lv_nmos ad=0.1406p pd=1.12u as=0.1406p ps=1.12u w=0.74u l=0.13u
X1675 VGND.t426 sg13cmos5l_inv_16_10.A sg13cmos5l_inv_16_10.Y VGND.t684 sg13_lv_nmos ad=0.2516p pd=2.16u as=0.1406p ps=1.12u w=0.74u l=0.13u
X1676 sg13cmos5l_inv_16_5.Y sg13cmos5l_inv_16_5.A VPWR.t313 VPWR.t0 sg13_lv_pmos ad=0.2128p pd=1.5u as=0.2128p ps=1.5u w=1.12u l=0.13u
X1677 sg13cmos5l_inv_8_7.A sg13cmos5l_inv_4_7.A VGND.t196 VGND.t844 sg13_lv_nmos ad=0.1406p pd=1.12u as=0.1406p ps=1.12u w=0.74u l=0.13u
X1678 VGND.t190 sg13cmos5l_inv_16_19.A sg13cmos5l_inv_16_22.A VGND.t557 sg13_lv_nmos ad=0.1406p pd=1.12u as=0.1406p ps=1.12u w=0.74u l=0.13u
X1679 sg13cmos5l_inv_16_1.A sg13cmos5l_inv_16_14.A VGND.t117 VGND.t736 sg13_lv_nmos ad=0.1406p pd=1.12u as=0.1406p ps=1.12u w=0.74u l=0.13u
X1680 VGND.t312 sg13cmos5l_inv_16_12.A sg13cmos5l_inv_16_13.A VGND.t884 sg13_lv_nmos ad=0.1406p pd=1.12u as=0.1406p ps=1.12u w=0.74u l=0.13u
X1681 sg13cmos5l_inv_16_10.Y sg13cmos5l_inv_16_10.A VGND.t426 VGND.t679 sg13_lv_nmos ad=0.1406p pd=1.12u as=0.1406p ps=1.12u w=0.74u l=0.13u
X1682 VPWR.t313 sg13cmos5l_inv_4_0.A sg13cmos5l_inv_4_0.Y VPWR.t0 sg13_lv_pmos ad=0.2128p pd=1.5u as=0.2128p ps=1.5u w=1.12u l=0.13u
X1683 a_14732_3858# en[3] VGND.t66 VGND.t65 sg13_lv_nmos ad=0.187p pd=1.78u as=0.14875p ps=1.16u w=0.55u l=0.13u
X1684 sg13cmos5l_inv_16_14.A sg13cmos5l_inv_16_15.A VPWR.t122 VPWR.t20 sg13_lv_pmos ad=0.2128p pd=1.5u as=0.2128p ps=1.5u w=1.12u l=0.13u
X1685 VPWR.t17 VGND.t443 VPWR.t198 VPWR.t0 sg13_lv_pmos ad=0.19p pd=1.38u as=0 ps=0 w=1u l=1u
X1686 VGND.t381 VPWR.t117 VGND.t381 VGND.t382 sg13_lv_nmos ad=79.8f pd=0.8u as=0 ps=0 w=0.42u l=1u
X1687 VPWR.t487 VGND.t379 VPWR.t617 VPWR.t20 sg13_lv_pmos ad=0.19p pd=1.38u as=0 ps=0 w=1u l=1u
X1688 VPWR.t24 sg13cmos5l_dlygate4sd3_1_4.X a_27416_874# VPWR.t0 sg13_lv_pmos ad=0.1523p pd=1.38u as=0.1428p ps=1.52u w=0.42u l=0.13u
X1689 VGND.t712 sg13cmos5l_inv_16_22.A sg13cmos5l_inv_16_21.A VGND.t723 sg13_lv_nmos ad=0.1406p pd=1.12u as=0.1406p ps=1.12u w=0.74u l=0.13u
X1690 VPWR.t130 sg13cmos5l_inv_16_29.Y sg13cmos5l_inv_16_4.Y VPWR.t20 sg13_lv_pmos ad=0.2128p pd=1.5u as=0.2128p ps=1.5u w=1.12u l=0.13u
X1691 VPWR.t119 sg13cmos5l_inv_8_1.A sg13cmos5l_inv_16_15.A VPWR.t18 sg13_lv_pmos ad=0.3808p pd=2.92u as=0.2128p ps=1.5u w=1.12u l=0.13u
X1692 VGND.t172 sg13cmos5l_inv_16_9.Y sg13cmos5l_inv_16_11.Y VGND.t180 sg13_lv_nmos ad=0.1406p pd=1.12u as=0.1406p ps=1.12u w=0.74u l=0.13u
X1693 a_6284_3858# en[1] VPWR.t19 VPWR.t18 sg13_lv_pmos ad=0.2856p pd=2.36u as=0.2114p ps=1.54u w=0.84u l=0.13u
X1694 sg13cmos5l_inv_16_23.A sg13cmos5l_inv_16_27.A VPWR.t262 VPWR.t18 sg13_lv_pmos ad=0.2128p pd=1.5u as=0.2128p ps=1.5u w=1.12u l=0.13u
X1695 VGND.t27 sg13cmos5l_xnor2_1_6.Y a_26165_2386# VGND.t751 sg13_lv_nmos ad=0.1898p pd=1.36u as=0.2516p ps=2.16u w=0.74u l=0.13u
X1696 sg13cmos5l_inv_16_21.A sg13cmos5l_inv_16_22.A VPWR.t586 VPWR.t0 sg13_lv_pmos ad=0.2128p pd=1.5u as=0.3808p ps=2.92u w=1.12u l=0.13u
X1697 sg13cmos5l_inv_16_3.Y sg13cmos5l_inv_16_5.Y VPWR.t313 VPWR.t0 sg13_lv_pmos ad=0.2128p pd=1.5u as=0.2128p ps=1.5u w=1.12u l=0.13u
X1698 VGND.t190 sg13cmos5l_inv_16_23.A sg13cmos5l_inv_16_23.Y VGND.t658 sg13_lv_nmos ad=0.1406p pd=1.12u as=0.1406p ps=1.12u w=0.74u l=0.13u
X1699 VPWR.t512 sg13cmos5l_inv_16_31.A sg13cmos5l_inv_16_29.A VPWR.t20 sg13_lv_pmos ad=0.4368p pd=3.02u as=0.2128p ps=1.5u w=1.12u l=0.13u
X1700 VPWR.t218 VGND.t73 VPWR.t218 VPWR.t18 sg13_lv_pmos ad=0.34p pd=2.68u as=0 ps=0 w=1u l=1u
X1701 VGND.t384 sg13cmos5l_inv_16_29.A sg13cmos5l_inv_16_29.Y VGND.t489 sg13_lv_nmos ad=0.1406p pd=1.12u as=0.1406p ps=1.12u w=0.74u l=0.13u
X1702 VGND.t361 sg13cmos5l_inv_16_9.A sg13cmos5l_inv_16_9.Y VGND.t517 sg13_lv_nmos ad=0.1406p pd=1.12u as=0.1406p ps=1.12u w=0.74u l=0.13u
X1703 sg13cmos5l_inv_16_24.A sg13cmos5l_inv_4_6.Y VGND.t121 VGND.t691 sg13_lv_nmos ad=0.1406p pd=1.12u as=0.1406p ps=1.12u w=0.74u l=0.13u
X1704 sg13cmos5l_inv_16_15.A sg13cmos5l_inv_8_1.A VPWR.t678 VPWR.t18 sg13_lv_pmos ad=0.2128p pd=1.5u as=0.2128p ps=1.5u w=1.12u l=0.13u
X1705 sg13cmos5l_inv_16_10.Y sg13cmos5l_inv_16_10.A VPWR.t36 VPWR.t0 sg13_lv_pmos ad=0.2128p pd=1.5u as=0.2128p ps=1.5u w=1.12u l=0.13u
X1706 sg13cmos5l_and2_1_7.A a_26991_3108# VPWR.t260 VPWR.t20 sg13_lv_pmos ad=0.2128p pd=1.5u as=0.2128p ps=1.5u w=1.12u l=0.13u
X1707 sg13cmos5l_inv_16_11.Y sg13cmos5l_inv_16_9.Y VGND.t172 VGND.t177 sg13_lv_nmos ad=0.1406p pd=1.12u as=0.1406p ps=1.12u w=0.74u l=0.13u
X1708 sg13cmos5l_inv_16_21.Y sg13cmos5l_inv_16_21.A VGND.t390 VGND.t703 sg13_lv_nmos ad=0.1406p pd=1.12u as=0.1406p ps=1.12u w=0.74u l=0.13u
X1709 a_25979_2428# sg13cmos5l_xnor2_1_6.Y VGND.t27 VGND.t750 sg13_lv_nmos ad=78.39999f pd=0.885u as=0.2272p ps=1.99u w=0.64u l=0.13u
X1710 sg13cmos5l_inv_16_25.Y sg13cmos5l_inv_16_23.Y VGND.t32 VGND.t510 sg13_lv_nmos ad=0.1406p pd=1.12u as=0.1406p ps=1.12u w=0.74u l=0.13u
R0 VPWR.n5 VPWR.n9 4.17712
R1 VPWR.t538 VPWR.n5 1.12363
R2 VPWR.t14 VPWR.t1 0.112772
R3 VPWR.n86 VPWR.n85 9.0005
R4 VPWR.n3 VPWR.n88 9.0005
R5 VPWR.n0 VPWR.n1 1.09959
R6 VPWR.n15 VPWR.t116 1.03913
R7 VPWR.n44 VPWR.t0 0.392214
R8 VPWR.t87 VPWR.n43 0.730254
R9 VPWR.t20 VPWR.n7 0.0346862
R10 VPWR.t243 VPWR.n59 0.123414
R11 VPWR.t649 VPWR.n10 0.387453
R12 VPWR.t346 VPWR.n47 0.090904
R13 VPWR.n49 VPWR.n6 4.22738
R14 VPWR.t216 VPWR.n8 8.49975
R15 VPWR.n8 VPWR.n56 4.17746
R16 VPWR.n34 VPWR.t134 0.175331
R17 VPWR.n11 VPWR.t172 0.119079
R18 VPWR.t480 VPWR.n52 0.118742
R19 VPWR.n8 VPWR.n21 3.30738
R20 VPWR.n13 VPWR.t617 0.177814
R21 VPWR.n6 VPWR.n33 4.177
R22 VPWR.n33 VPWR.t117 0.119605
R23 VPWR.n26 VPWR.t519 0.17801
R24 VPWR.t615 VPWR.n27 0.177814
R25 VPWR.n5 VPWR.n18 2.02145
R26 VPWR.n20 VPWR.n5 3.30696
R27 VPWR.n5 VPWR.n45 4.177
R28 VPWR.n45 VPWR.t481 0.119605
R29 VPWR.n24 VPWR.t21 0.2914
R30 VPWR.t854 VPWR.t538 0.468595
R31 VPWR.n17 VPWR.n5 3.36144
R32 VPWR.t530 VPWR.n5 8.47111
R33 VPWR.n46 VPWR.t358 0.119605
R34 VPWR.n46 VPWR.n5 4.177
R35 VPWR.n6 VPWR.t350 8.47111
R36 VPWR.n6 VPWR.n47 4.19881
R37 VPWR.n6 VPWR.n48 4.18203
R38 VPWR.n30 VPWR.t60 0.177827
R39 VPWR.t727 VPWR.n6 8.47111
R40 VPWR.t669 VPWR.n49 0.0330928
R41 VPWR.n6 VPWR.t665 8.47111
R42 VPWR.n6 VPWR.n50 4.177
R43 VPWR.n50 VPWR.t512 0.119605
R44 VPWR.t508 VPWR.n31 0.17801
R45 VPWR.n32 VPWR.t421 0.10981
R46 VPWR.n6 VPWR.t146 8.47111
R47 VPWR.n6 VPWR.t130 8.47111
R48 VPWR.n51 VPWR.n6 4.177
R49 VPWR.n51 VPWR.t126 0.119605
R50 VPWR.n35 VPWR.t122 0.119605
R51 VPWR.n6 VPWR.n35 4.177
R52 VPWR.n52 VPWR.n6 4.17752
R53 VPWR.n36 VPWR.t631 0.119605
R54 VPWR.n6 VPWR.n36 4.177
R55 VPWR.n53 VPWR.n6 4.177
R56 VPWR.t625 VPWR.n53 0.119605
R57 VPWR.n54 VPWR.n6 4.177
R58 VPWR.n54 VPWR.t226 0.119605
R59 VPWR.n23 VPWR.t221 0.17801
R60 VPWR.n8 VPWR.n55 4.177
R61 VPWR.n55 VPWR.t251 0.119605
R62 VPWR.n37 VPWR.t248 0.17801
R63 VPWR.n38 VPWR.t215 0.177814
R64 VPWR.n22 VPWR.n8 3.30688
R65 VPWR.n39 VPWR.t794 0.0638656
R66 VPWR.t730 VPWR.n40 0.179397
R67 VPWR.n40 VPWR.n8 2.7614
R68 VPWR.n8 VPWR.t839 8.47111
R69 VPWR.n8 VPWR.n41 3.3524
R70 VPWR.n8 VPWR.n11 4.1774
R71 VPWR.n56 VPWR.t168 0.11899
R72 VPWR.n57 VPWR.t166 0.119605
R73 VPWR.n57 VPWR.n8 4.177
R74 VPWR.t162 VPWR.n8 8.47111
R75 VPWR.t160 VPWR.n42 0.119605
R76 VPWR.n42 VPWR.n8 4.177
R77 VPWR.n58 VPWR.n5 2.73418
R78 VPWR.n7 VPWR.n6 0.0410911
R79 VPWR.n5 VPWR.t312 5.66639
R80 VPWR.n6 VPWR.n32 3.3524
R81 VPWR.n8 VPWR.t249 5.66639
R82 VPWR.n41 VPWR.t34 0.0737819
R83 VPWR.t516 VPWR.n19 0.158239
R84 VPWR.t532 VPWR.n17 0.0428552
R85 VPWR.n39 VPWR.n8 3.36144
R86 VPWR.n6 VPWR.n16 2.72543
R87 VPWR.n6 VPWR.n30 3.30705
R88 VPWR.n6 VPWR.n34 3.30814
R89 VPWR.n6 VPWR.n12 2.72171
R90 VPWR.n12 VPWR.t224 0.174183
R91 VPWR.n6 VPWR.n13 3.30696
R92 VPWR.n6 VPWR.t489 5.61485
R93 VPWR.n25 VPWR.t143 0.122599
R94 VPWR.n58 VPWR.t242 0.1655
R95 VPWR.n5 VPWR.n26 3.30688
R96 VPWR.n5 VPWR.n19 2.73604
R97 VPWR.n5 VPWR.t260 5.61485
R98 VPWR.n27 VPWR.n5 3.30696
R99 VPWR.t23 VPWR.n18 0.219808
R100 VPWR.t307 VPWR.n20 0.118193
R101 VPWR.n81 VPWR.n5 5.61485
R102 VPWR.n5 VPWR.n14 1.97603
R103 VPWR.n5 VPWR.n24 2.29759
R104 VPWR.n9 VPWR.t568 0.0600369
R105 VPWR.n5 VPWR.n28 3.30688
R106 VPWR.n6 VPWR.t345 5.61485
R107 VPWR.t65 VPWR.n16 0.17008
R108 VPWR.n6 VPWR.n29 3.30688
R109 VPWR.t510 VPWR.n6 5.61485
R110 VPWR.n6 VPWR.n31 3.30688
R111 VPWR.n6 VPWR.t849 5.61485
R112 VPWR.n6 VPWR.t124 5.61485
R113 VPWR.n6 VPWR.t479 5.61485
R114 VPWR.n8 VPWR.n23 3.30688
R115 VPWR.n8 VPWR.n37 3.30688
R116 VPWR.n38 VPWR.n8 3.30696
R117 VPWR.n22 VPWR.t389 0.118323
R118 VPWR.t388 VPWR.n8 5.61485
R119 VPWR.n21 VPWR.t522 0.117576
R120 VPWR.t521 VPWR.n8 5.61485
R121 VPWR.t18 VPWR.n59 3.33348
R122 VPWR.t193 VPWR.n61 5.16578
R123 VPWR.n82 VPWR.t262 5.16578
R124 VPWR.n80 VPWR.t119 5.16578
R125 VPWR.n66 VPWR.n61 4.5005
R126 VPWR.n83 VPWR.t36 4.5005
R127 VPWR.n82 VPWR.t569 4.5005
R128 VPWR.t485 VPWR.n80 4.5005
R129 VPWR.n84 VPWR.n3 4.49573
R130 VPWR.n3 VPWR.n60 4.49046
R131 VPWR.n87 VPWR.n86 4.49046
R132 VPWR.n2 VPWR.n0 3.29959
R133 VPWR.n8 VPWR.t157 5.63643
R134 VPWR.n25 VPWR.n6 2.35111
R135 VPWR.t0 VPWR.n64 3.30758
R136 VPWR.t0 VPWR.t198 2.72109
R137 VPWR.t18 VPWR.n10 1.53119
R138 VPWR.t18 VPWR.t261 1.38228
R139 VPWR.n15 VPWR.t24 0.551463
R140 VPWR.t678 VPWR.t18 1.20447
R141 VPWR.t18 VPWR.n72 1.17385
R142 VPWR.t559 VPWR.n74 1.16943
R143 VPWR.t120 VPWR.n71 1.14189
R144 VPWR.t651 VPWR.n76 1.14095
R145 VPWR.t218 VPWR.t68 1.09668
R146 VPWR.t313 VPWR.n79 1.08908
R147 VPWR.t42 VPWR.t46 1.08357
R148 VPWR.t586 VPWR.t396 1.08239
R149 VPWR.t41 VPWR.n44 0.916035
R150 VPWR.n63 VPWR.t1 1.06455
R151 VPWR.n79 VPWR.t96 1.06378
R152 VPWR.t68 VPWR.t58 1.06116
R153 VPWR.t596 VPWR.n77 1.04671
R154 VPWR.n76 VPWR.t104 1.04337
R155 VPWR.n77 VPWR.t313 1.03656
R156 VPWR.n78 VPWR.t0 1.03555
R157 VPWR.n68 VPWR.t218 1.03476
R158 VPWR.n71 VPWR.t106 1.02548
R159 VPWR.t649 VPWR.t156 1.02366
R160 VPWR.t685 VPWR.n70 1.02364
R161 VPWR.n65 VPWR.t78 1.02221
R162 VPWR.t403 VPWR.t174 1.01197
R163 VPWR.t78 VPWR.t586 1.01148
R164 VPWR.t119 VPWR.n67 1.01103
R165 VPWR.t116 VPWR.t115 1.00774
R166 VPWR.n74 VPWR.t19 1.00577
R167 VPWR.t25 VPWR.n69 1.00228
R168 VPWR.t115 VPWR.t17 1.00154
R169 VPWR.n73 VPWR.t193 0.995832
R170 VPWR.n67 VPWR.t58 0.96216
R171 VPWR.t36 VPWR.n63 0.95752
R172 VPWR.t46 VPWR.n65 0.951052
R173 VPWR.t396 VPWR.t403 0.915485
R174 VPWR.t19 VPWR.n75 0.907799
R175 VPWR.n69 VPWR.t262 0.90153
R176 VPWR.t0 VPWR.n4 0.80532
R177 VPWR.t96 VPWR.n43 0.92476
R178 VPWR.t193 VPWR.t427 0.840534
R179 VPWR.n62 VPWR.t0 0.837656
R180 VPWR.t254 VPWR.t87 0.831059
R181 VPWR.t182 VPWR.n73 0.826655
R182 VPWR.n43 VPWR.t0 0.671146
R183 VPWR.n4 VPWR.t254 0.0370355
R184 VPWR.n70 VPWR.t120 0.760222
R185 VPWR.n75 VPWR.t651 0.745063
R186 VPWR.t18 VPWR.n69 0.728502
R187 VPWR.t18 VPWR.t427 0.718035
R188 VPWR.t678 VPWR.t243 0.703218
R189 VPWR.n4 VPWR.t14 0.696765
R190 VPWR.t538 VPWR.t569 0.673353
R191 VPWR.t119 VPWR.t678 0.670077
R192 VPWR.t36 VPWR.n62 0.661771
R193 VPWR.n78 VPWR.t41 0.655961
R194 VPWR.n72 VPWR.t106 0.615091
R195 VPWR.t0 VPWR.t403 0.605175
R196 VPWR.t685 VPWR.t261 0.586139
R197 VPWR.t427 VPWR.t559 0.560497
R198 VPWR.t0 VPWR.n65 0.553018
R199 VPWR.t0 VPWR.t115 0.52886
R200 VPWR.t18 VPWR.n73 0.507064
R201 VPWR.t18 VPWR.n71 0.505944
R202 VPWR.t18 VPWR.n76 0.505685
R203 VPWR.t596 VPWR.n78 0.502233
R204 VPWR.n10 VPWR.t25 0.436678
R205 VPWR.n84 VPWR.n83 0.4845
R206 VPWR.t18 VPWR.n70 0.476193
R207 VPWR.n77 VPWR.t0 0.463677
R208 VPWR.t0 VPWR.t586 0.462892
R209 VPWR.n44 VPWR.t42 0.0507584
R210 VPWR.t18 VPWR.n74 0.462438
R211 VPWR.t261 VPWR.t262 0.439604
R212 VPWR VPWR.n3 0.42994
R213 VPWR.n79 VPWR.t0 0.425099
R214 VPWR.t18 VPWR.t68 0.423164
R215 VPWR.t18 VPWR.n75 0.39206
R216 VPWR.t0 VPWR.n63 0.362426
R217 VPWR.n14 VPWR.t497 0.286727
R218 VPWR.t657 VPWR.t260 0.360811
R219 VPWR.t487 VPWR.t489 0.360811
R220 VPWR.t568 VPWR.t155 0.360471
R221 VPWR.t388 VPWR.t389 0.360471
R222 VPWR.t521 VPWR.t522 0.360471
R223 VPWR.n12 VPWR.t222 0.174184
R224 VPWR.n83 VPWR 0.3525
R225 VPWR.n16 VPWR.t386 0.170303
R226 VPWR.t18 VPWR.n68 0.341414
R227 VPWR.t198 VPWR.t181 0.336158
R228 VPWR.t144 VPWR.t146 0.330788
R229 VPWR.t657 VPWR.n19 0.157534
R230 VPWR.t181 VPWR.n64 0.317829
R231 VPWR.t17 VPWR.t198 0.314035
R232 VPWR.t508 VPWR.t510 0.301114
R233 VPWR.t352 VPWR.n28 0.118323
R234 VPWR.t61 VPWR.n29 0.118323
R235 VPWR.t422 VPWR.n31 0.118323
R236 VPWR.t105 VPWR.n81 0.301114
R237 VPWR.t306 VPWR.t307 0.301114
R238 VPWR.t564 VPWR.n18 0.174341
R239 VPWR.t868 VPWR.n26 0.118323
R240 VPWR.n24 VPWR.t155 0.232176
R241 VPWR.t391 VPWR.t300 0.301114
R242 VPWR.n29 VPWR.t65 0.478624
R243 VPWR.t117 VPWR.t489 0.301114
R244 VPWR.t124 VPWR.t126 0.301114
R245 VPWR.n22 VPWR.t391 0.17801
R246 VPWR.t252 VPWR.n23 0.118323
R247 VPWR.t247 VPWR.n37 0.118323
R248 VPWR.t794 VPWR.t521 0.301114
R249 VPWR.t303 VPWR.n30 0.118208
R250 VPWR.n14 VPWR.t105 0.346587
R251 VPWR.n20 VPWR.t423 0.177814
R252 VPWR.t23 VPWR.n27 0.478504
R253 VPWR.t615 VPWR.t260 0.300775
R254 VPWR.n81 VPWR.t481 0.300775
R255 VPWR.t21 VPWR.t497 0.300775
R256 VPWR.t510 VPWR.t512 0.300775
R257 VPWR.t350 VPWR.t352 0.300775
R258 VPWR.t40 VPWR.t345 0.300775
R259 VPWR.t60 VPWR.t61 0.300775
R260 VPWR.t421 VPWR.t422 0.300775
R261 VPWR.t118 VPWR.t143 0.300775
R262 VPWR.n13 VPWR.t487 0.118193
R263 VPWR.t122 VPWR.t124 0.300775
R264 VPWR.t631 VPWR.t479 0.300775
R265 VPWR.t253 VPWR.t252 0.300775
R266 VPWR.t300 VPWR.n38 0.118193
R267 VPWR.t224 VPWR.t226 0.30075
R268 VPWR.t130 VPWR.t132 0.300355
R269 VPWR.t221 VPWR.t222 0.300355
R270 VPWR.t727 VPWR.t303 0.300228
R271 VPWR.t524 VPWR.t388 0.299335
R272 VPWR.t479 VPWR.t480 0.299167
R273 VPWR.t524 VPWR.n21 0.17689
R274 VPWR.t134 VPWR.t849 0.298457
R275 VPWR.n34 VPWR.t132 0.116545
R276 VPWR.t157 VPWR.t158 0.283026
R277 VPWR.t423 VPWR.t564 0.263235
R278 VPWR.t730 VPWR.t520 0.263235
R279 VPWR.t530 VPWR.t532 0.263235
R280 VPWR.t242 VPWR.t312 0.244152
R281 VPWR.n45 VPWR.t306 0.119605
R282 VPWR.t158 VPWR.n42 0.119605
R283 VPWR.t160 VPWR.t162 0.241078
R284 VPWR.t162 VPWR.t164 0.241078
R285 VPWR.t729 VPWR.n40 0.122722
R286 VPWR.t230 VPWR.t625 0.241078
R287 VPWR.n53 VPWR.t232 0.119605
R288 VPWR.t669 VPWR.t727 0.241078
R289 VPWR.n28 VPWR.t356 0.418588
R290 VPWR.t18 VPWR.n67 0.304207
R291 VPWR.t536 VPWR.t854 0.241078
R292 VPWR.t358 VPWR.t530 0.241078
R293 VPWR.t356 VPWR.n46 0.119605
R294 VPWR.t348 VPWR.t350 0.241078
R295 VPWR.t663 VPWR.t665 0.241078
R296 VPWR.n50 VPWR.t663 0.119605
R297 VPWR.n33 VPWR.t118 0.119605
R298 VPWR.t128 VPWR.t130 0.241078
R299 VPWR.n51 VPWR.t128 0.119605
R300 VPWR.t121 VPWR.n35 0.119605
R301 VPWR.t637 VPWR.t121 0.241078
R302 VPWR.t234 VPWR.n36 0.119605
R303 VPWR.t232 VPWR.t234 0.241078
R304 VPWR.n54 VPWR.t230 0.119605
R305 VPWR.n55 VPWR.t253 0.119605
R306 VPWR.t35 VPWR.t839 0.241078
R307 VPWR.t166 VPWR.t168 0.241078
R308 VPWR.t164 VPWR.n57 0.119605
R309 VPWR.n11 VPWR.t566 0.119071
R310 VPWR.n56 VPWR.t170 0.118999
R311 VPWR.n52 VPWR.t637 0.118738
R312 VPWR.n64 VPWR.t174 0.236403
R313 VPWR.t170 VPWR.t172 0.236067
R314 VPWR.n48 VPWR.t40 0.112913
R315 VPWR.n25 VPWR.t144 0.0919335
R316 VPWR.n72 VPWR.t816 0.211792
R317 VPWR.t244 VPWR.n59 0.0818513
R318 VPWR.n62 VPWR.t366 0.193897
R319 VPWR.t248 VPWR.t249 0.185371
R320 VPWR.t146 VPWR.t419 0.185371
R321 VPWR.t519 VPWR.t312 0.185371
R322 VPWR.t419 VPWR.n32 0.0737819
R323 VPWR.t249 VPWR.t251 0.184455
R324 VPWR.t35 VPWR.n41 0.10981
R325 VPWR.t839 VPWR.t729 0.183789
R326 VPWR.t215 VPWR.t216 0.183789
R327 VPWR.t665 VPWR.t667 0.183789
R328 VPWR.n47 VPWR.t348 0.0905912
R329 VPWR.t485 VPWR.t849 0.180825
R330 VPWR.t868 VPWR.t516 0.1657
R331 VPWR.t244 VPWR.t104 0.154575
R332 VPWR.t386 VPWR.n48 0.257712
R333 VPWR.t345 VPWR.t346 0.12695
R334 VPWR.t216 VPWR.t247 0.124735
R335 VPWR.t485 VPWR.t617 0.120789
R336 VPWR.n58 VPWR.t142 0.244174
R337 VPWR.t0 VPWR.n15 0.228646
R338 VPWR.n9 VPWR.t569 0.219761
R339 VPWR.n7 VPWR.n5 0.116667
R340 VPWR.n17 VPWR.t536 0.0638656
R341 VPWR.t520 VPWR.n39 0.0428552
R342 VPWR.t566 VPWR.n66 0.100789
R343 VPWR.t156 VPWR.n68 0.0934142
R344 VPWR.n66 VPWR.t34 0.0850823
R345 VPWR.n6 VPWR.n8 0.0812715
R346 VPWR.t14 VPWR.t446 0.0728699
R347 VPWR.t667 VPWR.n49 0.0332013
R348 VPWR.n88 VPWR.n61 0.05506
R349 VPWR.n2 VPWR.n82 0.120884
R350 VPWR.n80 VPWR.n1 0.120884
R351 VPWR.n87 VPWR.n60 0.0436411
R352 VPWR.t181 VPWR.n2 5.05031
R353 VPWR.n86 VPWR.n0 2.2005
R354 VPWR.n85 VPWR.n84 0.04274
R355 VPWR.n86 VPWR.n3 0.0225952
R356 VPWR.n85 VPWR.n60 0.0220706
R357 VPWR.n88 VPWR.n87 0.0220706
R358 VPWR.t596 VPWR.n1 5.05031
R359 VGND.n606 VGND.n45 6317.68
R360 VGND.n45 VGND.n0 6058.01
R361 VGND.t442 VGND.n0 183.805
R362 VGND.n0 VGND.t447 183.806
R363 VGND.n0 VGND.n64 14.245
R364 VGND.n95 VGND.n0 0.37382
R365 VGND.t584 VGND.n82 29.6918
R366 VGND.t711 VGND.n79 29.6918
R367 VGND.n84 VGND.n0 16.2739
R368 VGND.n93 VGND.n0 0.37382
R369 VGND.n66 VGND.n0 0.37382
R370 VGND.t864 VGND.n507 710.804
R371 VGND.t149 VGND.n88 42.9343
R372 VGND.n507 VGND.t515 696.027
R373 VGND.n478 VGND.t151 694.582
R374 VGND.t514 VGND.n505 694.582
R375 VGND.n537 VGND.t901 694.582
R376 VGND.n452 VGND.t670 679.803
R377 VGND.n465 VGND.t569 679.803
R378 VGND.n479 VGND.t217 679.803
R379 VGND.n492 VGND.t288 679.803
R380 VGND.n509 VGND.t865 679.803
R381 VGND.n522 VGND.t46 679.803
R382 VGND.t900 VGND.n535 679.803
R383 VGND.n540 VGND.t713 679.803
R384 VGND.n553 VGND.t586 679.803
R385 VGND.t804 VGND.n0 61.8303
R386 VGND.t775 VGND.n603 651.692
R387 VGND.t684 VGND.n89 66.2758
R388 VGND.n87 VGND.t582 118.328
R389 VGND.t233 VGND.n94 66.2767
R390 VGND.n92 VGND.t301 118.328
R391 VGND.t513 VGND.n91 652.615
R392 VGND.n86 VGND.t879 118.328
R393 VGND.n85 VGND.t60 118.328
R394 VGND.n538 VGND.t902 650.246
R395 VGND.t727 VGND.n81 66.2767
R396 VGND.t600 VGND.n72 66.2766
R397 VGND.n64 VGND.t165 652.615
R398 VGND.n453 VGND.t671 635.468
R399 VGND.n466 VGND.t570 635.468
R400 VGND.n480 VGND.t218 635.468
R401 VGND.n493 VGND.t289 635.468
R402 VGND.n510 VGND.t866 635.468
R403 VGND.n523 VGND.t47 635.468
R404 VGND.t899 VGND.n80 638.513
R405 VGND.n541 VGND.t714 635.468
R406 VGND.n554 VGND.t587 635.468
R407 VGND.n91 VGND.n0 14.245
R408 VGND.n65 VGND.t153 86.6784
R409 VGND.t683 VGND.n464 605.912
R410 VGND.t582 VGND.n477 605.912
R411 VGND.t232 VGND.n491 605.912
R412 VGND.t301 VGND.n504 605.912
R413 VGND.t879 VGND.n521 605.912
R414 VGND.t60 VGND.n534 605.912
R415 VGND.n539 VGND.t903 605.912
R416 VGND.t726 VGND.n552 605.912
R417 VGND.t599 VGND.n565 605.912
R418 VGND.t898 VGND.n80 106.153
R419 VGND.n454 VGND.t672 591.134
R420 VGND.n467 VGND.t571 591.134
R421 VGND.n481 VGND.t219 591.134
R422 VGND.n494 VGND.t290 591.134
R423 VGND.n511 VGND.t867 591.134
R424 VGND.n524 VGND.t48 591.134
R425 VGND.n542 VGND.t715 591.134
R426 VGND.n555 VGND.t588 591.134
R427 VGND.t63 VGND.n62 114.002
R428 VGND.n60 VGND.t162 114.004
R429 VGND.n63 VGND.t304 155.251
R430 VGND.t682 VGND.n463 561.577
R431 VGND.t581 VGND.n476 561.577
R432 VGND.t230 VGND.n490 561.577
R433 VGND.t300 VGND.n503 561.577
R434 VGND.t878 VGND.n520 561.577
R435 VGND.t58 VGND.n533 561.577
R436 VGND.t725 VGND.n551 561.577
R437 VGND.t598 VGND.n564 561.577
R438 VGND.n455 VGND.t673 546.798
R439 VGND.n468 VGND.t572 546.798
R440 VGND.n482 VGND.t220 546.798
R441 VGND.n495 VGND.t291 546.798
R442 VGND.n512 VGND.t868 546.798
R443 VGND.n525 VGND.t49 546.798
R444 VGND.n543 VGND.t716 546.798
R445 VGND.n556 VGND.t589 546.798
R446 VGND.t164 VGND.n84 539.747
R447 VGND.n78 VGND.t905 138.046
R448 VGND.t681 VGND.n462 517.241
R449 VGND.t580 VGND.n475 517.241
R450 VGND.t229 VGND.n489 517.241
R451 VGND.t299 VGND.n502 517.241
R452 VGND.t877 VGND.n519 517.241
R453 VGND.t57 VGND.n532 517.241
R454 VGND.t724 VGND.n550 517.241
R455 VGND.t597 VGND.n563 517.241
R456 VGND.n456 VGND.t674 502.464
R457 VGND.n469 VGND.t573 502.464
R458 VGND.n483 VGND.t221 502.464
R459 VGND.n496 VGND.t292 502.464
R460 VGND.n513 VGND.t869 502.464
R461 VGND.n526 VGND.t50 502.464
R462 VGND.n544 VGND.t717 502.464
R463 VGND.n557 VGND.t590 502.464
R464 VGND.t680 VGND.n461 472.906
R465 VGND.t579 VGND.n474 472.906
R466 VGND.t228 VGND.n488 472.906
R467 VGND.t298 VGND.n501 472.906
R468 VGND.t876 VGND.n518 472.906
R469 VGND.t56 VGND.n531 472.906
R470 VGND.t723 VGND.n549 472.906
R471 VGND.t596 VGND.n562 472.906
R472 VGND.t286 VGND.n0 174.839
R473 VGND.n457 VGND.t675 458.128
R474 VGND.n470 VGND.t574 458.128
R475 VGND.n484 VGND.t222 458.128
R476 VGND.n497 VGND.t293 458.128
R477 VGND.n514 VGND.t870 458.128
R478 VGND.n527 VGND.t51 458.128
R479 VGND.n545 VGND.t718 458.128
R480 VGND.n558 VGND.t591 458.128
R481 VGND.t679 VGND.n460 428.572
R482 VGND.t578 VGND.n473 428.572
R483 VGND.t227 VGND.n487 428.572
R484 VGND.t297 VGND.n500 428.572
R485 VGND.t875 VGND.n517 428.572
R486 VGND.t55 VGND.n530 428.572
R487 VGND.t722 VGND.n548 428.572
R488 VGND.t595 VGND.n561 428.572
R489 VGND.t429 VGND.n0 182.042
R490 VGND.t433 VGND.n0 182.042
R491 VGND.n14 VGND.t43 422.846
R492 VGND.n90 VGND.t785 8.07964
R493 VGND.n27 VGND.n56 0.613873
R494 VGND.n54 VGND.t132 22.913
R495 VGND.t881 VGND.n24 418.841
R496 VGND.n9 VGND.t732 418.56
R497 VGND.t268 VGND.n16 418.56
R498 VGND.t361 VGND.n43 16.0228
R499 VGND.t361 VGND.n58 16.0236
R500 VGND.t750 VGND.n32 418.56
R501 VGND.t566 VGND.n33 418.56
R502 VGND.n40 VGND.t462 418.56
R503 VGND.n458 VGND.t676 413.793
R504 VGND.n471 VGND.t575 413.793
R505 VGND.n485 VGND.t223 413.793
R506 VGND.n498 VGND.t294 413.793
R507 VGND.n515 VGND.t871 413.793
R508 VGND.n528 VGND.t52 413.793
R509 VGND.n546 VGND.t719 413.793
R510 VGND.n559 VGND.t592 413.793
R511 VGND.t358 VGND.n27 109.7
R512 VGND.n71 VGND.t389 242.846
R513 VGND.t812 VGND.n114 407.144
R514 VGND.n0 VGND.t451 182.042
R515 VGND.n622 VGND.t826 402.858
R516 VGND.t817 VGND.n206 402.858
R517 VGND.n249 VGND.t159 402.858
R518 VGND.t238 VGND.n186 402.858
R519 VGND.n261 VGND.t74 402.858
R520 VGND.n52 VGND.t0 411.541
R521 VGND.n421 VGND.t37 402.858
R522 VGND.n71 VGND.t693 418.56
R523 VGND.n74 VGND.t774 26.8309
R524 VGND.n30 VGND.t619 397.132
R525 VGND.t163 VGND.n30 397.132
R526 VGND.t171 VGND.n135 394.286
R527 VGND.n144 VGND.t882 394.286
R528 VGND.n156 VGND.t540 394.286
R529 VGND.n158 VGND.t236 394.286
R530 VGND.n223 VGND.t827 394.286
R531 VGND.t733 VGND.n214 394.286
R532 VGND.n240 VGND.t818 394.286
R533 VGND.t160 VGND.n196 394.286
R534 VGND.n251 VGND.t757 394.286
R535 VGND.t75 VGND.n183 394.286
R536 VGND.n263 VGND.t497 394.286
R537 VGND.n44 VGND.t532 29.4525
R538 VGND.t649 VGND.n609 394.286
R539 VGND.n617 VGND.t127 394.286
R540 VGND.t517 VGND.n360 394.286
R541 VGND.t2 VGND.n440 394.286
R542 VGND.n426 VGND.t821 394.286
R543 VGND.t308 VGND.n419 394.286
R544 VGND.t100 VGND.n413 394.286
R545 VGND.t134 VGND.n380 394.286
R546 VGND.t481 VGND.n350 394.286
R547 VGND.n321 VGND.t694 394.286
R548 VGND.t544 VGND.n320 394.286
R549 VGND.t192 VGND.n310 394.286
R550 VGND.n307 VGND.t23 394.286
R551 VGND.t687 VGND.t802 390
R552 VGND.n155 VGND.t19 385.714
R553 VGND.n250 VGND.t808 385.714
R554 VGND.n277 VGND.t940 385.714
R555 VGND.t935 VGND.n607 385.714
R556 VGND.t193 VGND.t842 385.714
R557 VGND.t533 VGND.n22 384.274
R558 VGND.t565 VGND.n34 384.274
R559 VGND.t678 VGND.n459 384.236
R560 VGND.t577 VGND.n472 384.236
R561 VGND.t226 VGND.n486 384.236
R562 VGND.t296 VGND.n499 384.236
R563 VGND.t874 VGND.n516 384.236
R564 VGND.t54 VGND.n529 384.236
R565 VGND.t721 VGND.n547 384.236
R566 VGND.t594 VGND.n560 384.236
R567 VGND.n75 VGND.t186 42.9373
R568 VGND.t841 VGND.n216 377.144
R569 VGND.n239 VGND.t816 377.144
R570 VGND.t158 VGND.n197 377.144
R571 VGND.t771 VGND.n187 377.144
R572 VGND.n259 VGND.t239 377.144
R573 VGND.t72 VGND.n184 377.144
R574 VGND.n283 VGND.t801 377.144
R575 VGND.n616 VGND.t125 377.144
R576 VGND.t651 VGND.n608 377.144
R577 VGND.t530 VGND.n69 74.4159
R578 VGND.n427 VGND.t17 377.144
R579 VGND.n422 VGND.t36 377.144
R580 VGND.n381 VGND.t616 377.144
R581 VGND.t147 VGND.n68 74.4159
R582 VGND.n586 VGND.t96 377.144
R583 VGND.n600 VGND.t194 377.144
R584 VGND.n298 VGND.t26 377.144
R585 VGND.n301 VGND.t266 377.144
R586 VGND.t807 VGND.n115 372.858
R587 VGND.n620 VGND.t155 372.858
R588 VGND.n0 VGND.t438 185.647
R589 VGND.t435 VGND.n0 185.647
R590 VGND.t44 VGND.n70 29.6918
R591 VGND.n0 VGND.t448 185.648
R592 VGND.n459 VGND.t677 369.459
R593 VGND.n472 VGND.t576 369.459
R594 VGND.n486 VGND.t225 369.459
R595 VGND.n499 VGND.t295 369.459
R596 VGND.n516 VGND.t873 369.459
R597 VGND.n529 VGND.t53 369.459
R598 VGND.n547 VGND.t720 369.459
R599 VGND.n560 VGND.t593 369.459
R600 VGND.n136 VGND.t173 368.572
R601 VGND.t883 VGND.n127 368.572
R602 VGND.t541 VGND.n116 368.572
R603 VGND.n232 VGND.t734 368.572
R604 VGND.t819 VGND.n205 368.572
R605 VGND.t758 VGND.n194 368.572
R606 VGND.n264 VGND.t498 368.572
R607 VGND.t271 VGND.n175 368.572
R608 VGND.n613 VGND.t686 368.572
R609 VGND.n361 VGND.t518 368.572
R610 VGND.t309 VGND.n418 368.572
R611 VGND.t39 VGND.n417 368.572
R612 VGND.t135 VGND.n379 368.572
R613 VGND.n568 VGND.t482 368.572
R614 VGND.n322 VGND.t695 368.572
R615 VGND.n591 VGND.t545 368.572
R616 VGND.n599 VGND.t191 368.572
R617 VGND.n67 VGND.t21 375.288
R618 VGND.t457 VGND.n290 368.572
R619 VGND.t751 VGND.n295 368.572
R620 VGND.t806 VGND.n296 368.572
R621 VGND.t460 VGND.n302 368.572
R622 VGND.n27 VGND.t157 367.755
R623 VGND.n33 VGND.t285 367.132
R624 VGND.n36 VGND.t755 367.132
R625 VGND.n36 VGND.t809 367.132
R626 VGND.n152 VGND.t623 360
R627 VGND.t129 VGND.n118 360
R628 VGND.t941 VGND.n167 360
R629 VGND.n619 VGND.t120 360
R630 VGND.n0 VGND.t450 185.643
R631 VGND.t185 VGND.n129 351.43
R632 VGND.t895 VGND.n122 351.43
R633 VGND.t934 VGND.t896 351.43
R634 VGND.t537 VGND.n119 351.43
R635 VGND.n229 VGND.t840 351.43
R636 VGND.t815 VGND.n207 351.43
R637 VGND.n257 VGND.t770 351.43
R638 VGND.n260 VGND.t71 351.43
R639 VGND.n276 VGND.t283 351.43
R640 VGND.n618 VGND.t652 351.43
R641 VGND.t530 VGND.n354 351.43
R642 VGND.n428 VGND.t16 351.43
R643 VGND.n382 VGND.t615 351.43
R644 VGND.n368 VGND.t147 351.43
R645 VGND.t708 VGND.n588 351.43
R646 VGND.n312 VGND.t667 351.43
R647 VGND.t195 VGND.n308 351.43
R648 VGND.n299 VGND.t931 351.43
R649 VGND.t629 VGND.n27 350.613
R650 VGND.n59 VGND.t626 60.8148
R651 VGND.t77 VGND.n3 349.99
R652 VGND.t685 VGND.n22 349.99
R653 VGND.t174 VGND.n134 342.858
R654 VGND.n145 VGND.t884 342.858
R655 VGND.n224 VGND.t829 342.858
R656 VGND.n233 VGND.t735 342.858
R657 VGND.n252 VGND.t759 342.858
R658 VGND.t499 VGND.n182 342.858
R659 VGND.n271 VGND.t272 342.858
R660 VGND.t789 VGND.n166 342.858
R661 VGND.t519 VGND.n359 342.858
R662 VGND.t4 VGND.n438 342.858
R663 VGND.t102 VGND.n411 342.858
R664 VGND.t136 VGND.n378 342.858
R665 VGND.n569 VGND.t483 342.858
R666 VGND.t677 VGND.n458 339.901
R667 VGND.t576 VGND.n471 339.901
R668 VGND.t225 VGND.n485 339.901
R669 VGND.t295 VGND.n498 339.901
R670 VGND.t873 VGND.n515 339.901
R671 VGND.t53 VGND.n528 339.901
R672 VGND.t720 VGND.n546 339.901
R673 VGND.t593 VGND.n559 339.901
R674 VGND.n285 VGND.t264 338.572
R675 VGND.t115 VGND.n286 338.572
R676 VGND.t428 VGND.n0 183.806
R677 VGND.t434 VGND.n0 183.806
R678 VGND.t444 VGND.n0 182.042
R679 VGND.t454 VGND.n0 183.806
R680 VGND.t262 VGND.n120 334.286
R681 VGND.n154 VGND.t624 334.286
R682 VGND.n157 VGND.t542 334.286
R683 VGND.n241 VGND.t820 334.286
R684 VGND.n278 VGND.t630 334.286
R685 VGND.t40 VGND.n416 334.286
R686 VGND.t546 VGND.t653 334.286
R687 VGND.t189 VGND.n311 334.286
R688 VGND.t306 VGND.n25 328.841
R689 VGND.n13 VGND.t65 328.56
R690 VGND.n18 VGND.t910 328.56
R691 VGND.n141 VGND.t184 325.714
R692 VGND.n150 VGND.t894 325.714
R693 VGND.n153 VGND.t536 325.714
R694 VGND.t839 VGND.n217 325.714
R695 VGND.n209 VGND.t745 325.714
R696 VGND.n238 VGND.t814 325.714
R697 VGND.t783 VGND.n198 325.714
R698 VGND.t769 VGND.n188 325.714
R699 VGND.t70 VGND.n185 325.714
R700 VGND.t509 VGND.n177 325.714
R701 VGND.t282 VGND.n170 325.714
R702 VGND.n366 VGND.t529 325.714
R703 VGND.n429 VGND.t15 325.714
R704 VGND.n369 VGND.t146 325.714
R705 VGND.n585 VGND.t94 325.714
R706 VGND.t936 VGND.t696 325.714
R707 VGND.n332 VGND.t707 325.714
R708 VGND.n598 VGND.t666 325.714
R709 VGND.n601 VGND.t197 325.714
R710 VGND.n460 VGND.t678 325.123
R711 VGND.n473 VGND.t577 325.123
R712 VGND.n487 VGND.t226 325.123
R713 VGND.n500 VGND.t296 325.123
R714 VGND.n517 VGND.t874 325.123
R715 VGND.n530 VGND.t54 325.123
R716 VGND.n548 VGND.t721 325.123
R717 VGND.n561 VGND.t594 325.123
R718 VGND.t439 VGND.n0 182.042
R719 VGND.n0 VGND.t436 182.042
R720 VGND.t431 VGND.n0 183.805
R721 VGND.n0 VGND.t425 182.042
R722 VGND.n137 VGND.t175 317.144
R723 VGND.t830 VGND.n221 317.144
R724 VGND.t918 VGND.n204 317.144
R725 VGND.t927 VGND.t779 317.144
R726 VGND.t781 VGND.t928 317.144
R727 VGND.t929 VGND.t782 317.144
R728 VGND.t760 VGND.n193 317.144
R729 VGND.n265 VGND.t500 317.144
R730 VGND.t790 VGND.n165 317.144
R731 VGND.t906 VGND.t688 317.144
R732 VGND.t689 VGND.t907 317.144
R733 VGND.t908 VGND.t690 317.144
R734 VGND.t691 VGND.t909 317.144
R735 VGND.n362 VGND.t520 317.144
R736 VGND.t5 VGND.n437 317.144
R737 VGND.t103 VGND.n410 317.144
R738 VGND.t137 VGND.n377 317.144
R739 VGND.n581 VGND.t85 317.144
R740 VGND.n324 VGND.t697 317.144
R741 VGND.n592 VGND.t547 317.144
R742 VGND.n11 VGND.t784 315.704
R743 VGND.n20 VGND.t692 315.704
R744 VGND.t31 VGND.t510 312.858
R745 VGND.t825 VGND.n606 312.858
R746 VGND.t620 VGND.n288 312.858
R747 VGND.t25 VGND.n293 312.858
R748 VGND.t258 VGND.n294 312.858
R749 VGND.t265 VGND.n300 312.858
R750 VGND.t30 VGND.n304 312.858
R751 VGND.t124 VGND.t913 308.572
R752 VGND.t81 VGND.t645 308.572
R753 VGND.t646 VGND.t83 308.572
R754 VGND.t84 VGND.t647 308.572
R755 VGND.t183 VGND.n130 300
R756 VGND.t534 VGND.n120 300
R757 VGND.n237 VGND.t744 300
R758 VGND.t813 VGND.n208 300
R759 VGND.n245 VGND.t926 300
R760 VGND.n178 VGND.t508 300
R761 VGND.n275 VGND.t281 300
R762 VGND.t798 VGND.n161 300
R763 VGND.t528 VGND.n355 300
R764 VGND.n370 VGND.t145 300
R765 VGND.t644 VGND.n340 300
R766 VGND.t93 VGND.n334 300
R767 VGND.t665 VGND.n313 300
R768 VGND.t893 VGND.t752 295.714
R769 VGND.t676 VGND.n457 295.567
R770 VGND.t575 VGND.n470 295.567
R771 VGND.t223 VGND.n484 295.567
R772 VGND.t294 VGND.n497 295.567
R773 VGND.t871 VGND.n514 295.567
R774 VGND.t52 VGND.n527 295.567
R775 VGND.t719 VGND.n545 295.567
R776 VGND.t592 VGND.n558 295.567
R777 VGND.t176 VGND.n133 291.43
R778 VGND.n146 VGND.t886 291.43
R779 VGND.n242 VGND.t919 291.43
R780 VGND.t501 VGND.n181 291.43
R781 VGND.n272 VGND.t274 291.43
R782 VGND.n279 VGND.t791 291.43
R783 VGND.t810 VGND.n159 291.43
R784 VGND.t521 VGND.n358 291.43
R785 VGND.t822 VGND.t33 291.43
R786 VGND.t823 VGND.t34 291.43
R787 VGND.t824 VGND.t35 291.43
R788 VGND.t104 VGND.n409 291.43
R789 VGND.t246 VGND.n398 291.43
R790 VGND.t138 VGND.n376 291.43
R791 VGND.n570 VGND.t485 291.43
R792 VGND.t637 VGND.n343 291.43
R793 VGND.t86 VGND.n337 291.43
R794 VGND.n325 VGND.t698 291.43
R795 VGND.t548 VGND.n318 291.43
R796 VGND.n292 VGND.t42 291.43
R797 VGND.t242 VGND.t111 282.858
R798 VGND.t243 VGND.t112 282.858
R799 VGND.t244 VGND.t113 282.858
R800 VGND.t245 VGND.t114 282.858
R801 VGND.t617 VGND.t613 282.858
R802 VGND.t618 VGND.t614 282.858
R803 VGND.t633 VGND.t492 282.858
R804 VGND.t493 VGND.t634 282.858
R805 VGND.t635 VGND.t494 282.858
R806 VGND.t495 VGND.t636 282.858
R807 VGND.t122 VGND.n0 174.839
R808 VGND.t259 VGND.n0 61.8302
R809 VGND.t261 VGND.n0 174.839
R810 VGND.n461 VGND.t679 280.788
R811 VGND.n474 VGND.t578 280.788
R812 VGND.n488 VGND.t227 280.788
R813 VGND.n501 VGND.t297 280.788
R814 VGND.n518 VGND.t875 280.788
R815 VGND.n531 VGND.t55 280.788
R816 VGND.n549 VGND.t722 280.788
R817 VGND.n562 VGND.t595 280.788
R818 VGND.t511 VGND.t911 278.572
R819 VGND.t648 VGND.t561 278.572
R820 VGND.n140 VGND.t182 274.286
R821 VGND.n149 VGND.t892 274.286
R822 VGND.t837 VGND.n218 274.286
R823 VGND.t925 VGND.n201 274.286
R824 VGND.n268 VGND.t507 274.286
R825 VGND.n162 VGND.t797 274.286
R826 VGND.n365 VGND.t527 274.286
R827 VGND.n431 VGND.t13 274.286
R828 VGND.n404 VGND.t110 274.286
R829 VGND.n385 VGND.t612 274.286
R830 VGND.n371 VGND.t144 274.286
R831 VGND.t491 VGND.n346 274.286
R832 VGND.n578 VGND.t643 274.286
R833 VGND.n584 VGND.t92 274.286
R834 VGND.n597 VGND.t664 274.286
R835 VGND.n2 VGND.t803 272.846
R836 VGND.t234 VGND.t560 270
R837 VGND.n138 VGND.t177 265.714
R838 VGND.t887 VGND.n125 265.714
R839 VGND.t832 VGND.n220 265.714
R840 VGND.n266 VGND.t502 265.714
R841 VGND.t275 VGND.n173 265.714
R842 VGND.t792 VGND.n164 265.714
R843 VGND.n363 VGND.t522 265.714
R844 VGND.t8 VGND.n435 265.714
R845 VGND.t247 VGND.n397 265.714
R846 VGND.t139 VGND.n375 265.714
R847 VGND.t486 VGND.n348 265.714
R848 VGND.n576 VGND.t638 265.714
R849 VGND.n582 VGND.t87 265.714
R850 VGND.n326 VGND.t699 265.714
R851 VGND.n593 VGND.t549 265.714
R852 VGND.t704 VGND.t562 257.144
R853 VGND.t706 VGND.t563 257.144
R854 VGND.n290 VGND.t305 257.144
R855 VGND.t622 VGND.t799 252.857
R856 VGND.n25 VGND.t340 108.639
R857 VGND.n24 VGND.t310 108.639
R858 VGND.t361 VGND.t374 252.065
R859 VGND.n27 VGND.n51 9.63482
R860 VGND.n23 VGND.t315 251.417
R861 VGND.t342 VGND.n11 251.417
R862 VGND.n40 VGND.t405 251.417
R863 VGND.t675 VGND.n456 251.232
R864 VGND.t574 VGND.n469 251.232
R865 VGND.t222 VGND.n483 251.232
R866 VGND.t293 VGND.n496 251.232
R867 VGND.t870 VGND.n513 251.232
R868 VGND.t51 VGND.n526 251.232
R869 VGND.t718 VGND.n544 251.232
R870 VGND.t591 VGND.n557 251.232
R871 VGND.t181 VGND.n131 248.571
R872 VGND.t891 VGND.n148 248.571
R873 VGND.n227 VGND.t836 248.571
R874 VGND.n244 VGND.t924 248.571
R875 VGND.t506 VGND.n179 248.571
R876 VGND.n274 VGND.t279 248.571
R877 VGND.n281 VGND.t796 248.571
R878 VGND.t526 VGND.n356 248.571
R879 VGND.n432 VGND.t12 248.571
R880 VGND.n405 VGND.t109 248.571
R881 VGND.n386 VGND.t611 248.571
R882 VGND.n372 VGND.t143 248.571
R883 VGND.n572 VGND.t490 248.571
R884 VGND.t642 VGND.n341 248.571
R885 VGND.t703 VGND.n329 248.571
R886 VGND.t663 VGND.n314 248.571
R887 VGND.t336 VGND.n48 98.6916
R888 VGND.t373 VGND.n76 100.888
R889 VGND.n55 VGND.t361 9.30719
R890 VGND.t343 VGND.n7 242.846
R891 VGND.t178 VGND.n132 240
R892 VGND.n226 VGND.t833 240
R893 VGND.t736 VGND.t625 240
R894 VGND.t749 VGND.t737 240
R895 VGND.t738 VGND.t116 240
R896 VGND.n235 VGND.t739 240
R897 VGND.n243 VGND.t921 240
R898 VGND.n254 VGND.t763 240
R899 VGND.t240 VGND.t68 240
R900 VGND.t503 VGND.n180 240
R901 VGND.n273 VGND.t276 240
R902 VGND.n280 VGND.t793 240
R903 VGND.t523 VGND.n357 240
R904 VGND.t9 VGND.n434 240
R905 VGND.t106 VGND.n407 240
R906 VGND.t140 VGND.n374 240
R907 VGND.t639 VGND.n342 240
R908 VGND.n327 VGND.t700 240
R909 VGND.t550 VGND.n317 240
R910 VGND.n462 VGND.t680 236.453
R911 VGND.n475 VGND.t579 236.453
R912 VGND.n489 VGND.t228 236.453
R913 VGND.n502 VGND.t298 236.453
R914 VGND.n519 VGND.t876 236.453
R915 VGND.n532 VGND.t56 236.453
R916 VGND.n550 VGND.t723 236.453
R917 VGND.n563 VGND.t596 236.453
R918 VGND.n230 VGND.t321 235.714
R919 VGND.t345 VGND.n196 235.714
R920 VGND.n61 VGND.t327 101.781
R921 VGND.t355 VGND.n169 235.714
R922 VGND.n416 VGND.t372 235.714
R923 VGND.t388 VGND.n333 235.714
R924 VGND.t391 VGND.n589 235.714
R925 VGND.t198 VGND.t361 316.342
R926 VGND.t361 VGND.n67 9.63521
R927 VGND.n306 VGND.t402 235.714
R928 VGND.t423 VGND.n303 235.714
R929 VGND.t248 VGND.t601 231.429
R930 VGND.t311 VGND.n128 227.143
R931 VGND.n147 VGND.t314 227.143
R932 VGND.n622 VGND.t316 227.143
R933 VGND.n225 VGND.t318 227.143
R934 VGND.n231 VGND.t322 227.143
R935 VGND.n61 VGND.t348 236.154
R936 VGND.t762 VGND.t154 227.143
R937 VGND.t330 VGND.n50 235.006
R938 VGND.t352 VGND.n174 227.143
R939 VGND.t356 VGND.n49 106.677
R940 VGND.n52 VGND.t367 102.457
R941 VGND.t369 VGND.n436 227.143
R942 VGND.t375 VGND.n412 227.143
R943 VGND.t382 VGND.n367 227.143
R944 VGND.n571 VGND.t385 227.143
R945 VGND.t361 VGND.t394 109.953
R946 VGND.n73 VGND.t361 9.30762
R947 VGND.n305 VGND.t403 227.143
R948 VGND.n55 VGND.t406 234.188
R949 VGND.n62 VGND.t263 155.252
R950 VGND.t456 VGND.n60 155.252
R951 VGND.n0 VGND.n63 0.980641
R952 VGND.n139 VGND.t180 222.857
R953 VGND.t890 VGND.n124 222.857
R954 VGND.t835 VGND.n219 222.857
R955 VGND.t741 VGND.n211 222.857
R956 VGND.t923 VGND.n202 222.857
R957 VGND.t765 VGND.n190 222.857
R958 VGND.t98 VGND.t766 222.857
R959 VGND.t767 VGND.t78 222.857
R960 VGND.t627 VGND.t768 222.857
R961 VGND.t278 VGND.n172 222.857
R962 VGND.t795 VGND.n163 222.857
R963 VGND.n364 VGND.t525 222.857
R964 VGND.n433 VGND.t11 222.857
R965 VGND.n406 VGND.t108 222.857
R966 VGND.n387 VGND.t610 222.857
R967 VGND.n373 VGND.t142 222.857
R968 VGND.t489 VGND.n347 222.857
R969 VGND.n577 VGND.t641 222.857
R970 VGND.n583 VGND.t90 222.857
R971 VGND.t702 VGND.n328 222.857
R972 VGND.n596 VGND.t662 222.857
R973 VGND.t412 VGND.n53 15.0018
R974 VGND.n27 VGND.n50 8.48814
R975 VGND.n27 VGND.n57 100.308
R976 VGND.n6 VGND.t344 110.704
R977 VGND.t326 VGND.n8 221.417
R978 VGND.n6 VGND.t130 423.171
R979 VGND.n415 VGND.t413 221.417
R980 VGND.t408 VGND.t361 110.704
R981 VGND.t496 VGND.t333 218.571
R982 VGND.t351 VGND.t270 218.571
R983 VGND.n139 VGND.t179 214.286
R984 VGND.t889 VGND.n124 214.286
R985 VGND.t834 VGND.n219 214.286
R986 VGND.t740 VGND.n211 214.286
R987 VGND.t922 VGND.n202 214.286
R988 VGND.t764 VGND.n190 214.286
R989 VGND.n267 VGND.t504 214.286
R990 VGND.t794 VGND.n163 214.286
R991 VGND.n364 VGND.t524 214.286
R992 VGND.t10 VGND.n433 214.286
R993 VGND.t107 VGND.n406 214.286
R994 VGND.t250 VGND.n395 214.286
R995 VGND.t609 VGND.n387 214.286
R996 VGND.t141 VGND.n373 214.286
R997 VGND.t488 VGND.n347 214.286
R998 VGND.n583 VGND.t89 214.286
R999 VGND.n328 VGND.t701 214.286
R1000 VGND.n594 VGND.t552 214.286
R1001 VGND.t748 VGND.t742 210
R1002 VGND.t674 VGND.n455 206.898
R1003 VGND.t573 VGND.n468 206.898
R1004 VGND.t221 VGND.n482 206.898
R1005 VGND.t292 VGND.n495 206.898
R1006 VGND.t869 VGND.n512 206.898
R1007 VGND.t50 VGND.n525 206.898
R1008 VGND.t717 VGND.n543 206.898
R1009 VGND.t590 VGND.n556 206.898
R1010 VGND.t323 VGND.n203 205.714
R1011 VGND.n248 VGND.t326 205.714
R1012 VGND.t350 VGND.n50 102.703
R1013 VGND.n267 VGND.t334 205.714
R1014 VGND.t459 VGND.t337 205.714
R1015 VGND.t376 VGND.n408 205.714
R1016 VGND.t602 VGND.t251 205.714
R1017 VGND.t603 VGND.t252 205.714
R1018 VGND.t604 VGND.t253 205.714
R1019 VGND.t605 VGND.t254 205.714
R1020 VGND.t606 VGND.t255 205.714
R1021 VGND.t607 VGND.t256 205.714
R1022 VGND.t608 VGND.t257 205.714
R1023 VGND.n577 VGND.t416 205.714
R1024 VGND.t396 VGND.n58 206.042
R1025 VGND.n590 VGND.t396 205.714
R1026 VGND.t361 VGND.t709 50.6769
R1027 VGND.t328 VGND.n57 9.68125
R1028 VGND.n27 VGND.n49 3.31704
R1029 VGND.n47 VGND.n27 86.7547
R1030 VGND.t362 VGND.t361 109.993
R1031 VGND.n52 VGND.t361 7.66905
R1032 VGND.t361 VGND.t378 109.993
R1033 VGND.t361 VGND.t400 109.986
R1034 VGND.t316 VGND.n26 199.989
R1035 VGND.n8 VGND.t343 199.989
R1036 VGND.t348 VGND.n13 199.989
R1037 VGND.n3 VGND.t330 199.989
R1038 VGND.t333 VGND.n14 199.989
R1039 VGND.n39 VGND.t389 199.989
R1040 VGND.t406 VGND.n41 199.989
R1041 VGND.t179 VGND.n132 197.143
R1042 VGND.n147 VGND.t889 197.143
R1043 VGND.n226 VGND.t834 197.143
R1044 VGND.n235 VGND.t740 197.143
R1045 VGND.n243 VGND.t922 197.143
R1046 VGND.t933 VGND.t347 197.143
R1047 VGND.n254 VGND.t764 197.143
R1048 VGND.t504 VGND.n180 197.143
R1049 VGND.n273 VGND.t277 197.143
R1050 VGND.n280 VGND.t794 197.143
R1051 VGND.t524 VGND.n357 197.143
R1052 VGND.n434 VGND.t10 197.143
R1053 VGND.n407 VGND.t107 197.143
R1054 VGND.n396 VGND.t250 197.143
R1055 VGND.n388 VGND.t609 197.143
R1056 VGND.n374 VGND.t141 197.143
R1057 VGND.n571 VGND.t488 197.143
R1058 VGND.t640 VGND.n342 197.143
R1059 VGND.t89 VGND.n336 197.143
R1060 VGND.t701 VGND.n327 197.143
R1061 VGND.t661 VGND.n315 197.143
R1062 VGND.t828 VGND.t317 192.857
R1063 VGND.t863 VGND.t761 192.857
R1064 VGND.t329 VGND.t76 192.857
R1065 VGND.t3 VGND.t368 192.857
R1066 VGND.n463 VGND.t681 192.119
R1067 VGND.n476 VGND.t580 192.119
R1068 VGND.n490 VGND.t229 192.119
R1069 VGND.n503 VGND.t299 192.119
R1070 VGND.n520 VGND.t877 192.119
R1071 VGND.n533 VGND.t57 192.119
R1072 VGND.n78 VGND.t904 565.973
R1073 VGND.n551 VGND.t724 192.119
R1074 VGND.n564 VGND.t597 192.119
R1075 VGND.n47 VGND.t357 22.2411
R1076 VGND.t337 VGND.n27 192.042
R1077 VGND.n49 VGND.t335 105.683
R1078 VGND.n61 VGND.n27 7.34144
R1079 VGND.t398 VGND.t361 108.993
R1080 VGND.t377 VGND.t361 108.999
R1081 VGND.t361 VGND.n53 96.0268
R1082 VGND.t360 VGND.t361 108.999
R1083 VGND.t321 VGND.n9 191.417
R1084 VGND.n12 VGND.t345 191.417
R1085 VGND.t372 VGND.n415 191.417
R1086 VGND.t380 VGND.t361 108.639
R1087 VGND.n41 VGND.t423 191.417
R1088 VGND.t180 VGND.n131 188.571
R1089 VGND.t341 VGND.t631 188.571
R1090 VGND.n148 VGND.t890 188.571
R1091 VGND.n236 VGND.t741 188.571
R1092 VGND.n255 VGND.t765 188.571
R1093 VGND.t505 VGND.n179 188.571
R1094 VGND.n274 VGND.t278 188.571
R1095 VGND.n281 VGND.t795 188.571
R1096 VGND.t525 VGND.n356 188.571
R1097 VGND.t108 VGND.n405 188.571
R1098 VGND.t251 VGND.n394 188.571
R1099 VGND.t610 VGND.n386 188.571
R1100 VGND.t142 VGND.n372 188.571
R1101 VGND.n572 VGND.t489 188.571
R1102 VGND.t641 VGND.n341 188.571
R1103 VGND.t90 VGND.n335 188.571
R1104 VGND.n329 VGND.t702 188.571
R1105 VGND.t553 VGND.n316 188.571
R1106 VGND.n603 VGND.t164 186.174
R1107 VGND.n142 VGND.t341 184.286
R1108 VGND.n143 VGND.t311 184.286
R1109 VGND.n228 VGND.t320 184.286
R1110 VGND.t322 VGND.n215 184.286
R1111 VGND.t354 VGND.n171 184.286
R1112 VGND.n430 VGND.t371 184.286
R1113 VGND.t413 VGND.n76 212.758
R1114 VGND.n43 VGND.t382 184.614
R1115 VGND.t387 VGND.n335 184.286
R1116 VGND.n73 VGND.t422 100.888
R1117 VGND.t403 VGND.n302 184.286
R1118 VGND.n55 VGND.t424 100.883
R1119 VGND.t166 VGND.n48 8.35505
R1120 VGND.t313 VGND.n126 175.714
R1121 VGND.t315 VGND.n114 175.714
R1122 VGND.t317 VGND.n222 175.714
R1123 VGND.n227 VGND.t319 175.714
R1124 VGND.t743 VGND.t128 175.714
R1125 VGND.n248 VGND.t342 175.714
R1126 VGND.t347 VGND.n195 175.714
R1127 VGND.n262 VGND.t329 175.714
R1128 VGND.t332 VGND.n51 99.5774
R1129 VGND.n270 VGND.t351 175.714
R1130 VGND.t353 VGND.n172 175.714
R1131 VGND.t368 VGND.n439 175.714
R1132 VGND.t370 VGND.n432 175.714
R1133 VGND.t383 VGND.n349 175.714
R1134 VGND.t386 VGND.n336 175.714
R1135 VGND.t420 VGND.n67 99.5815
R1136 VGND.t405 VGND.n303 175.714
R1137 VGND.n138 VGND.t178 171.429
R1138 VGND.t888 VGND.n125 171.429
R1139 VGND.t833 VGND.n220 171.429
R1140 VGND.t739 VGND.n212 171.429
R1141 VGND.t921 VGND.n203 171.429
R1142 VGND.t763 VGND.n191 171.429
R1143 VGND.n266 VGND.t503 171.429
R1144 VGND.t276 VGND.n173 171.429
R1145 VGND.n363 VGND.t523 171.429
R1146 VGND.n435 VGND.t9 171.429
R1147 VGND.n408 VGND.t106 171.429
R1148 VGND.n397 VGND.t248 171.429
R1149 VGND.n389 VGND.t608 171.429
R1150 VGND.n375 VGND.t140 171.429
R1151 VGND.t487 VGND.n348 171.429
R1152 VGND.n576 VGND.t639 171.429
R1153 VGND.n582 VGND.t88 171.429
R1154 VGND.n595 VGND.t660 171.429
R1155 VGND.t803 VGND.n1 169.989
R1156 VGND.t374 VGND.t99 167.143
R1157 VGND.n140 VGND.t181 162.857
R1158 VGND.n149 VGND.t891 162.857
R1159 VGND.t836 VGND.n218 162.857
R1160 VGND.t742 VGND.n210 162.857
R1161 VGND.t766 VGND.n189 162.857
R1162 VGND.n268 VGND.t506 162.857
R1163 VGND.t279 VGND.n171 162.857
R1164 VGND.t796 VGND.n162 162.857
R1165 VGND.n365 VGND.t526 162.857
R1166 VGND.t12 VGND.n431 162.857
R1167 VGND.t252 VGND.n393 162.857
R1168 VGND.t611 VGND.n385 162.857
R1169 VGND.t143 VGND.n371 162.857
R1170 VGND.n578 VGND.t642 162.857
R1171 VGND.n584 VGND.t91 162.857
R1172 VGND.n330 VGND.t703 162.857
R1173 VGND.n595 VGND.t554 162.857
R1174 VGND.t673 VGND.n454 162.562
R1175 VGND.t572 VGND.n467 162.562
R1176 VGND.t220 VGND.n481 162.562
R1177 VGND.t291 VGND.n494 162.562
R1178 VGND.t868 VGND.n511 162.562
R1179 VGND.t49 VGND.n524 162.562
R1180 VGND.t716 VGND.n542 162.562
R1181 VGND.t589 VGND.n555 162.562
R1182 VGND.t109 VGND.t241 154.286
R1183 VGND.t490 VGND.t632 154.286
R1184 VGND.t564 VGND.n285 154.286
R1185 VGND.n286 VGND.t932 154.286
R1186 VGND.t305 VGND.n289 154.286
R1187 VGND.n464 VGND.t682 147.784
R1188 VGND.n477 VGND.t581 147.784
R1189 VGND.n491 VGND.t230 147.784
R1190 VGND.n504 VGND.t300 147.784
R1191 VGND.n521 VGND.t878 147.784
R1192 VGND.n534 VGND.t58 147.784
R1193 VGND.t904 VGND.n539 147.784
R1194 VGND.n552 VGND.t725 147.784
R1195 VGND.n565 VGND.t598 147.784
R1196 VGND.t177 VGND.n133 145.714
R1197 VGND.n146 VGND.t887 145.714
R1198 VGND.n225 VGND.t832 145.714
R1199 VGND.n234 VGND.t738 145.714
R1200 VGND.n242 VGND.t920 145.714
R1201 VGND.n253 VGND.t762 145.714
R1202 VGND.n272 VGND.t275 145.714
R1203 VGND.t522 VGND.n358 145.714
R1204 VGND.n436 VGND.t8 145.714
R1205 VGND.n409 VGND.t105 145.714
R1206 VGND.n398 VGND.t247 145.714
R1207 VGND.n390 VGND.t607 145.714
R1208 VGND.n376 VGND.t139 145.714
R1209 VGND.n570 VGND.t486 145.714
R1210 VGND.t638 VGND.n343 145.714
R1211 VGND.t87 VGND.n337 145.714
R1212 VGND.t659 VGND.n316 145.714
R1213 VGND.n63 VGND.t187 114.01
R1214 VGND.n60 VGND.n0 0.980587
R1215 VGND.n0 VGND.n62 0.980533
R1216 VGND.t885 VGND.t313 141.429
R1217 VGND.t284 VGND.t355 141.429
R1218 VGND.t101 VGND.t375 141.429
R1219 VGND.t484 VGND.t383 141.429
R1220 VGND.t709 VGND.t391 141.429
R1221 VGND.t28 VGND.t402 141.429
R1222 VGND.t182 VGND.n130 137.143
R1223 VGND.t892 VGND.n123 137.143
R1224 VGND.n228 VGND.t837 137.143
R1225 VGND.n237 VGND.t743 137.143
R1226 VGND.n256 VGND.t767 137.143
R1227 VGND.t507 VGND.n178 137.143
R1228 VGND.n275 VGND.t280 137.143
R1229 VGND.t797 VGND.n161 137.143
R1230 VGND.t527 VGND.n355 137.143
R1231 VGND.t13 VGND.n430 137.143
R1232 VGND.t110 VGND.n403 137.143
R1233 VGND.t253 VGND.n392 137.143
R1234 VGND.t612 VGND.n384 137.143
R1235 VGND.t144 VGND.n370 137.143
R1236 VGND.n573 VGND.t491 137.143
R1237 VGND.t92 VGND.n334 137.143
R1238 VGND.n331 VGND.t704 137.143
R1239 VGND.t555 VGND.n315 137.143
R1240 VGND.t161 VGND.t564 137.143
R1241 VGND.t932 VGND.t67 137.143
R1242 VGND.t361 VGND.t161 136.327
R1243 VGND.t67 VGND.t361 136.327
R1244 VGND.t811 VGND.t346 132.857
R1245 VGND.t643 VGND.t79 128.571
R1246 VGND.n137 VGND.t176 120.001
R1247 VGND.t886 VGND.n126 120.001
R1248 VGND.t831 VGND.n221 120.001
R1249 VGND.t737 VGND.n213 120.001
R1250 VGND.t919 VGND.n204 120.001
R1251 VGND.t924 VGND.t777 120.001
R1252 VGND.t778 VGND.t925 120.001
R1253 VGND.t761 VGND.n193 120.001
R1254 VGND.t274 VGND.n174 120.001
R1255 VGND.t791 VGND.n165 120.001
R1256 VGND.n362 VGND.t521 120.001
R1257 VGND.n437 VGND.t6 120.001
R1258 VGND.n410 VGND.t104 120.001
R1259 VGND.n399 VGND.t246 120.001
R1260 VGND.n391 VGND.t606 120.001
R1261 VGND.n377 VGND.t138 120.001
R1262 VGND.t485 VGND.n349 120.001
R1263 VGND.n575 VGND.t637 120.001
R1264 VGND.n581 VGND.t86 120.001
R1265 VGND.n594 VGND.t658 120.001
R1266 VGND.t672 VGND.n453 118.228
R1267 VGND.t571 VGND.n466 118.228
R1268 VGND.t219 VGND.n480 118.228
R1269 VGND.t290 VGND.n493 118.228
R1270 VGND.t867 VGND.n510 118.228
R1271 VGND.t48 VGND.n523 118.228
R1272 VGND.t715 VGND.n541 118.228
R1273 VGND.t588 VGND.n554 118.228
R1274 VGND.t320 VGND.t838 115.715
R1275 VGND.t371 VGND.t14 115.715
R1276 VGND.t95 VGND.t388 115.715
R1277 VGND.n34 VGND.t265 114.275
R1278 VGND.n141 VGND.t183 111.43
R1279 VGND.n150 VGND.t893 111.43
R1280 VGND.n153 VGND.t534 111.43
R1281 VGND.t838 VGND.n217 111.43
R1282 VGND.t744 VGND.n209 111.43
R1283 VGND.t776 VGND.t923 111.43
R1284 VGND.t926 VGND.n200 111.43
R1285 VGND.t784 VGND.n198 111.43
R1286 VGND.t768 VGND.n188 111.43
R1287 VGND.t68 VGND.n185 111.43
R1288 VGND.t508 VGND.n177 111.43
R1289 VGND.t281 VGND.n170 111.43
R1290 VGND.n282 VGND.t798 111.43
R1291 VGND.t692 VGND.n610 111.43
R1292 VGND.n366 VGND.t528 111.43
R1293 VGND.t14 VGND.n429 111.43
R1294 VGND.t33 VGND.n424 111.43
R1295 VGND.t111 VGND.n402 111.43
R1296 VGND.t254 VGND.n391 111.43
R1297 VGND.t613 VGND.n383 111.43
R1298 VGND.t145 VGND.n369 111.43
R1299 VGND.t492 VGND.n345 111.43
R1300 VGND.n579 VGND.t644 111.43
R1301 VGND.n585 VGND.t93 111.43
R1302 VGND.t698 VGND.t937 111.43
R1303 VGND.t699 VGND.t938 111.43
R1304 VGND.t700 VGND.t939 111.43
R1305 VGND.n332 VGND.t706 111.43
R1306 VGND.n596 VGND.t556 111.43
R1307 VGND.n598 VGND.t665 111.43
R1308 VGND.t118 VGND.t792 107.144
R1309 VGND.n89 VGND.t683 118.328
R1310 VGND.n65 VGND.t152 652.615
R1311 VGND.n94 VGND.t232 118.328
R1312 VGND.n91 VGND.t512 86.6785
R1313 VGND.t903 VGND.n538 103.448
R1314 VGND.n81 VGND.t726 118.328
R1315 VGND.n72 VGND.t599 118.328
R1316 VGND.t18 VGND.n64 86.6785
R1317 VGND.t654 VGND.t548 102.858
R1318 VGND.t549 VGND.t655 102.858
R1319 VGND.t656 VGND.t550 102.858
R1320 VGND.t552 VGND.t657 102.858
R1321 VGND.t658 VGND.t553 102.858
R1322 VGND.t554 VGND.t659 102.858
R1323 VGND.t660 VGND.t555 102.858
R1324 VGND.t556 VGND.t661 102.858
R1325 VGND.t662 VGND.t557 102.858
R1326 VGND.t558 VGND.t663 102.858
R1327 VGND.t664 VGND.t559 102.858
R1328 VGND.n142 VGND.t306 98.5719
R1329 VGND.t560 VGND.n115 98.5719
R1330 VGND.t128 VGND.n210 98.5719
R1331 VGND.t65 VGND.n195 98.5719
R1332 VGND.n253 VGND.t863 98.5719
R1333 VGND.t911 VGND.n176 98.5719
R1334 VGND.t862 VGND.n164 98.5719
R1335 VGND.t910 VGND.n46 112.825
R1336 VGND.n620 VGND.t825 98.5719
R1337 VGND.n289 VGND.t620 98.5719
R1338 VGND.n295 VGND.t258 98.5719
R1339 VGND.n305 VGND.t30 98.5719
R1340 VGND.t175 VGND.n134 94.2862
R1341 VGND.n145 VGND.t885 94.2862
R1342 VGND.n224 VGND.t830 94.2862
R1343 VGND.n233 VGND.t736 94.2862
R1344 VGND.n241 VGND.t918 94.2862
R1345 VGND.n252 VGND.t760 94.2862
R1346 VGND.n271 VGND.t273 94.2862
R1347 VGND.n166 VGND.t790 94.2862
R1348 VGND.t520 VGND.n359 94.2862
R1349 VGND.n438 VGND.t5 94.2862
R1350 VGND.n411 VGND.t103 94.2862
R1351 VGND.n400 VGND.t245 94.2862
R1352 VGND.n392 VGND.t605 94.2862
R1353 VGND.n378 VGND.t137 94.2862
R1354 VGND.n569 VGND.t484 94.2862
R1355 VGND.t636 VGND.n344 94.2862
R1356 VGND.t85 VGND.n338 94.2862
R1357 VGND.t697 VGND.n323 94.2862
R1358 VGND.t547 VGND.n319 94.2862
R1359 VGND.t657 VGND.n317 94.2862
R1360 VGND.n604 VGND.t775 90.1151
R1361 VGND.t273 VGND.t352 90.0005
R1362 VGND.t280 VGND.t354 90.0005
R1363 VGND.t805 VGND.t25 90.0005
R1364 VGND.n32 VGND.t648 88.5605
R1365 VGND.t184 VGND.n129 85.7148
R1366 VGND.t894 VGND.n122 85.7148
R1367 VGND.t536 VGND.n119 85.7148
R1368 VGND.n229 VGND.t839 85.7148
R1369 VGND.t745 VGND.n208 85.7148
R1370 VGND.n246 VGND.t927 85.7148
R1371 VGND.n247 VGND.t783 85.7148
R1372 VGND.n257 VGND.t769 85.7148
R1373 VGND.n260 VGND.t70 85.7148
R1374 VGND.n269 VGND.t509 85.7148
R1375 VGND.n276 VGND.t282 85.7148
R1376 VGND.t799 VGND.n159 85.7148
R1377 VGND.n614 VGND.t906 85.7148
R1378 VGND.n615 VGND.t691 85.7148
R1379 VGND.t529 VGND.n354 85.7148
R1380 VGND.t15 VGND.n428 85.7148
R1381 VGND.t34 VGND.n423 85.7148
R1382 VGND.t112 VGND.n401 85.7148
R1383 VGND.t255 VGND.n390 85.7148
R1384 VGND.t614 VGND.n382 85.7148
R1385 VGND.t146 VGND.n368 85.7148
R1386 VGND.n574 VGND.t493 85.7148
R1387 VGND.t645 VGND.n339 85.7148
R1388 VGND.t94 VGND.n333 85.7148
R1389 VGND.n588 VGND.t707 85.7148
R1390 VGND.t557 VGND.n314 85.7148
R1391 VGND.t666 VGND.n312 85.7148
R1392 VGND.t42 VGND.t621 85.7148
R1393 VGND.n152 VGND.t262 77.1434
R1394 VGND.t542 VGND.n116 77.1434
R1395 VGND.t625 VGND.n213 77.1434
R1396 VGND.n244 VGND.t776 77.1434
R1397 VGND.n59 VGND.t346 230.093
R1398 VGND.n256 VGND.t627 77.1434
R1399 VGND.n262 VGND.t77 77.1434
R1400 VGND.t628 VGND.n181 77.1434
R1401 VGND.n613 VGND.t685 77.1434
R1402 VGND.n417 VGND.t40 77.1434
R1403 VGND.n0 VGND.n81 1.73371
R1404 VGND.n92 VGND.t302 66.2767
R1405 VGND.n0 VGND.n94 1.73371
R1406 VGND.n0 VGND.n89 1.73368
R1407 VGND.n87 VGND.t583 66.2758
R1408 VGND.n86 VGND.t880 66.2758
R1409 VGND.n85 VGND.t61 66.2758
R1410 VGND.n0 VGND.n72 1.7337
R1411 VGND.t165 VGND.n604 75.3368
R1412 VGND.t671 VGND.n452 73.8921
R1413 VGND.t570 VGND.n465 73.8921
R1414 VGND.t218 VGND.n479 73.8921
R1415 VGND.t289 VGND.n492 73.8921
R1416 VGND.t866 VGND.n509 73.8921
R1417 VGND.t47 VGND.n522 73.8921
R1418 VGND.n535 VGND.t899 73.8921
R1419 VGND.t714 VGND.n540 73.8921
R1420 VGND.t587 VGND.n553 73.8921
R1421 VGND.t793 VGND.t862 72.8576
R1422 VGND.n282 VGND.t622 72.8576
R1423 VGND.t463 VGND.t629 72.8576
R1424 VGND.t264 VGND.n74 74.0048
R1425 VGND.n287 VGND.t115 72.8576
R1426 VGND.n136 VGND.t174 68.5719
R1427 VGND.t884 VGND.n127 68.5719
R1428 VGND.t829 VGND.n222 68.5719
R1429 VGND.t735 VGND.n232 68.5719
R1430 VGND.t917 VGND.n205 68.5719
R1431 VGND.n264 VGND.t499 68.5719
R1432 VGND.t500 VGND.t168 68.5719
R1433 VGND.t710 VGND.t501 68.5719
R1434 VGND.t502 VGND.t628 68.5719
R1435 VGND.t272 VGND.n175 68.5719
R1436 VGND.n278 VGND.t789 68.5719
R1437 VGND.n361 VGND.t519 68.5719
R1438 VGND.n439 VGND.t4 68.5719
R1439 VGND.n412 VGND.t102 68.5719
R1440 VGND.n401 VGND.t244 68.5719
R1441 VGND.n393 VGND.t604 68.5719
R1442 VGND.n379 VGND.t136 68.5719
R1443 VGND.t483 VGND.n568 68.5719
R1444 VGND.n574 VGND.t635 68.5719
R1445 VGND.n580 VGND.t84 68.5719
R1446 VGND.t696 VGND.n322 68.5719
R1447 VGND.n591 VGND.t546 68.5719
R1448 VGND.n593 VGND.t656 68.5719
R1449 VGND.n0 VGND.t461 61.8302
R1450 VGND.t318 VGND.t831 64.2862
R1451 VGND.t759 VGND.t97 64.2862
R1452 VGND.t6 VGND.t369 64.2862
R1453 VGND.t88 VGND.t386 64.2862
R1454 VGND.t91 VGND.t387 64.2862
R1455 VGND.n75 VGND.t185 74.4159
R1456 VGND.n151 VGND.t895 60.0005
R1457 VGND.n154 VGND.t537 60.0005
R1458 VGND.t840 VGND.n216 60.0005
R1459 VGND.n238 VGND.t746 60.0005
R1460 VGND.n239 VGND.t815 60.0005
R1461 VGND.t920 VGND.t323 60.0005
R1462 VGND.t928 VGND.n199 60.0005
R1463 VGND.t782 VGND.n199 60.0005
R1464 VGND.n259 VGND.t240 60.0005
R1465 VGND.t510 VGND.n176 60.0005
R1466 VGND.t283 VGND.n169 60.0005
R1467 VGND.t800 VGND.t810 60.0005
R1468 VGND.n283 VGND.t800 60.0005
R1469 VGND.t907 VGND.n611 60.0005
R1470 VGND.t690 VGND.n611 60.0005
R1471 VGND.n616 VGND.t124 60.0005
R1472 VGND.t652 VGND.n608 60.0005
R1473 VGND.t16 VGND.n427 60.0005
R1474 VGND.n423 VGND.t824 60.0005
R1475 VGND.t35 VGND.n422 60.0005
R1476 VGND.t105 VGND.t376 60.0005
R1477 VGND.t113 VGND.n400 60.0005
R1478 VGND.t256 VGND.n389 60.0005
R1479 VGND.t615 VGND.n381 60.0005
R1480 VGND.t494 VGND.n344 60.0005
R1481 VGND.n580 VGND.t646 60.0005
R1482 VGND.n586 VGND.t95 60.0005
R1483 VGND.t939 VGND.n326 60.0005
R1484 VGND.n589 VGND.t708 60.0005
R1485 VGND.n597 VGND.t558 60.0005
R1486 VGND.t667 VGND.n311 60.0005
R1487 VGND.n601 VGND.t845 60.0005
R1488 VGND.t561 VGND.n292 60.0005
R1489 VGND.t285 VGND.n299 60.0005
R1490 VGND.t755 VGND.n301 60.0005
R1491 VGND.t809 VGND.n306 60.0005
R1492 VGND.t152 VGND.n478 59.1138
R1493 VGND.n505 VGND.t513 59.1138
R1494 VGND.t902 VGND.n537 59.1138
R1495 VGND.t913 VGND.n20 58.5605
R1496 VGND.n31 VGND.t457 58.5605
R1497 VGND.n35 VGND.t565 58.5605
R1498 VGND.n42 VGND.t460 58.5605
R1499 VGND.t631 VGND.n27 54.9227
R1500 VGND.n27 VGND.t933 54.8979
R1501 VGND.t930 VGND.n46 46.0238
R1502 VGND.t155 VGND.n18 54.2748
R1503 VGND.t623 VGND.n121 51.4291
R1504 VGND.n234 VGND.t749 51.4291
R1505 VGND.t746 VGND.t813 51.4291
R1506 VGND.t814 VGND.t747 51.4291
R1507 VGND.n250 VGND.t811 51.4291
R1508 VGND.t78 VGND.n189 51.4291
R1509 VGND.n265 VGND.t710 51.4291
R1510 VGND.n47 VGND.t338 23.2336
R1511 VGND.t120 VGND.n607 51.4291
R1512 VGND.t843 VGND.t195 51.4291
R1513 VGND.t197 VGND.t844 51.4291
R1514 VGND.t845 VGND.t198 51.4291
R1515 VGND.n75 VGND.n27 1.93639
R1516 VGND.t531 VGND.n69 42.9373
R1517 VGND.t148 VGND.n68 42.9373
R1518 VGND.n27 VGND.t284 50.6131
R1519 VGND.n16 VGND.t511 49.9891
R1520 VGND.t801 VGND.n2 49.9891
R1521 VGND.t96 VGND.n39 49.9891
R1522 VGND.t621 VGND.n31 49.9891
R1523 VGND.t266 VGND.n35 49.9891
R1524 VGND.n42 VGND.t28 49.9891
R1525 VGND.t670 VGND.t669 45.7963
R1526 VGND.t569 VGND.n95 45.7968
R1527 VGND.t217 VGND.n66 45.7968
R1528 VGND.t288 VGND.n93 45.7968
R1529 VGND.t515 VGND.n506 45.7801
R1530 VGND.t865 VGND.n508 45.7801
R1531 VGND.t46 VGND.n70 45.7968
R1532 VGND.n536 VGND.t900 45.7801
R1533 VGND.t713 VGND.n79 45.7968
R1534 VGND.t586 VGND.n82 45.7968
R1535 VGND.n1 VGND.t459 45.7034
R1536 VGND.t173 VGND.n135 42.8576
R1537 VGND.n144 VGND.t883 42.8576
R1538 VGND.t624 VGND.t538 42.8576
R1539 VGND.t539 VGND.t129 42.8576
R1540 VGND.n156 VGND.t541 42.8576
R1541 VGND.n158 VGND.t234 42.8576
R1542 VGND.n223 VGND.t828 42.8576
R1543 VGND.t734 VGND.n214 42.8576
R1544 VGND.n240 VGND.t819 42.8576
R1545 VGND.t777 VGND.n201 42.8576
R1546 VGND.t753 VGND.n197 42.8576
R1547 VGND.n251 VGND.t758 42.8576
R1548 VGND.t770 VGND.t237 42.8576
R1549 VGND.t730 VGND.n184 42.8576
R1550 VGND.t76 VGND.n183 42.8576
R1551 VGND.t498 VGND.n263 42.8576
R1552 VGND.n270 VGND.t271 42.8576
R1553 VGND.t788 VGND.n167 42.8576
R1554 VGND.n44 VGND.t533 57.9381
R1555 VGND.t686 VGND.n612 42.8576
R1556 VGND.t518 VGND.n360 42.8576
R1557 VGND.n440 VGND.t3 42.8576
R1558 VGND.n418 VGND.t39 42.8576
R1559 VGND.n413 VGND.t101 42.8576
R1560 VGND.n402 VGND.t243 42.8576
R1561 VGND.n394 VGND.t603 42.8576
R1562 VGND.n383 VGND.t618 42.8576
R1563 VGND.n380 VGND.t135 42.8576
R1564 VGND.n350 VGND.t482 42.8576
R1565 VGND.t634 VGND.n345 42.8576
R1566 VGND.t83 VGND.n339 42.8576
R1567 VGND.t695 VGND.n321 42.8576
R1568 VGND.t563 VGND.n331 42.8576
R1569 VGND.t545 VGND.n320 42.8576
R1570 VGND.t655 VGND.n318 42.8576
R1571 VGND.t668 VGND.t189 42.8576
R1572 VGND.t191 VGND.n310 42.8576
R1573 VGND.t21 VGND.n307 42.8576
R1574 VGND.n296 VGND.t751 42.8576
R1575 VGND.n297 VGND.t806 42.8576
R1576 VGND.t808 VGND.n12 41.4177
R1577 VGND.n157 VGND.t807 38.5719
R1578 VGND.n236 VGND.t748 38.5719
R1579 VGND.t154 VGND.n191 38.5719
R1580 VGND.n269 VGND.t31 38.5719
R1581 VGND.t277 VGND.t353 38.5719
R1582 VGND.n279 VGND.t118 38.5719
R1583 VGND.t896 VGND.n121 34.2862
R1584 VGND.t538 VGND.n118 34.2862
R1585 VGND.n230 VGND.t841 34.2862
R1586 VGND.t747 VGND.n207 34.2862
R1587 VGND.t816 VGND.n206 34.2862
R1588 VGND.n246 VGND.t781 34.2862
R1589 VGND.n247 VGND.t929 34.2862
R1590 VGND.n258 VGND.t771 34.2862
R1591 VGND.t239 VGND.n186 34.2862
R1592 VGND.t787 VGND.t941 34.2862
R1593 VGND.t630 VGND.t788 34.2862
R1594 VGND.n614 VGND.t689 34.2862
R1595 VGND.n615 VGND.t908 34.2862
R1596 VGND.t125 VGND.n609 34.2862
R1597 VGND.n617 VGND.t651 34.2862
R1598 VGND.t17 VGND.n426 34.2862
R1599 VGND.n424 VGND.t823 34.2862
R1600 VGND.t36 VGND.n421 34.2862
R1601 VGND.t114 VGND.n399 34.2862
R1602 VGND.t257 VGND.n388 34.2862
R1603 VGND.n575 VGND.t495 34.2862
R1604 VGND.t647 VGND.n338 34.2862
R1605 VGND.t938 VGND.n325 34.2862
R1606 VGND.t559 VGND.n313 34.2862
R1607 VGND.n599 VGND.t668 34.2862
R1608 VGND.t194 VGND.n309 34.2862
R1609 VGND.t844 VGND.n308 34.2862
R1610 VGND.t26 VGND.n297 34.2862
R1611 VGND.t260 VGND.n298 34.2862
R1612 VGND.t169 VGND.t171 32.8816
R1613 VGND.t516 VGND.t517 32.8816
R1614 VGND.t236 VGND.n23 32.8462
R1615 VGND.n621 VGND.t827 32.8462
R1616 VGND.t818 VGND.n10 32.8462
R1617 VGND.n5 VGND.t160 32.8462
R1618 VGND.t757 VGND.n56 32.8822
R1619 VGND.n4 VGND.t75 32.8462
R1620 VGND.t497 VGND.n15 32.8462
R1621 VGND.t270 VGND.n17 32.8462
R1622 VGND.n21 VGND.t687 32.8462
R1623 VGND.n441 VGND.t2 32.8462
R1624 VGND.t821 VGND.n425 32.8462
R1625 VGND.n414 VGND.t100 32.8462
R1626 VGND.n54 VGND.t134 32.8822
R1627 VGND.t694 VGND.n38 32.8462
R1628 VGND.n37 VGND.t192 32.8462
R1629 VGND.n95 VGND.t567 29.6918
R1630 VGND.t151 VGND.n88 31.0263
R1631 VGND.n66 VGND.t216 29.6918
R1632 VGND.n93 VGND.t287 29.6918
R1633 VGND.n506 VGND.t514 31.0018
R1634 VGND.n508 VGND.t864 31.0018
R1635 VGND.t901 VGND.n536 31.0018
R1636 VGND.t364 VGND.n53 12.9737
R1637 VGND.t616 VGND.t897 30.0005
R1638 VGND.t619 VGND.n287 30.0005
R1639 VGND.n151 VGND.t934 25.7148
R1640 VGND.t19 VGND.n117 25.7148
R1641 VGND.t116 VGND.n212 25.7148
R1642 VGND.n255 VGND.t98 25.7148
R1643 VGND.t168 VGND.n182 25.7148
R1644 VGND.t940 VGND.n90 26.0429
R1645 VGND.n618 VGND.t935 25.7148
R1646 VGND.t38 VGND.t309 25.7148
R1647 VGND.t931 VGND.t260 25.7148
R1648 VGND.t826 VGND.n621 24.2748
R1649 VGND.n10 VGND.t817 24.2748
R1650 VGND.t159 VGND.n5 24.2748
R1651 VGND.t756 VGND.n56 22.913
R1652 VGND.t74 VGND.n4 24.2748
R1653 VGND.n15 VGND.t496 24.2748
R1654 VGND.n17 VGND.t268 24.2748
R1655 VGND.t688 VGND.n21 24.2748
R1656 VGND.n19 VGND.t126 24.2748
R1657 VGND.t650 VGND.n19 24.2748
R1658 VGND.t0 VGND.n441 24.2748
R1659 VGND.n425 VGND.t822 24.2748
R1660 VGND.t99 VGND.n414 24.2748
R1661 VGND.t693 VGND.n38 24.2748
R1662 VGND.n37 VGND.t193 24.2748
R1663 VGND.t349 VGND.n57 10.7153
R1664 VGND.t458 VGND.t163 21.4291
R1665 VGND.t897 VGND.t361 20.6131
R1666 VGND.n27 VGND.n48 11.302
R1667 VGND.n26 VGND.t812 19.9891
R1668 VGND.n7 VGND.t130 19.9891
R1669 VGND.t882 VGND.n128 17.1434
R1670 VGND.t540 VGND.n117 17.1434
R1671 VGND.n231 VGND.t733 17.1434
R1672 VGND.n245 VGND.t778 17.1434
R1673 VGND.t157 VGND.t753 17.1434
R1674 VGND.t754 VGND.t158 17.1434
R1675 VGND.n249 VGND.t754 17.1434
R1676 VGND.t237 VGND.n187 17.1434
R1677 VGND.t71 VGND.t730 17.1434
R1678 VGND.t731 VGND.t72 17.1434
R1679 VGND.n261 VGND.t731 17.1434
R1680 VGND.t334 VGND.t505 17.1434
R1681 VGND.n277 VGND.t787 17.1434
R1682 VGND.n27 VGND.n44 1.27083
R1683 VGND.n420 VGND.t308 17.1434
R1684 VGND.n419 VGND.t38 17.1434
R1685 VGND.n403 VGND.t242 17.1434
R1686 VGND.n395 VGND.t602 17.1434
R1687 VGND.n384 VGND.t617 17.1434
R1688 VGND.n367 VGND.t481 17.1434
R1689 VGND.n573 VGND.t633 17.1434
R1690 VGND.n579 VGND.t81 17.1434
R1691 VGND.n323 VGND.t936 17.1434
R1692 VGND.t562 VGND.n330 17.1434
R1693 VGND.n590 VGND.t544 17.1434
R1694 VGND.n592 VGND.t654 17.1434
R1695 VGND.t842 VGND.n309 17.1434
R1696 VGND.t23 VGND.n73 24.1875
R1697 VGND.n566 VGND.n0 17.0005
R1698 VGND.n565 VGND.n0 17.0005
R1699 VGND.n564 VGND.n0 17.0005
R1700 VGND.n563 VGND.n0 17.0005
R1701 VGND.n562 VGND.n0 17.0005
R1702 VGND.n561 VGND.n0 17.0005
R1703 VGND.n560 VGND.n0 17.0005
R1704 VGND.n559 VGND.n0 17.0005
R1705 VGND.n558 VGND.n0 17.0005
R1706 VGND.n557 VGND.n0 17.0005
R1707 VGND.n556 VGND.n0 17.0005
R1708 VGND.n555 VGND.n0 17.0005
R1709 VGND.n554 VGND.n0 17.0005
R1710 VGND.n553 VGND.n0 17.0005
R1711 VGND.n552 VGND.n0 17.0005
R1712 VGND.n551 VGND.n0 17.0005
R1713 VGND.n550 VGND.n0 17.0005
R1714 VGND.n549 VGND.n0 17.0005
R1715 VGND.n548 VGND.n0 17.0005
R1716 VGND.n547 VGND.n0 17.0005
R1717 VGND.n546 VGND.n0 17.0005
R1718 VGND.n545 VGND.n0 17.0005
R1719 VGND.n544 VGND.n0 17.0005
R1720 VGND.n543 VGND.n0 17.0005
R1721 VGND.n542 VGND.n0 17.0005
R1722 VGND.n541 VGND.n0 17.0005
R1723 VGND.n540 VGND.n0 17.0005
R1724 VGND.n78 VGND.n0 12.2161
R1725 VGND.n539 VGND.n0 17.0005
R1726 VGND.n538 VGND.n0 17.0005
R1727 VGND.n537 VGND.n0 17.0005
R1728 VGND.n535 VGND.n0 17.0005
R1729 VGND.n80 VGND.n0 13.5687
R1730 VGND.n85 VGND.n0 1.73368
R1731 VGND.n534 VGND.n0 17.0005
R1732 VGND.n533 VGND.n0 17.0005
R1733 VGND.n532 VGND.n0 17.0005
R1734 VGND.n531 VGND.n0 17.0005
R1735 VGND.n530 VGND.n0 17.0005
R1736 VGND.n529 VGND.n0 17.0005
R1737 VGND.n528 VGND.n0 17.0005
R1738 VGND.n527 VGND.n0 17.0005
R1739 VGND.n526 VGND.n0 17.0005
R1740 VGND.n525 VGND.n0 17.0005
R1741 VGND.n524 VGND.n0 17.0005
R1742 VGND.n523 VGND.n0 17.0005
R1743 VGND.n522 VGND.n0 17.0005
R1744 VGND.n86 VGND.n0 1.73368
R1745 VGND.n521 VGND.n0 17.0005
R1746 VGND.n520 VGND.n0 17.0005
R1747 VGND.n519 VGND.n0 17.0005
R1748 VGND.n518 VGND.n0 17.0005
R1749 VGND.n517 VGND.n0 17.0005
R1750 VGND.n516 VGND.n0 17.0005
R1751 VGND.n515 VGND.n0 17.0005
R1752 VGND.n514 VGND.n0 17.0005
R1753 VGND.n513 VGND.n0 17.0005
R1754 VGND.n512 VGND.n0 17.0005
R1755 VGND.n511 VGND.n0 17.0005
R1756 VGND.n510 VGND.n0 17.0005
R1757 VGND.n509 VGND.n0 17.0005
R1758 VGND.n505 VGND.n0 17.0005
R1759 VGND.n92 VGND.n0 1.73371
R1760 VGND.n504 VGND.n0 17.0005
R1761 VGND.n503 VGND.n0 17.0005
R1762 VGND.n502 VGND.n0 17.0005
R1763 VGND.n501 VGND.n0 17.0005
R1764 VGND.n500 VGND.n0 17.0005
R1765 VGND.n499 VGND.n0 17.0005
R1766 VGND.n498 VGND.n0 17.0005
R1767 VGND.n497 VGND.n0 17.0005
R1768 VGND.n496 VGND.n0 17.0005
R1769 VGND.n495 VGND.n0 17.0005
R1770 VGND.n494 VGND.n0 17.0005
R1771 VGND.n493 VGND.n0 17.0005
R1772 VGND.n492 VGND.n0 17.0005
R1773 VGND.n491 VGND.n0 17.0005
R1774 VGND.n490 VGND.n0 17.0005
R1775 VGND.n489 VGND.n0 17.0005
R1776 VGND.n488 VGND.n0 17.0005
R1777 VGND.n487 VGND.n0 17.0005
R1778 VGND.n486 VGND.n0 17.0005
R1779 VGND.n485 VGND.n0 17.0005
R1780 VGND.n484 VGND.n0 17.0005
R1781 VGND.n483 VGND.n0 17.0005
R1782 VGND.n482 VGND.n0 17.0005
R1783 VGND.n481 VGND.n0 17.0005
R1784 VGND.n480 VGND.n0 17.0005
R1785 VGND.n479 VGND.n0 17.0005
R1786 VGND.n65 VGND.n0 14.245
R1787 VGND.n478 VGND.n0 17.0005
R1788 VGND.n87 VGND.n0 1.73368
R1789 VGND.n477 VGND.n0 17.0005
R1790 VGND.n476 VGND.n0 17.0005
R1791 VGND.n475 VGND.n0 17.0005
R1792 VGND.n474 VGND.n0 17.0005
R1793 VGND.n473 VGND.n0 17.0005
R1794 VGND.n472 VGND.n0 17.0005
R1795 VGND.n471 VGND.n0 17.0005
R1796 VGND.n470 VGND.n0 17.0005
R1797 VGND.n469 VGND.n0 17.0005
R1798 VGND.n468 VGND.n0 17.0005
R1799 VGND.n467 VGND.n0 17.0005
R1800 VGND.n466 VGND.n0 17.0005
R1801 VGND.n465 VGND.n0 17.0005
R1802 VGND.n464 VGND.n0 17.0005
R1803 VGND.n463 VGND.n0 17.0005
R1804 VGND.n462 VGND.n0 17.0005
R1805 VGND.n461 VGND.n0 17.0005
R1806 VGND.n460 VGND.n0 17.0005
R1807 VGND.n459 VGND.n0 17.0005
R1808 VGND.n458 VGND.n0 17.0005
R1809 VGND.n457 VGND.n0 17.0005
R1810 VGND.n456 VGND.n0 17.0005
R1811 VGND.n455 VGND.n0 17.0005
R1812 VGND.n454 VGND.n0 17.0005
R1813 VGND.n453 VGND.n0 17.0005
R1814 VGND.n452 VGND.n0 17.0005
R1815 VGND.n27 VGND.n606 17.0005
R1816 VGND.n27 VGND.n620 17.0005
R1817 VGND.n27 VGND.n46 2.09936
R1818 VGND.n27 VGND.n619 17.0005
R1819 VGND.n27 VGND.n607 17.0005
R1820 VGND.n27 VGND.n618 17.0005
R1821 VGND.n27 VGND.n608 17.0005
R1822 VGND.n27 VGND.n617 17.0005
R1823 VGND.n27 VGND.n609 17.0005
R1824 VGND.n27 VGND.n616 17.0005
R1825 VGND.n27 VGND.n610 17.0005
R1826 VGND.n27 VGND.n615 17.0005
R1827 VGND.n27 VGND.n611 17.0005
R1828 VGND.n27 VGND.n614 17.0005
R1829 VGND.n27 VGND.n612 17.0005
R1830 VGND.n27 VGND.n613 17.0005
R1831 VGND.n27 VGND.n283 17.0005
R1832 VGND.n27 VGND.n159 17.0005
R1833 VGND.n27 VGND.n282 17.0005
R1834 VGND.n27 VGND.n161 17.0005
R1835 VGND.n27 VGND.n162 17.0005
R1836 VGND.n27 VGND.n281 17.0005
R1837 VGND.n27 VGND.n163 17.0005
R1838 VGND.n27 VGND.n280 17.0005
R1839 VGND.n27 VGND.n164 17.0005
R1840 VGND.n27 VGND.n279 17.0005
R1841 VGND.n27 VGND.n165 17.0005
R1842 VGND.n27 VGND.n166 17.0005
R1843 VGND.n27 VGND.n278 17.0005
R1844 VGND.n27 VGND.n167 17.0005
R1845 VGND.n27 VGND.n277 17.0005
R1846 VGND.n27 VGND.n90 16.0236
R1847 VGND.n27 VGND.n169 17.0005
R1848 VGND.n27 VGND.n276 17.0005
R1849 VGND.n27 VGND.n170 17.0005
R1850 VGND.n27 VGND.n275 17.0005
R1851 VGND.n27 VGND.n171 17.0005
R1852 VGND.n27 VGND.n274 17.0005
R1853 VGND.n27 VGND.n172 17.0005
R1854 VGND.n27 VGND.n273 17.0005
R1855 VGND.n27 VGND.n173 17.0005
R1856 VGND.n27 VGND.n272 17.0005
R1857 VGND.n27 VGND.n174 17.0005
R1858 VGND.n27 VGND.n271 17.0005
R1859 VGND.n27 VGND.n175 17.0005
R1860 VGND.n27 VGND.n270 17.0005
R1861 VGND.n27 VGND.n176 17.0005
R1862 VGND.n27 VGND.n269 17.0005
R1863 VGND.n27 VGND.n177 17.0005
R1864 VGND.n27 VGND.n178 17.0005
R1865 VGND.n27 VGND.n268 17.0005
R1866 VGND.n27 VGND.n179 17.0005
R1867 VGND.n27 VGND.n267 17.0005
R1868 VGND.n27 VGND.n180 17.0005
R1869 VGND.n27 VGND.n266 17.0005
R1870 VGND.n27 VGND.n181 17.0005
R1871 VGND.n27 VGND.n265 17.0005
R1872 VGND.n27 VGND.n182 17.0005
R1873 VGND.n27 VGND.n264 17.0005
R1874 VGND.n27 VGND.n263 17.0005
R1875 VGND.n27 VGND.n262 17.0005
R1876 VGND.n27 VGND.n183 17.0005
R1877 VGND.n27 VGND.n261 17.0005
R1878 VGND.n27 VGND.n184 17.0005
R1879 VGND.n27 VGND.n260 17.0005
R1880 VGND.n27 VGND.n185 17.0005
R1881 VGND.n27 VGND.n259 17.0005
R1882 VGND.n27 VGND.n186 17.0005
R1883 VGND.n27 VGND.n258 17.0005
R1884 VGND.n27 VGND.n187 17.0005
R1885 VGND.n27 VGND.n257 17.0005
R1886 VGND.n27 VGND.n188 17.0005
R1887 VGND.n27 VGND.n256 17.0005
R1888 VGND.n27 VGND.n189 17.0005
R1889 VGND.n27 VGND.n255 17.0005
R1890 VGND.n27 VGND.n190 17.0005
R1891 VGND.n27 VGND.n254 17.0005
R1892 VGND.n27 VGND.n191 17.0005
R1893 VGND.n27 VGND.n253 17.0005
R1894 VGND.n27 VGND.n193 17.0005
R1895 VGND.n27 VGND.n252 17.0005
R1896 VGND.n27 VGND.n194 17.0005
R1897 VGND.n27 VGND.n251 17.0005
R1898 VGND.n27 VGND.n195 17.0005
R1899 VGND.n27 VGND.n59 13.4026
R1900 VGND.n27 VGND.n250 17.0005
R1901 VGND.n27 VGND.n196 17.0005
R1902 VGND.n27 VGND.n249 17.0005
R1903 VGND.n27 VGND.n197 17.0005
R1904 VGND.n27 VGND.n248 17.0005
R1905 VGND.n27 VGND.n198 17.0005
R1906 VGND.n27 VGND.n247 17.0005
R1907 VGND.n27 VGND.n199 17.0005
R1908 VGND.n27 VGND.n246 17.0005
R1909 VGND.n27 VGND.n200 17.0005
R1910 VGND.n27 VGND.n245 17.0005
R1911 VGND.n27 VGND.n201 17.0005
R1912 VGND.n27 VGND.n244 17.0005
R1913 VGND.n27 VGND.n202 17.0005
R1914 VGND.n27 VGND.n243 17.0005
R1915 VGND.n27 VGND.n203 17.0005
R1916 VGND.n27 VGND.n242 17.0005
R1917 VGND.n27 VGND.n204 17.0005
R1918 VGND.n27 VGND.n241 17.0005
R1919 VGND.n27 VGND.n205 17.0005
R1920 VGND.n27 VGND.n240 17.0005
R1921 VGND.n27 VGND.n206 17.0005
R1922 VGND.n27 VGND.n239 17.0005
R1923 VGND.n27 VGND.n207 17.0005
R1924 VGND.n27 VGND.n238 17.0005
R1925 VGND.n27 VGND.n208 17.0005
R1926 VGND.n27 VGND.n209 17.0005
R1927 VGND.n27 VGND.n237 17.0005
R1928 VGND.n27 VGND.n210 17.0005
R1929 VGND.n27 VGND.n236 17.0005
R1930 VGND.n27 VGND.n211 17.0005
R1931 VGND.n27 VGND.n235 17.0005
R1932 VGND.n27 VGND.n212 17.0005
R1933 VGND.n27 VGND.n234 17.0005
R1934 VGND.n27 VGND.n213 17.0005
R1935 VGND.n27 VGND.n233 17.0005
R1936 VGND.n27 VGND.n232 17.0005
R1937 VGND.n27 VGND.n214 17.0005
R1938 VGND.n27 VGND.n231 17.0005
R1939 VGND.n27 VGND.n215 17.0005
R1940 VGND.n27 VGND.n230 17.0005
R1941 VGND.n27 VGND.n216 17.0005
R1942 VGND.n27 VGND.n229 17.0005
R1943 VGND.n27 VGND.n217 17.0005
R1944 VGND.n27 VGND.n228 17.0005
R1945 VGND.n27 VGND.n218 17.0005
R1946 VGND.n27 VGND.n227 17.0005
R1947 VGND.n27 VGND.n219 17.0005
R1948 VGND.n27 VGND.n226 17.0005
R1949 VGND.n27 VGND.n220 17.0005
R1950 VGND.n27 VGND.n225 17.0005
R1951 VGND.n27 VGND.n221 17.0005
R1952 VGND.n27 VGND.n224 17.0005
R1953 VGND.n27 VGND.n222 17.0005
R1954 VGND.n27 VGND.n223 17.0005
R1955 VGND.n27 VGND.n622 17.0005
R1956 VGND.n27 VGND.n114 17.0005
R1957 VGND.n27 VGND.n158 17.0005
R1958 VGND.n27 VGND.n115 17.0005
R1959 VGND.n27 VGND.n157 17.0005
R1960 VGND.n27 VGND.n116 17.0005
R1961 VGND.n27 VGND.n156 17.0005
R1962 VGND.n27 VGND.n117 17.0005
R1963 VGND.n27 VGND.n155 17.0005
R1964 VGND.n27 VGND.n118 17.0005
R1965 VGND.n27 VGND.n154 17.0005
R1966 VGND.n27 VGND.n119 17.0005
R1967 VGND.n27 VGND.n153 17.0005
R1968 VGND.n27 VGND.n120 17.0005
R1969 VGND.n27 VGND.n152 17.0005
R1970 VGND.n27 VGND.n121 17.0005
R1971 VGND.n27 VGND.n151 17.0005
R1972 VGND.n27 VGND.n122 17.0005
R1973 VGND.n27 VGND.n150 17.0005
R1974 VGND.n27 VGND.n123 17.0005
R1975 VGND.n27 VGND.n149 17.0005
R1976 VGND.n27 VGND.n148 17.0005
R1977 VGND.n27 VGND.n124 17.0005
R1978 VGND.n27 VGND.n147 17.0005
R1979 VGND.n27 VGND.n125 17.0005
R1980 VGND.n27 VGND.n146 17.0005
R1981 VGND.n27 VGND.n126 17.0005
R1982 VGND.n27 VGND.n145 17.0005
R1983 VGND.n27 VGND.n127 17.0005
R1984 VGND.n27 VGND.n144 17.0005
R1985 VGND.n27 VGND.n128 17.0005
R1986 VGND.n27 VGND.n143 17.0005
R1987 VGND.n27 VGND.n142 17.0005
R1988 VGND.n27 VGND.n129 17.0005
R1989 VGND.n27 VGND.n141 17.0005
R1990 VGND.n27 VGND.n130 17.0005
R1991 VGND.n27 VGND.n140 17.0005
R1992 VGND.n27 VGND.n131 17.0005
R1993 VGND.n27 VGND.n139 17.0005
R1994 VGND.n27 VGND.n132 17.0005
R1995 VGND.n27 VGND.n138 17.0005
R1996 VGND.n27 VGND.n133 17.0005
R1997 VGND.n27 VGND.n137 17.0005
R1998 VGND.n27 VGND.n134 17.0005
R1999 VGND.n27 VGND.n136 17.0005
R2000 VGND.n27 VGND.n135 17.0005
R2001 VGND.n71 VGND.t361 0.649813
R2002 VGND.t361 VGND.n586 17.0005
R2003 VGND.t361 VGND.n333 17.0005
R2004 VGND.t361 VGND.n585 17.0005
R2005 VGND.t361 VGND.n334 17.0005
R2006 VGND.t361 VGND.n584 17.0005
R2007 VGND.t361 VGND.n335 17.0005
R2008 VGND.t361 VGND.n583 17.0005
R2009 VGND.t361 VGND.n336 17.0005
R2010 VGND.t361 VGND.n582 17.0005
R2011 VGND.t361 VGND.n337 17.0005
R2012 VGND.t361 VGND.n581 17.0005
R2013 VGND.t361 VGND.n338 17.0005
R2014 VGND.t361 VGND.n580 17.0005
R2015 VGND.t361 VGND.n339 17.0005
R2016 VGND.t361 VGND.n579 17.0005
R2017 VGND.t361 VGND.n340 17.0005
R2018 VGND.t361 VGND.n578 17.0005
R2019 VGND.t361 VGND.n341 17.0005
R2020 VGND.t361 VGND.n577 17.0005
R2021 VGND.t361 VGND.n342 17.0005
R2022 VGND.t361 VGND.n576 17.0005
R2023 VGND.t361 VGND.n343 17.0005
R2024 VGND.t361 VGND.n575 17.0005
R2025 VGND.t361 VGND.n344 17.0005
R2026 VGND.t361 VGND.n574 17.0005
R2027 VGND.t361 VGND.n345 17.0005
R2028 VGND.t361 VGND.n573 17.0005
R2029 VGND.t361 VGND.n346 17.0005
R2030 VGND.t361 VGND.n572 17.0005
R2031 VGND.t361 VGND.n347 17.0005
R2032 VGND.t361 VGND.n571 17.0005
R2033 VGND.t361 VGND.n348 17.0005
R2034 VGND.t361 VGND.n570 17.0005
R2035 VGND.t361 VGND.n349 17.0005
R2036 VGND.t361 VGND.n569 17.0005
R2037 VGND.n568 VGND.t361 17.0005
R2038 VGND.t361 VGND.n350 17.0005
R2039 VGND.n367 VGND.t361 17.0005
R2040 VGND.n589 VGND.t361 17.0005
R2041 VGND.n588 VGND.t361 17.0005
R2042 VGND.t361 VGND.n332 17.0005
R2043 VGND.t361 VGND.n331 17.0005
R2044 VGND.t361 VGND.n330 17.0005
R2045 VGND.t361 VGND.n329 17.0005
R2046 VGND.t361 VGND.n328 17.0005
R2047 VGND.t361 VGND.n327 17.0005
R2048 VGND.t361 VGND.n326 17.0005
R2049 VGND.t361 VGND.n325 17.0005
R2050 VGND.t361 VGND.n324 17.0005
R2051 VGND.t361 VGND.n323 17.0005
R2052 VGND.t361 VGND.n322 17.0005
R2053 VGND.t361 VGND.n321 17.0005
R2054 VGND.t361 VGND.n601 17.0005
R2055 VGND.t361 VGND.n308 17.0005
R2056 VGND.t361 VGND.n600 17.0005
R2057 VGND.t361 VGND.n309 17.0005
R2058 VGND.t361 VGND.n310 17.0005
R2059 VGND.t361 VGND.n599 17.0005
R2060 VGND.t361 VGND.n311 17.0005
R2061 VGND.t361 VGND.n312 17.0005
R2062 VGND.t361 VGND.n598 17.0005
R2063 VGND.t361 VGND.n313 17.0005
R2064 VGND.t361 VGND.n597 17.0005
R2065 VGND.t361 VGND.n314 17.0005
R2066 VGND.t361 VGND.n596 17.0005
R2067 VGND.t361 VGND.n315 17.0005
R2068 VGND.t361 VGND.n595 17.0005
R2069 VGND.t361 VGND.n316 17.0005
R2070 VGND.t361 VGND.n594 17.0005
R2071 VGND.t361 VGND.n317 17.0005
R2072 VGND.t361 VGND.n593 17.0005
R2073 VGND.t361 VGND.n318 17.0005
R2074 VGND.t361 VGND.n592 17.0005
R2075 VGND.t361 VGND.n319 17.0005
R2076 VGND.t361 VGND.n591 17.0005
R2077 VGND.t361 VGND.n320 17.0005
R2078 VGND.t361 VGND.n590 17.0005
R2079 VGND.t361 VGND.n307 17.0005
R2080 VGND.t361 VGND.n303 17.0005
R2081 VGND.n304 VGND.t361 17.0005
R2082 VGND.t361 VGND.n305 17.0005
R2083 VGND.t361 VGND.n302 17.0005
R2084 VGND.n306 VGND.t361 17.0005
R2085 VGND.t361 VGND.n301 17.0005
R2086 VGND.t361 VGND.n300 17.0005
R2087 VGND.t361 VGND.n299 17.0005
R2088 VGND.t361 VGND.n298 17.0005
R2089 VGND.t361 VGND.n297 17.0005
R2090 VGND.t361 VGND.n296 17.0005
R2091 VGND.t361 VGND.n295 17.0005
R2092 VGND.t361 VGND.n294 17.0005
R2093 VGND.t361 VGND.n293 17.0005
R2094 VGND.t361 VGND.n292 17.0005
R2095 VGND.t361 VGND.n290 17.0005
R2096 VGND.t361 VGND.n289 17.0005
R2097 VGND.t361 VGND.n288 17.0005
R2098 VGND.t361 VGND.n287 17.0005
R2099 VGND.t361 VGND.n286 17.0005
R2100 VGND.t361 VGND.n285 17.0005
R2101 VGND.t361 VGND.n74 15.2046
R2102 VGND.n68 VGND.t361 1.93639
R2103 VGND.n368 VGND.t361 17.0005
R2104 VGND.n369 VGND.t361 17.0005
R2105 VGND.n370 VGND.t361 17.0005
R2106 VGND.n371 VGND.t361 17.0005
R2107 VGND.n372 VGND.t361 17.0005
R2108 VGND.n373 VGND.t361 17.0005
R2109 VGND.n374 VGND.t361 17.0005
R2110 VGND.n375 VGND.t361 17.0005
R2111 VGND.n376 VGND.t361 17.0005
R2112 VGND.n377 VGND.t361 17.0005
R2113 VGND.n378 VGND.t361 17.0005
R2114 VGND.n379 VGND.t361 17.0005
R2115 VGND.n380 VGND.t361 17.0005
R2116 VGND.n381 VGND.t361 17.0005
R2117 VGND.n382 VGND.t361 17.0005
R2118 VGND.n383 VGND.t361 17.0005
R2119 VGND.n384 VGND.t361 17.0005
R2120 VGND.n385 VGND.t361 17.0005
R2121 VGND.n386 VGND.t361 17.0005
R2122 VGND.n387 VGND.t361 17.0005
R2123 VGND.n388 VGND.t361 17.0005
R2124 VGND.n389 VGND.t361 17.0005
R2125 VGND.n390 VGND.t361 17.0005
R2126 VGND.n391 VGND.t361 17.0005
R2127 VGND.n392 VGND.t361 17.0005
R2128 VGND.n393 VGND.t361 17.0005
R2129 VGND.n394 VGND.t361 17.0005
R2130 VGND.n395 VGND.t361 17.0005
R2131 VGND.n396 VGND.t361 17.0005
R2132 VGND.n397 VGND.t361 17.0005
R2133 VGND.n398 VGND.t361 17.0005
R2134 VGND.n399 VGND.t361 17.0005
R2135 VGND.n400 VGND.t361 17.0005
R2136 VGND.n401 VGND.t361 17.0005
R2137 VGND.n402 VGND.t361 17.0005
R2138 VGND.n403 VGND.t361 17.0005
R2139 VGND.n404 VGND.t361 17.0005
R2140 VGND.n405 VGND.t361 17.0005
R2141 VGND.n406 VGND.t361 17.0005
R2142 VGND.n407 VGND.t361 17.0005
R2143 VGND.n408 VGND.t361 17.0005
R2144 VGND.n409 VGND.t361 17.0005
R2145 VGND.n410 VGND.t361 17.0005
R2146 VGND.n411 VGND.t361 17.0005
R2147 VGND.n412 VGND.t361 17.0005
R2148 VGND.n413 VGND.t361 17.0005
R2149 VGND.n76 VGND.t361 9.30762
R2150 VGND.n416 VGND.t361 17.0005
R2151 VGND.n417 VGND.t361 17.0005
R2152 VGND.n418 VGND.t361 17.0005
R2153 VGND.n419 VGND.t361 17.0005
R2154 VGND.n420 VGND.t361 17.0005
R2155 VGND.n421 VGND.t361 17.0005
R2156 VGND.n422 VGND.t361 17.0005
R2157 VGND.n423 VGND.t361 17.0005
R2158 VGND.n424 VGND.t361 17.0005
R2159 VGND.n426 VGND.t361 17.0005
R2160 VGND.n427 VGND.t361 17.0005
R2161 VGND.n428 VGND.t361 17.0005
R2162 VGND.n429 VGND.t361 17.0005
R2163 VGND.n430 VGND.t361 17.0005
R2164 VGND.n431 VGND.t361 17.0005
R2165 VGND.n432 VGND.t361 17.0005
R2166 VGND.n433 VGND.t361 17.0005
R2167 VGND.n434 VGND.t361 17.0005
R2168 VGND.n435 VGND.t361 17.0005
R2169 VGND.n436 VGND.t361 17.0005
R2170 VGND.n437 VGND.t361 17.0005
R2171 VGND.n438 VGND.t361 17.0005
R2172 VGND.n439 VGND.t361 17.0005
R2173 VGND.n440 VGND.t361 17.0005
R2174 VGND.t361 VGND.n69 1.93639
R2175 VGND.t361 VGND.n354 17.0005
R2176 VGND.t361 VGND.n366 17.0005
R2177 VGND.t361 VGND.n355 17.0005
R2178 VGND.t361 VGND.n365 17.0005
R2179 VGND.t361 VGND.n356 17.0005
R2180 VGND.t361 VGND.n364 17.0005
R2181 VGND.t361 VGND.n357 17.0005
R2182 VGND.t361 VGND.n363 17.0005
R2183 VGND.t361 VGND.n358 17.0005
R2184 VGND.t361 VGND.n362 17.0005
R2185 VGND.t361 VGND.n359 17.0005
R2186 VGND.t361 VGND.n361 17.0005
R2187 VGND.t361 VGND.n360 17.0005
R2188 VGND.n84 VGND.t772 14.1472
R2189 VGND.t314 VGND.t888 12.8576
R2190 VGND.t319 VGND.t835 12.8576
R2191 VGND.t11 VGND.t370 12.8576
R2192 VGND.t385 VGND.t487 12.8576
R2193 VGND.n143 VGND.t881 8.57193
R2194 VGND.n155 VGND.t539 8.57193
R2195 VGND.t732 VGND.n215 8.57193
R2196 VGND.t820 VGND.t917 8.57193
R2197 VGND.t779 VGND.n200 8.57193
R2198 VGND.n258 VGND.t238 8.57193
R2199 VGND.t909 VGND.n610 8.57193
R2200 VGND.t126 VGND.t649 8.57193
R2201 VGND.t127 VGND.t650 8.57193
R2202 VGND.t37 VGND.n420 8.57193
R2203 VGND.t241 VGND.n404 8.57193
R2204 VGND.t601 VGND.n396 8.57193
R2205 VGND.t480 VGND.n43 8.07923
R2206 VGND.t632 VGND.n346 8.57193
R2207 VGND.t416 VGND.t640 8.57193
R2208 VGND.t79 VGND.n340 8.57193
R2209 VGND.t937 VGND.n324 8.57193
R2210 VGND.t543 VGND.n58 8.07961
R2211 VGND.t653 VGND.n319 8.57193
R2212 VGND.n600 VGND.t843 8.57193
R2213 VGND.n288 VGND.t458 8.57193
R2214 VGND.n293 VGND.t750 8.57193
R2215 VGND.n294 VGND.t805 8.57193
R2216 VGND.n300 VGND.t566 8.57193
R2217 VGND.n304 VGND.t462 8.57193
R2218 VGND.t455 VGND.n0 3.46061
R2219 VGND.t452 VGND.n98 0.130189
R2220 VGND.t449 VGND.n97 0.525986
R2221 VGND.t446 VGND.n83 0.219244
R2222 VGND.t443 VGND.n0 8.501
R2223 VGND.t440 VGND.n96 0.130189
R2224 VGND.t359 VGND.n110 0.775347
R2225 VGND.n101 VGND.t361 0.807318
R2226 VGND.t417 VGND.n100 0.797315
R2227 VGND.n99 VGND.t361 0.890778
R2228 VGND.n77 VGND.t381 0.219244
R2229 VGND.n102 VGND.t392 0.129991
R2230 VGND.t395 VGND.t361 8.501
R2231 VGND.t361 VGND.t401 8.501
R2232 VGND.t199 VGND.n104 0.130189
R2233 VGND.t397 VGND.n103 0.857968
R2234 VGND.t22 VGND.n105 0.129991
R2235 VGND.t24 VGND.n106 0.623726
R2236 VGND.t404 VGND.n108 0.535954
R2237 VGND.t267 VGND.n107 0.129991
R2238 VGND.n109 VGND.t361 2.02534
R2239 VGND.n605 VGND.n0 8.47111
R2240 VGND.t170 VGND.n27 5.6326
R2241 VGND.n0 VGND.n98 3.33079
R2242 VGND.n0 VGND.n96 3.33079
R2243 VGND.t361 VGND.n587 5.61485
R2244 VGND.n102 VGND.t361 3.33087
R2245 VGND.t361 VGND.n104 3.33079
R2246 VGND.t361 VGND.n105 3.33087
R2247 VGND.t361 VGND.n107 3.33087
R2248 VGND.t445 VGND.n602 5.16578
R2249 VGND.n567 VGND.t432 5.16578
R2250 VGND.n624 VGND.t307 4.5005
R2251 VGND.t365 VGND.n113 4.5005
R2252 VGND.t427 VGND.n448 4.5005
R2253 VGND.n284 VGND.t786 4.5005
R2254 VGND.n602 VGND.t22 4.5005
R2255 VGND.n444 VGND.t131 4.5005
R2256 VGND.t379 VGND.n567 4.5005
R2257 VGND.n625 VGND.n111 4.49573
R2258 VGND.t752 VGND.n123 4.28621
R2259 VGND.t97 VGND.n194 4.28621
R2260 VGND.t43 VGND.n51 11.0031
R2261 VGND.t802 VGND.n612 4.28621
R2262 VGND.n619 VGND.t463 4.28621
R2263 VGND.n443 VGND.n284 3.37758
R2264 VGND.t361 VGND.t366 3.33329
R2265 VGND.n0 VGND.n83 2.33245
R2266 VGND.n77 VGND.t361 2.33245
R2267 VGND.n27 VGND.t167 3.32876
R2268 VGND.n627 VGND.n626 3.002
R2269 VGND.n626 VGND.n112 3.00144
R2270 VGND.t7 VGND.n109 0.396506
R2271 VGND.n443 VGND.n112 2.19295
R2272 VGND.t196 VGND.t361 1.9765
R2273 VGND.n27 VGND.t339 1.3785
R2274 VGND.t361 VGND.n108 1.09148
R2275 VGND.n97 VGND.n0 1.09202
R2276 VGND.t66 VGND.t69 1.21873
R2277 VGND.t123 VGND.n0 1.03452
R2278 VGND.t361 VGND.t363 1.20745
R2279 VGND.n444 VGND.n443 1.17169
R2280 VGND.t64 VGND.t188 1.16454
R2281 VGND.t224 VGND.t231 1.16287
R2282 VGND.t535 VGND.t312 1.14671
R2283 VGND.n0 VGND.t430 1.12874
R2284 VGND.t267 VGND.n291 1.12167
R2285 VGND.t231 VGND.t303 1.11935
R2286 VGND.n168 VGND.t32 1.10972
R2287 VGND.n29 VGND.t117 0.443217
R2288 VGND.n168 VGND.t269 1.10142
R2289 VGND.n27 VGND.t156 1.09489
R2290 VGND.t361 VGND.n106 0.889668
R2291 VGND.n445 VGND.t303 1.0811
R2292 VGND.n446 VGND.t150 1.08089
R2293 VGND.n192 VGND.t73 1.08083
R2294 VGND.n291 VGND.t27 1.08002
R2295 VGND.n450 VGND.t712 1.06714
R2296 VGND.t249 VGND.n442 1.06182
R2297 VGND.t59 VGND.t62 1.0591
R2298 VGND.n451 VGND.t712 1.05747
R2299 VGND.n450 VGND.t62 1.05736
R2300 VGND.n449 VGND.t45 1.05279
R2301 VGND.t190 VGND.t551 1.04616
R2302 VGND.t325 VGND.t324 1.04319
R2303 VGND.n623 VGND.t172 1.04248
R2304 VGND.n351 VGND.t133 1.04248
R2305 VGND.t224 VGND.n446 1.04027
R2306 VGND.t872 VGND.n445 1.04025
R2307 VGND.n160 VGND.t119 1.03976
R2308 VGND.n451 VGND.t585 1.03966
R2309 VGND.t80 VGND.t82 1.03916
R2310 VGND.n442 VGND.t41 1.03784
R2311 VGND.n353 VGND.t7 1.03497
R2312 VGND.t133 VGND.n352 1.03332
R2313 VGND.n352 VGND.t249 1.02155
R2314 VGND.t235 VGND.n28 0.280705
R2315 VGND.t45 VGND.t59 1.01697
R2316 VGND.t551 VGND.n103 0.0566949
R2317 VGND.t131 VGND.t66 1.01462
R2318 VGND.t121 VGND.n110 1.06933
R2319 VGND.n447 VGND.t427 1.00251
R2320 VGND.t32 VGND.t331 1.00067
R2321 VGND.t324 VGND.n29 0.170232
R2322 VGND.t568 VGND.t150 0.981841
R2323 VGND.t568 VGND.t427 0.977857
R2324 VGND.n101 VGND.t705 0.0770299
R2325 VGND.n447 VGND.t426 0.959052
R2326 VGND.n100 VGND.t80 0.0630753
R2327 VGND.t41 VGND.n353 0.933949
R2328 VGND.n623 VGND.t307 0.916657
R2329 VGND.t379 VGND.n351 0.916657
R2330 VGND.n449 VGND.t432 0.899038
R2331 VGND.t69 VGND.n192 0.897135
R2332 VGND.t331 VGND.t73 0.896359
R2333 VGND.t786 VGND.n160 0.870137
R2334 VGND.n27 VGND.n28 0.289025
R2335 VGND.n27 VGND.t780 0.816397
R2336 VGND.t392 VGND.t705 0.805781
R2337 VGND.t390 VGND.n101 0.663991
R2338 VGND.t20 VGND.n28 0.263295
R2339 VGND.t131 VGND.t780 0.772031
R2340 VGND.t307 VGND.t312 0.767633
R2341 VGND.t780 VGND.t325 0.764918
R2342 VGND.n106 VGND.t27 0.79032
R2343 VGND.n99 VGND.t384 0.620402
R2344 VGND.t417 VGND.n99 0.829432
R2345 VGND.n27 VGND.n110 0.610065
R2346 VGND.t535 VGND.t20 0.698508
R2347 VGND.t430 VGND.t872 0.666796
R2348 VGND.n448 VGND.n113 0.66578
R2349 VGND.n624 VGND.n113 0.66578
R2350 VGND.n602 VGND.n284 0.66578
R2351 VGND.n567 VGND.n444 0.66578
R2352 VGND.t361 VGND.n100 0.558135
R2353 VGND.n27 VGND.n160 0.662724
R2354 VGND.t407 VGND.n108 0.0858508
R2355 VGND.t773 VGND.t123 0.654166
R2356 VGND.n27 VGND.n18 0.649813
R2357 VGND.n27 VGND.n19 0.649813
R2358 VGND.n27 VGND.n20 0.649813
R2359 VGND.n27 VGND.n21 0.649813
R2360 VGND.n27 VGND.n22 0.649813
R2361 VGND.n27 VGND.n1 0.649813
R2362 VGND.n27 VGND.n2 0.649813
R2363 VGND.n27 VGND.n17 0.649813
R2364 VGND.n27 VGND.n16 0.649813
R2365 VGND.n27 VGND.n15 0.649813
R2366 VGND.n27 VGND.n14 0.649813
R2367 VGND.n27 VGND.n3 0.649813
R2368 VGND.n27 VGND.n4 0.649813
R2369 VGND.n27 VGND.n13 0.649813
R2370 VGND.n27 VGND.n12 0.649813
R2371 VGND.n27 VGND.n5 0.649813
R2372 VGND.n27 VGND.n7 0.649813
R2373 VGND.n27 VGND.n8 0.649813
R2374 VGND.n27 VGND.n11 0.649813
R2375 VGND.n27 VGND.n10 0.649813
R2376 VGND.n27 VGND.n9 0.649813
R2377 VGND.n621 VGND.n27 0.649813
R2378 VGND.n27 VGND.n26 0.649813
R2379 VGND.n27 VGND.n23 0.649813
R2380 VGND.n27 VGND.n24 0.369515
R2381 VGND.n27 VGND.n25 0.369515
R2382 VGND.t361 VGND.n39 0.649813
R2383 VGND.t361 VGND.n38 0.649813
R2384 VGND.t361 VGND.n37 0.649813
R2385 VGND.t361 VGND.n41 0.649813
R2386 VGND.t361 VGND.n40 0.649813
R2387 VGND.t361 VGND.n42 0.649813
R2388 VGND.t361 VGND.n36 0.649813
R2389 VGND.t361 VGND.n35 0.649813
R2390 VGND.t361 VGND.n34 0.649813
R2391 VGND.t361 VGND.n33 0.649813
R2392 VGND.t361 VGND.n32 0.649813
R2393 VGND.t361 VGND.n31 0.649813
R2394 VGND.t361 VGND.n30 0.649813
R2395 VGND.t361 VGND.n45 427.457
R2396 VGND.n54 VGND.t361 0.613873
R2397 VGND.n414 VGND.t361 0.649813
R2398 VGND.n415 VGND.t361 0.649813
R2399 VGND.n425 VGND.t361 0.649813
R2400 VGND.n441 VGND.t361 0.649813
R2401 VGND.n97 VGND.t773 0.084197
R2402 VGND.t359 VGND.t339 0.621023
R2403 VGND.n27 VGND.t169 0.613476
R2404 VGND.t361 VGND.t516 0.613476
R2405 VGND.t121 VGND.t156 0.582725
R2406 VGND VGND.n627 0.56194
R2407 VGND.t361 VGND.n103 0.467443
R2408 VGND.n0 VGND.t568 0.552282
R2409 VGND.t199 VGND.t196 0.510599
R2410 VGND.n352 VGND.t361 0.507315
R2411 VGND.n27 VGND.n192 0.505436
R2412 VGND.n353 VGND.t361 0.471066
R2413 VGND.t430 VGND.t432 0.469132
R2414 VGND.n451 VGND.n0 0.463136
R2415 VGND.n27 VGND.t312 0.459453
R2416 VGND.n623 VGND.n27 0.442431
R2417 VGND.n351 VGND.t361 0.442431
R2418 VGND.t409 VGND.t407 0.441112
R2419 VGND.n27 VGND.n29 0.195168
R2420 VGND.n450 VGND.n0 0.424251
R2421 VGND.t361 VGND.n291 0.424027
R2422 VGND.n0 VGND.n446 0.423959
R2423 VGND.n0 VGND.n445 0.423916
R2424 VGND.t339 VGND.t119 0.415226
R2425 VGND.n27 VGND.t331 0.410845
R2426 VGND.t196 VGND.t190 0.406747
R2427 VGND.t59 VGND.n0 0.405685
R2428 VGND.n604 VGND.n0 0.389775
R2429 VGND.n603 VGND.n0 0.389775
R2430 VGND.n82 VGND.n0 0.37382
R2431 VGND.n79 VGND.n0 0.37382
R2432 VGND.n536 VGND.n0 0.389775
R2433 VGND.n70 VGND.n0 0.37382
R2434 VGND.n508 VGND.n0 0.389775
R2435 VGND.n507 VGND.n0 0.389775
R2436 VGND.n506 VGND.n0 0.389775
R2437 VGND.n88 VGND.n0 0.366073
R2438 VGND.n449 VGND.n0 0.38438
R2439 VGND.t669 VGND.n0 0.373361
R2440 VGND.n0 VGND.t231 0.35577
R2441 VGND.n27 VGND.n168 0.349191
R2442 VGND.n27 VGND.t66 0.340994
R2443 VGND.n0 VGND.n447 0.317125
R2444 VGND.n77 VGND.t379 0.216505
R2445 VGND.t445 VGND.n83 0.216505
R2446 VGND.t1 VGND.t366 0.308403
R2447 VGND.t1 VGND.n109 0.199073
R2448 VGND.t395 VGND.t393 0.227075
R2449 VGND.t29 VGND.t404 0.227075
R2450 VGND.t24 VGND.t421 0.227075
R2451 VGND.t786 VGND.t167 0.226756
R2452 VGND.t455 VGND.t453 0.226736
R2453 VGND.t441 VGND.t443 0.226736
R2454 VGND.t399 VGND.t401 0.226736
R2455 VGND.n587 VGND.t390 0.226736
R2456 VGND.t453 VGND.n98 0.0863258
R2457 VGND.t399 VGND.n104 0.0863258
R2458 VGND.n96 VGND.t441 0.0863258
R2459 VGND.n102 VGND.t393 0.0861948
R2460 VGND.n107 VGND.t29 0.0861948
R2461 VGND.n105 VGND.t421 0.0861948
R2462 VGND.t172 VGND.t170 0.171487
R2463 VGND.t452 VGND.n605 0.164539
R2464 VGND.t167 VGND.t269 0.149195
R2465 VGND.n605 VGND.t188 0.145789
R2466 VGND.t365 VGND.t366 0.124412
R2467 VGND.t365 VGND.t363 0.11002
R2468 VGND.n566 VGND.t440 0.10425
R2469 VGND.t445 VGND.t443 0.0855
R2470 VGND.t22 VGND.t401 0.0855
R2471 VGND.t381 VGND.t384 0.0855
R2472 VGND.t446 VGND.t449 0.07425
R2473 VGND.t397 VGND.t395 0.07425
R2474 VGND.n626 VGND.n625 0.0673813
R2475 VGND.t585 VGND.n566 0.06675
R2476 VGND.n587 VGND.t82 0.0605362
R2477 VGND.n448 VGND 0.01986
R2478 VGND.n625 VGND.n624 0.01458
R2479 VGND.n112 VGND.n111 0.0115476
R2480 VGND.n627 VGND.n111 0.0115476
R2481 VGND.t437 VGND.n0 183.806
R2482 VGND.n442 VGND.t361 1.24041
R2483 VGND.n27 VGND.n6 1.19591
R2484 VGND.n0 VGND.t64 1.03304
C0 sg13cmos5l_and2_1_4.B sg13cmos5l_inv_1_4.Y 0.03599f
C1 a_26991_3108# sg13cmos5l_xnor2_1_4.Y 0.01226f
C2 sg13cmos5l_xnor2_1_6.A a_25397_2386# 0.01271f
C3 sg13cmos5l_inv_16_14.A sg13cmos5l_inv_1_0.A 0.05855f
C4 sg13cmos5l_inv_16_29.Y sg13cmos5l_inv_16_4.Y 0.88075f
C5 a_28736_3230# VPWR 0.07066f
C6 a_2632_4026# VPWR 0.15802f
C7 a_26822_874# a_26934_938# 0.67711f
C8 a_25382_1632# VPWR 0.25078f
C9 a_26016_2697# sg13cmos5l_xnor2_1_4.Y 0.23291f
C10 sg13cmos5l_xnor2_1_3.Y sg13cmos5l_xnor2_1_1.Y 0.02941f
C11 sg13cmos5l_inv_16_1.Y sg13cmos5l_inv_1_0.A 0.01223f
C12 sg13cmos5l_inv_1_7.A a_28736_3230# 0.01644f
C13 sg13cmos5l_inv_4_1.A sg13cmos5l_inv_2_1.A 0.40567f
C14 en[3] VPWR 0.27268f
C15 a_17800_2514# sg13cmos5l_inv_16_21.A 0.01159f
C16 a_27029_2002# sg13cmos5l_xnor2_1_1.Y 0.06689f
C17 a_17800_2514# VPWR 0.15342f
C18 sg13cmos5l_inv_16_22.A a_18472_1002# 0.03325f
C19 sg13cmos5l_inv_16_10.A VPWR 4.16151f
C20 sg13cmos5l_inv_4_7.A a_22016_2514# 0.03557f
C21 a_16736_4097# sg13cmos5l_inv_8_6.A 0.09249f
C22 a_25494_1656# a_25382_1632# 0.67711f
C23 sg13cmos5l_dlygate4sd3_1_4.X a_27798_938# 0.03425f
C24 sg13cmos5l_xnor2_1_3.Y sg13cmos5l_xnor2_1_4.Y 0.07676f
C25 a_16264_3932# VPWR 0.31225f
C26 sg13cmos5l_inv_16_16.A a_8008_1002# 0.01799f
C27 en[5] a_20588_3858# 0.33766f
C28 sg13cmos5l_and2_1_7.A sg13cmos5l_inv_1_6.A 0.05207f
C29 sg13cmos5l_inv_16_3.Y VPWR 2.70861f
C30 sg13cmos5l_inv_4_4.A sg13cmos5l_inv_16_21.A 0.03989f
C31 sg13cmos5l_inv_4_4.A VPWR 0.95433f
C32 sg13cmos5l_inv_16_29.Y sg13cmos5l_inv_16_5.Y 0.19274f
C33 sg13cmos5l_dlygate4sd3_1_0.A a_24730_2350# 0.53561f
C34 sg13cmos5l_inv_16_22.A sg13cmos5l_inv_16_28.A 0.02325f
C35 sg13cmos5l_inv_16_7.A VPWR 4.46686f
C36 sg13cmos5l_xnor2_1_6.Y sg13cmos5l_xnor2_1_4.Y 0.02166f
C37 a_19424_4026# VPWR 0.08738f
C38 sg13cmos5l_inv_16_1.A sg13cmos5l_inv_16_0.A 0.08647f
C39 a_24704_3230# VPWR 0.0683f
C40 sg13cmos5l_and2_1_7.A a_28160_4097# 0.1205f
C41 a_10024_1002# VPWR 0.14939f
C42 sg13cmos5l_inv_16_16.A a_6952_1718# 0.03325f
C43 en[5] sg13cmos5l_and2_1_5.B 0.14165f
C44 sg13cmos5l_inv_16_2.A VPWR 4.00469f
C45 sg13cmos5l_inv_16_29.A VPWR 4.31675f
C46 a_25688_874# VPWR 0.36765f
C47 sg13cmos5l_inv_16_7.A sg13cmos5l_inv_4_2.Y 0.01179f
C48 sg13cmos5l_inv_2_7.Y a_28160_4097# 0.0297f
C49 a_16736_4097# sg13cmos5l_and2_1_4.B 0.34891f
C50 a_26070_938# VPWR 0.21402f
C51 a_24518_1632# sg13cmos5l_xnor2_1_3.B 0.01202f
C52 a_3304_1002# VPWR 0.14171f
C53 a_28652_3858# VPWR 0.25717f
C54 sg13cmos5l_xnor2_1_1.B a_27599_2002# 0.04203f
C55 sg13cmos5l_inv_16_1.A a_8096_2514# 0.03438f
C56 a_28936_1002# VPWR 0.13916f
C57 a_13288_1718# a_13472_1718# 0.11523f
C58 sg13cmos5l_dlygate4sd3_1_0.A en[6] 0.01002f
C59 sg13cmos5l_inv_16_29.A sg13cmos5l_inv_16_30.A 0.06972f
C60 sg13cmos5l_inv_16_18.A VPWR 4.06508f
C61 sg13cmos5l_inv_2_1.A sg13cmos5l_inv_1_3.A 0.1046f
C62 en[5] VPWR 0.22525f
C63 sg13cmos5l_and2_1_7.A a_25306_3108# 0.01753f
C64 sg13cmos5l_inv_16_7.A sg13cmos5l_inv_16_6.A 0.03291f
C65 sg13cmos5l_inv_16_26.A sg13cmos5l_inv_8_6.A 0.91673f
C66 sg13cmos5l_dlygate4sd3_1_0.A sg13cmos5l_inv_4_7.A 0.01231f
C67 sg13cmos5l_dlygate4sd3_1_1.X a_25958_874# 0.01529f
C68 sg13cmos5l_inv_16_5.A VPWR 4.28932f
C69 sg13cmos5l_and2_1_6.B VPWR 0.28305f
C70 sg13cmos5l_inv_16_1.A sg13cmos5l_inv_2_0.A 0.01298f
C71 sg13cmos5l_and2_1_7.A a_14240_4097# 0.15875f
C72 sg13cmos5l_inv_16_21.A a_19528_1718# 0.04979f
C73 sg13cmos5l_inv_4_2.Y sg13cmos5l_inv_16_18.A 0.01622f
C74 a_19528_1718# VPWR 0.15041f
C75 sg13cmos5l_inv_4_2.A sg13cmos5l_inv_16_18.Y 0.0258f
C76 a_5709_3940# a_6284_3858# 0.02706f
C77 sg13cmos5l_inv_4_1.A sg13cmos5l_inv_1_3.A 0.03864f
C78 sg13cmos5l_dlygate4sd3_1_3.X sg13cmos5l_xnor2_1_3.Y 0.27813f
C79 sg13cmos5l_inv_4_6.Y sg13cmos5l_inv_2_7.Y 1.10655f
C80 sg13cmos5l_inv_1_7.A sg13cmos5l_and2_1_6.B 0.01656f
C81 sg13cmos5l_inv_16_5.A sg13cmos5l_inv_16_30.A 0.90138f
C82 sg13cmos5l_inv_16_26.A sg13cmos5l_inv_4_5.A 0.02899f
C83 sg13cmos5l_inv_16_29.Y sg13cmos5l_inv_2_3.A 0.10572f
C84 VPWR a_14732_3858# 0.34747f
C85 VPWR sg13cmos5l_inv_1_2.A 0.53106f
C86 a_24730_2350# VPWR 0.41241f
C87 sg13cmos5l_and2_1_7.B VPWR 0.31959f
C88 sg13cmos5l_inv_16_17.Y VPWR 2.71856f
C89 sg13cmos5l_and2_1_7.A sg13cmos5l_inv_2_3.Y 0.03478f
C90 sg13cmos5l_inv_16_21.A sg13cmos5l_inv_16_19.A 0.02017f
C91 sg13cmos5l_and2_1_7.A sg13cmos5l_inv_1_8.Y 0.03378f
C92 sg13cmos5l_inv_16_19.A VPWR 4.08129f
C93 sg13cmos5l_xnor2_1_1.B VPWR 0.60323f
C94 sg13cmos5l_and2_1_1.B a_6284_3858# 0.29212f
C95 sg13cmos5l_inv_1_1.A a_4640_4026# 0.03553f
C96 sg13cmos5l_dlygate4sd3_1_0.A sg13cmos5l_xnor2_1_3.B 0.02769f
C97 a_16264_3932# sg13cmos5l_inv_1_4.Y 0.02159f
C98 a_28652_3858# a_28936_4026# 0.01225f
C99 sg13cmos5l_inv_1_8.Y sg13cmos5l_inv_2_7.Y 0.16296f
C100 a_24576_1185# a_24725_874# 0.3658f
C101 VPWR sg13cmos5l_and2_1_2.B 0.28803f
C102 sg13cmos5l_inv_16_29.Y sg13cmos5l_inv_16_15.A 0.1591f
C103 sg13cmos5l_inv_16_4.Y sg13cmos5l_inv_16_0.A 0.08671f
C104 VPWR sg13cmos5l_inv_8_1.A 1.5464f
C105 a_28940_3108# VPWR 0.24954f
C106 sg13cmos5l_inv_2_1.A VPWR 1.00943f
C107 a_26112_1671# sg13cmos5l_xnor2_1_0.Y 0.25595f
C108 en[5] sg13cmos5l_inv_16_23.A 0.02561f
C109 sg13cmos5l_xnor2_1_0.Y VPWR 0.50183f
C110 a_26552_874# a_26822_874# 0.33585f
C111 a_22016_2514# VPWR 0.08665f
C112 a_2632_4026# a_2816_4026# 0.11523f
C113 sg13cmos5l_inv_1_1.A sg13cmos5l_inv_2_2.A 0.12415f
C114 en[2] sg13cmos5l_inv_1_0.A 0.01849f
C115 sg13cmos5l_inv_2_3.Y a_14240_4097# 0.02972f
C116 sg13cmos5l_and2_1_4.B sg13cmos5l_inv_1_4.A 0.37911f
C117 sg13cmos5l_inv_1_8.Y sg13cmos5l_inv_4_6.Y 0.0609f
C118 a_24518_1632# VPWR 0.25074f
C119 a_26528_3230# sg13cmos5l_inv_1_8.Y 0.01129f
C120 sg13cmos5l_and2_1_7.B sg13cmos5l_inv_16_24.A 0.01248f
C121 sg13cmos5l_inv_1_7.A a_28940_3108# 0.30475f
C122 a_24910_3411# a_24704_3230# 0.03208f
C123 a_6080_1002# sg13cmos5l_inv_16_18.A 0.03438f
C124 en[6] VPWR 0.25342f
C125 en[4] sg13cmos5l_and2_1_4.B 0.04155f
C126 sg13cmos5l_inv_16_29.Y sg13cmos5l_inv_16_0.A 0.05245f
C127 VPWR sg13cmos5l_inv_4_0.Y 1.67868f
C128 sg13cmos5l_and2_1_7.A a_5512_4026# 0.0563f
C129 sg13cmos5l_inv_2_1.A sg13cmos5l_inv_4_2.Y 0.02192f
C130 sg13cmos5l_inv_4_1.A VPWR 1.93781f
C131 sg13cmos5l_and2_1_1.B en[1] 0.04163f
C132 sg13cmos5l_and2_1_7.A sg13cmos5l_inv_16_15.A 0.0185f
C133 sg13cmos5l_xnor2_1_6.A sg13cmos5l_dlygate4sd3_1_0.A 0.6594f
C134 sg13cmos5l_dlygate4sd3_1_1.X a_26261_2002# 0.01131f
C135 a_2920_3932# VPWR 0.32934f
C136 sg13cmos5l_inv_16_9.A sg13cmos5l_inv_16_7.A 0.19274f
C137 sg13cmos5l_inv_4_7.A VPWR 2.87826f
C138 sg13cmos5l_inv_1_1.A sg13cmos5l_buf_1_1.X 0.03621f
C139 sg13cmos5l_dlygate4sd3_1_4.X a_27416_874# 0.63106f
C140 sg13cmos5l_inv_16_1.Y sg13cmos5l_inv_16_17.Y 0.88095f
C141 sg13cmos5l_inv_16_5.Y sg13cmos5l_inv_16_0.A 0.06593f
C142 sg13cmos5l_xnor2_1_1.B sg13cmos5l_xnor2_1_1.Y 0.29508f
C143 sg13cmos5l_inv_4_0.A sg13cmos5l_inv_16_0.A 0.07005f
C144 sg13cmos5l_inv_16_19.A sg13cmos5l_inv_16_23.A 0.12586f
C145 a_17800_2514# a_17984_2514# 0.11523f
C146 sg13cmos5l_inv_2_0.A sg13cmos5l_inv_16_4.Y 0.03737f
C147 sg13cmos5l_xnor2_1_2.B a_27798_938# 0.19594f
C148 sg13cmos5l_inv_4_1.A sg13cmos5l_inv_4_2.Y 0.01714f
C149 sg13cmos5l_and2_1_7.A sg13cmos5l_inv_16_0.A 0.01969f
C150 sg13cmos5l_inv_16_9.Y VPWR 4.44213f
C151 a_19616_4097# sg13cmos5l_inv_1_6.A 0.12859f
C152 a_13288_4026# a_13472_4026# 0.11523f
C153 sg13cmos5l_inv_2_3.A sg13cmos5l_inv_2_3.Y 0.15475f
C154 en[6] sg13cmos5l_inv_16_24.A 0.07279f
C155 a_24236_3108# a_24032_3230# 0.03376f
C156 sg13cmos5l_inv_16_14.A sg13cmos5l_inv_4_0.Y 0.123f
C157 sg13cmos5l_inv_16_16.A sg13cmos5l_inv_16_0.A 0.05158f
C158 sg13cmos5l_xnor2_1_0.Y sg13cmos5l_xnor2_1_1.Y 0.02704f
C159 sg13cmos5l_inv_4_4.A a_17984_2514# 0.03489f
C160 a_22016_2514# sg13cmos5l_inv_16_23.A 0.04353f
C161 sg13cmos5l_inv_4_1.A sg13cmos5l_inv_16_6.A 0.01427f
C162 sg13cmos5l_inv_16_19.A sg13cmos5l_inv_16_28.A 1.04024f
C163 a_26880_1671# a_27029_2002# 0.3658f
C164 sg13cmos5l_xnor2_1_2.B sg13cmos5l_dlygate4sd3_1_4.X 0.69772f
C165 sg13cmos5l_xnor2_1_3.B VPWR 0.67805f
C166 a_20672_1002# VPWR 0.07103f
C167 sg13cmos5l_and2_1_5.B a_20588_3858# 0.29036f
C168 sg13cmos5l_inv_8_6.A sg13cmos5l_inv_1_6.A 0.02892f
C169 sg13cmos5l_dlygate4sd3_1_0.A VPWR 1.018f
C170 a_16264_3932# a_16736_4097# 0.02706f
C171 a_24518_1632# a_24248_1673# 0.33585f
C172 a_25568_1002# VPWR 0.11461f
C173 sg13cmos5l_inv_16_1.A sg13cmos5l_inv_1_0.A 0.31905f
C174 sg13cmos5l_inv_2_5.A sg13cmos5l_inv_4_4.A 0.22487f
C175 sg13cmos5l_inv_4_1.Y sg13cmos5l_inv_2_1.A 0.03772f
C176 a_27686_874# VPWR 0.24472f
C177 a_23648_3403# sg13cmos5l_and2_1_7.A 0.13666f
C178 VPWR a_15872_4026# 0.06602f
C179 sg13cmos5l_and2_1_7.A a_19616_4097# 0.15936f
C180 sg13cmos5l_xnor2_1_0.Y sg13cmos5l_xnor2_1_4.Y 0.14566f
C181 sg13cmos5l_inv_2_0.A sg13cmos5l_inv_4_0.A 0.16167f
C182 sg13cmos5l_inv_4_7.A sg13cmos5l_inv_16_23.A 0.06064f
C183 sg13cmos5l_dlygate4sd3_1_3.X a_26070_938# 0.23331f
C184 sg13cmos5l_xnor2_1_1.B a_27564_1898# 0.22612f
C185 sg13cmos5l_inv_8_7.A a_21632_1718# 0.03724f
C186 VPWR sg13cmos5l_inv_1_3.A 0.40927f
C187 a_23648_3403# a_23456_3230# 0.02877f
C188 a_29120_1718# VPWR 0.05803f
C189 sg13cmos5l_inv_4_0.Y a_10208_4026# 0.03989f
C190 a_25248_2697# sg13cmos5l_xnor2_1_6.Y 0.2565f
C191 a_20588_3858# VPWR 0.31332f
C192 sg13cmos5l_xnor2_1_6.A VPWR 1.85182f
C193 sg13cmos5l_inv_4_1.Y sg13cmos5l_inv_4_1.A 0.6667f
C194 sg13cmos5l_and2_1_7.A sg13cmos5l_inv_8_6.A 0.05862f
C195 sg13cmos5l_inv_2_4.A sg13cmos5l_and2_1_7.A 0.02353f
C196 a_10016_2514# VPWR 0.09007f
C197 a_5120_4097# VPWR 0.45056f
C198 sg13cmos5l_buf_1_1.X sg13cmos5l_and2_1_7.A 0.51864f
C199 a_23272_3230# VPWR 0.13148f
C200 a_24128_2514# VPWR 0.07308f
C201 sg13cmos5l_and2_1_5.B VPWR 0.34718f
C202 sg13cmos5l_inv_16_12.A sg13cmos5l_inv_4_1.A 0.0324f
C203 sg13cmos5l_inv_16_21.A a_17600_1718# 0.03438f
C204 sg13cmos5l_and2_1_7.A sg13cmos5l_inv_4_5.A 0.13341f
C205 a_17600_1718# VPWR 0.08917f
C206 sg13cmos5l_inv_1_5.A sg13cmos5l_and2_1_7.A 0.64928f
C207 sg13cmos5l_inv_1_5.A a_23456_3230# 0.01965f
C208 sg13cmos5l_xnor2_1_6.A sg13cmos5l_inv_4_8.A 0.59236f
C209 sg13cmos5l_inv_16_0.A sg13cmos5l_inv_16_15.A 0.07514f
C210 a_24518_1632# sg13cmos5l_xnor2_1_3.A 0.08017f
C211 sg13cmos5l_xnor2_1_3.Y a_26259_2680# 0.01038f
C212 a_28552_3230# a_28736_3230# 0.11523f
C213 sg13cmos5l_inv_16_31.A sg13cmos5l_inv_16_29.A 1.00298f
C214 a_26344_3230# VPWR 0.14208f
C215 en[3] en[4] 0.03484f
C216 sg13cmos5l_and2_1_7.A sg13cmos5l_and2_1_4.B 0.32305f
C217 a_26112_1671# VPWR 0.26375f
C218 sg13cmos5l_inv_16_21.A VPWR 4.066f
C219 sg13cmos5l_inv_8_4.A sg13cmos5l_inv_16_21.Y 0.12151f
C220 a_3680_1718# VPWR 0.12345f
C221 sg13cmos5l_inv_4_2.A sg13cmos5l_inv_16_8.A 0.0336f
C222 a_3304_1002# a_3488_1002# 0.11523f
C223 sg13cmos5l_inv_16_28.A a_20672_1002# 0.03438f
C224 sg13cmos5l_inv_16_1.Y sg13cmos5l_inv_1_3.A 0.04464f
C225 a_2920_3932# en[0] 0.32782f
C226 a_16264_3932# sg13cmos5l_inv_1_4.A 0.0567f
C227 a_20588_3858# sg13cmos5l_inv_16_23.A 0.02278f
C228 sg13cmos5l_inv_4_7.A sg13cmos5l_xnor2_1_3.A 0.0197f
C229 sg13cmos5l_xnor2_1_6.A sg13cmos5l_xnor2_1_5.Y 0.06612f
C230 sg13cmos5l_dlygate4sd3_1_3.X sg13cmos5l_xnor2_1_0.Y 0.09552f
C231 en[4] a_16264_3932# 0.32525f
C232 a_28936_1002# a_29120_1002# 0.11523f
C233 a_25248_2697# a_25397_2386# 0.3658f
C234 VPWR a_9357_3940# 0.47255f
C235 a_23368_4026# VPWR 0.15656f
C236 sg13cmos5l_inv_1_7.A VPWR 0.33748f
C237 a_3304_3230# VPWR 0.1506f
C238 sg13cmos5l_inv_4_1.A a_5312_2514# 0.03557f
C239 sg13cmos5l_inv_16_20.A a_17600_1718# 0.04554f
C240 sg13cmos5l_xnor2_1_3.Y a_24576_1185# 0.2308f
C241 sg13cmos5l_inv_16_30.A VPWR 4.08319f
C242 sg13cmos5l_and2_1_7.A a_26991_3108# 0.36201f
C243 a_25494_1656# VPWR 0.22066f
C244 sg13cmos5l_inv_4_2.Y VPWR 1.46519f
C245 sg13cmos5l_inv_16_9.A sg13cmos5l_inv_16_9.Y 1.51018f
C246 a_24910_3411# sg13cmos5l_dlygate4sd3_1_0.A 0.20164f
C247 sg13cmos5l_xnor2_1_3.Y a_25958_874# 0.03836f
C248 a_28160_4097# sg13cmos5l_inv_1_8.A 0.12891f
C249 sg13cmos5l_inv_16_13.A sg13cmos5l_inv_2_2.A 0.07989f
C250 sg13cmos5l_dlygate4sd3_1_4.X a_26822_874# 0.01601f
C251 sg13cmos5l_inv_1_4.Y a_15872_4026# 0.01122f
C252 sg13cmos5l_inv_16_29.Y sg13cmos5l_inv_1_0.A 0.03761f
C253 sg13cmos5l_inv_16_23.Y sg13cmos5l_inv_16_19.A 0.01276f
C254 VPWR sg13cmos5l_and2_1_3.B 0.22557f
C255 sg13cmos5l_inv_16_24.A VPWR 2.79611f
C256 sg13cmos5l_inv_16_1.A sg13cmos5l_inv_16_2.A 0.01398f
C257 a_26880_2697# VPWR 0.3071f
C258 sg13cmos5l_inv_4_8.A VPWR 0.63555f
C259 sg13cmos5l_inv_16_14.A VPWR 3.98271f
C260 sg13cmos5l_inv_16_18.A sg13cmos5l_inv_16_18.Y 0.90342f
C261 sg13cmos5l_inv_16_20.A sg13cmos5l_inv_16_21.A 0.02571f
C262 sg13cmos5l_and2_1_7.A sg13cmos5l_inv_1_8.A 1.83705f
C263 sg13cmos5l_inv_16_20.A VPWR 3.02336f
C264 sg13cmos5l_inv_16_6.A a_3680_1718# 0.03438f
C265 a_26624_2514# VPWR 0.08925f
C266 sg13cmos5l_inv_16_6.A VPWR 2.85859f
C267 sg13cmos5l_inv_16_12.A sg13cmos5l_inv_1_3.A 0.0146f
C268 sg13cmos5l_and2_1_3.B a_9357_3940# 0.34891f
C269 sg13cmos5l_inv_2_7.Y sg13cmos5l_inv_1_8.A 0.01148f
C270 sg13cmos5l_xnor2_1_3.A sg13cmos5l_xnor2_1_3.B 1.15268f
C271 sg13cmos5l_inv_16_24.A a_23368_4026# 0.03325f
C272 a_26991_3108# sg13cmos5l_inv_4_6.Y 0.0361f
C273 sg13cmos5l_inv_4_8.A sg13cmos5l_inv_1_7.A 0.18607f
C274 sg13cmos5l_and2_1_7.A en[1] 0.08334f
C275 sg13cmos5l_inv_4_0.A sg13cmos5l_inv_1_0.A 0.06586f
C276 sg13cmos5l_inv_2_0.A sg13cmos5l_inv_16_0.A 0.08252f
C277 a_28936_4026# VPWR 0.11786f
C278 sg13cmos5l_inv_16_23.A VPWR 4.47315f
C279 sg13cmos5l_xnor2_1_1.Y VPWR 0.64782f
C280 sg13cmos5l_buf_1_1.X a_5512_4026# 0.05315f
C281 sg13cmos5l_xnor2_1_5.Y VPWR 0.84737f
C282 a_27564_1898# a_27599_2002# 0.3658f
C283 sg13cmos5l_inv_16_21.A a_18472_1002# 0.01751f
C284 sg13cmos5l_inv_16_1.Y VPWR 4.58532f
C285 a_19528_1718# a_19712_1718# 0.11523f
C286 a_25382_1632# a_25112_1673# 0.33585f
C287 sg13cmos5l_and2_1_7.A sg13cmos5l_inv_1_0.A 0.02658f
C288 sg13cmos5l_inv_16_20.A sg13cmos5l_inv_16_30.A 0.92608f
C289 a_18472_1002# VPWR 0.14989f
C290 a_24248_1673# VPWR 0.36388f
C291 a_24032_3230# sg13cmos5l_and2_1_7.A 0.04707f
C292 sg13cmos5l_inv_16_6.A sg13cmos5l_inv_4_2.Y 1.14501f
C293 sg13cmos5l_inv_1_2.A a_13288_4026# 0.04366f
C294 en[2] sg13cmos5l_inv_4_0.Y 0.01207f
C295 sg13cmos5l_inv_4_6.Y sg13cmos5l_inv_1_8.A 0.15361f
C296 a_26528_3230# sg13cmos5l_inv_1_8.A 0.03553f
C297 sg13cmos5l_and2_1_7.B a_24236_3108# 0.29357f
C298 a_5408_1002# sg13cmos5l_inv_16_8.A 0.0429f
C299 a_26934_938# VPWR 0.21493f
C300 a_6080_1002# VPWR 0.08385f
C301 VPWR a_10208_4026# 0.07537f
C302 sg13cmos5l_xnor2_1_4.Y VPWR 0.79423f
C303 sg13cmos5l_inv_16_19.A a_19712_1718# 0.03438f
C304 sg13cmos5l_inv_4_1.Y VPWR 1.58591f
C305 sg13cmos5l_xnor2_1_1.B a_26880_1671# 0.4382f
C306 sg13cmos5l_inv_16_28.A VPWR 2.97916f
C307 sg13cmos5l_inv_2_2.A a_4640_4026# 0.01054f
C308 sg13cmos5l_inv_1_8.Y sg13cmos5l_inv_1_8.A 0.15869f
C309 sg13cmos5l_xnor2_1_1.Y a_26880_2697# 0.45091f
C310 sg13cmos5l_xnor2_1_5.Y a_26880_2697# 0.22845f
C311 sg13cmos5l_inv_4_4.A a_18656_2514# 0.04686f
C312 sg13cmos5l_xnor2_1_5.Y sg13cmos5l_inv_4_8.A 0.03397f
C313 sg13cmos5l_inv_16_17.Y sg13cmos5l_inv_16_1.A 0.01267f
C314 sg13cmos5l_inv_16_1.Y sg13cmos5l_inv_16_14.A 0.05458f
C315 VPWR sg13cmos5l_inv_1_4.Y 0.56452f
C316 a_26261_2002# sg13cmos5l_xnor2_1_3.Y 0.01693f
C317 a_24910_3411# VPWR 0.21962f
C318 sg13cmos5l_xnor2_1_3.A a_24128_2514# 0.01243f
C319 sg13cmos5l_inv_16_12.A VPWR 2.83233f
C320 sg13cmos5l_inv_4_1.Y sg13cmos5l_inv_4_2.Y 0.01064f
C321 sg13cmos5l_xnor2_1_0.Y a_26880_1671# 0.19867f
C322 a_27564_1898# VPWR 0.28898f
C323 sg13cmos5l_inv_2_4.A a_23648_3403# 0.01031f
C324 sg13cmos5l_inv_2_4.A a_23944_2514# 0.03694f
C325 a_24520_3230# a_24704_3230# 0.11523f
C326 sg13cmos5l_inv_2_3.Y a_13472_4026# 0.03886f
C327 a_24236_3108# en[6] 0.34042f
C328 a_9932_3858# sg13cmos5l_inv_1_0.A 0.02089f
C329 sg13cmos5l_xnor2_1_4.Y a_26880_2697# 0.17598f
C330 sg13cmos5l_xnor2_1_5.Y sg13cmos5l_xnor2_1_1.Y 0.09219f
C331 sg13cmos5l_inv_16_10.Y sg13cmos5l_inv_16_10.A 0.90342f
C332 sg13cmos5l_inv_16_2.A a_8008_1002# 0.03325f
C333 sg13cmos5l_dlygate4sd3_1_1.X sg13cmos5l_xnor2_1_3.Y 0.40977f
C334 sg13cmos5l_xnor2_1_4.Y a_26624_2514# 0.046f
C335 sg13cmos5l_and2_1_7.A en[3] 0.22492f
C336 sg13cmos5l_inv_4_1.Y sg13cmos5l_inv_16_6.A 0.01439f
C337 sg13cmos5l_inv_16_9.A VPWR 4.30874f
C338 sg13cmos5l_dlygate4sd3_1_0.A a_25025_3410# 0.01566f
C339 en[7] a_28652_3858# 0.32844f
C340 en[0] VPWR 0.44568f
C341 sg13cmos5l_inv_8_7.A sg13cmos5l_inv_16_19.A 0.02694f
C342 sg13cmos5l_inv_1_6.A a_19424_4026# 0.0195f
C343 sg13cmos5l_xnor2_1_3.A VPWR 0.68953f
C344 sg13cmos5l_buf_1_1.X sg13cmos5l_inv_2_2.A 0.01359f
C345 sg13cmos5l_inv_1_5.A a_23648_3403# 0.13772f
C346 sg13cmos5l_xnor2_1_4.Y sg13cmos5l_xnor2_1_1.Y 0.58514f
C347 sg13cmos5l_inv_16_1.A sg13cmos5l_inv_4_0.Y 0.05922f
C348 a_25688_874# a_25958_874# 0.33585f
C349 sg13cmos5l_xnor2_1_5.Y sg13cmos5l_xnor2_1_4.Y 0.01982f
C350 a_5709_3940# sg13cmos5l_inv_1_3.A 0.12856f
C351 sg13cmos5l_inv_16_18.A a_8008_1002# 0.0483f
C352 sg13cmos5l_inv_16_28.A sg13cmos5l_inv_16_23.A 0.01161f
C353 sg13cmos5l_inv_16_5.Y sg13cmos5l_inv_16_3.Y 0.90339f
C354 sg13cmos5l_dlygate4sd3_1_1.X sg13cmos5l_xnor2_1_6.Y 0.07351f
C355 sg13cmos5l_inv_16_29.Y sg13cmos5l_inv_16_29.A 0.91171f
C356 a_5312_2514# VPWR 0.0945f
C357 a_25958_874# a_26070_938# 0.67711f
C358 sg13cmos5l_inv_16_12.A sg13cmos5l_inv_16_6.A 0.03399f
C359 en[7] sg13cmos5l_and2_1_6.B 0.04379f
C360 a_2816_4026# VPWR 0.07626f
C361 sg13cmos5l_inv_4_5.A sg13cmos5l_inv_8_6.A 0.70119f
C362 a_22016_2514# sg13cmos5l_inv_8_7.A 0.01305f
C363 sg13cmos5l_inv_1_5.A sg13cmos5l_inv_2_4.A 0.25671f
C364 sg13cmos5l_xnor2_1_6.A a_25025_3410# 0.01321f
C365 sg13cmos5l_dlygate4sd3_1_3.X a_26112_1671# 0.42923f
C366 sg13cmos5l_dlygate4sd3_1_3.X VPWR 0.67643f
C367 a_5120_4097# a_5709_3940# 0.03863f
C368 sg13cmos5l_inv_16_25.Y VPWR 2.72069f
C369 sg13cmos5l_and2_1_1.B sg13cmos5l_inv_1_3.A 0.35541f
C370 a_6952_1718# sg13cmos5l_inv_16_18.A 0.01772f
C371 sg13cmos5l_inv_4_0.A a_10024_1002# 0.04677f
C372 sg13cmos5l_inv_4_0.A sg13cmos5l_inv_16_2.A 0.22523f
C373 a_17984_2514# VPWR 0.0724f
C374 sg13cmos5l_inv_16_22.A a_20488_1002# 0.04841f
C375 a_24236_3108# sg13cmos5l_dlygate4sd3_1_0.A 0.03873f
C376 sg13cmos5l_xnor2_1_3.Y a_24725_874# 0.04203f
C377 sg13cmos5l_inv_4_7.A sg13cmos5l_inv_8_7.A 0.61894f
C378 sg13cmos5l_dlygate4sd3_1_1.X a_25382_1632# 0.02242f
C379 sg13cmos5l_inv_16_5.A sg13cmos5l_inv_16_29.Y 0.01819f
C380 sg13cmos5l_inv_1_0.A sg13cmos5l_inv_16_0.A 0.06305f
C381 sg13cmos5l_inv_2_5.A sg13cmos5l_inv_16_21.A 0.02149f
C382 a_16736_4097# VPWR 0.44985f
C383 sg13cmos5l_inv_2_5.A VPWR 0.9539f
C384 sg13cmos5l_and2_1_7.A a_28652_3858# 0.03614f
C385 sg13cmos5l_inv_16_12.A sg13cmos5l_inv_4_1.Y 1.16193f
C386 en[5] sg13cmos5l_inv_16_27.A 0.03982f
C387 sg13cmos5l_inv_16_16.A sg13cmos5l_inv_16_2.A 1.03609f
C388 a_13288_1718# VPWR 0.15012f
C389 sg13cmos5l_dlygate4sd3_1_0.A a_25248_2697# 0.46271f
C390 sg13cmos5l_inv_16_9.Y sg13cmos5l_inv_16_11.Y 0.91105f
C391 sg13cmos5l_xnor2_1_3.A a_24248_1673# 0.56223f
C392 a_28160_4097# sg13cmos5l_and2_1_6.B 0.45592f
C393 sg13cmos5l_inv_16_7.A sg13cmos5l_inv_16_8.A 1.05771f
C394 sg13cmos5l_and2_1_7.A en[5] 0.01413f
C395 sg13cmos5l_inv_1_4.A a_15872_4026# 0.03553f
C396 sg13cmos5l_inv_16_5.A sg13cmos5l_inv_16_5.Y 1.04832f
C397 a_5709_3940# VPWR 0.45066f
C398 en[2] VPWR 0.27993f
C399 sg13cmos5l_inv_16_5.A sg13cmos5l_inv_4_0.A 0.03942f
C400 sg13cmos5l_inv_16_23.Y VPWR 4.51183f
C401 a_25025_3410# VPWR 0.25467f
C402 sg13cmos5l_and2_1_7.A sg13cmos5l_and2_1_6.B 0.17125f
C403 a_14336_1002# VPWR 0.11983f
C404 sg13cmos5l_inv_16_16.A sg13cmos5l_inv_16_18.A 1.03773f
C405 a_24320_1002# VPWR 0.12024f
C406 a_24520_3230# en[6] 0.0635f
C407 sg13cmos5l_xnor2_1_6.A a_25248_2697# 0.13368f
C408 a_26552_874# VPWR 0.33482f
C409 a_3488_1002# VPWR 0.06996f
C410 a_5408_1002# sg13cmos5l_inv_4_2.A 0.03543f
C411 sg13cmos5l_and2_1_1.B VPWR 0.22801f
C412 a_26048_4026# VPWR 0.09546f
C413 sg13cmos5l_inv_2_0.A sg13cmos5l_inv_1_0.A 0.2835f
C414 sg13cmos5l_inv_16_31.A VPWR 4.40205f
C415 sg13cmos5l_inv_16_1.A a_10016_2514# 0.04331f
C416 sg13cmos5l_and2_1_7.A a_14732_3858# 0.04247f
C417 sg13cmos5l_xnor2_1_1.B sg13cmos5l_dlygate4sd3_1_4.X 0.05407f
C418 sg13cmos5l_and2_1_7.A sg13cmos5l_inv_1_2.A 0.29493f
C419 sg13cmos5l_inv_16_30.A a_14336_1002# 0.03438f
C420 a_29120_1002# VPWR 0.05685f
C421 sg13cmos5l_inv_8_4.A a_17320_1002# 0.03662f
C422 sg13cmos5l_and2_1_7.B sg13cmos5l_and2_1_7.A 0.17036f
C423 sg13cmos5l_dlygate4sd3_1_1.X a_25688_874# 0.52473f
C424 en[2] sg13cmos5l_and2_1_3.B 0.05605f
C425 sg13cmos5l_inv_4_6.Y sg13cmos5l_and2_1_6.B 0.01363f
C426 a_25025_3410# sg13cmos5l_inv_16_24.A 0.01737f
C427 a_24449_2572# a_24730_2350# 0.33585f
C428 sg13cmos5l_dlygate4sd3_1_1.X a_26070_938# 0.01475f
C429 VPWR a_13288_4026# 0.14486f
C430 VPWR a_9248_4026# 0.08704f
C431 sg13cmos5l_inv_16_31.A sg13cmos5l_inv_16_30.A 0.01714f
C432 a_24236_3108# VPWR 0.26355f
C433 sg13cmos5l_inv_16_26.A VPWR 2.94298f
C434 a_24334_2571# a_24128_2514# 0.03208f
C435 sg13cmos5l_and2_1_7.A sg13cmos5l_and2_1_2.B 0.43286f
C436 sg13cmos5l_and2_1_7.A sg13cmos5l_inv_8_1.A 1.86978f
C437 a_26880_1671# VPWR 0.26241f
C438 sg13cmos5l_inv_16_18.Y VPWR 2.67741f
C439 a_19712_1718# VPWR 0.07221f
C440 sg13cmos5l_inv_1_2.A a_14240_4097# 0.13046f
C441 en[6] sg13cmos5l_inv_16_27.A 0.1779f
C442 sg13cmos5l_inv_16_23.Y sg13cmos5l_inv_16_23.A 0.99581f
C443 sg13cmos5l_xnor2_1_3.B a_25112_1673# 0.61416f
C444 sg13cmos5l_inv_16_3.Y sg13cmos5l_inv_16_0.A 0.06149f
C445 a_28940_3108# osc 0.33115f
C446 VPWR sg13cmos5l_inv_1_4.A 0.35888f
C447 sg13cmos5l_inv_16_5.Y sg13cmos5l_inv_4_0.Y 0.04756f
C448 sg13cmos5l_inv_4_0.A sg13cmos5l_inv_4_0.Y 1.04098f
C449 a_26016_2697# a_26165_2386# 0.3658f
C450 a_25248_2697# VPWR 0.30635f
C451 sg13cmos5l_inv_16_31.A sg13cmos5l_inv_16_20.A 0.04714f
C452 sg13cmos5l_and2_1_7.A en[6] 0.05675f
C453 sg13cmos5l_inv_2_4.A a_23368_2514# 0.04511f
C454 sg13cmos5l_inv_16_1.A VPWR 4.26049f
C455 sg13cmos5l_and2_1_7.A sg13cmos5l_inv_4_0.Y 0.01766f
C456 sg13cmos5l_inv_8_4.A sg13cmos5l_inv_16_22.A 0.01387f
C457 en[4] VPWR 0.21578f
C458 a_24334_2571# VPWR 0.25346f
C459 sg13cmos5l_inv_1_1.A a_5120_4097# 0.16128f
C460 sg13cmos5l_xnor2_1_3.B a_24576_1185# 0.43042f
C461 a_14240_4097# sg13cmos5l_and2_1_2.B 0.44911f
C462 en[2] a_10208_4026# 0.05968f
C463 a_2816_4026# en[0] 0.05843f
C464 sg13cmos5l_inv_1_2.A sg13cmos5l_inv_2_3.Y 0.02391f
C465 sg13cmos5l_and2_1_7.A sg13cmos5l_inv_4_7.A 0.06445f
C466 a_26991_3108# sg13cmos5l_inv_1_8.A 0.05344f
C467 a_10024_1002# sg13cmos5l_inv_16_0.A 0.01121f
C468 sg13cmos5l_inv_16_2.A sg13cmos5l_inv_16_0.A 0.95046f
C469 sg13cmos5l_xnor2_1_3.Y a_26165_2386# 0.02264f
C470 sg13cmos5l_inv_16_26.A sg13cmos5l_inv_16_20.A 0.01509f
C471 a_28552_3230# VPWR 0.13128f
C472 a_6284_3858# en[1] 0.32651f
C473 a_26261_2002# sg13cmos5l_xnor2_1_0.Y 0.05828f
C474 sg13cmos5l_inv_16_11.Y VPWR 2.6805f
C475 sg13cmos5l_xnor2_1_6.A a_25112_1673# 0.02571f
C476 sg13cmos5l_inv_8_7.A VPWR 1.51532f
C477 sg13cmos5l_inv_8_1.A sg13cmos5l_inv_2_3.Y 0.59322f
C478 sg13cmos5l_inv_1_2.A sg13cmos5l_inv_2_3.A 0.09456f
C479 a_24040_1718# VPWR 0.15218f
C480 a_17800_2514# sg13cmos5l_inv_8_6.A 0.01168f
C481 a_27686_874# a_27798_938# 0.67711f
C482 a_24910_3411# a_25025_3410# 0.67711f
C483 sg13cmos5l_inv_1_7.A a_28552_3230# 0.06604f
C484 sg13cmos5l_inv_16_14.A sg13cmos5l_inv_16_1.A 0.96654f
C485 a_26880_1671# sg13cmos5l_xnor2_1_1.Y 0.23198f
C486 sg13cmos5l_xnor2_1_6.Y a_26165_2386# 0.01134f
C487 sg13cmos5l_inv_1_1.A VPWR 0.43498f
C488 a_19616_4097# a_19424_4026# 0.02877f
C489 a_28936_1718# a_28936_1002# 0.01275f
C490 sg13cmos5l_inv_8_1.A sg13cmos5l_inv_2_3.A 0.0122f
C491 a_9932_3858# sg13cmos5l_inv_4_0.Y 0.01472f
C492 sg13cmos5l_and2_1_7.A sg13cmos5l_dlygate4sd3_1_0.A 0.0132f
C493 sg13cmos5l_xnor2_1_3.Y a_26016_2697# 0.44453f
C494 sg13cmos5l_inv_4_4.A sg13cmos5l_inv_8_6.A 0.0154f
C495 sg13cmos5l_dlygate4sd3_1_4.X a_27686_874# 0.03939f
C496 sg13cmos5l_inv_16_1.Y sg13cmos5l_inv_16_1.A 1.03147f
C497 a_26259_2680# VPWR 0.01234f
C498 sg13cmos5l_dlygate4sd3_1_0.A a_24449_2572# 0.01742f
C499 sg13cmos5l_inv_16_19.A a_20488_1002# 0.01513f
C500 sg13cmos5l_and2_1_5.B sg13cmos5l_inv_1_6.A 0.01877f
C501 sg13cmos5l_inv_2_5.A sg13cmos5l_inv_16_25.Y 0.02067f
C502 a_25306_3108# sg13cmos5l_dlygate4sd3_1_0.A 0.01315f
C503 en[7] VPWR 0.22696f
C504 sg13cmos5l_and2_1_7.A sg13cmos5l_inv_1_3.A 0.0274f
C505 a_25112_1673# VPWR 0.33232f
C506 sg13cmos5l_inv_8_1.A sg13cmos5l_inv_16_15.A 1.00951f
C507 sg13cmos5l_xnor2_1_3.A a_24320_1002# 0.03833f
C508 sg13cmos5l_xnor2_1_6.Y a_26016_2697# 0.18645f
C509 a_18656_2514# VPWR 0.0887f
C510 a_24520_3230# VPWR 0.12379f
C511 a_27599_2002# sg13cmos5l_dlygate4sd3_1_4.X 0.01213f
C512 a_8008_1002# VPWR 0.15001f
C513 sg13cmos5l_and2_1_7.A sg13cmos5l_xnor2_1_6.A 1.98707f
C514 sg13cmos5l_inv_4_4.A sg13cmos5l_inv_8_4.A 0.56914f
C515 sg13cmos5l_inv_16_4.Y VPWR 2.92568f
C516 sg13cmos5l_inv_8_7.A sg13cmos5l_inv_16_23.A 0.03698f
C517 a_26880_1671# a_27564_1898# 0.03782f
C518 a_24576_1185# VPWR 0.29216f
C519 a_5120_4097# sg13cmos5l_and2_1_7.A 0.34702f
C520 sg13cmos5l_inv_16_23.Y sg13cmos5l_inv_16_25.Y 0.88095f
C521 sg13cmos5l_inv_1_4.A sg13cmos5l_inv_1_4.Y 0.10166f
C522 a_16264_3932# sg13cmos5l_and2_1_4.B 0.29212f
C523 a_24518_1632# a_24630_1656# 0.67711f
C524 a_25958_874# VPWR 0.24257f
C525 sg13cmos5l_inv_4_0.Y sg13cmos5l_inv_16_15.A 0.04768f
C526 sg13cmos5l_inv_1_6.A VPWR 0.52265f
C527 sg13cmos5l_xnor2_1_6.Y sg13cmos5l_xnor2_1_3.Y 0.59381f
C528 en[4] sg13cmos5l_inv_1_4.Y 0.06921f
C529 a_27798_938# VPWR 0.22192f
C530 a_25306_3108# sg13cmos5l_xnor2_1_6.A 0.52808f
C531 sg13cmos5l_and2_1_7.A sg13cmos5l_and2_1_5.B 0.42756f
C532 sg13cmos5l_inv_4_2.A sg13cmos5l_inv_16_18.A 0.02301f
C533 a_26880_2697# a_27029_2386# 0.3658f
C534 a_6952_1718# VPWR 0.19326f
C535 sg13cmos5l_inv_16_29.Y VPWR 6.45859f
C536 sg13cmos5l_dlygate4sd3_1_3.X a_26552_874# 0.59996f
C537 sg13cmos5l_dlygate4sd3_1_1.X sg13cmos5l_xnor2_1_3.B 0.0622f
C538 sg13cmos5l_xnor2_1_1.B sg13cmos5l_xnor2_1_2.B 0.06514f
C539 sg13cmos5l_inv_8_7.A sg13cmos5l_inv_16_28.A 0.90039f
C540 a_24520_3230# sg13cmos5l_inv_16_24.A 0.01109f
C541 sg13cmos5l_inv_16_13.A sg13cmos5l_inv_16_9.Y 0.29671f
C542 a_23272_3230# a_23456_3230# 0.11523f
C543 a_23648_3403# sg13cmos5l_and2_1_7.B 0.41215f
C544 sg13cmos5l_dlygate4sd3_1_1.X a_25568_1002# 0.07232f
C545 sg13cmos5l_inv_16_10.Y VPWR 2.68651f
C546 sg13cmos5l_inv_4_0.Y sg13cmos5l_inv_16_0.A 1.09964f
C547 a_28160_4097# VPWR 0.44979f
C548 sg13cmos5l_inv_16_27.A VPWR 4.34817f
C549 sg13cmos5l_dlygate4sd3_1_3.X a_26355_1632# 0.01298f
C550 sg13cmos5l_dlygate4sd3_1_4.X VPWR 0.74441f
C551 sg13cmos5l_inv_16_29.A a_13472_1718# 0.03438f
C552 sg13cmos5l_inv_16_5.Y VPWR 4.15298f
C553 sg13cmos5l_xnor2_1_1.Y a_27029_2386# 0.02524f
C554 sg13cmos5l_xnor2_1_5.Y a_27029_2386# 0.04203f
C555 sg13cmos5l_inv_4_0.A VPWR 0.90047f
C556 en[7] a_28936_4026# 0.06311f
C557 sg13cmos5l_and2_1_7.A VPWR 3.84399f
C558 a_24334_2571# sg13cmos5l_xnor2_1_3.A 0.20222f
C559 sg13cmos5l_inv_2_7.Y VPWR 0.89678f
C560 a_24449_2572# VPWR 0.28828f
C561 a_23456_3230# VPWR 0.06716f
C562 osc VPWR 0.34557f
C563 sg13cmos5l_inv_16_21.A sg13cmos5l_inv_16_21.Y 0.87978f
C564 sg13cmos5l_and2_1_7.A a_9357_3940# 0.16137f
C565 sg13cmos5l_inv_16_21.Y VPWR 2.69795f
C566 sg13cmos5l_and2_1_7.A sg13cmos5l_inv_1_7.A 0.05419f
C567 sg13cmos5l_inv_16_16.A VPWR 4.11267f
C568 sg13cmos5l_xnor2_1_4.Y a_27029_2386# 0.01134f
C569 sg13cmos5l_inv_2_1.A sg13cmos5l_inv_2_2.A 0.08034f
C570 sg13cmos5l_inv_16_12.A sg13cmos5l_inv_1_1.A 0.0144f
C571 sg13cmos5l_and2_1_1.B a_5709_3940# 0.34891f
C572 a_24630_1656# sg13cmos5l_xnor2_1_3.B 0.24197f
C573 a_25306_3108# VPWR 0.39723f
C574 a_20488_1002# a_20672_1002# 0.11523f
C575 sg13cmos5l_inv_16_27.A sg13cmos5l_inv_16_24.A 0.89546f
C576 sg13cmos5l_inv_1_5.A sg13cmos5l_and2_1_7.B 0.04062f
C577 a_26344_3230# a_26528_3230# 0.11523f
C578 VPWR a_14240_4097# 0.45489f
C579 sg13cmos5l_inv_1_7.A osc 0.01123f
C580 sg13cmos5l_inv_4_6.Y VPWR 1.39422f
C581 sg13cmos5l_inv_2_0.A sg13cmos5l_inv_4_0.Y 0.55215f
C582 a_24040_1718# sg13cmos5l_xnor2_1_3.A 0.07756f
C583 a_26528_3230# VPWR 0.06835f
C584 sg13cmos5l_inv_2_1.A sg13cmos5l_inv_4_2.A 0.16674f
C585 a_26112_1671# a_26261_2002# 0.3658f
C586 sg13cmos5l_and2_1_7.A sg13cmos5l_and2_1_3.B 0.33707f
C587 sg13cmos5l_and2_1_7.A sg13cmos5l_inv_16_24.A 0.02282f
C588 sg13cmos5l_and2_1_7.A sg13cmos5l_inv_4_8.A 0.04419f
C589 sg13cmos5l_inv_16_14.A sg13cmos5l_and2_1_7.A 0.01988f
C590 sg13cmos5l_inv_16_8.A VPWR 4.07207f
C591 sg13cmos5l_inv_4_1.A sg13cmos5l_inv_2_2.A 0.197f
C592 sg13cmos5l_inv_16_24.A sg13cmos5l_inv_2_7.Y 0.70847f
C593 a_16736_4097# sg13cmos5l_inv_1_4.A 0.12925f
C594 a_27416_874# a_27686_874# 0.33585f
C595 sg13cmos5l_inv_16_27.A sg13cmos5l_inv_16_23.A 0.93451f
C596 a_26344_3230# sg13cmos5l_inv_1_8.Y 0.01926f
C597 sg13cmos5l_inv_4_8.A sg13cmos5l_inv_2_7.Y 0.01796f
C598 a_15688_4026# a_15872_4026# 0.11523f
C599 sg13cmos5l_inv_16_2.A sg13cmos5l_inv_1_0.A 0.01628f
C600 VPWR sg13cmos5l_inv_2_3.Y 0.75021f
C601 sg13cmos5l_inv_1_8.Y VPWR 0.49423f
C602 VPWR a_9932_3858# 0.29241f
C603 sg13cmos5l_xnor2_1_6.Y a_25397_2386# 0.04203f
C604 a_5120_4097# a_5512_4026# 0.01796f
C605 sg13cmos5l_inv_2_4.A sg13cmos5l_inv_4_7.A 0.65353f
C606 a_3488_3230# VPWR 0.07459f
C607 sg13cmos5l_inv_4_1.A sg13cmos5l_inv_4_2.A 0.05719f
C608 sg13cmos5l_inv_16_20.A sg13cmos5l_inv_16_21.Y 0.02182f
C609 sg13cmos5l_dlygate4sd3_1_1.X a_26112_1671# 0.17113f
C610 sg13cmos5l_xnor2_1_3.Y a_25688_874# 0.02445f
C611 sg13cmos5l_and2_1_7.A sg13cmos5l_inv_16_23.A 0.03006f
C612 sg13cmos5l_dlygate4sd3_1_1.X VPWR 0.77765f
C613 sg13cmos5l_inv_4_2.Y sg13cmos5l_inv_16_8.A 0.06551f
C614 sg13cmos5l_and2_1_7.A sg13cmos5l_xnor2_1_5.Y 0.03762f
C615 a_2920_3932# sg13cmos5l_buf_1_1.X 0.29531f
C616 sg13cmos5l_xnor2_1_3.Y a_26070_938# 0.03647f
C617 sg13cmos5l_and2_1_6.B sg13cmos5l_inv_1_8.A 0.0175f
C618 a_9357_3940# a_9932_3858# 0.02706f
C619 sg13cmos5l_inv_16_24.A sg13cmos5l_inv_4_6.Y 0.82322f
C620 sg13cmos5l_xnor2_1_5.Y sg13cmos5l_inv_2_7.Y 0.01552f
C621 sg13cmos5l_dlygate4sd3_1_4.X a_26934_938# 0.233f
C622 sg13cmos5l_inv_16_26.A sg13cmos5l_inv_16_31.A 0.96095f
C623 a_3304_3230# a_3488_3230# 0.11523f
C624 a_24449_2572# a_24248_1673# 0.01258f
C625 VPWR sg13cmos5l_inv_2_3.A 0.86343f
C626 a_25491_2680# VPWR 0.01064f
C627 sg13cmos5l_inv_16_1.Y sg13cmos5l_inv_16_16.A 0.02534f
C628 sg13cmos5l_xnor2_1_2.B a_27686_874# 0.01992f
C629 a_28936_1718# a_29120_1718# 0.11523f
C630 a_25494_1656# sg13cmos5l_dlygate4sd3_1_1.X 0.24795f
C631 sg13cmos5l_inv_16_6.A sg13cmos5l_inv_16_8.A 1.03975f
C632 sg13cmos5l_inv_4_1.Y sg13cmos5l_and2_1_7.A 0.02224f
C633 a_27123_2680# VPWR 0.01234f
C634 sg13cmos5l_inv_16_13.A VPWR 4.38974f
C635 sg13cmos5l_xnor2_1_3.A a_24576_1185# 0.12926f
C636 sg13cmos5l_and2_1_3.B a_9932_3858# 0.2919f
C637 sg13cmos5l_inv_16_24.A sg13cmos5l_inv_1_8.Y 0.10052f
C638 sg13cmos5l_inv_16_31.A sg13cmos5l_inv_1_4.A 0.01416f
C639 a_5512_4026# VPWR 0.13512f
C640 VPWR sg13cmos5l_inv_16_15.A 2.86312f
C641 a_29120_4026# VPWR 0.05569f
C642 sg13cmos5l_inv_16_19.A a_21632_1718# 0.04361f
C643 sg13cmos5l_inv_2_4.A sg13cmos5l_dlygate4sd3_1_0.A 0.02075f
C644 sg13cmos5l_inv_16_23.Y sg13cmos5l_inv_8_7.A 0.01356f
C645 a_19528_1718# sg13cmos5l_inv_16_22.A 0.01577f
C646 sg13cmos5l_and2_1_7.A sg13cmos5l_inv_1_4.Y 2.08675f
C647 a_27564_1898# sg13cmos5l_dlygate4sd3_1_4.X 0.13415f
C648 a_20488_1002# VPWR 0.13366f
C649 a_24910_3411# sg13cmos5l_and2_1_7.A 0.0125f
C650 a_24630_1656# VPWR 0.21853f
C651 sg13cmos5l_inv_16_12.A sg13cmos5l_and2_1_7.A 0.01854f
C652 sg13cmos5l_xnor2_1_1.B a_27123_1632# 0.01016f
C653 sg13cmos5l_inv_2_2.A sg13cmos5l_inv_1_3.A 0.06242f
C654 sg13cmos5l_inv_16_7.A sg13cmos5l_inv_16_10.A 1.05126f
C655 sg13cmos5l_inv_16_26.A sg13cmos5l_inv_1_4.A 0.02194f
C656 sg13cmos5l_and2_1_7.B a_24032_3230# 0.01678f
C657 sg13cmos5l_xnor2_1_0.Y a_26822_874# 0.01314f
C658 a_27416_874# VPWR 0.33255f
C659 VPWR a_15688_4026# 0.13804f
C660 VPWR sg13cmos5l_inv_16_0.A 3.03736f
C661 sg13cmos5l_inv_2_0.A a_10016_2514# 0.03353f
C662 sg13cmos5l_inv_16_19.A sg13cmos5l_inv_16_22.A 0.98428f
C663 sg13cmos5l_dlygate4sd3_1_3.X a_25958_874# 0.02468f
C664 sg13cmos5l_inv_16_25.Y sg13cmos5l_inv_1_6.A 0.02927f
C665 a_19616_4097# sg13cmos5l_and2_1_5.B 0.33965f
C666 a_23944_2514# a_24128_2514# 0.11523f
C667 sg13cmos5l_inv_2_5.A a_18656_2514# 0.03491f
C668 a_28936_1718# VPWR 0.15577f
C669 sg13cmos5l_xnor2_1_4.Y sg13cmos5l_inv_1_8.Y 0.01274f
C670 sg13cmos5l_inv_16_14.A sg13cmos5l_inv_16_15.A 0.95643f
C671 en[4] sg13cmos5l_inv_1_4.A 0.06652f
C672 sg13cmos5l_inv_16_2.A sg13cmos5l_inv_16_3.Y 0.01125f
C673 sg13cmos5l_xnor2_1_0.Y sg13cmos5l_xnor2_1_3.Y 0.02352f
C674 sg13cmos5l_xnor2_1_1.Y a_27123_2680# 0.01001f
C675 a_8096_2514# VPWR 0.12566f
C676 sg13cmos5l_xnor2_1_3.A a_24449_2572# 0.01738f
C677 sg13cmos5l_xnor2_1_0.Y a_27029_2002# 0.02362f
C678 sg13cmos5l_xnor2_1_2.B VPWR 0.68818f
C679 a_4640_4026# VPWR 0.08708f
C680 sg13cmos5l_buf_1_1.X a_5120_4097# 0.15397f
C681 sg13cmos5l_inv_2_5.A sg13cmos5l_inv_1_6.A 0.10792f
C682 sg13cmos5l_dlygate4sd3_1_3.X sg13cmos5l_dlygate4sd3_1_4.X 0.03988f
C683 a_28936_4026# a_29120_4026# 0.11523f
C684 sg13cmos5l_inv_4_0.Y sg13cmos5l_inv_1_0.A 0.41209f
C685 a_23648_3403# VPWR 0.45548f
C686 sg13cmos5l_inv_16_14.A sg13cmos5l_inv_16_0.A 0.1797f
C687 a_23944_2514# VPWR 0.14604f
C688 a_19616_4097# VPWR 0.48375f
C689 sg13cmos5l_inv_16_2.A a_10024_1002# 0.0482f
C690 sg13cmos5l_inv_16_12.A a_3488_3230# 0.03438f
C691 sg13cmos5l_inv_16_25.Y sg13cmos5l_and2_1_7.A 0.07348f
C692 sg13cmos5l_inv_2_0.A VPWR 1.17434f
C693 sg13cmos5l_inv_2_2.A VPWR 0.69648f
C694 sg13cmos5l_inv_16_23.Y sg13cmos5l_inv_1_6.A 0.05965f
C695 sg13cmos5l_xnor2_1_3.B a_24819_1168# 0.01298f
C696 sg13cmos5l_inv_1_5.A a_23272_3230# 0.05468f
C697 en[3] a_14732_3858# 0.32678f
C698 sg13cmos5l_inv_4_1.Y a_5512_4026# 0.0111f
C699 sg13cmos5l_inv_8_6.A VPWR 1.43691f
C700 sg13cmos5l_inv_2_4.A VPWR 0.885f
C701 a_28940_3108# a_28736_3230# 0.03376f
C702 a_6284_3858# sg13cmos5l_inv_1_3.A 0.0237f
C703 sg13cmos5l_inv_16_18.A sg13cmos5l_inv_16_2.A 0.02672f
C704 sg13cmos5l_and2_1_7.A a_16736_4097# 0.15629f
C705 sg13cmos5l_inv_4_2.A VPWR 1.00867f
C706 sg13cmos5l_inv_16_13.A sg13cmos5l_inv_16_12.A 0.88388f
C707 sg13cmos5l_buf_1_1.X VPWR 0.46772f
C708 a_20588_3858# a_20384_4026# 0.03376f
C709 a_24236_3108# a_24520_3230# 0.01225f
C710 en[3] sg13cmos5l_and2_1_2.B 0.04178f
C711 sg13cmos5l_xnor2_1_6.A a_26991_3108# 0.1317f
C712 sg13cmos5l_inv_16_5.A sg13cmos5l_inv_16_29.A 0.01592f
C713 sg13cmos5l_inv_4_5.A VPWR 0.79151f
C714 sg13cmos5l_and2_1_7.A a_5709_3940# 0.16137f
C715 sg13cmos5l_and2_1_7.A en[2] 0.76047f
C716 sg13cmos5l_inv_1_5.A VPWR 0.43311f
C717 sg13cmos5l_inv_16_14.A sg13cmos5l_inv_2_0.A 0.02916f
C718 sg13cmos5l_xnor2_1_3.Y sg13cmos5l_xnor2_1_3.B 0.14999f
C719 sg13cmos5l_inv_8_4.A sg13cmos5l_inv_16_21.A 0.16137f
C720 sg13cmos5l_inv_16_23.Y sg13cmos5l_and2_1_7.A 0.06308f
C721 sg13cmos5l_and2_1_7.A a_25025_3410# 0.01842f
C722 sg13cmos5l_inv_8_4.A VPWR 1.55284f
C723 sg13cmos5l_inv_4_2.A sg13cmos5l_inv_4_2.Y 0.78035f
C724 sg13cmos5l_inv_16_13.A sg13cmos5l_inv_16_9.A 1.04368f
C725 sg13cmos5l_and2_1_6.B a_28652_3858# 0.29274f
C726 sg13cmos5l_and2_1_5.B a_20384_4026# 0.01398f
C727 sg13cmos5l_xnor2_1_6.A sg13cmos5l_inv_1_8.A 0.03946f
C728 sg13cmos5l_dlygate4sd3_1_1.X sg13cmos5l_dlygate4sd3_1_3.X 0.65878f
C729 en[1] sg13cmos5l_inv_1_3.A 0.01834f
C730 sg13cmos5l_and2_1_4.B VPWR 0.2264f
C731 sg13cmos5l_and2_1_7.A sg13cmos5l_and2_1_1.B 0.33707f
C732 a_25306_3108# a_25025_3410# 0.33585f
C733 a_13472_1718# VPWR 0.07488f
C734 sg13cmos5l_inv_4_2.A sg13cmos5l_inv_16_6.A 0.42675f
C735 sg13cmos5l_dlygate4sd3_1_0.A sg13cmos5l_xnor2_1_6.Y 0.06311f
C736 sg13cmos5l_inv_16_9.Y a_2632_4026# 0.04297f
C737 sg13cmos5l_xnor2_1_3.A a_24630_1656# 0.04973f
C738 sg13cmos5l_xnor2_1_3.A a_24725_874# 0.01078f
C739 a_6284_3858# VPWR 0.33833f
C740 a_20384_4026# VPWR 0.11564f
C741 a_26991_3108# VPWR 0.57828f
C742 sg13cmos5l_and2_1_7.A a_9248_4026# 0.0494f
C743 sg13cmos5l_inv_8_4.A sg13cmos5l_inv_16_20.A 0.90127f
C744 a_17320_1002# VPWR 0.18803f
C745 a_24236_3108# sg13cmos5l_and2_1_7.A 0.02019f
C746 sg13cmos5l_inv_16_26.A sg13cmos5l_and2_1_7.A 0.02015f
C747 sg13cmos5l_inv_4_1.Y sg13cmos5l_inv_2_2.A 0.09185f
C748 a_27564_1898# sg13cmos5l_xnor2_1_2.B 0.44467f
C749 en[2] a_9932_3858# 0.32646f
C750 sg13cmos5l_xnor2_1_6.A sg13cmos5l_xnor2_1_6.Y 0.05699f
C751 a_25382_1632# sg13cmos5l_xnor2_1_3.B 0.01133f
C752 a_3488_1002# sg13cmos5l_inv_16_8.A 0.03443f
C753 a_26822_874# VPWR 0.24643f
C754 a_6080_1002# sg13cmos5l_inv_4_2.A 0.0419f
C755 a_5408_1002# VPWR 0.08157f
C756 sg13cmos5l_inv_16_2.A sg13cmos5l_inv_4_0.Y 0.07416f
C757 sg13cmos5l_inv_1_8.A VPWR 0.39963f
C758 a_26016_2697# VPWR 0.29706f
C759 sg13cmos5l_inv_16_1.A sg13cmos5l_inv_4_0.A 0.01627f
C760 sg13cmos5l_inv_4_1.Y sg13cmos5l_inv_4_2.A 0.01554f
C761 sg13cmos5l_and2_1_7.A sg13cmos5l_inv_1_4.A 0.0255f
C762 sg13cmos5l_inv_16_16.A sg13cmos5l_inv_16_18.Y 0.01057f
C763 sg13cmos5l_inv_8_4.A a_18472_1002# 0.04443f
C764 a_21632_1718# VPWR 0.08498f
C765 sg13cmos5l_inv_16_12.A sg13cmos5l_inv_2_2.A 0.20729f
C766 sg13cmos5l_and2_1_7.A en[4] 0.07239f
C767 en[1] VPWR 0.24034f
C768 sg13cmos5l_inv_8_6.A sg13cmos5l_inv_1_4.Y 0.34203f
C769 sg13cmos5l_inv_1_8.Y a_26048_4026# 0.03405f
C770 VPWR a_13472_4026# 0.06941f
C771 a_26112_1671# sg13cmos5l_xnor2_1_3.Y 0.04773f
C772 VPWR sg13cmos5l_inv_1_0.A 0.97219f
C773 sg13cmos5l_xnor2_1_3.Y VPWR 0.91321f
C774 a_24334_2571# a_24449_2572# 0.67711f
C775 a_24032_3230# VPWR 0.07864f
C776 sg13cmos5l_inv_16_1.A sg13cmos5l_inv_16_16.A 0.05669f
C777 sg13cmos5l_inv_16_21.A sg13cmos5l_inv_16_22.A 1.04117f
C778 sg13cmos5l_inv_16_20.A a_17320_1002# 0.01968f
C779 sg13cmos5l_inv_16_22.A VPWR 4.0429f
C780 sg13cmos5l_inv_16_12.A sg13cmos5l_buf_1_1.X 0.01279f
C781 a_5709_3940# a_5512_4026# 0.01796f
C782 sg13cmos5l_and2_1_2.B a_14732_3858# 0.29274f
C783 sg13cmos5l_inv_1_2.A sg13cmos5l_and2_1_2.B 0.01398f
C784 sg13cmos5l_inv_8_1.A sg13cmos5l_inv_1_2.A 1.1436f
C785 a_9357_3940# sg13cmos5l_inv_1_0.A 0.12864f
C786 sg13cmos5l_inv_4_5.A sg13cmos5l_inv_1_4.Y 0.85922f
C787 sg13cmos5l_inv_4_8.A sg13cmos5l_inv_1_8.A 0.03157f
C788 a_26991_3108# sg13cmos5l_xnor2_1_1.Y 0.01031f
C789 a_26991_3108# sg13cmos5l_xnor2_1_5.Y 0.39668f
C790 sg13cmos5l_inv_2_1.A sg13cmos5l_inv_16_17.Y 0.04151f
C791 sg13cmos5l_xnor2_1_4.Y a_26165_2386# 0.04203f
C792 a_26016_2697# a_26624_2514# 0.0358f
C793 sg13cmos5l_xnor2_1_6.Y VPWR 0.76828f
C794 sg13cmos5l_dlygate4sd3_1_0.A a_24704_3230# 0.01243f
C795 sg13cmos5l_xnor2_1_0.Y sg13cmos5l_xnor2_1_1.B 0.57125f
C796 a_24518_1632# a_24730_2350# 0.01258f
C797 a_23368_2514# VPWR 0.16785f
C798 sg13cmos5l_inv_1_1.A sg13cmos5l_and2_1_7.A 0.03401f
C799 sg13cmos5l_buf_1_1.X en[0] 0.05969f
C800 en[2] sg13cmos5l_inv_16_0.A 0.01082f
C801 sg13cmos5l_and2_1_3.B sg13cmos5l_inv_1_0.A 0.35635f
C802 sg13cmos5l_and2_1_7.B en[6] 0.04268f
C803 VPWR VGND 0.10012p
C804 a_29120_1002# VGND 0.07556f ; **FLOATING
C805 a_28936_1002# VGND 0.12289f ; **FLOATING
C806 a_27798_938# VGND 0.08224f
C807 a_26934_938# VGND 0.08287f
C808 a_26070_938# VGND 0.09044f
C809 a_25568_1002# VGND 0.05953f ; **FLOATING
C810 a_24725_874# VGND 0.20535f
C811 a_24539_916# VGND 0.1312f
C812 a_24819_1168# VGND 0.44664f
C813 a_24320_1002# VGND 0.06189f ; **FLOATING
C814 a_24576_1185# VGND 0.04675f
C815 a_20672_1002# VGND 0.03867f ; **FLOATING
C816 a_20488_1002# VGND 0.07896f ; **FLOATING
C817 a_18472_1002# VGND 0.08488f ; **FLOATING
C818 a_17320_1002# VGND 0.10093f ; **FLOATING
C819 a_14336_1002# VGND 0.06042f ; **FLOATING
C820 a_10024_1002# VGND 0.08456f ; **FLOATING
C821 a_8008_1002# VGND 0.08507f ; **FLOATING
C822 sg13cmos5l_inv_16_18.Y VGND 5.42996f
C823 a_6080_1002# VGND 0.0439f ; **FLOATING
C824 a_5408_1002# VGND 0.0434f ; **FLOATING
C825 a_3488_1002# VGND 0.04841f ; **FLOATING
C826 a_3304_1002# VGND 0.16159f ; **FLOATING
C827 sg13cmos5l_inv_16_10.Y VGND 5.56455f
C828 a_29120_1718# VGND 0.07537f ; **FLOATING
C829 a_28936_1718# VGND 0.11786f ; **FLOATING
C830 a_27123_1632# VGND 0.18839f
C831 a_26355_1632# VGND 0.13591f
C832 a_28020_1980# VGND 0.33774f
C833 a_27599_2002# VGND 0.69876f
C834 a_27029_2002# VGND 0.43665f
C835 a_26843_1980# VGND 0.25523f
C836 sg13cmos5l_xnor2_1_0.Y VGND 0.07783f
C837 a_26261_2002# VGND 0.72986f
C838 a_26075_1980# VGND 0.05514f
C839 a_24040_1718# VGND 0.14609f ; **FLOATING
C840 a_24518_1632# VGND 0.17852f
C841 a_21632_1718# VGND 0.04176f ; **FLOATING
C842 a_19712_1718# VGND 0.03812f ; **FLOATING
C843 a_19528_1718# VGND 0.07389f ; **FLOATING
C844 sg13cmos5l_inv_16_21.Y VGND 5.34766f
C845 a_17600_1718# VGND 0.04213f ; **FLOATING
C846 a_13472_1718# VGND 0.0474f ; **FLOATING
C847 a_13288_1718# VGND 0.1605f ; **FLOATING
C848 sg13cmos5l_inv_16_3.Y VGND 5.55885f
C849 a_6952_1718# VGND 0.10034f ; **FLOATING
C850 a_3680_1718# VGND 0.0608f ; **FLOATING
C851 a_27029_2386# VGND 0.59826f
C852 a_26843_2428# VGND 0.36807f
C853 a_27123_2680# VGND 0.07297f
C854 a_26624_2514# VGND 0.04477f ; **FLOATING
C855 a_26165_2386# VGND 0.32322f
C856 a_25397_2386# VGND 1.17595f
C857 a_26259_2680# VGND 0.24108f
C858 a_25211_2428# VGND 0.07851f
C859 a_26880_2697# VGND 0.03723f
C860 sg13cmos5l_xnor2_1_3.Y VGND 0.03849f
C861 a_24128_2514# VGND 0.03937f ; **FLOATING
C862 a_23944_2514# VGND 0.08175f ; **FLOATING
C863 a_23368_2514# VGND 0.15595f ; **FLOATING
C864 sg13cmos5l_inv_8_7.A VGND 0.08259f
C865 a_22016_2514# VGND 0.04689f ; **FLOATING
C866 a_18656_2514# VGND 0.0481f ; **FLOATING
C867 a_17984_2514# VGND 0.03787f ; **FLOATING
C868 a_17800_2514# VGND 0.119f ; **FLOATING
C869 sg13cmos5l_inv_16_4.Y VGND 5.79958f
C870 a_10016_2514# VGND 0.0432f ; **FLOATING
C871 a_8096_2514# VGND 0.05902f ; **FLOATING
C872 a_5312_2514# VGND 0.08532f ; **FLOATING
C873 a_28736_3230# VGND 0.04022f ; **FLOATING
C874 a_28552_3230# VGND 0.09747f ; **FLOATING
C875 a_26528_3230# VGND 0.03971f ; **FLOATING
C876 a_26344_3230# VGND 0.12131f ; **FLOATING
C877 sg13cmos5l_inv_1_7.A VGND 0.25875f
C878 sg13cmos5l_xnor2_1_5.Y VGND 0.07297f
C879 a_24704_3230# VGND 0.03884f ; **FLOATING
C880 a_24520_3230# VGND 0.07688f ; **FLOATING
C881 sg13cmos5l_dlygate4sd3_1_0.A VGND 0.04754f
C882 a_24032_3230# VGND 0.04356f ; **FLOATING
C883 a_23785_3492# VGND 0.21522f
C884 a_23456_3230# VGND 0.04489f ; **FLOATING
C885 a_23272_3230# VGND 0.11015f ; **FLOATING
C886 sg13cmos5l_inv_2_4.A VGND 0.07411f
C887 sg13cmos5l_inv_16_25.Y VGND 5.93704f
C888 sg13cmos5l_inv_2_5.A VGND 0.0942f
C889 sg13cmos5l_inv_16_17.Y VGND 5.54115f
C890 sg13cmos5l_inv_2_1.A VGND 0.61858f
C891 a_3488_3230# VGND 0.04763f ; **FLOATING
C892 a_3304_3230# VGND 0.15851f ; **FLOATING
C893 a_29120_4026# VGND 0.07929f ; **FLOATING
C894 a_28936_4026# VGND 0.09426f ; **FLOATING
C895 a_28297_3940# VGND 0.20743f
C896 a_26048_4026# VGND 0.09018f ; **FLOATING
C897 a_23368_4026# VGND 0.16127f ; **FLOATING
C898 a_20384_4026# VGND 0.06487f ; **FLOATING
C899 a_19753_3940# VGND 0.45066f
C900 a_19424_4026# VGND 0.09053f ; **FLOATING
C901 a_19616_4097# VGND 0.1582f
C902 a_15872_4026# VGND 0.0431f ; **FLOATING
C903 a_15688_4026# VGND 0.13616f ; **FLOATING
C904 a_14377_3940# VGND 0.07879f
C905 a_13472_4026# VGND 0.04848f ; **FLOATING
C906 a_13288_4026# VGND 0.10743f ; **FLOATING
C907 sg13cmos5l_inv_1_4.A VGND 0.24136f
C908 a_14732_3858# VGND 0.54107f
C909 a_10208_4026# VGND 0.04674f ; **FLOATING
C910 a_9451_3940# VGND 0.01009f
C911 a_9248_4026# VGND 0.0896f ; **FLOATING
C912 a_5803_3940# VGND 0.19046f
C913 sg13cmos5l_inv_1_2.A VGND 0.16096f
C914 sg13cmos5l_inv_4_0.Y VGND 0.1229f
C915 a_9357_3940# VGND 0.34545f
C916 a_5512_4026# VGND 0.0968f ; **FLOATING
C917 a_5257_3940# VGND 6.44802f
C918 a_5120_4097# VGND 1.399f
C919 a_4640_4026# VGND 0.09122f ; **FLOATING
C920 sg13cmos5l_inv_2_2.A VGND 0.03483f
C921 a_2816_4026# VGND 0.03836f ; **FLOATING
C922 a_2632_4026# VGND 0.08599f ; **FLOATING
C923 sg13cmos5l_inv_16_11.Y VGND 5.96829f
C924 VGND.t307 VGND 1.66441f
C925 VGND.t20 VGND 0.74907f
C926 VGND.t535 VGND 6.28283f
C927 VGND.t119 VGND 0.1409f
C928 VGND.t167 VGND 0.33036f
C929 VGND.t786 VGND 2.10168f
C930 VGND.t269 VGND 0.02291f
C931 VGND.t69 VGND 3.60057f
C932 VGND.t66 VGND 1.85414f
C933 VGND.t780 VGND 1.36952f
C934 VGND.t325 VGND 1.47136f
C935 VGND.t324 VGND 0.27044f
C936 VGND.t359 VGND 0.36658f
C937 VGND.t188 VGND 0.26723f
C938 VGND.t64 VGND 0.35951f
C939 VGND.t773 VGND 0.053f
C940 VGND.t446 VGND 1.32026f
C941 VGND.t445 VGND 0.37329f
C942 VGND.t421 VGND 0.81417f
C943 VGND.t24 VGND 0.35219f
C944 VGND.t27 VGND 2.26584f
C945 VGND.t29 VGND 0.7025f
C946 VGND.t267 VGND 0.12433f
C947 VGND.t404 VGND 0.29242f
C948 VGND.t407 VGND 0.29242f
C949 VGND.t409 VGND 0.80775f
C950 VGND.t190 VGND 1.70323f
C951 VGND.t196 VGND 0.92219f
C952 VGND.t551 VGND 1.68696f
C953 VGND.t395 VGND 0.09421f
C954 VGND.t393 VGND 0.34869f
C955 VGND.t392 VGND 0.25489f
C956 VGND.t381 VGND 0.37732f
C957 VGND.t133 VGND 1.36877f
C958 VGND.t249 VGND 0.98972f
C959 VGND.t41 VGND 1.16526f
C960 VGND.t366 VGND 0.91849f
C961 VGND.t872 VGND 0.03895f
C962 VGND.t430 VGND 1.04812f
C963 VGND.t303 VGND 3.69604f
C964 VGND.t231 VGND 5.88551f
C965 VGND.t568 VGND 2.55482f
C966 VGND.t426 VGND 1.54926f
C967 VGND.t45 VGND 2.7732f
C968 VGND.t712 VGND 1.25559f
C969 VGND.t399 VGND 0.43647f
C970 VGND.t452 VGND 0.04522f
C971 VGND.t453 VGND 1.254f
C972 VGND.t455 VGND 1.20878f
C973 VGND.t121 VGND 2.71736f
C974 VGND.t172 VGND 1.66441f
C975 VPWR.n0 VGND 11.2028f
C976 VPWR.n1 VGND 0.81135f
C977 VPWR.n2 VGND 6.98993f
C978 VPWR.n3 VGND 0.83109f
C979 VPWR.t446 VGND 0.0671f
C980 VPWR.t14 VGND 0.97099f
C981 VPWR.t18 VGND 31.4639f
C982 VPWR.n5 VGND 1.12194f
C983 VPWR.n6 VGND 1.41415f
C984 VPWR.n8 VGND 0.9233f
C985 VPWR.t569 VGND 0.42279f
C986 VPWR.n9 VGND 0.02036f
C987 VPWR.n10 VGND 0.05792f
C988 VPWR.n14 VGND 0.03824f
C989 VPWR.n15 VGND 0.35002f
C990 VPWR.t0 VGND 51.2721f
C991 VPWR.n18 VGND 0.05754f
C992 VPWR.n24 VGND 0.02506f
C993 VPWR.n27 VGND 0.08962f
C994 VPWR.n28 VGND 0.09962f
C995 VPWR.n29 VGND 0.09721f
C996 VPWR.n40 VGND 0.01906f
C997 VPWR.t20 VGND 46.9754f
C998 VPWR.n43 VGND 0.37577f
C999 VPWR.n48 VGND 0.1439f
C1000 VPWR.n58 VGND 0.02525f
C1001 VPWR.n60 VGND 0.01948f
C1002 VPWR.n61 VGND 0.61478f
C1003 VPWR.n62 VGND 0.13297f
C1004 VPWR.n63 VGND 0.71835f
C1005 VPWR.t254 VGND 0.38515f
C1006 VPWR.t366 VGND 3.78498f
C1007 VPWR.n64 VGND 0.12507f
C1008 VPWR.t181 VGND 0.56566f
C1009 VPWR.t174 VGND 2.28269f
C1010 VPWR.t403 VGND 0.50759f
C1011 VPWR.t396 VGND 3.32448f
C1012 VPWR.t586 VGND 1.42391f
C1013 VPWR.t78 VGND 4.08808f
C1014 VPWR.n65 VGND 0.63843f
C1015 VPWR.t46 VGND 4.08808f
C1016 VPWR.t42 VGND 0.76376f
C1017 VPWR.t17 VGND 0.04675f
C1018 VPWR.t115 VGND 1.71792f
C1019 VPWR.t116 VGND 0.46431f
C1020 VPWR.t262 VGND 1.44673f
C1021 VPWR.t166 VGND 0.14005f
C1022 VPWR.t164 VGND 2.87358f
C1023 VPWR.t168 VGND 0.13817f
C1024 VPWR.t170 VGND 0.53687f
C1025 VPWR.t172 VGND 0.16327f
C1026 VPWR.n66 VGND 0.03368f
C1027 VPWR.t566 VGND 6.93794f
C1028 VPWR.t839 VGND 0.42928f
C1029 VPWR.t35 VGND 0.57761f
C1030 VPWR.t729 VGND 0.3336f
C1031 VPWR.t522 VGND 0.71353f
C1032 VPWR.t521 VGND 1.73652f
C1033 VPWR.t794 VGND 0.29537f
C1034 VPWR.t520 VGND 0.08326f
C1035 VPWR.t388 VGND 0.19002f
C1036 VPWR.t524 VGND 0.93113f
C1037 VPWR.t389 VGND 0.5366f
C1038 VPWR.t391 VGND 0.20101f
C1039 VPWR.t215 VGND 1.5371f
C1040 VPWR.t300 VGND 0.18407f
C1041 VPWR.t216 VGND 1.37716f
C1042 VPWR.t248 VGND 0.14906f
C1043 VPWR.t247 VGND 2.10842f
C1044 VPWR.t253 VGND 0.21297f
C1045 VPWR.t251 VGND 0.13428f
C1046 VPWR.t222 VGND 0.18441f
C1047 VPWR.t221 VGND 0.18854f
C1048 VPWR.t224 VGND 0.19727f
C1049 VPWR.t226 VGND 1.93426f
C1050 VPWR.t625 VGND 0.13863f
C1051 VPWR.t230 VGND 0.13935f
C1052 VPWR.t234 VGND 2.76904f
C1053 VPWR.t232 VGND 1.07947f
C1054 VPWR.t631 VGND 0.13021f
C1055 VPWR.t479 VGND 0.16187f
C1056 VPWR.t480 VGND 0.17529f
C1057 VPWR.t121 VGND 0.13844f
C1058 VPWR.t637 VGND 0.13508f
C1059 VPWR.t122 VGND 0.16193f
C1060 VPWR.t126 VGND 0.70645f
C1061 VPWR.t124 VGND 0.16205f
C1062 VPWR.t128 VGND 0.14036f
C1063 VPWR.t130 VGND 0.1621f
C1064 VPWR.t132 VGND 0.16151f
C1065 VPWR.t849 VGND 2.69909f
C1066 VPWR.t134 VGND 0.66105f
C1067 VPWR.t617 VGND 0.64227f
C1068 VPWR.t489 VGND 0.7961f
C1069 VPWR.t487 VGND 2.0672f
C1070 VPWR.t118 VGND 1.08248f
C1071 VPWR.t143 VGND 0.43469f
C1072 VPWR.t146 VGND 2.34764f
C1073 VPWR.t422 VGND 0.04081f
C1074 VPWR.t421 VGND 2.01279f
C1075 VPWR.t508 VGND 0.34481f
C1076 VPWR.t510 VGND 0.15455f
C1077 VPWR.t665 VGND 0.41767f
C1078 VPWR.t663 VGND 0.15444f
C1079 VPWR.t512 VGND 0.17485f
C1080 VPWR.t667 VGND 0.19319f
C1081 VPWR.t669 VGND 0.09115f
C1082 VPWR.t61 VGND 1.73986f
C1083 VPWR.t60 VGND 0.29338f
C1084 VPWR.t303 VGND 1.34175f
C1085 VPWR.t727 VGND 0.53581f
C1086 VPWR.t65 VGND 0.2542f
C1087 VPWR.t40 VGND 0.26496f
C1088 VPWR.t345 VGND 0.23623f
C1089 VPWR.t352 VGND 1.57819f
C1090 VPWR.t350 VGND 1.79117f
C1091 VPWR.t348 VGND 0.12866f
C1092 VPWR.t356 VGND 0.19627f
C1093 VPWR.t358 VGND 0.18882f
C1094 VPWR.t530 VGND 1.59049f
C1095 VPWR.t854 VGND 0.69041f
C1096 VPWR.t536 VGND 0.26143f
C1097 VPWR.t532 VGND 1.64158f
C1098 VPWR.n67 VGND 0.3368f
C1099 VPWR.t678 VGND 0.43261f
C1100 VPWR.t58 VGND 2.88245f
C1101 VPWR.t68 VGND 1.61566f
C1102 VPWR.t218 VGND 1.61653f
C1103 VPWR.n68 VGND 0.10919f
C1104 VPWR.t156 VGND 6.293f
C1105 VPWR.n69 VGND 0.31608f
C1106 VPWR.t25 VGND 0.89979f
C1107 VPWR.n70 VGND 0.32208f
C1108 VPWR.t261 VGND 1.67401f
C1109 VPWR.t685 VGND 0.90361f
C1110 VPWR.n71 VGND 0.41548f
C1111 VPWR.t120 VGND 1.28045f
C1112 VPWR.t816 VGND 1.12726f
C1113 VPWR.t106 VGND 1.94958f
C1114 VPWR.n72 VGND 0.05148f
C1115 VPWR.n73 VGND 0.29777f
C1116 VPWR.t182 VGND 0.53556f
C1117 VPWR.t427 VGND 1.2792f
C1118 VPWR.t193 VGND 0.96519f
C1119 VPWR.n74 VGND 0.31341f
C1120 VPWR.t559 VGND 2.0143f
C1121 VPWR.t19 VGND 5.81149f
C1122 VPWR.n75 VGND 0.7805f
C1123 VPWR.n76 VGND 0.33502f
C1124 VPWR.t651 VGND 2.99142f
C1125 VPWR.t244 VGND 0.14734f
C1126 VPWR.t104 VGND 2.31444f
C1127 VPWR.n77 VGND 0.61887f
C1128 VPWR.n78 VGND 0.54916f
C1129 VPWR.t313 VGND 2.77353f
C1130 VPWR.n79 VGND 0.63807f
C1131 VPWR.t96 VGND 2.91871f
C1132 VPWR.n80 VGND 0.65334f
C1133 VPWR.t730 VGND 0.98955f
C1134 VPWR.t162 VGND 0.13863f
C1135 VPWR.t160 VGND 0.13863f
C1136 VPWR.t158 VGND 0.23717f
C1137 VPWR.t157 VGND 0.21011f
C1138 VPWR.t155 VGND 0.29998f
C1139 VPWR.t568 VGND 0.04365f
C1140 VPWR.t21 VGND 0.34666f
C1141 VPWR.t497 VGND 0.13374f
C1142 VPWR.t307 VGND 0.53405f
C1143 VPWR.t306 VGND 0.10677f
C1144 VPWR.t481 VGND 0.44859f
C1145 VPWR.n81 VGND 0.0599f
C1146 VPWR.t23 VGND 1.4548f
C1147 VPWR.t564 VGND 0.52477f
C1148 VPWR.t260 VGND 0.56147f
C1149 VPWR.t516 VGND 0.33205f
C1150 VPWR.t657 VGND 0.36182f
C1151 VPWR.t615 VGND 0.22276f
C1152 VPWR.t519 VGND 0.20644f
C1153 VPWR.t868 VGND 0.35667f
C1154 VPWR.t312 VGND 0.06094f
C1155 VPWR.t242 VGND 0.24543f
C1156 VPWR.t423 VGND 0.20566f
C1157 VPWR.t105 VGND 1.14535f
C1158 VPWR.n82 VGND 0.65334f
C1159 VPWR.n83 VGND 0.38551f
C1160 VPWR.n84 VGND 0.24267f
C1161 VPWR.n85 VGND 0.03896f
C1162 VPWR.n86 VGND 4.05804f
C1163 VPWR.n87 VGND 0.01948f
C1164 VPWR.n88 VGND 0.04464f
.ends
